.title rho_232_b22
.lib "C:/Users/kadhi/OneDrive/Desktop/amux/verilogLearning/Leaky-Integrate-Fire---SNN-model-on-FPGA/experiments/frontend_optimization/ngspice_frontend/sky130_minimal.lib.spice" tt
.option scale=1.0u method=gear reltol=0.01 gmin=1e-15
.temp 27

Vdd vdd 0 0.9
Vss vss 0 0
Vbias vbias 0 0.300

Vecg0 ecg_l0 0 PWL(0.0000000 0.300000 0.4275556 0.300000 0.4305556 0.253333 0.4333333 0.253333 0.4361111 0.254000 0.4388889 0.254667 0.4416667 0.256667 0.4444444 0.258667 0.4472222 0.260667 0.4500000 0.263333 0.4527778 0.263333 0.4555556 0.261333 0.4583333 0.262667 0.4611111 0.262000 0.4638889 0.261333 0.4666667 0.264000 0.4694444 0.264000 0.4722222 0.266667 0.4750000 0.269333 0.4777778 0.268667 0.4805556 0.269333 0.4833333 0.270000 0.4861111 0.266667 0.4888889 0.264667 0.4916667 0.262667 0.4944444 0.262667 0.4972222 0.262667 0.5000000 0.266000 0.5027778 0.268000 0.5055556 0.268000 0.5083333 0.267333 0.5111111 0.266000 0.5138889 0.264000 0.5166667 0.265333 0.5194444 0.265333 0.5222222 0.264000 0.5250000 0.265333 0.5277778 0.265333 0.5305556 0.266667 0.5333333 0.266667 0.5361111 0.265333 0.5388889 0.266667 0.5416667 0.263333 0.5444444 0.264667 0.5472222 0.264667 0.5500000 0.265333 0.5527778 0.266667 0.5555556 0.268000 0.5583333 0.268000 0.5611111 0.266667 0.5638889 0.266667 0.5666667 0.266667 0.5694444 0.265333 0.5722222 0.264000 0.5750000 0.262667 0.5777778 0.262667 0.5805556 0.262667 0.5833333 0.263333 0.5861111 0.262667 0.5888889 0.263333 0.5916667 0.262000 0.5944444 0.262000 0.5972222 0.262667 0.6000000 0.261333 0.6027778 0.261333 0.6055556 0.261333 0.6083333 0.263333 0.6111111 0.264667 0.6138889 0.267333 0.6166667 0.268000 0.6194444 0.267333 0.6222222 0.267333 0.6250000 0.264667 0.6277778 0.264000 0.6305556 0.262000 0.6333333 0.260667 0.6361111 0.260667 0.6388889 0.261333 0.6416667 0.263333 0.6444444 0.265333 0.6472222 0.266000 0.6500000 0.266667 0.6527778 0.267333 0.6555556 0.269333 0.6583333 0.270000 0.6611111 0.270000 0.6638889 0.274000 0.6666667 0.282667 0.6694444 0.296667 0.6722222 0.312667 0.6750000 0.332000 0.6777778 0.350667 0.6805556 0.360667 0.6833333 0.360667 0.6861111 0.343333 0.6888889 0.314667 0.6916667 0.278000 0.6944444 0.246667 0.6972222 0.228000 0.7000000 0.220000 0.7027778 0.222667 0.7055556 0.226667 0.7083333 0.232667 0.7111111 0.236667 0.7138889 0.239333 0.7166667 0.238000 0.7194444 0.238000 0.7222222 0.234667 0.7250000 0.230000 0.7277778 0.227333 0.7305556 0.228000 0.7333333 0.232667 0.7361111 0.236000 0.7388889 0.240667 0.7416667 0.242667 0.7444444 0.243333 0.7472222 0.240000 0.7500000 0.236667 0.7527778 0.233333 0.7555556 0.232667 0.7583333 0.233333 0.7611111 0.235333 0.7638889 0.239333 0.7666667 0.242667 0.7694444 0.250667 0.7722222 0.258000 0.7750000 0.262667 0.7777778 0.266667 0.7805556 0.265333 0.7833333 0.266667 0.7861111 0.265333 0.7888889 0.263333 0.7916667 0.261333 0.7944444 0.260667 0.7972222 0.260667 0.8000000 0.260667 0.8027778 0.260000 0.8055556 0.260667 0.8083333 0.262667 0.8111111 0.266000 0.8138889 0.266667 0.8166667 0.266000 0.8194444 0.266667 0.8222222 0.265333 0.8250000 0.264667 0.8277778 0.266000 0.8305556 0.265333 0.8333333 0.266667 0.8361111 0.267333 0.8388889 0.269333 0.8416667 0.269333 0.8444444 0.270667 0.8472222 0.269333 0.8500000 0.269333 0.8527778 0.270000 0.8555556 0.270000 0.8583333 0.270667 0.8611111 0.270000 0.8638889 0.269333 0.8666667 0.270667 0.8694444 0.268000 0.8722222 0.269333 0.8750000 0.270667 0.8777778 0.272667 0.8805556 0.275333 0.8833333 0.276667 0.8861111 0.277333 0.8888889 0.276000 0.8916667 0.274000 0.8944444 0.273333 0.8972222 0.272667 0.9000000 0.274000 0.9027778 0.274667 0.9055556 0.278000 0.9083333 0.281333 0.9111111 0.282000 0.9138889 0.282667 0.9166667 0.283333 0.9194444 0.284667 0.9222222 0.284667 0.9250000 0.286667 0.9277778 0.288000 0.9305556 0.290667 0.9333333 0.290667 0.9361111 0.295333 0.9388889 0.297333 0.9416667 0.299333 0.9444444 0.300000 0.9472222 0.298667 0.9500000 0.297333 0.9527778 0.297333 0.9555556 0.298000 0.9583333 0.298667 0.9611111 0.301333 0.9638889 0.303333 0.9666667 0.305333 0.9694444 0.303333 0.9722222 0.303333 0.9750000 0.301333 0.9777778 0.301333 0.9835556 0.300000 1.1636667 0.300000 1.1666667 0.259333 1.1694444 0.260000 1.1722222 0.262000 1.1750000 0.263333 1.1777778 0.264667 1.1805556 0.266000 1.1833333 0.266667 1.1861111 0.266667 1.1888889 0.266000 1.1916667 0.266000 1.1944444 0.266000 1.1972222 0.268000 1.2000000 0.267333 1.2027778 0.270000 1.2055556 0.272667 1.2083333 0.272000 1.2111111 0.272000 1.2138889 0.271333 1.2166667 0.270667 1.2194444 0.270000 1.2222222 0.267333 1.2250000 0.265333 1.2277778 0.264000 1.2305556 0.265333 1.2333333 0.264000 1.2361111 0.266667 1.2388889 0.268000 1.2416667 0.269333 1.2444444 0.271333 1.2472222 0.270667 1.2500000 0.270667 1.2527778 0.269333 1.2555556 0.268000 1.2583333 0.266000 1.2611111 0.263333 1.2638889 0.263333 1.2666667 0.261333 1.2694444 0.260667 1.2722222 0.262667 1.2750000 0.264667 1.2777778 0.264667 1.2805556 0.262000 1.2833333 0.263333 1.2861111 0.260667 1.2888889 0.260667 1.2916667 0.259333 1.2944444 0.260000 1.2972222 0.262667 1.3000000 0.266000 1.3027778 0.268000 1.3055556 0.268667 1.3083333 0.266667 1.3111111 0.262667 1.3138889 0.258000 1.3166667 0.256667 1.3194444 0.255333 1.3222222 0.256000 1.3250000 0.256667 1.3277778 0.259333 1.3305556 0.263333 1.3333333 0.264667 1.3361111 0.266000 1.3388889 0.266667 1.3416667 0.266000 1.3444444 0.265333 1.3472222 0.263333 1.3500000 0.263333 1.3527778 0.262667 1.3555556 0.264667 1.3583333 0.266000 1.3611111 0.265333 1.3638889 0.264667 1.3666667 0.264000 1.3694444 0.262667 1.3722222 0.264000 1.3750000 0.264667 1.3777778 0.266667 1.3805556 0.268000 1.3833333 0.270000 1.3861111 0.272667 1.3888889 0.273333 1.3916667 0.274667 1.3944444 0.278000 1.3972222 0.280000 1.4000000 0.281333 1.4027778 0.285333 1.4055556 0.294667 1.4083333 0.302667 1.4111111 0.311333 1.4138889 0.322000 1.4166667 0.332000 1.4194444 0.342000 1.4222222 0.344667 1.4250000 0.338667 1.4277778 0.318667 1.4305556 0.290000 1.4333333 0.259333 1.4361111 0.236667 1.4388889 0.223333 1.4416667 0.221333 1.4444444 0.226000 1.4472222 0.231333 1.4500000 0.238000 1.4527778 0.238000 1.4555556 0.234000 1.4583333 0.230667 1.4611111 0.227333 1.4638889 0.224000 1.4666667 0.225333 1.4694444 0.224667 1.4722222 0.228000 1.4750000 0.230000 1.4777778 0.238000 1.4805556 0.240000 1.4833333 0.244667 1.4861111 0.244667 1.4888889 0.242667 1.4916667 0.241333 1.4944444 0.242000 1.4972222 0.242000 1.5000000 0.240667 1.5027778 0.240667 1.5055556 0.242667 1.5083333 0.244667 1.5111111 0.249333 1.5138889 0.250667 1.5166667 0.255333 1.5194444 0.258667 1.5222222 0.261333 1.5250000 0.265333 1.5277778 0.264667 1.5305556 0.264000 1.5333333 0.264667 1.5361111 0.262667 1.5388889 0.266000 1.5416667 0.266000 1.5444444 0.264667 1.5472222 0.264667 1.5500000 0.265333 1.5527778 0.265333 1.5555556 0.262000 1.5583333 0.264667 1.5611111 0.264000 1.5638889 0.266000 1.5666667 0.264667 1.5694444 0.264667 1.5722222 0.266000 1.5750000 0.267333 1.5777778 0.266667 1.5805556 0.265333 1.5833333 0.263333 1.5861111 0.262000 1.5888889 0.261333 1.5916667 0.261333 1.5944444 0.259333 1.5972222 0.259333 1.6000000 0.257333 1.6027778 0.260000 1.6055556 0.261333 1.6083333 0.261333 1.6111111 0.264667 1.6138889 0.264667 1.6166667 0.264000 1.6194444 0.263333 1.6222222 0.264667 1.6250000 0.264000 1.6277778 0.261333 1.6305556 0.260667 1.6333333 0.261333 1.6361111 0.262000 1.6388889 0.263333 1.6416667 0.267333 1.6444444 0.270667 1.6472222 0.275333 1.6500000 0.277333 1.6527778 0.280000 1.6555556 0.275333 1.6583333 0.272667 1.6611111 0.269333 1.6638889 0.269333 1.6666667 0.268667 1.6694444 0.271333 1.6722222 0.273333 1.6750000 0.275333 1.6777778 0.275333 1.6805556 0.277333 1.6833333 0.278667 1.6861111 0.279333 1.6888889 0.279333 1.6916667 0.280667 1.6944444 0.280667 1.6972222 0.282000 1.7000000 0.283333 1.7027778 0.286000 1.7055556 0.287333 1.7083333 0.287333 1.7111111 0.288000 1.7138889 0.287333 1.7196667 0.300000 1.9108889 0.300000 1.9138889 0.262667 1.9166667 0.260000 1.9194444 0.255333 1.9222222 0.255333 1.9250000 0.253333 1.9277778 0.254667 1.9305556 0.258000 1.9333333 0.260000 1.9361111 0.262000 1.9388889 0.261333 1.9416667 0.262000 1.9444444 0.263333 1.9472222 0.262667 1.9500000 0.264000 1.9527778 0.266667 1.9555556 0.268000 1.9583333 0.270000 1.9611111 0.271333 1.9638889 0.272667 1.9666667 0.270667 1.9694444 0.269333 1.9722222 0.267333 1.9750000 0.266667 1.9777778 0.266000 1.9805556 0.261333 1.9833333 0.260667 1.9861111 0.260000 1.9888889 0.258667 1.9916667 0.258667 1.9944444 0.257333 1.9972222 0.260667 2.0000000 0.262667 2.0027778 0.265333 2.0055556 0.268667 2.0083333 0.270667 2.0111111 0.270667 2.0138889 0.269333 2.0166667 0.269333 2.0194444 0.266000 2.0222222 0.265333 2.0250000 0.265333 2.0277778 0.265333 2.0305556 0.264667 2.0333333 0.265333 2.0361111 0.265333 2.0388889 0.265333 2.0416667 0.266000 2.0444444 0.267333 2.0472222 0.266000 2.0500000 0.264667 2.0527778 0.264000 2.0555556 0.264000 2.0583333 0.266000 2.0611111 0.265333 2.0638889 0.267333 2.0666667 0.266667 2.0694444 0.266667 2.0722222 0.266000 2.0750000 0.264667 2.0777778 0.265333 2.0805556 0.264000 2.0833333 0.266000 2.0861111 0.266000 2.0888889 0.266667 2.0916667 0.265333 2.0944444 0.265333 2.0972222 0.268667 2.1000000 0.270000 2.1027778 0.268667 2.1055556 0.272000 2.1083333 0.274667 2.1111111 0.278667 2.1138889 0.279333 2.1166667 0.282000 2.1194444 0.282667 2.1222222 0.280000 2.1250000 0.280000 2.1277778 0.275333 2.1305556 0.273333 2.1333333 0.274000 2.1361111 0.276000 2.1388889 0.278667 2.1416667 0.282667 2.1444444 0.286667 2.1472222 0.290667 2.1500000 0.296000 2.1527778 0.305333 2.1555556 0.314000 2.1583333 0.323333 2.1611111 0.332667 2.1638889 0.340000 2.1666667 0.343333 2.1694444 0.338667 2.1722222 0.324667 2.1750000 0.302667 2.1777778 0.276000 2.1805556 0.251333 2.1833333 0.238000 2.1861111 0.231333 2.1888889 0.232000 2.1916667 0.235333 2.1944444 0.240000 2.1972222 0.241333 2.2000000 0.244667 2.2027778 0.243333 2.2055556 0.242000 2.2083333 0.240000 2.2111111 0.238667 2.2138889 0.238000 2.2166667 0.240000 2.2194444 0.244667 2.2222222 0.248667 2.2250000 0.252000 2.2277778 0.252000 2.2305556 0.250667 2.2333333 0.248667 2.2361111 0.248000 2.2388889 0.248667 2.2416667 0.249333 2.2444444 0.248000 2.2472222 0.250667 2.2500000 0.250000 2.2527778 0.250667 2.2555556 0.253333 2.2583333 0.256667 2.2611111 0.258000 2.2638889 0.263333 2.2666667 0.266000 2.2694444 0.270000 2.2722222 0.273333 2.2750000 0.274000 2.2777778 0.276000 2.2805556 0.276000 2.2833333 0.272667 2.2861111 0.271333 2.2888889 0.270000 2.2916667 0.267333 2.2944444 0.266000 2.2972222 0.266000 2.3000000 0.266000 2.3027778 0.268000 2.3055556 0.269333 2.3083333 0.272000 2.3111111 0.274000 2.3138889 0.276000 2.3166667 0.276667 2.3194444 0.274667 2.3222222 0.273333 2.3250000 0.271333 2.3277778 0.268667 2.3305556 0.266667 2.3333333 0.266000 2.3361111 0.268000 2.3388889 0.272667 2.3416667 0.274667 2.3444444 0.277333 2.3472222 0.275333 2.3500000 0.271333 2.3527778 0.266000 2.3555556 0.266667 2.3583333 0.265333 2.3611111 0.265333 2.3638889 0.267333 2.3666667 0.270667 2.3694444 0.271333 2.3722222 0.274667 2.3750000 0.274667 2.3777778 0.274667 2.3805556 0.274000 2.3833333 0.274667 2.3861111 0.276667 2.3888889 0.276000 2.3916667 0.276000 2.3944444 0.276667 2.3972222 0.276667 2.4000000 0.276667 2.4027778 0.276000 2.4055556 0.277333 2.4083333 0.279333 2.4111111 0.282000 2.4138889 0.282000 2.4166667 0.283333 2.4194444 0.286000 2.4222222 0.286667 2.4250000 0.286667 2.4277778 0.287333 2.4305556 0.287333 2.4333333 0.289333 2.4361111 0.290000 2.4388889 0.293333 2.4416667 0.297333 2.4444444 0.298000 2.4472222 0.296000 2.4500000 0.294000 2.4527778 0.292000 2.4555556 0.289333 2.4583333 0.290000 2.4611111 0.289333 2.4668889 0.300000 2.6470000 0.300000 2.6500000 0.259333 2.6527778 0.259333 2.6555556 0.258000 2.6583333 0.258000 2.6611111 0.257333 2.6638889 0.256667 2.6666667 0.257333 2.6694444 0.258000 2.6722222 0.260000 2.6750000 0.262000 2.6777778 0.264667 2.6805556 0.265333 2.6833333 0.264667 2.6861111 0.263333 2.6888889 0.264667 2.6916667 0.264667 2.6944444 0.264667 2.6972222 0.266000 2.7000000 0.266667 2.7027778 0.268000 2.7055556 0.266000 2.7083333 0.264667 2.7111111 0.260667 2.7138889 0.259333 2.7166667 0.259333 2.7194444 0.259333 2.7222222 0.259333 2.7250000 0.259333 2.7277778 0.259333 2.7305556 0.256667 2.7333333 0.253333 2.7361111 0.252000 2.7388889 0.251333 2.7416667 0.254000 2.7444444 0.258000 2.7472222 0.260667 2.7500000 0.262667 2.7527778 0.263333 2.7555556 0.263333 2.7583333 0.260667 2.7611111 0.257333 2.7638889 0.256000 2.7666667 0.253333 2.7694444 0.254000 2.7722222 0.256000 2.7750000 0.258000 2.7777778 0.260000 2.7805556 0.260667 2.7833333 0.256667 2.7861111 0.256000 2.7888889 0.254000 2.7916667 0.253333 2.7944444 0.253333 2.7972222 0.255333 2.8000000 0.257333 2.8027778 0.260000 2.8055556 0.260667 2.8083333 0.260667 2.8111111 0.260667 2.8138889 0.258667 2.8166667 0.258000 2.8194444 0.258000 2.8222222 0.256667 2.8250000 0.258000 2.8277778 0.257333 2.8305556 0.258667 2.8333333 0.258000 2.8361111 0.256000 2.8388889 0.254667 2.8416667 0.256000 2.8444444 0.256000 2.8472222 0.255333 2.8500000 0.256667 2.8527778 0.258000 2.8555556 0.259333 2.8583333 0.258667 2.8611111 0.257333 2.8638889 0.256000 2.8666667 0.256000 2.8694444 0.256667 2.8722222 0.260667 2.8750000 0.264000 2.8777778 0.266667 2.8805556 0.270000 2.8833333 0.274667 2.8861111 0.282000 2.8888889 0.290667 2.8916667 0.304000 2.8944444 0.322000 2.8972222 0.338667 2.9000000 0.353333 2.9027778 0.360000 2.9055556 0.358667 2.9083333 0.338667 2.9111111 0.304667 2.9138889 0.267333 2.9166667 0.235333 2.9194444 0.214000 2.9222222 0.204667 2.9250000 0.207333 2.9277778 0.211333 2.9305556 0.217333 2.9333333 0.225333 2.9361111 0.231333 2.9388889 0.233333 2.9416667 0.232000 2.9444444 0.228667 2.9472222 0.223333 2.9500000 0.220667 2.9527778 0.220667 2.9555556 0.222000 2.9583333 0.226667 2.9611111 0.232667 2.9638889 0.237333 2.9666667 0.239333 2.9694444 0.240667 2.9722222 0.241333 2.9750000 0.239333 2.9777778 0.238000 2.9805556 0.234667 2.9833333 0.232667 2.9861111 0.230000 2.9888889 0.230000 2.9916667 0.231333 2.9944444 0.235333 2.9972222 0.240000 3.0000000 0.243333 3.0027778 0.248000 3.0055556 0.251333 3.0083333 0.254667 3.0111111 0.253333 3.0138889 0.252000 3.0166667 0.252000 3.0194444 0.249333 3.0222222 0.246000 3.0250000 0.246667 3.0277778 0.247333 3.0305556 0.248000 3.0333333 0.250667 3.0361111 0.254000 3.0388889 0.255333 3.0416667 0.257333 3.0444444 0.258000 3.0472222 0.258000 3.0500000 0.258667 3.0527778 0.257333 3.0555556 0.258000 3.0583333 0.259333 3.0611111 0.256000 3.0638889 0.254000 3.0666667 0.252000 3.0694444 0.250667 3.0722222 0.250667 3.0750000 0.254000 3.0777778 0.256000 3.0805556 0.258667 3.0833333 0.260000 3.0861111 0.264000 3.0888889 0.263333 3.0916667 0.264667 3.0944444 0.261333 3.0972222 0.261333 3.1000000 0.259333 3.1027778 0.262000 3.1055556 0.264667 3.1083333 0.268667 3.1111111 0.269333 3.1138889 0.269333 3.1166667 0.266667 3.1194444 0.265333 3.1222222 0.263333 3.1250000 0.264000 3.1277778 0.262667 3.1305556 0.266667 3.1333333 0.268000 3.1361111 0.270000 3.1388889 0.272667 3.1416667 0.274667 3.1444444 0.276000 3.1472222 0.272667 3.1500000 0.275333 3.1527778 0.276667 3.1555556 0.278000 3.1583333 0.276667 3.1611111 0.276000 3.1638889 0.275333 3.1666667 0.276000 3.1694444 0.278000 3.1722222 0.281333 3.1750000 0.283333 3.1777778 0.286000 3.1805556 0.286667 3.1833333 0.288000 3.1861111 0.288667 3.1888889 0.286667 3.1916667 0.286000 3.1944444 0.288000 3.1972222 0.288000 3.2030000 0.300000 3.3803333 0.300000 3.3833333 0.238000 3.3861111 0.238667 3.3888889 0.238000 3.3916667 0.238667 3.3944444 0.240000 3.3972222 0.240667 3.4000000 0.242000 3.4027778 0.243333 3.4055556 0.245333 3.4083333 0.246000 3.4111111 0.248667 3.4138889 0.250667 3.4166667 0.253333 3.4194444 0.254000 3.4222222 0.255333 3.4250000 0.257333 3.4277778 0.256667 3.4305556 0.258000 3.4333333 0.259333 3.4361111 0.260667 3.4388889 0.262667 3.4416667 0.264000 3.4444444 0.264667 3.4472222 0.264000 3.4500000 0.264667 3.4527778 0.264000 3.4555556 0.263333 3.4583333 0.260000 3.4611111 0.260000 3.4638889 0.260667 3.4666667 0.258667 3.4694444 0.260000 3.4722222 0.260667 3.4750000 0.262000 3.4777778 0.262000 3.4805556 0.262667 3.4833333 0.263333 3.4861111 0.265333 3.4888889 0.264000 3.4916667 0.262667 3.4944444 0.260667 3.4972222 0.256667 3.5000000 0.256000 3.5027778 0.254667 3.5055556 0.254667 3.5083333 0.256000 3.5111111 0.256667 3.5138889 0.259333 3.5166667 0.261333 3.5194444 0.261333 3.5222222 0.261333 3.5250000 0.261333 3.5277778 0.260000 3.5305556 0.260000 3.5333333 0.262667 3.5361111 0.265333 3.5388889 0.265333 3.5416667 0.268000 3.5444444 0.268667 3.5472222 0.267333 3.5500000 0.268000 3.5527778 0.267333 3.5555556 0.267333 3.5583333 0.267333 3.5611111 0.266000 3.5638889 0.264667 3.5666667 0.264000 3.5694444 0.262000 3.5722222 0.264000 3.5750000 0.265333 3.5777778 0.265333 3.5805556 0.266667 3.5833333 0.268000 3.5861111 0.268000 3.5888889 0.269333 3.5916667 0.268667 3.5944444 0.266000 3.5972222 0.264667 3.6000000 0.263333 3.6027778 0.263333 3.6055556 0.266000 3.6083333 0.266667 3.6111111 0.271333 3.6138889 0.273333 3.6166667 0.277333 3.6194444 0.284667 3.6222222 0.294667 3.6250000 0.311333 3.6277778 0.328667 3.6305556 0.344667 3.6333333 0.358667 3.6361111 0.368667 3.6388889 0.363333 3.6416667 0.341333 3.6444444 0.307333 3.6472222 0.269333 3.6500000 0.240667 3.6527778 0.222000 3.6555556 0.214000 3.6583333 0.214000 3.6611111 0.217333 3.6638889 0.222667 3.6666667 0.227333 3.6694444 0.230667 3.6722222 0.232000 3.6750000 0.231333 3.6777778 0.230000 3.6805556 0.227333 3.6833333 0.228667 3.6861111 0.233333 3.6888889 0.238000 3.6916667 0.245333 3.6944444 0.247333 3.6972222 0.248667 3.7000000 0.248000 3.7027778 0.245333 3.7055556 0.244000 3.7083333 0.242000 3.7111111 0.241333 3.7138889 0.242000 3.7166667 0.242000 3.7194444 0.242000 3.7222222 0.245333 3.7250000 0.248667 3.7277778 0.251333 3.7305556 0.254000 3.7333333 0.257333 3.7361111 0.260667 3.7388889 0.262667 3.7416667 0.265333 3.7444444 0.267333 3.7472222 0.268667 3.7500000 0.269333 3.7527778 0.268667 3.7555556 0.267333 3.7583333 0.266000 3.7611111 0.264000 3.7638889 0.263333 3.7666667 0.264000 3.7694444 0.264000 3.7722222 0.266667 3.7750000 0.268667 3.7777778 0.270000 3.7805556 0.269333 3.7833333 0.270667 3.7861111 0.270000 3.7888889 0.266667 3.7916667 0.266000 3.7944444 0.266667 3.7972222 0.268667 3.8000000 0.269333 3.8027778 0.270667 3.8055556 0.272667 3.8083333 0.274000 3.8111111 0.275333 3.8138889 0.276000 3.8166667 0.273333 3.8194444 0.273333 3.8222222 0.270667 3.8250000 0.270000 3.8277778 0.269333 3.8305556 0.270667 3.8333333 0.271333 3.8361111 0.273333 3.8388889 0.272667 3.8416667 0.276000 3.8444444 0.276667 3.8472222 0.278000 3.8500000 0.276667 3.8527778 0.278667 3.8555556 0.281333 3.8583333 0.282667 3.8611111 0.283333 3.8638889 0.284667 3.8666667 0.286000 3.8694444 0.288000 3.8722222 0.288667 3.8750000 0.289333 3.8777778 0.292000 3.8805556 0.292667 3.8833333 0.295333 3.8861111 0.296667 3.8888889 0.299333 3.8916667 0.300667 3.8944444 0.302000 3.8972222 0.304000 3.9000000 0.304667 3.9027778 0.307333 3.9055556 0.308000 3.9083333 0.310667 3.9111111 0.311333 3.9138889 0.312667 3.9166667 0.312667 3.9194444 0.313333 3.9222222 0.312000 3.9250000 0.312667 3.9277778 0.310667 3.9305556 0.309333 3.9363333 0.300000 4.0914444 0.300000 4.0944444 0.267333 4.0972222 0.266667 4.1000000 0.266667 4.1027778 0.268000 4.1055556 0.268667 4.1083333 0.268000 4.1111111 0.270000 4.1138889 0.271333 4.1166667 0.272667 4.1194444 0.273333 4.1222222 0.272000 4.1250000 0.270667 4.1277778 0.268000 4.1305556 0.266667 4.1333333 0.266667 4.1361111 0.268000 4.1388889 0.271333 4.1416667 0.275333 4.1444444 0.276667 4.1472222 0.277333 4.1500000 0.277333 4.1527778 0.277333 4.1555556 0.275333 4.1583333 0.272667 4.1611111 0.272000 4.1638889 0.270000 4.1666667 0.267333 4.1694444 0.268667 4.1722222 0.269333 4.1750000 0.270667 4.1777778 0.271333 4.1805556 0.270000 4.1833333 0.272000 4.1861111 0.270000 4.1888889 0.271333 4.1916667 0.270000 4.1944444 0.270667 4.1972222 0.272000 4.2000000 0.274667 4.2027778 0.275333 4.2055556 0.278667 4.2083333 0.278000 4.2111111 0.278000 4.2138889 0.278000 4.2166667 0.277333 4.2194444 0.276000 4.2222222 0.272000 4.2250000 0.270667 4.2277778 0.270000 4.2305556 0.270000 4.2333333 0.272000 4.2361111 0.274000 4.2388889 0.276667 4.2416667 0.276667 4.2444444 0.277333 4.2472222 0.278000 4.2500000 0.274000 4.2527778 0.274667 4.2555556 0.272667 4.2583333 0.272000 4.2611111 0.272000 4.2638889 0.272000 4.2666667 0.274667 4.2694444 0.274000 4.2722222 0.274000 4.2750000 0.276000 4.2777778 0.276667 4.2805556 0.275333 4.2833333 0.276000 4.2861111 0.277333 4.2888889 0.277333 4.2916667 0.278667 4.2944444 0.277333 4.2972222 0.274667 4.3000000 0.274667 4.3027778 0.273333 4.3055556 0.275333 4.3083333 0.277333 4.3111111 0.278000 4.3138889 0.277333 4.3166667 0.277333 4.3194444 0.278000 4.3222222 0.280000 4.3250000 0.283333 4.3277778 0.288667 4.3305556 0.295333 4.3333333 0.310000 4.3361111 0.325333 4.3388889 0.340000 4.3416667 0.357333 4.3444444 0.371333 4.3472222 0.378000 4.3500000 0.372000 4.3527778 0.352000 4.3555556 0.319333 4.3583333 0.284667 4.3611111 0.252667 4.3638889 0.233333 4.3666667 0.222000 4.3694444 0.222000 4.3722222 0.227333 4.3750000 0.232667 4.3777778 0.238000 4.3805556 0.241333 4.3833333 0.244667 4.3861111 0.244000 4.3888889 0.243333 4.3916667 0.241333 4.3944444 0.240000 4.3972222 0.238667 4.4000000 0.242000 4.4027778 0.246000 4.4055556 0.251333 4.4083333 0.256667 4.4111111 0.259333 4.4138889 0.257333 4.4166667 0.255333 4.4194444 0.250667 4.4222222 0.249333 4.4250000 0.246667 4.4277778 0.246000 4.4305556 0.248667 4.4333333 0.252667 4.4361111 0.259333 4.4388889 0.265333 4.4416667 0.270000 4.4444444 0.274000 4.4472222 0.278667 4.4500000 0.278000 4.4527778 0.276000 4.4555556 0.274000 4.4583333 0.270667 4.4611111 0.269333 4.4638889 0.271333 4.4666667 0.272000 4.4694444 0.272000 4.4722222 0.275333 4.4750000 0.276667 4.4777778 0.278667 4.4805556 0.277333 4.4833333 0.275333 4.4861111 0.277333 4.4888889 0.276000 4.4916667 0.272667 4.4944444 0.272667 4.4972222 0.273333 4.5000000 0.274000 4.5027778 0.276000 4.5055556 0.276000 4.5083333 0.277333 4.5111111 0.280667 4.5138889 0.280000 4.5166667 0.280000 4.5194444 0.278000 4.5222222 0.276000 4.5250000 0.274000 4.5277778 0.274667 4.5305556 0.276667 4.5333333 0.278000 4.5361111 0.278667 4.5388889 0.280000 4.5416667 0.282000 4.5444444 0.284667 4.5472222 0.285333 4.5500000 0.284667 4.5527778 0.286000 4.5555556 0.285333 4.5583333 0.284667 4.5611111 0.285333 4.5638889 0.284000 4.5666667 0.284667 4.5694444 0.286667 4.5722222 0.287333 4.5750000 0.288667 4.5777778 0.290000 4.5805556 0.293333 4.5833333 0.294000 4.5861111 0.296000 4.5888889 0.296667 4.5916667 0.297333 4.5944444 0.299333 4.5972222 0.298667 4.6000000 0.300667 4.6027778 0.300000 4.6055556 0.301333 4.6083333 0.302667 4.6111111 0.304667 4.6138889 0.306000 4.6166667 0.306667 4.6194444 0.309333 4.6222222 0.308667 4.6250000 0.312000 4.6277778 0.312000 4.6305556 0.311333 4.6333333 0.310000 4.6361111 0.309333 4.6388889 0.310000 4.6416667 0.312000 4.6474444 0.300000 6.1220000 0.300000 6.1250000 0.283333 6.1277778 0.284667 6.1305556 0.282667 6.1333333 0.284000 6.1361111 0.284667 6.1388889 0.287333 6.1416667 0.288667 6.1444444 0.290667 6.1472222 0.291333 6.1500000 0.290000 6.1527778 0.291333 6.1555556 0.290000 6.1583333 0.290667 6.1611111 0.290000 6.1638889 0.292000 6.1666667 0.293333 6.1694444 0.293333 6.1722222 0.293333 6.1750000 0.292667 6.1777778 0.294000 6.1805556 0.294667 6.1833333 0.294667 6.1861111 0.295333 6.1888889 0.294667 6.1916667 0.293333 6.1944444 0.290667 6.1972222 0.289333 6.2000000 0.289333 6.2027778 0.288667 6.2055556 0.288000 6.2083333 0.287333 6.2111111 0.287333 6.2138889 0.287333 6.2166667 0.286000 6.2194444 0.287333 6.2222222 0.289333 6.2250000 0.290000 6.2277778 0.290667 6.2305556 0.288000 6.2333333 0.290667 6.2361111 0.291333 6.2388889 0.289333 6.2416667 0.290667 6.2444444 0.289333 6.2472222 0.286000 6.2500000 0.283333 6.2527778 0.280000 6.2555556 0.278667 6.2583333 0.276667 6.2611111 0.276667 6.2638889 0.278000 6.2666667 0.278667 6.2694444 0.280000 6.2722222 0.282667 6.2750000 0.284667 6.2777778 0.285333 6.2805556 0.282667 6.2833333 0.283333 6.2861111 0.281333 6.2888889 0.281333 6.2916667 0.282000 6.2944444 0.281333 6.2972222 0.282000 6.3000000 0.281333 6.3027778 0.280667 6.3055556 0.279333 6.3083333 0.279333 6.3111111 0.281333 6.3138889 0.281333 6.3166667 0.281333 6.3194444 0.282000 6.3222222 0.282000 6.3250000 0.279333 6.3277778 0.279333 6.3305556 0.280000 6.3333333 0.281333 6.3361111 0.283333 6.3388889 0.283333 6.3416667 0.285333 6.3444444 0.286667 6.3472222 0.289333 6.3500000 0.291333 6.3527778 0.293333 6.3555556 0.297333 6.3583333 0.301333 6.3611111 0.309333 6.3638889 0.320000 6.3666667 0.336000 6.3694444 0.352000 6.3722222 0.366000 6.3750000 0.378667 6.3777778 0.383333 6.3805556 0.372000 6.3833333 0.346667 6.3861111 0.315333 6.3888889 0.280000 6.3916667 0.259333 6.3944444 0.247333 6.3972222 0.242000 6.4000000 0.242667 6.4027778 0.246000 6.4055556 0.246667 6.4083333 0.248000 6.4111111 0.248667 6.4138889 0.248667 6.4166667 0.248000 6.4194444 0.247333 6.4222222 0.245333 6.4250000 0.244667 6.4277778 0.245333 6.4305556 0.248000 6.4333333 0.250667 6.4361111 0.256667 6.4388889 0.260000 6.4416667 0.260667 6.4444444 0.262000 6.4472222 0.259333 6.4500000 0.258000 6.4527778 0.255333 6.4555556 0.254667 6.4583333 0.254667 6.4611111 0.258000 6.4638889 0.260000 6.4666667 0.264000 6.4694444 0.266000 6.4722222 0.271333 6.4750000 0.274667 6.4777778 0.280000 6.4805556 0.283333 6.4833333 0.285333 6.4861111 0.286000 6.4888889 0.284667 6.4916667 0.280667 6.4944444 0.278667 6.4972222 0.276667 6.5000000 0.277333 6.5027778 0.276667 6.5055556 0.278000 6.5083333 0.280000 6.5111111 0.280667 6.5138889 0.281333 6.5166667 0.280000 6.5194444 0.280667 6.5222222 0.280667 6.5250000 0.279333 6.5277778 0.278667 6.5305556 0.278000 6.5333333 0.278667 6.5361111 0.280000 6.5388889 0.282000 6.5416667 0.282667 6.5444444 0.283333 6.5472222 0.284000 6.5500000 0.283333 6.5527778 0.284667 6.5555556 0.284000 6.5583333 0.284000 6.5611111 0.284000 6.5638889 0.282000 6.5666667 0.283333 6.5694444 0.282000 6.5722222 0.282667 6.5750000 0.284667 6.5777778 0.285333 6.5805556 0.286667 6.5833333 0.286667 6.5861111 0.286667 6.5888889 0.286000 6.5916667 0.286667 6.5944444 0.288000 6.5972222 0.288667 6.6000000 0.286667 6.6027778 0.287333 6.6055556 0.288000 6.6083333 0.288667 6.6111111 0.291333 6.6138889 0.291333 6.6166667 0.293333 6.6194444 0.292000 6.6222222 0.294000 6.6250000 0.296667 6.6277778 0.296667 6.6305556 0.297333 6.6333333 0.299333 6.6361111 0.300667 6.6388889 0.302000 6.6416667 0.302000 6.6444444 0.302667 6.6472222 0.302000 6.6500000 0.306000 6.6527778 0.306667 6.6555556 0.304000 6.6583333 0.305333 6.6611111 0.306000 6.6638889 0.308667 6.6666667 0.308667 6.6694444 0.311333 6.6722222 0.313333 6.6780000 0.300000 8.8386667 0.300000 8.8416667 0.284667 8.8444444 0.285333 8.8472222 0.286000 8.8500000 0.286000 8.8527778 0.285333 8.8555556 0.284667 8.8583333 0.284667 8.8611111 0.282667 8.8638889 0.284000 8.8666667 0.286000 8.8694444 0.287333 8.8722222 0.288000 8.8750000 0.292000 8.8777778 0.294667 8.8805556 0.294667 8.8833333 0.295333 8.8861111 0.296000 8.8888889 0.296000 8.8916667 0.294667 8.8944444 0.294000 8.8972222 0.293333 8.9000000 0.294000 8.9027778 0.292667 8.9055556 0.294000 8.9083333 0.294667 8.9111111 0.294667 8.9138889 0.294667 8.9166667 0.293333 8.9194444 0.292667 8.9222222 0.290667 8.9250000 0.288000 8.9277778 0.287333 8.9305556 0.288667 8.9333333 0.290000 8.9361111 0.290000 8.9388889 0.291333 8.9416667 0.291333 8.9444444 0.291333 8.9472222 0.290667 8.9500000 0.290000 8.9527778 0.289333 8.9555556 0.288000 8.9583333 0.286000 8.9611111 0.284000 8.9638889 0.282667 8.9666667 0.282000 8.9694444 0.281333 8.9722222 0.281333 8.9750000 0.282000 8.9777778 0.283333 8.9805556 0.283333 8.9833333 0.282667 8.9861111 0.281333 8.9888889 0.281333 8.9916667 0.281333 8.9944444 0.280667 8.9972222 0.280667 9.0000000 0.280667 9.0027778 0.280667 9.0055556 0.280667 9.0083333 0.281333 9.0111111 0.284000 9.0138889 0.282667 9.0166667 0.282667 9.0194444 0.282667 9.0222222 0.281333 9.0250000 0.283333 9.0277778 0.282667 9.0305556 0.284667 9.0333333 0.286000 9.0361111 0.286000 9.0388889 0.286000 9.0416667 0.286000 9.0444444 0.286000 9.0472222 0.284667 9.0500000 0.284000 9.0527778 0.284667 9.0555556 0.282667 9.0583333 0.282000 9.0611111 0.283333 9.0638889 0.284667 9.0666667 0.286000 9.0694444 0.289333 9.0722222 0.290667 9.0750000 0.294667 9.0777778 0.300667 9.0805556 0.308667 9.0833333 0.318000 9.0861111 0.330667 9.0888889 0.343333 9.0916667 0.356667 9.0944444 0.364000 9.0972222 0.365333 9.1000000 0.352000 9.1027778 0.324667 9.1055556 0.295333 9.1083333 0.266667 9.1111111 0.248000 9.1138889 0.240000 9.1166667 0.239333 9.1194444 0.241333 9.1222222 0.244667 9.1250000 0.250667 9.1277778 0.253333 9.1305556 0.252667 9.1333333 0.251333 9.1361111 0.249333 9.1388889 0.247333 9.1416667 0.249333 9.1444444 0.253333 9.1472222 0.258000 9.1500000 0.262000 9.1527778 0.264667 9.1555556 0.262667 9.1583333 0.260000 9.1611111 0.257333 9.1638889 0.254667 9.1666667 0.254000 9.1694444 0.254667 9.1722222 0.258667 9.1750000 0.262667 9.1777778 0.265333 9.1805556 0.268000 9.1833333 0.269333 9.1861111 0.272667 9.1888889 0.274667 9.1916667 0.276667 9.1944444 0.276000 9.1972222 0.276667 9.2000000 0.278000 9.2027778 0.280000 9.2055556 0.282000 9.2083333 0.283333 9.2111111 0.284000 9.2138889 0.283333 9.2166667 0.283333 9.2194444 0.283333 9.2222222 0.282000 9.2250000 0.281333 9.2277778 0.279333 9.2305556 0.279333 9.2333333 0.278667 9.2361111 0.278000 9.2388889 0.280000 9.2416667 0.280667 9.2444444 0.281333 9.2472222 0.283333 9.2500000 0.283333 9.2527778 0.284667 9.2555556 0.283333 9.2583333 0.282667 9.2611111 0.282000 9.2638889 0.281333 9.2666667 0.280667 9.2694444 0.281333 9.2722222 0.282667 9.2750000 0.283333 9.2777778 0.285333 9.2805556 0.286667 9.2833333 0.286000 9.2861111 0.288000 9.2888889 0.287333 9.2916667 0.286667 9.2944444 0.286000 9.2972222 0.285333 9.3000000 0.286000 9.3027778 0.285333 9.3055556 0.285333 9.3083333 0.287333 9.3111111 0.288000 9.3138889 0.290000 9.3166667 0.290667 9.3194444 0.290000 9.3222222 0.293333 9.3250000 0.294000 9.3277778 0.294000 9.3305556 0.295333 9.3333333 0.296667 9.3361111 0.298000 9.3388889 0.299333 9.3416667 0.298667 9.3444444 0.300000 9.3472222 0.300667 9.3500000 0.299333 9.3527778 0.301333 9.3555556 0.301333 9.3583333 0.302667 9.3611111 0.302667 9.3638889 0.303333 9.3666667 0.303333 9.3694444 0.304000 9.3722222 0.305333 9.3750000 0.308667 9.3777778 0.311333 9.3805556 0.314667 9.3833333 0.315333 9.3861111 0.316667 9.3888889 0.316000 9.3946667 0.300000 9.9497778 0.300000 9.9527778 0.282667 9.9555556 0.282667 9.9583333 0.284000 9.9611111 0.283333 9.9638889 0.284667 9.9666667 0.287333 9.9694444 0.287333 9.9722222 0.291333 9.9750000 0.292667 9.9777778 0.293333 9.9805556 0.291333 9.9833333 0.290667 9.9861111 0.290667 9.9888889 0.290667 9.9916667 0.289333 9.9944444 0.290000 9.9972222 0.290000 10.0000000 0.290667 10.0027778 0.290667 10.0055556 0.292000 10.0083333 0.292667 10.0111111 0.295333 10.0138889 0.296000 10.0166667 0.294667 10.0194444 0.294000 10.0222222 0.291333 10.0250000 0.290000 10.0277778 0.288000 10.0305556 0.287333 10.0333333 0.287333 10.0361111 0.288000 10.0388889 0.290667 10.0416667 0.290667 10.0444444 0.290667 10.0472222 0.290667 10.0500000 0.289333 10.0527778 0.289333 10.0555556 0.288000 10.0583333 0.286667 10.0611111 0.282667 10.0638889 0.280667 10.0666667 0.282000 10.0694444 0.282667 10.0722222 0.280667 10.0750000 0.280667 10.0777778 0.282000 10.0805556 0.280000 10.0833333 0.279333 10.0861111 0.281333 10.0888889 0.279333 10.0916667 0.280667 10.0944444 0.278667 10.0972222 0.278000 10.1000000 0.276667 10.1027778 0.277333 10.1055556 0.278000 10.1083333 0.279333 10.1111111 0.278667 10.1138889 0.280000 10.1166667 0.280667 10.1194444 0.282667 10.1222222 0.280000 10.1250000 0.279333 10.1277778 0.279333 10.1305556 0.277333 10.1333333 0.277333 10.1361111 0.276667 10.1388889 0.279333 10.1416667 0.280000 10.1444444 0.282667 10.1472222 0.282000 10.1500000 0.280667 10.1527778 0.280667 10.1555556 0.279333 10.1583333 0.279333 10.1611111 0.279333 10.1638889 0.278000 10.1666667 0.280667 10.1694444 0.280000 10.1722222 0.282667 10.1750000 0.285333 10.1777778 0.286667 10.1805556 0.290667 10.1833333 0.293333 10.1861111 0.300000 10.1888889 0.311333 10.1916667 0.324667 10.1944444 0.342000 10.1972222 0.360667 10.2000000 0.378000 10.2027778 0.391333 10.2055556 0.396667 10.2083333 0.389333 10.2111111 0.366667 10.2138889 0.332667 10.2166667 0.294000 10.2194444 0.264000 10.2222222 0.244000 10.2250000 0.235333 10.2277778 0.233333 10.2305556 0.234667 10.2333333 0.238667 10.2361111 0.242000 10.2388889 0.248000 10.2416667 0.250000 10.2444444 0.251333 10.2472222 0.250000 10.2500000 0.247333 10.2527778 0.246000 10.2555556 0.244667 10.2583333 0.246667 10.2611111 0.250667 10.2638889 0.256667 10.2666667 0.262000 10.2694444 0.265333 10.2722222 0.266667 10.2750000 0.267333 10.2777778 0.266667 10.2805556 0.264000 10.2833333 0.261333 10.2861111 0.260667 10.2888889 0.258667 10.2916667 0.260000 10.2944444 0.260000 10.2972222 0.259333 10.3000000 0.262000 10.3027778 0.266667 10.3055556 0.271333 10.3083333 0.277333 10.3111111 0.282000 10.3138889 0.284000 10.3166667 0.286000 10.3194444 0.286000 10.3222222 0.287333 10.3250000 0.284000 10.3277778 0.286667 10.3305556 0.285333 10.3333333 0.284667 10.3361111 0.283333 10.3388889 0.284667 10.3416667 0.285333 10.3444444 0.286000 10.3472222 0.286000 10.3500000 0.285333 10.3527778 0.285333 10.3555556 0.284667 10.3583333 0.285333 10.3611111 0.284667 10.3638889 0.284667 10.3666667 0.286000 10.3694444 0.286000 10.3722222 0.287333 10.3750000 0.288000 10.3777778 0.290000 10.3805556 0.290000 10.3833333 0.292000 10.3861111 0.290000 10.3888889 0.290000 10.3916667 0.289333 10.3944444 0.287333 10.3972222 0.286667 10.4000000 0.287333 10.4027778 0.287333 10.4055556 0.286667 10.4083333 0.288000 10.4111111 0.290000 10.4138889 0.291333 10.4166667 0.293333 10.4194444 0.294000 10.4222222 0.296000 10.4250000 0.295333 10.4277778 0.296000 10.4305556 0.296667 10.4333333 0.297333 10.4361111 0.297333 10.4388889 0.298000 10.4416667 0.299333 10.4444444 0.300667 10.4472222 0.303333 10.4500000 0.303333 10.4527778 0.303333 10.4555556 0.303333 10.4583333 0.306667 10.4611111 0.306000 10.4638889 0.307333 10.4666667 0.310000 10.4694444 0.309333 10.4722222 0.312667 10.4750000 0.315333 10.4777778 0.317333 10.4805556 0.320000 10.4833333 0.320000 10.4861111 0.320667 10.4888889 0.320667 10.4916667 0.318000 10.4944444 0.319333 10.4972222 0.322667 10.5000000 0.324667 10.5057778 0.300000 10.6664444 0.300000 10.6694444 0.278667 10.6722222 0.282000 10.6750000 0.283333 10.6777778 0.284000 10.6805556 0.286667 10.6833333 0.286000 10.6861111 0.286000 10.6888889 0.286000 10.6916667 0.286667 10.6944444 0.286667 10.6972222 0.286000 10.7000000 0.288000 10.7027778 0.289333 10.7055556 0.290667 10.7083333 0.290667 10.7111111 0.291333 10.7138889 0.291333 10.7166667 0.291333 10.7194444 0.290667 10.7222222 0.290667 10.7250000 0.290667 10.7277778 0.290667 10.7305556 0.290667 10.7333333 0.290000 10.7361111 0.289333 10.7388889 0.288000 10.7416667 0.288667 10.7444444 0.288667 10.7472222 0.290667 10.7500000 0.291333 10.7527778 0.293333 10.7555556 0.293333 10.7583333 0.293333 10.7611111 0.292000 10.7638889 0.292000 10.7666667 0.292000 10.7694444 0.289333 10.7722222 0.289333 10.7750000 0.290667 10.7777778 0.290667 10.7805556 0.293333 10.7833333 0.294667 10.7861111 0.294000 10.7888889 0.293333 10.7916667 0.294000 10.7944444 0.291333 10.7972222 0.288667 10.8000000 0.289333 10.8027778 0.288000 10.8055556 0.287333 10.8083333 0.288000 10.8111111 0.288000 10.8138889 0.288000 10.8166667 0.290000 10.8194444 0.290667 10.8222222 0.289333 10.8250000 0.290000 10.8277778 0.289333 10.8305556 0.290000 10.8333333 0.288667 10.8361111 0.288000 10.8388889 0.287333 10.8416667 0.288000 10.8444444 0.286667 10.8472222 0.288000 10.8500000 0.286000 10.8527778 0.285333 10.8555556 0.286000 10.8583333 0.284667 10.8611111 0.284667 10.8638889 0.282667 10.8666667 0.280667 10.8694444 0.280667 10.8722222 0.282667 10.8750000 0.284000 10.8777778 0.286000 10.8805556 0.287333 10.8833333 0.291333 10.8861111 0.290000 10.8888889 0.290667 10.8916667 0.288667 10.8944444 0.289333 10.8972222 0.288667 10.9000000 0.289333 10.9027778 0.295333 10.9055556 0.303333 10.9083333 0.316667 10.9111111 0.334000 10.9138889 0.351333 10.9166667 0.368000 10.9194444 0.382667 10.9222222 0.392000 10.9250000 0.386667 10.9277778 0.367333 10.9305556 0.334667 10.9333333 0.297333 10.9361111 0.264000 10.9388889 0.242667 10.9416667 0.230000 10.9444444 0.229333 10.9472222 0.233333 10.9500000 0.238000 10.9527778 0.243333 10.9555556 0.244667 10.9583333 0.244667 10.9611111 0.240667 10.9638889 0.236000 10.9666667 0.232667 10.9694444 0.232000 10.9722222 0.234000 10.9750000 0.238667 10.9777778 0.248000 10.9805556 0.254000 10.9833333 0.256667 10.9861111 0.256000 10.9888889 0.254000 10.9916667 0.252000 10.9944444 0.249333 10.9972222 0.248000 11.0000000 0.248000 11.0027778 0.249333 11.0055556 0.251333 11.0083333 0.254667 11.0111111 0.257333 11.0138889 0.261333 11.0166667 0.264000 11.0194444 0.267333 11.0222222 0.268667 11.0250000 0.270000 11.0277778 0.270000 11.0305556 0.270000 11.0333333 0.270667 11.0361111 0.271333 11.0388889 0.272667 11.0416667 0.272667 11.0444444 0.272667 11.0472222 0.272667 11.0500000 0.271333 11.0527778 0.270667 11.0555556 0.270667 11.0583333 0.270000 11.0611111 0.270000 11.0638889 0.270000 11.0666667 0.269333 11.0694444 0.267333 11.0722222 0.267333 11.0750000 0.268667 11.0777778 0.270000 11.0805556 0.270000 11.0833333 0.269333 11.0861111 0.268000 11.0888889 0.266667 11.0916667 0.266667 11.0944444 0.266000 11.0972222 0.268667 11.1000000 0.268667 11.1027778 0.270000 11.1055556 0.271333 11.1083333 0.272000 11.1111111 0.272000 11.1138889 0.273333 11.1166667 0.274667 11.1194444 0.275333 11.1222222 0.274667 11.1250000 0.276000 11.1277778 0.274667 11.1305556 0.274667 11.1333333 0.274000 11.1361111 0.274000 11.1388889 0.275333 11.1416667 0.278667 11.1444444 0.280667 11.1472222 0.280667 11.1500000 0.279333 11.1527778 0.280000 11.1555556 0.280000 11.1583333 0.281333 11.1611111 0.281333 11.1638889 0.280667 11.1666667 0.281333 11.1694444 0.280667 11.1722222 0.281333 11.1750000 0.282000 11.1777778 0.282000 11.1805556 0.285333 11.1833333 0.288667 11.1861111 0.294000 11.1888889 0.298000 11.1916667 0.300000 11.1944444 0.304000 11.1972222 0.304667 11.2000000 0.306000 11.2027778 0.306000 11.2055556 0.305333 11.2083333 0.306000 11.2111111 0.306667 11.2138889 0.305333 11.2166667 0.306667 11.2224444 0.300000 11.2470000 0.300000 11.2500000 0.301333 11.2527778 0.299333 11.2555556 0.296667 11.2583333 0.295333 11.2611111 0.293333 11.2638889 0.292000 11.2666667 0.290000 11.2694444 0.288000 11.2722222 0.284000 11.2750000 0.281333 11.2777778 0.276667 11.2805556 0.275333 11.2833333 0.274000 11.2861111 0.276000 11.2888889 0.276667 11.2916667 0.276000 11.2944444 0.276000 11.2972222 0.275333 11.3000000 0.274000 11.3027778 0.273333 11.3055556 0.272000 11.3083333 0.269333 11.3111111 0.268667 11.3138889 0.268000 11.3166667 0.268667 11.3194444 0.270667 11.3222222 0.270667 11.3250000 0.268667 11.3277778 0.266667 11.3305556 0.266667 11.3333333 0.266667 11.3361111 0.268000 11.3388889 0.270000 11.3416667 0.272000 11.3444444 0.272667 11.3472222 0.270000 11.3500000 0.266667 11.3527778 0.264667 11.3555556 0.264000 11.3583333 0.264667 11.3611111 0.265333 11.3638889 0.265333 11.3666667 0.266000 11.3694444 0.267333 11.3722222 0.267333 11.3750000 0.268667 11.3777778 0.269333 11.3805556 0.272667 11.3833333 0.274667 11.3861111 0.277333 11.3888889 0.277333 11.3916667 0.280000 11.3944444 0.278000 11.3972222 0.277333 11.4000000 0.274667 11.4027778 0.272000 11.4055556 0.272000 11.4083333 0.271333 11.4111111 0.271333 11.4138889 0.276667 11.4166667 0.276667 11.4194444 0.276667 11.4222222 0.277333 11.4250000 0.277333 11.4277778 0.275333 11.4305556 0.277333 11.4333333 0.278667 11.4361111 0.280667 11.4388889 0.282667 11.4416667 0.286667 11.4444444 0.287333 11.4472222 0.288000 11.4500000 0.286000 11.4527778 0.286000 11.4555556 0.284667 11.4583333 0.282000 11.4611111 0.278667 11.4638889 0.274667 11.4666667 0.270667 11.4694444 0.270000 11.4722222 0.270000 11.4750000 0.274667 11.4777778 0.281333 11.4805556 0.289333 11.4833333 0.296000 11.4861111 0.308000 11.4888889 0.323333 11.4916667 0.339333 11.4944444 0.354000 11.4972222 0.368000 11.5000000 0.380000 11.5027778 0.379333 11.5055556 0.369333 11.5083333 0.343333 11.5111111 0.310000 11.5138889 0.274667 11.5166667 0.247333 11.5194444 0.232667 11.5222222 0.228667 11.5250000 0.232000 11.5277778 0.238000 11.5305556 0.244667 11.5333333 0.251333 11.5361111 0.254000 11.5388889 0.252667 11.5416667 0.247333 11.5444444 0.242667 11.5472222 0.239333 11.5500000 0.239333 11.5527778 0.242667 11.5555556 0.248667 11.5583333 0.252667 11.5611111 0.254000 11.5638889 0.252667 11.5666667 0.253333 11.5694444 0.251333 11.5722222 0.250667 11.5750000 0.250667 11.5777778 0.251333 11.5805556 0.254667 11.5833333 0.256000 11.5861111 0.260000 11.5888889 0.266000 11.5916667 0.271333 11.5944444 0.274667 11.5972222 0.278667 11.6000000 0.281333 11.6027778 0.283333 11.6055556 0.282000 11.6083333 0.282667 11.6111111 0.285333 11.6138889 0.284667 11.6166667 0.282000 11.6194444 0.281333 11.6222222 0.281333 11.6250000 0.280667 11.6277778 0.280000 11.6305556 0.280000 11.6333333 0.282667 11.6361111 0.281333 11.6388889 0.280667 11.6416667 0.280000 11.6444444 0.278000 11.6472222 0.276667 11.6500000 0.275333 11.6527778 0.276667 11.6555556 0.278000 11.6583333 0.277333 11.6611111 0.276667 11.6638889 0.276667 11.6666667 0.277333 11.6694444 0.278667 11.6722222 0.281333 11.6750000 0.282667 11.6777778 0.283333 11.6805556 0.285333 11.6833333 0.285333 11.6861111 0.286000 11.6888889 0.285333 11.6916667 0.284000 11.6944444 0.286000 11.6972222 0.287333 11.7000000 0.288000 11.7027778 0.288667 11.7055556 0.288000 11.7083333 0.289333 11.7111111 0.288667 11.7138889 0.287333 11.7166667 0.285333 11.7194444 0.284000 11.7222222 0.284667 11.7250000 0.285333 11.7277778 0.288000 11.7305556 0.292667 11.7333333 0.295333 11.7361111 0.296667 11.7388889 0.299333 11.7416667 0.299333 11.7444444 0.300667 11.7472222 0.300667 11.7500000 0.301333 11.7527778 0.302000 11.7555556 0.300667 11.7583333 0.300667 11.7611111 0.300667 11.7638889 0.300667 11.7666667 0.302000 11.7694444 0.305333 11.7722222 0.306667 11.7750000 0.310667 11.7777778 0.314667 11.7805556 0.316000 11.7833333 0.316667 11.7861111 0.314667 11.7888889 0.311333 11.7916667 0.308000 11.7944444 0.306000 11.7972222 0.306667 11.8030000 0.300000 12.0831111 0.300000 12.0861111 0.270000 12.0888889 0.268000 12.0916667 0.269333 12.0944444 0.267333 12.0972222 0.266000 12.1000000 0.264667 12.1027778 0.265333 12.1055556 0.266667 12.1083333 0.266667 12.1111111 0.267333 12.1138889 0.268000 12.1166667 0.270000 12.1194444 0.271333 12.1222222 0.272667 12.1250000 0.274667 12.1277778 0.274667 12.1305556 0.276000 12.1333333 0.277333 12.1361111 0.278000 12.1388889 0.277333 12.1416667 0.278667 12.1444444 0.278000 12.1472222 0.276667 12.1500000 0.275333 12.1527778 0.274667 12.1555556 0.274667 12.1583333 0.273333 12.1611111 0.274667 12.1638889 0.272667 12.1666667 0.270667 12.1694444 0.269333 12.1722222 0.270000 12.1750000 0.272000 12.1777778 0.271333 12.1805556 0.274000 12.1833333 0.276000 12.1861111 0.276667 12.1888889 0.278000 12.1916667 0.276667 12.1944444 0.276667 12.1972222 0.277333 12.2000000 0.276667 12.2027778 0.276000 12.2055556 0.274667 12.2083333 0.274000 12.2111111 0.276667 12.2138889 0.279333 12.2166667 0.280667 12.2194444 0.279333 12.2222222 0.280000 12.2250000 0.278667 12.2277778 0.280000 12.2305556 0.280667 12.2333333 0.280000 12.2361111 0.278667 12.2388889 0.277333 12.2416667 0.274667 12.2444444 0.276000 12.2472222 0.275333 12.2500000 0.276000 12.2527778 0.276667 12.2555556 0.274000 12.2583333 0.274667 12.2611111 0.274667 12.2638889 0.274667 12.2666667 0.276000 12.2694444 0.277333 12.2722222 0.277333 12.2750000 0.278667 12.2777778 0.280667 12.2805556 0.281333 12.2833333 0.282000 12.2861111 0.282000 12.2888889 0.280667 12.2916667 0.280667 12.2944444 0.279333 12.2972222 0.277333 12.3000000 0.278000 12.3027778 0.278000 12.3055556 0.280000 12.3083333 0.282667 12.3111111 0.286000 12.3138889 0.288667 12.3166667 0.292667 12.3194444 0.298667 12.3222222 0.306000 12.3250000 0.319333 12.3277778 0.329333 12.3305556 0.343333 12.3333333 0.358667 12.3361111 0.369333 12.3388889 0.374667 12.3416667 0.368667 12.3444444 0.350000 12.3472222 0.318000 12.3500000 0.284000 12.3527778 0.256000 12.3555556 0.239333 12.3583333 0.231333 12.3611111 0.230000 12.3638889 0.232667 12.3666667 0.238000 12.3694444 0.242667 12.3722222 0.246667 12.3750000 0.248667 12.3777778 0.248667 12.3805556 0.248000 12.3833333 0.246667 12.3861111 0.248667 12.3888889 0.254000 12.3916667 0.256667 12.3944444 0.261333 12.3972222 0.262000 12.4000000 0.262000 12.4027778 0.260000 12.4055556 0.257333 12.4083333 0.256000 12.4111111 0.256000 12.4138889 0.258667 12.4166667 0.259333 12.4194444 0.262000 12.4222222 0.262667 12.4250000 0.266000 12.4277778 0.270000 12.4305556 0.272667 12.4333333 0.276000 12.4361111 0.277333 12.4388889 0.280667 12.4416667 0.281333 12.4444444 0.281333 12.4472222 0.280667 12.4500000 0.278667 12.4527778 0.278667 12.4555556 0.277333 12.4583333 0.276667 12.4611111 0.276667 12.4638889 0.277333 12.4666667 0.278000 12.4694444 0.279333 12.4722222 0.280667 12.4750000 0.280667 12.4777778 0.281333 12.4805556 0.281333 12.4833333 0.282667 12.4861111 0.280000 12.4888889 0.279333 12.4916667 0.279333 12.4944444 0.279333 12.4972222 0.278667 12.5000000 0.278667 12.5027778 0.280667 12.5055556 0.280000 12.5083333 0.280000 12.5111111 0.281333 12.5138889 0.282667 12.5166667 0.282667 12.5194444 0.283333 12.5222222 0.282000 12.5250000 0.284000 12.5277778 0.282667 12.5305556 0.283333 12.5333333 0.282667 12.5361111 0.284667 12.5388889 0.285333 12.5416667 0.286667 12.5444444 0.286667 12.5472222 0.287333 12.5500000 0.287333 12.5527778 0.286667 12.5555556 0.284000 12.5583333 0.284000 12.5611111 0.285333 12.5638889 0.288000 12.5666667 0.291333 12.5694444 0.291333 12.5722222 0.295333 12.5750000 0.296667 12.5777778 0.300000 12.5805556 0.299333 12.5833333 0.298667 12.5861111 0.298667 12.5888889 0.298667 12.5916667 0.300667 12.5944444 0.303333 12.5972222 0.304667 12.6000000 0.306667 12.6027778 0.307333 12.6055556 0.308667 12.6083333 0.310667 12.6111111 0.313333 12.6138889 0.314000 12.6166667 0.312667 12.6194444 0.313333 12.6222222 0.313333 12.6250000 0.312667 12.6277778 0.314667 12.6305556 0.314000 12.6333333 0.314000 12.6391111 0.300000 12.7858889 0.300000 12.7888889 0.273333 12.7916667 0.271333 12.7944444 0.270667 12.7972222 0.270667 12.8000000 0.272667 12.8027778 0.274000 12.8055556 0.276000 12.8083333 0.276667 12.8111111 0.275333 12.8138889 0.279333 12.8166667 0.279333 12.8194444 0.279333 12.8222222 0.277333 12.8250000 0.277333 12.8277778 0.278000 12.8305556 0.277333 12.8333333 0.278667 12.8361111 0.281333 12.8388889 0.283333 12.8416667 0.283333 12.8444444 0.284667 12.8472222 0.284667 12.8500000 0.282667 12.8527778 0.283333 12.8555556 0.280667 12.8583333 0.279333 12.8611111 0.280000 12.8638889 0.279333 12.8666667 0.278000 12.8694444 0.279333 12.8722222 0.279333 12.8750000 0.278667 12.8777778 0.280000 12.8805556 0.280000 12.8833333 0.279333 12.8861111 0.278000 12.8888889 0.278000 12.8916667 0.278000 12.8944444 0.278000 12.8972222 0.278000 12.9000000 0.279333 12.9027778 0.282000 12.9055556 0.282000 12.9083333 0.282667 12.9111111 0.281333 12.9138889 0.280667 12.9166667 0.278000 12.9194444 0.278667 12.9222222 0.277333 12.9250000 0.278000 12.9277778 0.278000 12.9305556 0.276667 12.9333333 0.276667 12.9361111 0.278667 12.9388889 0.278667 12.9416667 0.278667 12.9444444 0.278667 12.9472222 0.280000 12.9500000 0.282000 12.9527778 0.283333 12.9555556 0.280667 12.9583333 0.278667 12.9611111 0.275333 12.9638889 0.272667 12.9666667 0.274667 12.9694444 0.274667 12.9722222 0.276000 12.9750000 0.279333 12.9777778 0.279333 12.9805556 0.280667 12.9833333 0.280667 12.9861111 0.280000 12.9888889 0.280000 12.9916667 0.280000 12.9944444 0.281333 12.9972222 0.282000 13.0000000 0.282000 13.0027778 0.282000 13.0055556 0.282667 13.0083333 0.283333 13.0111111 0.286000 13.0138889 0.286667 13.0166667 0.291333 13.0194444 0.294000 13.0222222 0.299333 13.0250000 0.307333 13.0277778 0.318667 13.0305556 0.332667 13.0333333 0.348667 13.0361111 0.364000 13.0388889 0.375333 13.0416667 0.380000 13.0444444 0.373333 13.0472222 0.352000 13.0500000 0.321333 13.0527778 0.288000 13.0555556 0.260667 13.0583333 0.244000 13.0611111 0.233333 13.0638889 0.231333 13.0666667 0.232667 13.0694444 0.234667 13.0722222 0.238667 13.0750000 0.240667 13.0777778 0.246000 13.0805556 0.248000 13.0833333 0.248667 13.0861111 0.248000 13.0888889 0.246000 13.0916667 0.248000 13.0944444 0.249333 13.0972222 0.256667 13.1000000 0.261333 13.1027778 0.264000 13.1055556 0.265333 13.1083333 0.264000 13.1111111 0.262667 13.1138889 0.264000 13.1166667 0.261333 13.1194444 0.260667 13.1222222 0.259333 13.1250000 0.260000 13.1277778 0.259333 13.1305556 0.262000 13.1333333 0.264667 13.1361111 0.268000 13.1388889 0.274667 13.1416667 0.279333 13.1444444 0.283333 13.1472222 0.286000 13.1500000 0.286000 13.1527778 0.286667 13.1555556 0.284000 13.1583333 0.283333 13.1611111 0.282000 13.1638889 0.280000 13.1666667 0.280000 13.1694444 0.280000 13.1722222 0.282000 13.1750000 0.282667 13.1777778 0.283333 13.1805556 0.284000 13.1833333 0.284000 13.1861111 0.284667 13.1888889 0.286000 13.1916667 0.283333 13.1944444 0.284000 13.1972222 0.284000 13.2000000 0.283333 13.2027778 0.282000 13.2055556 0.282000 13.2083333 0.284000 13.2111111 0.285333 13.2138889 0.284667 13.2166667 0.285333 13.2194444 0.287333 13.2222222 0.286000 13.2250000 0.288667 13.2277778 0.287333 13.2305556 0.288000 13.2333333 0.288000 13.2361111 0.288000 13.2388889 0.289333 13.2416667 0.290667 13.2444444 0.293333 13.2472222 0.294667 13.2500000 0.295333 13.2527778 0.293333 13.2555556 0.294667 13.2583333 0.294667 13.2611111 0.293333 13.2638889 0.296000 13.2666667 0.295333 13.2694444 0.296000 13.2722222 0.298000 13.2750000 0.299333 13.2777778 0.300667 13.2805556 0.303333 13.2833333 0.304000 13.2861111 0.306667 13.2888889 0.308000 13.2916667 0.308000 13.2944444 0.308000 13.2972222 0.307333 13.3000000 0.310667 13.3027778 0.311333 13.3055556 0.312667 13.3083333 0.314667 13.3111111 0.317333 13.3138889 0.318667 13.3166667 0.319333 13.3194444 0.320000 13.3222222 0.318667 13.3250000 0.319333 13.3277778 0.318000 13.3305556 0.317333 13.3333333 0.318000 13.3361111 0.319333 13.3418889 0.300000 13.5053333 0.300000 13.5083333 0.272667 13.5111111 0.274000 13.5138889 0.275333 13.5166667 0.275333 13.5194444 0.276000 13.5222222 0.275333 13.5250000 0.274667 13.5277778 0.274667 13.5305556 0.275333 13.5333333 0.274000 13.5361111 0.276000 13.5388889 0.278667 13.5416667 0.279333 13.5444444 0.280667 13.5472222 0.281333 13.5500000 0.281333 13.5527778 0.282667 13.5555556 0.282667 13.5583333 0.282667 13.5611111 0.281333 13.5638889 0.280000 13.5666667 0.281333 13.5694444 0.280000 13.5722222 0.278667 13.5750000 0.277333 13.5777778 0.278000 13.5805556 0.280667 13.5833333 0.282000 13.5861111 0.280667 13.5888889 0.280667 13.5916667 0.281333 13.5944444 0.279333 13.5972222 0.277333 13.6000000 0.276000 13.6027778 0.276000 13.6055556 0.275333 13.6083333 0.275333 13.6111111 0.278000 13.6138889 0.280000 13.6166667 0.279333 13.6194444 0.279333 13.6222222 0.278000 13.6250000 0.278000 13.6277778 0.275333 13.6305556 0.275333 13.6333333 0.278667 13.6361111 0.278667 13.6388889 0.280000 13.6416667 0.280667 13.6444444 0.280000 13.6472222 0.278000 13.6500000 0.276000 13.6527778 0.275333 13.6555556 0.274667 13.6583333 0.273333 13.6611111 0.274000 13.6638889 0.274000 13.6666667 0.276667 13.6694444 0.276000 13.6722222 0.278000 13.6750000 0.278000 13.6777778 0.279333 13.6805556 0.280667 13.6833333 0.280667 13.6861111 0.280667 13.6888889 0.279333 13.6916667 0.277333 13.6944444 0.278000 13.6972222 0.274000 13.7000000 0.276667 13.7027778 0.277333 13.7055556 0.277333 13.7083333 0.277333 13.7111111 0.278000 13.7138889 0.278667 13.7166667 0.277333 13.7194444 0.276667 13.7222222 0.279333 13.7250000 0.279333 13.7277778 0.280667 13.7305556 0.283333 13.7333333 0.283333 13.7361111 0.284000 13.7388889 0.286667 13.7416667 0.291333 13.7444444 0.294000 13.7472222 0.302000 13.7500000 0.310000 13.7527778 0.323333 13.7555556 0.337333 13.7583333 0.353333 13.7611111 0.364667 13.7638889 0.367333 13.7666667 0.352000 13.7694444 0.322667 13.7722222 0.288667 13.7750000 0.256000 13.7777778 0.236667 13.7805556 0.228000 13.7833333 0.226000 13.7861111 0.230667 13.7888889 0.236667 13.7916667 0.240667 13.7944444 0.246000 13.7972222 0.245333 13.8000000 0.244000 13.8027778 0.243333 13.8055556 0.242000 13.8083333 0.243333 13.8111111 0.246667 13.8138889 0.253333 13.8166667 0.258000 13.8194444 0.260000 13.8222222 0.263333 13.8250000 0.260667 13.8277778 0.256667 13.8305556 0.256000 13.8333333 0.254000 13.8361111 0.254667 13.8388889 0.256000 13.8416667 0.257333 13.8444444 0.259333 13.8472222 0.261333 13.8500000 0.264667 13.8527778 0.267333 13.8555556 0.269333 13.8583333 0.272000 13.8611111 0.274000 13.8638889 0.276667 13.8666667 0.277333 13.8694444 0.276000 13.8722222 0.276667 13.8750000 0.278667 13.8777778 0.278667 13.8805556 0.279333 13.8833333 0.277333 13.8861111 0.278000 13.8888889 0.278000 13.8916667 0.275333 13.8944444 0.274667 13.8972222 0.273333 13.9000000 0.273333 13.9027778 0.272000 13.9055556 0.275333 13.9083333 0.275333 13.9111111 0.277333 13.9138889 0.278000 13.9166667 0.280000 13.9194444 0.279333 13.9222222 0.279333 13.9250000 0.279333 13.9277778 0.278000 13.9305556 0.278667 13.9333333 0.278667 13.9361111 0.277333 13.9388889 0.278000 13.9416667 0.279333 13.9444444 0.278667 13.9472222 0.281333 13.9500000 0.280667 13.9527778 0.281333 13.9555556 0.280667 13.9583333 0.280667 13.9611111 0.280000 13.9638889 0.278667 13.9666667 0.281333 13.9694444 0.280667 13.9722222 0.283333 13.9750000 0.286000 13.9777778 0.286000 13.9805556 0.288000 13.9833333 0.288667 13.9861111 0.291333 13.9888889 0.292000 13.9916667 0.291333 13.9944444 0.292667 13.9972222 0.292000 14.0000000 0.294667 14.0027778 0.296000 14.0055556 0.295333 14.0083333 0.297333 14.0111111 0.299333 14.0138889 0.302667 14.0166667 0.303333 14.0194444 0.307333 14.0222222 0.308667 14.0250000 0.307333 14.0277778 0.306667 14.0305556 0.305333 14.0333333 0.306667 14.0361111 0.306667 14.0388889 0.308000 14.0416667 0.309333 14.0444444 0.310000 14.0472222 0.308667 14.0500000 0.308667 14.0527778 0.309333 14.0555556 0.308000 14.0613333 0.300000 15.4386667 0.300000 15.4416667 0.276667 15.4444444 0.278667 15.4472222 0.279333 15.4500000 0.280000 15.4527778 0.281333 15.4555556 0.280667 15.4583333 0.278667 15.4611111 0.279333 15.4638889 0.278667 15.4666667 0.281333 15.4694444 0.281333 15.4722222 0.284667 15.4750000 0.286000 15.4777778 0.288000 15.4805556 0.289333 15.4833333 0.288000 15.4861111 0.288000 15.4888889 0.284667 15.4916667 0.284667 15.4944444 0.284000 15.4972222 0.283333 15.5000000 0.282667 15.5027778 0.283333 15.5055556 0.282000 15.5083333 0.285333 15.5111111 0.286000 15.5138889 0.286000 15.5166667 0.285333 15.5194444 0.285333 15.5222222 0.284667 15.5250000 0.286000 15.5277778 0.283333 15.5305556 0.281333 15.5333333 0.280000 15.5361111 0.278667 15.5388889 0.278667 15.5416667 0.280000 15.5444444 0.280667 15.5472222 0.282000 15.5500000 0.281333 15.5527778 0.282000 15.5555556 0.282667 15.5583333 0.282000 15.5611111 0.280667 15.5638889 0.278667 15.5666667 0.276000 15.5694444 0.276000 15.5722222 0.274000 15.5750000 0.274000 15.5777778 0.276000 15.5805556 0.276000 15.5833333 0.276000 15.5861111 0.276000 15.5888889 0.277333 15.5916667 0.277333 15.5944444 0.276000 15.5972222 0.276000 15.6000000 0.275333 15.6027778 0.273333 15.6055556 0.274000 15.6083333 0.274667 15.6111111 0.274000 15.6138889 0.276000 15.6166667 0.276000 15.6194444 0.276000 15.6222222 0.275333 15.6250000 0.275333 15.6277778 0.276000 15.6305556 0.276000 15.6333333 0.273333 15.6361111 0.274667 15.6388889 0.275333 15.6416667 0.276000 15.6444444 0.277333 15.6472222 0.277333 15.6500000 0.277333 15.6527778 0.276000 15.6555556 0.275333 15.6583333 0.276000 15.6611111 0.278667 15.6638889 0.280000 15.6666667 0.284667 15.6694444 0.288000 15.6722222 0.292000 15.6750000 0.295333 15.6777778 0.302000 15.6805556 0.309333 15.6833333 0.319333 15.6861111 0.330000 15.6888889 0.342000 15.6916667 0.351333 15.6944444 0.354667 15.6972222 0.348667 15.7000000 0.330000 15.7027778 0.301333 15.7055556 0.273333 15.7083333 0.252667 15.7111111 0.242667 15.7138889 0.238000 15.7166667 0.236667 15.7194444 0.238000 15.7222222 0.238000 15.7250000 0.240667 15.7277778 0.244000 15.7305556 0.246000 15.7333333 0.248667 15.7361111 0.247333 15.7388889 0.247333 15.7416667 0.247333 15.7444444 0.247333 15.7472222 0.253333 15.7500000 0.258000 15.7527778 0.260667 15.7555556 0.259333 15.7583333 0.260000 15.7611111 0.256000 15.7638889 0.252667 15.7666667 0.252000 15.7694444 0.252000 15.7722222 0.251333 15.7750000 0.255333 15.7777778 0.258667 15.7805556 0.258000 15.7833333 0.264000 15.7861111 0.268000 15.7888889 0.271333 15.7916667 0.273333 15.7944444 0.274000 15.7972222 0.274000 15.8000000 0.276000 15.8027778 0.274667 15.8055556 0.275333 15.8083333 0.276000 15.8111111 0.276667 15.8138889 0.276667 15.8166667 0.277333 15.8194444 0.278667 15.8222222 0.276667 15.8250000 0.276000 15.8277778 0.276000 15.8305556 0.275333 15.8333333 0.276667 15.8361111 0.278000 15.8388889 0.280667 15.8416667 0.281333 15.8444444 0.282000 15.8472222 0.281333 15.8500000 0.280667 15.8527778 0.280000 15.8555556 0.279333 15.8583333 0.276667 15.8611111 0.277333 15.8638889 0.277333 15.8666667 0.277333 15.8694444 0.280667 15.8722222 0.280000 15.8750000 0.279333 15.8777778 0.278667 15.8805556 0.279333 15.8833333 0.279333 15.8861111 0.280667 15.8888889 0.280000 15.8916667 0.282000 15.8944444 0.282667 15.8972222 0.283333 15.9000000 0.284667 15.9027778 0.284667 15.9055556 0.284000 15.9083333 0.286667 15.9111111 0.284667 15.9138889 0.286667 15.9166667 0.286667 15.9194444 0.288000 15.9222222 0.287333 15.9250000 0.286667 15.9277778 0.287333 15.9305556 0.288667 15.9333333 0.288000 15.9361111 0.289333 15.9388889 0.292000 15.9416667 0.293333 15.9444444 0.297333 15.9472222 0.298000 15.9500000 0.299333 15.9527778 0.300667 15.9555556 0.300667 15.9583333 0.298667 15.9611111 0.298000 15.9638889 0.298000 15.9666667 0.298000 15.9694444 0.300000 15.9722222 0.301333 15.9750000 0.303333 15.9777778 0.304667 15.9805556 0.306000 15.9833333 0.306000 15.9861111 0.306667 15.9888889 0.306667 15.9946667 0.300000 16.1247778 0.300000 16.1277778 0.275333 16.1305556 0.274667 16.1333333 0.274667 16.1361111 0.274000 16.1388889 0.274667 16.1416667 0.276000 16.1444444 0.278667 16.1472222 0.282667 16.1500000 0.284000 16.1527778 0.284667 16.1555556 0.286000 16.1583333 0.287333 16.1611111 0.285333 16.1638889 0.284000 16.1666667 0.282000 16.1694444 0.280667 16.1722222 0.280000 16.1750000 0.278667 16.1777778 0.281333 16.1805556 0.282667 16.1833333 0.284000 16.1861111 0.284000 16.1888889 0.282000 16.1916667 0.282000 16.1944444 0.282000 16.1972222 0.281333 16.2000000 0.282000 16.2027778 0.281333 16.2055556 0.282667 16.2083333 0.283333 16.2111111 0.282000 16.2138889 0.284667 16.2166667 0.284000 16.2194444 0.283333 16.2222222 0.284000 16.2250000 0.283333 16.2277778 0.282000 16.2305556 0.280000 16.2333333 0.281333 16.2361111 0.280000 16.2388889 0.280000 16.2416667 0.280667 16.2444444 0.282667 16.2472222 0.284000 16.2500000 0.284000 16.2527778 0.282667 16.2555556 0.280667 16.2583333 0.280667 16.2611111 0.277333 16.2638889 0.278000 16.2666667 0.279333 16.2694444 0.280000 16.2722222 0.279333 16.2750000 0.279333 16.2777778 0.281333 16.2805556 0.282000 16.2833333 0.282000 16.2861111 0.282000 16.2888889 0.282000 16.2916667 0.282667 16.2944444 0.282000 16.2972222 0.281333 16.3000000 0.281333 16.3027778 0.280667 16.3055556 0.280667 16.3083333 0.280667 16.3111111 0.281333 16.3138889 0.282000 16.3166667 0.282000 16.3194444 0.282000 16.3222222 0.283333 16.3250000 0.282667 16.3277778 0.281333 16.3305556 0.281333 16.3333333 0.281333 16.3361111 0.281333 16.3388889 0.281333 16.3416667 0.282000 16.3444444 0.283333 16.3472222 0.286000 16.3500000 0.286667 16.3527778 0.288000 16.3555556 0.288667 16.3583333 0.288667 16.3611111 0.291333 16.3638889 0.297333 16.3666667 0.306667 16.3694444 0.318667 16.3722222 0.330667 16.3750000 0.342000 16.3777778 0.350667 16.3805556 0.355333 16.3833333 0.347333 16.3861111 0.329333 16.3888889 0.303333 16.3916667 0.276667 16.3944444 0.254667 16.3972222 0.244000 16.4000000 0.242000 16.4027778 0.244667 16.4055556 0.247333 16.4083333 0.250667 16.4111111 0.254667 16.4138889 0.254667 16.4166667 0.255333 16.4194444 0.254667 16.4222222 0.250000 16.4250000 0.249333 16.4277778 0.250000 16.4305556 0.252000 16.4333333 0.256667 16.4361111 0.260667 16.4388889 0.265333 16.4416667 0.266000 16.4444444 0.262667 16.4472222 0.262667 16.4500000 0.260667 16.4527778 0.258000 16.4555556 0.257333 16.4583333 0.260667 16.4611111 0.260667 16.4638889 0.263333 16.4666667 0.264000 16.4694444 0.266667 16.4722222 0.270667 16.4750000 0.273333 16.4777778 0.274667 16.4805556 0.277333 16.4833333 0.278000 16.4861111 0.281333 16.4888889 0.280667 16.4916667 0.280000 16.4944444 0.281333 16.4972222 0.280667 16.5000000 0.279333 16.5027778 0.278667 16.5055556 0.280000 16.5083333 0.281333 16.5111111 0.281333 16.5138889 0.280667 16.5166667 0.282000 16.5194444 0.282000 16.5222222 0.282000 16.5250000 0.281333 16.5277778 0.278667 16.5305556 0.276000 16.5333333 0.275333 16.5361111 0.278667 16.5388889 0.281333 16.5416667 0.282667 16.5444444 0.284000 16.5472222 0.285333 16.5500000 0.286000 16.5527778 0.286000 16.5555556 0.285333 16.5583333 0.284000 16.5611111 0.282667 16.5638889 0.281333 16.5666667 0.282000 16.5694444 0.284000 16.5722222 0.286000 16.5750000 0.285333 16.5777778 0.284667 16.5805556 0.285333 16.5833333 0.286000 16.5861111 0.285333 16.5888889 0.285333 16.5916667 0.286000 16.5944444 0.286000 16.5972222 0.287333 16.6000000 0.288000 16.6027778 0.288000 16.6055556 0.288667 16.6083333 0.288000 16.6111111 0.289333 16.6138889 0.291333 16.6166667 0.290667 16.6194444 0.292667 16.6222222 0.294667 16.6250000 0.296667 16.6277778 0.296000 16.6305556 0.296667 16.6333333 0.298667 16.6361111 0.299333 16.6388889 0.302667 16.6416667 0.304000 16.6444444 0.307333 16.6472222 0.307333 16.6500000 0.308667 16.6527778 0.311333 16.6555556 0.312000 16.6583333 0.309333 16.6611111 0.307333 16.6638889 0.304000 16.6666667 0.301333 16.6694444 0.302667 16.6722222 0.304000 16.6750000 0.303333 16.6807778 0.300000 16.8497778 0.300000 16.8527778 0.283333 16.8555556 0.284000 16.8583333 0.283333 16.8611111 0.284667 16.8638889 0.285333 16.8666667 0.286000 16.8694444 0.286000 16.8722222 0.286000 16.8750000 0.285333 16.8777778 0.285333 16.8805556 0.284667 16.8833333 0.286000 16.8861111 0.284667 16.8888889 0.283333 16.8916667 0.283333 16.8944444 0.282000 16.8972222 0.286000 16.9000000 0.287333 16.9027778 0.289333 16.9055556 0.292000 16.9083333 0.293333 16.9111111 0.294000 16.9138889 0.292000 16.9166667 0.288000 16.9194444 0.286000 16.9222222 0.284000 16.9250000 0.283333 16.9277778 0.284000 16.9305556 0.284667 16.9333333 0.289333 16.9361111 0.289333 16.9388889 0.290667 16.9416667 0.290000 16.9444444 0.286667 16.9472222 0.285333 16.9500000 0.284000 16.9527778 0.284000 16.9555556 0.282667 16.9583333 0.284000 16.9611111 0.283333 16.9638889 0.284000 16.9666667 0.284000 16.9694444 0.285333 16.9722222 0.285333 16.9750000 0.286000 16.9777778 0.286667 16.9805556 0.288667 16.9833333 0.289333 16.9861111 0.289333 16.9888889 0.286667 16.9916667 0.284667 16.9944444 0.284000 16.9972222 0.281333 17.0000000 0.282000 17.0027778 0.282667 17.0055556 0.283333 17.0083333 0.284667 17.0111111 0.284667 17.0138889 0.286667 17.0166667 0.287333 17.0194444 0.290667 17.0222222 0.291333 17.0250000 0.291333 17.0277778 0.291333 17.0305556 0.291333 17.0333333 0.291333 17.0361111 0.290667 17.0388889 0.289333 17.0416667 0.291333 17.0444444 0.291333 17.0472222 0.293333 17.0500000 0.292667 17.0527778 0.292667 17.0555556 0.292000 17.0583333 0.289333 17.0611111 0.288667 17.0638889 0.288667 17.0666667 0.291333 17.0694444 0.292667 17.0722222 0.294667 17.0750000 0.300000 17.0777778 0.302000 17.0805556 0.303333 17.0833333 0.306667 17.0861111 0.309333 17.0888889 0.312000 17.0916667 0.316667 17.0944444 0.322667 17.0972222 0.325333 17.1000000 0.333333 17.1027778 0.339333 17.1055556 0.346000 17.1083333 0.347333 17.1111111 0.342667 17.1138889 0.330000 17.1166667 0.308667 17.1194444 0.284667 17.1222222 0.265333 17.1250000 0.253333 17.1277778 0.248000 17.1305556 0.248000 17.1333333 0.249333 17.1361111 0.254667 17.1388889 0.257333 17.1416667 0.260667 17.1444444 0.263333 17.1472222 0.265333 17.1500000 0.262000 17.1527778 0.260667 17.1555556 0.257333 17.1583333 0.259333 17.1611111 0.262667 17.1638889 0.268667 17.1666667 0.273333 17.1694444 0.277333 17.1722222 0.280000 17.1750000 0.277333 17.1777778 0.276000 17.1805556 0.274000 17.1833333 0.271333 17.1861111 0.269333 17.1888889 0.271333 17.1916667 0.270000 17.1944444 0.271333 17.1972222 0.273333 17.2000000 0.276000 17.2027778 0.278667 17.2055556 0.281333 17.2083333 0.284000 17.2111111 0.286667 17.2138889 0.292000 17.2166667 0.294000 17.2194444 0.294000 17.2222222 0.294000 17.2250000 0.291333 17.2277778 0.290000 17.2305556 0.288000 17.2333333 0.286667 17.2361111 0.285333 17.2388889 0.288667 17.2416667 0.289333 17.2444444 0.290667 17.2472222 0.291333 17.2500000 0.291333 17.2527778 0.291333 17.2555556 0.291333 17.2583333 0.290000 17.2611111 0.289333 17.2638889 0.290000 17.2666667 0.290000 17.2694444 0.289333 17.2722222 0.290000 17.2750000 0.290667 17.2777778 0.291333 17.2805556 0.293333 17.2833333 0.292667 17.2861111 0.291333 17.2888889 0.291333 17.2916667 0.288667 17.2944444 0.286667 17.2972222 0.288667 17.3000000 0.289333 17.3027778 0.289333 17.3055556 0.291333 17.3083333 0.292667 17.3111111 0.296667 17.3138889 0.296667 17.3166667 0.296667 17.3194444 0.296667 17.3222222 0.296000 17.3250000 0.296000 17.3277778 0.294667 17.3305556 0.293333 17.3333333 0.291333 17.3361111 0.293333 17.3388889 0.295333 17.3416667 0.296667 17.3444444 0.298667 17.3472222 0.300667 17.3500000 0.302000 17.3527778 0.302667 17.3555556 0.303333 17.3583333 0.304000 17.3611111 0.303333 17.3638889 0.306000 17.3666667 0.306667 17.3694444 0.308000 17.3722222 0.308000 17.3750000 0.309333 17.3777778 0.310667 17.3805556 0.312000 17.3833333 0.312000 17.3861111 0.311333 17.3888889 0.311333 17.3916667 0.310000 17.3944444 0.308667 17.3972222 0.308000 17.4000000 0.310000 17.4057778 0.300000 17.5664444 0.300000 17.5694444 0.279333 17.5722222 0.276667 17.5750000 0.279333 17.5777778 0.279333 17.5805556 0.278667 17.5833333 0.280667 17.5861111 0.280000 17.5888889 0.279333 17.5916667 0.280667 17.5944444 0.281333 17.5972222 0.279333 17.6000000 0.278667 17.6027778 0.281333 17.6055556 0.280667 17.6083333 0.282667 17.6111111 0.284000 17.6138889 0.285333 17.6166667 0.286000 17.6194444 0.286667 17.6222222 0.288667 17.6250000 0.288000 17.6277778 0.285333 17.6305556 0.284667 17.6333333 0.284667 17.6361111 0.284000 17.6388889 0.282667 17.6416667 0.283333 17.6444444 0.284667 17.6472222 0.286667 17.6500000 0.288000 17.6527778 0.288000 17.6555556 0.286000 17.6583333 0.286000 17.6611111 0.283333 17.6638889 0.282667 17.6666667 0.281333 17.6694444 0.282667 17.6722222 0.282667 17.6750000 0.284000 17.6777778 0.284000 17.6805556 0.286000 17.6833333 0.288000 17.6861111 0.286667 17.6888889 0.285333 17.6916667 0.283333 17.6944444 0.283333 17.6972222 0.283333 17.7000000 0.284667 17.7027778 0.284667 17.7055556 0.286000 17.7083333 0.286667 17.7111111 0.286000 17.7138889 0.287333 17.7166667 0.285333 17.7194444 0.285333 17.7222222 0.285333 17.7250000 0.285333 17.7277778 0.285333 17.7305556 0.284000 17.7333333 0.282667 17.7361111 0.282667 17.7388889 0.284000 17.7416667 0.285333 17.7444444 0.286000 17.7472222 0.287333 17.7500000 0.288000 17.7527778 0.288000 17.7555556 0.290000 17.7583333 0.290000 17.7611111 0.290000 17.7638889 0.288000 17.7666667 0.288000 17.7694444 0.286667 17.7722222 0.286000 17.7750000 0.286000 17.7777778 0.288667 17.7805556 0.290000 17.7833333 0.289333 17.7861111 0.290667 17.7888889 0.288667 17.7916667 0.290000 17.7944444 0.290667 17.7972222 0.293333 17.8000000 0.295333 17.8027778 0.298667 17.8055556 0.302000 17.8083333 0.306000 17.8111111 0.310667 17.8138889 0.318667 17.8166667 0.326667 17.8194444 0.337333 17.8222222 0.344667 17.8250000 0.349333 17.8277778 0.344667 17.8305556 0.330667 17.8333333 0.306000 17.8361111 0.280000 17.8388889 0.257333 17.8416667 0.245333 17.8444444 0.242667 17.8472222 0.244667 17.8500000 0.252000 17.8527778 0.258000 17.8555556 0.263333 17.8583333 0.268000 17.8611111 0.268000 17.8638889 0.265333 17.8666667 0.260667 17.8694444 0.258000 17.8722222 0.260667 17.8750000 0.265333 17.8777778 0.270667 17.8805556 0.274667 17.8833333 0.276667 17.8861111 0.276000 17.8888889 0.273333 17.8916667 0.270000 17.8944444 0.266667 17.8972222 0.267333 17.9000000 0.267333 17.9027778 0.269333 17.9055556 0.272000 17.9083333 0.275333 17.9111111 0.278000 17.9138889 0.282000 17.9166667 0.284000 17.9194444 0.286000 17.9222222 0.287333 17.9250000 0.287333 17.9277778 0.288667 17.9305556 0.287333 17.9333333 0.288000 17.9361111 0.287333 17.9388889 0.287333 17.9416667 0.287333 17.9444444 0.289333 17.9472222 0.290667 17.9500000 0.292000 17.9527778 0.291333 17.9555556 0.293333 17.9583333 0.293333 17.9611111 0.293333 17.9638889 0.290667 17.9666667 0.289333 17.9694444 0.286667 17.9722222 0.288000 17.9750000 0.288000 17.9777778 0.289333 17.9805556 0.291333 17.9833333 0.292667 17.9861111 0.292667 17.9888889 0.292000 17.9916667 0.292000 17.9944444 0.292667 17.9972222 0.290667 18.0000000 0.290000 18.0027778 0.290000 18.0055556 0.290667 18.0083333 0.292000 18.0111111 0.294000 18.0138889 0.296667 18.0166667 0.296667 18.0194444 0.294667 18.0222222 0.294667 18.0250000 0.293333 18.0277778 0.293333 18.0305556 0.293333 18.0333333 0.293333 18.0361111 0.294000 18.0388889 0.297333 18.0416667 0.299333 18.0444444 0.302667 18.0472222 0.304000 18.0500000 0.303333 18.0527778 0.305333 18.0555556 0.305333 18.0583333 0.304667 18.0611111 0.304667 18.0638889 0.305333 18.0666667 0.304000 18.0694444 0.306667 18.0722222 0.306667 18.0750000 0.309333 18.0777778 0.310667 18.0805556 0.313333 18.0833333 0.313333 18.0861111 0.313333 18.0888889 0.315333 18.0916667 0.316000 18.0944444 0.316667 18.0972222 0.316667 18.1000000 0.315333 18.1027778 0.316000 18.1055556 0.314000 18.1083333 0.316000 18.1111111 0.315333 18.1138889 0.316667 18.1166667 0.315333 18.1224444 0.300000 20.0553333 0.300000 20.0583333 0.276667 20.0611111 0.277333 20.0638889 0.278000 20.0666667 0.276000 20.0694444 0.275333 20.0722222 0.274000 20.0750000 0.274000 20.0777778 0.277333 20.0805556 0.278000 20.0833333 0.280667 20.0861111 0.281333 20.0888889 0.282000 20.0916667 0.282000 20.0944444 0.281333 20.0972222 0.281333 20.1000000 0.283333 20.1027778 0.285333 20.1055556 0.287333 20.1083333 0.286667 20.1111111 0.288000 20.1138889 0.288000 20.1166667 0.286000 20.1194444 0.286000 20.1222222 0.286000 20.1250000 0.282667 20.1277778 0.280667 20.1305556 0.280000 20.1333333 0.278667 20.1361111 0.278000 20.1388889 0.279333 20.1416667 0.278000 20.1444444 0.278000 20.1472222 0.281333 20.1500000 0.281333 20.1527778 0.280667 20.1555556 0.282000 20.1583333 0.282667 20.1611111 0.280667 20.1638889 0.280000 20.1666667 0.278000 20.1694444 0.277333 20.1722222 0.277333 20.1750000 0.278000 20.1777778 0.275333 20.1805556 0.276000 20.1833333 0.277333 20.1861111 0.275333 20.1888889 0.272667 20.1916667 0.270000 20.1944444 0.269333 20.1972222 0.268000 20.2000000 0.270000 20.2027778 0.272667 20.2055556 0.272667 20.2083333 0.273333 20.2111111 0.272000 20.2138889 0.274000 20.2166667 0.273333 20.2194444 0.273333 20.2222222 0.274000 20.2250000 0.272000 20.2277778 0.270667 20.2305556 0.270000 20.2333333 0.268000 20.2361111 0.270000 20.2388889 0.272000 20.2416667 0.274000 20.2444444 0.276000 20.2472222 0.278667 20.2500000 0.278667 20.2527778 0.276000 20.2555556 0.274667 20.2583333 0.270667 20.2611111 0.271333 20.2638889 0.268667 20.2666667 0.269333 20.2694444 0.270000 20.2722222 0.271333 20.2750000 0.273333 20.2777778 0.275333 20.2805556 0.277333 20.2833333 0.278667 20.2861111 0.279333 20.2888889 0.281333 20.2916667 0.282667 20.2944444 0.290000 20.2972222 0.298000 20.3000000 0.309333 20.3027778 0.322667 20.3055556 0.338000 20.3083333 0.352000 20.3111111 0.358667 20.3138889 0.354667 20.3166667 0.335333 20.3194444 0.306000 20.3222222 0.276667 20.3250000 0.250667 20.3277778 0.236000 20.3305556 0.228000 20.3333333 0.226000 20.3361111 0.228667 20.3388889 0.233333 20.3416667 0.240667 20.3444444 0.245333 20.3472222 0.249333 20.3500000 0.249333 20.3527778 0.247333 20.3555556 0.244000 20.3583333 0.244000 20.3611111 0.242667 20.3638889 0.247333 20.3666667 0.251333 20.3694444 0.254667 20.3722222 0.258667 20.3750000 0.257333 20.3777778 0.254000 20.3805556 0.254667 20.3833333 0.252000 20.3861111 0.251333 20.3888889 0.252000 20.3916667 0.254667 20.3944444 0.258000 20.3972222 0.260000 20.4000000 0.262667 20.4027778 0.264000 20.4055556 0.265333 20.4083333 0.267333 20.4111111 0.270667 20.4138889 0.272667 20.4166667 0.274667 20.4194444 0.274000 20.4222222 0.272000 20.4250000 0.270000 20.4277778 0.268667 20.4305556 0.268667 20.4333333 0.268667 20.4361111 0.270667 20.4388889 0.272667 20.4416667 0.274000 20.4444444 0.274667 20.4472222 0.276000 20.4500000 0.274667 20.4527778 0.273333 20.4555556 0.272000 20.4583333 0.272000 20.4611111 0.271333 20.4638889 0.271333 20.4666667 0.270000 20.4694444 0.270667 20.4722222 0.270000 20.4750000 0.272667 20.4777778 0.272000 20.4805556 0.274667 20.4833333 0.274667 20.4861111 0.274667 20.4888889 0.276000 20.4916667 0.274667 20.4944444 0.273333 20.4972222 0.272000 20.5000000 0.272000 20.5027778 0.272667 20.5055556 0.273333 20.5083333 0.272667 20.5111111 0.274000 20.5138889 0.275333 20.5166667 0.276000 20.5194444 0.277333 20.5222222 0.277333 20.5250000 0.278000 20.5277778 0.277333 20.5305556 0.277333 20.5333333 0.276667 20.5361111 0.276000 20.5388889 0.276667 20.5416667 0.279333 20.5444444 0.280000 20.5472222 0.282667 20.5500000 0.283333 20.5527778 0.283333 20.5555556 0.284000 20.5583333 0.282667 20.5611111 0.280667 20.5638889 0.280667 20.5666667 0.280000 20.5694444 0.282667 20.5722222 0.283333 20.5750000 0.286000 20.5777778 0.287333 20.5805556 0.291333 20.5833333 0.291333 20.5861111 0.293333 20.5888889 0.293333 20.5916667 0.293333 20.5944444 0.293333 20.5972222 0.292667 20.6000000 0.290667 20.6027778 0.293333 20.6055556 0.293333 20.6113333 0.300000 21.4108889 0.300000 21.4138889 0.268000 21.4166667 0.268000 21.4194444 0.267333 21.4222222 0.266667 21.4250000 0.264000 21.4277778 0.264000 21.4305556 0.264000 21.4333333 0.265333 21.4361111 0.268667 21.4388889 0.270667 21.4416667 0.272000 21.4444444 0.272667 21.4472222 0.270667 21.4500000 0.270667 21.4527778 0.270667 21.4555556 0.271333 21.4583333 0.273333 21.4611111 0.272667 21.4638889 0.272000 21.4666667 0.274000 21.4694444 0.274000 21.4722222 0.274667 21.4750000 0.273333 21.4777778 0.273333 21.4805556 0.272667 21.4833333 0.272000 21.4861111 0.272667 21.4888889 0.272000 21.4916667 0.270000 21.4944444 0.268667 21.4972222 0.266000 21.5000000 0.264000 21.5027778 0.263333 21.5055556 0.264000 21.5083333 0.265333 21.5111111 0.265333 21.5138889 0.267333 21.5166667 0.267333 21.5194444 0.270667 21.5222222 0.270000 21.5250000 0.266667 21.5277778 0.262667 21.5305556 0.259333 21.5333333 0.254000 21.5361111 0.252667 21.5388889 0.250000 21.5416667 0.250667 21.5444444 0.250667 21.5472222 0.254000 21.5500000 0.255333 21.5527778 0.258000 21.5555556 0.259333 21.5583333 0.260667 21.5611111 0.260000 21.5638889 0.257333 21.5666667 0.254667 21.5694444 0.254000 21.5722222 0.254667 21.5750000 0.256000 21.5777778 0.258000 21.5805556 0.258667 21.5833333 0.258667 21.5861111 0.259333 21.5888889 0.258667 21.5916667 0.257333 21.5944444 0.257333 21.5972222 0.255333 21.6000000 0.255333 21.6027778 0.255333 21.6055556 0.254667 21.6083333 0.255333 21.6111111 0.255333 21.6138889 0.254667 21.6166667 0.254000 21.6194444 0.254667 21.6222222 0.257333 21.6250000 0.259333 21.6277778 0.259333 21.6305556 0.260000 21.6333333 0.260000 21.6361111 0.260667 21.6388889 0.262000 21.6416667 0.263333 21.6444444 0.265333 21.6472222 0.272667 21.6500000 0.280667 21.6527778 0.293333 21.6555556 0.308000 21.6583333 0.323333 21.6611111 0.339333 21.6638889 0.352667 21.6666667 0.359333 21.6694444 0.354000 21.6722222 0.335333 21.6750000 0.302667 21.6777778 0.268000 21.6805556 0.240000 21.6833333 0.220667 21.6861111 0.210667 21.6888889 0.206667 21.6916667 0.209333 21.6944444 0.216000 21.6972222 0.222000 21.7000000 0.224000 21.7027778 0.225333 21.7055556 0.222000 21.7083333 0.220000 21.7111111 0.222667 21.7138889 0.228667 21.7166667 0.232000 21.7194444 0.236000 21.7222222 0.237333 21.7250000 0.237333 21.7277778 0.234667 21.7305556 0.232667 21.7333333 0.232000 21.7361111 0.231333 21.7388889 0.230667 21.7416667 0.234667 21.7444444 0.236000 21.7472222 0.240000 21.7500000 0.242667 21.7527778 0.243333 21.7555556 0.246000 21.7583333 0.248667 21.7611111 0.250000 21.7638889 0.249333 21.7666667 0.251333 21.7694444 0.253333 21.7722222 0.254667 21.7750000 0.257333 21.7777778 0.257333 21.7805556 0.258667 21.7833333 0.258667 21.7861111 0.258000 21.7888889 0.257333 21.7916667 0.256000 21.7944444 0.252667 21.7972222 0.250667 21.8000000 0.250000 21.8027778 0.250667 21.8055556 0.251333 21.8083333 0.252667 21.8111111 0.252667 21.8138889 0.255333 21.8166667 0.256667 21.8194444 0.256667 21.8222222 0.258667 21.8250000 0.256667 21.8277778 0.257333 21.8305556 0.257333 21.8333333 0.257333 21.8361111 0.256000 21.8388889 0.258000 21.8416667 0.259333 21.8444444 0.260000 21.8472222 0.262000 21.8500000 0.263333 21.8527778 0.264000 21.8555556 0.264000 21.8583333 0.261333 21.8611111 0.260000 21.8638889 0.260000 21.8666667 0.260667 21.8694444 0.260667 21.8722222 0.260000 21.8750000 0.262667 21.8777778 0.263333 21.8805556 0.266000 21.8833333 0.269333 21.8861111 0.270667 21.8888889 0.271333 21.8916667 0.272000 21.8944444 0.273333 21.8972222 0.273333 21.9000000 0.272000 21.9027778 0.274000 21.9055556 0.273333 21.9083333 0.276000 21.9111111 0.278667 21.9138889 0.282000 21.9166667 0.284000 21.9194444 0.286667 21.9222222 0.287333 21.9250000 0.288000 21.9277778 0.287333 21.9305556 0.289333 21.9333333 0.289333 21.9361111 0.290667 21.9388889 0.291333 21.9416667 0.294667 21.9444444 0.298000 21.9472222 0.298000 21.9500000 0.299333 21.9527778 0.298667 21.9555556 0.298667 21.9583333 0.298667 21.9611111 0.296667 21.9668889 0.300000 22.1053333 0.300000 22.1083333 0.246000 22.1111111 0.246000 22.1138889 0.245333 22.1166667 0.246667 22.1194444 0.246000 22.1222222 0.247333 22.1250000 0.246667 22.1277778 0.248000 22.1305556 0.250000 22.1333333 0.250000 22.1361111 0.250667 22.1388889 0.252000 22.1416667 0.254000 22.1444444 0.256667 22.1472222 0.258667 22.1500000 0.258667 22.1527778 0.260000 22.1555556 0.259333 22.1583333 0.257333 22.1611111 0.257333 22.1638889 0.254667 22.1666667 0.254000 22.1694444 0.252667 22.1722222 0.254667 22.1750000 0.255333 22.1777778 0.259333 22.1805556 0.261333 22.1833333 0.262667 22.1861111 0.263333 22.1888889 0.262667 22.1916667 0.260000 22.1944444 0.258000 22.1972222 0.255333 22.2000000 0.255333 22.2027778 0.256000 22.2055556 0.256667 22.2083333 0.260667 22.2111111 0.262667 22.2138889 0.264000 22.2166667 0.261333 22.2194444 0.260667 22.2222222 0.258667 22.2250000 0.256667 22.2277778 0.256000 22.2305556 0.256000 22.2333333 0.257333 22.2361111 0.257333 22.2388889 0.259333 22.2416667 0.259333 22.2444444 0.261333 22.2472222 0.261333 22.2500000 0.262667 22.2527778 0.262000 22.2555556 0.260667 22.2583333 0.257333 22.2611111 0.258667 22.2638889 0.257333 22.2666667 0.254667 22.2694444 0.253333 22.2722222 0.255333 22.2750000 0.255333 22.2777778 0.258000 22.2805556 0.258000 22.2833333 0.258667 22.2861111 0.258000 22.2888889 0.260667 22.2916667 0.261333 22.2944444 0.263333 22.2972222 0.260667 22.3000000 0.260000 22.3027778 0.260000 22.3055556 0.260000 22.3083333 0.261333 22.3111111 0.262000 22.3138889 0.262667 22.3166667 0.264000 22.3194444 0.264000 22.3222222 0.263333 22.3250000 0.262667 22.3277778 0.261333 22.3305556 0.262000 22.3333333 0.264000 22.3361111 0.266000 22.3388889 0.272667 22.3416667 0.280667 22.3444444 0.296000 22.3472222 0.313333 22.3500000 0.332000 22.3527778 0.352667 22.3555556 0.371333 22.3583333 0.384667 22.3611111 0.385333 22.3638889 0.371333 22.3666667 0.341333 22.3694444 0.302667 22.3722222 0.262667 22.3750000 0.231333 22.3777778 0.215333 22.3805556 0.210000 22.3833333 0.210667 22.3861111 0.217333 22.3888889 0.224000 22.3916667 0.228000 22.3944444 0.230000 22.3972222 0.231333 22.4000000 0.230667 22.4027778 0.226000 22.4055556 0.226000 22.4083333 0.223333 22.4111111 0.226000 22.4138889 0.230000 22.4166667 0.234000 22.4194444 0.238667 22.4222222 0.242667 22.4250000 0.243333 22.4277778 0.240000 22.4305556 0.238667 22.4333333 0.236667 22.4361111 0.238000 22.4388889 0.238667 22.4416667 0.240000 22.4444444 0.240000 22.4472222 0.244000 22.4500000 0.246000 22.4527778 0.248000 22.4555556 0.250667 22.4583333 0.252000 22.4611111 0.253333 22.4638889 0.253333 22.4666667 0.254000 22.4694444 0.254667 22.4722222 0.256667 22.4750000 0.259333 22.4777778 0.260667 22.4805556 0.262000 22.4833333 0.262667 22.4861111 0.262000 22.4888889 0.263333 22.4916667 0.262667 22.4944444 0.261333 22.4972222 0.259333 22.5000000 0.259333 22.5027778 0.258667 22.5055556 0.260000 22.5083333 0.260667 22.5111111 0.260000 22.5138889 0.262667 22.5166667 0.264000 22.5194444 0.264000 22.5222222 0.262667 22.5250000 0.262667 22.5277778 0.261333 22.5305556 0.262667 22.5333333 0.259333 22.5361111 0.261333 22.5388889 0.262000 22.5416667 0.263333 22.5444444 0.264000 22.5472222 0.265333 22.5500000 0.266667 22.5527778 0.266667 22.5555556 0.266667 22.5583333 0.266000 22.5611111 0.266667 22.5638889 0.268667 22.5666667 0.269333 22.5694444 0.271333 22.5722222 0.271333 22.5750000 0.274000 22.5777778 0.274000 22.5805556 0.276667 22.5833333 0.276667 22.5861111 0.277333 22.5888889 0.276667 22.5916667 0.278667 22.5944444 0.280667 22.5972222 0.281333 22.6000000 0.282000 22.6027778 0.284000 22.6055556 0.284667 22.6083333 0.288000 22.6111111 0.292000 22.6138889 0.295333 22.6166667 0.295333 22.6194444 0.297333 22.6222222 0.297333 22.6250000 0.298667 22.6277778 0.299333 22.6305556 0.298667 22.6333333 0.299333 22.6361111 0.300667 22.6388889 0.303333 22.6416667 0.305333 22.6444444 0.306667 22.6472222 0.308000 22.6500000 0.306667 22.6527778 0.306000 22.6555556 0.305333 22.6613333 0.300000 22.8470000 0.300000 22.8500000 0.258000 22.8527778 0.257333 22.8555556 0.260000 22.8583333 0.258667 22.8611111 0.258667 22.8638889 0.258667 22.8666667 0.258000 22.8694444 0.258667 22.8722222 0.260000 22.8750000 0.259333 22.8777778 0.258667 22.8805556 0.260000 22.8833333 0.260667 22.8861111 0.262000 22.8888889 0.264000 22.8916667 0.264000 22.8944444 0.263333 22.8972222 0.262000 22.9000000 0.262667 22.9027778 0.263333 22.9055556 0.264000 22.9083333 0.264667 22.9111111 0.265333 22.9138889 0.264000 22.9166667 0.263333 22.9194444 0.263333 22.9222222 0.262667 22.9250000 0.263333 22.9277778 0.260667 22.9305556 0.260000 22.9333333 0.257333 22.9361111 0.257333 22.9388889 0.256667 22.9416667 0.258000 22.9444444 0.259333 22.9472222 0.262667 22.9500000 0.262667 22.9527778 0.264000 22.9555556 0.264667 22.9583333 0.264667 22.9611111 0.264667 22.9638889 0.263333 22.9666667 0.264000 22.9694444 0.262000 22.9722222 0.259333 22.9750000 0.260667 22.9777778 0.262000 22.9805556 0.261333 22.9833333 0.264000 22.9861111 0.263333 22.9888889 0.264000 22.9916667 0.263333 22.9944444 0.262667 22.9972222 0.262667 23.0000000 0.260667 23.0027778 0.262000 23.0055556 0.260667 23.0083333 0.262000 23.0111111 0.262667 23.0138889 0.264667 23.0166667 0.267333 23.0194444 0.265333 23.0222222 0.265333 23.0250000 0.264667 23.0277778 0.264000 23.0305556 0.262000 23.0333333 0.261333 23.0361111 0.260000 23.0388889 0.260000 23.0416667 0.262000 23.0444444 0.263333 23.0472222 0.266000 23.0500000 0.269333 23.0527778 0.269333 23.0555556 0.270000 23.0583333 0.269333 23.0611111 0.268667 23.0638889 0.268667 23.0666667 0.267333 23.0694444 0.267333 23.0722222 0.270000 23.0750000 0.273333 23.0777778 0.276667 23.0805556 0.283333 23.0833333 0.290000 23.0861111 0.300000 23.0888889 0.314000 23.0916667 0.329333 23.0944444 0.344667 23.0972222 0.362000 23.1000000 0.374000 23.1027778 0.380667 23.1055556 0.370000 23.1083333 0.342000 23.1111111 0.303333 23.1138889 0.265333 23.1166667 0.234667 23.1194444 0.214667 23.1222222 0.206667 23.1250000 0.208000 23.1277778 0.213333 23.1305556 0.218000 23.1333333 0.225333 23.1361111 0.232000 23.1388889 0.234000 23.1416667 0.235333 23.1444444 0.234667 23.1472222 0.234667 23.1500000 0.234667 23.1527778 0.237333 23.1555556 0.238667 23.1583333 0.242667 23.1611111 0.246667 23.1638889 0.248667 23.1666667 0.248667 23.1694444 0.248000 23.1722222 0.246667 23.1750000 0.245333 23.1777778 0.244000 23.1805556 0.242000 23.1833333 0.244000 23.1861111 0.244667 23.1888889 0.248000 23.1916667 0.248667 23.1944444 0.250000 23.1972222 0.254000 23.2000000 0.255333 23.2027778 0.260667 23.2055556 0.262667 23.2083333 0.265333 23.2111111 0.268667 23.2138889 0.269333 23.2166667 0.270000 23.2194444 0.268000 23.2222222 0.266000 23.2250000 0.266000 23.2277778 0.265333 23.2305556 0.266667 23.2333333 0.266667 23.2361111 0.266667 23.2388889 0.267333 23.2416667 0.268000 23.2444444 0.268000 23.2472222 0.269333 23.2500000 0.269333 23.2527778 0.270667 23.2555556 0.272000 23.2583333 0.271333 23.2611111 0.271333 23.2638889 0.270000 23.2666667 0.269333 23.2694444 0.268000 23.2722222 0.268667 23.2750000 0.269333 23.2777778 0.268000 23.2805556 0.268000 23.2833333 0.266667 23.2861111 0.269333 23.2888889 0.270667 23.2916667 0.270000 23.2944444 0.270000 23.2972222 0.272000 23.3000000 0.270667 23.3027778 0.272667 23.3055556 0.274000 23.3083333 0.276000 23.3111111 0.276000 23.3138889 0.276000 23.3166667 0.277333 23.3194444 0.275333 23.3222222 0.274667 23.3250000 0.274000 23.3277778 0.275333 23.3305556 0.277333 23.3333333 0.279333 23.3361111 0.281333 23.3388889 0.284667 23.3416667 0.287333 23.3444444 0.289333 23.3472222 0.292667 23.3500000 0.293333 23.3527778 0.296667 23.3555556 0.296667 23.3583333 0.296667 23.3611111 0.298000 23.3638889 0.298000 23.3666667 0.298667 23.3694444 0.299333 23.3722222 0.299333 23.3750000 0.301333 23.3777778 0.304000 23.3805556 0.306667 23.3833333 0.308000 23.3861111 0.309333 23.3888889 0.308667 23.3916667 0.308000 23.3944444 0.308667 23.3972222 0.308000 23.4030000 0.300000 23.5636667 0.300000 23.5666667 0.260667 23.5694444 0.261333 23.5722222 0.262667 23.5750000 0.264667 23.5777778 0.265333 23.5805556 0.266000 23.5833333 0.266000 23.5861111 0.267333 23.5888889 0.266667 23.5916667 0.266667 23.5944444 0.265333 23.5972222 0.264667 23.6000000 0.264667 23.6027778 0.265333 23.6055556 0.267333 23.6083333 0.269333 23.6111111 0.272667 23.6138889 0.274667 23.6166667 0.276000 23.6194444 0.276667 23.6222222 0.275333 23.6250000 0.272000 23.6277778 0.270667 23.6305556 0.268667 23.6333333 0.266667 23.6361111 0.266667 23.6388889 0.266000 23.6416667 0.267333 23.6444444 0.269333 23.6472222 0.268000 23.6500000 0.268667 23.6527778 0.266000 23.6555556 0.266000 23.6583333 0.262667 23.6611111 0.264000 23.6638889 0.265333 23.6666667 0.266667 23.6694444 0.269333 23.6722222 0.272667 23.6750000 0.273333 23.6777778 0.273333 23.6805556 0.272000 23.6833333 0.272000 23.6861111 0.268667 23.6888889 0.268000 23.6916667 0.267333 23.6944444 0.267333 23.6972222 0.268000 23.7000000 0.268000 23.7027778 0.267333 23.7055556 0.266000 23.7083333 0.266667 23.7111111 0.267333 23.7138889 0.268667 23.7166667 0.269333 23.7194444 0.270000 23.7222222 0.272667 23.7250000 0.274000 23.7277778 0.274667 23.7305556 0.272667 23.7333333 0.271333 23.7361111 0.270667 23.7388889 0.268667 23.7416667 0.269333 23.7444444 0.268000 23.7472222 0.268000 23.7500000 0.266667 23.7527778 0.266667 23.7555556 0.268667 23.7583333 0.265333 23.7611111 0.268667 23.7638889 0.268667 23.7666667 0.268667 23.7694444 0.270667 23.7722222 0.270000 23.7750000 0.271333 23.7777778 0.272000 23.7805556 0.276000 23.7833333 0.276000 23.7861111 0.276000 23.7888889 0.278000 23.7916667 0.278667 23.7944444 0.281333 23.7972222 0.285333 23.8000000 0.293333 23.8027778 0.307333 23.8055556 0.324000 23.8083333 0.344667 23.8111111 0.364667 23.8138889 0.382000 23.8166667 0.394000 23.8194444 0.394000 23.8222222 0.382000 23.8250000 0.354000 23.8277778 0.313333 23.8305556 0.272000 23.8333333 0.238000 23.8361111 0.219333 23.8388889 0.210667 23.8416667 0.211333 23.8444444 0.216000 23.8472222 0.222667 23.8500000 0.228000 23.8527778 0.234667 23.8555556 0.238000 23.8583333 0.239333 23.8611111 0.238000 23.8638889 0.234667 23.8666667 0.233333 23.8694444 0.233333 23.8722222 0.236000 23.8750000 0.243333 23.8777778 0.248000 23.8805556 0.254000 23.8833333 0.255333 23.8861111 0.252000 23.8888889 0.249333 23.8916667 0.246000 23.8944444 0.246667 23.8972222 0.246000 23.9000000 0.244667 23.9027778 0.246667 23.9055556 0.248000 23.9083333 0.250667 23.9111111 0.254000 23.9138889 0.257333 23.9166667 0.261333 23.9194444 0.265333 23.9222222 0.268667 23.9250000 0.269333 23.9277778 0.268667 23.9305556 0.269333 23.9333333 0.267333 23.9361111 0.268000 23.9388889 0.266667 23.9416667 0.266000 23.9444444 0.266667 23.9472222 0.268000 23.9500000 0.268667 23.9527778 0.268000 23.9555556 0.270667 23.9583333 0.270000 23.9611111 0.270667 23.9638889 0.269333 23.9666667 0.268667 23.9694444 0.270000 23.9722222 0.270667 23.9750000 0.271333 23.9777778 0.271333 23.9805556 0.272000 23.9833333 0.272667 23.9861111 0.272000 23.9888889 0.274667 23.9916667 0.271333 23.9944444 0.271333 23.9972222 0.270000 24.0000000 0.270667 24.0027778 0.271333 24.0055556 0.271333 24.0083333 0.273333 24.0111111 0.276667 24.0138889 0.278000 24.0166667 0.279333 24.0194444 0.278000 24.0222222 0.277333 24.0250000 0.277333 24.0277778 0.276000 24.0305556 0.275333 24.0333333 0.274000 24.0361111 0.275333 24.0388889 0.276000 24.0416667 0.278000 24.0444444 0.280667 24.0472222 0.282000 24.0500000 0.283333 24.0527778 0.284000 24.0555556 0.286667 24.0583333 0.287333 24.0611111 0.287333 24.0638889 0.288000 24.0666667 0.290667 24.0694444 0.291333 24.0722222 0.292667 24.0750000 0.295333 24.0777778 0.298000 24.0805556 0.300000 24.0833333 0.301333 24.0861111 0.302667 24.0888889 0.303333 24.0916667 0.304000 24.0944444 0.304000 24.0972222 0.304000 24.1000000 0.304667 24.1027778 0.305333 24.1055556 0.306000 24.1083333 0.308000 24.1111111 0.310667 24.1138889 0.310000 24.1196667 0.300000 24.3025556 0.300000 24.3055556 0.262000 24.3083333 0.263333 24.3111111 0.264000 24.3138889 0.266667 24.3166667 0.269333 24.3194444 0.268667 24.3222222 0.268000 24.3250000 0.267333 24.3277778 0.267333 24.3305556 0.266667 24.3333333 0.268000 24.3361111 0.267333 24.3388889 0.267333 24.3416667 0.268667 24.3444444 0.271333 24.3472222 0.272667 24.3500000 0.276000 24.3527778 0.276667 24.3555556 0.276000 24.3583333 0.276000 24.3611111 0.272667 24.3638889 0.272000 24.3666667 0.270000 24.3694444 0.270667 24.3722222 0.270000 24.3750000 0.270667 24.3777778 0.270667 24.3805556 0.270667 24.3833333 0.270000 24.3861111 0.269333 24.3888889 0.267333 24.3916667 0.267333 24.3944444 0.266667 24.3972222 0.264667 24.4000000 0.266667 24.4027778 0.267333 24.4055556 0.269333 24.4083333 0.270667 24.4111111 0.272667 24.4138889 0.274000 24.4166667 0.274000 24.4194444 0.272667 24.4222222 0.271333 24.4250000 0.269333 24.4277778 0.267333 24.4305556 0.266000 24.4333333 0.268000 24.4361111 0.266000 24.4388889 0.267333 24.4416667 0.266667 24.4444444 0.267333 24.4472222 0.268667 24.4500000 0.272000 24.4527778 0.272000 24.4555556 0.271333 24.4583333 0.272000 24.4611111 0.270000 24.4638889 0.269333 24.4666667 0.267333 24.4694444 0.267333 24.4722222 0.267333 24.4750000 0.267333 24.4777778 0.267333 24.4805556 0.271333 24.4833333 0.271333 24.4861111 0.271333 24.4888889 0.270000 24.4916667 0.268667 24.4944444 0.268000 24.4972222 0.268000 24.5000000 0.269333 24.5027778 0.269333 24.5055556 0.270000 24.5083333 0.272000 24.5111111 0.273333 24.5138889 0.274000 24.5166667 0.274000 24.5194444 0.272000 24.5222222 0.273333 24.5250000 0.272000 24.5277778 0.272667 24.5305556 0.274000 24.5333333 0.274000 24.5361111 0.279333 24.5388889 0.285333 24.5416667 0.294667 24.5444444 0.307333 24.5472222 0.325333 24.5500000 0.341333 24.5527778 0.360000 24.5555556 0.376000 24.5583333 0.383333 24.5611111 0.376000 24.5638889 0.352667 24.5666667 0.314667 24.5694444 0.275333 24.5722222 0.242667 24.5750000 0.221333 24.5777778 0.215333 24.5805556 0.214000 24.5833333 0.219333 24.5861111 0.225333 24.5888889 0.234000 24.5916667 0.239333 24.5944444 0.242000 24.5972222 0.242667 24.6000000 0.241333 24.6027778 0.237333 24.6055556 0.236000 24.6083333 0.237333 24.6111111 0.241333 24.6138889 0.247333 24.6166667 0.252667 24.6194444 0.255333 24.6222222 0.256000 24.6250000 0.253333 24.6277778 0.252000 24.6305556 0.248000 24.6333333 0.246667 24.6361111 0.246000 24.6388889 0.248000 24.6416667 0.248000 24.6444444 0.252000 24.6472222 0.254000 24.6500000 0.258000 24.6527778 0.259333 24.6555556 0.262667 24.6583333 0.265333 24.6611111 0.267333 24.6638889 0.268000 24.6666667 0.268667 24.6694444 0.267333 24.6722222 0.269333 24.6750000 0.270000 24.6777778 0.270000 24.6805556 0.272000 24.6833333 0.270667 24.6861111 0.270000 24.6888889 0.270000 24.6916667 0.271333 24.6944444 0.272667 24.6972222 0.272667 24.7000000 0.272667 24.7027778 0.273333 24.7055556 0.271333 24.7083333 0.270667 24.7111111 0.273333 24.7138889 0.272667 24.7166667 0.272667 24.7194444 0.271333 24.7222222 0.272000 24.7250000 0.272000 24.7277778 0.272000 24.7305556 0.273333 24.7333333 0.273333 24.7361111 0.272667 24.7388889 0.272000 24.7416667 0.274000 24.7444444 0.274667 24.7472222 0.276667 24.7500000 0.277333 24.7527778 0.276000 24.7555556 0.276000 24.7583333 0.276000 24.7611111 0.274667 24.7638889 0.274667 24.7666667 0.276000 24.7694444 0.277333 24.7722222 0.280000 24.7750000 0.282667 24.7777778 0.285333 24.7805556 0.287333 24.7833333 0.287333 24.7861111 0.289333 24.7888889 0.287333 24.7916667 0.286000 24.7944444 0.287333 24.7972222 0.288000 24.8000000 0.289333 24.8027778 0.292667 24.8055556 0.293333 24.8083333 0.296000 24.8111111 0.297333 24.8138889 0.300000 24.8166667 0.303333 24.8194444 0.304000 24.8222222 0.306000 24.8250000 0.305333 24.8277778 0.304667 24.8305556 0.307333 24.8333333 0.307333 24.8361111 0.308667 24.8388889 0.308667 24.8416667 0.310000 24.8444444 0.310000 24.8472222 0.312667 24.8500000 0.312667 24.8527778 0.312667 24.8585556 0.300000 25.0525556 0.300000 25.0555556 0.265333 25.0583333 0.266000 25.0611111 0.262667 25.0638889 0.262000 25.0666667 0.262000 25.0694444 0.260000 25.0722222 0.260667 25.0750000 0.263333 25.0777778 0.266000 25.0805556 0.268667 25.0833333 0.270000 25.0861111 0.272000 25.0888889 0.272667 25.0916667 0.273333 25.0944444 0.272667 25.0972222 0.270000 25.1000000 0.268000 25.1027778 0.269333 25.1055556 0.268000 25.1083333 0.268000 25.1111111 0.268000 25.1138889 0.268667 25.1166667 0.268667 25.1194444 0.266667 25.1222222 0.266000 25.1250000 0.264667 25.1277778 0.263333 25.1305556 0.261333 25.1333333 0.262000 25.1361111 0.263333 25.1388889 0.266000 25.1416667 0.268000 25.1444444 0.270667 25.1472222 0.273333 25.1500000 0.274667 25.1527778 0.272667 25.1555556 0.272667 25.1583333 0.269333 25.1611111 0.267333 25.1638889 0.266000 25.1666667 0.264667 25.1694444 0.265333 25.1722222 0.265333 25.1750000 0.268667 25.1777778 0.272000 25.1805556 0.272000 25.1833333 0.272000 25.1861111 0.272667 25.1888889 0.271333 25.1916667 0.270667 25.1944444 0.271333 25.1972222 0.270000 25.2000000 0.270000 25.2027778 0.268667 25.2055556 0.267333 25.2083333 0.268667 25.2111111 0.269333 25.2138889 0.270667 25.2166667 0.270667 25.2194444 0.269333 25.2222222 0.269333 25.2250000 0.270000 25.2277778 0.270000 25.2305556 0.270000 25.2333333 0.270667 25.2361111 0.272000 25.2388889 0.272667 25.2416667 0.273333 25.2444444 0.274000 25.2472222 0.274667 25.2500000 0.274667 25.2527778 0.274667 25.2555556 0.276000 25.2583333 0.274000 25.2611111 0.273333 25.2638889 0.272000 25.2666667 0.270667 25.2694444 0.270667 25.2722222 0.270667 25.2750000 0.272000 25.2777778 0.275333 25.2805556 0.280000 25.2833333 0.285333 25.2861111 0.294667 25.2888889 0.301333 25.2916667 0.312667 25.2944444 0.325333 25.2972222 0.338667 25.3000000 0.351333 25.3027778 0.365333 25.3055556 0.378000 25.3083333 0.382000 25.3111111 0.376000 25.3138889 0.354667 25.3166667 0.319333 25.3194444 0.281333 25.3222222 0.248000 25.3250000 0.226000 25.3277778 0.216667 25.3305556 0.215333 25.3333333 0.219333 25.3361111 0.226000 25.3388889 0.232000 25.3416667 0.237333 25.3444444 0.242000 25.3472222 0.242000 25.3500000 0.242667 25.3527778 0.240000 25.3555556 0.240000 25.3583333 0.239333 25.3611111 0.244000 25.3638889 0.249333 25.3666667 0.252667 25.3694444 0.256667 25.3722222 0.255333 25.3750000 0.254667 25.3777778 0.252000 25.3805556 0.251333 25.3833333 0.250667 25.3861111 0.252000 25.3888889 0.253333 25.3916667 0.254667 25.3944444 0.257333 25.3972222 0.257333 25.4000000 0.260000 25.4027778 0.262667 25.4055556 0.264667 25.4083333 0.268667 25.4111111 0.270667 25.4138889 0.272667 25.4166667 0.274000 25.4194444 0.271333 25.4222222 0.272000 25.4250000 0.270667 25.4277778 0.270000 25.4305556 0.269333 25.4333333 0.270667 25.4361111 0.271333 25.4388889 0.271333 25.4416667 0.271333 25.4444444 0.272000 25.4472222 0.273333 25.4500000 0.273333 25.4527778 0.274000 25.4555556 0.274000 25.4583333 0.275333 25.4611111 0.274667 25.4638889 0.272667 25.4666667 0.271333 25.4694444 0.272000 25.4722222 0.272667 25.4750000 0.273333 25.4777778 0.276000 25.4805556 0.278667 25.4833333 0.280000 25.4861111 0.280000 25.4888889 0.277333 25.4916667 0.277333 25.4944444 0.276000 25.4972222 0.274000 25.5000000 0.273333 25.5027778 0.275333 25.5055556 0.276667 25.5083333 0.278000 25.5111111 0.280667 25.5138889 0.283333 25.5166667 0.282667 25.5194444 0.283333 25.5222222 0.282667 25.5250000 0.284667 25.5277778 0.286000 25.5305556 0.288000 25.5333333 0.289333 25.5361111 0.290000 25.5388889 0.291333 25.5416667 0.292000 25.5444444 0.293333 25.5472222 0.296000 25.5500000 0.298667 25.5527778 0.299333 25.5555556 0.300667 25.5583333 0.300000 25.5611111 0.300000 25.5638889 0.304667 25.5666667 0.306000 25.5694444 0.306667 25.5722222 0.311333 25.5750000 0.314000 25.5777778 0.314000 25.5805556 0.314000 25.5833333 0.314000 25.5861111 0.314000 25.5888889 0.314000 25.5916667 0.314000 25.5944444 0.313333 25.5972222 0.313333 25.6000000 0.310667 25.6027778 0.309333 25.6085556 0.300000 25.7831111 0.300000 25.7861111 0.267333 25.7888889 0.267333 25.7916667 0.266667 25.7944444 0.266667 25.7972222 0.265333 25.8000000 0.267333 25.8027778 0.268000 25.8055556 0.270000 25.8083333 0.272667 25.8111111 0.272667 25.8138889 0.273333 25.8166667 0.273333 25.8194444 0.274000 25.8222222 0.274667 25.8250000 0.272667 25.8277778 0.273333 25.8305556 0.272000 25.8333333 0.271333 25.8361111 0.272000 25.8388889 0.272000 25.8416667 0.273333 25.8444444 0.273333 25.8472222 0.273333 25.8500000 0.274667 25.8527778 0.273333 25.8555556 0.274000 25.8583333 0.274667 25.8611111 0.273333 25.8638889 0.275333 25.8666667 0.274000 25.8694444 0.273333 25.8722222 0.270667 25.8750000 0.269333 25.8777778 0.268000 25.8805556 0.266667 25.8833333 0.269333 25.8861111 0.270000 25.8888889 0.271333 25.8916667 0.274667 25.8944444 0.274000 25.8972222 0.272667 25.9000000 0.270667 25.9027778 0.272000 25.9055556 0.272000 25.9083333 0.270667 25.9111111 0.274667 25.9138889 0.276000 25.9166667 0.277333 25.9194444 0.275333 25.9222222 0.274667 25.9250000 0.274000 25.9277778 0.272667 25.9305556 0.270667 25.9333333 0.270000 25.9361111 0.269333 25.9388889 0.270000 25.9416667 0.270667 25.9444444 0.271333 25.9472222 0.272667 25.9500000 0.275333 25.9527778 0.274667 25.9555556 0.275333 25.9583333 0.276000 25.9611111 0.274000 25.9638889 0.272667 25.9666667 0.271333 25.9694444 0.271333 25.9722222 0.272000 25.9750000 0.274000 25.9777778 0.274000 25.9805556 0.274000 25.9833333 0.274667 25.9861111 0.274667 25.9888889 0.274000 25.9916667 0.274000 25.9944444 0.275333 25.9972222 0.273333 26.0000000 0.276667 26.0027778 0.276000 26.0055556 0.277333 26.0083333 0.280000 26.0111111 0.281333 26.0138889 0.284000 26.0166667 0.288667 26.0194444 0.292667 26.0222222 0.301333 26.0250000 0.316667 26.0277778 0.330667 26.0305556 0.348667 26.0333333 0.367333 26.0361111 0.383333 26.0388889 0.396000 26.0416667 0.398667 26.0444444 0.387333 26.0472222 0.357333 26.0500000 0.316000 26.0527778 0.273333 26.0555556 0.242667 26.0583333 0.224667 26.0611111 0.216667 26.0638889 0.216667 26.0666667 0.220000 26.0694444 0.226000 26.0722222 0.232000 26.0750000 0.238000 26.0777778 0.241333 26.0805556 0.242000 26.0833333 0.242000 26.0861111 0.240000 26.0888889 0.238667 26.0916667 0.240000 26.0944444 0.246000 26.0972222 0.250000 26.1000000 0.253333 26.1027778 0.258000 26.1055556 0.258667 26.1083333 0.256667 26.1111111 0.254667 26.1138889 0.252000 26.1166667 0.251333 26.1194444 0.251333 26.1222222 0.251333 26.1250000 0.251333 26.1277778 0.253333 26.1305556 0.255333 26.1333333 0.258667 26.1361111 0.262000 26.1388889 0.266000 26.1416667 0.270667 26.1444444 0.273333 26.1472222 0.276000 26.1500000 0.276000 26.1527778 0.276000 26.1555556 0.275333 26.1583333 0.272667 26.1611111 0.272000 26.1638889 0.270667 26.1666667 0.269333 26.1694444 0.269333 26.1722222 0.270000 26.1750000 0.273333 26.1777778 0.274000 26.1805556 0.276000 26.1833333 0.276000 26.1861111 0.277333 26.1888889 0.278000 26.1916667 0.276667 26.1944444 0.276000 26.1972222 0.276667 26.2000000 0.274667 26.2027778 0.276000 26.2055556 0.276000 26.2083333 0.274667 26.2111111 0.277333 26.2138889 0.278667 26.2166667 0.279333 26.2194444 0.279333 26.2222222 0.278667 26.2250000 0.277333 26.2277778 0.276000 26.2305556 0.276667 26.2333333 0.277333 26.2361111 0.278000 26.2388889 0.282000 26.2416667 0.282667 26.2444444 0.284667 26.2472222 0.287333 26.2500000 0.285333 26.2527778 0.285333 26.2555556 0.285333 26.2583333 0.285333 26.2611111 0.283333 26.2638889 0.284667 26.2666667 0.285333 26.2694444 0.287333 26.2722222 0.289333 26.2750000 0.290667 26.2777778 0.292000 26.2805556 0.296667 26.2833333 0.299333 26.2861111 0.301333 26.2888889 0.302667 26.2916667 0.306667 26.2944444 0.306000 26.2972222 0.306667 26.3000000 0.306667 26.3027778 0.307333 26.3055556 0.308667 26.3083333 0.310000 26.3111111 0.312667 26.3138889 0.314667 26.3166667 0.313333 26.3194444 0.315333 26.3222222 0.315333 26.3250000 0.316000 26.3277778 0.317333 26.3305556 0.318000 26.3333333 0.317333 26.3391111 0.300000 26.5192222 0.300000 26.5222222 0.268667 26.5250000 0.268667 26.5277778 0.267333 26.5305556 0.268000 26.5333333 0.267333 26.5361111 0.268667 26.5388889 0.266000 26.5416667 0.266000 26.5444444 0.267333 26.5472222 0.267333 26.5500000 0.268667 26.5527778 0.270000 26.5555556 0.268667 26.5583333 0.269333 26.5611111 0.270667 26.5638889 0.272000 26.5666667 0.271333 26.5694444 0.274000 26.5722222 0.275333 26.5750000 0.278000 26.5777778 0.278000 26.5805556 0.278667 26.5833333 0.277333 26.5861111 0.275333 26.5888889 0.275333 26.5916667 0.273333 26.5944444 0.272667 26.5972222 0.271333 26.6000000 0.268667 26.6027778 0.268667 26.6055556 0.268000 26.6083333 0.268667 26.6111111 0.266667 26.6138889 0.269333 26.6166667 0.272000 26.6194444 0.274667 26.6222222 0.277333 26.6250000 0.277333 26.6277778 0.276000 26.6305556 0.274667 26.6333333 0.276000 26.6361111 0.274000 26.6388889 0.273333 26.6416667 0.273333 26.6444444 0.273333 26.6472222 0.273333 26.6500000 0.274667 26.6527778 0.273333 26.6555556 0.275333 26.6583333 0.275333 26.6611111 0.275333 26.6638889 0.274667 26.6666667 0.274000 26.6694444 0.273333 26.6722222 0.273333 26.6750000 0.272667 26.6777778 0.274667 26.6805556 0.275333 26.6833333 0.275333 26.6861111 0.274000 26.6888889 0.274000 26.6916667 0.272667 26.6944444 0.272667 26.6972222 0.271333 26.7000000 0.271333 26.7027778 0.271333 26.7055556 0.274000 26.7083333 0.276000 26.7111111 0.277333 26.7138889 0.278667 26.7166667 0.280667 26.7194444 0.279333 26.7222222 0.278667 26.7250000 0.277333 26.7277778 0.276667 26.7305556 0.274000 26.7333333 0.274000 26.7361111 0.275333 26.7388889 0.275333 26.7416667 0.275333 26.7444444 0.278667 26.7472222 0.280000 26.7500000 0.282000 26.7527778 0.286000 26.7555556 0.291333 26.7583333 0.298667 26.7611111 0.310667 26.7638889 0.323333 26.7666667 0.338000 26.7694444 0.358000 26.7722222 0.377333 26.7750000 0.390000 26.7777778 0.390667 26.7805556 0.374000 26.7833333 0.338667 26.7861111 0.294667 26.7888889 0.254000 26.7916667 0.226000 26.7944444 0.212667 26.7972222 0.211333 26.8000000 0.216000 26.8027778 0.227333 26.8055556 0.236000 26.8083333 0.242667 26.8111111 0.247333 26.8138889 0.246667 26.8166667 0.244667 26.8194444 0.242000 26.8222222 0.243333 26.8250000 0.246667 26.8277778 0.252000 26.8305556 0.256000 26.8333333 0.258667 26.8361111 0.258000 26.8388889 0.255333 26.8416667 0.253333 26.8444444 0.253333 26.8472222 0.254000 26.8500000 0.256000 26.8527778 0.258000 26.8555556 0.259333 26.8583333 0.260000 26.8611111 0.260667 26.8638889 0.262667 26.8666667 0.264667 26.8694444 0.268667 26.8722222 0.270667 26.8750000 0.274000 26.8777778 0.276000 26.8805556 0.276667 26.8833333 0.277333 26.8861111 0.276667 26.8888889 0.276667 26.8916667 0.275333 26.8944444 0.276000 26.8972222 0.275333 26.9000000 0.274667 26.9027778 0.275333 26.9055556 0.276000 26.9083333 0.277333 26.9111111 0.276667 26.9138889 0.276000 26.9166667 0.276667 26.9194444 0.276000 26.9222222 0.277333 26.9250000 0.276667 26.9277778 0.276000 26.9305556 0.276000 26.9333333 0.276667 26.9361111 0.276667 26.9388889 0.278000 26.9416667 0.279333 26.9444444 0.282000 26.9472222 0.282667 26.9500000 0.284000 26.9527778 0.282000 26.9555556 0.281333 26.9583333 0.281333 26.9611111 0.280000 26.9638889 0.278667 26.9666667 0.279333 26.9694444 0.280667 26.9722222 0.282667 26.9750000 0.284667 26.9777778 0.285333 26.9805556 0.286667 26.9833333 0.287333 26.9861111 0.290000 26.9888889 0.292667 26.9916667 0.292667 26.9944444 0.293333 26.9972222 0.294000 27.0000000 0.294000 27.0027778 0.294667 27.0055556 0.297333 27.0083333 0.297333 27.0111111 0.299333 27.0138889 0.300667 27.0166667 0.301333 27.0194444 0.302000 27.0222222 0.303333 27.0250000 0.307333 27.0277778 0.308667 27.0305556 0.310000 27.0333333 0.312667 27.0361111 0.316000 27.0388889 0.316667 27.0416667 0.319333 27.0444444 0.320667 27.0472222 0.320667 27.0500000 0.322667 27.0527778 0.322667 27.0555556 0.320667 27.0583333 0.320000 27.0611111 0.320000 27.0638889 0.314667 27.0666667 0.312667 27.0694444 0.312000 27.0752222 0.300000 27.2414444 0.300000 27.2444444 0.270000 27.2472222 0.270667 27.2500000 0.272000 27.2527778 0.272000 27.2555556 0.271333 27.2583333 0.270000 27.2611111 0.268667 27.2638889 0.269333 27.2666667 0.269333 27.2694444 0.271333 27.2722222 0.273333 27.2750000 0.274000 27.2777778 0.275333 27.2805556 0.276667 27.2833333 0.278000 27.2861111 0.279333 27.2888889 0.280667 27.2916667 0.280667 27.2944444 0.278667 27.2972222 0.277333 27.3000000 0.275333 27.3027778 0.274000 27.3055556 0.272000 27.3083333 0.274000 27.3111111 0.275333 27.3138889 0.275333 27.3166667 0.278667 27.3194444 0.277333 27.3222222 0.278667 27.3250000 0.279333 27.3277778 0.278000 27.3305556 0.276667 27.3333333 0.276667 27.3361111 0.275333 27.3388889 0.274667 27.3416667 0.276000 27.3444444 0.276000 27.3472222 0.278667 27.3500000 0.280000 27.3527778 0.280000 27.3555556 0.278667 27.3583333 0.277333 27.3611111 0.276000 27.3638889 0.274667 27.3666667 0.274000 27.3694444 0.273333 27.3722222 0.276000 27.3750000 0.276000 27.3777778 0.278000 27.3805556 0.278000 27.3833333 0.276667 27.3861111 0.273333 27.3888889 0.273333 27.3916667 0.272667 27.3944444 0.271333 27.3972222 0.272000 27.4000000 0.271333 27.4027778 0.272000 27.4055556 0.274000 27.4083333 0.277333 27.4111111 0.280000 27.4138889 0.282000 27.4166667 0.280000 27.4194444 0.280000 27.4222222 0.278667 27.4250000 0.276000 27.4277778 0.273333 27.4305556 0.274000 27.4333333 0.272667 27.4361111 0.274000 27.4388889 0.274000 27.4416667 0.276667 27.4444444 0.277333 27.4472222 0.279333 27.4500000 0.281333 27.4527778 0.280667 27.4555556 0.281333 27.4583333 0.282000 27.4611111 0.282667 27.4638889 0.281333 27.4666667 0.282667 27.4694444 0.282000 27.4722222 0.284000 27.4750000 0.288000 27.4777778 0.291333 27.4805556 0.299333 27.4833333 0.310000 27.4861111 0.324667 27.4888889 0.339333 27.4916667 0.357333 27.4944444 0.372000 27.4972222 0.385333 27.5000000 0.388667 27.5027778 0.380667 27.5055556 0.353333 27.5083333 0.316000 27.5111111 0.277333 27.5138889 0.246667 27.5166667 0.228667 27.5194444 0.220667 27.5222222 0.219333 27.5250000 0.223333 27.5277778 0.224667 27.5305556 0.229333 27.5333333 0.233333 27.5361111 0.237333 27.5388889 0.240667 27.5416667 0.244000 27.5444444 0.242000 27.5472222 0.241333 27.5500000 0.243333 27.5527778 0.245333 27.5555556 0.251333 27.5583333 0.257333 27.5611111 0.260667 27.5638889 0.262667 27.5666667 0.260667 27.5694444 0.257333 27.5722222 0.256000 27.5750000 0.253333 27.5777778 0.253333 27.5805556 0.254667 27.5833333 0.255333 27.5861111 0.257333 27.5888889 0.261333 27.5916667 0.264667 27.5944444 0.268000 27.5972222 0.271333 27.6000000 0.274667 27.6027778 0.277333 27.6055556 0.279333 27.6083333 0.279333 27.6111111 0.280000 27.6138889 0.280000 27.6166667 0.278667 27.6194444 0.278000 27.6222222 0.276667 27.6250000 0.276000 27.6277778 0.273333 27.6305556 0.273333 27.6333333 0.274000 27.6361111 0.275333 27.6388889 0.278000 27.6416667 0.278667 27.6444444 0.280000 27.6472222 0.280667 27.6500000 0.281333 27.6527778 0.280667 27.6555556 0.282000 27.6583333 0.280000 27.6611111 0.278667 27.6638889 0.277333 27.6666667 0.276667 27.6694444 0.276667 27.6722222 0.278000 27.6750000 0.279333 27.6777778 0.279333 27.6805556 0.282667 27.6833333 0.283333 27.6861111 0.282667 27.6888889 0.282667 27.6916667 0.282000 27.6944444 0.282667 27.6972222 0.281333 27.7000000 0.280667 27.7027778 0.284000 27.7055556 0.284000 27.7083333 0.284667 27.7111111 0.287333 27.7138889 0.288667 27.7166667 0.290000 27.7194444 0.290000 27.7222222 0.292000 27.7250000 0.292000 27.7277778 0.292000 27.7305556 0.292667 27.7333333 0.292667 27.7361111 0.294667 27.7388889 0.298000 27.7416667 0.300667 27.7444444 0.302667 27.7472222 0.305333 27.7500000 0.304667 27.7527778 0.307333 27.7555556 0.308000 27.7583333 0.308667 27.7611111 0.310000 27.7638889 0.310000 27.7666667 0.309333 27.7694444 0.311333 27.7722222 0.312000 27.7750000 0.313333 27.7777778 0.316000 27.7805556 0.318667 27.7833333 0.319333 27.7861111 0.320000 27.7888889 0.321333 27.7916667 0.318000 27.7974444 0.300000 27.9942222 0.300000 27.9972222 0.264000 28.0000000 0.265333 28.0027778 0.266667 28.0055556 0.266000 28.0083333 0.270000 28.0111111 0.269333 28.0138889 0.272667 28.0166667 0.274000 28.0194444 0.273333 28.0222222 0.276000 28.0250000 0.277333 28.0277778 0.278667 28.0305556 0.279333 28.0333333 0.278000 28.0361111 0.276667 28.0388889 0.276000 28.0416667 0.276000 28.0444444 0.274667 28.0472222 0.276000 28.0500000 0.276667 28.0527778 0.276000 28.0555556 0.276667 28.0583333 0.273333 28.0611111 0.273333 28.0638889 0.272667 28.0666667 0.271333 28.0694444 0.272000 28.0722222 0.272000 28.0750000 0.273333 28.0777778 0.273333 28.0805556 0.275333 28.0833333 0.276667 28.0861111 0.276000 28.0888889 0.276667 28.0916667 0.277333 28.0944444 0.276000 28.0972222 0.273333 28.1000000 0.272667 28.1027778 0.272000 28.1055556 0.273333 28.1083333 0.272000 28.1111111 0.273333 28.1138889 0.273333 28.1166667 0.275333 28.1194444 0.276667 28.1222222 0.277333 28.1250000 0.276667 28.1277778 0.275333 28.1305556 0.276000 28.1333333 0.274667 28.1361111 0.274667 28.1388889 0.274667 28.1416667 0.274000 28.1444444 0.274667 28.1472222 0.274000 28.1500000 0.276000 28.1527778 0.275333 28.1555556 0.274667 28.1583333 0.274000 28.1611111 0.274000 28.1638889 0.272667 28.1666667 0.272667 28.1694444 0.272000 28.1722222 0.273333 28.1750000 0.274667 28.1777778 0.276000 28.1805556 0.276667 28.1833333 0.278667 28.1861111 0.278000 28.1888889 0.278000 28.1916667 0.276667 28.1944444 0.275333 28.1972222 0.274000 28.2000000 0.273333 28.2027778 0.274667 28.2055556 0.274667 28.2083333 0.274000 28.2111111 0.276000 28.2138889 0.278667 28.2166667 0.283333 28.2194444 0.286000 28.2222222 0.289333 28.2250000 0.292000 28.2277778 0.295333 28.2305556 0.299333 28.2333333 0.306667 28.2361111 0.320000 28.2388889 0.336667 28.2416667 0.354667 28.2444444 0.372667 28.2472222 0.388667 28.2500000 0.398667 28.2527778 0.396000 28.2555556 0.378667 28.2583333 0.347333 28.2611111 0.306667 28.2638889 0.268667 28.2666667 0.240667 28.2694444 0.224667 28.2722222 0.220000 28.2750000 0.219333 28.2777778 0.224000 28.2805556 0.228000 28.2833333 0.233333 28.2861111 0.238667 28.2888889 0.240667 28.2916667 0.240667 28.2944444 0.241333 28.2972222 0.237333 28.3000000 0.236667 28.3027778 0.237333 28.3055556 0.240667 28.3083333 0.247333 28.3111111 0.251333 28.3138889 0.258000 28.3166667 0.262000 28.3194444 0.262667 28.3222222 0.260000 28.3250000 0.257333 28.3277778 0.257333 28.3305556 0.255333 28.3333333 0.254667 28.3361111 0.255333 28.3388889 0.257333 28.3416667 0.259333 28.3444444 0.262000 28.3472222 0.266667 28.3500000 0.269333 28.3527778 0.274000 28.3555556 0.275333 28.3583333 0.277333 28.3611111 0.278000 28.3638889 0.278000 28.3666667 0.276667 28.3694444 0.276667 28.3722222 0.276667 28.3750000 0.277333 28.3777778 0.277333 28.3805556 0.279333 28.3833333 0.278667 28.3861111 0.277333 28.3888889 0.278667 28.3916667 0.277333 28.3944444 0.274667 28.3972222 0.278000 28.4000000 0.276000 28.4027778 0.277333 28.4055556 0.277333 28.4083333 0.276667 28.4111111 0.280000 28.4138889 0.281333 28.4166667 0.280667 28.4194444 0.281333 28.4222222 0.280000 28.4250000 0.280000 28.4277778 0.279333 28.4305556 0.280000 28.4333333 0.279333 28.4361111 0.279333 28.4388889 0.280667 28.4416667 0.281333 28.4444444 0.280667 28.4472222 0.283333 28.4500000 0.284000 28.4527778 0.282667 28.4555556 0.283333 28.4583333 0.286000 28.4611111 0.286000 28.4638889 0.287333 28.4666667 0.287333 28.4694444 0.287333 28.4722222 0.289333 28.4750000 0.290000 28.4777778 0.292667 28.4805556 0.294667 28.4833333 0.296000 28.4861111 0.296667 28.4888889 0.298667 28.4916667 0.298667 28.4944444 0.300667 28.4972222 0.300667 28.5000000 0.301333 28.5027778 0.302667 28.5055556 0.305333 28.5083333 0.308667 28.5111111 0.313333 28.5138889 0.315333 28.5166667 0.318667 28.5194444 0.320667 28.5222222 0.319333 28.5250000 0.318667 28.5277778 0.318667 28.5305556 0.319333 28.5333333 0.319333 28.5361111 0.320667 28.5388889 0.321333 28.5416667 0.322667 28.5444444 0.324000 28.5502222 0.300000 31.1525556 0.300000 31.1555556 0.278000 31.1583333 0.277333 31.1611111 0.276667 31.1638889 0.277333 31.1666667 0.277333 31.1694444 0.279333 31.1722222 0.280667 31.1750000 0.282667 31.1777778 0.282667 31.1805556 0.285333 31.1833333 0.287333 31.1861111 0.286667 31.1888889 0.288667 31.1916667 0.286000 31.1944444 0.287333 31.1972222 0.284000 31.2000000 0.282667 31.2027778 0.286000 31.2055556 0.287333 31.2083333 0.287333 31.2111111 0.289333 31.2138889 0.290667 31.2166667 0.290667 31.2194444 0.291333 31.2222222 0.292000 31.2250000 0.291333 31.2277778 0.291333 31.2305556 0.289333 31.2333333 0.287333 31.2361111 0.286000 31.2388889 0.282667 31.2416667 0.282000 31.2444444 0.282000 31.2472222 0.281333 31.2500000 0.282000 31.2527778 0.279333 31.2555556 0.283333 31.2583333 0.283333 31.2611111 0.282667 31.2638889 0.284000 31.2666667 0.281333 31.2694444 0.282667 31.2722222 0.281333 31.2750000 0.282000 31.2777778 0.281333 31.2805556 0.278667 31.2833333 0.278667 31.2861111 0.276000 31.2888889 0.277333 31.2916667 0.276667 31.2944444 0.274667 31.2972222 0.274667 31.3000000 0.273333 31.3027778 0.272667 31.3055556 0.271333 31.3083333 0.272667 31.3111111 0.274000 31.3138889 0.276000 31.3166667 0.277333 31.3194444 0.276667 31.3222222 0.277333 31.3250000 0.279333 31.3277778 0.278667 31.3305556 0.277333 31.3333333 0.275333 31.3361111 0.276667 31.3388889 0.274000 31.3416667 0.272667 31.3444444 0.275333 31.3472222 0.275333 31.3500000 0.276667 31.3527778 0.276000 31.3555556 0.276667 31.3583333 0.276000 31.3611111 0.276667 31.3638889 0.276667 31.3666667 0.276667 31.3694444 0.277333 31.3722222 0.280667 31.3750000 0.282667 31.3777778 0.285333 31.3805556 0.290667 31.3833333 0.293333 31.3861111 0.298000 31.3888889 0.305333 31.3916667 0.315333 31.3944444 0.326000 31.3972222 0.342000 31.4000000 0.356667 31.4027778 0.372667 31.4055556 0.384000 31.4083333 0.387333 31.4111111 0.374667 31.4138889 0.348000 31.4166667 0.314667 31.4194444 0.279333 31.4222222 0.256000 31.4250000 0.240667 31.4277778 0.232667 31.4305556 0.229333 31.4333333 0.229333 31.4361111 0.232000 31.4388889 0.237333 31.4416667 0.241333 31.4444444 0.244000 31.4472222 0.243333 31.4500000 0.243333 31.4527778 0.241333 31.4555556 0.246000 31.4583333 0.248667 31.4611111 0.253333 31.4638889 0.255333 31.4666667 0.256667 31.4694444 0.256667 31.4722222 0.252667 31.4750000 0.251333 31.4777778 0.251333 31.4805556 0.250667 31.4833333 0.251333 31.4861111 0.252667 31.4888889 0.254000 31.4916667 0.256667 31.4944444 0.258000 31.4972222 0.260667 31.5000000 0.263333 31.5027778 0.266667 31.5055556 0.268000 31.5083333 0.270667 31.5111111 0.271333 31.5138889 0.272667 31.5166667 0.276000 31.5194444 0.276000 31.5222222 0.274667 31.5250000 0.273333 31.5277778 0.270667 31.5305556 0.268000 31.5333333 0.269333 31.5361111 0.269333 31.5388889 0.270667 31.5416667 0.272000 31.5444444 0.272667 31.5472222 0.274667 31.5500000 0.277333 31.5527778 0.276667 31.5555556 0.276000 31.5583333 0.275333 31.5611111 0.275333 31.5638889 0.274667 31.5666667 0.274000 31.5694444 0.274667 31.5722222 0.272667 31.5750000 0.273333 31.5777778 0.274000 31.5805556 0.275333 31.5833333 0.277333 31.5861111 0.278000 31.5888889 0.278667 31.5916667 0.278667 31.5944444 0.276667 31.5972222 0.276000 31.6000000 0.276000 31.6027778 0.275333 31.6055556 0.278667 31.6083333 0.280667 31.6111111 0.282000 31.6138889 0.281333 31.6166667 0.282000 31.6194444 0.281333 31.6222222 0.281333 31.6250000 0.278000 31.6277778 0.280000 31.6305556 0.279333 31.6333333 0.281333 31.6361111 0.282000 31.6388889 0.282000 31.6416667 0.284667 31.6444444 0.286667 31.6472222 0.288667 31.6500000 0.292000 31.6527778 0.292667 31.6555556 0.293333 31.6583333 0.294000 31.6611111 0.294000 31.6638889 0.292667 31.6666667 0.292000 31.6694444 0.294000 31.6722222 0.296000 31.6750000 0.298000 31.6777778 0.300667 31.6805556 0.302667 31.6833333 0.302000 31.6861111 0.303333 31.6888889 0.304667 31.6916667 0.304667 31.6944444 0.304667 31.6972222 0.306667 31.7000000 0.306000 31.7027778 0.308667 31.7085556 0.300000 32.3858889 0.300000 32.3888889 0.274667 32.3916667 0.274000 32.3944444 0.274000 32.3972222 0.275333 32.4000000 0.276667 32.4027778 0.277333 32.4055556 0.278000 32.4083333 0.278000 32.4111111 0.278667 32.4138889 0.279333 32.4166667 0.282667 32.4194444 0.282000 32.4222222 0.284000 32.4250000 0.282667 32.4277778 0.282000 32.4305556 0.282000 32.4333333 0.281333 32.4361111 0.282667 32.4388889 0.282667 32.4416667 0.285333 32.4444444 0.285333 32.4472222 0.286000 32.4500000 0.287333 32.4527778 0.286000 32.4555556 0.284667 32.4583333 0.282000 32.4611111 0.280000 32.4638889 0.276000 32.4666667 0.274667 32.4694444 0.272667 32.4722222 0.273333 32.4750000 0.275333 32.4777778 0.276667 32.4805556 0.278000 32.4833333 0.278000 32.4861111 0.277333 32.4888889 0.276667 32.4916667 0.274667 32.4944444 0.275333 32.4972222 0.272667 32.5000000 0.270667 32.5027778 0.270000 32.5055556 0.269333 32.5083333 0.268000 32.5111111 0.268667 32.5138889 0.270000 32.5166667 0.271333 32.5194444 0.272667 32.5222222 0.272000 32.5250000 0.272667 32.5277778 0.271333 32.5305556 0.272000 32.5333333 0.271333 32.5361111 0.270667 32.5388889 0.270000 32.5416667 0.270667 32.5444444 0.271333 32.5472222 0.271333 32.5500000 0.272000 32.5527778 0.273333 32.5555556 0.272667 32.5583333 0.272667 32.5611111 0.272000 32.5638889 0.270667 32.5666667 0.268667 32.5694444 0.270000 32.5722222 0.268000 32.5750000 0.268000 32.5777778 0.271333 32.5805556 0.272667 32.5833333 0.275333 32.5861111 0.276000 32.5888889 0.276667 32.5916667 0.276000 32.5944444 0.274000 32.5972222 0.272667 32.6000000 0.272000 32.6027778 0.272667 32.6055556 0.271333 32.6083333 0.272667 32.6111111 0.278000 32.6138889 0.281333 32.6166667 0.285333 32.6194444 0.290000 32.6222222 0.295333 32.6250000 0.302000 32.6277778 0.312667 32.6305556 0.324667 32.6333333 0.338667 32.6361111 0.356000 32.6388889 0.367333 32.6416667 0.373333 32.6444444 0.366000 32.6472222 0.343333 32.6500000 0.310000 32.6527778 0.276667 32.6555556 0.248000 32.6583333 0.230000 32.6611111 0.223333 32.6638889 0.222000 32.6666667 0.224000 32.6694444 0.230667 32.6722222 0.237333 32.6750000 0.243333 32.6777778 0.247333 32.6805556 0.248667 32.6833333 0.245333 32.6861111 0.242667 32.6888889 0.242667 32.6916667 0.244000 32.6944444 0.246667 32.6972222 0.250000 32.7000000 0.254667 32.7027778 0.257333 32.7055556 0.256667 32.7083333 0.255333 32.7111111 0.254000 32.7138889 0.253333 32.7166667 0.255333 32.7194444 0.256000 32.7222222 0.256667 32.7250000 0.257333 32.7277778 0.258000 32.7305556 0.260000 32.7333333 0.262667 32.7361111 0.264000 32.7388889 0.268667 32.7416667 0.271333 32.7444444 0.275333 32.7472222 0.275333 32.7500000 0.274667 32.7527778 0.273333 32.7555556 0.272000 32.7583333 0.272000 32.7611111 0.271333 32.7638889 0.274000 32.7666667 0.274667 32.7694444 0.276000 32.7722222 0.274667 32.7750000 0.275333 32.7777778 0.274000 32.7805556 0.274667 32.7833333 0.275333 32.7861111 0.274667 32.7888889 0.275333 32.7916667 0.274000 32.7944444 0.274000 32.7972222 0.274000 32.8000000 0.274000 32.8027778 0.275333 32.8055556 0.276667 32.8083333 0.276667 32.8111111 0.276000 32.8138889 0.276000 32.8166667 0.276667 32.8194444 0.277333 32.8222222 0.278000 32.8250000 0.276000 32.8277778 0.276000 32.8305556 0.275333 32.8333333 0.277333 32.8361111 0.278000 32.8388889 0.278000 32.8416667 0.278000 32.8444444 0.278667 32.8472222 0.278667 32.8500000 0.278667 32.8527778 0.278000 32.8555556 0.279333 32.8583333 0.279333 32.8611111 0.280000 32.8638889 0.280667 32.8666667 0.282000 32.8694444 0.283333 32.8722222 0.284667 32.8750000 0.285333 32.8777778 0.287333 32.8805556 0.288667 32.8833333 0.290000 32.8861111 0.290000 32.8888889 0.291333 32.8916667 0.290667 32.8944444 0.292667 32.8972222 0.294000 32.9000000 0.294000 32.9027778 0.296667 32.9055556 0.299333 32.9083333 0.301333 32.9111111 0.303333 32.9138889 0.304667 32.9166667 0.306667 32.9194444 0.308000 32.9222222 0.309333 32.9250000 0.309333 32.9277778 0.310000 32.9305556 0.311333 32.9333333 0.311333 32.9361111 0.312000 32.9418889 0.300000 33.0997778 0.300000 33.1027778 0.266667 33.1055556 0.267333 33.1083333 0.268667 33.1111111 0.270000 33.1138889 0.270667 33.1166667 0.272000 33.1194444 0.272000 33.1222222 0.271333 33.1250000 0.270667 33.1277778 0.272000 33.1305556 0.272000 33.1333333 0.272667 33.1361111 0.273333 33.1388889 0.273333 33.1416667 0.274000 33.1444444 0.276667 33.1472222 0.278000 33.1500000 0.278000 33.1527778 0.278667 33.1555556 0.278000 33.1583333 0.278000 33.1611111 0.276667 33.1638889 0.276667 33.1666667 0.276667 33.1694444 0.276667 33.1722222 0.277333 33.1750000 0.278000 33.1777778 0.276667 33.1805556 0.278000 33.1833333 0.276667 33.1861111 0.276667 33.1888889 0.276000 33.1916667 0.276000 33.1944444 0.277333 33.1972222 0.278667 33.2000000 0.279333 33.2027778 0.281333 33.2055556 0.280000 33.2083333 0.281333 33.2111111 0.280000 33.2138889 0.277333 33.2166667 0.278667 33.2194444 0.277333 33.2222222 0.277333 33.2250000 0.277333 33.2277778 0.276000 33.2305556 0.274667 33.2333333 0.275333 33.2361111 0.275333 33.2388889 0.275333 33.2416667 0.275333 33.2444444 0.276000 33.2472222 0.278667 33.2500000 0.279333 33.2527778 0.279333 33.2555556 0.280000 33.2583333 0.280000 33.2611111 0.280000 33.2638889 0.278000 33.2666667 0.275333 33.2694444 0.276000 33.2722222 0.275333 33.2750000 0.275333 33.2777778 0.275333 33.2805556 0.276000 33.2833333 0.276667 33.2861111 0.277333 33.2888889 0.278000 33.2916667 0.279333 33.2944444 0.279333 33.2972222 0.278667 33.3000000 0.278000 33.3027778 0.278000 33.3055556 0.278000 33.3083333 0.277333 33.3111111 0.279333 33.3138889 0.279333 33.3166667 0.280667 33.3194444 0.281333 33.3222222 0.280667 33.3250000 0.282000 33.3277778 0.282667 33.3305556 0.285333 33.3333333 0.288667 33.3361111 0.296667 33.3388889 0.308000 33.3416667 0.323333 33.3444444 0.340000 33.3472222 0.357333 33.3500000 0.376667 33.3527778 0.390000 33.3555556 0.398667 33.3583333 0.394000 33.3611111 0.374000 33.3638889 0.340667 33.3666667 0.301333 33.3694444 0.267333 33.3722222 0.242000 33.3750000 0.226667 33.3777778 0.224667 33.3805556 0.228000 33.3833333 0.233333 33.3861111 0.238667 33.3888889 0.244667 33.3916667 0.248667 33.3944444 0.251333 33.3972222 0.248667 33.4000000 0.244667 33.4027778 0.241333 33.4055556 0.239333 33.4083333 0.242667 33.4111111 0.245333 33.4138889 0.250667 33.4166667 0.255333 33.4194444 0.257333 33.4222222 0.258667 33.4250000 0.258000 33.4277778 0.255333 33.4305556 0.252667 33.4333333 0.250667 33.4361111 0.250667 33.4388889 0.254000 33.4416667 0.256000 33.4444444 0.260000 33.4472222 0.262000 33.4500000 0.266000 33.4527778 0.270000 33.4555556 0.272000 33.4583333 0.273333 33.4611111 0.276000 33.4638889 0.277333 33.4666667 0.276000 33.4694444 0.276000 33.4722222 0.276000 33.4750000 0.275333 33.4777778 0.275333 33.4805556 0.278000 33.4833333 0.279333 33.4861111 0.282667 33.4888889 0.283333 33.4916667 0.282667 33.4944444 0.281333 33.4972222 0.281333 33.5000000 0.278667 33.5027778 0.278667 33.5055556 0.276667 33.5083333 0.276667 33.5111111 0.276667 33.5138889 0.276000 33.5166667 0.278000 33.5194444 0.278000 33.5222222 0.278667 33.5250000 0.280000 33.5277778 0.280000 33.5305556 0.280667 33.5333333 0.281333 33.5361111 0.283333 33.5388889 0.282667 33.5416667 0.284000 33.5444444 0.285333 33.5472222 0.286000 33.5500000 0.286000 33.5527778 0.283333 33.5555556 0.283333 33.5583333 0.284000 33.5611111 0.282667 33.5638889 0.284667 33.5666667 0.284667 33.5694444 0.286000 33.5722222 0.285333 33.5750000 0.286667 33.5777778 0.288667 33.5805556 0.291333 33.5833333 0.294000 33.5861111 0.294000 33.5888889 0.294000 33.5916667 0.295333 33.5944444 0.295333 33.5972222 0.296667 33.6000000 0.296000 33.6027778 0.297333 33.6055556 0.299333 33.6083333 0.303333 33.6111111 0.304667 33.6138889 0.306667 33.6166667 0.308667 33.6194444 0.308000 33.6222222 0.309333 33.6250000 0.311333 33.6277778 0.312667 33.6305556 0.314000 33.6333333 0.315333 33.6361111 0.319333 33.6388889 0.318667 33.6416667 0.320000 33.6444444 0.321333 33.6472222 0.322000 33.6500000 0.322667 33.6557778 0.300000 33.8608889 0.300000 33.8638889 0.272000 33.8666667 0.274000 33.8694444 0.274000 33.8722222 0.274667 33.8750000 0.275333 33.8777778 0.277333 33.8805556 0.276667 33.8833333 0.278000 33.8861111 0.278000 33.8888889 0.276667 33.8916667 0.276667 33.8944444 0.276667 33.8972222 0.277333 33.9000000 0.278667 33.9027778 0.278667 33.9055556 0.279333 33.9083333 0.278667 33.9111111 0.280000 33.9138889 0.282000 33.9166667 0.282000 33.9194444 0.281333 33.9222222 0.281333 33.9250000 0.280667 33.9277778 0.280000 33.9305556 0.278667 33.9333333 0.278667 33.9361111 0.278000 33.9388889 0.276000 33.9416667 0.278000 33.9444444 0.278667 33.9472222 0.279333 33.9500000 0.278667 33.9527778 0.278000 33.9555556 0.277333 33.9583333 0.275333 33.9611111 0.276667 33.9638889 0.278000 33.9666667 0.280000 33.9694444 0.283333 33.9722222 0.284000 33.9750000 0.283333 33.9777778 0.282000 33.9805556 0.282667 33.9833333 0.280000 33.9861111 0.278000 33.9888889 0.278000 33.9916667 0.278667 33.9944444 0.278667 33.9972222 0.278000 34.0000000 0.276000 34.0027778 0.277333 34.0055556 0.276667 34.0083333 0.278000 34.0111111 0.280000 34.0138889 0.282000 34.0166667 0.282000 34.0194444 0.282667 34.0222222 0.281333 34.0250000 0.280667 34.0277778 0.279333 34.0305556 0.278667 34.0333333 0.277333 34.0361111 0.278667 34.0388889 0.280000 34.0416667 0.280667 34.0444444 0.281333 34.0472222 0.281333 34.0500000 0.281333 34.0527778 0.280000 34.0555556 0.280667 34.0583333 0.278667 34.0611111 0.279333 34.0638889 0.278667 34.0666667 0.279333 34.0694444 0.279333 34.0722222 0.280000 34.0750000 0.280000 34.0777778 0.281333 34.0805556 0.282667 34.0833333 0.282667 34.0861111 0.284667 34.0888889 0.286667 34.0916667 0.288667 34.0944444 0.291333 34.0972222 0.296000 34.1000000 0.304000 34.1027778 0.319333 34.1055556 0.339333 34.1083333 0.360667 34.1111111 0.380667 34.1138889 0.395333 34.1166667 0.398000 34.1194444 0.383333 34.1222222 0.353333 34.1250000 0.313333 34.1277778 0.274667 34.1305556 0.244667 34.1333333 0.226667 34.1361111 0.221333 34.1388889 0.221333 34.1416667 0.226667 34.1444444 0.234000 34.1472222 0.239333 34.1500000 0.243333 34.1527778 0.246000 34.1555556 0.247333 34.1583333 0.247333 34.1611111 0.246667 34.1638889 0.244000 34.1666667 0.240667 34.1694444 0.242000 34.1722222 0.245333 34.1750000 0.252667 34.1777778 0.256667 34.1805556 0.258000 34.1833333 0.260000 34.1861111 0.259333 34.1888889 0.258000 34.1916667 0.254000 34.1944444 0.253333 34.1972222 0.252000 34.2000000 0.250000 34.2027778 0.253333 34.2055556 0.256000 34.2083333 0.258667 34.2111111 0.264667 34.2138889 0.269333 34.2166667 0.273333 34.2194444 0.276000 34.2222222 0.278667 34.2250000 0.280000 34.2277778 0.280000 34.2305556 0.278000 34.2333333 0.277333 34.2361111 0.277333 34.2388889 0.276667 34.2416667 0.276667 34.2444444 0.278000 34.2472222 0.279333 34.2500000 0.282000 34.2527778 0.282667 34.2555556 0.282667 34.2583333 0.282000 34.2611111 0.282000 34.2638889 0.280000 34.2666667 0.280667 34.2694444 0.278667 34.2722222 0.277333 34.2750000 0.278667 34.2777778 0.280000 34.2805556 0.281333 34.2833333 0.280667 34.2861111 0.280667 34.2888889 0.281333 34.2916667 0.281333 34.2944444 0.281333 34.2972222 0.281333 34.3000000 0.282000 34.3027778 0.282667 34.3055556 0.284000 34.3083333 0.283333 34.3111111 0.286667 34.3138889 0.286667 34.3166667 0.288000 34.3194444 0.286000 34.3222222 0.286000 34.3250000 0.286667 34.3277778 0.285333 34.3305556 0.285333 34.3333333 0.285333 34.3361111 0.286000 34.3388889 0.288667 34.3416667 0.291333 34.3444444 0.294667 34.3472222 0.296667 34.3500000 0.298667 34.3527778 0.298000 34.3555556 0.298667 34.3583333 0.300667 34.3611111 0.300000 34.3638889 0.299333 34.3666667 0.300667 34.3694444 0.300667 34.3722222 0.301333 34.3750000 0.304000 34.3777778 0.306000 34.3805556 0.308000 34.3833333 0.312000 34.3861111 0.312000 34.3888889 0.313333 34.3916667 0.314667 34.3944444 0.316000 34.3972222 0.316667 34.4000000 0.315333 34.4027778 0.316667 34.4055556 0.316000 34.4083333 0.314667 34.4111111 0.316000 34.4168889 0.300000 34.5886667 0.300000 34.5916667 0.275333 34.5944444 0.273333 34.5972222 0.273333 34.6000000 0.272000 34.6027778 0.273333 34.6055556 0.272667 34.6083333 0.273333 34.6111111 0.275333 34.6138889 0.276000 34.6166667 0.276667 34.6194444 0.278000 34.6222222 0.278667 34.6250000 0.279333 34.6277778 0.279333 34.6305556 0.280000 34.6333333 0.280000 34.6361111 0.280667 34.6388889 0.280000 34.6416667 0.281333 34.6444444 0.282667 34.6472222 0.283333 34.6500000 0.282000 34.6527778 0.281333 34.6555556 0.280000 34.6583333 0.278667 34.6611111 0.277333 34.6638889 0.277333 34.6666667 0.275333 34.6694444 0.276000 34.6722222 0.278000 34.6750000 0.278000 34.6777778 0.278000 34.6805556 0.279333 34.6833333 0.280000 34.6861111 0.278000 34.6888889 0.279333 34.6916667 0.276667 34.6944444 0.278000 34.6972222 0.277333 34.7000000 0.275333 34.7027778 0.275333 34.7055556 0.275333 34.7083333 0.274000 34.7111111 0.276667 34.7138889 0.276000 34.7166667 0.278000 34.7194444 0.278667 34.7222222 0.279333 34.7250000 0.278000 34.7277778 0.278000 34.7305556 0.276000 34.7333333 0.274667 34.7361111 0.274667 34.7388889 0.273333 34.7416667 0.274000 34.7444444 0.274667 34.7472222 0.277333 34.7500000 0.278000 34.7527778 0.275333 34.7555556 0.277333 34.7583333 0.274667 34.7611111 0.275333 34.7638889 0.275333 34.7666667 0.276667 34.7694444 0.278000 34.7722222 0.278667 34.7750000 0.278667 34.7777778 0.278000 34.7805556 0.278667 34.7833333 0.280000 34.7861111 0.279333 34.7888889 0.278667 34.7916667 0.277333 34.7944444 0.276000 34.7972222 0.275333 34.8000000 0.275333 34.8027778 0.276667 34.8055556 0.276667 34.8083333 0.278667 34.8111111 0.281333 34.8138889 0.285333 34.8166667 0.288000 34.8194444 0.290667 34.8222222 0.294000 34.8250000 0.297333 34.8277778 0.301333 34.8305556 0.310667 34.8333333 0.322667 34.8361111 0.338667 34.8388889 0.354000 34.8416667 0.368000 34.8444444 0.378667 34.8472222 0.378667 34.8500000 0.365333 34.8527778 0.338000 34.8555556 0.303333 34.8583333 0.270000 34.8611111 0.245333 34.8638889 0.230667 34.8666667 0.226000 34.8694444 0.226667 34.8722222 0.230000 34.8750000 0.234667 34.8777778 0.238667 34.8805556 0.242667 34.8833333 0.246000 34.8861111 0.248667 34.8888889 0.248000 34.8916667 0.247333 34.8944444 0.244000 34.8972222 0.242667 34.9000000 0.244000 34.9027778 0.248000 34.9055556 0.254667 34.9083333 0.260667 34.9111111 0.263333 34.9138889 0.264667 34.9166667 0.263333 34.9194444 0.260000 34.9222222 0.259333 34.9250000 0.256000 34.9277778 0.257333 34.9305556 0.256667 34.9333333 0.258000 34.9361111 0.260667 34.9388889 0.262667 34.9416667 0.266667 34.9444444 0.272000 34.9472222 0.274000 34.9500000 0.278000 34.9527778 0.280000 34.9555556 0.280000 34.9583333 0.280000 34.9611111 0.279333 34.9638889 0.277333 34.9666667 0.276000 34.9694444 0.275333 34.9722222 0.276667 34.9750000 0.277333 34.9777778 0.279333 34.9805556 0.280667 34.9833333 0.281333 34.9861111 0.278667 34.9888889 0.280000 34.9916667 0.277333 34.9944444 0.277333 34.9972222 0.276667 35.0000000 0.276667 35.0027778 0.276667 35.0055556 0.278000 35.0083333 0.278000 35.0111111 0.278667 35.0138889 0.282000 35.0166667 0.282000 35.0194444 0.282000 35.0222222 0.280000 35.0250000 0.280667 35.0277778 0.280667 35.0305556 0.280667 35.0333333 0.280000 35.0361111 0.280000 35.0388889 0.282000 35.0416667 0.282000 35.0444444 0.284667 35.0472222 0.285333 35.0500000 0.286000 35.0527778 0.286667 35.0555556 0.288000 35.0583333 0.288000 35.0611111 0.286667 35.0638889 0.288000 35.0666667 0.288000 35.0694444 0.288667 35.0722222 0.290000 35.0750000 0.291333 35.0777778 0.292000 35.0805556 0.292000 35.0833333 0.294667 35.0861111 0.296000 35.0888889 0.297333 35.0916667 0.299333 35.0944444 0.301333 35.0972222 0.302000 35.1000000 0.304000 35.1027778 0.303333 35.1055556 0.304000 35.1083333 0.304667 35.1111111 0.308667 35.1138889 0.309333 35.1166667 0.314000 35.1194444 0.312000 35.1222222 0.313333 35.1250000 0.313333 35.1277778 0.314000 35.1305556 0.315333 35.1333333 0.314667 35.1361111 0.314667 35.1388889 0.316000 35.1446667 0.300000 35.3192222 0.300000 35.3222222 0.272000 35.3250000 0.271333 35.3277778 0.272667 35.3305556 0.272000 35.3333333 0.272667 35.3361111 0.272667 35.3388889 0.273333 35.3416667 0.273333 35.3444444 0.273333 35.3472222 0.275333 35.3500000 0.277333 35.3527778 0.276667 35.3555556 0.278000 35.3583333 0.277333 35.3611111 0.277333 35.3638889 0.278667 35.3666667 0.278000 35.3694444 0.278667 35.3722222 0.279333 35.3750000 0.278667 35.3777778 0.280000 35.3805556 0.280000 35.3833333 0.280000 35.3861111 0.278000 35.3888889 0.276667 35.3916667 0.278000 35.3944444 0.276667 35.3972222 0.276000 35.4000000 0.276000 35.4027778 0.274667 35.4055556 0.274000 35.4083333 0.274000 35.4111111 0.274000 35.4138889 0.274667 35.4166667 0.275333 35.4194444 0.276667 35.4222222 0.277333 35.4250000 0.277333 35.4277778 0.277333 35.4305556 0.276667 35.4333333 0.276000 35.4361111 0.275333 35.4388889 0.274667 35.4416667 0.274000 35.4444444 0.274667 35.4472222 0.274667 35.4500000 0.274667 35.4527778 0.274667 35.4555556 0.275333 35.4583333 0.275333 35.4611111 0.273333 35.4638889 0.270667 35.4666667 0.270667 35.4694444 0.271333 35.4722222 0.268667 35.4750000 0.272667 35.4777778 0.273333 35.4805556 0.274000 35.4833333 0.274667 35.4861111 0.274000 35.4888889 0.275333 35.4916667 0.273333 35.4944444 0.272667 35.4972222 0.275333 35.5000000 0.272000 35.5027778 0.272000 35.5055556 0.272667 35.5083333 0.274667 35.5111111 0.274667 35.5138889 0.275333 35.5166667 0.275333 35.5194444 0.276000 35.5222222 0.276000 35.5250000 0.276000 35.5277778 0.275333 35.5305556 0.274000 35.5333333 0.274667 35.5361111 0.276000 35.5388889 0.276667 35.5416667 0.278000 35.5444444 0.280000 35.5472222 0.282000 35.5500000 0.286000 35.5527778 0.288667 35.5555556 0.292000 35.5583333 0.298667 35.5611111 0.311333 35.5638889 0.323333 35.5666667 0.336667 35.5694444 0.351333 35.5722222 0.364667 35.5750000 0.372667 35.5777778 0.370667 35.5805556 0.355333 35.5833333 0.326667 35.5861111 0.290667 35.5888889 0.258667 35.5916667 0.236000 35.5944444 0.222667 35.5972222 0.220000 35.6000000 0.222667 35.6027778 0.228000 35.6055556 0.234000 35.6083333 0.240000 35.6111111 0.244667 35.6138889 0.248667 35.6166667 0.247333 35.6194444 0.248000 35.6222222 0.244667 35.6250000 0.244667 35.6277778 0.246667 35.6305556 0.252000 35.6333333 0.257333 35.6361111 0.261333 35.6388889 0.262667 35.6416667 0.261333 35.6444444 0.260000 35.6472222 0.258000 35.6500000 0.256667 35.6527778 0.256000 35.6555556 0.257333 35.6583333 0.258000 35.6611111 0.258000 35.6638889 0.259333 35.6666667 0.262667 35.6694444 0.264667 35.6722222 0.266667 35.6750000 0.270667 35.6777778 0.276667 35.6805556 0.276667 35.6833333 0.280667 35.6861111 0.280667 35.6888889 0.281333 35.6916667 0.280000 35.6944444 0.278667 35.6972222 0.275333 35.7000000 0.276000 35.7027778 0.276000 35.7055556 0.277333 35.7083333 0.278667 35.7111111 0.278667 35.7138889 0.280667 35.7166667 0.282000 35.7194444 0.280667 35.7222222 0.280000 35.7250000 0.280667 35.7277778 0.280000 35.7305556 0.277333 35.7333333 0.278667 35.7361111 0.278000 35.7388889 0.276667 35.7416667 0.280000 35.7444444 0.280667 35.7472222 0.282000 35.7500000 0.284000 35.7527778 0.282667 35.7555556 0.284000 35.7583333 0.283333 35.7611111 0.282667 35.7638889 0.283333 35.7666667 0.283333 35.7694444 0.283333 35.7722222 0.282667 35.7750000 0.285333 35.7777778 0.286000 35.7805556 0.286000 35.7833333 0.286667 35.7861111 0.288667 35.7888889 0.287333 35.7916667 0.289333 35.7944444 0.288667 35.7972222 0.289333 35.8000000 0.290667 35.8027778 0.291333 35.8055556 0.293333 35.8083333 0.294667 35.8111111 0.296667 35.8138889 0.299333 35.8166667 0.302000 35.8194444 0.304000 35.8222222 0.303333 35.8250000 0.303333 35.8277778 0.304667 35.8305556 0.304667 35.8333333 0.305333 35.8361111 0.308000 35.8388889 0.309333 35.8416667 0.310000 35.8444444 0.311333 35.8472222 0.313333 35.8500000 0.316000 35.8527778 0.313333 35.8555556 0.313333 35.8583333 0.314000 35.8611111 0.314000 35.8638889 0.313333 35.8666667 0.314000 35.8694444 0.312667 35.8752222 0.300000 36.0525556 0.300000 36.0555556 0.272667 36.0583333 0.270667 36.0611111 0.271333 36.0638889 0.272000 36.0666667 0.272000 36.0694444 0.272000 36.0722222 0.272667 36.0750000 0.274000 36.0777778 0.274000 36.0805556 0.276667 36.0833333 0.276667 36.0861111 0.276667 36.0888889 0.277333 36.0916667 0.278667 36.0944444 0.278667 36.0972222 0.278667 36.1000000 0.281333 36.1027778 0.279333 36.1055556 0.280000 36.1083333 0.279333 36.1111111 0.278667 36.1138889 0.277333 36.1166667 0.279333 36.1194444 0.279333 36.1222222 0.279333 36.1250000 0.279333 36.1277778 0.278000 36.1305556 0.274667 36.1333333 0.275333 36.1361111 0.274667 36.1388889 0.276000 36.1416667 0.275333 36.1444444 0.276000 36.1472222 0.277333 36.1500000 0.278667 36.1527778 0.276000 36.1555556 0.276667 36.1583333 0.277333 36.1611111 0.274667 36.1638889 0.273333 36.1666667 0.274000 36.1694444 0.274667 36.1722222 0.274000 36.1750000 0.274667 36.1777778 0.276000 36.1805556 0.278000 36.1833333 0.276667 36.1861111 0.277333 36.1888889 0.276667 36.1916667 0.275333 36.1944444 0.274667 36.1972222 0.275333 36.2000000 0.274000 36.2027778 0.274667 36.2055556 0.273333 36.2083333 0.273333 36.2111111 0.274000 36.2138889 0.276667 36.2166667 0.278000 36.2194444 0.279333 36.2222222 0.276000 36.2250000 0.277333 36.2277778 0.272667 36.2305556 0.272667 36.2333333 0.272667 36.2361111 0.270667 36.2388889 0.272667 36.2416667 0.271333 36.2444444 0.276000 36.2472222 0.277333 36.2500000 0.277333 36.2527778 0.276000 36.2555556 0.277333 36.2583333 0.274667 36.2611111 0.273333 36.2638889 0.276000 36.2666667 0.274667 36.2694444 0.275333 36.2722222 0.276000 36.2750000 0.276667 36.2777778 0.279333 36.2805556 0.283333 36.2833333 0.286667 36.2861111 0.288000 36.2888889 0.292000 36.2916667 0.296667 36.2944444 0.304667 36.2972222 0.317333 36.3000000 0.331333 36.3027778 0.349333 36.3055556 0.365333 36.3083333 0.373333 36.3111111 0.371333 36.3138889 0.353333 36.3166667 0.320000 36.3194444 0.282000 36.3222222 0.248667 36.3250000 0.226667 36.3277778 0.216000 36.3305556 0.214000 36.3333333 0.219333 36.3361111 0.226000 36.3388889 0.233333 36.3416667 0.239333 36.3444444 0.244000 36.3472222 0.245333 36.3500000 0.242000 36.3527778 0.242667 36.3555556 0.242667 36.3583333 0.245333 36.3611111 0.249333 36.3638889 0.254000 36.3666667 0.256667 36.3694444 0.258000 36.3722222 0.256667 36.3750000 0.255333 36.3777778 0.253333 36.3805556 0.252667 36.3833333 0.253333 36.3861111 0.254667 36.3888889 0.255333 36.3916667 0.258000 36.3944444 0.259333 36.3972222 0.264000 36.4000000 0.266000 36.4027778 0.268667 36.4055556 0.271333 36.4083333 0.274000 36.4111111 0.275333 36.4138889 0.276000 36.4166667 0.276667 36.4194444 0.276000 36.4222222 0.276000 36.4250000 0.274667 36.4277778 0.272667 36.4305556 0.274000 36.4333333 0.273333 36.4361111 0.274000 36.4388889 0.274000 36.4416667 0.276000 36.4444444 0.276667 36.4472222 0.278000 36.4500000 0.278000 36.4527778 0.278000 36.4555556 0.278667 36.4583333 0.278667 36.4611111 0.278667 36.4638889 0.277333 36.4666667 0.278000 36.4694444 0.276667 36.4722222 0.277333 36.4750000 0.276667 36.4777778 0.276000 36.4805556 0.276667 36.4833333 0.278667 36.4861111 0.277333 36.4888889 0.278000 36.4916667 0.278000 36.4944444 0.280000 36.4972222 0.280000 36.5000000 0.279333 36.5027778 0.280667 36.5055556 0.280000 36.5083333 0.279333 36.5111111 0.281333 36.5138889 0.284000 36.5166667 0.285333 36.5194444 0.286000 36.5222222 0.286667 36.5250000 0.285333 36.5277778 0.284667 36.5305556 0.284000 36.5333333 0.285333 36.5361111 0.284000 36.5388889 0.287333 36.5416667 0.290000 36.5444444 0.289333 36.5472222 0.294667 36.5500000 0.297333 36.5527778 0.298667 36.5555556 0.300000 36.5583333 0.301333 36.5611111 0.301333 36.5638889 0.302667 36.5666667 0.304000 36.5694444 0.304667 36.5722222 0.305333 36.5750000 0.306667 36.5777778 0.306667 36.5805556 0.307333 36.5833333 0.308667 36.5861111 0.309333 36.5888889 0.310667 36.5916667 0.310000 36.5944444 0.309333 36.5972222 0.310667 36.6000000 0.310667 36.6027778 0.310667 36.6085556 0.300000 36.7997778 0.300000 36.8027778 0.268667 36.8055556 0.269333 36.8083333 0.270667 36.8111111 0.271333 36.8138889 0.271333 36.8166667 0.270000 36.8194444 0.270000 36.8222222 0.272000 36.8250000 0.272000 36.8277778 0.272667 36.8305556 0.274000 36.8333333 0.275333 36.8361111 0.277333 36.8388889 0.276000 36.8416667 0.276667 36.8444444 0.276667 36.8472222 0.276667 36.8500000 0.276000 36.8527778 0.274667 36.8555556 0.272667 36.8583333 0.272667 36.8611111 0.270667 36.8638889 0.271333 36.8666667 0.270667 36.8694444 0.271333 36.8722222 0.272667 36.8750000 0.273333 36.8777778 0.274000 36.8805556 0.274667 36.8833333 0.274000 36.8861111 0.272667 36.8888889 0.272667 36.8916667 0.272667 36.8944444 0.272000 36.8972222 0.270667 36.9000000 0.271333 36.9027778 0.271333 36.9055556 0.270667 36.9083333 0.271333 36.9111111 0.270667 36.9138889 0.270667 36.9166667 0.270667 36.9194444 0.270667 36.9222222 0.273333 36.9250000 0.272667 36.9277778 0.271333 36.9305556 0.270000 36.9333333 0.270000 36.9361111 0.266000 36.9388889 0.266667 36.9416667 0.268000 36.9444444 0.269333 36.9472222 0.270667 36.9500000 0.272667 36.9527778 0.272000 36.9555556 0.270667 36.9583333 0.270667 36.9611111 0.268667 36.9638889 0.269333 36.9666667 0.269333 36.9694444 0.269333 36.9722222 0.270000 36.9750000 0.269333 36.9777778 0.270000 36.9805556 0.269333 36.9833333 0.269333 36.9861111 0.270667 36.9888889 0.270667 36.9916667 0.270667 36.9944444 0.270667 36.9972222 0.268000 37.0000000 0.268000 37.0027778 0.267333 37.0055556 0.266667 37.0083333 0.270000 37.0111111 0.269333 37.0138889 0.271333 37.0166667 0.272667 37.0194444 0.274667 37.0222222 0.276000 37.0250000 0.276000 37.0277778 0.278000 37.0305556 0.278667 37.0333333 0.278667 37.0361111 0.282000 37.0388889 0.289333 37.0416667 0.297333 37.0444444 0.309333 37.0472222 0.322000 37.0500000 0.335333 37.0527778 0.348667 37.0555556 0.358000 37.0583333 0.360667 37.0611111 0.348667 37.0638889 0.324000 37.0666667 0.292667 37.0694444 0.260667 37.0722222 0.235333 37.0750000 0.222000 37.0777778 0.218000 37.0805556 0.220000 37.0833333 0.224667 37.0861111 0.228667 37.0888889 0.233333 37.0916667 0.235333 37.0944444 0.238667 37.0972222 0.239333 37.1000000 0.238667 37.1027778 0.237333 37.1055556 0.236000 37.1083333 0.237333 37.1111111 0.240000 37.1138889 0.245333 37.1166667 0.253333 37.1194444 0.257333 37.1222222 0.260000 37.1250000 0.258667 37.1277778 0.256000 37.1305556 0.250667 37.1333333 0.247333 37.1361111 0.246667 37.1388889 0.248667 37.1416667 0.249333 37.1444444 0.252667 37.1472222 0.256000 37.1500000 0.260000 37.1527778 0.264000 37.1555556 0.267333 37.1583333 0.270000 37.1611111 0.271333 37.1638889 0.270667 37.1666667 0.270000 37.1694444 0.269333 37.1722222 0.270667 37.1750000 0.269333 37.1777778 0.270667 37.1805556 0.270000 37.1833333 0.273333 37.1861111 0.273333 37.1888889 0.272000 37.1916667 0.272667 37.1944444 0.271333 37.1972222 0.271333 37.2000000 0.271333 37.2027778 0.271333 37.2055556 0.272667 37.2083333 0.273333 37.2111111 0.273333 37.2138889 0.274667 37.2166667 0.275333 37.2194444 0.275333 37.2222222 0.275333 37.2250000 0.273333 37.2277778 0.274000 37.2305556 0.274667 37.2333333 0.274000 37.2361111 0.274000 37.2388889 0.274667 37.2416667 0.276667 37.2444444 0.276667 37.2472222 0.277333 37.2500000 0.278000 37.2527778 0.279333 37.2555556 0.279333 37.2583333 0.279333 37.2611111 0.279333 37.2638889 0.278667 37.2666667 0.278667 37.2694444 0.278000 37.2722222 0.279333 37.2750000 0.280000 37.2777778 0.280667 37.2805556 0.282000 37.2833333 0.284000 37.2861111 0.285333 37.2888889 0.284667 37.2916667 0.286667 37.2944444 0.286000 37.2972222 0.287333 37.3000000 0.288000 37.3027778 0.288667 37.3055556 0.289333 37.3083333 0.292667 37.3111111 0.295333 37.3138889 0.296000 37.3166667 0.298667 37.3194444 0.298667 37.3222222 0.300000 37.3250000 0.300000 37.3277778 0.301333 37.3305556 0.304667 37.3333333 0.303333 37.3361111 0.304000 37.3388889 0.305333 37.3416667 0.306667 37.3444444 0.308000 37.3472222 0.310000 37.3500000 0.311333 37.3557778 0.300000 38.5497778 0.300000 38.5527778 0.266667 38.5555556 0.266000 38.5583333 0.265333 38.5611111 0.264667 38.5638889 0.263333 38.5666667 0.262667 38.5694444 0.262667 38.5722222 0.264000 38.5750000 0.266667 38.5777778 0.270000 38.5805556 0.272000 38.5833333 0.274000 38.5861111 0.273333 38.5888889 0.274667 38.5916667 0.274667 38.5944444 0.274667 38.5972222 0.274667 38.6000000 0.274000 38.6027778 0.274000 38.6055556 0.274000 38.6083333 0.276000 38.6111111 0.276667 38.6138889 0.278000 38.6166667 0.278667 38.6194444 0.278667 38.6222222 0.278000 38.6250000 0.277333 38.6277778 0.276667 38.6305556 0.273333 38.6333333 0.272000 38.6361111 0.271333 38.6388889 0.269333 38.6416667 0.268667 38.6444444 0.270667 38.6472222 0.272667 38.6500000 0.273333 38.6527778 0.274667 38.6555556 0.274667 38.6583333 0.272667 38.6611111 0.272667 38.6638889 0.272000 38.6666667 0.270667 38.6694444 0.270000 38.6722222 0.267333 38.6750000 0.266667 38.6777778 0.267333 38.6805556 0.266000 38.6833333 0.265333 38.6861111 0.263333 38.6888889 0.264000 38.6916667 0.262000 38.6944444 0.262000 38.6972222 0.262000 38.7000000 0.261333 38.7027778 0.262000 38.7055556 0.262000 38.7083333 0.262000 38.7111111 0.264000 38.7138889 0.263333 38.7166667 0.266000 38.7194444 0.264000 38.7222222 0.264667 38.7250000 0.264667 38.7277778 0.265333 38.7305556 0.265333 38.7333333 0.266000 38.7361111 0.263333 38.7388889 0.264000 38.7416667 0.264667 38.7444444 0.264667 38.7472222 0.264667 38.7500000 0.266000 38.7527778 0.266667 38.7555556 0.265333 38.7583333 0.266667 38.7611111 0.266667 38.7638889 0.266667 38.7666667 0.266000 38.7694444 0.266667 38.7722222 0.267333 38.7750000 0.270000 38.7777778 0.271333 38.7805556 0.274667 38.7833333 0.280000 38.7861111 0.287333 38.7888889 0.300667 38.7916667 0.317333 38.7944444 0.332667 38.7972222 0.354000 38.8000000 0.371333 38.8027778 0.384667 38.8055556 0.386667 38.8083333 0.371333 38.8111111 0.340667 38.8138889 0.302000 38.8166667 0.264667 38.8194444 0.239333 38.8222222 0.224667 38.8250000 0.218000 38.8277778 0.216000 38.8305556 0.220000 38.8333333 0.222667 38.8361111 0.228667 38.8388889 0.232000 38.8416667 0.234667 38.8444444 0.236000 38.8472222 0.234667 38.8500000 0.230667 38.8527778 0.229333 38.8555556 0.232000 38.8583333 0.236000 38.8611111 0.239333 38.8638889 0.244000 38.8666667 0.247333 38.8694444 0.248000 38.8722222 0.248000 38.8750000 0.244667 38.8777778 0.243333 38.8805556 0.244667 38.8833333 0.244000 38.8861111 0.244667 38.8888889 0.247333 38.8916667 0.250000 38.8944444 0.251333 38.8972222 0.254667 38.9000000 0.256667 38.9027778 0.258667 38.9055556 0.262000 38.9083333 0.264000 38.9111111 0.265333 38.9138889 0.266667 38.9166667 0.268667 38.9194444 0.268000 38.9222222 0.267333 38.9250000 0.266000 38.9277778 0.267333 38.9305556 0.266667 38.9333333 0.267333 38.9361111 0.267333 38.9388889 0.268667 38.9416667 0.267333 38.9444444 0.267333 38.9472222 0.266667 38.9500000 0.268667 38.9527778 0.268667 38.9555556 0.268667 38.9583333 0.267333 38.9611111 0.268000 38.9638889 0.267333 38.9666667 0.265333 38.9694444 0.266000 38.9722222 0.269333 38.9750000 0.269333 38.9777778 0.269333 38.9805556 0.270000 38.9833333 0.272667 38.9861111 0.272667 38.9888889 0.272000 38.9916667 0.273333 38.9944444 0.272667 38.9972222 0.272667 39.0000000 0.272667 39.0027778 0.272667 39.0055556 0.273333 39.0083333 0.274000 39.0111111 0.276667 39.0138889 0.278000 39.0166667 0.280000 39.0194444 0.280000 39.0222222 0.280000 39.0250000 0.280000 39.0277778 0.280000 39.0305556 0.282667 39.0333333 0.282000 39.0361111 0.284000 39.0388889 0.286000 39.0416667 0.287333 39.0444444 0.289333 39.0472222 0.291333 39.0500000 0.294667 39.0527778 0.295333 39.0555556 0.296000 39.0583333 0.296667 39.0611111 0.297333 39.0638889 0.296667 39.0666667 0.298000 39.0694444 0.298667 39.0722222 0.301333 39.0750000 0.301333 39.0777778 0.302667 39.0805556 0.304000 39.0833333 0.304667 39.0861111 0.306000 39.0888889 0.304667 39.0916667 0.305333 39.0944444 0.304000 39.0972222 0.304667 39.1000000 0.305333 39.1057778 0.300000 39.2164444 0.300000 39.2194444 0.266667 39.2222222 0.268000 39.2250000 0.267333 39.2277778 0.266667 39.2305556 0.266000 39.2333333 0.266667 39.2361111 0.266000 39.2388889 0.267333 39.2416667 0.268667 39.2444444 0.270000 39.2472222 0.270000 39.2500000 0.272667 39.2527778 0.274667 39.2555556 0.274000 39.2583333 0.274667 39.2611111 0.276000 39.2638889 0.273333 39.2666667 0.275333 39.2694444 0.275333 39.2722222 0.277333 39.2750000 0.276667 39.2777778 0.276000 39.2805556 0.276667 39.2833333 0.274667 39.2861111 0.275333 39.2888889 0.272667 39.2916667 0.274667 39.2944444 0.274000 39.2972222 0.272000 39.3000000 0.272667 39.3027778 0.272000 39.3055556 0.272667 39.3083333 0.274000 39.3111111 0.276000 39.3138889 0.278000 39.3166667 0.278667 39.3194444 0.281333 39.3222222 0.282000 39.3250000 0.281333 39.3277778 0.278667 39.3305556 0.278000 39.3333333 0.276667 39.3361111 0.276667 39.3388889 0.276667 39.3416667 0.276667 39.3444444 0.276667 39.3472222 0.277333 39.3500000 0.278000 39.3527778 0.277333 39.3555556 0.276000 39.3583333 0.278000 39.3611111 0.278000 39.3638889 0.278000 39.3666667 0.277333 39.3694444 0.273333 39.3722222 0.275333 39.3750000 0.275333 39.3777778 0.276000 39.3805556 0.275333 39.3833333 0.276000 39.3861111 0.276000 39.3888889 0.275333 39.3916667 0.275333 39.3944444 0.275333 39.3972222 0.274667 39.4000000 0.273333 39.4027778 0.274000 39.4055556 0.274667 39.4083333 0.274000 39.4111111 0.274000 39.4138889 0.274667 39.4166667 0.276000 39.4194444 0.276667 39.4222222 0.278000 39.4250000 0.278000 39.4277778 0.276667 39.4305556 0.276000 39.4333333 0.276000 39.4361111 0.276000 39.4388889 0.278000 39.4416667 0.280000 39.4444444 0.282667 39.4472222 0.284000 39.4500000 0.289333 39.4527778 0.297333 39.4555556 0.307333 39.4583333 0.320667 39.4611111 0.338000 39.4638889 0.355333 39.4666667 0.372667 39.4694444 0.388000 39.4722222 0.394000 39.4750000 0.390667 39.4777778 0.372667 39.4805556 0.340000 39.4833333 0.301333 39.4861111 0.264000 39.4888889 0.237333 39.4916667 0.222000 39.4944444 0.220000 39.4972222 0.222000 39.5000000 0.226667 39.5027778 0.232000 39.5055556 0.236667 39.5083333 0.242000 39.5111111 0.244667 39.5138889 0.245333 39.5166667 0.243333 39.5194444 0.240000 39.5222222 0.238667 39.5250000 0.239333 39.5277778 0.241333 39.5305556 0.246667 39.5333333 0.251333 39.5361111 0.255333 39.5388889 0.256667 39.5416667 0.254667 39.5444444 0.256667 39.5472222 0.254667 39.5500000 0.254667 39.5527778 0.254000 39.5555556 0.253333 39.5583333 0.255333 39.5611111 0.256667 39.5638889 0.258667 39.5666667 0.261333 39.5694444 0.265333 39.5722222 0.270667 39.5750000 0.272000 39.5777778 0.275333 39.5805556 0.276000 39.5833333 0.278000 39.5861111 0.277333 39.5888889 0.276000 39.5916667 0.274667 39.5944444 0.274667 39.5972222 0.274000 39.6000000 0.273333 39.6027778 0.272000 39.6055556 0.272667 39.6083333 0.274000 39.6111111 0.274667 39.6138889 0.274000 39.6166667 0.274667 39.6194444 0.276000 39.6222222 0.275333 39.6250000 0.276000 39.6277778 0.273333 39.6305556 0.273333 39.6333333 0.272000 39.6361111 0.273333 39.6388889 0.275333 39.6416667 0.277333 39.6444444 0.278000 39.6472222 0.279333 39.6500000 0.278667 39.6527778 0.280000 39.6555556 0.280000 39.6583333 0.279333 39.6611111 0.278667 39.6638889 0.278667 39.6666667 0.279333 39.6694444 0.278000 39.6722222 0.280000 39.6750000 0.281333 39.6777778 0.282000 39.6805556 0.284000 39.6833333 0.286000 39.6861111 0.286667 39.6888889 0.285333 39.6916667 0.285333 39.6944444 0.286667 39.6972222 0.288000 39.7000000 0.288000 39.7027778 0.288667 39.7055556 0.288667 39.7083333 0.290667 39.7111111 0.294000 39.7138889 0.294667 39.7166667 0.297333 39.7194444 0.299333 39.7222222 0.301333 39.7250000 0.302667 39.7277778 0.303333 39.7305556 0.303333 39.7333333 0.304000 39.7361111 0.304000 39.7388889 0.306000 39.7416667 0.305333 39.7444444 0.308667 39.7472222 0.312000 39.7500000 0.314000 39.7527778 0.314667 39.7555556 0.316667 39.7583333 0.316000 39.7611111 0.316000 39.7638889 0.314667 39.7666667 0.314667 39.7724444 0.300000 39.9608889 0.300000 39.9638889 0.266667 39.9666667 0.267333 39.9694444 0.267333 39.9722222 0.268000 39.9750000 0.267333 39.9777778 0.267333 39.9805556 0.266667 39.9833333 0.267333 39.9861111 0.267333 39.9888889 0.267333 39.9916667 0.267333 39.9944444 0.267333 39.9972222 0.266667 40.0000000 0.266667 40.0027778 0.268667 40.0055556 0.271333 40.0083333 0.272000 40.0111111 0.273333 40.0138889 0.277333 40.0166667 0.276000 40.0194444 0.274000 40.0222222 0.274000 40.0250000 0.272000 40.0277778 0.270667 40.0305556 0.270000 40.0333333 0.268000 40.0361111 0.266667 40.0388889 0.267333 40.0416667 0.268000 40.0444444 0.268667 40.0472222 0.270000 40.0500000 0.270667 40.0527778 0.270667 40.0555556 0.268667 40.0583333 0.268667 40.0611111 0.268000 40.0638889 0.268667 40.0666667 0.270000 40.0694444 0.270000 40.0722222 0.272667 40.0750000 0.272000 40.0777778 0.272000 40.0805556 0.271333 40.0833333 0.272000 40.0861111 0.270000 40.0888889 0.271333 40.0916667 0.268000 40.0944444 0.268000 40.0972222 0.268000 40.1000000 0.267333 40.1027778 0.269333 40.1055556 0.270000 40.1083333 0.270667 40.1111111 0.270667 40.1138889 0.272000 40.1166667 0.273333 40.1194444 0.271333 40.1222222 0.272000 40.1250000 0.273333 40.1277778 0.272000 40.1305556 0.271333 40.1333333 0.270000 40.1361111 0.270000 40.1388889 0.270000 40.1416667 0.270000 40.1444444 0.270667 40.1472222 0.273333 40.1500000 0.273333 40.1527778 0.274000 40.1555556 0.274000 40.1583333 0.271333 40.1611111 0.272000 40.1638889 0.271333 40.1666667 0.271333 40.1694444 0.270000 40.1722222 0.268667 40.1750000 0.269333 40.1777778 0.272667 40.1805556 0.273333 40.1833333 0.276667 40.1861111 0.276667 40.1888889 0.280000 40.1916667 0.279333 40.1944444 0.281333 40.1972222 0.286000 40.2000000 0.293333 40.2027778 0.303333 40.2055556 0.317333 40.2083333 0.333333 40.2111111 0.352000 40.2138889 0.365333 40.2166667 0.376000 40.2194444 0.377333 40.2222222 0.364000 40.2250000 0.338000 40.2277778 0.300000 40.2305556 0.265333 40.2333333 0.237333 40.2361111 0.219333 40.2388889 0.212667 40.2416667 0.213333 40.2444444 0.218667 40.2472222 0.225333 40.2500000 0.232667 40.2527778 0.237333 40.2555556 0.240667 40.2583333 0.240000 40.2611111 0.238000 40.2638889 0.235333 40.2666667 0.233333 40.2694444 0.233333 40.2722222 0.235333 40.2750000 0.242000 40.2777778 0.248667 40.2805556 0.253333 40.2833333 0.254000 40.2861111 0.255333 40.2888889 0.252667 40.2916667 0.251333 40.2944444 0.248000 40.2972222 0.247333 40.3000000 0.246667 40.3027778 0.248000 40.3055556 0.250000 40.3083333 0.252667 40.3111111 0.256667 40.3138889 0.261333 40.3166667 0.266667 40.3194444 0.268667 40.3222222 0.270000 40.3250000 0.270667 40.3277778 0.269333 40.3305556 0.269333 40.3333333 0.268000 40.3361111 0.268667 40.3388889 0.269333 40.3416667 0.270000 40.3444444 0.270000 40.3472222 0.270667 40.3500000 0.272000 40.3527778 0.272000 40.3555556 0.272000 40.3583333 0.272000 40.3611111 0.272000 40.3638889 0.272667 40.3666667 0.270667 40.3694444 0.270667 40.3722222 0.268667 40.3750000 0.269333 40.3777778 0.271333 40.3805556 0.272000 40.3833333 0.272000 40.3861111 0.274000 40.3888889 0.272000 40.3916667 0.274000 40.3944444 0.272667 40.3972222 0.275333 40.4000000 0.276000 40.4027778 0.275333 40.4055556 0.276667 40.4083333 0.276000 40.4111111 0.277333 40.4138889 0.276667 40.4166667 0.278000 40.4194444 0.278000 40.4222222 0.278000 40.4250000 0.278667 40.4277778 0.275333 40.4305556 0.276667 40.4333333 0.274667 40.4361111 0.275333 40.4388889 0.276667 40.4416667 0.279333 40.4444444 0.281333 40.4472222 0.285333 40.4500000 0.286000 40.4527778 0.287333 40.4555556 0.286000 40.4583333 0.287333 40.4611111 0.285333 40.4638889 0.285333 40.4666667 0.286000 40.4694444 0.287333 40.4722222 0.289333 40.4750000 0.292667 40.4777778 0.294000 40.4805556 0.295333 40.4833333 0.298000 40.4861111 0.300000 40.4888889 0.300667 40.4916667 0.300667 40.4944444 0.301333 40.4972222 0.302000 40.5000000 0.302667 40.5027778 0.302000 40.5055556 0.303333 40.5083333 0.304667 40.5111111 0.304667 40.5168889 0.300000 40.7138889 0.300000)
Vecg1 ecg_l1 0 PWL(0.0000000 0.300000 0.4275556 0.300000 0.4305556 0.302000 0.4333333 0.301333 0.4361111 0.302000 0.4388889 0.303333 0.4416667 0.304667 0.4444444 0.308000 0.4472222 0.306000 0.4500000 0.304000 0.4527778 0.304000 0.4555556 0.303333 0.4583333 0.302000 0.4611111 0.303333 0.4638889 0.303333 0.4666667 0.306000 0.4694444 0.307333 0.4722222 0.308667 0.4750000 0.311333 0.4777778 0.309333 0.4805556 0.306667 0.4833333 0.306667 0.4861111 0.305333 0.4888889 0.303333 0.4916667 0.304000 0.4944444 0.303333 0.4972222 0.303333 0.5000000 0.301333 0.5027778 0.302000 0.5055556 0.302667 0.5083333 0.306667 0.5111111 0.306000 0.5138889 0.306667 0.5166667 0.306667 0.5194444 0.305333 0.5222222 0.304667 0.5250000 0.305333 0.5277778 0.304000 0.5305556 0.306000 0.5333333 0.306000 0.5361111 0.309333 0.5388889 0.310000 0.5416667 0.312667 0.5444444 0.312000 0.5472222 0.311333 0.5500000 0.311333 0.5527778 0.310000 0.5555556 0.310000 0.5583333 0.309333 0.5611111 0.308667 0.5638889 0.310000 0.5666667 0.310667 0.5694444 0.310667 0.5722222 0.312667 0.5750000 0.312667 0.5777778 0.313333 0.5805556 0.312667 0.5833333 0.312667 0.5861111 0.313333 0.5888889 0.314000 0.5916667 0.312000 0.5944444 0.310667 0.5972222 0.310000 0.6000000 0.312667 0.6027778 0.313333 0.6055556 0.314667 0.6083333 0.315333 0.6111111 0.314000 0.6138889 0.314000 0.6166667 0.313333 0.6194444 0.312000 0.6222222 0.311333 0.6250000 0.312000 0.6277778 0.311333 0.6305556 0.313333 0.6333333 0.314000 0.6361111 0.316000 0.6388889 0.315333 0.6416667 0.315333 0.6444444 0.314000 0.6472222 0.315333 0.6500000 0.316667 0.6527778 0.318667 0.6555556 0.320667 0.6583333 0.320000 0.6611111 0.321333 0.6638889 0.318667 0.6666667 0.313333 0.6694444 0.304000 0.6722222 0.290667 0.6750000 0.276000 0.6777778 0.262000 0.6805556 0.251333 0.6833333 0.244000 0.6861111 0.239333 0.6888889 0.244000 0.6916667 0.256667 0.6944444 0.276000 0.6972222 0.298667 0.7000000 0.323333 0.7027778 0.343333 0.7055556 0.355333 0.7083333 0.363333 0.7111111 0.364000 0.7138889 0.364000 0.7166667 0.362000 0.7194444 0.362667 0.7222222 0.364667 0.7250000 0.366000 0.7277778 0.370000 0.7305556 0.374667 0.7333333 0.378667 0.7361111 0.382667 0.7388889 0.386667 0.7416667 0.390000 0.7444444 0.391333 0.7472222 0.392000 0.7500000 0.392667 0.7527778 0.388000 0.7555556 0.381333 0.7583333 0.374667 0.7611111 0.362667 0.7638889 0.350000 0.7666667 0.338667 0.7694444 0.328000 0.7722222 0.316667 0.7750000 0.309333 0.7777778 0.303333 0.7805556 0.300000 0.7833333 0.300000 0.7861111 0.300000 0.7888889 0.298667 0.7916667 0.298000 0.7944444 0.299333 0.7972222 0.300000 0.8000000 0.298667 0.8027778 0.298000 0.8055556 0.299333 0.8083333 0.298667 0.8111111 0.298667 0.8138889 0.301333 0.8166667 0.299333 0.8194444 0.297333 0.8222222 0.296667 0.8250000 0.296000 0.8277778 0.296000 0.8305556 0.296000 0.8333333 0.298000 0.8361111 0.298000 0.8388889 0.299333 0.8416667 0.299333 0.8444444 0.299333 0.8472222 0.298000 0.8500000 0.298000 0.8527778 0.296000 0.8555556 0.294000 0.8583333 0.293333 0.8611111 0.293333 0.8638889 0.292000 0.8666667 0.294000 0.8694444 0.295333 0.8722222 0.295333 0.8750000 0.296667 0.8777778 0.295333 0.8805556 0.294667 0.8833333 0.294000 0.8861111 0.291333 0.8888889 0.290000 0.8916667 0.290667 0.8944444 0.289333 0.8972222 0.288667 0.9000000 0.287333 0.9027778 0.287333 0.9055556 0.288667 0.9083333 0.288667 0.9111111 0.286667 0.9138889 0.284000 0.9166667 0.282667 0.9194444 0.278667 0.9222222 0.278000 0.9250000 0.276000 0.9277778 0.276000 0.9305556 0.276667 0.9333333 0.277333 0.9361111 0.276000 0.9388889 0.274667 0.9416667 0.275333 0.9444444 0.275333 0.9472222 0.271333 0.9500000 0.273333 0.9527778 0.269333 0.9555556 0.268667 0.9583333 0.268667 0.9611111 0.268667 0.9638889 0.268667 0.9666667 0.270667 0.9694444 0.271333 0.9722222 0.274000 0.9750000 0.277333 0.9777778 0.278000 0.9835556 0.300000 1.1636667 0.300000 1.1666667 0.303333 1.1694444 0.302000 1.1722222 0.301333 1.1750000 0.301333 1.1777778 0.301333 1.1805556 0.300667 1.1833333 0.302000 1.1861111 0.298667 1.1888889 0.299333 1.1916667 0.297333 1.1944444 0.297333 1.1972222 0.298000 1.2000000 0.296667 1.2027778 0.297333 1.2055556 0.299333 1.2083333 0.300000 1.2111111 0.300000 1.2138889 0.300000 1.2166667 0.298667 1.2194444 0.300000 1.2222222 0.300000 1.2250000 0.298000 1.2277778 0.298000 1.2305556 0.299333 1.2333333 0.297333 1.2361111 0.296667 1.2388889 0.296667 1.2416667 0.295333 1.2444444 0.294667 1.2472222 0.296667 1.2500000 0.295333 1.2527778 0.295333 1.2555556 0.298667 1.2583333 0.300000 1.2611111 0.302000 1.2638889 0.303333 1.2666667 0.303333 1.2694444 0.305333 1.2722222 0.308667 1.2750000 0.311333 1.2777778 0.313333 1.2805556 0.316667 1.2833333 0.318000 1.2861111 0.318667 1.2888889 0.317333 1.2916667 0.314000 1.2944444 0.310000 1.2972222 0.311333 1.3000000 0.310000 1.3027778 0.311333 1.3055556 0.316000 1.3083333 0.320000 1.3111111 0.320000 1.3138889 0.318667 1.3166667 0.318000 1.3194444 0.314667 1.3222222 0.313333 1.3250000 0.311333 1.3277778 0.312667 1.3305556 0.312000 1.3333333 0.314000 1.3361111 0.316000 1.3388889 0.315333 1.3416667 0.318667 1.3444444 0.318667 1.3472222 0.318000 1.3500000 0.317333 1.3527778 0.318000 1.3555556 0.316000 1.3583333 0.318000 1.3611111 0.316667 1.3638889 0.315333 1.3666667 0.310667 1.3694444 0.306667 1.3722222 0.302667 1.3750000 0.302667 1.3777778 0.305333 1.3805556 0.306667 1.3833333 0.308000 1.3861111 0.310667 1.3888889 0.311333 1.3916667 0.314000 1.3944444 0.314667 1.3972222 0.316667 1.4000000 0.316667 1.4027778 0.318000 1.4055556 0.312000 1.4083333 0.306000 1.4111111 0.292667 1.4138889 0.279333 1.4166667 0.266667 1.4194444 0.250667 1.4222222 0.241333 1.4250000 0.235333 1.4277778 0.232667 1.4305556 0.240000 1.4333333 0.254667 1.4361111 0.278000 1.4388889 0.303333 1.4416667 0.328667 1.4444444 0.349333 1.4472222 0.358667 1.4500000 0.362667 1.4527778 0.362000 1.4555556 0.360667 1.4583333 0.357333 1.4611111 0.357333 1.4638889 0.361333 1.4666667 0.366000 1.4694444 0.370667 1.4722222 0.376667 1.4750000 0.380667 1.4777778 0.382667 1.4805556 0.384667 1.4833333 0.385333 1.4861111 0.385333 1.4888889 0.386667 1.4916667 0.388000 1.4944444 0.386000 1.4972222 0.383333 1.5000000 0.376667 1.5027778 0.371333 1.5055556 0.361333 1.5083333 0.352667 1.5111111 0.342000 1.5138889 0.330667 1.5166667 0.319333 1.5194444 0.310667 1.5222222 0.307333 1.5250000 0.302000 1.5277778 0.300667 1.5305556 0.302000 1.5333333 0.302667 1.5361111 0.304000 1.5388889 0.304000 1.5416667 0.304667 1.5444444 0.306000 1.5472222 0.303333 1.5500000 0.302667 1.5527778 0.302667 1.5555556 0.300667 1.5583333 0.301333 1.5611111 0.299333 1.5638889 0.300667 1.5666667 0.301333 1.5694444 0.301333 1.5722222 0.302667 1.5750000 0.304000 1.5777778 0.305333 1.5805556 0.304000 1.5833333 0.304667 1.5861111 0.302000 1.5888889 0.302667 1.5916667 0.301333 1.5944444 0.302000 1.5972222 0.302667 1.6000000 0.304667 1.6027778 0.306000 1.6055556 0.307333 1.6083333 0.308000 1.6111111 0.308000 1.6138889 0.304000 1.6166667 0.303333 1.6194444 0.301333 1.6222222 0.300000 1.6250000 0.299333 1.6277778 0.298667 1.6305556 0.300000 1.6333333 0.299333 1.6361111 0.300000 1.6388889 0.298667 1.6416667 0.299333 1.6444444 0.296000 1.6472222 0.294000 1.6500000 0.292000 1.6527778 0.289333 1.6555556 0.289333 1.6583333 0.288667 1.6611111 0.289333 1.6638889 0.290667 1.6666667 0.290000 1.6694444 0.290667 1.6722222 0.288667 1.6750000 0.286667 1.6777778 0.285333 1.6805556 0.283333 1.6833333 0.282000 1.6861111 0.278667 1.6888889 0.279333 1.6916667 0.276667 1.6944444 0.277333 1.6972222 0.277333 1.7000000 0.275333 1.7027778 0.278000 1.7055556 0.276667 1.7083333 0.276000 1.7111111 0.276000 1.7138889 0.274000 1.7196667 0.300000 1.9108889 0.300000 1.9138889 0.313333 1.9166667 0.312000 1.9194444 0.313333 1.9222222 0.310000 1.9250000 0.308667 1.9277778 0.307333 1.9305556 0.308667 1.9333333 0.309333 1.9361111 0.310000 1.9388889 0.310667 1.9416667 0.312000 1.9444444 0.312667 1.9472222 0.312667 1.9500000 0.313333 1.9527778 0.313333 1.9555556 0.310667 1.9583333 0.307333 1.9611111 0.306000 1.9638889 0.306667 1.9666667 0.306000 1.9694444 0.309333 1.9722222 0.309333 1.9750000 0.310667 1.9777778 0.310000 1.9805556 0.310000 1.9833333 0.310000 1.9861111 0.309333 1.9888889 0.308000 1.9916667 0.308000 1.9944444 0.307333 1.9972222 0.308000 2.0000000 0.308000 2.0027778 0.310000 2.0055556 0.312000 2.0083333 0.314000 2.0111111 0.317333 2.0138889 0.318000 2.0166667 0.319333 2.0194444 0.318000 2.0222222 0.316000 2.0250000 0.314667 2.0277778 0.312667 2.0305556 0.310667 2.0333333 0.312667 2.0361111 0.314667 2.0388889 0.315333 2.0416667 0.318000 2.0444444 0.316667 2.0472222 0.315333 2.0500000 0.314000 2.0527778 0.312667 2.0555556 0.310667 2.0583333 0.308667 2.0611111 0.308667 2.0638889 0.309333 2.0666667 0.310667 2.0694444 0.314000 2.0722222 0.312000 2.0750000 0.313333 2.0777778 0.314000 2.0805556 0.312000 2.0833333 0.310667 2.0861111 0.310667 2.0888889 0.308667 2.0916667 0.308000 2.0944444 0.308000 2.0972222 0.308000 2.1000000 0.308000 2.1027778 0.307333 2.1055556 0.307333 2.1083333 0.308667 2.1111111 0.310000 2.1138889 0.307333 2.1166667 0.309333 2.1194444 0.308667 2.1222222 0.306000 2.1250000 0.306667 2.1277778 0.306667 2.1305556 0.308667 2.1333333 0.312667 2.1361111 0.315333 2.1388889 0.319333 2.1416667 0.320000 2.1444444 0.318667 2.1472222 0.314667 2.1500000 0.305333 2.1527778 0.292667 2.1555556 0.278667 2.1583333 0.263333 2.1611111 0.250667 2.1638889 0.240000 2.1666667 0.231333 2.1694444 0.228000 2.1722222 0.229333 2.1750000 0.236000 2.1777778 0.248000 2.1805556 0.267333 2.1833333 0.290667 2.1861111 0.316000 2.1888889 0.338000 2.1916667 0.354667 2.1944444 0.359333 2.1972222 0.359333 2.2000000 0.358000 2.2027778 0.356667 2.2055556 0.358000 2.2083333 0.363333 2.2111111 0.368667 2.2138889 0.373333 2.2166667 0.376667 2.2194444 0.378000 2.2222222 0.378000 2.2250000 0.378000 2.2277778 0.380000 2.2305556 0.382000 2.2333333 0.384000 2.2361111 0.386000 2.2388889 0.380667 2.2416667 0.376667 2.2444444 0.371333 2.2472222 0.364000 2.2500000 0.356000 2.2527778 0.344667 2.2555556 0.334000 2.2583333 0.324667 2.2611111 0.314000 2.2638889 0.307333 2.2666667 0.300000 2.2694444 0.298667 2.2722222 0.296667 2.2750000 0.296667 2.2777778 0.296000 2.2805556 0.296000 2.2833333 0.296000 2.2861111 0.296667 2.2888889 0.296667 2.2916667 0.294000 2.2944444 0.292667 2.2972222 0.291333 2.3000000 0.291333 2.3027778 0.288667 2.3055556 0.291333 2.3083333 0.292000 2.3111111 0.292000 2.3138889 0.293333 2.3166667 0.292667 2.3194444 0.291333 2.3222222 0.291333 2.3250000 0.291333 2.3277778 0.290000 2.3305556 0.289333 2.3333333 0.290000 2.3361111 0.289333 2.3388889 0.290000 2.3416667 0.291333 2.3444444 0.290667 2.3472222 0.290000 2.3500000 0.291333 2.3527778 0.290000 2.3555556 0.291333 2.3583333 0.289333 2.3611111 0.287333 2.3638889 0.286000 2.3666667 0.286000 2.3694444 0.286000 2.3722222 0.287333 2.3750000 0.287333 2.3777778 0.287333 2.3805556 0.286000 2.3833333 0.284000 2.3861111 0.280667 2.3888889 0.279333 2.3916667 0.276000 2.3944444 0.276667 2.3972222 0.274000 2.4000000 0.276000 2.4027778 0.277333 2.4055556 0.276667 2.4083333 0.277333 2.4111111 0.276000 2.4138889 0.274667 2.4166667 0.270667 2.4194444 0.268667 2.4222222 0.266667 2.4250000 0.266000 2.4277778 0.266000 2.4305556 0.266667 2.4333333 0.264667 2.4361111 0.266667 2.4388889 0.264667 2.4416667 0.265333 2.4444444 0.265333 2.4472222 0.266000 2.4500000 0.266000 2.4527778 0.264000 2.4555556 0.262667 2.4583333 0.261333 2.4611111 0.260667 2.4668889 0.300000 2.6470000 0.300000 2.6500000 0.290667 2.6527778 0.289333 2.6555556 0.288667 2.6583333 0.289333 2.6611111 0.291333 2.6638889 0.292667 2.6666667 0.295333 2.6694444 0.293333 2.6722222 0.294000 2.6750000 0.294000 2.6777778 0.294667 2.6805556 0.294000 2.6833333 0.294000 2.6861111 0.294000 2.6888889 0.296000 2.6916667 0.295333 2.6944444 0.295333 2.6972222 0.294000 2.7000000 0.292667 2.7027778 0.292667 2.7055556 0.295333 2.7083333 0.296667 2.7111111 0.296667 2.7138889 0.298667 2.7166667 0.299333 2.7194444 0.297333 2.7222222 0.293333 2.7250000 0.292000 2.7277778 0.291333 2.7305556 0.292000 2.7333333 0.294000 2.7361111 0.296000 2.7388889 0.297333 2.7416667 0.300000 2.7444444 0.301333 2.7472222 0.300667 2.7500000 0.300000 2.7527778 0.299333 2.7555556 0.298667 2.7583333 0.298667 2.7611111 0.298667 2.7638889 0.298000 2.7666667 0.298000 2.7694444 0.299333 2.7722222 0.300667 2.7750000 0.301333 2.7777778 0.301333 2.7805556 0.303333 2.7833333 0.305333 2.7861111 0.306000 2.7888889 0.304667 2.7916667 0.303333 2.7944444 0.302000 2.7972222 0.302000 2.8000000 0.304000 2.8027778 0.305333 2.8055556 0.306667 2.8083333 0.306667 2.8111111 0.307333 2.8138889 0.304667 2.8166667 0.304667 2.8194444 0.303333 2.8222222 0.302000 2.8250000 0.300667 2.8277778 0.300000 2.8305556 0.300667 2.8333333 0.301333 2.8361111 0.302667 2.8388889 0.304667 2.8416667 0.308667 2.8444444 0.310000 2.8472222 0.308667 2.8500000 0.308000 2.8527778 0.307333 2.8555556 0.307333 2.8583333 0.304000 2.8611111 0.304000 2.8638889 0.302667 2.8666667 0.304000 2.8694444 0.307333 2.8722222 0.308000 2.8750000 0.309333 2.8777778 0.310000 2.8805556 0.309333 2.8833333 0.310000 2.8861111 0.305333 2.8888889 0.300667 2.8916667 0.291333 2.8944444 0.280667 2.8972222 0.270000 2.9000000 0.258667 2.9027778 0.249333 2.9055556 0.246000 2.9083333 0.247333 2.9111111 0.255333 2.9138889 0.267333 2.9166667 0.282000 2.9194444 0.300000 2.9222222 0.314000 2.9250000 0.325333 2.9277778 0.331333 2.9305556 0.334000 2.9333333 0.332667 2.9361111 0.335333 2.9388889 0.336667 2.9416667 0.340667 2.9444444 0.344000 2.9472222 0.346000 2.9500000 0.346667 2.9527778 0.349333 2.9555556 0.350667 2.9583333 0.350000 2.9611111 0.353333 2.9638889 0.354667 2.9666667 0.358000 2.9694444 0.360667 2.9722222 0.362667 2.9750000 0.362667 2.9777778 0.360667 2.9805556 0.356667 2.9833333 0.351333 2.9861111 0.342667 2.9888889 0.332000 2.9916667 0.324000 2.9944444 0.315333 2.9972222 0.311333 3.0000000 0.303333 3.0027778 0.296667 3.0055556 0.292000 3.0083333 0.291333 3.0111111 0.289333 3.0138889 0.291333 3.0166667 0.291333 3.0194444 0.290667 3.0222222 0.290667 3.0250000 0.290000 3.0277778 0.291333 3.0305556 0.292000 3.0333333 0.295333 3.0361111 0.295333 3.0388889 0.295333 3.0416667 0.295333 3.0444444 0.294000 3.0472222 0.291333 3.0500000 0.289333 3.0527778 0.288667 3.0555556 0.289333 3.0583333 0.289333 3.0611111 0.291333 3.0638889 0.293333 3.0666667 0.294000 3.0694444 0.296000 3.0722222 0.292667 3.0750000 0.292667 3.0777778 0.292000 3.0805556 0.292000 3.0833333 0.291333 3.0861111 0.291333 3.0888889 0.289333 3.0916667 0.288667 3.0944444 0.288667 3.0972222 0.290667 3.1000000 0.292000 3.1027778 0.293333 3.1055556 0.294667 3.1083333 0.296667 3.1111111 0.297333 3.1138889 0.296000 3.1166667 0.296667 3.1194444 0.292667 3.1222222 0.286000 3.1250000 0.281333 3.1277778 0.277333 3.1305556 0.277333 3.1333333 0.280667 3.1361111 0.284667 3.1388889 0.288667 3.1416667 0.288667 3.1444444 0.284667 3.1472222 0.277333 3.1500000 0.270667 3.1527778 0.264667 3.1555556 0.260000 3.1583333 0.258000 3.1611111 0.258000 3.1638889 0.260000 3.1666667 0.262667 3.1694444 0.263333 3.1722222 0.262667 3.1750000 0.265333 3.1777778 0.268000 3.1805556 0.268667 3.1833333 0.270667 3.1861111 0.271333 3.1888889 0.270667 3.1916667 0.267333 3.1944444 0.267333 3.1972222 0.265333 3.2030000 0.300000 3.3803333 0.300000 3.3833333 0.316000 3.3861111 0.312667 3.3888889 0.311333 3.3916667 0.312000 3.3944444 0.311333 3.3972222 0.314000 3.4000000 0.314000 3.4027778 0.314000 3.4055556 0.313333 3.4083333 0.315333 3.4111111 0.315333 3.4138889 0.313333 3.4166667 0.313333 3.4194444 0.314000 3.4222222 0.312667 3.4250000 0.312000 3.4277778 0.313333 3.4305556 0.312667 3.4333333 0.314667 3.4361111 0.316667 3.4388889 0.318000 3.4416667 0.320000 3.4444444 0.322667 3.4472222 0.322667 3.4500000 0.322000 3.4527778 0.323333 3.4555556 0.322000 3.4583333 0.323333 3.4611111 0.326667 3.4638889 0.327333 3.4666667 0.328000 3.4694444 0.331333 3.4722222 0.330667 3.4750000 0.328000 3.4777778 0.322000 3.4805556 0.320000 3.4833333 0.316000 3.4861111 0.314000 3.4888889 0.311333 3.4916667 0.309333 3.4944444 0.308000 3.4972222 0.304000 3.5000000 0.304000 3.5027778 0.302000 3.5055556 0.302667 3.5083333 0.306667 3.5111111 0.308000 3.5138889 0.310667 3.5166667 0.312667 3.5194444 0.314667 3.5222222 0.317333 3.5250000 0.318667 3.5277778 0.318000 3.5305556 0.316667 3.5333333 0.316667 3.5361111 0.316667 3.5388889 0.316000 3.5416667 0.314667 3.5444444 0.312000 3.5472222 0.310667 3.5500000 0.306000 3.5527778 0.304667 3.5555556 0.302667 3.5583333 0.302000 3.5611111 0.302667 3.5638889 0.306667 3.5666667 0.306667 3.5694444 0.310000 3.5722222 0.312000 3.5750000 0.314000 3.5777778 0.314000 3.5805556 0.313333 3.5833333 0.312000 3.5861111 0.311333 3.5888889 0.310667 3.5916667 0.312000 3.5944444 0.311333 3.5972222 0.312000 3.6000000 0.314000 3.6027778 0.314667 3.6055556 0.316667 3.6083333 0.318667 3.6111111 0.322667 3.6138889 0.322000 3.6166667 0.321333 3.6194444 0.318000 3.6222222 0.311333 3.6250000 0.302000 3.6277778 0.290667 3.6305556 0.280667 3.6333333 0.269333 3.6361111 0.261333 3.6388889 0.256000 3.6416667 0.256000 3.6444444 0.260000 3.6472222 0.272000 3.6500000 0.288000 3.6527778 0.302667 3.6555556 0.320667 3.6583333 0.334667 3.6611111 0.342000 3.6638889 0.347333 3.6666667 0.350000 3.6694444 0.350667 3.6722222 0.350667 3.6750000 0.354000 3.6777778 0.356667 3.6805556 0.357333 3.6833333 0.364000 3.6861111 0.364000 3.6888889 0.365333 3.6916667 0.369333 3.6944444 0.370000 3.6972222 0.372667 3.7000000 0.374667 3.7027778 0.376000 3.7055556 0.376667 3.7083333 0.376000 3.7111111 0.372667 3.7138889 0.368667 3.7166667 0.362667 3.7194444 0.352000 3.7222222 0.342667 3.7250000 0.334000 3.7277778 0.324000 3.7305556 0.317333 3.7333333 0.312000 3.7361111 0.308667 3.7388889 0.307333 3.7416667 0.310000 3.7444444 0.306667 3.7472222 0.309333 3.7500000 0.309333 3.7527778 0.307333 3.7555556 0.308000 3.7583333 0.304667 3.7611111 0.304667 3.7638889 0.306000 3.7666667 0.305333 3.7694444 0.306000 3.7722222 0.307333 3.7750000 0.308000 3.7777778 0.306667 3.7805556 0.304667 3.7833333 0.305333 3.7861111 0.304000 3.7888889 0.304000 3.7916667 0.303333 3.7944444 0.304667 3.7972222 0.304000 3.8000000 0.304667 3.8027778 0.304667 3.8055556 0.304667 3.8083333 0.306000 3.8111111 0.304667 3.8138889 0.306000 3.8166667 0.306000 3.8194444 0.303333 3.8222222 0.302000 3.8250000 0.300667 3.8277778 0.300000 3.8305556 0.298667 3.8333333 0.298667 3.8361111 0.300000 3.8388889 0.300667 3.8416667 0.300667 3.8444444 0.301333 3.8472222 0.300000 3.8500000 0.296000 3.8527778 0.294667 3.8555556 0.291333 3.8583333 0.291333 3.8611111 0.289333 3.8638889 0.288000 3.8666667 0.288667 3.8694444 0.288667 3.8722222 0.287333 3.8750000 0.289333 3.8777778 0.286667 3.8805556 0.284000 3.8833333 0.284000 3.8861111 0.280000 3.8888889 0.280000 3.8916667 0.278000 3.8944444 0.278000 3.8972222 0.276667 3.9000000 0.276667 3.9027778 0.276667 3.9055556 0.278000 3.9083333 0.278000 3.9111111 0.278667 3.9138889 0.278000 3.9166667 0.277333 3.9194444 0.276667 3.9222222 0.277333 3.9250000 0.274667 3.9277778 0.277333 3.9305556 0.276667 3.9363333 0.300000 4.0914444 0.300000 4.0944444 0.308000 4.0972222 0.306667 4.1000000 0.306000 4.1027778 0.307333 4.1055556 0.307333 4.1083333 0.310000 4.1111111 0.308667 4.1138889 0.308667 4.1166667 0.308667 4.1194444 0.307333 4.1222222 0.305333 4.1250000 0.303333 4.1277778 0.304000 4.1305556 0.304667 4.1333333 0.306000 4.1361111 0.308667 4.1388889 0.309333 4.1416667 0.310000 4.1444444 0.310667 4.1472222 0.309333 4.1500000 0.310000 4.1527778 0.308667 4.1555556 0.308000 4.1583333 0.305333 4.1611111 0.307333 4.1638889 0.308000 4.1666667 0.310000 4.1694444 0.309333 4.1722222 0.310667 4.1750000 0.310667 4.1777778 0.310000 4.1805556 0.312000 4.1833333 0.312667 4.1861111 0.310000 4.1888889 0.310667 4.1916667 0.309333 4.1944444 0.310667 4.1972222 0.309333 4.2000000 0.312667 4.2027778 0.314000 4.2055556 0.318000 4.2083333 0.318667 4.2111111 0.320000 4.2138889 0.317333 4.2166667 0.316000 4.2194444 0.316000 4.2222222 0.315333 4.2250000 0.318000 4.2277778 0.317333 4.2305556 0.317333 4.2333333 0.317333 4.2361111 0.316667 4.2388889 0.316000 4.2416667 0.318000 4.2444444 0.318000 4.2472222 0.318000 4.2500000 0.320667 4.2527778 0.318667 4.2555556 0.318000 4.2583333 0.315333 4.2611111 0.315333 4.2638889 0.315333 4.2666667 0.316667 4.2694444 0.317333 4.2722222 0.317333 4.2750000 0.320000 4.2777778 0.320000 4.2805556 0.319333 4.2833333 0.319333 4.2861111 0.317333 4.2888889 0.316000 4.2916667 0.315333 4.2944444 0.314667 4.2972222 0.316000 4.3000000 0.316667 4.3027778 0.316667 4.3055556 0.316667 4.3083333 0.320000 4.3111111 0.322667 4.3138889 0.323333 4.3166667 0.324667 4.3194444 0.324667 4.3222222 0.326667 4.3250000 0.324000 4.3277778 0.323333 4.3305556 0.319333 4.3333333 0.311333 4.3361111 0.304000 4.3388889 0.297333 4.3416667 0.287333 4.3444444 0.276667 4.3472222 0.267333 4.3500000 0.257333 4.3527778 0.255333 4.3555556 0.258000 4.3583333 0.267333 4.3611111 0.282667 4.3638889 0.302000 4.3666667 0.324667 4.3694444 0.344000 4.3722222 0.354667 4.3750000 0.364000 4.3777778 0.364000 4.3805556 0.361333 4.3833333 0.358667 4.3861111 0.356667 4.3888889 0.359333 4.3916667 0.361333 4.3944444 0.364000 4.3972222 0.369333 4.4000000 0.372000 4.4027778 0.375333 4.4055556 0.378667 4.4083333 0.381333 4.4111111 0.384667 4.4138889 0.385333 4.4166667 0.386667 4.4194444 0.384667 4.4222222 0.378667 4.4250000 0.372667 4.4277778 0.366667 4.4305556 0.355333 4.4333333 0.347333 4.4361111 0.338000 4.4388889 0.328667 4.4416667 0.320667 4.4444444 0.314667 4.4472222 0.310000 4.4500000 0.308000 4.4527778 0.308000 4.4555556 0.306000 4.4583333 0.306000 4.4611111 0.306667 4.4638889 0.307333 4.4666667 0.308000 4.4694444 0.309333 4.4722222 0.310000 4.4750000 0.310000 4.4777778 0.309333 4.4805556 0.308667 4.4833333 0.307333 4.4861111 0.304667 4.4888889 0.305333 4.4916667 0.305333 4.4944444 0.302667 4.4972222 0.306667 4.5000000 0.304667 4.5027778 0.304000 4.5055556 0.306667 4.5083333 0.308667 4.5111111 0.306667 4.5138889 0.307333 4.5166667 0.304667 4.5194444 0.303333 4.5222222 0.301333 4.5250000 0.300667 4.5277778 0.300000 4.5305556 0.300667 4.5333333 0.300667 4.5361111 0.300000 4.5388889 0.300000 4.5416667 0.300000 4.5444444 0.302000 4.5472222 0.300667 4.5500000 0.300000 4.5527778 0.299333 4.5555556 0.296000 4.5583333 0.295333 4.5611111 0.296000 4.5638889 0.293333 4.5666667 0.292667 4.5694444 0.294000 4.5722222 0.292000 4.5750000 0.292000 4.5777778 0.290667 4.5805556 0.290000 4.5833333 0.290667 4.5861111 0.288000 4.5888889 0.286000 4.5916667 0.284000 4.5944444 0.282667 4.5972222 0.284667 4.6000000 0.282667 4.6027778 0.284667 4.6055556 0.284000 4.6083333 0.284000 4.6111111 0.282667 4.6138889 0.283333 4.6166667 0.283333 4.6194444 0.280000 4.6222222 0.280000 4.6250000 0.276667 4.6277778 0.276667 4.6305556 0.276000 4.6333333 0.276667 4.6361111 0.276667 4.6388889 0.278000 4.6416667 0.280000 4.6474444 0.300000 6.1220000 0.300000 6.1250000 0.314667 6.1277778 0.315333 6.1305556 0.316667 6.1333333 0.316667 6.1361111 0.318667 6.1388889 0.318000 6.1416667 0.318667 6.1444444 0.320000 6.1472222 0.320000 6.1500000 0.320667 6.1527778 0.319333 6.1555556 0.318667 6.1583333 0.318667 6.1611111 0.319333 6.1638889 0.318000 6.1666667 0.318667 6.1694444 0.320000 6.1722222 0.320667 6.1750000 0.320667 6.1777778 0.320667 6.1805556 0.319333 6.1833333 0.317333 6.1861111 0.316000 6.1888889 0.312667 6.1916667 0.312667 6.1944444 0.312000 6.1972222 0.312000 6.2000000 0.313333 6.2027778 0.314000 6.2055556 0.314000 6.2083333 0.316000 6.2111111 0.316667 6.2138889 0.314667 6.2166667 0.314000 6.2194444 0.313333 6.2222222 0.311333 6.2250000 0.310000 6.2277778 0.311333 6.2305556 0.313333 6.2333333 0.314667 6.2361111 0.318000 6.2388889 0.320000 6.2416667 0.319333 6.2444444 0.320667 6.2472222 0.319333 6.2500000 0.318000 6.2527778 0.319333 6.2555556 0.318667 6.2583333 0.318000 6.2611111 0.317333 6.2638889 0.316667 6.2666667 0.317333 6.2694444 0.320000 6.2722222 0.321333 6.2750000 0.322000 6.2777778 0.322000 6.2805556 0.322667 6.2833333 0.320667 6.2861111 0.320667 6.2888889 0.320667 6.2916667 0.318667 6.2944444 0.316667 6.2972222 0.318667 6.3000000 0.318000 6.3027778 0.320000 6.3055556 0.321333 6.3083333 0.321333 6.3111111 0.322667 6.3138889 0.323333 6.3166667 0.320667 6.3194444 0.320667 6.3222222 0.322667 6.3250000 0.320000 6.3277778 0.320000 6.3305556 0.319333 6.3333333 0.318667 6.3361111 0.320000 6.3388889 0.322000 6.3416667 0.323333 6.3444444 0.326667 6.3472222 0.328000 6.3500000 0.330667 6.3527778 0.329333 6.3555556 0.328667 6.3583333 0.323333 6.3611111 0.316667 6.3638889 0.308667 6.3666667 0.299333 6.3694444 0.290000 6.3722222 0.279333 6.3750000 0.269333 6.3777778 0.260667 6.3805556 0.255333 6.3833333 0.256000 6.3861111 0.263333 6.3888889 0.275333 6.3916667 0.292667 6.3944444 0.312000 6.3972222 0.331333 6.4000000 0.345333 6.4027778 0.356667 6.4055556 0.363333 6.4083333 0.364000 6.4111111 0.367333 6.4138889 0.367333 6.4166667 0.369333 6.4194444 0.370667 6.4222222 0.374000 6.4250000 0.374667 6.4277778 0.381333 6.4305556 0.382000 6.4333333 0.388000 6.4361111 0.392000 6.4388889 0.396000 6.4416667 0.398000 6.4444444 0.400000 6.4472222 0.400000 6.4500000 0.396667 6.4527778 0.391333 6.4555556 0.382667 6.4583333 0.375333 6.4611111 0.365333 6.4638889 0.356000 6.4666667 0.346667 6.4694444 0.340000 6.4722222 0.336000 6.4750000 0.329333 6.4777778 0.326667 6.4805556 0.322000 6.4833333 0.320000 6.4861111 0.317333 6.4888889 0.319333 6.4916667 0.318000 6.4944444 0.318667 6.4972222 0.320000 6.5000000 0.320000 6.5027778 0.319333 6.5055556 0.320667 6.5083333 0.319333 6.5111111 0.320000 6.5138889 0.320667 6.5166667 0.320000 6.5194444 0.318667 6.5222222 0.317333 6.5250000 0.316667 6.5277778 0.315333 6.5305556 0.314667 6.5333333 0.315333 6.5361111 0.317333 6.5388889 0.317333 6.5416667 0.317333 6.5444444 0.318667 6.5472222 0.316667 6.5500000 0.316667 6.5527778 0.316000 6.5555556 0.315333 6.5583333 0.314000 6.5611111 0.315333 6.5638889 0.312667 6.5666667 0.314000 6.5694444 0.314000 6.5722222 0.315333 6.5750000 0.314667 6.5777778 0.315333 6.5805556 0.313333 6.5833333 0.314000 6.5861111 0.314000 6.5888889 0.312000 6.5916667 0.308667 6.5944444 0.308000 6.5972222 0.308000 6.6000000 0.308667 6.6027778 0.308667 6.6055556 0.308667 6.6083333 0.311333 6.6111111 0.310667 6.6138889 0.307333 6.6166667 0.307333 6.6194444 0.304667 6.6222222 0.303333 6.6250000 0.300667 6.6277778 0.299333 6.6305556 0.298667 6.6333333 0.299333 6.6361111 0.299333 6.6388889 0.301333 6.6416667 0.301333 6.6444444 0.300000 6.6472222 0.298667 6.6500000 0.296000 6.6527778 0.295333 6.6555556 0.292000 6.6583333 0.291333 6.6611111 0.289333 6.6638889 0.289333 6.6666667 0.288000 6.6694444 0.290000 6.6722222 0.288000 6.6780000 0.300000 8.8386667 0.300000 8.8416667 0.318000 8.8444444 0.319333 8.8472222 0.320000 8.8500000 0.318000 8.8527778 0.317333 8.8555556 0.315333 8.8583333 0.316000 8.8611111 0.314000 8.8638889 0.314667 8.8666667 0.316667 8.8694444 0.318667 8.8722222 0.318667 8.8750000 0.320000 8.8777778 0.321333 8.8805556 0.320000 8.8833333 0.319333 8.8861111 0.319333 8.8888889 0.320667 8.8916667 0.318000 8.8944444 0.317333 8.8972222 0.314667 8.9000000 0.314667 8.9027778 0.314000 8.9055556 0.314000 8.9083333 0.314000 8.9111111 0.312667 8.9138889 0.312667 8.9166667 0.310667 8.9194444 0.310000 8.9222222 0.309333 8.9250000 0.307333 8.9277778 0.307333 8.9305556 0.306000 8.9333333 0.308000 8.9361111 0.310667 8.9388889 0.311333 8.9416667 0.310667 8.9444444 0.310000 8.9472222 0.309333 8.9500000 0.311333 8.9527778 0.311333 8.9555556 0.312667 8.9583333 0.313333 8.9611111 0.312000 8.9638889 0.312000 8.9666667 0.310000 8.9694444 0.310667 8.9722222 0.312667 8.9750000 0.312667 8.9777778 0.314667 8.9805556 0.314667 8.9833333 0.314667 8.9861111 0.312667 8.9888889 0.312000 8.9916667 0.312667 8.9944444 0.310000 8.9972222 0.310000 9.0000000 0.310000 9.0027778 0.312667 9.0055556 0.314667 9.0083333 0.316000 9.0111111 0.315333 9.0138889 0.316667 9.0166667 0.316000 9.0194444 0.314667 9.0222222 0.313333 9.0250000 0.312667 9.0277778 0.313333 9.0305556 0.311333 9.0333333 0.314000 9.0361111 0.316000 9.0388889 0.316000 9.0416667 0.316667 9.0444444 0.317333 9.0472222 0.315333 9.0500000 0.317333 9.0527778 0.315333 9.0555556 0.315333 9.0583333 0.315333 9.0611111 0.316000 9.0638889 0.318000 9.0666667 0.319333 9.0694444 0.322000 9.0722222 0.323333 9.0750000 0.324000 9.0777778 0.318667 9.0805556 0.313333 9.0833333 0.303333 9.0861111 0.290667 9.0888889 0.274667 9.0916667 0.258667 9.0944444 0.245333 9.0972222 0.236000 9.1000000 0.234000 9.1027778 0.242000 9.1055556 0.256000 9.1083333 0.280667 9.1111111 0.306667 9.1138889 0.330000 9.1166667 0.346667 9.1194444 0.356667 9.1222222 0.359333 9.1250000 0.358667 9.1277778 0.356667 9.1305556 0.356667 9.1333333 0.357333 9.1361111 0.364667 9.1388889 0.370000 9.1416667 0.374667 9.1444444 0.378667 9.1472222 0.382000 9.1500000 0.382667 9.1527778 0.384667 9.1555556 0.384667 9.1583333 0.386667 9.1611111 0.386667 9.1638889 0.384667 9.1666667 0.381333 9.1694444 0.377333 9.1722222 0.372000 9.1750000 0.365333 9.1777778 0.356667 9.1805556 0.347333 9.1833333 0.338000 9.1861111 0.328000 9.1888889 0.323333 9.1916667 0.316667 9.1944444 0.312000 9.1972222 0.308667 9.2000000 0.307333 9.2027778 0.307333 9.2055556 0.308667 9.2083333 0.308667 9.2111111 0.310000 9.2138889 0.310000 9.2166667 0.308000 9.2194444 0.307333 9.2222222 0.304667 9.2250000 0.304667 9.2277778 0.303333 9.2305556 0.304667 9.2333333 0.303333 9.2361111 0.306667 9.2388889 0.307333 9.2416667 0.308000 9.2444444 0.307333 9.2472222 0.307333 9.2500000 0.304667 9.2527778 0.303333 9.2555556 0.303333 9.2583333 0.304667 9.2611111 0.301333 9.2638889 0.302667 9.2666667 0.301333 9.2694444 0.302667 9.2722222 0.304000 9.2750000 0.304000 9.2777778 0.304667 9.2805556 0.302667 9.2833333 0.303333 9.2861111 0.300667 9.2888889 0.300667 9.2916667 0.300667 9.2944444 0.299333 9.2972222 0.298000 9.3000000 0.298000 9.3027778 0.298667 9.3055556 0.298000 9.3083333 0.299333 9.3111111 0.298667 9.3138889 0.297333 9.3166667 0.296000 9.3194444 0.296000 9.3222222 0.293333 9.3250000 0.290667 9.3277778 0.291333 9.3305556 0.289333 9.3333333 0.289333 9.3361111 0.290000 9.3388889 0.288667 9.3416667 0.289333 9.3444444 0.288667 9.3472222 0.286667 9.3500000 0.286000 9.3527778 0.283333 9.3555556 0.280000 9.3583333 0.280000 9.3611111 0.278667 9.3638889 0.278000 9.3666667 0.278000 9.3694444 0.278667 9.3722222 0.278667 9.3750000 0.278667 9.3777778 0.276667 9.3805556 0.277333 9.3833333 0.278667 9.3861111 0.276667 9.3888889 0.276000 9.3946667 0.300000 9.9497778 0.300000 9.9527778 0.305333 9.9555556 0.307333 9.9583333 0.307333 9.9611111 0.307333 9.9638889 0.307333 9.9666667 0.307333 9.9694444 0.310000 9.9722222 0.311333 9.9750000 0.312000 9.9777778 0.314000 9.9805556 0.314667 9.9833333 0.314000 9.9861111 0.310667 9.9888889 0.310000 9.9916667 0.308000 9.9944444 0.307333 9.9972222 0.306667 10.0000000 0.304667 10.0027778 0.304000 10.0055556 0.306000 10.0083333 0.306000 10.0111111 0.306000 10.0138889 0.306000 10.0166667 0.306667 10.0194444 0.306000 10.0222222 0.302667 10.0250000 0.301333 10.0277778 0.301333 10.0305556 0.300000 10.0333333 0.301333 10.0361111 0.303333 10.0388889 0.304667 10.0416667 0.305333 10.0444444 0.305333 10.0472222 0.306000 10.0500000 0.307333 10.0527778 0.308667 10.0555556 0.307333 10.0583333 0.308667 10.0611111 0.306000 10.0638889 0.304667 10.0666667 0.305333 10.0694444 0.307333 10.0722222 0.307333 10.0750000 0.308667 10.0777778 0.308000 10.0805556 0.309333 10.0833333 0.308000 10.0861111 0.307333 10.0888889 0.308000 10.0916667 0.307333 10.0944444 0.306667 10.0972222 0.308667 10.1000000 0.306667 10.1027778 0.308000 10.1055556 0.308667 10.1083333 0.308667 10.1111111 0.310000 10.1138889 0.312000 10.1166667 0.312000 10.1194444 0.310000 10.1222222 0.308667 10.1250000 0.310000 10.1277778 0.310000 10.1305556 0.310000 10.1333333 0.310000 10.1361111 0.312000 10.1388889 0.312000 10.1416667 0.313333 10.1444444 0.312000 10.1472222 0.314000 10.1500000 0.311333 10.1527778 0.310667 10.1555556 0.310000 10.1583333 0.309333 10.1611111 0.310667 10.1638889 0.309333 10.1666667 0.310667 10.1694444 0.312000 10.1722222 0.314000 10.1750000 0.316667 10.1777778 0.318000 10.1805556 0.318667 10.1833333 0.318000 10.1861111 0.313333 10.1888889 0.308667 10.1916667 0.298667 10.1944444 0.288000 10.1972222 0.276000 10.2000000 0.266667 10.2027778 0.260000 10.2055556 0.253333 10.2083333 0.252000 10.2111111 0.254000 10.2138889 0.259333 10.2166667 0.272000 10.2194444 0.287333 10.2222222 0.306000 10.2250000 0.322667 10.2277778 0.335333 10.2305556 0.341333 10.2333333 0.344667 10.2361111 0.345333 10.2388889 0.347333 10.2416667 0.349333 10.2444444 0.351333 10.2472222 0.352667 10.2500000 0.354000 10.2527778 0.356667 10.2555556 0.358000 10.2583333 0.360667 10.2611111 0.362000 10.2638889 0.364667 10.2666667 0.366667 10.2694444 0.372000 10.2722222 0.375333 10.2750000 0.377333 10.2777778 0.378667 10.2805556 0.378000 10.2833333 0.376000 10.2861111 0.370667 10.2888889 0.362667 10.2916667 0.355333 10.2944444 0.347333 10.2972222 0.339333 10.3000000 0.331333 10.3027778 0.324000 10.3055556 0.318000 10.3083333 0.314000 10.3111111 0.308667 10.3138889 0.307333 10.3166667 0.305333 10.3194444 0.303333 10.3222222 0.304000 10.3250000 0.304000 10.3277778 0.303333 10.3305556 0.302667 10.3333333 0.302667 10.3361111 0.304000 10.3388889 0.306000 10.3416667 0.306000 10.3444444 0.304667 10.3472222 0.304667 10.3500000 0.305333 10.3527778 0.304000 10.3555556 0.305333 10.3583333 0.303333 10.3611111 0.302667 10.3638889 0.302667 10.3666667 0.303333 10.3694444 0.304000 10.3722222 0.304667 10.3750000 0.306000 10.3777778 0.307333 10.3805556 0.306000 10.3833333 0.304667 10.3861111 0.302000 10.3888889 0.300667 10.3916667 0.301333 10.3944444 0.301333 10.3972222 0.300667 10.4000000 0.299333 10.4027778 0.300000 10.4055556 0.302000 10.4083333 0.301333 10.4111111 0.302000 10.4138889 0.301333 10.4166667 0.300000 10.4194444 0.299333 10.4222222 0.298000 10.4250000 0.298000 10.4277778 0.296667 10.4305556 0.295333 10.4333333 0.296667 10.4361111 0.296000 10.4388889 0.296000 10.4416667 0.295333 10.4444444 0.295333 10.4472222 0.294667 10.4500000 0.293333 10.4527778 0.292667 10.4555556 0.290667 10.4583333 0.288000 10.4611111 0.288667 10.4638889 0.286000 10.4666667 0.284667 10.4694444 0.285333 10.4722222 0.284667 10.4750000 0.284667 10.4777778 0.284667 10.4805556 0.283333 10.4833333 0.282000 10.4861111 0.280000 10.4888889 0.278000 10.4916667 0.276667 10.4944444 0.277333 10.4972222 0.276667 10.5000000 0.277333 10.5057778 0.300000 10.6664444 0.300000 10.6694444 0.310000 10.6722222 0.312000 10.6750000 0.313333 10.6777778 0.312000 10.6805556 0.312000 10.6833333 0.310667 10.6861111 0.310000 10.6888889 0.311333 10.6916667 0.310667 10.6944444 0.312667 10.6972222 0.313333 10.7000000 0.316000 10.7027778 0.316000 10.7055556 0.317333 10.7083333 0.317333 10.7111111 0.317333 10.7138889 0.317333 10.7166667 0.316000 10.7194444 0.316667 10.7222222 0.313333 10.7250000 0.311333 10.7277778 0.310667 10.7305556 0.311333 10.7333333 0.312667 10.7361111 0.314667 10.7388889 0.317333 10.7416667 0.316000 10.7444444 0.317333 10.7472222 0.318000 10.7500000 0.318000 10.7527778 0.318667 10.7555556 0.318000 10.7583333 0.318000 10.7611111 0.318000 10.7638889 0.317333 10.7666667 0.318667 10.7694444 0.318667 10.7722222 0.320667 10.7750000 0.323333 10.7777778 0.321333 10.7805556 0.322000 10.7833333 0.321333 10.7861111 0.321333 10.7888889 0.320000 10.7916667 0.316667 10.7944444 0.316000 10.7972222 0.316667 10.8000000 0.314667 10.8027778 0.315333 10.8055556 0.314000 10.8083333 0.316000 10.8111111 0.318667 10.8138889 0.318000 10.8166667 0.322000 10.8194444 0.321333 10.8222222 0.318667 10.8250000 0.316667 10.8277778 0.317333 10.8305556 0.318000 10.8333333 0.320667 10.8361111 0.323333 10.8388889 0.326667 10.8416667 0.327333 10.8444444 0.328000 10.8472222 0.328000 10.8500000 0.326000 10.8527778 0.323333 10.8555556 0.323333 10.8583333 0.323333 10.8611111 0.323333 10.8638889 0.328000 10.8666667 0.330667 10.8694444 0.332667 10.8722222 0.333333 10.8750000 0.334000 10.8777778 0.336667 10.8805556 0.334667 10.8833333 0.334667 10.8861111 0.333333 10.8888889 0.335333 10.8916667 0.332667 10.8944444 0.336000 10.8972222 0.339333 10.9000000 0.340000 10.9027778 0.339333 10.9055556 0.338000 10.9083333 0.330000 10.9111111 0.323333 10.9138889 0.312667 10.9166667 0.304000 10.9194444 0.293333 10.9222222 0.282000 10.9250000 0.275333 10.9277778 0.274667 10.9305556 0.278667 10.9333333 0.288667 10.9361111 0.306667 10.9388889 0.326000 10.9416667 0.344667 10.9444444 0.356667 10.9472222 0.362667 10.9500000 0.366667 10.9527778 0.366667 10.9555556 0.370000 10.9583333 0.371333 10.9611111 0.373333 10.9638889 0.377333 10.9666667 0.380000 10.9694444 0.383333 10.9722222 0.386667 10.9750000 0.390000 10.9777778 0.394000 10.9805556 0.397333 10.9833333 0.399333 10.9861111 0.402667 10.9888889 0.403333 10.9916667 0.403333 10.9944444 0.404000 10.9972222 0.398000 11.0000000 0.393333 11.0027778 0.387333 11.0055556 0.379333 11.0083333 0.368667 11.0111111 0.358000 11.0138889 0.345333 11.0166667 0.336000 11.0194444 0.325333 11.0222222 0.320667 11.0250000 0.318000 11.0277778 0.320000 11.0305556 0.322000 11.0333333 0.326000 11.0361111 0.326667 11.0388889 0.324000 11.0416667 0.321333 11.0444444 0.318667 11.0472222 0.317333 11.0500000 0.321333 11.0527778 0.324667 11.0555556 0.328000 11.0583333 0.332000 11.0611111 0.332000 11.0638889 0.334000 11.0666667 0.335333 11.0694444 0.331333 11.0722222 0.327333 11.0750000 0.323333 11.0777778 0.322667 11.0805556 0.324000 11.0833333 0.329333 11.0861111 0.330000 11.0888889 0.330000 11.0916667 0.328000 11.0944444 0.325333 11.0972222 0.322667 11.1000000 0.322667 11.1027778 0.330000 11.1055556 0.338000 11.1083333 0.342667 11.1111111 0.339333 11.1138889 0.324000 11.1166667 0.301333 11.1194444 0.282000 11.1222222 0.272667 11.1250000 0.274667 11.1277778 0.285333 11.1305556 0.294000 11.1333333 0.304000 11.1361111 0.308000 11.1388889 0.309333 11.1416667 0.307333 11.1444444 0.305333 11.1472222 0.300000 11.1500000 0.297333 11.1527778 0.298667 11.1555556 0.300000 11.1583333 0.306667 11.1611111 0.312667 11.1638889 0.321333 11.1666667 0.329333 11.1694444 0.339333 11.1722222 0.348000 11.1750000 0.354667 11.1777778 0.348667 11.1805556 0.334000 11.1833333 0.317333 11.1861111 0.306000 11.1888889 0.303333 11.1916667 0.308667 11.1944444 0.314000 11.1972222 0.306000 11.2000000 0.284667 11.2027778 0.262000 11.2055556 0.245333 11.2083333 0.240667 11.2111111 0.245333 11.2138889 0.251333 11.2166667 0.253333 11.2224444 0.300000 11.2470000 0.300000 11.2500000 0.263333 11.2527778 0.266000 11.2555556 0.270000 11.2583333 0.271333 11.2611111 0.274667 11.2638889 0.277333 11.2666667 0.280667 11.2694444 0.285333 11.2722222 0.286000 11.2750000 0.287333 11.2777778 0.294000 11.2805556 0.300667 11.2833333 0.308000 11.2861111 0.309333 11.2888889 0.300667 11.2916667 0.279333 11.2944444 0.259333 11.2972222 0.248000 11.3000000 0.251333 11.3027778 0.267333 11.3055556 0.285333 11.3083333 0.298000 11.3111111 0.300000 11.3138889 0.294000 11.3166667 0.283333 11.3194444 0.276000 11.3222222 0.270667 11.3250000 0.270667 11.3277778 0.267333 11.3305556 0.258667 11.3333333 0.254667 11.3361111 0.250000 11.3388889 0.252667 11.3416667 0.259333 11.3444444 0.264667 11.3472222 0.267333 11.3500000 0.260667 11.3527778 0.253333 11.3555556 0.244000 11.3583333 0.238000 11.3611111 0.238667 11.3638889 0.243333 11.3666667 0.249333 11.3694444 0.256000 11.3722222 0.260667 11.3750000 0.264000 11.3777778 0.268667 11.3805556 0.272000 11.3833333 0.274667 11.3861111 0.278667 11.3888889 0.279333 11.3916667 0.278000 11.3944444 0.280000 11.3972222 0.290667 11.4000000 0.304000 11.4027778 0.310000 11.4055556 0.300000 11.4083333 0.279333 11.4111111 0.256000 11.4138889 0.244000 11.4166667 0.249333 11.4194444 0.262000 11.4222222 0.275333 11.4250000 0.277333 11.4277778 0.274667 11.4305556 0.262000 11.4333333 0.249333 11.4361111 0.238000 11.4388889 0.226000 11.4416667 0.219333 11.4444444 0.220667 11.4472222 0.229333 11.4500000 0.237333 11.4527778 0.242000 11.4555556 0.245333 11.4583333 0.245333 11.4611111 0.246667 11.4638889 0.250000 11.4666667 0.253333 11.4694444 0.258000 11.4722222 0.262667 11.4750000 0.266000 11.4777778 0.267333 11.4805556 0.266667 11.4833333 0.261333 11.4861111 0.255333 11.4888889 0.249333 11.4916667 0.243333 11.4944444 0.236000 11.4972222 0.230000 11.5000000 0.223333 11.5027778 0.216000 11.5055556 0.208667 11.5083333 0.206000 11.5111111 0.211333 11.5138889 0.224667 11.5166667 0.242667 11.5194444 0.255333 11.5222222 0.262667 11.5250000 0.262667 11.5277778 0.261333 11.5305556 0.265333 11.5333333 0.276000 11.5361111 0.288000 11.5388889 0.294000 11.5416667 0.294000 11.5444444 0.286667 11.5472222 0.280667 11.5500000 0.282000 11.5527778 0.288000 11.5555556 0.297333 11.5583333 0.306667 11.5611111 0.314000 11.5638889 0.318667 11.5666667 0.318667 11.5694444 0.317333 11.5722222 0.316667 11.5750000 0.314667 11.5777778 0.312000 11.5805556 0.308000 11.5833333 0.304000 11.5861111 0.300000 11.5888889 0.296000 11.5916667 0.290000 11.5944444 0.280667 11.5972222 0.267333 11.6000000 0.250667 11.6027778 0.236000 11.6055556 0.226000 11.6083333 0.223333 11.6111111 0.228667 11.6138889 0.239333 11.6166667 0.249333 11.6194444 0.254667 11.6222222 0.254000 11.6250000 0.248667 11.6277778 0.240000 11.6305556 0.235333 11.6333333 0.232667 11.6361111 0.234000 11.6388889 0.237333 11.6416667 0.240667 11.6444444 0.243333 11.6472222 0.243333 11.6500000 0.242000 11.6527778 0.239333 11.6555556 0.239333 11.6583333 0.238000 11.6611111 0.238667 11.6638889 0.239333 11.6666667 0.242000 11.6694444 0.243333 11.6722222 0.244667 11.6750000 0.243333 11.6777778 0.243333 11.6805556 0.241333 11.6833333 0.239333 11.6861111 0.236667 11.6888889 0.236000 11.6916667 0.233333 11.6944444 0.234000 11.6972222 0.235333 11.7000000 0.236667 11.7027778 0.238667 11.7055556 0.240000 11.7083333 0.243333 11.7111111 0.243333 11.7138889 0.242000 11.7166667 0.239333 11.7194444 0.234000 11.7222222 0.231333 11.7250000 0.234667 11.7277778 0.239333 11.7305556 0.246667 11.7333333 0.252000 11.7361111 0.250667 11.7388889 0.242667 11.7416667 0.228000 11.7444444 0.213333 11.7472222 0.206000 11.7500000 0.207333 11.7527778 0.214667 11.7555556 0.224000 11.7583333 0.228000 11.7611111 0.228667 11.7638889 0.227333 11.7666667 0.225333 11.7694444 0.220667 11.7722222 0.220667 11.7750000 0.220000 11.7777778 0.220000 11.7805556 0.222000 11.7833333 0.224667 11.7861111 0.227333 11.7888889 0.227333 11.7916667 0.226000 11.7944444 0.224667 11.7972222 0.225333 11.8030000 0.300000 12.0831111 0.300000 12.0861111 0.281333 12.0888889 0.280000 12.0916667 0.280667 12.0944444 0.284000 12.0972222 0.284000 12.1000000 0.287333 12.1027778 0.288000 12.1055556 0.291333 12.1083333 0.289333 12.1111111 0.290667 12.1138889 0.290667 12.1166667 0.291333 12.1194444 0.290000 12.1222222 0.290000 12.1250000 0.290000 12.1277778 0.291333 12.1305556 0.290000 12.1333333 0.293333 12.1361111 0.296667 12.1388889 0.303333 12.1416667 0.303333 12.1444444 0.304667 12.1472222 0.300667 12.1500000 0.296000 12.1527778 0.292667 12.1555556 0.290000 12.1583333 0.289333 12.1611111 0.288000 12.1638889 0.286667 12.1666667 0.289333 12.1694444 0.290667 12.1722222 0.294667 12.1750000 0.296000 12.1777778 0.296000 12.1805556 0.294667 12.1833333 0.294000 12.1861111 0.294667 12.1888889 0.295333 12.1916667 0.294667 12.1944444 0.296000 12.1972222 0.294667 12.2000000 0.294667 12.2027778 0.297333 12.2055556 0.298000 12.2083333 0.300000 12.2111111 0.300000 12.2138889 0.302000 12.2166667 0.301333 12.2194444 0.300667 12.2222222 0.300000 12.2250000 0.297333 12.2277778 0.296667 12.2305556 0.297333 12.2333333 0.300000 12.2361111 0.302667 12.2388889 0.306667 12.2416667 0.310000 12.2444444 0.311333 12.2472222 0.307333 12.2500000 0.304667 12.2527778 0.304000 12.2555556 0.303333 12.2583333 0.302000 12.2611111 0.300667 12.2638889 0.300667 12.2666667 0.302000 12.2694444 0.302000 12.2722222 0.305333 12.2750000 0.306000 12.2777778 0.308000 12.2805556 0.308667 12.2833333 0.308000 12.2861111 0.307333 12.2888889 0.308000 12.2916667 0.306000 12.2944444 0.306000 12.2972222 0.307333 12.3000000 0.309333 12.3027778 0.310667 12.3055556 0.312667 12.3083333 0.316667 12.3111111 0.317333 12.3138889 0.318000 12.3166667 0.317333 12.3194444 0.314000 12.3222222 0.308000 12.3250000 0.300667 12.3277778 0.292667 12.3305556 0.282667 12.3333333 0.271333 12.3361111 0.262000 12.3388889 0.254000 12.3416667 0.250667 12.3444444 0.253333 12.3472222 0.259333 12.3500000 0.270667 12.3527778 0.287333 12.3555556 0.307333 12.3583333 0.324000 12.3611111 0.333333 12.3638889 0.341333 12.3666667 0.345333 12.3694444 0.347333 12.3722222 0.348000 12.3750000 0.350667 12.3777778 0.352000 12.3805556 0.352000 12.3833333 0.355333 12.3861111 0.357333 12.3888889 0.361333 12.3916667 0.364667 12.3944444 0.368000 12.3972222 0.370667 12.4000000 0.374000 12.4027778 0.376000 12.4055556 0.376667 12.4083333 0.375333 12.4111111 0.370667 12.4138889 0.366000 12.4166667 0.356667 12.4194444 0.346667 12.4222222 0.337333 12.4250000 0.328667 12.4277778 0.320000 12.4305556 0.316000 12.4333333 0.314667 12.4361111 0.312667 12.4388889 0.309333 12.4416667 0.310000 12.4444444 0.310000 12.4472222 0.308000 12.4500000 0.308667 12.4527778 0.307333 12.4555556 0.306000 12.4583333 0.305333 12.4611111 0.306000 12.4638889 0.307333 12.4666667 0.306667 12.4694444 0.307333 12.4722222 0.308000 12.4750000 0.309333 12.4777778 0.310000 12.4805556 0.310667 12.4833333 0.310667 12.4861111 0.310000 12.4888889 0.308667 12.4916667 0.307333 12.4944444 0.306667 12.4972222 0.304667 12.5000000 0.306000 12.5027778 0.306000 12.5055556 0.306667 12.5083333 0.308000 12.5111111 0.310000 12.5138889 0.308667 12.5166667 0.308000 12.5194444 0.307333 12.5222222 0.306000 12.5250000 0.302667 12.5277778 0.300000 12.5305556 0.297333 12.5333333 0.295333 12.5361111 0.296000 12.5388889 0.297333 12.5416667 0.302000 12.5444444 0.304000 12.5472222 0.304000 12.5500000 0.301333 12.5527778 0.300667 12.5555556 0.294667 12.5583333 0.292000 12.5611111 0.290000 12.5638889 0.291333 12.5666667 0.293333 12.5694444 0.293333 12.5722222 0.292667 12.5750000 0.294000 12.5777778 0.292667 12.5805556 0.291333 12.5833333 0.289333 12.5861111 0.286000 12.5888889 0.284667 12.5916667 0.284667 12.5944444 0.284000 12.5972222 0.284000 12.6000000 0.282667 12.6027778 0.284000 12.6055556 0.284000 12.6083333 0.284667 12.6111111 0.285333 12.6138889 0.286000 12.6166667 0.284667 12.6194444 0.283333 12.6222222 0.282000 12.6250000 0.280000 12.6277778 0.282000 12.6305556 0.284000 12.6333333 0.285333 12.6391111 0.300000 12.7858889 0.300000 12.7888889 0.322000 12.7916667 0.320667 12.7944444 0.320000 12.7972222 0.318667 12.8000000 0.317333 12.8027778 0.318667 12.8055556 0.319333 12.8083333 0.319333 12.8111111 0.322000 12.8138889 0.322000 12.8166667 0.323333 12.8194444 0.322667 12.8222222 0.321333 12.8250000 0.319333 12.8277778 0.320000 12.8305556 0.319333 12.8333333 0.322667 12.8361111 0.325333 12.8388889 0.328000 12.8416667 0.329333 12.8444444 0.332667 12.8472222 0.330667 12.8500000 0.330000 12.8527778 0.328000 12.8555556 0.326667 12.8583333 0.326667 12.8611111 0.327333 12.8638889 0.328000 12.8666667 0.326000 12.8694444 0.328000 12.8722222 0.327333 12.8750000 0.328667 12.8777778 0.329333 12.8805556 0.330667 12.8833333 0.330667 12.8861111 0.330000 12.8888889 0.328667 12.8916667 0.327333 12.8944444 0.326667 12.8972222 0.328667 12.9000000 0.330667 12.9027778 0.332667 12.9055556 0.334667 12.9083333 0.336000 12.9111111 0.334667 12.9138889 0.332667 12.9166667 0.332667 12.9194444 0.330667 12.9222222 0.330000 12.9250000 0.328667 12.9277778 0.326667 12.9305556 0.328000 12.9333333 0.328667 12.9361111 0.328667 12.9388889 0.330000 12.9416667 0.331333 12.9444444 0.332667 12.9472222 0.331333 12.9500000 0.331333 12.9527778 0.331333 12.9555556 0.333333 12.9583333 0.334667 12.9611111 0.332667 12.9638889 0.334667 12.9666667 0.334667 12.9694444 0.336000 12.9722222 0.336000 12.9750000 0.338000 12.9777778 0.337333 12.9805556 0.338000 12.9833333 0.336000 12.9861111 0.335333 12.9888889 0.336000 12.9916667 0.334667 12.9944444 0.334000 12.9972222 0.332667 13.0000000 0.332667 13.0027778 0.333333 13.0055556 0.333333 13.0083333 0.335333 13.0111111 0.338667 13.0138889 0.339333 13.0166667 0.340667 13.0194444 0.340667 13.0222222 0.335333 13.0250000 0.331333 13.0277778 0.322000 13.0305556 0.310667 13.0333333 0.302000 13.0361111 0.293333 13.0388889 0.285333 13.0416667 0.280667 13.0444444 0.278000 13.0472222 0.277333 13.0500000 0.280667 13.0527778 0.290000 13.0555556 0.304000 13.0583333 0.322000 13.0611111 0.338667 13.0638889 0.352667 13.0666667 0.364000 13.0694444 0.371333 13.0722222 0.376000 13.0750000 0.376000 13.0777778 0.378000 13.0805556 0.377333 13.0833333 0.380000 13.0861111 0.379333 13.0888889 0.380667 13.0916667 0.381333 13.0944444 0.384000 13.0972222 0.386667 13.1000000 0.389333 13.1027778 0.392000 13.1055556 0.396000 13.1083333 0.398000 13.1111111 0.399333 13.1138889 0.398000 13.1166667 0.394667 13.1194444 0.390000 13.1222222 0.382000 13.1250000 0.374667 13.1277778 0.366667 13.1305556 0.358000 13.1333333 0.349333 13.1361111 0.342667 13.1388889 0.335333 13.1416667 0.334000 13.1444444 0.330000 13.1472222 0.326667 13.1500000 0.324667 13.1527778 0.327333 13.1555556 0.327333 13.1583333 0.326000 13.1611111 0.326000 13.1638889 0.326667 13.1666667 0.325333 13.1694444 0.324000 13.1722222 0.323333 13.1750000 0.324667 13.1777778 0.325333 13.1805556 0.326000 13.1833333 0.324667 13.1861111 0.321333 13.1888889 0.319333 13.1916667 0.319333 13.1944444 0.318000 13.1972222 0.318667 13.2000000 0.321333 13.2027778 0.321333 13.2055556 0.324000 13.2083333 0.324667 13.2111111 0.325333 13.2138889 0.325333 13.2166667 0.321333 13.2194444 0.320667 13.2222222 0.320000 13.2250000 0.316000 13.2277778 0.313333 13.2305556 0.313333 13.2333333 0.312667 13.2361111 0.314667 13.2388889 0.315333 13.2416667 0.316000 13.2444444 0.316000 13.2472222 0.314000 13.2500000 0.313333 13.2527778 0.310667 13.2555556 0.310000 13.2583333 0.309333 13.2611111 0.309333 13.2638889 0.309333 13.2666667 0.306000 13.2694444 0.307333 13.2722222 0.306000 13.2750000 0.305333 13.2777778 0.305333 13.2805556 0.303333 13.2833333 0.301333 13.2861111 0.300667 13.2888889 0.298667 13.2916667 0.298000 13.2944444 0.298667 13.2972222 0.298667 13.3000000 0.297333 13.3027778 0.300667 13.3055556 0.300667 13.3083333 0.298000 13.3111111 0.296667 13.3138889 0.294000 13.3166667 0.294667 13.3194444 0.292667 13.3222222 0.288667 13.3250000 0.287333 13.3277778 0.282667 13.3305556 0.280000 13.3333333 0.276000 13.3361111 0.277333 13.3418889 0.300000 13.5053333 0.300000 13.5083333 0.323333 13.5111111 0.321333 13.5138889 0.318000 13.5166667 0.314000 13.5194444 0.310000 13.5222222 0.310000 13.5250000 0.308000 13.5277778 0.310667 13.5305556 0.313333 13.5333333 0.316000 13.5361111 0.318000 13.5388889 0.317333 13.5416667 0.316000 13.5444444 0.315333 13.5472222 0.313333 13.5500000 0.312000 13.5527778 0.309333 13.5555556 0.310667 13.5583333 0.310000 13.5611111 0.313333 13.5638889 0.312667 13.5666667 0.314000 13.5694444 0.315333 13.5722222 0.314667 13.5750000 0.314000 13.5777778 0.314000 13.5805556 0.313333 13.5833333 0.313333 13.5861111 0.314667 13.5888889 0.314667 13.5916667 0.314667 13.5944444 0.315333 13.5972222 0.316000 13.6000000 0.318667 13.6027778 0.320667 13.6055556 0.323333 13.6083333 0.327333 13.6111111 0.328667 13.6138889 0.329333 13.6166667 0.325333 13.6194444 0.320667 13.6222222 0.313333 13.6250000 0.308000 13.6277778 0.306667 13.6305556 0.307333 13.6333333 0.311333 13.6361111 0.316000 13.6388889 0.318000 13.6416667 0.321333 13.6444444 0.321333 13.6472222 0.320667 13.6500000 0.320667 13.6527778 0.320000 13.6555556 0.317333 13.6583333 0.317333 13.6611111 0.316667 13.6638889 0.318000 13.6666667 0.319333 13.6694444 0.320667 13.6722222 0.322000 13.6750000 0.322000 13.6777778 0.324000 13.6805556 0.324000 13.6833333 0.324000 13.6861111 0.324000 13.6888889 0.321333 13.6916667 0.322000 13.6944444 0.322667 13.6972222 0.322000 13.7000000 0.321333 13.7027778 0.321333 13.7055556 0.323333 13.7083333 0.324000 13.7111111 0.324000 13.7138889 0.324667 13.7166667 0.326000 13.7194444 0.324000 13.7222222 0.323333 13.7250000 0.323333 13.7277778 0.325333 13.7305556 0.326000 13.7333333 0.328000 13.7361111 0.330000 13.7388889 0.330667 13.7416667 0.332000 13.7444444 0.332667 13.7472222 0.329333 13.7500000 0.320000 13.7527778 0.310000 13.7555556 0.294000 13.7583333 0.279333 13.7611111 0.266000 13.7638889 0.256000 13.7666667 0.254000 13.7694444 0.260667 13.7722222 0.275333 13.7750000 0.297333 13.7777778 0.322000 13.7805556 0.344000 13.7833333 0.355333 13.7861111 0.359333 13.7888889 0.358667 13.7916667 0.355333 13.7944444 0.353333 13.7972222 0.352667 13.8000000 0.358000 13.8027778 0.361333 13.8055556 0.367333 13.8083333 0.371333 13.8111111 0.374000 13.8138889 0.378000 13.8166667 0.380000 13.8194444 0.381333 13.8222222 0.382667 13.8250000 0.385333 13.8277778 0.386000 13.8305556 0.384000 13.8333333 0.382000 13.8361111 0.375333 13.8388889 0.366667 13.8416667 0.359333 13.8444444 0.349333 13.8472222 0.340000 13.8500000 0.330667 13.8527778 0.324000 13.8555556 0.316667 13.8583333 0.309333 13.8611111 0.306000 13.8638889 0.304667 13.8666667 0.306000 13.8694444 0.308000 13.8722222 0.308667 13.8750000 0.310667 13.8777778 0.311333 13.8805556 0.310667 13.8833333 0.308667 13.8861111 0.308667 13.8888889 0.306000 13.8916667 0.306667 13.8944444 0.305333 13.8972222 0.305333 13.9000000 0.306000 13.9027778 0.307333 13.9055556 0.309333 13.9083333 0.308667 13.9111111 0.308667 13.9138889 0.308667 13.9166667 0.309333 13.9194444 0.308667 13.9222222 0.306667 13.9250000 0.306000 13.9277778 0.304667 13.9305556 0.306667 13.9333333 0.306667 13.9361111 0.307333 13.9388889 0.308000 13.9416667 0.310000 13.9444444 0.309333 13.9472222 0.310000 13.9500000 0.308667 13.9527778 0.306667 13.9555556 0.306000 13.9583333 0.305333 13.9611111 0.305333 13.9638889 0.304000 13.9666667 0.303333 13.9694444 0.305333 13.9722222 0.307333 13.9750000 0.306000 13.9777778 0.306000 13.9805556 0.304000 13.9833333 0.305333 13.9861111 0.303333 13.9888889 0.302000 13.9916667 0.300667 13.9944444 0.300000 13.9972222 0.299333 14.0000000 0.299333 14.0027778 0.299333 14.0055556 0.297333 14.0083333 0.297333 14.0111111 0.296000 14.0138889 0.294000 14.0166667 0.296000 14.0194444 0.295333 14.0222222 0.292000 14.0250000 0.291333 14.0277778 0.290667 14.0305556 0.288000 14.0333333 0.288000 14.0361111 0.290000 14.0388889 0.290667 14.0416667 0.292667 14.0444444 0.296000 14.0472222 0.297333 14.0500000 0.297333 14.0527778 0.298000 14.0555556 0.298667 14.0613333 0.300000 15.4386667 0.300000 15.4416667 0.319333 15.4444444 0.322667 15.4472222 0.324000 15.4500000 0.323333 15.4527778 0.325333 15.4555556 0.325333 15.4583333 0.324000 15.4611111 0.321333 15.4638889 0.318667 15.4666667 0.319333 15.4694444 0.318000 15.4722222 0.318000 15.4750000 0.318000 15.4777778 0.320667 15.4805556 0.322000 15.4833333 0.324000 15.4861111 0.322667 15.4888889 0.321333 15.4916667 0.320000 15.4944444 0.316000 15.4972222 0.315333 15.5000000 0.315333 15.5027778 0.315333 15.5055556 0.315333 15.5083333 0.314000 15.5111111 0.315333 15.5138889 0.315333 15.5166667 0.314000 15.5194444 0.313333 15.5222222 0.313333 15.5250000 0.312000 15.5277778 0.312667 15.5305556 0.311333 15.5333333 0.312000 15.5361111 0.312667 15.5388889 0.312667 15.5416667 0.313333 15.5444444 0.316000 15.5472222 0.316000 15.5500000 0.316667 15.5527778 0.318667 15.5555556 0.318000 15.5583333 0.316000 15.5611111 0.314667 15.5638889 0.314000 15.5666667 0.312667 15.5694444 0.314667 15.5722222 0.316667 15.5750000 0.319333 15.5777778 0.318000 15.5805556 0.317333 15.5833333 0.316000 15.5861111 0.315333 15.5888889 0.317333 15.5916667 0.318000 15.5944444 0.316667 15.5972222 0.316667 15.6000000 0.315333 15.6027778 0.314000 15.6055556 0.315333 15.6083333 0.316000 15.6111111 0.316000 15.6138889 0.316667 15.6166667 0.316667 15.6194444 0.316000 15.6222222 0.315333 15.6250000 0.313333 15.6277778 0.311333 15.6305556 0.311333 15.6333333 0.312000 15.6361111 0.311333 15.6388889 0.314667 15.6416667 0.316667 15.6444444 0.316667 15.6472222 0.315333 15.6500000 0.314667 15.6527778 0.312667 15.6555556 0.312000 15.6583333 0.311333 15.6611111 0.312667 15.6638889 0.315333 15.6666667 0.316667 15.6694444 0.318667 15.6722222 0.320000 15.6750000 0.318000 15.6777778 0.314000 15.6805556 0.304000 15.6833333 0.294000 15.6861111 0.280000 15.6888889 0.266667 15.6916667 0.256000 15.6944444 0.245333 15.6972222 0.240000 15.7000000 0.240667 15.7027778 0.246000 15.7055556 0.260000 15.7083333 0.278000 15.7111111 0.300000 15.7138889 0.317333 15.7166667 0.336000 15.7194444 0.346667 15.7222222 0.353333 15.7250000 0.356000 15.7277778 0.355333 15.7305556 0.356667 15.7333333 0.355333 15.7361111 0.360000 15.7388889 0.364667 15.7416667 0.372667 15.7444444 0.377333 15.7472222 0.380667 15.7500000 0.382000 15.7527778 0.385333 15.7555556 0.384667 15.7583333 0.384000 15.7611111 0.385333 15.7638889 0.385333 15.7666667 0.383333 15.7694444 0.379333 15.7722222 0.374000 15.7750000 0.368000 15.7777778 0.360667 15.7805556 0.349333 15.7833333 0.341333 15.7861111 0.330667 15.7888889 0.323333 15.7916667 0.318667 15.7944444 0.313333 15.7972222 0.310000 15.8000000 0.309333 15.8027778 0.310667 15.8055556 0.312000 15.8083333 0.312667 15.8111111 0.312667 15.8138889 0.312667 15.8166667 0.311333 15.8194444 0.311333 15.8222222 0.308667 15.8250000 0.309333 15.8277778 0.308667 15.8305556 0.307333 15.8333333 0.308667 15.8361111 0.308667 15.8388889 0.310667 15.8416667 0.310667 15.8444444 0.311333 15.8472222 0.311333 15.8500000 0.311333 15.8527778 0.310667 15.8555556 0.311333 15.8583333 0.309333 15.8611111 0.308667 15.8638889 0.306667 15.8666667 0.306667 15.8694444 0.306000 15.8722222 0.308000 15.8750000 0.310000 15.8777778 0.311333 15.8805556 0.310667 15.8833333 0.309333 15.8861111 0.308667 15.8888889 0.307333 15.8916667 0.305333 15.8944444 0.305333 15.8972222 0.306000 15.9000000 0.306667 15.9027778 0.307333 15.9055556 0.306667 15.9083333 0.308000 15.9111111 0.307333 15.9138889 0.307333 15.9166667 0.305333 15.9194444 0.302000 15.9222222 0.300000 15.9250000 0.297333 15.9277778 0.296000 15.9305556 0.296000 15.9333333 0.298000 15.9361111 0.298667 15.9388889 0.298000 15.9416667 0.298667 15.9444444 0.296667 15.9472222 0.294667 15.9500000 0.294000 15.9527778 0.290667 15.9555556 0.291333 15.9583333 0.290000 15.9611111 0.288667 15.9638889 0.287333 15.9666667 0.286000 15.9694444 0.286667 15.9722222 0.288000 15.9750000 0.287333 15.9777778 0.286000 15.9805556 0.286000 15.9833333 0.286667 15.9861111 0.285333 15.9888889 0.284667 15.9946667 0.300000 16.1247778 0.300000 16.1277778 0.312000 16.1305556 0.313333 16.1333333 0.311333 16.1361111 0.314667 16.1388889 0.316000 16.1416667 0.316000 16.1444444 0.316000 16.1472222 0.315333 16.1500000 0.314667 16.1527778 0.314667 16.1555556 0.314667 16.1583333 0.316000 16.1611111 0.315333 16.1638889 0.315333 16.1666667 0.314667 16.1694444 0.314000 16.1722222 0.315333 16.1750000 0.316667 16.1777778 0.317333 16.1805556 0.316667 16.1833333 0.316000 16.1861111 0.314000 16.1888889 0.314000 16.1916667 0.313333 16.1944444 0.314667 16.1972222 0.313333 16.2000000 0.316000 16.2027778 0.316667 16.2055556 0.318000 16.2083333 0.318000 16.2111111 0.318000 16.2138889 0.318667 16.2166667 0.318667 16.2194444 0.320000 16.2222222 0.320000 16.2250000 0.320667 16.2277778 0.321333 16.2305556 0.319333 16.2333333 0.320667 16.2361111 0.320667 16.2388889 0.320000 16.2416667 0.324000 16.2444444 0.322000 16.2472222 0.323333 16.2500000 0.322000 16.2527778 0.321333 16.2555556 0.319333 16.2583333 0.318667 16.2611111 0.319333 16.2638889 0.318667 16.2666667 0.320667 16.2694444 0.321333 16.2722222 0.322667 16.2750000 0.321333 16.2777778 0.324667 16.2805556 0.324000 16.2833333 0.325333 16.2861111 0.324000 16.2888889 0.322667 16.2916667 0.321333 16.2944444 0.318667 16.2972222 0.319333 16.3000000 0.318667 16.3027778 0.320667 16.3055556 0.321333 16.3083333 0.324000 16.3111111 0.326000 16.3138889 0.325333 16.3166667 0.324667 16.3194444 0.323333 16.3222222 0.320667 16.3250000 0.320000 16.3277778 0.319333 16.3305556 0.320667 16.3333333 0.323333 16.3361111 0.323333 16.3388889 0.324000 16.3416667 0.323333 16.3444444 0.326000 16.3472222 0.325333 16.3500000 0.328000 16.3527778 0.330667 16.3555556 0.332000 16.3583333 0.330000 16.3611111 0.325333 16.3638889 0.316667 16.3666667 0.306000 16.3694444 0.293333 16.3722222 0.280667 16.3750000 0.270000 16.3777778 0.260000 16.3805556 0.251333 16.3833333 0.248667 16.3861111 0.248000 16.3888889 0.253333 16.3916667 0.268667 16.3944444 0.287333 16.3972222 0.310667 16.4000000 0.332000 16.4027778 0.349333 16.4055556 0.360000 16.4083333 0.364667 16.4111111 0.366667 16.4138889 0.366000 16.4166667 0.364000 16.4194444 0.364667 16.4222222 0.367333 16.4250000 0.371333 16.4277778 0.374000 16.4305556 0.381333 16.4333333 0.386000 16.4361111 0.389333 16.4388889 0.392000 16.4416667 0.392667 16.4444444 0.394000 16.4472222 0.392000 16.4500000 0.388000 16.4527778 0.385333 16.4555556 0.378667 16.4583333 0.371333 16.4611111 0.362667 16.4638889 0.352000 16.4666667 0.342667 16.4694444 0.334000 16.4722222 0.328000 16.4750000 0.322000 16.4777778 0.318000 16.4805556 0.314667 16.4833333 0.312000 16.4861111 0.310667 16.4888889 0.309333 16.4916667 0.308667 16.4944444 0.308000 16.4972222 0.309333 16.5000000 0.310000 16.5027778 0.309333 16.5055556 0.310000 16.5083333 0.310000 16.5111111 0.310667 16.5138889 0.310000 16.5166667 0.309333 16.5194444 0.307333 16.5222222 0.306667 16.5250000 0.306667 16.5277778 0.305333 16.5305556 0.306000 16.5333333 0.306000 16.5361111 0.308000 16.5388889 0.308000 16.5416667 0.308000 16.5444444 0.306667 16.5472222 0.306667 16.5500000 0.306000 16.5527778 0.307333 16.5555556 0.306667 16.5583333 0.306000 16.5611111 0.304667 16.5638889 0.304667 16.5666667 0.305333 16.5694444 0.307333 16.5722222 0.308000 16.5750000 0.307333 16.5777778 0.306667 16.5805556 0.304667 16.5833333 0.304667 16.5861111 0.305333 16.5888889 0.304000 16.5916667 0.304667 16.5944444 0.302667 16.5972222 0.302000 16.6000000 0.300000 16.6027778 0.300000 16.6055556 0.300000 16.6083333 0.298667 16.6111111 0.302000 16.6138889 0.302000 16.6166667 0.298667 16.6194444 0.296667 16.6222222 0.294000 16.6250000 0.290667 16.6277778 0.289333 16.6305556 0.288000 16.6333333 0.289333 16.6361111 0.287333 16.6388889 0.289333 16.6416667 0.288667 16.6444444 0.286000 16.6472222 0.284000 16.6500000 0.282667 16.6527778 0.281333 16.6555556 0.281333 16.6583333 0.282000 16.6611111 0.281333 16.6638889 0.280667 16.6666667 0.281333 16.6694444 0.281333 16.6722222 0.280667 16.6750000 0.282667 16.6807778 0.300000 16.8497778 0.300000 16.8527778 0.325333 16.8555556 0.322667 16.8583333 0.319333 16.8611111 0.316000 16.8638889 0.314000 16.8666667 0.316000 16.8694444 0.316667 16.8722222 0.318000 16.8750000 0.320000 16.8777778 0.323333 16.8805556 0.322000 16.8833333 0.322000 16.8861111 0.320667 16.8888889 0.317333 16.8916667 0.316000 16.8944444 0.313333 16.8972222 0.314667 16.9000000 0.314667 16.9027778 0.316000 16.9055556 0.319333 16.9083333 0.320000 16.9111111 0.322667 16.9138889 0.323333 16.9166667 0.323333 16.9194444 0.324000 16.9222222 0.321333 16.9250000 0.320000 16.9277778 0.316667 16.9305556 0.314667 16.9333333 0.314000 16.9361111 0.314000 16.9388889 0.314667 16.9416667 0.316000 16.9444444 0.318000 16.9472222 0.317333 16.9500000 0.314667 16.9527778 0.312667 16.9555556 0.312000 16.9583333 0.310667 16.9611111 0.308667 16.9638889 0.311333 16.9666667 0.312000 16.9694444 0.314000 16.9722222 0.316000 16.9750000 0.318667 16.9777778 0.319333 16.9805556 0.321333 16.9833333 0.320000 16.9861111 0.320000 16.9888889 0.320667 16.9916667 0.318000 16.9944444 0.320000 16.9972222 0.320667 17.0000000 0.318667 17.0027778 0.320667 17.0055556 0.321333 17.0083333 0.320000 17.0111111 0.322667 17.0138889 0.325333 17.0166667 0.326000 17.0194444 0.324667 17.0222222 0.325333 17.0250000 0.325333 17.0277778 0.324000 17.0305556 0.324000 17.0333333 0.324667 17.0361111 0.326667 17.0388889 0.328667 17.0416667 0.330667 17.0444444 0.331333 17.0472222 0.332000 17.0500000 0.331333 17.0527778 0.328000 17.0555556 0.328000 17.0583333 0.326667 17.0611111 0.326667 17.0638889 0.326000 17.0666667 0.327333 17.0694444 0.330000 17.0722222 0.332000 17.0750000 0.334000 17.0777778 0.337333 17.0805556 0.338667 17.0833333 0.338667 17.0861111 0.337333 17.0888889 0.330667 17.0916667 0.322000 17.0944444 0.310000 17.0972222 0.296667 17.1000000 0.282000 17.1027778 0.270000 17.1055556 0.255333 17.1083333 0.248000 17.1111111 0.242000 17.1138889 0.243333 17.1166667 0.248667 17.1194444 0.261333 17.1222222 0.277333 17.1250000 0.298000 17.1277778 0.319333 17.1305556 0.337333 17.1333333 0.349333 17.1361111 0.358000 17.1388889 0.360667 17.1416667 0.360667 17.1444444 0.360000 17.1472222 0.358000 17.1500000 0.356667 17.1527778 0.359333 17.1555556 0.362000 17.1583333 0.366667 17.1611111 0.368667 17.1638889 0.372000 17.1666667 0.376000 17.1694444 0.378667 17.1722222 0.384000 17.1750000 0.386667 17.1777778 0.388667 17.1805556 0.388000 17.1833333 0.384000 17.1861111 0.379333 17.1888889 0.372000 17.1916667 0.364000 17.1944444 0.356667 17.1972222 0.347333 17.2000000 0.339333 17.2027778 0.330000 17.2055556 0.323333 17.2083333 0.318667 17.2111111 0.314667 17.2138889 0.312667 17.2166667 0.310000 17.2194444 0.311333 17.2222222 0.311333 17.2250000 0.310000 17.2277778 0.310000 17.2305556 0.311333 17.2333333 0.313333 17.2361111 0.313333 17.2388889 0.313333 17.2416667 0.313333 17.2444444 0.312667 17.2472222 0.314000 17.2500000 0.313333 17.2527778 0.312667 17.2555556 0.312667 17.2583333 0.312000 17.2611111 0.310000 17.2638889 0.311333 17.2666667 0.310000 17.2694444 0.309333 17.2722222 0.307333 17.2750000 0.308667 17.2777778 0.310000 17.2805556 0.308667 17.2833333 0.308000 17.2861111 0.308000 17.2888889 0.307333 17.2916667 0.304000 17.2944444 0.302000 17.2972222 0.302000 17.3000000 0.300667 17.3027778 0.302000 17.3055556 0.302000 17.3083333 0.301333 17.3111111 0.303333 17.3138889 0.302000 17.3166667 0.302000 17.3194444 0.300667 17.3222222 0.298667 17.3250000 0.297333 17.3277778 0.294667 17.3305556 0.295333 17.3333333 0.296667 17.3361111 0.294667 17.3388889 0.294000 17.3416667 0.295333 17.3444444 0.295333 17.3472222 0.292667 17.3500000 0.292667 17.3527778 0.290000 17.3555556 0.290667 17.3583333 0.288667 17.3611111 0.286667 17.3638889 0.286667 17.3666667 0.286000 17.3694444 0.284667 17.3722222 0.282000 17.3750000 0.281333 17.3777778 0.280667 17.3805556 0.282000 17.3833333 0.281333 17.3861111 0.281333 17.3888889 0.280000 17.3916667 0.278667 17.3944444 0.277333 17.3972222 0.277333 17.4000000 0.278000 17.4057778 0.300000 17.5664444 0.300000 17.5694444 0.311333 17.5722222 0.310000 17.5750000 0.307333 17.5777778 0.306667 17.5805556 0.306667 17.5833333 0.306000 17.5861111 0.307333 17.5888889 0.307333 17.5916667 0.308000 17.5944444 0.306667 17.5972222 0.305333 17.6000000 0.306000 17.6027778 0.306000 17.6055556 0.306000 17.6083333 0.307333 17.6111111 0.309333 17.6138889 0.311333 17.6166667 0.310667 17.6194444 0.310000 17.6222222 0.309333 17.6250000 0.307333 17.6277778 0.308000 17.6305556 0.309333 17.6333333 0.309333 17.6361111 0.308667 17.6388889 0.308000 17.6416667 0.308000 17.6444444 0.309333 17.6472222 0.308667 17.6500000 0.308667 17.6527778 0.308000 17.6555556 0.306000 17.6583333 0.305333 17.6611111 0.304000 17.6638889 0.303333 17.6666667 0.306000 17.6694444 0.306667 17.6722222 0.310000 17.6750000 0.312000 17.6777778 0.312000 17.6805556 0.314667 17.6833333 0.314667 17.6861111 0.314667 17.6888889 0.314667 17.6916667 0.312667 17.6944444 0.312667 17.6972222 0.310667 17.7000000 0.313333 17.7027778 0.314000 17.7055556 0.315333 17.7083333 0.316667 17.7111111 0.316667 17.7138889 0.316667 17.7166667 0.316667 17.7194444 0.316000 17.7222222 0.313333 17.7250000 0.314000 17.7277778 0.312000 17.7305556 0.314667 17.7333333 0.314667 17.7361111 0.316000 17.7388889 0.314667 17.7416667 0.316667 17.7444444 0.317333 17.7472222 0.318000 17.7500000 0.316000 17.7527778 0.315333 17.7555556 0.315333 17.7583333 0.314000 17.7611111 0.313333 17.7638889 0.316000 17.7666667 0.316000 17.7694444 0.316667 17.7722222 0.318000 17.7750000 0.318000 17.7777778 0.317333 17.7805556 0.318667 17.7833333 0.317333 17.7861111 0.317333 17.7888889 0.318000 17.7916667 0.319333 17.7944444 0.321333 17.7972222 0.324667 17.8000000 0.328000 17.8027778 0.330000 17.8055556 0.332000 17.8083333 0.328000 17.8111111 0.320667 17.8138889 0.306000 17.8166667 0.287333 17.8194444 0.271333 17.8222222 0.254667 17.8250000 0.241333 17.8277778 0.232000 17.8305556 0.234000 17.8333333 0.243333 17.8361111 0.260667 17.8388889 0.287333 17.8416667 0.316000 17.8444444 0.341333 17.8472222 0.361333 17.8500000 0.368000 17.8527778 0.370000 17.8555556 0.368667 17.8583333 0.364000 17.8611111 0.364667 17.8638889 0.365333 17.8666667 0.371333 17.8694444 0.375333 17.8722222 0.380000 17.8750000 0.384000 17.8777778 0.387333 17.8805556 0.389333 17.8833333 0.392000 17.8861111 0.393333 17.8888889 0.393333 17.8916667 0.392667 17.8944444 0.390667 17.8972222 0.386667 17.9000000 0.379333 17.9027778 0.370667 17.9055556 0.360667 17.9083333 0.352667 17.9111111 0.342667 17.9138889 0.333333 17.9166667 0.323333 17.9194444 0.318667 17.9222222 0.311333 17.9250000 0.308667 17.9277778 0.307333 17.9305556 0.305333 17.9333333 0.307333 17.9361111 0.307333 17.9388889 0.308667 17.9416667 0.311333 17.9444444 0.308667 17.9472222 0.310000 17.9500000 0.309333 17.9527778 0.306667 17.9555556 0.304667 17.9583333 0.304000 17.9611111 0.301333 17.9638889 0.304667 17.9666667 0.304667 17.9694444 0.306667 17.9722222 0.307333 17.9750000 0.309333 17.9777778 0.310000 17.9805556 0.308667 17.9833333 0.308000 17.9861111 0.306667 17.9888889 0.306000 17.9916667 0.304000 17.9944444 0.304667 17.9972222 0.303333 18.0000000 0.306667 18.0027778 0.306000 18.0055556 0.306667 18.0083333 0.306667 18.0111111 0.306000 18.0138889 0.306667 18.0166667 0.304667 18.0194444 0.302667 18.0222222 0.300667 18.0250000 0.301333 18.0277778 0.302000 18.0305556 0.300667 18.0333333 0.300667 18.0361111 0.300667 18.0388889 0.300000 18.0416667 0.299333 18.0444444 0.299333 18.0472222 0.300000 18.0500000 0.298000 18.0527778 0.297333 18.0555556 0.294000 18.0583333 0.292000 18.0611111 0.290000 18.0638889 0.288000 18.0666667 0.288667 18.0694444 0.288000 18.0722222 0.288667 18.0750000 0.289333 18.0777778 0.289333 18.0805556 0.286667 18.0833333 0.286667 18.0861111 0.286000 18.0888889 0.283333 18.0916667 0.282000 18.0944444 0.280000 18.0972222 0.281333 18.1000000 0.281333 18.1027778 0.280667 18.1055556 0.283333 18.1083333 0.286000 18.1111111 0.288000 18.1138889 0.289333 18.1166667 0.289333 18.1224444 0.300000 20.0553333 0.300000 20.0583333 0.309333 20.0611111 0.310667 20.0638889 0.310667 20.0666667 0.311333 20.0694444 0.310667 20.0722222 0.312000 20.0750000 0.312667 20.0777778 0.312667 20.0805556 0.312000 20.0833333 0.311333 20.0861111 0.312667 20.0888889 0.310667 20.0916667 0.311333 20.0944444 0.312000 20.0972222 0.312667 20.1000000 0.313333 20.1027778 0.312667 20.1055556 0.312000 20.1083333 0.312667 20.1111111 0.313333 20.1138889 0.312000 20.1166667 0.310000 20.1194444 0.308000 20.1222222 0.308000 20.1250000 0.306667 20.1277778 0.306000 20.1305556 0.306667 20.1333333 0.306667 20.1361111 0.305333 20.1388889 0.308000 20.1416667 0.307333 20.1444444 0.309333 20.1472222 0.308667 20.1500000 0.308000 20.1527778 0.307333 20.1555556 0.305333 20.1583333 0.306667 20.1611111 0.306000 20.1638889 0.308000 20.1666667 0.308667 20.1694444 0.310667 20.1722222 0.313333 20.1750000 0.314000 20.1777778 0.314000 20.1805556 0.312667 20.1833333 0.311333 20.1861111 0.312000 20.1888889 0.311333 20.1916667 0.310667 20.1944444 0.308000 20.1972222 0.308000 20.2000000 0.308000 20.2027778 0.310000 20.2055556 0.311333 20.2083333 0.314000 20.2111111 0.314000 20.2138889 0.316000 20.2166667 0.312000 20.2194444 0.311333 20.2222222 0.308667 20.2250000 0.308000 20.2277778 0.306667 20.2305556 0.310000 20.2333333 0.312000 20.2361111 0.315333 20.2388889 0.315333 20.2416667 0.316667 20.2444444 0.317333 20.2472222 0.319333 20.2500000 0.318667 20.2527778 0.317333 20.2555556 0.312667 20.2583333 0.311333 20.2611111 0.308000 20.2638889 0.305333 20.2666667 0.305333 20.2694444 0.304667 20.2722222 0.304000 20.2750000 0.305333 20.2777778 0.307333 20.2805556 0.309333 20.2833333 0.312000 20.2861111 0.312667 20.2888889 0.312000 20.2916667 0.312000 20.2944444 0.306667 20.2972222 0.297333 20.3000000 0.285333 20.3027778 0.272000 20.3055556 0.256667 20.3083333 0.242000 20.3111111 0.234000 20.3138889 0.228000 20.3166667 0.228000 20.3194444 0.232667 20.3222222 0.242667 20.3250000 0.259333 20.3277778 0.278667 20.3305556 0.297333 20.3333333 0.312000 20.3361111 0.320000 20.3388889 0.324000 20.3416667 0.324000 20.3444444 0.326667 20.3472222 0.328667 20.3500000 0.330667 20.3527778 0.336000 20.3555556 0.338667 20.3583333 0.344000 20.3611111 0.347333 20.3638889 0.350667 20.3666667 0.354000 20.3694444 0.358000 20.3722222 0.363333 20.3750000 0.366000 20.3777778 0.368667 20.3805556 0.369333 20.3833333 0.366000 20.3861111 0.360000 20.3888889 0.352667 20.3916667 0.342667 20.3944444 0.333333 20.3972222 0.324667 20.4000000 0.315333 20.4027778 0.311333 20.4055556 0.305333 20.4083333 0.300667 20.4111111 0.299333 20.4138889 0.296667 20.4166667 0.294000 20.4194444 0.294000 20.4222222 0.293333 20.4250000 0.293333 20.4277778 0.292667 20.4305556 0.294667 20.4333333 0.292667 20.4361111 0.292667 20.4388889 0.292667 20.4416667 0.290667 20.4444444 0.292667 20.4472222 0.293333 20.4500000 0.293333 20.4527778 0.294000 20.4555556 0.294667 20.4583333 0.292667 20.4611111 0.292000 20.4638889 0.292000 20.4666667 0.292000 20.4694444 0.293333 20.4722222 0.294667 20.4750000 0.294667 20.4777778 0.294667 20.4805556 0.296667 20.4833333 0.296000 20.4861111 0.296000 20.4888889 0.295333 20.4916667 0.294667 20.4944444 0.294667 20.4972222 0.292667 20.5000000 0.293333 20.5027778 0.294667 20.5055556 0.294667 20.5083333 0.296667 20.5111111 0.299333 20.5138889 0.301333 20.5166667 0.300000 20.5194444 0.299333 20.5222222 0.297333 20.5250000 0.296000 20.5277778 0.294667 20.5305556 0.294667 20.5333333 0.294000 20.5361111 0.294000 20.5388889 0.294667 20.5416667 0.294667 20.5444444 0.295333 20.5472222 0.293333 20.5500000 0.292000 20.5527778 0.291333 20.5555556 0.288667 20.5583333 0.287333 20.5611111 0.285333 20.5638889 0.284000 20.5666667 0.284000 20.5694444 0.281333 20.5722222 0.281333 20.5750000 0.282000 20.5777778 0.282667 20.5805556 0.282000 20.5833333 0.280667 20.5861111 0.280000 20.5888889 0.276667 20.5916667 0.276000 20.5944444 0.274000 20.5972222 0.273333 20.6000000 0.274000 20.6027778 0.274000 20.6055556 0.276000 20.6113333 0.300000 21.4108889 0.300000 21.4138889 0.302667 21.4166667 0.300000 21.4194444 0.300000 21.4222222 0.300000 21.4250000 0.299333 21.4277778 0.300000 21.4305556 0.300000 21.4333333 0.301333 21.4361111 0.303333 21.4388889 0.305333 21.4416667 0.304667 21.4444444 0.304000 21.4472222 0.304000 21.4500000 0.306000 21.4527778 0.305333 21.4555556 0.304667 21.4583333 0.304667 21.4611111 0.302000 21.4638889 0.300667 21.4666667 0.299333 21.4694444 0.297333 21.4722222 0.298000 21.4750000 0.298000 21.4777778 0.298667 21.4805556 0.298000 21.4833333 0.298667 21.4861111 0.298667 21.4888889 0.298667 21.4916667 0.297333 21.4944444 0.298000 21.4972222 0.298000 21.5000000 0.299333 21.5027778 0.299333 21.5055556 0.298667 21.5083333 0.297333 21.5111111 0.297333 21.5138889 0.296667 21.5166667 0.298000 21.5194444 0.298000 21.5222222 0.299333 21.5250000 0.298667 21.5277778 0.298000 21.5305556 0.298667 21.5333333 0.298667 21.5361111 0.298667 21.5388889 0.300000 21.5416667 0.298667 21.5444444 0.299333 21.5472222 0.299333 21.5500000 0.300667 21.5527778 0.298667 21.5555556 0.297333 21.5583333 0.297333 21.5611111 0.296667 21.5638889 0.299333 21.5666667 0.300000 21.5694444 0.300667 21.5722222 0.304000 21.5750000 0.304667 21.5777778 0.304667 21.5805556 0.303333 21.5833333 0.302000 21.5861111 0.300667 21.5888889 0.299333 21.5916667 0.300000 21.5944444 0.296667 21.5972222 0.300000 21.6000000 0.299333 21.6027778 0.301333 21.6055556 0.302667 21.6083333 0.303333 21.6111111 0.304000 21.6138889 0.304667 21.6166667 0.302667 21.6194444 0.302000 21.6222222 0.300000 21.6250000 0.298667 21.6277778 0.295333 21.6305556 0.297333 21.6333333 0.298667 21.6361111 0.302000 21.6388889 0.305333 21.6416667 0.310667 21.6444444 0.310667 21.6472222 0.308000 21.6500000 0.302667 21.6527778 0.291333 21.6555556 0.282000 21.6583333 0.270667 21.6611111 0.258000 21.6638889 0.251333 21.6666667 0.245333 21.6694444 0.244000 21.6722222 0.244667 21.6750000 0.250667 21.6777778 0.260667 21.6805556 0.275333 21.6833333 0.290667 21.6861111 0.304000 21.6888889 0.314000 21.6916667 0.320667 21.6944444 0.322000 21.6972222 0.324000 21.7000000 0.327333 21.7027778 0.328000 21.7055556 0.333333 21.7083333 0.337333 21.7111111 0.340667 21.7138889 0.344000 21.7166667 0.345333 21.7194444 0.349333 21.7222222 0.350000 21.7250000 0.351333 21.7277778 0.353333 21.7305556 0.354667 21.7333333 0.354000 21.7361111 0.349333 21.7388889 0.344000 21.7416667 0.337333 21.7444444 0.326667 21.7472222 0.318000 21.7500000 0.310000 21.7527778 0.300000 21.7555556 0.295333 21.7583333 0.291333 21.7611111 0.288667 21.7638889 0.287333 21.7666667 0.290000 21.7694444 0.290667 21.7722222 0.290667 21.7750000 0.289333 21.7777778 0.288667 21.7805556 0.288667 21.7833333 0.287333 21.7861111 0.287333 21.7888889 0.286667 21.7916667 0.287333 21.7944444 0.288667 21.7972222 0.287333 21.8000000 0.286667 21.8027778 0.289333 21.8055556 0.286667 21.8083333 0.286667 21.8111111 0.285333 21.8138889 0.286000 21.8166667 0.287333 21.8194444 0.287333 21.8222222 0.288000 21.8250000 0.288000 21.8277778 0.286667 21.8305556 0.284000 21.8333333 0.282667 21.8361111 0.282667 21.8388889 0.284000 21.8416667 0.284667 21.8444444 0.284667 21.8472222 0.284667 21.8500000 0.282667 21.8527778 0.280667 21.8555556 0.278000 21.8583333 0.277333 21.8611111 0.276667 21.8638889 0.276667 21.8666667 0.277333 21.8694444 0.278000 21.8722222 0.280667 21.8750000 0.282000 21.8777778 0.284000 21.8805556 0.284667 21.8833333 0.280667 21.8861111 0.280000 21.8888889 0.278000 21.8916667 0.276667 21.8944444 0.275333 21.8972222 0.273333 21.9000000 0.272000 21.9027778 0.273333 21.9055556 0.272000 21.9083333 0.274000 21.9111111 0.273333 21.9138889 0.272667 21.9166667 0.270667 21.9194444 0.268667 21.9222222 0.266000 21.9250000 0.265333 21.9277778 0.263333 21.9305556 0.264667 21.9333333 0.263333 21.9361111 0.264000 21.9388889 0.266000 21.9416667 0.266000 21.9444444 0.268000 21.9472222 0.266000 21.9500000 0.264000 21.9527778 0.264667 21.9555556 0.262000 21.9583333 0.262000 21.9611111 0.260000 21.9668889 0.300000 22.1053333 0.300000 22.1083333 0.282667 22.1111111 0.282667 22.1138889 0.283333 22.1166667 0.284000 22.1194444 0.285333 22.1222222 0.287333 22.1250000 0.285333 22.1277778 0.286667 22.1305556 0.286667 22.1333333 0.286000 22.1361111 0.286667 22.1388889 0.285333 22.1416667 0.286667 22.1444444 0.288667 22.1472222 0.288667 22.1500000 0.290667 22.1527778 0.288000 22.1555556 0.286667 22.1583333 0.286000 22.1611111 0.283333 22.1638889 0.282667 22.1666667 0.282667 22.1694444 0.284667 22.1722222 0.285333 22.1750000 0.286000 22.1777778 0.288000 22.1805556 0.289333 22.1833333 0.290667 22.1861111 0.288667 22.1888889 0.285333 22.1916667 0.286000 22.1944444 0.283333 22.1972222 0.282667 22.2000000 0.283333 22.2027778 0.286000 22.2055556 0.288667 22.2083333 0.289333 22.2111111 0.290667 22.2138889 0.290000 22.2166667 0.294000 22.2194444 0.293333 22.2222222 0.293333 22.2250000 0.292667 22.2277778 0.291333 22.2305556 0.290667 22.2333333 0.290000 22.2361111 0.291333 22.2388889 0.292000 22.2416667 0.292000 22.2444444 0.293333 22.2472222 0.294000 22.2500000 0.294000 22.2527778 0.295333 22.2555556 0.292000 22.2583333 0.293333 22.2611111 0.290667 22.2638889 0.289333 22.2666667 0.291333 22.2694444 0.294667 22.2722222 0.295333 22.2750000 0.298000 22.2777778 0.296667 22.2805556 0.295333 22.2833333 0.292667 22.2861111 0.292667 22.2888889 0.292667 22.2916667 0.293333 22.2944444 0.294000 22.2972222 0.293333 22.3000000 0.294667 22.3027778 0.295333 22.3055556 0.297333 22.3083333 0.296667 22.3111111 0.298000 22.3138889 0.296667 22.3166667 0.298000 22.3194444 0.297333 22.3222222 0.295333 22.3250000 0.294667 22.3277778 0.294000 22.3305556 0.296667 22.3333333 0.296667 22.3361111 0.300000 22.3388889 0.299333 22.3416667 0.299333 22.3444444 0.296000 22.3472222 0.290000 22.3500000 0.278667 22.3527778 0.269333 22.3555556 0.259333 22.3583333 0.252000 22.3611111 0.245333 22.3638889 0.244667 22.3666667 0.246667 22.3694444 0.253333 22.3722222 0.264667 22.3750000 0.277333 22.3777778 0.294667 22.3805556 0.309333 22.3833333 0.319333 22.3861111 0.324000 22.3888889 0.325333 22.3916667 0.324000 22.3944444 0.323333 22.3972222 0.324000 22.4000000 0.325333 22.4027778 0.328000 22.4055556 0.328667 22.4083333 0.331333 22.4111111 0.335333 22.4138889 0.335333 22.4166667 0.339333 22.4194444 0.342667 22.4222222 0.344000 22.4250000 0.349333 22.4277778 0.352000 22.4305556 0.350667 22.4333333 0.350000 22.4361111 0.348000 22.4388889 0.343333 22.4416667 0.338667 22.4444444 0.332667 22.4472222 0.327333 22.4500000 0.321333 22.4527778 0.314000 22.4555556 0.305333 22.4583333 0.297333 22.4611111 0.291333 22.4638889 0.286667 22.4666667 0.284667 22.4694444 0.284000 22.4722222 0.286000 22.4750000 0.287333 22.4777778 0.290667 22.4805556 0.293333 22.4833333 0.292667 22.4861111 0.291333 22.4888889 0.290667 22.4916667 0.288667 22.4944444 0.288000 22.4972222 0.285333 22.5000000 0.286667 22.5027778 0.288667 22.5055556 0.289333 22.5083333 0.287333 22.5111111 0.289333 22.5138889 0.288667 22.5166667 0.288000 22.5194444 0.288667 22.5222222 0.289333 22.5250000 0.286667 22.5277778 0.286000 22.5305556 0.284667 22.5333333 0.285333 22.5361111 0.283333 22.5388889 0.282667 22.5416667 0.284000 22.5444444 0.285333 22.5472222 0.286000 22.5500000 0.286667 22.5527778 0.285333 22.5555556 0.282667 22.5583333 0.282000 22.5611111 0.278000 22.5638889 0.276667 22.5666667 0.276667 22.5694444 0.278000 22.5722222 0.278000 22.5750000 0.280667 22.5777778 0.281333 22.5805556 0.280667 22.5833333 0.280000 22.5861111 0.280000 22.5888889 0.278667 22.5916667 0.278667 22.5944444 0.276667 22.5972222 0.274000 22.6000000 0.274000 22.6027778 0.274667 22.6055556 0.272000 22.6083333 0.274000 22.6111111 0.274667 22.6138889 0.274000 22.6166667 0.274000 22.6194444 0.274000 22.6222222 0.271333 22.6250000 0.268667 22.6277778 0.266000 22.6305556 0.263333 22.6333333 0.262667 22.6361111 0.266000 22.6388889 0.266667 22.6416667 0.266000 22.6444444 0.268000 22.6472222 0.267333 22.6500000 0.266000 22.6527778 0.264000 22.6555556 0.265333 22.6613333 0.300000 22.8470000 0.300000 22.8500000 0.298667 22.8527778 0.298000 22.8555556 0.296000 22.8583333 0.294000 22.8611111 0.292000 22.8638889 0.289333 22.8666667 0.291333 22.8694444 0.292667 22.8722222 0.294000 22.8750000 0.295333 22.8777778 0.296000 22.8805556 0.294667 22.8833333 0.298000 22.8861111 0.298000 22.8888889 0.298667 22.8916667 0.296667 22.8944444 0.297333 22.8972222 0.296000 22.9000000 0.297333 22.9027778 0.296667 22.9055556 0.299333 22.9083333 0.299333 22.9111111 0.300000 22.9138889 0.300667 22.9166667 0.299333 22.9194444 0.298667 22.9222222 0.298667 22.9250000 0.297333 22.9277778 0.298667 22.9305556 0.298000 22.9333333 0.297333 22.9361111 0.298667 22.9388889 0.299333 22.9416667 0.299333 22.9444444 0.301333 22.9472222 0.302667 22.9500000 0.304667 22.9527778 0.304667 22.9555556 0.306000 22.9583333 0.305333 22.9611111 0.303333 22.9638889 0.302667 22.9666667 0.304667 22.9694444 0.305333 22.9722222 0.306000 22.9750000 0.308667 22.9777778 0.308000 22.9805556 0.308667 22.9833333 0.306667 22.9861111 0.307333 22.9888889 0.304667 22.9916667 0.304667 22.9944444 0.304000 22.9972222 0.302000 23.0000000 0.303333 23.0027778 0.306667 23.0055556 0.308667 23.0083333 0.310667 23.0111111 0.310000 23.0138889 0.309333 23.0166667 0.309333 23.0194444 0.308667 23.0222222 0.306667 23.0250000 0.306000 23.0277778 0.305333 23.0305556 0.306000 23.0333333 0.306667 23.0361111 0.308667 23.0388889 0.309333 23.0416667 0.310667 23.0444444 0.312000 23.0472222 0.312667 23.0500000 0.311333 23.0527778 0.308667 23.0555556 0.306667 23.0583333 0.306000 23.0611111 0.304667 23.0638889 0.304000 23.0666667 0.306667 23.0694444 0.307333 23.0722222 0.310000 23.0750000 0.312667 23.0777778 0.314667 23.0805556 0.317333 23.0833333 0.314667 23.0861111 0.310667 23.0888889 0.304667 23.0916667 0.298000 23.0944444 0.289333 23.0972222 0.278667 23.1000000 0.270667 23.1027778 0.262000 23.1055556 0.257333 23.1083333 0.258000 23.1111111 0.263333 23.1138889 0.272667 23.1166667 0.288000 23.1194444 0.304000 23.1222222 0.316000 23.1250000 0.326667 23.1277778 0.334667 23.1305556 0.338000 23.1333333 0.340000 23.1361111 0.338667 23.1388889 0.339333 23.1416667 0.339333 23.1444444 0.340000 23.1472222 0.343333 23.1500000 0.344667 23.1527778 0.348667 23.1555556 0.352667 23.1583333 0.354667 23.1611111 0.356000 23.1638889 0.360000 23.1666667 0.363333 23.1694444 0.363333 23.1722222 0.364000 23.1750000 0.364000 23.1777778 0.362667 23.1805556 0.358667 23.1833333 0.353333 23.1861111 0.349333 23.1888889 0.342667 23.1916667 0.336000 23.1944444 0.326000 23.1972222 0.318667 23.2000000 0.312667 23.2027778 0.306000 23.2055556 0.304000 23.2083333 0.302667 23.2111111 0.304000 23.2138889 0.306000 23.2166667 0.304000 23.2194444 0.306667 23.2222222 0.306000 23.2250000 0.304000 23.2277778 0.301333 23.2305556 0.300000 23.2333333 0.301333 23.2361111 0.302000 23.2388889 0.302000 23.2416667 0.304000 23.2444444 0.304000 23.2472222 0.304000 23.2500000 0.303333 23.2527778 0.302667 23.2555556 0.301333 23.2583333 0.300667 23.2611111 0.299333 23.2638889 0.298667 23.2666667 0.300667 23.2694444 0.302667 23.2722222 0.305333 23.2750000 0.304667 23.2777778 0.307333 23.2805556 0.307333 23.2833333 0.307333 23.2861111 0.304000 23.2888889 0.300667 23.2916667 0.298667 23.2944444 0.296667 23.2972222 0.297333 23.3000000 0.296667 23.3027778 0.298667 23.3055556 0.299333 23.3083333 0.298667 23.3111111 0.299333 23.3138889 0.298667 23.3166667 0.297333 23.3194444 0.296000 23.3222222 0.296000 23.3250000 0.296000 23.3277778 0.295333 23.3305556 0.294667 23.3333333 0.293333 23.3361111 0.293333 23.3388889 0.289333 23.3416667 0.289333 23.3444444 0.288667 23.3472222 0.288667 23.3500000 0.286667 23.3527778 0.287333 23.3555556 0.286000 23.3583333 0.285333 23.3611111 0.282667 23.3638889 0.282667 23.3666667 0.283333 23.3694444 0.282000 23.3722222 0.282667 23.3750000 0.283333 23.3777778 0.280667 23.3805556 0.282667 23.3833333 0.280000 23.3861111 0.279333 23.3888889 0.281333 23.3916667 0.280667 23.3944444 0.280000 23.3972222 0.280667 23.4030000 0.300000 23.5636667 0.300000 23.5666667 0.309333 23.5694444 0.310000 23.5722222 0.309333 23.5750000 0.309333 23.5777778 0.310667 23.5805556 0.310667 23.5833333 0.310667 23.5861111 0.310667 23.5888889 0.308667 23.5916667 0.308000 23.5944444 0.310667 23.5972222 0.310667 23.6000000 0.311333 23.6027778 0.312667 23.6055556 0.313333 23.6083333 0.313333 23.6111111 0.311333 23.6138889 0.310667 23.6166667 0.309333 23.6194444 0.309333 23.6222222 0.308667 23.6250000 0.307333 23.6277778 0.306667 23.6305556 0.307333 23.6333333 0.307333 23.6361111 0.307333 23.6388889 0.308000 23.6416667 0.308000 23.6444444 0.308667 23.6472222 0.308667 23.6500000 0.310000 23.6527778 0.310667 23.6555556 0.308667 23.6583333 0.308000 23.6611111 0.310000 23.6638889 0.311333 23.6666667 0.312000 23.6694444 0.313333 23.6722222 0.314000 23.6750000 0.315333 23.6777778 0.316000 23.6805556 0.316667 23.6833333 0.314667 23.6861111 0.315333 23.6888889 0.314667 23.6916667 0.317333 23.6944444 0.314667 23.6972222 0.312667 23.7000000 0.312000 23.7027778 0.312667 23.7055556 0.312667 23.7083333 0.316000 23.7111111 0.316000 23.7138889 0.320000 23.7166667 0.319333 23.7194444 0.318000 23.7222222 0.317333 23.7250000 0.315333 23.7277778 0.317333 23.7305556 0.313333 23.7333333 0.314667 23.7361111 0.316000 23.7388889 0.316000 23.7416667 0.318000 23.7444444 0.320000 23.7472222 0.320667 23.7500000 0.318000 23.7527778 0.316000 23.7555556 0.314667 23.7583333 0.312000 23.7611111 0.312000 23.7638889 0.314000 23.7666667 0.315333 23.7694444 0.317333 23.7722222 0.318667 23.7750000 0.319333 23.7777778 0.320000 23.7805556 0.318667 23.7833333 0.319333 23.7861111 0.320667 23.7888889 0.320667 23.7916667 0.322000 23.7944444 0.322667 23.7972222 0.321333 23.8000000 0.319333 23.8027778 0.318000 23.8055556 0.312667 23.8083333 0.304000 23.8111111 0.298000 23.8138889 0.289333 23.8166667 0.283333 23.8194444 0.276000 23.8222222 0.270000 23.8250000 0.268000 23.8277778 0.270667 23.8305556 0.278667 23.8333333 0.290667 23.8361111 0.304667 23.8388889 0.320667 23.8416667 0.334000 23.8444444 0.344000 23.8472222 0.350667 23.8500000 0.350667 23.8527778 0.351333 23.8555556 0.349333 23.8583333 0.349333 23.8611111 0.349333 23.8638889 0.350000 23.8666667 0.353333 23.8694444 0.356667 23.8722222 0.360667 23.8750000 0.363333 23.8777778 0.366000 23.8805556 0.370000 23.8833333 0.370000 23.8861111 0.371333 23.8888889 0.370667 23.8916667 0.369333 23.8944444 0.366667 23.8972222 0.363333 23.9000000 0.358667 23.9027778 0.355333 23.9055556 0.351333 23.9083333 0.344667 23.9111111 0.340667 23.9138889 0.332000 23.9166667 0.323333 23.9194444 0.316667 23.9222222 0.311333 23.9250000 0.309333 23.9277778 0.310000 23.9305556 0.309333 23.9333333 0.310000 23.9361111 0.309333 23.9388889 0.310000 23.9416667 0.309333 23.9444444 0.308000 23.9472222 0.308667 23.9500000 0.308667 23.9527778 0.308667 23.9555556 0.310000 23.9583333 0.309333 23.9611111 0.308667 23.9638889 0.307333 23.9666667 0.306667 23.9694444 0.306000 23.9722222 0.306000 23.9750000 0.306667 23.9777778 0.310000 23.9805556 0.310000 23.9833333 0.310000 23.9861111 0.307333 23.9888889 0.306667 23.9916667 0.305333 23.9944444 0.305333 23.9972222 0.305333 24.0000000 0.307333 24.0027778 0.310667 24.0055556 0.309333 24.0083333 0.309333 24.0111111 0.310000 24.0138889 0.309333 24.0166667 0.308667 24.0194444 0.306000 24.0222222 0.306667 24.0250000 0.304667 24.0277778 0.302667 24.0305556 0.302000 24.0333333 0.302667 24.0361111 0.301333 24.0388889 0.304667 24.0416667 0.304000 24.0444444 0.304667 24.0472222 0.302000 24.0500000 0.302000 24.0527778 0.300000 24.0555556 0.301333 24.0583333 0.300667 24.0611111 0.297333 24.0638889 0.296667 24.0666667 0.294667 24.0694444 0.292667 24.0722222 0.292667 24.0750000 0.294667 24.0777778 0.294667 24.0805556 0.294667 24.0833333 0.294000 24.0861111 0.292667 24.0888889 0.290667 24.0916667 0.290000 24.0944444 0.290000 24.0972222 0.288667 24.1000000 0.288000 24.1027778 0.288667 24.1055556 0.290000 24.1083333 0.290667 24.1111111 0.290667 24.1138889 0.290667 24.1196667 0.300000 24.3025556 0.300000 24.3055556 0.319333 24.3083333 0.320000 24.3111111 0.320000 24.3138889 0.319333 24.3166667 0.316000 24.3194444 0.315333 24.3222222 0.314667 24.3250000 0.312667 24.3277778 0.313333 24.3305556 0.314000 24.3333333 0.314667 24.3361111 0.312667 24.3388889 0.315333 24.3416667 0.316667 24.3444444 0.318000 24.3472222 0.318000 24.3500000 0.318000 24.3527778 0.320000 24.3555556 0.317333 24.3583333 0.316000 24.3611111 0.314667 24.3638889 0.312667 24.3666667 0.313333 24.3694444 0.315333 24.3722222 0.316000 24.3750000 0.316000 24.3777778 0.316667 24.3805556 0.320000 24.3833333 0.317333 24.3861111 0.317333 24.3888889 0.318667 24.3916667 0.317333 24.3944444 0.317333 24.3972222 0.314667 24.4000000 0.315333 24.4027778 0.316667 24.4055556 0.318000 24.4083333 0.318000 24.4111111 0.318667 24.4138889 0.322000 24.4166667 0.320667 24.4194444 0.323333 24.4222222 0.324000 24.4250000 0.321333 24.4277778 0.321333 24.4305556 0.320667 24.4333333 0.320667 24.4361111 0.320667 24.4388889 0.320667 24.4416667 0.318667 24.4444444 0.322000 24.4472222 0.322000 24.4500000 0.322667 24.4527778 0.324667 24.4555556 0.324000 24.4583333 0.324667 24.4611111 0.322000 24.4638889 0.321333 24.4666667 0.322000 24.4694444 0.324000 24.4722222 0.325333 24.4750000 0.324667 24.4777778 0.326000 24.4805556 0.324667 24.4833333 0.325333 24.4861111 0.325333 24.4888889 0.324000 24.4916667 0.324000 24.4944444 0.322000 24.4972222 0.320667 24.5000000 0.320667 24.5027778 0.322000 24.5055556 0.322000 24.5083333 0.324667 24.5111111 0.326667 24.5138889 0.324667 24.5166667 0.321333 24.5194444 0.320667 24.5222222 0.319333 24.5250000 0.320000 24.5277778 0.323333 24.5305556 0.324667 24.5333333 0.329333 24.5361111 0.330667 24.5388889 0.330667 24.5416667 0.329333 24.5444444 0.325333 24.5472222 0.318000 24.5500000 0.308667 24.5527778 0.297333 24.5555556 0.286667 24.5583333 0.276000 24.5611111 0.268000 24.5638889 0.264000 24.5666667 0.268000 24.5694444 0.276667 24.5722222 0.290000 24.5750000 0.307333 24.5777778 0.324000 24.5805556 0.339333 24.5833333 0.350000 24.5861111 0.352667 24.5888889 0.356000 24.5916667 0.353333 24.5944444 0.352000 24.5972222 0.352667 24.6000000 0.355333 24.6027778 0.358667 24.6055556 0.363333 24.6083333 0.367333 24.6111111 0.369333 24.6138889 0.374667 24.6166667 0.376000 24.6194444 0.376667 24.6222222 0.379333 24.6250000 0.378667 24.6277778 0.378000 24.6305556 0.377333 24.6333333 0.374667 24.6361111 0.370000 24.6388889 0.366000 24.6416667 0.361333 24.6444444 0.355333 24.6472222 0.350667 24.6500000 0.342667 24.6527778 0.335333 24.6555556 0.326667 24.6583333 0.320667 24.6611111 0.316000 24.6638889 0.312000 24.6666667 0.312000 24.6694444 0.314000 24.6722222 0.316000 24.6750000 0.318667 24.6777778 0.318667 24.6805556 0.320000 24.6833333 0.319333 24.6861111 0.316000 24.6888889 0.315333 24.6916667 0.312667 24.6944444 0.310667 24.6972222 0.310000 24.7000000 0.313333 24.7027778 0.314000 24.7055556 0.316000 24.7083333 0.318667 24.7111111 0.319333 24.7138889 0.321333 24.7166667 0.320000 24.7194444 0.318667 24.7222222 0.317333 24.7250000 0.315333 24.7277778 0.315333 24.7305556 0.312667 24.7333333 0.312000 24.7361111 0.314667 24.7388889 0.314667 24.7416667 0.315333 24.7444444 0.317333 24.7472222 0.315333 24.7500000 0.315333 24.7527778 0.314667 24.7555556 0.313333 24.7583333 0.312000 24.7611111 0.310667 24.7638889 0.307333 24.7666667 0.307333 24.7694444 0.307333 24.7722222 0.306667 24.7750000 0.307333 24.7777778 0.308667 24.7805556 0.308000 24.7833333 0.308000 24.7861111 0.306000 24.7888889 0.305333 24.7916667 0.303333 24.7944444 0.301333 24.7972222 0.299333 24.8000000 0.300000 24.8027778 0.298667 24.8055556 0.298667 24.8083333 0.299333 24.8111111 0.300667 24.8138889 0.298667 24.8166667 0.298667 24.8194444 0.297333 24.8222222 0.294000 24.8250000 0.294000 24.8277778 0.291333 24.8305556 0.289333 24.8333333 0.291333 24.8361111 0.290000 24.8388889 0.292667 24.8416667 0.292667 24.8444444 0.294000 24.8472222 0.294000 24.8500000 0.296000 24.8527778 0.295333 24.8585556 0.300000 25.0525556 0.300000 25.0555556 0.312000 25.0583333 0.312000 25.0611111 0.311333 25.0638889 0.310000 25.0666667 0.309333 25.0694444 0.309333 25.0722222 0.311333 25.0750000 0.312667 25.0777778 0.314000 25.0805556 0.315333 25.0833333 0.316000 25.0861111 0.318000 25.0888889 0.317333 25.0916667 0.316667 25.0944444 0.316667 25.0972222 0.314000 25.1000000 0.313333 25.1027778 0.312000 25.1055556 0.312667 25.1083333 0.312000 25.1111111 0.314000 25.1138889 0.315333 25.1166667 0.315333 25.1194444 0.314667 25.1222222 0.313333 25.1250000 0.312667 25.1277778 0.314000 25.1305556 0.312667 25.1333333 0.312000 25.1361111 0.316667 25.1388889 0.319333 25.1416667 0.321333 25.1444444 0.322000 25.1472222 0.323333 25.1500000 0.322667 25.1527778 0.322000 25.1555556 0.324000 25.1583333 0.323333 25.1611111 0.320667 25.1638889 0.320000 25.1666667 0.320000 25.1694444 0.320667 25.1722222 0.323333 25.1750000 0.323333 25.1777778 0.326667 25.1805556 0.326667 25.1833333 0.324667 25.1861111 0.326667 25.1888889 0.327333 25.1916667 0.326000 25.1944444 0.325333 25.1972222 0.323333 25.2000000 0.324000 25.2027778 0.324000 25.2055556 0.324667 25.2083333 0.325333 25.2111111 0.327333 25.2138889 0.326667 25.2166667 0.324667 25.2194444 0.323333 25.2222222 0.322667 25.2250000 0.325333 25.2277778 0.324667 25.2305556 0.324667 25.2333333 0.324000 25.2361111 0.325333 25.2388889 0.325333 25.2416667 0.326667 25.2444444 0.326667 25.2472222 0.327333 25.2500000 0.328000 25.2527778 0.328667 25.2555556 0.328000 25.2583333 0.326000 25.2611111 0.322667 25.2638889 0.322000 25.2666667 0.322000 25.2694444 0.324000 25.2722222 0.326000 25.2750000 0.328667 25.2777778 0.330000 25.2805556 0.332000 25.2833333 0.332667 25.2861111 0.331333 25.2888889 0.328000 25.2916667 0.324667 25.2944444 0.318000 25.2972222 0.310667 25.3000000 0.303333 25.3027778 0.294667 25.3055556 0.283333 25.3083333 0.277333 25.3111111 0.271333 25.3138889 0.270667 25.3166667 0.272667 25.3194444 0.278667 25.3222222 0.290000 25.3250000 0.304000 25.3277778 0.319333 25.3305556 0.332667 25.3333333 0.342000 25.3361111 0.346667 25.3388889 0.350667 25.3416667 0.350667 25.3444444 0.351333 25.3472222 0.353333 25.3500000 0.352000 25.3527778 0.355333 25.3555556 0.356667 25.3583333 0.358667 25.3611111 0.360000 25.3638889 0.361333 25.3666667 0.366000 25.3694444 0.369333 25.3722222 0.372000 25.3750000 0.375333 25.3777778 0.375333 25.3805556 0.372000 25.3833333 0.368667 25.3861111 0.364667 25.3888889 0.359333 25.3916667 0.354000 25.3944444 0.345333 25.3972222 0.337333 25.4000000 0.331333 25.4027778 0.326667 25.4055556 0.320000 25.4083333 0.316667 25.4111111 0.316000 25.4138889 0.313333 25.4166667 0.312000 25.4194444 0.310667 25.4222222 0.312667 25.4250000 0.310000 25.4277778 0.310667 25.4305556 0.310000 25.4333333 0.310667 25.4361111 0.312667 25.4388889 0.311333 25.4416667 0.312667 25.4444444 0.312667 25.4472222 0.312667 25.4500000 0.307333 25.4527778 0.309333 25.4555556 0.306667 25.4583333 0.306667 25.4611111 0.306667 25.4638889 0.308000 25.4666667 0.307333 25.4694444 0.308667 25.4722222 0.307333 25.4750000 0.307333 25.4777778 0.306000 25.4805556 0.304667 25.4833333 0.306000 25.4861111 0.305333 25.4888889 0.304667 25.4916667 0.304667 25.4944444 0.303333 25.4972222 0.305333 25.5000000 0.305333 25.5027778 0.304000 25.5055556 0.303333 25.5083333 0.304000 25.5111111 0.300667 25.5138889 0.300667 25.5166667 0.300000 25.5194444 0.298667 25.5222222 0.298000 25.5250000 0.297333 25.5277778 0.296667 25.5305556 0.295333 25.5333333 0.296000 25.5361111 0.294667 25.5388889 0.296000 25.5416667 0.294667 25.5444444 0.295333 25.5472222 0.294667 25.5500000 0.294000 25.5527778 0.292000 25.5555556 0.291333 25.5583333 0.288000 25.5611111 0.287333 25.5638889 0.288000 25.5666667 0.285333 25.5694444 0.286667 25.5722222 0.288667 25.5750000 0.292000 25.5777778 0.292000 25.5805556 0.292000 25.5833333 0.289333 25.5861111 0.289333 25.5888889 0.285333 25.5916667 0.284667 25.5944444 0.283333 25.5972222 0.284667 25.6000000 0.284000 25.6027778 0.286667 25.6085556 0.300000 25.7831111 0.300000 25.7861111 0.310000 25.7888889 0.308667 25.7916667 0.306667 25.7944444 0.304667 25.7972222 0.304000 25.8000000 0.305333 25.8027778 0.305333 25.8055556 0.306000 25.8083333 0.308667 25.8111111 0.309333 25.8138889 0.312667 25.8166667 0.313333 25.8194444 0.313333 25.8222222 0.313333 25.8250000 0.312000 25.8277778 0.311333 25.8305556 0.310667 25.8333333 0.311333 25.8361111 0.310667 25.8388889 0.310000 25.8416667 0.310667 25.8444444 0.311333 25.8472222 0.309333 25.8500000 0.310667 25.8527778 0.309333 25.8555556 0.308000 25.8583333 0.308000 25.8611111 0.307333 25.8638889 0.307333 25.8666667 0.307333 25.8694444 0.308000 25.8722222 0.312000 25.8750000 0.314000 25.8777778 0.317333 25.8805556 0.316667 25.8833333 0.318000 25.8861111 0.315333 25.8888889 0.316667 25.8916667 0.315333 25.8944444 0.314667 25.8972222 0.314000 25.9000000 0.315333 25.9027778 0.316000 25.9055556 0.318000 25.9083333 0.319333 25.9111111 0.318000 25.9138889 0.319333 25.9166667 0.318667 25.9194444 0.316667 25.9222222 0.316667 25.9250000 0.318000 25.9277778 0.316000 25.9305556 0.312667 25.9333333 0.312000 25.9361111 0.312000 25.9388889 0.314000 25.9416667 0.314667 25.9444444 0.316667 25.9472222 0.318000 25.9500000 0.318000 25.9527778 0.316000 25.9555556 0.313333 25.9583333 0.310667 25.9611111 0.312000 25.9638889 0.312667 25.9666667 0.316000 25.9694444 0.316667 25.9722222 0.317333 25.9750000 0.316667 25.9777778 0.315333 25.9805556 0.316000 25.9833333 0.316000 25.9861111 0.313333 25.9888889 0.310000 25.9916667 0.308667 25.9944444 0.308667 25.9972222 0.308667 26.0000000 0.309333 26.0027778 0.312667 26.0055556 0.315333 26.0083333 0.318667 26.0111111 0.320667 26.0138889 0.322000 26.0166667 0.321333 26.0194444 0.320667 26.0222222 0.318000 26.0250000 0.314000 26.0277778 0.307333 26.0305556 0.299333 26.0333333 0.291333 26.0361111 0.284000 26.0388889 0.277333 26.0416667 0.272000 26.0444444 0.268000 26.0472222 0.269333 26.0500000 0.273333 26.0527778 0.282000 26.0555556 0.292667 26.0583333 0.304000 26.0611111 0.316000 26.0638889 0.328667 26.0666667 0.335333 26.0694444 0.342000 26.0722222 0.344000 26.0750000 0.346667 26.0777778 0.347333 26.0805556 0.346000 26.0833333 0.346667 26.0861111 0.346667 26.0888889 0.348000 26.0916667 0.351333 26.0944444 0.356667 26.0972222 0.360000 26.1000000 0.364667 26.1027778 0.366667 26.1055556 0.367333 26.1083333 0.370000 26.1111111 0.370667 26.1138889 0.370000 26.1166667 0.368000 26.1194444 0.362667 26.1222222 0.358000 26.1250000 0.352000 26.1277778 0.343333 26.1305556 0.336667 26.1333333 0.328667 26.1361111 0.324667 26.1388889 0.320000 26.1416667 0.316667 26.1444444 0.316000 26.1472222 0.314667 26.1500000 0.312667 26.1527778 0.310000 26.1555556 0.310000 26.1583333 0.309333 26.1611111 0.310667 26.1638889 0.309333 26.1666667 0.310000 26.1694444 0.310667 26.1722222 0.310000 26.1750000 0.310000 26.1777778 0.311333 26.1805556 0.308667 26.1833333 0.307333 26.1861111 0.308000 26.1888889 0.309333 26.1916667 0.307333 26.1944444 0.306667 26.1972222 0.307333 26.2000000 0.306667 26.2027778 0.305333 26.2055556 0.304000 26.2083333 0.305333 26.2111111 0.305333 26.2138889 0.307333 26.2166667 0.306667 26.2194444 0.307333 26.2222222 0.308000 26.2250000 0.305333 26.2277778 0.305333 26.2305556 0.304667 26.2333333 0.304667 26.2361111 0.302667 26.2388889 0.304000 26.2416667 0.301333 26.2444444 0.300667 26.2472222 0.302667 26.2500000 0.302000 26.2527778 0.302667 26.2555556 0.303333 26.2583333 0.302667 26.2611111 0.300000 26.2638889 0.300000 26.2666667 0.299333 26.2694444 0.302000 26.2722222 0.300667 26.2750000 0.300000 26.2777778 0.298000 26.2805556 0.296000 26.2833333 0.295333 26.2861111 0.294000 26.2888889 0.294667 26.2916667 0.292000 26.2944444 0.292000 26.2972222 0.290000 26.3000000 0.287333 26.3027778 0.288000 26.3055556 0.288667 26.3083333 0.289333 26.3111111 0.290000 26.3138889 0.290000 26.3166667 0.288000 26.3194444 0.288000 26.3222222 0.288000 26.3250000 0.287333 26.3277778 0.286000 26.3305556 0.286000 26.3333333 0.285333 26.3391111 0.300000 26.5192222 0.300000 26.5222222 0.312667 26.5250000 0.311333 26.5277778 0.308000 26.5305556 0.306000 26.5333333 0.306000 26.5361111 0.306000 26.5388889 0.309333 26.5416667 0.312000 26.5444444 0.311333 26.5472222 0.311333 26.5500000 0.310000 26.5527778 0.310000 26.5555556 0.308000 26.5583333 0.309333 26.5611111 0.307333 26.5638889 0.308667 26.5666667 0.309333 26.5694444 0.310667 26.5722222 0.310000 26.5750000 0.311333 26.5777778 0.312667 26.5805556 0.313333 26.5833333 0.314000 26.5861111 0.310667 26.5888889 0.308667 26.5916667 0.308667 26.5944444 0.308000 26.5972222 0.308000 26.6000000 0.310000 26.6027778 0.312000 26.6055556 0.314000 26.6083333 0.314667 26.6111111 0.314667 26.6138889 0.314000 26.6166667 0.314000 26.6194444 0.313333 26.6222222 0.313333 26.6250000 0.311333 26.6277778 0.312667 26.6305556 0.313333 26.6333333 0.316667 26.6361111 0.317333 26.6388889 0.317333 26.6416667 0.318000 26.6444444 0.320000 26.6472222 0.320667 26.6500000 0.320000 26.6527778 0.319333 26.6555556 0.318667 26.6583333 0.317333 26.6611111 0.316000 26.6638889 0.316667 26.6666667 0.317333 26.6694444 0.320000 26.6722222 0.322000 26.6750000 0.322667 26.6777778 0.323333 26.6805556 0.322667 26.6833333 0.322667 26.6861111 0.320667 26.6888889 0.319333 26.6916667 0.316667 26.6944444 0.316667 26.6972222 0.318000 26.7000000 0.318667 26.7027778 0.318667 26.7055556 0.320000 26.7083333 0.322000 26.7111111 0.324000 26.7138889 0.324000 26.7166667 0.322667 26.7194444 0.322000 26.7222222 0.320000 26.7250000 0.318000 26.7277778 0.314667 26.7305556 0.316000 26.7333333 0.319333 26.7361111 0.318667 26.7388889 0.323333 26.7416667 0.322667 26.7444444 0.325333 26.7472222 0.325333 26.7500000 0.326667 26.7527778 0.326667 26.7555556 0.326000 26.7583333 0.324667 26.7611111 0.321333 26.7638889 0.316000 26.7666667 0.308667 26.7694444 0.299333 26.7722222 0.290000 26.7750000 0.280000 26.7777778 0.274000 26.7805556 0.268667 26.7833333 0.269333 26.7861111 0.276000 26.7888889 0.287333 26.7916667 0.307333 26.7944444 0.322667 26.7972222 0.337333 26.8000000 0.347333 26.8027778 0.350000 26.8055556 0.353333 26.8083333 0.352667 26.8111111 0.353333 26.8138889 0.354000 26.8166667 0.355333 26.8194444 0.358667 26.8222222 0.362000 26.8250000 0.364000 26.8277778 0.364667 26.8305556 0.366667 26.8333333 0.370000 26.8361111 0.372667 26.8388889 0.373333 26.8416667 0.376667 26.8444444 0.374667 26.8472222 0.372667 26.8500000 0.368667 26.8527778 0.362000 26.8555556 0.356000 26.8583333 0.348000 26.8611111 0.340000 26.8638889 0.332667 26.8666667 0.325333 26.8694444 0.321333 26.8722222 0.318000 26.8750000 0.314667 26.8777778 0.316000 26.8805556 0.316000 26.8833333 0.314000 26.8861111 0.313333 26.8888889 0.314000 26.8916667 0.313333 26.8944444 0.313333 26.8972222 0.312000 26.9000000 0.313333 26.9027778 0.311333 26.9055556 0.311333 26.9083333 0.313333 26.9111111 0.312667 26.9138889 0.312000 26.9166667 0.312000 26.9194444 0.311333 26.9222222 0.310000 26.9250000 0.310000 26.9277778 0.308000 26.9305556 0.307333 26.9333333 0.308000 26.9361111 0.308667 26.9388889 0.310667 26.9416667 0.310667 26.9444444 0.312667 26.9472222 0.311333 26.9500000 0.310667 26.9527778 0.308667 26.9555556 0.307333 26.9583333 0.309333 26.9611111 0.308000 26.9638889 0.309333 26.9666667 0.310000 26.9694444 0.308667 26.9722222 0.307333 26.9750000 0.305333 26.9777778 0.304667 26.9805556 0.304667 26.9833333 0.306000 26.9861111 0.305333 26.9888889 0.304667 26.9916667 0.305333 26.9944444 0.304000 26.9972222 0.303333 27.0000000 0.301333 27.0027778 0.300667 27.0055556 0.299333 27.0083333 0.299333 27.0111111 0.298667 27.0138889 0.298000 27.0166667 0.296000 27.0194444 0.296000 27.0222222 0.293333 27.0250000 0.291333 27.0277778 0.291333 27.0305556 0.290000 27.0333333 0.289333 27.0361111 0.292000 27.0388889 0.291333 27.0416667 0.291333 27.0444444 0.291333 27.0472222 0.292000 27.0500000 0.288667 27.0527778 0.286667 27.0555556 0.289333 27.0583333 0.288667 27.0611111 0.288667 27.0638889 0.290667 27.0666667 0.291333 27.0694444 0.293333 27.0752222 0.300000 27.2414444 0.300000 27.2444444 0.314667 27.2472222 0.313333 27.2500000 0.311333 27.2527778 0.312667 27.2555556 0.313333 27.2583333 0.312000 27.2611111 0.314000 27.2638889 0.312000 27.2666667 0.312000 27.2694444 0.312667 27.2722222 0.313333 27.2750000 0.314667 27.2777778 0.314667 27.2805556 0.317333 27.2833333 0.317333 27.2861111 0.317333 27.2888889 0.316667 27.2916667 0.316000 27.2944444 0.315333 27.2972222 0.314000 27.3000000 0.313333 27.3027778 0.314667 27.3055556 0.316667 27.3083333 0.317333 27.3111111 0.318667 27.3138889 0.317333 27.3166667 0.316000 27.3194444 0.315333 27.3222222 0.314000 27.3250000 0.313333 27.3277778 0.313333 27.3305556 0.312667 27.3333333 0.314000 27.3361111 0.315333 27.3388889 0.317333 27.3416667 0.316667 27.3444444 0.318000 27.3472222 0.317333 27.3500000 0.319333 27.3527778 0.321333 27.3555556 0.322667 27.3583333 0.324000 27.3611111 0.321333 27.3638889 0.321333 27.3666667 0.320000 27.3694444 0.319333 27.3722222 0.320000 27.3750000 0.321333 27.3777778 0.323333 27.3805556 0.324667 27.3833333 0.324667 27.3861111 0.323333 27.3888889 0.322667 27.3916667 0.320667 27.3944444 0.319333 27.3972222 0.318667 27.4000000 0.320000 27.4027778 0.318667 27.4055556 0.320667 27.4083333 0.322000 27.4111111 0.320667 27.4138889 0.323333 27.4166667 0.324667 27.4194444 0.324667 27.4222222 0.322667 27.4250000 0.324000 27.4277778 0.322000 27.4305556 0.322000 27.4333333 0.321333 27.4361111 0.320000 27.4388889 0.321333 27.4416667 0.320000 27.4444444 0.320667 27.4472222 0.322000 27.4500000 0.320000 27.4527778 0.319333 27.4555556 0.317333 27.4583333 0.317333 27.4611111 0.316667 27.4638889 0.319333 27.4666667 0.322000 27.4694444 0.324000 27.4722222 0.327333 27.4750000 0.330000 27.4777778 0.332667 27.4805556 0.332667 27.4833333 0.330667 27.4861111 0.324000 27.4888889 0.314000 27.4916667 0.300667 27.4944444 0.289333 27.4972222 0.277333 27.5000000 0.270000 27.5027778 0.266000 27.5055556 0.263333 27.5083333 0.268000 27.5111111 0.275333 27.5138889 0.287333 27.5166667 0.301333 27.5194444 0.316667 27.5222222 0.330667 27.5250000 0.340667 27.5277778 0.347333 27.5305556 0.352000 27.5333333 0.356000 27.5361111 0.357333 27.5388889 0.357333 27.5416667 0.356000 27.5444444 0.356667 27.5472222 0.357333 27.5500000 0.357333 27.5527778 0.361333 27.5555556 0.365333 27.5583333 0.367333 27.5611111 0.370000 27.5638889 0.371333 27.5666667 0.374000 27.5694444 0.376000 27.5722222 0.374667 27.5750000 0.375333 27.5777778 0.372667 27.5805556 0.368667 27.5833333 0.358667 27.5861111 0.350667 27.5888889 0.342000 27.5916667 0.332667 27.5944444 0.325333 27.5972222 0.318667 27.6000000 0.314667 27.6027778 0.312667 27.6055556 0.314000 27.6083333 0.312667 27.6111111 0.315333 27.6138889 0.314000 27.6166667 0.314667 27.6194444 0.313333 27.6222222 0.313333 27.6250000 0.311333 27.6277778 0.311333 27.6305556 0.310000 27.6333333 0.312000 27.6361111 0.312000 27.6388889 0.312000 27.6416667 0.312000 27.6444444 0.312667 27.6472222 0.313333 27.6500000 0.314000 27.6527778 0.314667 27.6555556 0.314000 27.6583333 0.313333 27.6611111 0.311333 27.6638889 0.309333 27.6666667 0.306667 27.6694444 0.307333 27.6722222 0.308000 27.6750000 0.310000 27.6777778 0.309333 27.6805556 0.310667 27.6833333 0.310667 27.6861111 0.308667 27.6888889 0.310000 27.6916667 0.307333 27.6944444 0.306667 27.6972222 0.306667 27.7000000 0.306667 27.7027778 0.307333 27.7055556 0.308000 27.7083333 0.308000 27.7111111 0.308000 27.7138889 0.308667 27.7166667 0.306000 27.7194444 0.302667 27.7222222 0.301333 27.7250000 0.300667 27.7277778 0.300000 27.7305556 0.300000 27.7333333 0.301333 27.7361111 0.302000 27.7388889 0.300667 27.7416667 0.301333 27.7444444 0.300000 27.7472222 0.299333 27.7500000 0.298667 27.7527778 0.296000 27.7555556 0.294000 27.7583333 0.294000 27.7611111 0.291333 27.7638889 0.290000 27.7666667 0.290667 27.7694444 0.288667 27.7722222 0.290000 27.7750000 0.292000 27.7777778 0.291333 27.7805556 0.292000 27.7833333 0.290667 27.7861111 0.292000 27.7888889 0.291333 27.7916667 0.291333 27.7974444 0.300000 27.9942222 0.300000 27.9972222 0.316667 28.0000000 0.317333 28.0027778 0.316000 28.0055556 0.316667 28.0083333 0.316667 28.0111111 0.316667 28.0138889 0.318667 28.0166667 0.319333 28.0194444 0.320667 28.0222222 0.320667 28.0250000 0.318000 28.0277778 0.318000 28.0305556 0.314667 28.0333333 0.314667 28.0361111 0.314000 28.0388889 0.316000 28.0416667 0.316667 28.0444444 0.318000 28.0472222 0.318000 28.0500000 0.317333 28.0527778 0.314667 28.0555556 0.316000 28.0583333 0.314667 28.0611111 0.314000 28.0638889 0.312000 28.0666667 0.311333 28.0694444 0.312000 28.0722222 0.314667 28.0750000 0.317333 28.0777778 0.319333 28.0805556 0.320667 28.0833333 0.320000 28.0861111 0.318667 28.0888889 0.318667 28.0916667 0.318000 28.0944444 0.319333 28.0972222 0.320000 28.1000000 0.322667 28.1027778 0.322000 28.1055556 0.322667 28.1083333 0.324000 28.1111111 0.326000 28.1138889 0.326000 28.1166667 0.326000 28.1194444 0.324000 28.1222222 0.324667 28.1250000 0.322667 28.1277778 0.322000 28.1305556 0.322000 28.1333333 0.321333 28.1361111 0.323333 28.1388889 0.324000 28.1416667 0.326000 28.1444444 0.326667 28.1472222 0.328000 28.1500000 0.327333 28.1527778 0.326000 28.1555556 0.325333 28.1583333 0.324000 28.1611111 0.322000 28.1638889 0.323333 28.1666667 0.322667 28.1694444 0.324000 28.1722222 0.326000 28.1750000 0.326667 28.1777778 0.329333 28.1805556 0.329333 28.1833333 0.326667 28.1861111 0.327333 28.1888889 0.326000 28.1916667 0.324667 28.1944444 0.324000 28.1972222 0.324000 28.2000000 0.324667 28.2027778 0.324000 28.2055556 0.324667 28.2083333 0.324000 28.2111111 0.326000 28.2138889 0.328000 28.2166667 0.328667 28.2194444 0.330667 28.2222222 0.332000 28.2250000 0.332667 28.2277778 0.332000 28.2305556 0.330667 28.2333333 0.329333 28.2361111 0.326000 28.2388889 0.318667 28.2416667 0.311333 28.2444444 0.302667 28.2472222 0.293333 28.2500000 0.286000 28.2527778 0.277333 28.2555556 0.273333 28.2583333 0.270667 28.2611111 0.271333 28.2638889 0.279333 28.2666667 0.291333 28.2694444 0.306000 28.2722222 0.324000 28.2750000 0.339333 28.2777778 0.352667 28.2805556 0.360000 28.2833333 0.364000 28.2861111 0.367333 28.2888889 0.366000 28.2916667 0.362000 28.2944444 0.358667 28.2972222 0.358000 28.3000000 0.359333 28.3027778 0.364000 28.3055556 0.365333 28.3083333 0.369333 28.3111111 0.372000 28.3138889 0.374667 28.3166667 0.378000 28.3194444 0.381333 28.3222222 0.381333 28.3250000 0.380000 28.3277778 0.379333 28.3305556 0.374000 28.3333333 0.371333 28.3361111 0.365333 28.3388889 0.358667 28.3416667 0.351333 28.3444444 0.343333 28.3472222 0.337333 28.3500000 0.330667 28.3527778 0.324667 28.3555556 0.320667 28.3583333 0.317333 28.3611111 0.315333 28.3638889 0.315333 28.3666667 0.314667 28.3694444 0.314667 28.3722222 0.319333 28.3750000 0.319333 28.3777778 0.318667 28.3805556 0.320667 28.3833333 0.318000 28.3861111 0.316000 28.3888889 0.315333 28.3916667 0.313333 28.3944444 0.312000 28.3972222 0.312667 28.4000000 0.312000 28.4027778 0.311333 28.4055556 0.314000 28.4083333 0.313333 28.4111111 0.314000 28.4138889 0.313333 28.4166667 0.312000 28.4194444 0.310667 28.4222222 0.307333 28.4250000 0.307333 28.4277778 0.308000 28.4305556 0.310000 28.4333333 0.312000 28.4361111 0.314000 28.4388889 0.313333 28.4416667 0.314667 28.4444444 0.313333 28.4472222 0.312667 28.4500000 0.312000 28.4527778 0.311333 28.4555556 0.308667 28.4583333 0.308000 28.4611111 0.306000 28.4638889 0.306000 28.4666667 0.306667 28.4694444 0.306667 28.4722222 0.307333 28.4750000 0.307333 28.4777778 0.307333 28.4805556 0.304667 28.4833333 0.303333 28.4861111 0.302667 28.4888889 0.301333 28.4916667 0.300667 28.4944444 0.298667 28.4972222 0.300667 28.5000000 0.298000 28.5027778 0.298000 28.5055556 0.298667 28.5083333 0.299333 28.5111111 0.300667 28.5138889 0.299333 28.5166667 0.296667 28.5194444 0.295333 28.5222222 0.294000 28.5250000 0.291333 28.5277778 0.290667 28.5305556 0.289333 28.5333333 0.290000 28.5361111 0.291333 28.5388889 0.292667 28.5416667 0.292000 28.5444444 0.294000 28.5502222 0.300000 31.1525556 0.300000 31.1555556 0.316667 31.1583333 0.315333 31.1611111 0.312667 31.1638889 0.312000 31.1666667 0.312000 31.1694444 0.311333 31.1722222 0.314000 31.1750000 0.316667 31.1777778 0.318000 31.1805556 0.320000 31.1833333 0.318667 31.1861111 0.320000 31.1888889 0.318667 31.1916667 0.318000 31.1944444 0.316667 31.1972222 0.316667 31.2000000 0.316667 31.2027778 0.316667 31.2055556 0.317333 31.2083333 0.318000 31.2111111 0.318000 31.2138889 0.318667 31.2166667 0.317333 31.2194444 0.315333 31.2222222 0.315333 31.2250000 0.312000 31.2277778 0.311333 31.2305556 0.309333 31.2333333 0.307333 31.2361111 0.309333 31.2388889 0.310000 31.2416667 0.312000 31.2444444 0.312667 31.2472222 0.314667 31.2500000 0.313333 31.2527778 0.313333 31.2555556 0.313333 31.2583333 0.313333 31.2611111 0.314000 31.2638889 0.314000 31.2666667 0.312667 31.2694444 0.314667 31.2722222 0.314000 31.2750000 0.315333 31.2777778 0.316667 31.2805556 0.316000 31.2833333 0.318000 31.2861111 0.316667 31.2888889 0.315333 31.2916667 0.315333 31.2944444 0.314667 31.2972222 0.312667 31.3000000 0.313333 31.3027778 0.314667 31.3055556 0.314667 31.3083333 0.315333 31.3111111 0.316667 31.3138889 0.320000 31.3166667 0.320000 31.3194444 0.319333 31.3222222 0.320000 31.3250000 0.320667 31.3277778 0.319333 31.3305556 0.316667 31.3333333 0.316000 31.3361111 0.316000 31.3388889 0.316000 31.3416667 0.317333 31.3444444 0.318000 31.3472222 0.319333 31.3500000 0.320000 31.3527778 0.318667 31.3555556 0.317333 31.3583333 0.316667 31.3611111 0.314000 31.3638889 0.313333 31.3666667 0.313333 31.3694444 0.318000 31.3722222 0.318000 31.3750000 0.320667 31.3777778 0.322667 31.3805556 0.327333 31.3833333 0.327333 31.3861111 0.326667 31.3888889 0.324000 31.3916667 0.316000 31.3944444 0.307333 31.3972222 0.298667 31.4000000 0.288667 31.4027778 0.282667 31.4055556 0.276667 31.4083333 0.269333 31.4111111 0.264667 31.4138889 0.262667 31.4166667 0.266667 31.4194444 0.275333 31.4222222 0.289333 31.4250000 0.302667 31.4277778 0.320000 31.4305556 0.333333 31.4333333 0.342000 31.4361111 0.348000 31.4388889 0.354000 31.4416667 0.355333 31.4444444 0.357333 31.4472222 0.360667 31.4500000 0.363333 31.4527778 0.364667 31.4555556 0.366667 31.4583333 0.370000 31.4611111 0.374667 31.4638889 0.376000 31.4666667 0.378000 31.4694444 0.381333 31.4722222 0.382667 31.4750000 0.384000 31.4777778 0.385333 31.4805556 0.380000 31.4833333 0.374000 31.4861111 0.365333 31.4888889 0.357333 31.4916667 0.348000 31.4944444 0.339333 31.4972222 0.330000 31.5000000 0.324000 31.5027778 0.320000 31.5055556 0.316000 31.5083333 0.314000 31.5111111 0.314000 31.5138889 0.314667 31.5166667 0.313333 31.5194444 0.312000 31.5222222 0.314667 31.5250000 0.312000 31.5277778 0.310667 31.5305556 0.308667 31.5333333 0.308000 31.5361111 0.308000 31.5388889 0.309333 31.5416667 0.310667 31.5444444 0.312000 31.5472222 0.313333 31.5500000 0.313333 31.5527778 0.310667 31.5555556 0.309333 31.5583333 0.307333 31.5611111 0.308000 31.5638889 0.308667 31.5666667 0.309333 31.5694444 0.310000 31.5722222 0.312000 31.5750000 0.312667 31.5777778 0.311333 31.5805556 0.312667 31.5833333 0.310000 31.5861111 0.309333 31.5888889 0.309333 31.5916667 0.308000 31.5944444 0.307333 31.5972222 0.305333 31.6000000 0.306000 31.6027778 0.306667 31.6055556 0.306667 31.6083333 0.307333 31.6111111 0.308000 31.6138889 0.308667 31.6166667 0.306667 31.6194444 0.306000 31.6222222 0.306000 31.6250000 0.302000 31.6277778 0.301333 31.6305556 0.300000 31.6333333 0.301333 31.6361111 0.300667 31.6388889 0.302000 31.6416667 0.301333 31.6444444 0.301333 31.6472222 0.301333 31.6500000 0.301333 31.6527778 0.300000 31.6555556 0.298667 31.6583333 0.296667 31.6611111 0.294667 31.6638889 0.292667 31.6666667 0.292000 31.6694444 0.290667 31.6722222 0.289333 31.6750000 0.289333 31.6777778 0.288667 31.6805556 0.290000 31.6833333 0.290000 31.6861111 0.288000 31.6888889 0.288000 31.6916667 0.284667 31.6944444 0.285333 31.6972222 0.284000 31.7000000 0.284000 31.7027778 0.284000 31.7085556 0.300000 32.3858889 0.300000 32.3888889 0.309333 32.3916667 0.307333 32.3944444 0.306000 32.3972222 0.304667 32.4000000 0.308000 32.4027778 0.308667 32.4055556 0.310667 32.4083333 0.310667 32.4111111 0.312000 32.4138889 0.313333 32.4166667 0.313333 32.4194444 0.310667 32.4222222 0.312000 32.4250000 0.311333 32.4277778 0.310000 32.4305556 0.312000 32.4333333 0.309333 32.4361111 0.309333 32.4388889 0.306667 32.4416667 0.307333 32.4444444 0.306000 32.4472222 0.304667 32.4500000 0.304000 32.4527778 0.305333 32.4555556 0.306667 32.4583333 0.304667 32.4611111 0.302000 32.4638889 0.302000 32.4666667 0.303333 32.4694444 0.303333 32.4722222 0.302000 32.4750000 0.303333 32.4777778 0.304000 32.4805556 0.305333 32.4833333 0.306667 32.4861111 0.308667 32.4888889 0.309333 32.4916667 0.310000 32.4944444 0.309333 32.4972222 0.308000 32.5000000 0.307333 32.5027778 0.308000 32.5055556 0.306667 32.5083333 0.308667 32.5111111 0.309333 32.5138889 0.310000 32.5166667 0.310667 32.5194444 0.310667 32.5222222 0.311333 32.5250000 0.308667 32.5277778 0.308000 32.5305556 0.306667 32.5333333 0.306000 32.5361111 0.306667 32.5388889 0.309333 32.5416667 0.310000 32.5444444 0.312667 32.5472222 0.313333 32.5500000 0.310667 32.5527778 0.308667 32.5555556 0.307333 32.5583333 0.308000 32.5611111 0.307333 32.5638889 0.306000 32.5666667 0.307333 32.5694444 0.308667 32.5722222 0.308667 32.5750000 0.308667 32.5777778 0.309333 32.5805556 0.310000 32.5833333 0.310000 32.5861111 0.310667 32.5888889 0.309333 32.5916667 0.311333 32.5944444 0.310667 32.5972222 0.310000 32.6000000 0.311333 32.6027778 0.310667 32.6055556 0.311333 32.6083333 0.312667 32.6111111 0.316000 32.6138889 0.318000 32.6166667 0.319333 32.6194444 0.320000 32.6222222 0.318667 32.6250000 0.313333 32.6277778 0.307333 32.6305556 0.299333 32.6333333 0.288000 32.6361111 0.274000 32.6388889 0.264000 32.6416667 0.256000 32.6444444 0.249333 32.6472222 0.246667 32.6500000 0.248667 32.6527778 0.258667 32.6555556 0.273333 32.6583333 0.292667 32.6611111 0.310667 32.6638889 0.326667 32.6666667 0.338667 32.6694444 0.344000 32.6722222 0.346000 32.6750000 0.347333 32.6777778 0.349333 32.6805556 0.351333 32.6833333 0.354000 32.6861111 0.356667 32.6888889 0.358000 32.6916667 0.359333 32.6944444 0.362667 32.6972222 0.363333 32.7000000 0.368000 32.7027778 0.371333 32.7055556 0.377333 32.7083333 0.378000 32.7111111 0.378667 32.7138889 0.380667 32.7166667 0.377333 32.7194444 0.372000 32.7222222 0.366000 32.7250000 0.358000 32.7277778 0.350667 32.7305556 0.342667 32.7333333 0.334667 32.7361111 0.327333 32.7388889 0.318667 32.7416667 0.313333 32.7444444 0.308667 32.7472222 0.307333 32.7500000 0.306000 32.7527778 0.304000 32.7555556 0.304667 32.7583333 0.304667 32.7611111 0.304000 32.7638889 0.303333 32.7666667 0.303333 32.7694444 0.302667 32.7722222 0.302000 32.7750000 0.304667 32.7777778 0.303333 32.7805556 0.306000 32.7833333 0.307333 32.7861111 0.307333 32.7888889 0.306000 32.7916667 0.305333 32.7944444 0.304667 32.7972222 0.304000 32.8000000 0.304000 32.8027778 0.304000 32.8055556 0.303333 32.8083333 0.306000 32.8111111 0.304667 32.8138889 0.305333 32.8166667 0.304667 32.8194444 0.303333 32.8222222 0.302667 32.8250000 0.301333 32.8277778 0.302000 32.8305556 0.300000 32.8333333 0.298667 32.8361111 0.299333 32.8388889 0.300000 32.8416667 0.298000 32.8444444 0.298667 32.8472222 0.299333 32.8500000 0.300000 32.8527778 0.299333 32.8555556 0.300667 32.8583333 0.300667 32.8611111 0.299333 32.8638889 0.295333 32.8666667 0.294000 32.8694444 0.294000 32.8722222 0.292000 32.8750000 0.291333 32.8777778 0.293333 32.8805556 0.293333 32.8833333 0.294000 32.8861111 0.294000 32.8888889 0.294667 32.8916667 0.292667 32.8944444 0.289333 32.8972222 0.287333 32.9000000 0.286000 32.9027778 0.285333 32.9055556 0.284667 32.9083333 0.284667 32.9111111 0.284000 32.9138889 0.284000 32.9166667 0.283333 32.9194444 0.283333 32.9222222 0.282667 32.9250000 0.280667 32.9277778 0.279333 32.9305556 0.278667 32.9333333 0.276667 32.9361111 0.278667 32.9418889 0.300000 33.0997778 0.300000 33.1027778 0.300000 33.1055556 0.300000 33.1083333 0.302667 33.1111111 0.304667 33.1138889 0.304667 33.1166667 0.304000 33.1194444 0.302667 33.1222222 0.302667 33.1250000 0.300000 33.1277778 0.300000 33.1305556 0.302000 33.1333333 0.302000 33.1361111 0.302667 33.1388889 0.302667 33.1416667 0.303333 33.1444444 0.304000 33.1472222 0.304000 33.1500000 0.304667 33.1527778 0.303333 33.1555556 0.303333 33.1583333 0.301333 33.1611111 0.300667 33.1638889 0.299333 33.1666667 0.300000 33.1694444 0.300000 33.1722222 0.300000 33.1750000 0.301333 33.1777778 0.302000 33.1805556 0.304000 33.1833333 0.304667 33.1861111 0.303333 33.1888889 0.303333 33.1916667 0.304667 33.1944444 0.304000 33.1972222 0.304000 33.2000000 0.304667 33.2027778 0.304667 33.2055556 0.302667 33.2083333 0.302667 33.2111111 0.301333 33.2138889 0.304000 33.2166667 0.304667 33.2194444 0.304667 33.2222222 0.304000 33.2250000 0.306000 33.2277778 0.304667 33.2305556 0.305333 33.2333333 0.303333 33.2361111 0.304667 33.2388889 0.304000 33.2416667 0.306667 33.2444444 0.308667 33.2472222 0.310667 33.2500000 0.311333 33.2527778 0.310000 33.2555556 0.309333 33.2583333 0.308000 33.2611111 0.305333 33.2638889 0.306667 33.2666667 0.306667 33.2694444 0.307333 33.2722222 0.309333 33.2750000 0.310000 33.2777778 0.310000 33.2805556 0.311333 33.2833333 0.310667 33.2861111 0.311333 33.2888889 0.310667 33.2916667 0.309333 33.2944444 0.308667 33.2972222 0.306667 33.3000000 0.306000 33.3027778 0.309333 33.3055556 0.308000 33.3083333 0.309333 33.3111111 0.310000 33.3138889 0.312000 33.3166667 0.313333 33.3194444 0.311333 33.3222222 0.313333 33.3250000 0.312000 33.3277778 0.311333 33.3305556 0.312667 33.3333333 0.312667 33.3361111 0.314000 33.3388889 0.312667 33.3416667 0.309333 33.3444444 0.304000 33.3472222 0.296000 33.3500000 0.283333 33.3527778 0.272667 33.3555556 0.263333 33.3583333 0.255333 33.3611111 0.252000 33.3638889 0.253333 33.3666667 0.258667 33.3694444 0.269333 33.3722222 0.284000 33.3750000 0.299333 33.3777778 0.317333 33.3805556 0.331333 33.3833333 0.338667 33.3861111 0.342667 33.3888889 0.342667 33.3916667 0.342667 33.3944444 0.340667 33.3972222 0.340667 33.4000000 0.342000 33.4027778 0.346000 33.4055556 0.349333 33.4083333 0.354000 33.4111111 0.357333 33.4138889 0.359333 33.4166667 0.361333 33.4194444 0.362000 33.4222222 0.364000 33.4250000 0.366000 33.4277778 0.366000 33.4305556 0.368000 33.4333333 0.364667 33.4361111 0.360000 33.4388889 0.356000 33.4416667 0.352000 33.4444444 0.345333 33.4472222 0.340000 33.4500000 0.331333 33.4527778 0.322000 33.4555556 0.314667 33.4583333 0.308000 33.4611111 0.302667 33.4638889 0.299333 33.4666667 0.296667 33.4694444 0.297333 33.4722222 0.298000 33.4750000 0.301333 33.4777778 0.303333 33.4805556 0.304667 33.4833333 0.304000 33.4861111 0.304667 33.4888889 0.303333 33.4916667 0.302000 33.4944444 0.300000 33.4972222 0.299333 33.5000000 0.297333 33.5027778 0.298667 33.5055556 0.298667 33.5083333 0.300667 33.5111111 0.302667 33.5138889 0.302000 33.5166667 0.302000 33.5194444 0.301333 33.5222222 0.300000 33.5250000 0.299333 33.5277778 0.298667 33.5305556 0.298667 33.5333333 0.296667 33.5361111 0.298000 33.5388889 0.298667 33.5416667 0.297333 33.5444444 0.296000 33.5472222 0.297333 33.5500000 0.297333 33.5527778 0.296667 33.5555556 0.297333 33.5583333 0.296000 33.5611111 0.294667 33.5638889 0.294667 33.5666667 0.292667 33.5694444 0.292667 33.5722222 0.293333 33.5750000 0.296000 33.5777778 0.296667 33.5805556 0.296667 33.5833333 0.295333 33.5861111 0.293333 33.5888889 0.293333 33.5916667 0.291333 33.5944444 0.290000 33.5972222 0.288000 33.6000000 0.286667 33.6027778 0.288667 33.6055556 0.288000 33.6083333 0.288667 33.6111111 0.288000 33.6138889 0.286667 33.6166667 0.286000 33.6194444 0.283333 33.6222222 0.282667 33.6250000 0.280667 33.6277778 0.280000 33.6305556 0.278667 33.6333333 0.278000 33.6361111 0.279333 33.6388889 0.278000 33.6416667 0.280000 33.6444444 0.278667 33.6472222 0.280667 33.6500000 0.280000 33.6557778 0.300000 33.8608889 0.300000 33.8638889 0.304667 33.8666667 0.303333 33.8694444 0.304000 33.8722222 0.304667 33.8750000 0.308000 33.8777778 0.308667 33.8805556 0.309333 33.8833333 0.310667 33.8861111 0.310000 33.8888889 0.307333 33.8916667 0.305333 33.8944444 0.303333 33.8972222 0.305333 33.9000000 0.306667 33.9027778 0.308667 33.9055556 0.310000 33.9083333 0.312000 33.9111111 0.312000 33.9138889 0.311333 33.9166667 0.310667 33.9194444 0.309333 33.9222222 0.311333 33.9250000 0.309333 33.9277778 0.310667 33.9305556 0.308667 33.9333333 0.308000 33.9361111 0.306667 33.9388889 0.306667 33.9416667 0.306667 33.9444444 0.308667 33.9472222 0.312000 33.9500000 0.312667 33.9527778 0.312667 33.9555556 0.313333 33.9583333 0.312667 33.9611111 0.311333 33.9638889 0.312667 33.9666667 0.313333 33.9694444 0.316000 33.9722222 0.314667 33.9750000 0.317333 33.9777778 0.318000 33.9805556 0.320000 33.9833333 0.320000 33.9861111 0.319333 33.9888889 0.318000 33.9916667 0.317333 33.9944444 0.317333 33.9972222 0.315333 34.0000000 0.314667 34.0027778 0.314667 34.0055556 0.315333 34.0083333 0.316667 34.0111111 0.317333 34.0138889 0.317333 34.0166667 0.320667 34.0194444 0.321333 34.0222222 0.320667 34.0250000 0.318667 34.0277778 0.318000 34.0305556 0.316000 34.0333333 0.314667 34.0361111 0.316000 34.0388889 0.317333 34.0416667 0.318667 34.0444444 0.320667 34.0472222 0.320000 34.0500000 0.318667 34.0527778 0.316667 34.0555556 0.314667 34.0583333 0.313333 34.0611111 0.312667 34.0638889 0.311333 34.0666667 0.312667 34.0694444 0.314667 34.0722222 0.315333 34.0750000 0.316000 34.0777778 0.317333 34.0805556 0.316667 34.0833333 0.316000 34.0861111 0.316667 34.0888889 0.318000 34.0916667 0.321333 34.0944444 0.322667 34.0972222 0.324000 34.1000000 0.320000 34.1027778 0.315333 34.1055556 0.307333 34.1083333 0.295333 34.1111111 0.286667 34.1138889 0.276000 34.1166667 0.268667 34.1194444 0.262000 34.1222222 0.259333 34.1250000 0.263333 34.1277778 0.272000 34.1305556 0.282667 34.1333333 0.296000 34.1361111 0.310667 34.1388889 0.327333 34.1416667 0.338667 34.1444444 0.346667 34.1472222 0.350667 34.1500000 0.352667 34.1527778 0.352667 34.1555556 0.352000 34.1583333 0.350667 34.1611111 0.352000 34.1638889 0.351333 34.1666667 0.354667 34.1694444 0.358000 34.1722222 0.360667 34.1750000 0.365333 34.1777778 0.368667 34.1805556 0.372000 34.1833333 0.374000 34.1861111 0.374667 34.1888889 0.374667 34.1916667 0.376000 34.1944444 0.371333 34.1972222 0.368000 34.2000000 0.362000 34.2027778 0.357333 34.2055556 0.349333 34.2083333 0.342667 34.2111111 0.335333 34.2138889 0.330000 34.2166667 0.323333 34.2194444 0.320000 34.2222222 0.314000 34.2250000 0.310000 34.2277778 0.307333 34.2305556 0.307333 34.2333333 0.306000 34.2361111 0.306667 34.2388889 0.308000 34.2416667 0.310000 34.2444444 0.310000 34.2472222 0.310667 34.2500000 0.310667 34.2527778 0.310000 34.2555556 0.308667 34.2583333 0.309333 34.2611111 0.308000 34.2638889 0.308667 34.2666667 0.308667 34.2694444 0.308000 34.2722222 0.310000 34.2750000 0.310667 34.2777778 0.311333 34.2805556 0.312000 34.2833333 0.311333 34.2861111 0.310667 34.2888889 0.310000 34.2916667 0.307333 34.2944444 0.305333 34.2972222 0.303333 34.3000000 0.302667 34.3027778 0.302000 34.3055556 0.302000 34.3083333 0.304667 34.3111111 0.306667 34.3138889 0.306667 34.3166667 0.306667 34.3194444 0.304667 34.3222222 0.302000 34.3250000 0.302667 34.3277778 0.300667 34.3305556 0.300000 34.3333333 0.299333 34.3361111 0.299333 34.3388889 0.299333 34.3416667 0.297333 34.3444444 0.296667 34.3472222 0.296000 34.3500000 0.297333 34.3527778 0.296000 34.3555556 0.294667 34.3583333 0.293333 34.3611111 0.289333 34.3638889 0.288667 34.3666667 0.286667 34.3694444 0.286667 34.3722222 0.286667 34.3750000 0.287333 34.3777778 0.288000 34.3805556 0.289333 34.3833333 0.288000 34.3861111 0.286000 34.3888889 0.282667 34.3916667 0.282000 34.3944444 0.280667 34.3972222 0.279333 34.4000000 0.281333 34.4027778 0.282000 34.4055556 0.282000 34.4083333 0.282000 34.4111111 0.281333 34.4168889 0.300000 34.5886667 0.300000 34.5916667 0.314000 34.5944444 0.311333 34.5972222 0.308667 34.6000000 0.308667 34.6027778 0.308000 34.6055556 0.308667 34.6083333 0.311333 34.6111111 0.312667 34.6138889 0.316000 34.6166667 0.314000 34.6194444 0.314667 34.6222222 0.315333 34.6250000 0.312667 34.6277778 0.315333 34.6305556 0.314667 34.6333333 0.314667 34.6361111 0.315333 34.6388889 0.315333 34.6416667 0.316000 34.6444444 0.314667 34.6472222 0.316000 34.6500000 0.316667 34.6527778 0.315333 34.6555556 0.313333 34.6583333 0.312000 34.6611111 0.311333 34.6638889 0.311333 34.6666667 0.310667 34.6694444 0.311333 34.6722222 0.310000 34.6750000 0.312667 34.6777778 0.312667 34.6805556 0.315333 34.6833333 0.316667 34.6861111 0.318667 34.6888889 0.316667 34.6916667 0.316667 34.6944444 0.314000 34.6972222 0.314000 34.7000000 0.313333 34.7027778 0.313333 34.7055556 0.316000 34.7083333 0.316667 34.7111111 0.316667 34.7138889 0.318667 34.7166667 0.320000 34.7194444 0.321333 34.7222222 0.320667 34.7250000 0.318000 34.7277778 0.316000 34.7305556 0.314000 34.7333333 0.313333 34.7361111 0.313333 34.7388889 0.316000 34.7416667 0.318000 34.7444444 0.319333 34.7472222 0.320000 34.7500000 0.320000 34.7527778 0.320667 34.7555556 0.320000 34.7583333 0.320000 34.7611111 0.318667 34.7638889 0.319333 34.7666667 0.319333 34.7694444 0.320000 34.7722222 0.319333 34.7750000 0.320000 34.7777778 0.319333 34.7805556 0.317333 34.7833333 0.318667 34.7861111 0.317333 34.7888889 0.318667 34.7916667 0.318000 34.7944444 0.318000 34.7972222 0.316000 34.8000000 0.316667 34.8027778 0.316667 34.8055556 0.316667 34.8083333 0.320000 34.8111111 0.322000 34.8138889 0.325333 34.8166667 0.325333 34.8194444 0.326667 34.8222222 0.325333 34.8250000 0.327333 34.8277778 0.324000 34.8305556 0.320000 34.8333333 0.314000 34.8361111 0.306667 34.8388889 0.296667 34.8416667 0.288000 34.8444444 0.278667 34.8472222 0.272000 34.8500000 0.266000 34.8527778 0.262000 34.8555556 0.264000 34.8583333 0.268000 34.8611111 0.277333 34.8638889 0.290000 34.8666667 0.308000 34.8694444 0.323333 34.8722222 0.336000 34.8750000 0.346667 34.8777778 0.353333 34.8805556 0.356667 34.8833333 0.357333 34.8861111 0.356667 34.8888889 0.356000 34.8916667 0.355333 34.8944444 0.358000 34.8972222 0.360000 34.9000000 0.362000 34.9027778 0.364667 34.9055556 0.368000 34.9083333 0.371333 34.9111111 0.376667 34.9138889 0.378667 34.9166667 0.383333 34.9194444 0.380667 34.9222222 0.378000 34.9250000 0.371333 34.9277778 0.364667 34.9305556 0.357333 34.9333333 0.348667 34.9361111 0.340667 34.9388889 0.333333 34.9416667 0.326667 34.9444444 0.320667 34.9472222 0.317333 34.9500000 0.314000 34.9527778 0.313333 34.9555556 0.314667 34.9583333 0.312667 34.9611111 0.312667 34.9638889 0.313333 34.9666667 0.312667 34.9694444 0.310667 34.9722222 0.310667 34.9750000 0.309333 34.9777778 0.310667 34.9805556 0.312000 34.9833333 0.312000 34.9861111 0.314000 34.9888889 0.312000 34.9916667 0.309333 34.9944444 0.310000 34.9972222 0.310000 35.0000000 0.310000 35.0027778 0.310667 35.0055556 0.310000 35.0083333 0.311333 35.0111111 0.311333 35.0138889 0.312000 35.0166667 0.311333 35.0194444 0.312667 35.0222222 0.312667 35.0250000 0.311333 35.0277778 0.310000 35.0305556 0.310000 35.0333333 0.308000 35.0361111 0.308667 35.0388889 0.308667 35.0416667 0.310000 35.0444444 0.308667 35.0472222 0.310000 35.0500000 0.309333 35.0527778 0.307333 35.0555556 0.306000 35.0583333 0.304667 35.0611111 0.304667 35.0638889 0.304000 35.0666667 0.302667 35.0694444 0.302000 35.0722222 0.304000 35.0750000 0.301333 35.0777778 0.302667 35.0805556 0.302000 35.0833333 0.302667 35.0861111 0.302000 35.0888889 0.300667 35.0916667 0.298000 35.0944444 0.298667 35.0972222 0.295333 35.1000000 0.294667 35.1027778 0.293333 35.1055556 0.290667 35.1083333 0.290000 35.1111111 0.290667 35.1138889 0.290000 35.1166667 0.290667 35.1194444 0.290667 35.1222222 0.290667 35.1250000 0.290000 35.1277778 0.287333 35.1305556 0.287333 35.1333333 0.289333 35.1361111 0.288667 35.1388889 0.290000 35.1446667 0.300000 35.3192222 0.300000 35.3222222 0.318667 35.3250000 0.316000 35.3277778 0.315333 35.3305556 0.314000 35.3333333 0.314667 35.3361111 0.316667 35.3388889 0.316667 35.3416667 0.319333 35.3444444 0.318000 35.3472222 0.318667 35.3500000 0.319333 35.3527778 0.318000 35.3555556 0.318000 35.3583333 0.318667 35.3611111 0.318000 35.3638889 0.318000 35.3666667 0.319333 35.3694444 0.317333 35.3722222 0.317333 35.3750000 0.317333 35.3777778 0.318667 35.3805556 0.317333 35.3833333 0.320000 35.3861111 0.319333 35.3888889 0.318000 35.3916667 0.318000 35.3944444 0.316000 35.3972222 0.314667 35.4000000 0.315333 35.4027778 0.315333 35.4055556 0.316667 35.4083333 0.319333 35.4111111 0.320000 35.4138889 0.322000 35.4166667 0.323333 35.4194444 0.320667 35.4222222 0.320667 35.4250000 0.320667 35.4277778 0.320000 35.4305556 0.321333 35.4333333 0.320667 35.4361111 0.323333 35.4388889 0.324667 35.4416667 0.326667 35.4444444 0.326667 35.4472222 0.326000 35.4500000 0.326667 35.4527778 0.326000 35.4555556 0.325333 35.4583333 0.323333 35.4611111 0.324667 35.4638889 0.322000 35.4666667 0.322667 35.4694444 0.322667 35.4722222 0.322000 35.4750000 0.323333 35.4777778 0.324667 35.4805556 0.325333 35.4833333 0.326000 35.4861111 0.326000 35.4888889 0.324000 35.4916667 0.324667 35.4944444 0.323333 35.4972222 0.324667 35.5000000 0.324000 35.5027778 0.324000 35.5055556 0.324000 35.5083333 0.324667 35.5111111 0.323333 35.5138889 0.324667 35.5166667 0.324000 35.5194444 0.323333 35.5222222 0.324667 35.5250000 0.323333 35.5277778 0.321333 35.5305556 0.320667 35.5333333 0.322667 35.5361111 0.320667 35.5388889 0.323333 35.5416667 0.324667 35.5444444 0.327333 35.5472222 0.329333 35.5500000 0.333333 35.5527778 0.332000 35.5555556 0.333333 35.5583333 0.330667 35.5611111 0.326667 35.5638889 0.317333 35.5666667 0.306000 35.5694444 0.295333 35.5722222 0.285333 35.5750000 0.275333 35.5777778 0.268000 35.5805556 0.264000 35.5833333 0.265333 35.5861111 0.268667 35.5888889 0.280667 35.5916667 0.292667 35.5944444 0.309333 35.5972222 0.327333 35.6000000 0.342000 35.6027778 0.351333 35.6055556 0.359333 35.6083333 0.360667 35.6111111 0.361333 35.6138889 0.362667 35.6166667 0.363333 35.6194444 0.363333 35.6222222 0.365333 35.6250000 0.368667 35.6277778 0.370000 35.6305556 0.372667 35.6333333 0.375333 35.6361111 0.376667 35.6388889 0.381333 35.6416667 0.384000 35.6444444 0.386667 35.6472222 0.388667 35.6500000 0.387333 35.6527778 0.382000 35.6555556 0.378000 35.6583333 0.370000 35.6611111 0.364000 35.6638889 0.357333 35.6666667 0.348000 35.6694444 0.342000 35.6722222 0.334667 35.6750000 0.330000 35.6777778 0.326000 35.6805556 0.320667 35.6833333 0.322000 35.6861111 0.319333 35.6888889 0.317333 35.6916667 0.316667 35.6944444 0.316000 35.6972222 0.316667 35.7000000 0.318000 35.7027778 0.317333 35.7055556 0.316667 35.7083333 0.316667 35.7111111 0.316000 35.7138889 0.316000 35.7166667 0.316667 35.7194444 0.317333 35.7222222 0.318000 35.7250000 0.317333 35.7277778 0.314667 35.7305556 0.314000 35.7333333 0.313333 35.7361111 0.314000 35.7388889 0.314667 35.7416667 0.314667 35.7444444 0.315333 35.7472222 0.315333 35.7500000 0.315333 35.7527778 0.314667 35.7555556 0.312667 35.7583333 0.312000 35.7611111 0.309333 35.7638889 0.309333 35.7666667 0.309333 35.7694444 0.308667 35.7722222 0.308000 35.7750000 0.308000 35.7777778 0.309333 35.7805556 0.308667 35.7833333 0.306667 35.7861111 0.305333 35.7888889 0.306000 35.7916667 0.304667 35.7944444 0.304000 35.7972222 0.302667 35.8000000 0.301333 35.8027778 0.302000 35.8055556 0.300000 35.8083333 0.302000 35.8111111 0.300667 35.8138889 0.300667 35.8166667 0.300000 35.8194444 0.299333 35.8222222 0.299333 35.8250000 0.295333 35.8277778 0.294667 35.8305556 0.293333 35.8333333 0.291333 35.8361111 0.290667 35.8388889 0.291333 35.8416667 0.291333 35.8444444 0.290667 35.8472222 0.290000 35.8500000 0.290667 35.8527778 0.290000 35.8555556 0.288000 35.8583333 0.288667 35.8611111 0.288667 35.8638889 0.288000 35.8666667 0.288667 35.8694444 0.289333 35.8752222 0.300000 36.0525556 0.300000 36.0555556 0.316667 36.0583333 0.313333 36.0611111 0.310667 36.0638889 0.310667 36.0666667 0.311333 36.0694444 0.314000 36.0722222 0.314667 36.0750000 0.316000 36.0777778 0.316667 36.0805556 0.319333 36.0833333 0.319333 36.0861111 0.319333 36.0888889 0.318667 36.0916667 0.316000 36.0944444 0.314667 36.0972222 0.314000 36.1000000 0.312667 36.1027778 0.312667 36.1055556 0.314667 36.1083333 0.315333 36.1111111 0.316000 36.1138889 0.318000 36.1166667 0.318000 36.1194444 0.318000 36.1222222 0.315333 36.1250000 0.313333 36.1277778 0.312667 36.1305556 0.310667 36.1333333 0.312000 36.1361111 0.312000 36.1388889 0.314000 36.1416667 0.316000 36.1444444 0.318000 36.1472222 0.319333 36.1500000 0.320000 36.1527778 0.320000 36.1555556 0.321333 36.1583333 0.321333 36.1611111 0.322667 36.1638889 0.322000 36.1666667 0.322000 36.1694444 0.321333 36.1722222 0.320667 36.1750000 0.321333 36.1777778 0.321333 36.1805556 0.322667 36.1833333 0.323333 36.1861111 0.324667 36.1888889 0.323333 36.1916667 0.321333 36.1944444 0.320667 36.1972222 0.320000 36.2000000 0.320000 36.2027778 0.321333 36.2055556 0.321333 36.2083333 0.324000 36.2111111 0.324667 36.2138889 0.325333 36.2166667 0.326000 36.2194444 0.326000 36.2222222 0.325333 36.2250000 0.324000 36.2277778 0.323333 36.2305556 0.320667 36.2333333 0.321333 36.2361111 0.320000 36.2388889 0.320667 36.2416667 0.321333 36.2444444 0.322000 36.2472222 0.322000 36.2500000 0.322667 36.2527778 0.323333 36.2555556 0.322000 36.2583333 0.322000 36.2611111 0.320667 36.2638889 0.320667 36.2666667 0.321333 36.2694444 0.322000 36.2722222 0.322667 36.2750000 0.324000 36.2777778 0.327333 36.2805556 0.329333 36.2833333 0.331333 36.2861111 0.332667 36.2888889 0.332667 36.2916667 0.331333 36.2944444 0.327333 36.2972222 0.317333 36.3000000 0.306667 36.3027778 0.294000 36.3055556 0.280667 36.3083333 0.270667 36.3111111 0.262667 36.3138889 0.259333 36.3166667 0.260667 36.3194444 0.268000 36.3222222 0.282667 36.3250000 0.300000 36.3277778 0.322000 36.3305556 0.339333 36.3333333 0.354000 36.3361111 0.361333 36.3388889 0.364000 36.3416667 0.363333 36.3444444 0.362000 36.3472222 0.361333 36.3500000 0.363333 36.3527778 0.366000 36.3555556 0.370667 36.3583333 0.373333 36.3611111 0.374667 36.3638889 0.375333 36.3666667 0.378667 36.3694444 0.381333 36.3722222 0.384667 36.3750000 0.386000 36.3777778 0.385333 36.3805556 0.383333 36.3833333 0.378667 36.3861111 0.372667 36.3888889 0.361333 36.3916667 0.351333 36.3944444 0.341333 36.3972222 0.330667 36.4000000 0.324667 36.4027778 0.319333 36.4055556 0.315333 36.4083333 0.314000 36.4111111 0.312667 36.4138889 0.312667 36.4166667 0.312667 36.4194444 0.312667 36.4222222 0.312000 36.4250000 0.310000 36.4277778 0.310667 36.4305556 0.308667 36.4333333 0.308667 36.4361111 0.307333 36.4388889 0.308667 36.4416667 0.309333 36.4444444 0.311333 36.4472222 0.311333 36.4500000 0.312000 36.4527778 0.311333 36.4555556 0.312667 36.4583333 0.312000 36.4611111 0.310000 36.4638889 0.308000 36.4666667 0.307333 36.4694444 0.306000 36.4722222 0.306667 36.4750000 0.308667 36.4777778 0.309333 36.4805556 0.311333 36.4833333 0.311333 36.4861111 0.312000 36.4888889 0.310667 36.4916667 0.307333 36.4944444 0.306667 36.4972222 0.304667 36.5000000 0.304667 36.5027778 0.303333 36.5055556 0.304000 36.5083333 0.304667 36.5111111 0.304667 36.5138889 0.304667 36.5166667 0.303333 36.5194444 0.303333 36.5222222 0.305333 36.5250000 0.304667 36.5277778 0.302667 36.5305556 0.300000 36.5333333 0.298667 36.5361111 0.298000 36.5388889 0.297333 36.5416667 0.299333 36.5444444 0.298000 36.5472222 0.298667 36.5500000 0.298000 36.5527778 0.296000 36.5555556 0.295333 36.5583333 0.291333 36.5611111 0.289333 36.5638889 0.290000 36.5666667 0.288000 36.5694444 0.287333 36.5722222 0.288000 36.5750000 0.290667 36.5777778 0.288667 36.5805556 0.289333 36.5833333 0.288667 36.5861111 0.286667 36.5888889 0.286667 36.5916667 0.284667 36.5944444 0.284000 36.5972222 0.284667 36.6000000 0.282667 36.6027778 0.284000 36.6085556 0.300000 36.7997778 0.300000 36.8027778 0.311333 36.8055556 0.313333 36.8083333 0.313333 36.8111111 0.313333 36.8138889 0.312667 36.8166667 0.315333 36.8194444 0.315333 36.8222222 0.315333 36.8250000 0.314667 36.8277778 0.316667 36.8305556 0.316000 36.8333333 0.314000 36.8361111 0.314667 36.8388889 0.318000 36.8416667 0.318000 36.8444444 0.318667 36.8472222 0.318000 36.8500000 0.318000 36.8527778 0.318667 36.8555556 0.318000 36.8583333 0.316000 36.8611111 0.314000 36.8638889 0.316000 36.8666667 0.313333 36.8694444 0.312000 36.8722222 0.314000 36.8750000 0.314667 36.8777778 0.315333 36.8805556 0.315333 36.8833333 0.316667 36.8861111 0.317333 36.8888889 0.316667 36.8916667 0.315333 36.8944444 0.315333 36.8972222 0.316667 36.9000000 0.316667 36.9027778 0.318667 36.9055556 0.320000 36.9083333 0.321333 36.9111111 0.323333 36.9138889 0.324000 36.9166667 0.324000 36.9194444 0.321333 36.9222222 0.322000 36.9250000 0.320667 36.9277778 0.320000 36.9305556 0.319333 36.9333333 0.320667 36.9361111 0.321333 36.9388889 0.322667 36.9416667 0.322000 36.9444444 0.321333 36.9472222 0.323333 36.9500000 0.325333 36.9527778 0.324667 36.9555556 0.325333 36.9583333 0.324000 36.9611111 0.323333 36.9638889 0.321333 36.9666667 0.320000 36.9694444 0.320667 36.9722222 0.322000 36.9750000 0.322667 36.9777778 0.324000 36.9805556 0.324667 36.9833333 0.324000 36.9861111 0.322667 36.9888889 0.322000 36.9916667 0.321333 36.9944444 0.320667 36.9972222 0.320667 37.0000000 0.321333 37.0027778 0.321333 37.0055556 0.322000 37.0083333 0.320667 37.0111111 0.321333 37.0138889 0.322667 37.0166667 0.322000 37.0194444 0.322000 37.0222222 0.322667 37.0250000 0.322667 37.0277778 0.324000 37.0305556 0.325333 37.0333333 0.326667 37.0361111 0.328667 37.0388889 0.330000 37.0416667 0.328000 37.0444444 0.323333 37.0472222 0.314000 37.0500000 0.304000 37.0527778 0.290667 37.0555556 0.280000 37.0583333 0.267333 37.0611111 0.257333 37.0638889 0.253333 37.0666667 0.258000 37.0694444 0.265333 37.0722222 0.280667 37.0750000 0.297333 37.0777778 0.316667 37.0805556 0.334000 37.0833333 0.348667 37.0861111 0.356000 37.0888889 0.358667 37.0916667 0.360000 37.0944444 0.358667 37.0972222 0.358667 37.1000000 0.358000 37.1027778 0.360000 37.1055556 0.362667 37.1083333 0.368667 37.1111111 0.370667 37.1138889 0.375333 37.1166667 0.377333 37.1194444 0.379333 37.1222222 0.380000 37.1250000 0.382000 37.1277778 0.384000 37.1305556 0.383333 37.1333333 0.383333 37.1361111 0.380667 37.1388889 0.374000 37.1416667 0.365333 37.1444444 0.356000 37.1472222 0.346000 37.1500000 0.334667 37.1527778 0.327333 37.1555556 0.322000 37.1583333 0.314667 37.1611111 0.310667 37.1638889 0.312000 37.1666667 0.310000 37.1694444 0.311333 37.1722222 0.312667 37.1750000 0.311333 37.1777778 0.312000 37.1805556 0.312000 37.1833333 0.312667 37.1861111 0.312000 37.1888889 0.310000 37.1916667 0.310000 37.1944444 0.308000 37.1972222 0.308000 37.2000000 0.306667 37.2027778 0.307333 37.2055556 0.308667 37.2083333 0.310000 37.2111111 0.311333 37.2138889 0.310667 37.2166667 0.312000 37.2194444 0.310667 37.2222222 0.309333 37.2250000 0.308667 37.2277778 0.308000 37.2305556 0.307333 37.2333333 0.309333 37.2361111 0.309333 37.2388889 0.308667 37.2416667 0.310667 37.2444444 0.310000 37.2472222 0.309333 37.2500000 0.308000 37.2527778 0.305333 37.2555556 0.306000 37.2583333 0.304667 37.2611111 0.305333 37.2638889 0.302667 37.2666667 0.302000 37.2694444 0.301333 37.2722222 0.302000 37.2750000 0.303333 37.2777778 0.304000 37.2805556 0.302667 37.2833333 0.304667 37.2861111 0.304000 37.2888889 0.304667 37.2916667 0.300000 37.2944444 0.298000 37.2972222 0.296000 37.3000000 0.295333 37.3027778 0.292000 37.3055556 0.292667 37.3083333 0.292667 37.3111111 0.294000 37.3138889 0.293333 37.3166667 0.293333 37.3194444 0.292000 37.3222222 0.291333 37.3250000 0.289333 37.3277778 0.286667 37.3305556 0.284667 37.3333333 0.284000 37.3361111 0.284667 37.3388889 0.284667 37.3416667 0.285333 37.3444444 0.286000 37.3472222 0.284000 37.3500000 0.284667 37.3557778 0.300000 38.5497778 0.300000 38.5527778 0.306667 38.5555556 0.308000 38.5583333 0.306667 38.5611111 0.306667 38.5638889 0.304000 38.5666667 0.302667 38.5694444 0.304000 38.5722222 0.304000 38.5750000 0.304667 38.5777778 0.308667 38.5805556 0.308667 38.5833333 0.311333 38.5861111 0.309333 38.5888889 0.309333 38.5916667 0.308000 38.5944444 0.307333 38.5972222 0.306667 38.6000000 0.306000 38.6027778 0.307333 38.6055556 0.307333 38.6083333 0.306000 38.6111111 0.306000 38.6138889 0.305333 38.6166667 0.304667 38.6194444 0.304667 38.6222222 0.302667 38.6250000 0.304000 38.6277778 0.302667 38.6305556 0.299333 38.6333333 0.300667 38.6361111 0.300667 38.6388889 0.300000 38.6416667 0.302000 38.6444444 0.304000 38.6472222 0.306667 38.6500000 0.307333 38.6527778 0.306667 38.6555556 0.304000 38.6583333 0.302667 38.6611111 0.300000 38.6638889 0.298000 38.6666667 0.299333 38.6694444 0.300667 38.6722222 0.304667 38.6750000 0.304000 38.6777778 0.306000 38.6805556 0.306000 38.6833333 0.304667 38.6861111 0.306000 38.6888889 0.306000 38.6916667 0.306000 38.6944444 0.306667 38.6972222 0.306000 38.7000000 0.303333 38.7027778 0.305333 38.7055556 0.306000 38.7083333 0.306667 38.7111111 0.307333 38.7138889 0.308667 38.7166667 0.308667 38.7194444 0.306000 38.7222222 0.306667 38.7250000 0.304667 38.7277778 0.304000 38.7305556 0.300667 38.7333333 0.305333 38.7361111 0.306000 38.7388889 0.308000 38.7416667 0.308000 38.7444444 0.308000 38.7472222 0.308667 38.7500000 0.308000 38.7527778 0.307333 38.7555556 0.308667 38.7583333 0.308000 38.7611111 0.306000 38.7638889 0.304000 38.7666667 0.301333 38.7694444 0.302000 38.7722222 0.306667 38.7750000 0.306667 38.7777778 0.310000 38.7805556 0.314667 38.7833333 0.314667 38.7861111 0.314000 38.7888889 0.311333 38.7916667 0.306667 38.7944444 0.300000 38.7972222 0.288667 38.8000000 0.280000 38.8027778 0.272000 38.8055556 0.264667 38.8083333 0.258667 38.8111111 0.257333 38.8138889 0.259333 38.8166667 0.268000 38.8194444 0.278000 38.8222222 0.293333 38.8250000 0.308000 38.8277778 0.318667 38.8305556 0.329333 38.8333333 0.332667 38.8361111 0.334667 38.8388889 0.336000 38.8416667 0.336000 38.8444444 0.338000 38.8472222 0.341333 38.8500000 0.344000 38.8527778 0.348667 38.8555556 0.352667 38.8583333 0.354667 38.8611111 0.354667 38.8638889 0.360000 38.8666667 0.360000 38.8694444 0.360667 38.8722222 0.366000 38.8750000 0.367333 38.8777778 0.366667 38.8805556 0.366667 38.8833333 0.363333 38.8861111 0.356667 38.8888889 0.348667 38.8916667 0.340667 38.8944444 0.332000 38.8972222 0.323333 38.9000000 0.316000 38.9027778 0.310667 38.9055556 0.309333 38.9083333 0.306667 38.9111111 0.305333 38.9138889 0.306000 38.9166667 0.305333 38.9194444 0.304000 38.9222222 0.302667 38.9250000 0.302667 38.9277778 0.302667 38.9305556 0.302000 38.9333333 0.304000 38.9361111 0.304667 38.9388889 0.304667 38.9416667 0.304667 38.9444444 0.305333 38.9472222 0.305333 38.9500000 0.305333 38.9527778 0.305333 38.9555556 0.304667 38.9583333 0.301333 38.9611111 0.302000 38.9638889 0.301333 38.9666667 0.300000 38.9694444 0.302000 38.9722222 0.301333 38.9750000 0.303333 38.9777778 0.302667 38.9805556 0.304667 38.9833333 0.305333 38.9861111 0.304000 38.9888889 0.301333 38.9916667 0.300667 38.9944444 0.298667 38.9972222 0.299333 39.0000000 0.296667 39.0027778 0.298000 39.0055556 0.298000 39.0083333 0.296000 39.0111111 0.298000 39.0138889 0.298000 39.0166667 0.296000 39.0194444 0.298000 39.0222222 0.297333 39.0250000 0.296667 39.0277778 0.296000 39.0305556 0.294000 39.0333333 0.292000 39.0361111 0.291333 39.0388889 0.290667 39.0416667 0.290000 39.0444444 0.290000 39.0472222 0.288667 39.0500000 0.288667 39.0527778 0.288000 39.0555556 0.285333 39.0583333 0.285333 39.0611111 0.282667 39.0638889 0.280667 39.0666667 0.281333 39.0694444 0.281333 39.0722222 0.282667 39.0750000 0.282000 39.0777778 0.284667 39.0805556 0.284000 39.0833333 0.284000 39.0861111 0.283333 39.0888889 0.282667 39.0916667 0.281333 39.0944444 0.280667 39.0972222 0.280000 39.1000000 0.280667 39.1057778 0.300000 39.2164444 0.300000 39.2194444 0.306667 39.2222222 0.306667 39.2250000 0.302000 39.2277778 0.302000 39.2305556 0.300667 39.2333333 0.302667 39.2361111 0.303333 39.2388889 0.304000 39.2416667 0.306000 39.2444444 0.308667 39.2472222 0.308000 39.2500000 0.308000 39.2527778 0.308000 39.2555556 0.308000 39.2583333 0.308000 39.2611111 0.308000 39.2638889 0.306667 39.2666667 0.306000 39.2694444 0.304667 39.2722222 0.305333 39.2750000 0.306667 39.2777778 0.308000 39.2805556 0.310000 39.2833333 0.310000 39.2861111 0.308667 39.2888889 0.307333 39.2916667 0.306000 39.2944444 0.306000 39.2972222 0.305333 39.3000000 0.306667 39.3027778 0.306667 39.3055556 0.307333 39.3083333 0.311333 39.3111111 0.310000 39.3138889 0.312667 39.3166667 0.313333 39.3194444 0.311333 39.3222222 0.310667 39.3250000 0.311333 39.3277778 0.310000 39.3305556 0.310667 39.3333333 0.312000 39.3361111 0.313333 39.3388889 0.314000 39.3416667 0.314667 39.3444444 0.315333 39.3472222 0.316000 39.3500000 0.316000 39.3527778 0.314667 39.3555556 0.315333 39.3583333 0.315333 39.3611111 0.314000 39.3638889 0.314667 39.3666667 0.313333 39.3694444 0.313333 39.3722222 0.314000 39.3750000 0.315333 39.3777778 0.313333 39.3805556 0.314000 39.3833333 0.316000 39.3861111 0.314000 39.3888889 0.314000 39.3916667 0.313333 39.3944444 0.313333 39.3972222 0.312667 39.4000000 0.313333 39.4027778 0.313333 39.4055556 0.313333 39.4083333 0.315333 39.4111111 0.315333 39.4138889 0.314667 39.4166667 0.314000 39.4194444 0.312000 39.4222222 0.312000 39.4250000 0.312667 39.4277778 0.313333 39.4305556 0.314000 39.4333333 0.316000 39.4361111 0.316667 39.4388889 0.318000 39.4416667 0.318000 39.4444444 0.319333 39.4472222 0.322667 39.4500000 0.323333 39.4527778 0.322667 39.4555556 0.322000 39.4583333 0.316667 39.4611111 0.308667 39.4638889 0.297333 39.4666667 0.286667 39.4694444 0.276000 39.4722222 0.270000 39.4750000 0.264667 39.4777778 0.262000 39.4805556 0.262000 39.4833333 0.266667 39.4861111 0.274667 39.4888889 0.290000 39.4916667 0.306000 39.4944444 0.322667 39.4972222 0.337333 39.5000000 0.344667 39.5027778 0.348667 39.5055556 0.348667 39.5083333 0.348000 39.5111111 0.348667 39.5138889 0.350667 39.5166667 0.354000 39.5194444 0.356000 39.5222222 0.360667 39.5250000 0.360667 39.5277778 0.360000 39.5305556 0.362000 39.5333333 0.364000 39.5361111 0.366667 39.5388889 0.370000 39.5416667 0.372667 39.5444444 0.378000 39.5472222 0.379333 39.5500000 0.376667 39.5527778 0.374000 39.5555556 0.367333 39.5583333 0.360667 39.5611111 0.350000 39.5638889 0.338667 39.5666667 0.331333 39.5694444 0.321333 39.5722222 0.319333 39.5750000 0.312667 39.5777778 0.310667 39.5805556 0.306667 39.5833333 0.307333 39.5861111 0.304000 39.5888889 0.303333 39.5916667 0.305333 39.5944444 0.304000 39.5972222 0.302667 39.6000000 0.302000 39.6027778 0.302667 39.6055556 0.302667 39.6083333 0.304000 39.6111111 0.304667 39.6138889 0.305333 39.6166667 0.304667 39.6194444 0.304667 39.6222222 0.304000 39.6250000 0.301333 39.6277778 0.301333 39.6305556 0.298000 39.6333333 0.298667 39.6361111 0.300000 39.6388889 0.300667 39.6416667 0.302000 39.6444444 0.302667 39.6472222 0.302667 39.6500000 0.303333 39.6527778 0.302000 39.6555556 0.303333 39.6583333 0.303333 39.6611111 0.302667 39.6638889 0.301333 39.6666667 0.302000 39.6694444 0.302000 39.6722222 0.302667 39.6750000 0.303333 39.6777778 0.302000 39.6805556 0.302667 39.6833333 0.301333 39.6861111 0.300667 39.6888889 0.299333 39.6916667 0.300667 39.6944444 0.299333 39.6972222 0.298667 39.7000000 0.295333 39.7027778 0.293333 39.7055556 0.291333 39.7083333 0.290667 39.7111111 0.293333 39.7138889 0.292667 39.7166667 0.292667 39.7194444 0.290000 39.7222222 0.288000 39.7250000 0.284000 39.7277778 0.284000 39.7305556 0.284667 39.7333333 0.282000 39.7361111 0.283333 39.7388889 0.283333 39.7416667 0.284000 39.7444444 0.282000 39.7472222 0.284000 39.7500000 0.284000 39.7527778 0.282667 39.7555556 0.280667 39.7583333 0.281333 39.7611111 0.278667 39.7638889 0.279333 39.7666667 0.278667 39.7724444 0.300000 39.9608889 0.300000 39.9638889 0.312000 39.9666667 0.310667 39.9694444 0.309333 39.9722222 0.308667 39.9750000 0.310000 39.9777778 0.309333 39.9805556 0.310667 39.9833333 0.311333 39.9861111 0.312000 39.9888889 0.311333 39.9916667 0.311333 39.9944444 0.310667 39.9972222 0.310000 40.0000000 0.311333 40.0027778 0.312000 40.0055556 0.311333 40.0083333 0.311333 40.0111111 0.312667 40.0138889 0.312000 40.0166667 0.313333 40.0194444 0.312000 40.0222222 0.312000 40.0250000 0.312000 40.0277778 0.312000 40.0305556 0.312667 40.0333333 0.311333 40.0361111 0.312000 40.0388889 0.313333 40.0416667 0.313333 40.0444444 0.312667 40.0472222 0.312667 40.0500000 0.314000 40.0527778 0.315333 40.0555556 0.314667 40.0583333 0.313333 40.0611111 0.312000 40.0638889 0.313333 40.0666667 0.312000 40.0694444 0.313333 40.0722222 0.315333 40.0750000 0.318000 40.0777778 0.320000 40.0805556 0.322000 40.0833333 0.322000 40.0861111 0.320667 40.0888889 0.322000 40.0916667 0.319333 40.0944444 0.319333 40.0972222 0.318667 40.1000000 0.318667 40.1027778 0.320000 40.1055556 0.317333 40.1083333 0.318667 40.1111111 0.319333 40.1138889 0.318667 40.1166667 0.320667 40.1194444 0.321333 40.1222222 0.319333 40.1250000 0.320667 40.1277778 0.318667 40.1305556 0.318667 40.1333333 0.317333 40.1361111 0.317333 40.1388889 0.316667 40.1416667 0.318000 40.1444444 0.320000 40.1472222 0.319333 40.1500000 0.320000 40.1527778 0.321333 40.1555556 0.322000 40.1583333 0.322000 40.1611111 0.319333 40.1638889 0.320000 40.1666667 0.318000 40.1694444 0.318667 40.1722222 0.318000 40.1750000 0.319333 40.1777778 0.320667 40.1805556 0.320667 40.1833333 0.322667 40.1861111 0.324000 40.1888889 0.323333 40.1916667 0.324667 40.1944444 0.325333 40.1972222 0.326000 40.2000000 0.327333 40.2027778 0.324667 40.2055556 0.320667 40.2083333 0.311333 40.2111111 0.302000 40.2138889 0.290667 40.2166667 0.279333 40.2194444 0.269333 40.2222222 0.262000 40.2250000 0.258667 40.2277778 0.259333 40.2305556 0.264667 40.2333333 0.278667 40.2361111 0.296667 40.2388889 0.316667 40.2416667 0.335333 40.2444444 0.346667 40.2472222 0.354667 40.2500000 0.356667 40.2527778 0.358000 40.2555556 0.356667 40.2583333 0.355333 40.2611111 0.358000 40.2638889 0.358667 40.2666667 0.360667 40.2694444 0.364000 40.2722222 0.369333 40.2750000 0.370000 40.2777778 0.369333 40.2805556 0.370000 40.2833333 0.374667 40.2861111 0.376667 40.2888889 0.380000 40.2916667 0.380000 40.2944444 0.376667 40.2972222 0.374667 40.3000000 0.368667 40.3027778 0.361333 40.3055556 0.352667 40.3083333 0.346667 40.3111111 0.338000 40.3138889 0.332667 40.3166667 0.328000 40.3194444 0.321333 40.3222222 0.317333 40.3250000 0.312667 40.3277778 0.310667 40.3305556 0.310000 40.3333333 0.308667 40.3361111 0.310000 40.3388889 0.308667 40.3416667 0.309333 40.3444444 0.312000 40.3472222 0.311333 40.3500000 0.314667 40.3527778 0.313333 40.3555556 0.311333 40.3583333 0.309333 40.3611111 0.309333 40.3638889 0.308667 40.3666667 0.306667 40.3694444 0.308000 40.3722222 0.308667 40.3750000 0.307333 40.3777778 0.307333 40.3805556 0.310000 40.3833333 0.310667 40.3861111 0.309333 40.3888889 0.308667 40.3916667 0.308000 40.3944444 0.308667 40.3972222 0.306000 40.4000000 0.305333 40.4027778 0.304000 40.4055556 0.304667 40.4083333 0.306000 40.4111111 0.306667 40.4138889 0.306000 40.4166667 0.306000 40.4194444 0.305333 40.4222222 0.305333 40.4250000 0.304000 40.4277778 0.302000 40.4305556 0.299333 40.4333333 0.300000 40.4361111 0.299333 40.4388889 0.300000 40.4416667 0.299333 40.4444444 0.300000 40.4472222 0.300000 40.4500000 0.300667 40.4527778 0.300000 40.4555556 0.298667 40.4583333 0.296000 40.4611111 0.294667 40.4638889 0.292000 40.4666667 0.288000 40.4694444 0.286667 40.4722222 0.286000 40.4750000 0.286667 40.4777778 0.284667 40.4805556 0.286000 40.4833333 0.286000 40.4861111 0.285333 40.4888889 0.284667 40.4916667 0.285333 40.4944444 0.282667 40.4972222 0.278667 40.5000000 0.275333 40.5027778 0.274667 40.5055556 0.274667 40.5083333 0.277333 40.5111111 0.280000 40.5168889 0.300000 40.7138889 0.300000)

Vrpk trig_rpeak 0 PWL(0.0000000 0.000000 0.6801556 0.000000 0.6805556 0.900000 0.6810556 0.900000 0.6814556 0.000000 1.4162667 0.000000 1.4166667 0.900000 1.4171667 0.900000 1.4175667 0.000000 2.1634889 0.000000 2.1638889 0.900000 2.1643889 0.900000 2.1647889 0.000000 2.8996000 0.000000 2.9000000 0.900000 2.9005000 0.900000 2.9009000 0.000000 3.6329333 0.000000 3.6333333 0.900000 3.6338333 0.900000 3.6342333 0.000000 4.3440444 0.000000 4.3444444 0.900000 4.3449444 0.900000 4.3453444 0.000000 6.3746000 0.000000 6.3750000 0.900000 6.3755000 0.900000 6.3759000 0.000000 9.0912667 0.000000 9.0916667 0.900000 9.0921667 0.900000 9.0925667 0.000000 10.2023778 0.000000 10.2027778 0.900000 10.2032778 0.900000 10.2036778 0.000000 10.9190444 0.000000 10.9194444 0.900000 10.9199444 0.900000 10.9203444 0.000000 11.4996000 0.000000 11.5000000 0.900000 11.5005000 0.900000 11.5009000 0.000000 12.3357111 0.000000 12.3361111 0.900000 12.3366111 0.900000 12.3370111 0.000000 13.0384889 0.000000 13.0388889 0.900000 13.0393889 0.900000 13.0397889 0.000000 13.7579333 0.000000 13.7583333 0.900000 13.7588333 0.900000 13.7592333 0.000000 15.6912667 0.000000 15.6916667 0.900000 15.6921667 0.900000 15.6925667 0.000000 16.3773778 0.000000 16.3777778 0.900000 16.3782778 0.900000 16.3786778 0.000000 17.1023778 0.000000 17.1027778 0.900000 17.1032778 0.900000 17.1036778 0.000000 17.8190444 0.000000 17.8194444 0.900000 17.8199444 0.900000 17.8203444 0.000000 20.3079333 0.000000 20.3083333 0.900000 20.3088333 0.900000 20.3092333 0.000000 21.6634889 0.000000 21.6638889 0.900000 21.6643889 0.900000 21.6647889 0.000000 22.3579333 0.000000 22.3583333 0.900000 22.3588333 0.900000 22.3592333 0.000000 23.0996000 0.000000 23.1000000 0.900000 23.1005000 0.900000 23.1009000 0.000000 23.8162667 0.000000 23.8166667 0.900000 23.8171667 0.900000 23.8175667 0.000000 24.5551556 0.000000 24.5555556 0.900000 24.5560556 0.900000 24.5564556 0.000000 25.3051556 0.000000 25.3055556 0.900000 25.3060556 0.900000 25.3064556 0.000000 26.0357111 0.000000 26.0361111 0.900000 26.0366111 0.900000 26.0370111 0.000000 26.7718222 0.000000 26.7722222 0.900000 26.7727222 0.900000 26.7731222 0.000000 27.4940444 0.000000 27.4944444 0.900000 27.4949444 0.900000 27.4953444 0.000000 28.2468222 0.000000 28.2472222 0.900000 28.2477222 0.900000 28.2481222 0.000000 31.4051556 0.000000 31.4055556 0.900000 31.4060556 0.900000 31.4064556 0.000000 32.6384889 0.000000 32.6388889 0.900000 32.6393889 0.900000 32.6397889 0.000000 33.3523778 0.000000 33.3527778 0.900000 33.3532778 0.900000 33.3536778 0.000000 34.1134889 0.000000 34.1138889 0.900000 34.1143889 0.900000 34.1147889 0.000000 34.8412667 0.000000 34.8416667 0.900000 34.8421667 0.900000 34.8425667 0.000000 35.5718222 0.000000 35.5722222 0.900000 35.5727222 0.900000 35.5731222 0.000000 36.3051556 0.000000 36.3055556 0.900000 36.3060556 0.900000 36.3064556 0.000000 37.0523778 0.000000 37.0527778 0.900000 37.0532778 0.900000 37.0536778 0.000000 38.8023778 0.000000 38.8027778 0.900000 38.8032778 0.900000 38.8036778 0.000000 39.4690444 0.000000 39.4694444 0.900000 39.4699444 0.900000 39.4703444 0.000000 40.2134889 0.000000 40.2138889 0.900000 40.2143889 0.900000 40.2147889 0.000000 40.7138889 0.000000)
Vrrc trig_rr_cap 0 PWL(0.0000000 0.000000 0.6201556 0.000000 0.6205556 0.900000 0.6755556 0.900000 0.6759556 0.000000 1.3562667 0.000000 1.3566667 0.900000 1.4116667 0.900000 1.4120667 0.000000 2.1034889 0.000000 2.1038889 0.900000 2.1588889 0.900000 2.1592889 0.000000 2.8396000 0.000000 2.8400000 0.900000 2.8950000 0.900000 2.8954000 0.000000 3.5729333 0.000000 3.5733333 0.900000 3.6283333 0.900000 3.6287333 0.000000 4.2840444 0.000000 4.2844444 0.900000 4.3394444 0.900000 4.3398444 0.000000 6.3146000 0.000000 6.3150000 0.900000 6.3700000 0.900000 6.3704000 0.000000 9.0312667 0.000000 9.0316667 0.900000 9.0866667 0.900000 9.0870667 0.000000 10.1423778 0.000000 10.1427778 0.900000 10.1977778 0.900000 10.1981778 0.000000 10.8590444 0.000000 10.8594444 0.900000 10.9144444 0.900000 10.9148444 0.000000 11.4396000 0.000000 11.4400000 0.900000 11.4950000 0.900000 11.4954000 0.000000 12.2757111 0.000000 12.2761111 0.900000 12.3311111 0.900000 12.3315111 0.000000 12.9784889 0.000000 12.9788889 0.900000 13.0338889 0.900000 13.0342889 0.000000 13.6979333 0.000000 13.6983333 0.900000 13.7533333 0.900000 13.7537333 0.000000 15.6312667 0.000000 15.6316667 0.900000 15.6866667 0.900000 15.6870667 0.000000 16.3173778 0.000000 16.3177778 0.900000 16.3727778 0.900000 16.3731778 0.000000 17.0423778 0.000000 17.0427778 0.900000 17.0977778 0.900000 17.0981778 0.000000 17.7590444 0.000000 17.7594444 0.900000 17.8144444 0.900000 17.8148444 0.000000 20.2479333 0.000000 20.2483333 0.900000 20.3033333 0.900000 20.3037333 0.000000 21.6034889 0.000000 21.6038889 0.900000 21.6588889 0.900000 21.6592889 0.000000 22.2979333 0.000000 22.2983333 0.900000 22.3533333 0.900000 22.3537333 0.000000 23.0396000 0.000000 23.0400000 0.900000 23.0950000 0.900000 23.0954000 0.000000 23.7562667 0.000000 23.7566667 0.900000 23.8116667 0.900000 23.8120667 0.000000 24.4951556 0.000000 24.4955556 0.900000 24.5505556 0.900000 24.5509556 0.000000 25.2451556 0.000000 25.2455556 0.900000 25.3005556 0.900000 25.3009556 0.000000 25.9757111 0.000000 25.9761111 0.900000 26.0311111 0.900000 26.0315111 0.000000 26.7118222 0.000000 26.7122222 0.900000 26.7672222 0.900000 26.7676222 0.000000 27.4340444 0.000000 27.4344444 0.900000 27.4894444 0.900000 27.4898444 0.000000 28.1868222 0.000000 28.1872222 0.900000 28.2422222 0.900000 28.2426222 0.000000 31.3451556 0.000000 31.3455556 0.900000 31.4005556 0.900000 31.4009556 0.000000 32.5784889 0.000000 32.5788889 0.900000 32.6338889 0.900000 32.6342889 0.000000 33.2923778 0.000000 33.2927778 0.900000 33.3477778 0.900000 33.3481778 0.000000 34.0534889 0.000000 34.0538889 0.900000 34.1088889 0.900000 34.1092889 0.000000 34.7812667 0.000000 34.7816667 0.900000 34.8366667 0.900000 34.8370667 0.000000 35.5118222 0.000000 35.5122222 0.900000 35.5672222 0.900000 35.5676222 0.000000 36.2451556 0.000000 36.2455556 0.900000 36.3005556 0.900000 36.3009556 0.000000 36.9923778 0.000000 36.9927778 0.900000 37.0477778 0.900000 37.0481778 0.000000 38.7423778 0.000000 38.7427778 0.900000 38.7977778 0.900000 38.7981778 0.000000 39.4090444 0.000000 39.4094444 0.900000 39.4644444 0.900000 39.4648444 0.000000 40.1534889 0.000000 40.1538889 0.900000 40.2088889 0.900000 40.2092889 0.000000 40.7138889 0.000000)
Vrry trig_rr_copy 0 PWL(0.0000000 0.000000 0.6901556 0.000000 0.6905556 0.900000 0.6925556 0.900000 0.6929556 0.000000 1.4262667 0.000000 1.4266667 0.900000 1.4286667 0.900000 1.4290667 0.000000 2.1734889 0.000000 2.1738889 0.900000 2.1758889 0.900000 2.1762889 0.000000 2.9096000 0.000000 2.9100000 0.900000 2.9120000 0.900000 2.9124000 0.000000 3.6429333 0.000000 3.6433333 0.900000 3.6453333 0.900000 3.6457333 0.000000 4.3540444 0.000000 4.3544444 0.900000 4.3564444 0.900000 4.3568444 0.000000 6.3846000 0.000000 6.3850000 0.900000 6.3870000 0.900000 6.3874000 0.000000 9.1012667 0.000000 9.1016667 0.900000 9.1036667 0.900000 9.1040667 0.000000 10.2123778 0.000000 10.2127778 0.900000 10.2147778 0.900000 10.2151778 0.000000 10.9290444 0.000000 10.9294444 0.900000 10.9314444 0.900000 10.9318444 0.000000 11.5096000 0.000000 11.5100000 0.900000 11.5120000 0.900000 11.5124000 0.000000 12.3457111 0.000000 12.3461111 0.900000 12.3481111 0.900000 12.3485111 0.000000 13.0484889 0.000000 13.0488889 0.900000 13.0508889 0.900000 13.0512889 0.000000 13.7679333 0.000000 13.7683333 0.900000 13.7703333 0.900000 13.7707333 0.000000 15.7012667 0.000000 15.7016667 0.900000 15.7036667 0.900000 15.7040667 0.000000 16.3873778 0.000000 16.3877778 0.900000 16.3897778 0.900000 16.3901778 0.000000 17.1123778 0.000000 17.1127778 0.900000 17.1147778 0.900000 17.1151778 0.000000 17.8290444 0.000000 17.8294444 0.900000 17.8314444 0.900000 17.8318444 0.000000 20.3179333 0.000000 20.3183333 0.900000 20.3203333 0.900000 20.3207333 0.000000 21.6734889 0.000000 21.6738889 0.900000 21.6758889 0.900000 21.6762889 0.000000 22.3679333 0.000000 22.3683333 0.900000 22.3703333 0.900000 22.3707333 0.000000 23.1096000 0.000000 23.1100000 0.900000 23.1120000 0.900000 23.1124000 0.000000 23.8262667 0.000000 23.8266667 0.900000 23.8286667 0.900000 23.8290667 0.000000 24.5651556 0.000000 24.5655556 0.900000 24.5675556 0.900000 24.5679556 0.000000 25.3151556 0.000000 25.3155556 0.900000 25.3175556 0.900000 25.3179556 0.000000 26.0457111 0.000000 26.0461111 0.900000 26.0481111 0.900000 26.0485111 0.000000 26.7818222 0.000000 26.7822222 0.900000 26.7842222 0.900000 26.7846222 0.000000 27.5040444 0.000000 27.5044444 0.900000 27.5064444 0.900000 27.5068444 0.000000 28.2568222 0.000000 28.2572222 0.900000 28.2592222 0.900000 28.2596222 0.000000 31.4151556 0.000000 31.4155556 0.900000 31.4175556 0.900000 31.4179556 0.000000 32.6484889 0.000000 32.6488889 0.900000 32.6508889 0.900000 32.6512889 0.000000 33.3623778 0.000000 33.3627778 0.900000 33.3647778 0.900000 33.3651778 0.000000 34.1234889 0.000000 34.1238889 0.900000 34.1258889 0.900000 34.1262889 0.000000 34.8512667 0.000000 34.8516667 0.900000 34.8536667 0.900000 34.8540667 0.000000 35.5818222 0.000000 35.5822222 0.900000 35.5842222 0.900000 35.5846222 0.000000 36.3151556 0.000000 36.3155556 0.900000 36.3175556 0.900000 36.3179556 0.000000 37.0623778 0.000000 37.0627778 0.900000 37.0647778 0.900000 37.0651778 0.000000 38.8123778 0.000000 38.8127778 0.900000 38.8147778 0.900000 38.8151778 0.000000 39.4790444 0.000000 39.4794444 0.900000 39.4814444 0.900000 39.4818444 0.000000 40.2234889 0.000000 40.2238889 0.900000 40.2258889 0.900000 40.2262889 0.000000 40.7138889 0.000000)
Vpwb trig_pw_base 0 PWL(0.0000000 0.000000 0.4746000 0.000000 0.4750000 0.900000 0.4755000 0.900000 0.4759000 0.000000 1.2107111 0.000000 1.2111111 0.900000 1.2116111 0.900000 1.2120111 0.000000 1.9579333 0.000000 1.9583333 0.900000 1.9588333 0.900000 1.9592333 0.000000 2.6940444 0.000000 2.6944444 0.900000 2.6949444 0.900000 2.6953444 0.000000 3.4273778 0.000000 3.4277778 0.900000 3.4282778 0.900000 3.4286778 0.000000 4.1384889 0.000000 4.1388889 0.900000 4.1393889 0.900000 4.1397889 0.000000 6.1690444 0.000000 6.1694444 0.900000 6.1699444 0.900000 6.1703444 0.000000 8.8857111 0.000000 8.8861111 0.900000 8.8866111 0.900000 8.8870111 0.000000 9.9968222 0.000000 9.9972222 0.900000 9.9977222 0.900000 9.9981222 0.000000 10.7134889 0.000000 10.7138889 0.900000 10.7143889 0.900000 10.7147889 0.000000 11.2940444 0.000000 11.2944444 0.900000 11.2949444 0.900000 11.2953444 0.000000 12.1301556 0.000000 12.1305556 0.900000 12.1310556 0.900000 12.1314556 0.000000 12.8329333 0.000000 12.8333333 0.900000 12.8338333 0.900000 12.8342333 0.000000 13.5523778 0.000000 13.5527778 0.900000 13.5532778 0.900000 13.5536778 0.000000 15.4857111 0.000000 15.4861111 0.900000 15.4866111 0.900000 15.4870111 0.000000 16.1718222 0.000000 16.1722222 0.900000 16.1727222 0.900000 16.1731222 0.000000 16.8968222 0.000000 16.8972222 0.900000 16.8977222 0.900000 16.8981222 0.000000 17.6134889 0.000000 17.6138889 0.900000 17.6143889 0.900000 17.6147889 0.000000 20.1023778 0.000000 20.1027778 0.900000 20.1032778 0.900000 20.1036778 0.000000 21.4579333 0.000000 21.4583333 0.900000 21.4588333 0.900000 21.4592333 0.000000 22.1523778 0.000000 22.1527778 0.900000 22.1532778 0.900000 22.1536778 0.000000 22.8940444 0.000000 22.8944444 0.900000 22.8949444 0.900000 22.8953444 0.000000 23.6107111 0.000000 23.6111111 0.900000 23.6116111 0.900000 23.6120111 0.000000 24.3496000 0.000000 24.3500000 0.900000 24.3505000 0.900000 24.3509000 0.000000 25.0996000 0.000000 25.1000000 0.900000 25.1005000 0.900000 25.1009000 0.000000 25.8301556 0.000000 25.8305556 0.900000 25.8310556 0.900000 25.8314556 0.000000 26.5662667 0.000000 26.5666667 0.900000 26.5671667 0.900000 26.5675667 0.000000 27.2884889 0.000000 27.2888889 0.900000 27.2893889 0.900000 27.2897889 0.000000 28.0412667 0.000000 28.0416667 0.900000 28.0421667 0.900000 28.0425667 0.000000 31.1996000 0.000000 31.2000000 0.900000 31.2005000 0.900000 31.2009000 0.000000 32.4329333 0.000000 32.4333333 0.900000 32.4338333 0.900000 32.4342333 0.000000 33.1468222 0.000000 33.1472222 0.900000 33.1477222 0.900000 33.1481222 0.000000 33.9079333 0.000000 33.9083333 0.900000 33.9088333 0.900000 33.9092333 0.000000 34.6357111 0.000000 34.6361111 0.900000 34.6366111 0.900000 34.6370111 0.000000 35.3662667 0.000000 35.3666667 0.900000 35.3671667 0.900000 35.3675667 0.000000 36.0996000 0.000000 36.1000000 0.900000 36.1005000 0.900000 36.1009000 0.000000 36.8468222 0.000000 36.8472222 0.900000 36.8477222 0.900000 36.8481222 0.000000 38.5968222 0.000000 38.5972222 0.900000 38.5977222 0.900000 38.5981222 0.000000 39.2634889 0.000000 39.2638889 0.900000 39.2643889 0.900000 39.2647889 0.000000 40.0079333 0.000000 40.0083333 0.900000 40.0088333 0.900000 40.0092333 0.000000 40.7138889 0.000000)
Vpwp trig_pw_peak 0 PWL(0.0000000 0.000000 0.5496000 0.000000 0.5500000 0.900000 0.5505000 0.900000 0.5509000 0.000000 1.2857111 0.000000 1.2861111 0.900000 1.2866111 0.900000 1.2870111 0.000000 2.0329333 0.000000 2.0333333 0.900000 2.0338333 0.900000 2.0342333 0.000000 2.7690444 0.000000 2.7694444 0.900000 2.7699444 0.900000 2.7703444 0.000000 3.5023778 0.000000 3.5027778 0.900000 3.5032778 0.900000 3.5036778 0.000000 4.2134889 0.000000 4.2138889 0.900000 4.2143889 0.900000 4.2147889 0.000000 6.2440444 0.000000 6.2444444 0.900000 6.2449444 0.900000 6.2453444 0.000000 8.9607111 0.000000 8.9611111 0.900000 8.9616111 0.900000 8.9620111 0.000000 10.0718222 0.000000 10.0722222 0.900000 10.0727222 0.900000 10.0731222 0.000000 10.7884889 0.000000 10.7888889 0.900000 10.7893889 0.900000 10.7897889 0.000000 11.3690444 0.000000 11.3694444 0.900000 11.3699444 0.900000 11.3703444 0.000000 12.2051556 0.000000 12.2055556 0.900000 12.2060556 0.900000 12.2064556 0.000000 12.9079333 0.000000 12.9083333 0.900000 12.9088333 0.900000 12.9092333 0.000000 13.6273778 0.000000 13.6277778 0.900000 13.6282778 0.900000 13.6286778 0.000000 15.5607111 0.000000 15.5611111 0.900000 15.5616111 0.900000 15.5620111 0.000000 16.2468222 0.000000 16.2472222 0.900000 16.2477222 0.900000 16.2481222 0.000000 16.9718222 0.000000 16.9722222 0.900000 16.9727222 0.900000 16.9731222 0.000000 17.6884889 0.000000 17.6888889 0.900000 17.6893889 0.900000 17.6897889 0.000000 20.1773778 0.000000 20.1777778 0.900000 20.1782778 0.900000 20.1786778 0.000000 21.5329333 0.000000 21.5333333 0.900000 21.5338333 0.900000 21.5342333 0.000000 22.2273778 0.000000 22.2277778 0.900000 22.2282778 0.900000 22.2286778 0.000000 22.9690444 0.000000 22.9694444 0.900000 22.9699444 0.900000 22.9703444 0.000000 23.6857111 0.000000 23.6861111 0.900000 23.6866111 0.900000 23.6870111 0.000000 24.4246000 0.000000 24.4250000 0.900000 24.4255000 0.900000 24.4259000 0.000000 25.1746000 0.000000 25.1750000 0.900000 25.1755000 0.900000 25.1759000 0.000000 25.9051556 0.000000 25.9055556 0.900000 25.9060556 0.900000 25.9064556 0.000000 26.6412667 0.000000 26.6416667 0.900000 26.6421667 0.900000 26.6425667 0.000000 27.3634889 0.000000 27.3638889 0.900000 27.3643889 0.900000 27.3647889 0.000000 28.1162667 0.000000 28.1166667 0.900000 28.1171667 0.900000 28.1175667 0.000000 31.2746000 0.000000 31.2750000 0.900000 31.2755000 0.900000 31.2759000 0.000000 32.5079333 0.000000 32.5083333 0.900000 32.5088333 0.900000 32.5092333 0.000000 33.2218222 0.000000 33.2222222 0.900000 33.2227222 0.900000 33.2231222 0.000000 33.9829333 0.000000 33.9833333 0.900000 33.9838333 0.900000 33.9842333 0.000000 34.7107111 0.000000 34.7111111 0.900000 34.7116111 0.900000 34.7120111 0.000000 35.4412667 0.000000 35.4416667 0.900000 35.4421667 0.900000 35.4425667 0.000000 36.1746000 0.000000 36.1750000 0.900000 36.1755000 0.900000 36.1759000 0.000000 36.9218222 0.000000 36.9222222 0.900000 36.9227222 0.900000 36.9231222 0.000000 38.6718222 0.000000 38.6722222 0.900000 38.6727222 0.900000 38.6731222 0.000000 39.3384889 0.000000 39.3388889 0.900000 39.3393889 0.900000 39.3397889 0.000000 40.0829333 0.000000 40.0833333 0.900000 40.0838333 0.900000 40.0842333 0.000000 40.7138889 0.000000)
Vrsh trig_rpeak_sh 0 PWL(0.0000000 0.000000 0.6801556 0.000000 0.6805556 0.900000 0.6810556 0.900000 0.6814556 0.000000 1.4162667 0.000000 1.4166667 0.900000 1.4171667 0.900000 1.4175667 0.000000 2.1634889 0.000000 2.1638889 0.900000 2.1643889 0.900000 2.1647889 0.000000 2.8996000 0.000000 2.9000000 0.900000 2.9005000 0.900000 2.9009000 0.000000 3.6329333 0.000000 3.6333333 0.900000 3.6338333 0.900000 3.6342333 0.000000 4.3440444 0.000000 4.3444444 0.900000 4.3449444 0.900000 4.3453444 0.000000 6.3746000 0.000000 6.3750000 0.900000 6.3755000 0.900000 6.3759000 0.000000 9.0912667 0.000000 9.0916667 0.900000 9.0921667 0.900000 9.0925667 0.000000 10.2023778 0.000000 10.2027778 0.900000 10.2032778 0.900000 10.2036778 0.000000 10.9190444 0.000000 10.9194444 0.900000 10.9199444 0.900000 10.9203444 0.000000 11.4996000 0.000000 11.5000000 0.900000 11.5005000 0.900000 11.5009000 0.000000 12.3357111 0.000000 12.3361111 0.900000 12.3366111 0.900000 12.3370111 0.000000 13.0384889 0.000000 13.0388889 0.900000 13.0393889 0.900000 13.0397889 0.000000 13.7579333 0.000000 13.7583333 0.900000 13.7588333 0.900000 13.7592333 0.000000 15.6912667 0.000000 15.6916667 0.900000 15.6921667 0.900000 15.6925667 0.000000 16.3773778 0.000000 16.3777778 0.900000 16.3782778 0.900000 16.3786778 0.000000 17.1023778 0.000000 17.1027778 0.900000 17.1032778 0.900000 17.1036778 0.000000 17.8190444 0.000000 17.8194444 0.900000 17.8199444 0.900000 17.8203444 0.000000 20.3079333 0.000000 20.3083333 0.900000 20.3088333 0.900000 20.3092333 0.000000 21.6634889 0.000000 21.6638889 0.900000 21.6643889 0.900000 21.6647889 0.000000 22.3579333 0.000000 22.3583333 0.900000 22.3588333 0.900000 22.3592333 0.000000 23.0996000 0.000000 23.1000000 0.900000 23.1005000 0.900000 23.1009000 0.000000 23.8162667 0.000000 23.8166667 0.900000 23.8171667 0.900000 23.8175667 0.000000 24.5551556 0.000000 24.5555556 0.900000 24.5560556 0.900000 24.5564556 0.000000 25.3051556 0.000000 25.3055556 0.900000 25.3060556 0.900000 25.3064556 0.000000 26.0357111 0.000000 26.0361111 0.900000 26.0366111 0.900000 26.0370111 0.000000 26.7718222 0.000000 26.7722222 0.900000 26.7727222 0.900000 26.7731222 0.000000 27.4940444 0.000000 27.4944444 0.900000 27.4949444 0.900000 27.4953444 0.000000 28.2468222 0.000000 28.2472222 0.900000 28.2477222 0.900000 28.2481222 0.000000 31.4051556 0.000000 31.4055556 0.900000 31.4060556 0.900000 31.4064556 0.000000 32.6384889 0.000000 32.6388889 0.900000 32.6393889 0.900000 32.6397889 0.000000 33.3523778 0.000000 33.3527778 0.900000 33.3532778 0.900000 33.3536778 0.000000 34.1134889 0.000000 34.1138889 0.900000 34.1143889 0.900000 34.1147889 0.000000 34.8412667 0.000000 34.8416667 0.900000 34.8421667 0.900000 34.8425667 0.000000 35.5718222 0.000000 35.5722222 0.900000 35.5727222 0.900000 35.5731222 0.000000 36.3051556 0.000000 36.3055556 0.900000 36.3060556 0.900000 36.3064556 0.000000 37.0523778 0.000000 37.0527778 0.900000 37.0532778 0.900000 37.0536778 0.000000 38.8023778 0.000000 38.8027778 0.900000 38.8032778 0.900000 38.8036778 0.000000 39.4690444 0.000000 39.4694444 0.900000 39.4699444 0.900000 39.4703444 0.000000 40.2134889 0.000000 40.2138889 0.900000 40.2143889 0.900000 40.2147889 0.000000 40.7138889 0.000000)
Vs14 trig_s14 0 PWL(0.0000000 0.000000 0.6940444 0.000000 0.6944444 0.900000 0.6949444 0.900000 0.6953444 0.000000 1.4301556 0.000000 1.4305556 0.900000 1.4310556 0.900000 1.4314556 0.000000 2.1773778 0.000000 2.1777778 0.900000 2.1782778 0.900000 2.1786778 0.000000 2.9134889 0.000000 2.9138889 0.900000 2.9143889 0.900000 2.9147889 0.000000 3.6468222 0.000000 3.6472222 0.900000 3.6477222 0.900000 3.6481222 0.000000 4.3579333 0.000000 4.3583333 0.900000 4.3588333 0.900000 4.3592333 0.000000 6.3884889 0.000000 6.3888889 0.900000 6.3893889 0.900000 6.3897889 0.000000 9.1051556 0.000000 9.1055556 0.900000 9.1060556 0.900000 9.1064556 0.000000 10.2162667 0.000000 10.2166667 0.900000 10.2171667 0.900000 10.2175667 0.000000 10.9329333 0.000000 10.9333333 0.900000 10.9338333 0.900000 10.9342333 0.000000 11.5134889 0.000000 11.5138889 0.900000 11.5143889 0.900000 11.5147889 0.000000 12.3496000 0.000000 12.3500000 0.900000 12.3505000 0.900000 12.3509000 0.000000 13.0523778 0.000000 13.0527778 0.900000 13.0532778 0.900000 13.0536778 0.000000 13.7718222 0.000000 13.7722222 0.900000 13.7727222 0.900000 13.7731222 0.000000 15.7051556 0.000000 15.7055556 0.900000 15.7060556 0.900000 15.7064556 0.000000 16.3912667 0.000000 16.3916667 0.900000 16.3921667 0.900000 16.3925667 0.000000 17.1162667 0.000000 17.1166667 0.900000 17.1171667 0.900000 17.1175667 0.000000 17.8329333 0.000000 17.8333333 0.900000 17.8338333 0.900000 17.8342333 0.000000 20.3218222 0.000000 20.3222222 0.900000 20.3227222 0.900000 20.3231222 0.000000 21.6773778 0.000000 21.6777778 0.900000 21.6782778 0.900000 21.6786778 0.000000 22.3718222 0.000000 22.3722222 0.900000 22.3727222 0.900000 22.3731222 0.000000 23.1134889 0.000000 23.1138889 0.900000 23.1143889 0.900000 23.1147889 0.000000 23.8301556 0.000000 23.8305556 0.900000 23.8310556 0.900000 23.8314556 0.000000 24.5690444 0.000000 24.5694444 0.900000 24.5699444 0.900000 24.5703444 0.000000 25.3190444 0.000000 25.3194444 0.900000 25.3199444 0.900000 25.3203444 0.000000 26.0496000 0.000000 26.0500000 0.900000 26.0505000 0.900000 26.0509000 0.000000 26.7857111 0.000000 26.7861111 0.900000 26.7866111 0.900000 26.7870111 0.000000 27.5079333 0.000000 27.5083333 0.900000 27.5088333 0.900000 27.5092333 0.000000 28.2607111 0.000000 28.2611111 0.900000 28.2616111 0.900000 28.2620111 0.000000 31.4190444 0.000000 31.4194444 0.900000 31.4199444 0.900000 31.4203444 0.000000 32.6523778 0.000000 32.6527778 0.900000 32.6532778 0.900000 32.6536778 0.000000 33.3662667 0.000000 33.3666667 0.900000 33.3671667 0.900000 33.3675667 0.000000 34.1273778 0.000000 34.1277778 0.900000 34.1282778 0.900000 34.1286778 0.000000 34.8551556 0.000000 34.8555556 0.900000 34.8560556 0.900000 34.8564556 0.000000 35.5857111 0.000000 35.5861111 0.900000 35.5866111 0.900000 35.5870111 0.000000 36.3190444 0.000000 36.3194444 0.900000 36.3199444 0.900000 36.3203444 0.000000 37.0662667 0.000000 37.0666667 0.900000 37.0671667 0.900000 37.0675667 0.000000 38.8162667 0.000000 38.8166667 0.900000 38.8171667 0.900000 38.8175667 0.000000 39.4829333 0.000000 39.4833333 0.900000 39.4838333 0.900000 39.4842333 0.000000 40.2273778 0.000000 40.2277778 0.900000 40.2282778 0.900000 40.2286778 0.000000 40.7138889 0.000000)
Vs69 trig_s69 0 PWL(0.0000000 0.000000 0.7496000 0.000000 0.7500000 0.900000 0.7505000 0.900000 0.7509000 0.000000 1.4857111 0.000000 1.4861111 0.900000 1.4866111 0.900000 1.4870111 0.000000 2.2329333 0.000000 2.2333333 0.900000 2.2338333 0.900000 2.2342333 0.000000 2.9690444 0.000000 2.9694444 0.900000 2.9699444 0.900000 2.9703444 0.000000 3.7023778 0.000000 3.7027778 0.900000 3.7032778 0.900000 3.7036778 0.000000 4.4134889 0.000000 4.4138889 0.900000 4.4143889 0.900000 4.4147889 0.000000 6.4440444 0.000000 6.4444444 0.900000 6.4449444 0.900000 6.4453444 0.000000 9.1607111 0.000000 9.1611111 0.900000 9.1616111 0.900000 9.1620111 0.000000 10.2718222 0.000000 10.2722222 0.900000 10.2727222 0.900000 10.2731222 0.000000 10.9884889 0.000000 10.9888889 0.900000 10.9893889 0.900000 10.9897889 0.000000 11.5690444 0.000000 11.5694444 0.900000 11.5699444 0.900000 11.5703444 0.000000 12.4051556 0.000000 12.4055556 0.900000 12.4060556 0.900000 12.4064556 0.000000 13.1079333 0.000000 13.1083333 0.900000 13.1088333 0.900000 13.1092333 0.000000 13.8273778 0.000000 13.8277778 0.900000 13.8282778 0.900000 13.8286778 0.000000 15.7607111 0.000000 15.7611111 0.900000 15.7616111 0.900000 15.7620111 0.000000 16.4468222 0.000000 16.4472222 0.900000 16.4477222 0.900000 16.4481222 0.000000 17.1718222 0.000000 17.1722222 0.900000 17.1727222 0.900000 17.1731222 0.000000 17.8884889 0.000000 17.8888889 0.900000 17.8893889 0.900000 17.8897889 0.000000 20.3773778 0.000000 20.3777778 0.900000 20.3782778 0.900000 20.3786778 0.000000 21.7329333 0.000000 21.7333333 0.900000 21.7338333 0.900000 21.7342333 0.000000 22.4273778 0.000000 22.4277778 0.900000 22.4282778 0.900000 22.4286778 0.000000 23.1690444 0.000000 23.1694444 0.900000 23.1699444 0.900000 23.1703444 0.000000 23.8857111 0.000000 23.8861111 0.900000 23.8866111 0.900000 23.8870111 0.000000 24.6246000 0.000000 24.6250000 0.900000 24.6255000 0.900000 24.6259000 0.000000 25.3746000 0.000000 25.3750000 0.900000 25.3755000 0.900000 25.3759000 0.000000 26.1051556 0.000000 26.1055556 0.900000 26.1060556 0.900000 26.1064556 0.000000 26.8412667 0.000000 26.8416667 0.900000 26.8421667 0.900000 26.8425667 0.000000 27.5634889 0.000000 27.5638889 0.900000 27.5643889 0.900000 27.5647889 0.000000 28.3162667 0.000000 28.3166667 0.900000 28.3171667 0.900000 28.3175667 0.000000 31.4746000 0.000000 31.4750000 0.900000 31.4755000 0.900000 31.4759000 0.000000 32.7079333 0.000000 32.7083333 0.900000 32.7088333 0.900000 32.7092333 0.000000 33.4218222 0.000000 33.4222222 0.900000 33.4227222 0.900000 33.4231222 0.000000 34.1829333 0.000000 34.1833333 0.900000 34.1838333 0.900000 34.1842333 0.000000 34.9107111 0.000000 34.9111111 0.900000 34.9116111 0.900000 34.9120111 0.000000 35.6412667 0.000000 35.6416667 0.900000 35.6421667 0.900000 35.6425667 0.000000 36.3746000 0.000000 36.3750000 0.900000 36.3755000 0.900000 36.3759000 0.000000 37.1218222 0.000000 37.1222222 0.900000 37.1227222 0.900000 37.1231222 0.000000 38.8718222 0.000000 38.8722222 0.900000 38.8727222 0.900000 38.8731222 0.000000 39.5384889 0.000000 39.5388889 0.900000 39.5393889 0.900000 39.5397889 0.000000 40.2829333 0.000000 40.2833333 0.900000 40.2838333 0.900000 40.2842333 0.000000 40.7138889 0.000000)
Vwid trig_wid 0 PWL(0.0000000 0.000000 0.7079333 0.000000 0.7083333 0.900000 0.7088333 0.900000 0.7092333 0.000000 1.4440444 0.000000 1.4444444 0.900000 1.4449444 0.900000 1.4453444 0.000000 2.1912667 0.000000 2.1916667 0.900000 2.1921667 0.900000 2.1925667 0.000000 2.9273778 0.000000 2.9277778 0.900000 2.9282778 0.900000 2.9286778 0.000000 3.6607111 0.000000 3.6611111 0.900000 3.6616111 0.900000 3.6620111 0.000000 4.3718222 0.000000 4.3722222 0.900000 4.3727222 0.900000 4.3731222 0.000000 6.4023778 0.000000 6.4027778 0.900000 6.4032778 0.900000 6.4036778 0.000000 9.1190444 0.000000 9.1194444 0.900000 9.1199444 0.900000 9.1203444 0.000000 10.2301556 0.000000 10.2305556 0.900000 10.2310556 0.900000 10.2314556 0.000000 10.9468222 0.000000 10.9472222 0.900000 10.9477222 0.900000 10.9481222 0.000000 11.5273778 0.000000 11.5277778 0.900000 11.5282778 0.900000 11.5286778 0.000000 12.3634889 0.000000 12.3638889 0.900000 12.3643889 0.900000 12.3647889 0.000000 13.0662667 0.000000 13.0666667 0.900000 13.0671667 0.900000 13.0675667 0.000000 13.7857111 0.000000 13.7861111 0.900000 13.7866111 0.900000 13.7870111 0.000000 15.7190444 0.000000 15.7194444 0.900000 15.7199444 0.900000 15.7203444 0.000000 16.4051556 0.000000 16.4055556 0.900000 16.4060556 0.900000 16.4064556 0.000000 17.1301556 0.000000 17.1305556 0.900000 17.1310556 0.900000 17.1314556 0.000000 17.8468222 0.000000 17.8472222 0.900000 17.8477222 0.900000 17.8481222 0.000000 20.3357111 0.000000 20.3361111 0.900000 20.3366111 0.900000 20.3370111 0.000000 21.6912667 0.000000 21.6916667 0.900000 21.6921667 0.900000 21.6925667 0.000000 22.3857111 0.000000 22.3861111 0.900000 22.3866111 0.900000 22.3870111 0.000000 23.1273778 0.000000 23.1277778 0.900000 23.1282778 0.900000 23.1286778 0.000000 23.8440444 0.000000 23.8444444 0.900000 23.8449444 0.900000 23.8453444 0.000000 24.5829333 0.000000 24.5833333 0.900000 24.5838333 0.900000 24.5842333 0.000000 25.3329333 0.000000 25.3333333 0.900000 25.3338333 0.900000 25.3342333 0.000000 26.0634889 0.000000 26.0638889 0.900000 26.0643889 0.900000 26.0647889 0.000000 26.7996000 0.000000 26.8000000 0.900000 26.8005000 0.900000 26.8009000 0.000000 27.5218222 0.000000 27.5222222 0.900000 27.5227222 0.900000 27.5231222 0.000000 28.2746000 0.000000 28.2750000 0.900000 28.2755000 0.900000 28.2759000 0.000000 31.4329333 0.000000 31.4333333 0.900000 31.4338333 0.900000 31.4342333 0.000000 32.6662667 0.000000 32.6666667 0.900000 32.6671667 0.900000 32.6675667 0.000000 33.3801556 0.000000 33.3805556 0.900000 33.3810556 0.900000 33.3814556 0.000000 34.1412667 0.000000 34.1416667 0.900000 34.1421667 0.900000 34.1425667 0.000000 34.8690444 0.000000 34.8694444 0.900000 34.8699444 0.900000 34.8703444 0.000000 35.5996000 0.000000 35.6000000 0.900000 35.6005000 0.900000 35.6009000 0.000000 36.3329333 0.000000 36.3333333 0.900000 36.3338333 0.900000 36.3342333 0.000000 37.0801556 0.000000 37.0805556 0.900000 37.0810556 0.900000 37.0814556 0.000000 38.8301556 0.000000 38.8305556 0.900000 38.8310556 0.900000 38.8314556 0.000000 39.4968222 0.000000 39.4972222 0.900000 39.4977222 0.900000 39.4981222 0.000000 40.2412667 0.000000 40.2416667 0.900000 40.2421667 0.900000 40.2425667 0.000000 40.7138889 0.000000)
Vbco trig_bi_copy 0 PWL(0.0000000 0.000000 0.9801556 0.000000 0.9805556 0.900000 0.9825556 0.900000 0.9829556 0.000000 1.7162667 0.000000 1.7166667 0.900000 1.7186667 0.900000 1.7190667 0.000000 2.4634889 0.000000 2.4638889 0.900000 2.4658889 0.900000 2.4662889 0.000000 3.1996000 0.000000 3.2000000 0.900000 3.2020000 0.900000 3.2024000 0.000000 3.9329333 0.000000 3.9333333 0.900000 3.9353333 0.900000 3.9357333 0.000000 4.6440444 0.000000 4.6444444 0.900000 4.6464444 0.900000 4.6468444 0.000000 6.6746000 0.000000 6.6750000 0.900000 6.6770000 0.900000 6.6774000 0.000000 9.3912667 0.000000 9.3916667 0.900000 9.3936667 0.900000 9.3940667 0.000000 10.5023778 0.000000 10.5027778 0.900000 10.5047778 0.900000 10.5051778 0.000000 11.2190444 0.000000 11.2194444 0.900000 11.2214444 0.900000 11.2218444 0.000000 11.7996000 0.000000 11.8000000 0.900000 11.8020000 0.900000 11.8024000 0.000000 12.6357111 0.000000 12.6361111 0.900000 12.6381111 0.900000 12.6385111 0.000000 13.3384889 0.000000 13.3388889 0.900000 13.3408889 0.900000 13.3412889 0.000000 14.0579333 0.000000 14.0583333 0.900000 14.0603333 0.900000 14.0607333 0.000000 15.9912667 0.000000 15.9916667 0.900000 15.9936667 0.900000 15.9940667 0.000000 16.6773778 0.000000 16.6777778 0.900000 16.6797778 0.900000 16.6801778 0.000000 17.4023778 0.000000 17.4027778 0.900000 17.4047778 0.900000 17.4051778 0.000000 18.1190444 0.000000 18.1194444 0.900000 18.1214444 0.900000 18.1218444 0.000000 20.6079333 0.000000 20.6083333 0.900000 20.6103333 0.900000 20.6107333 0.000000 21.9634889 0.000000 21.9638889 0.900000 21.9658889 0.900000 21.9662889 0.000000 22.6579333 0.000000 22.6583333 0.900000 22.6603333 0.900000 22.6607333 0.000000 23.3996000 0.000000 23.4000000 0.900000 23.4020000 0.900000 23.4024000 0.000000 24.1162667 0.000000 24.1166667 0.900000 24.1186667 0.900000 24.1190667 0.000000 24.8551556 0.000000 24.8555556 0.900000 24.8575556 0.900000 24.8579556 0.000000 25.6051556 0.000000 25.6055556 0.900000 25.6075556 0.900000 25.6079556 0.000000 26.3357111 0.000000 26.3361111 0.900000 26.3381111 0.900000 26.3385111 0.000000 27.0718222 0.000000 27.0722222 0.900000 27.0742222 0.900000 27.0746222 0.000000 27.7940444 0.000000 27.7944444 0.900000 27.7964444 0.900000 27.7968444 0.000000 28.5468222 0.000000 28.5472222 0.900000 28.5492222 0.900000 28.5496222 0.000000 31.7051556 0.000000 31.7055556 0.900000 31.7075556 0.900000 31.7079556 0.000000 32.9384889 0.000000 32.9388889 0.900000 32.9408889 0.900000 32.9412889 0.000000 33.6523778 0.000000 33.6527778 0.900000 33.6547778 0.900000 33.6551778 0.000000 34.4134889 0.000000 34.4138889 0.900000 34.4158889 0.900000 34.4162889 0.000000 35.1412667 0.000000 35.1416667 0.900000 35.1436667 0.900000 35.1440667 0.000000 35.8718222 0.000000 35.8722222 0.900000 35.8742222 0.900000 35.8746222 0.000000 36.6051556 0.000000 36.6055556 0.900000 36.6075556 0.900000 36.6079556 0.000000 37.3523778 0.000000 37.3527778 0.900000 37.3547778 0.900000 37.3551778 0.000000 39.1023778 0.000000 39.1027778 0.900000 39.1047778 0.900000 39.1051778 0.000000 39.7690444 0.000000 39.7694444 0.900000 39.7714444 0.900000 39.7718444 0.000000 40.5134889 0.000000 40.5138889 0.900000 40.5158889 0.900000 40.5162889 0.000000 40.7138889 0.000000)

.include "C:/Users/kadhi/OneDrive/Desktop/amux/verilogLearning/Leaky-Integrate-Fire---SNN-model-on-FPGA/experiments/frontend_optimization/complete_frontend/inverter.spice"
.include "C:/Users/kadhi/OneDrive/Desktop/amux/verilogLearning/Leaky-Integrate-Fire---SNN-model-on-FPGA/experiments/frontend_optimization/complete_frontend/rr_timing.spice"
.include "C:/Users/kadhi/OneDrive/Desktop/amux/verilogLearning/Leaky-Integrate-Fire---SNN-model-on-FPGA/experiments/frontend_optimization/complete_frontend/beat_instability.spice"
.include "C:/Users/kadhi/OneDrive/Desktop/amux/verilogLearning/Leaky-Integrate-Fire---SNN-model-on-FPGA/experiments/frontend_optimization/complete_frontend/pwave_diff.spice"
.include "C:/Users/kadhi/OneDrive/Desktop/amux/verilogLearning/Leaky-Integrate-Fire---SNN-model-on-FPGA/experiments/frontend_optimization/complete_frontend/qrs_width.spice"
.include "C:/Users/kadhi/OneDrive/Desktop/amux/verilogLearning/Leaky-Integrate-Fire---SNN-model-on-FPGA/experiments/frontend_optimization/complete_frontend/qrs_slope.spice"
.include "C:/Users/kadhi/OneDrive/Desktop/amux/verilogLearning/Leaky-Integrate-Fire---SNN-model-on-FPGA/experiments/frontend_optimization/complete_frontend/qrs_symmetry.spice"

Xrr ecg_l0 trig_rr_cap trig_rpeak trig_rr_copy f1_rr_ratio f2_rr_asym rr_timer rr_ewma vdd vss vbias rr_timing
Xbi0 ecg_l0 trig_rpeak_sh trig_bi_copy f3_bi_l0 vdd vss vbias beat_instability
Xbi1 ecg_l1 trig_rpeak_sh trig_bi_copy f4_bi_l1 vdd vss vbias beat_instability
Xpw ecg_l0 trig_pw_base trig_pw_peak f5_pwave vdd vss vbias pwave_diff
Xwid ecg_l0 trig_wid f6_width vdd vss qrs_width
Xslp ecg_l0 trig_s14 trig_s69 f7_slope vdd vss vbias qrs_slope
Xsym ecg_l0 trig_rpeak_sh f8_symmetry vdd vss qrs_symmetry

.ic V(xrr.net_timer)=0.900000
.ic V(xrr.ewma_node)=0.360748
.ic V(xrr.esamp_node)=0.360314
.ic V(xrr.prev_node)=0.270048
.ic V(xbi0.prev_node)=0.337099
.ic V(xbi0.esamp_node)=0.365802
.ic V(xbi1.prev_node)=0.246629
.ic V(xbi1.esamp_node)=0.250983

.tran 0.5m 40.7139

.meas tran f1_2 FIND V(f1_rr_ratio) AT=2.1538889
.meas tran f2_2 FIND V(f2_rr_asym) AT=2.8350000
.meas tran f3_2 FIND V(f3_bi_l0) AT=2.2638889
.meas tran f4_2 FIND V(f4_bi_l1) AT=2.2638889
.meas tran f5_2 FIND V(f5_pwave) AT=2.2638889
.meas tran f6_2 FIND V(f6_width) AT=2.2638889
.meas tran f7_2 FIND V(f7_slope) AT=2.2638889
.meas tran f8_2 FIND V(f8_symmetry) AT=2.2638889
.meas tran f1_3 FIND V(f1_rr_ratio) AT=2.8900000
.meas tran f2_3 FIND V(f2_rr_asym) AT=3.5683333
.meas tran f3_3 FIND V(f3_bi_l0) AT=3.0000000
.meas tran f4_3 FIND V(f4_bi_l1) AT=3.0000000
.meas tran f5_3 FIND V(f5_pwave) AT=3.0000000
.meas tran f6_3 FIND V(f6_width) AT=3.0000000
.meas tran f7_3 FIND V(f7_slope) AT=3.0000000
.meas tran f8_3 FIND V(f8_symmetry) AT=3.0000000
.meas tran f1_4 FIND V(f1_rr_ratio) AT=3.6233333
.meas tran f2_4 FIND V(f2_rr_asym) AT=4.2794444
.meas tran f3_4 FIND V(f3_bi_l0) AT=3.7333333
.meas tran f4_4 FIND V(f4_bi_l1) AT=3.7333333
.meas tran f5_4 FIND V(f5_pwave) AT=3.7333333
.meas tran f6_4 FIND V(f6_width) AT=3.7333333
.meas tran f7_4 FIND V(f7_slope) AT=3.7333333
.meas tran f8_4 FIND V(f8_symmetry) AT=3.7333333
.meas tran f1_5 FIND V(f1_rr_ratio) AT=4.3344444
.meas tran f2_5 FIND V(f2_rr_asym) AT=6.3100000
.meas tran f3_5 FIND V(f3_bi_l0) AT=4.4444444
.meas tran f4_5 FIND V(f4_bi_l1) AT=4.4444444
.meas tran f5_5 FIND V(f5_pwave) AT=4.4444444
.meas tran f6_5 FIND V(f6_width) AT=4.4444444
.meas tran f7_5 FIND V(f7_slope) AT=4.4444444
.meas tran f8_5 FIND V(f8_symmetry) AT=4.4444444
.meas tran f1_6 FIND V(f1_rr_ratio) AT=6.3650000
.meas tran f2_6 FIND V(f2_rr_asym) AT=9.0266667
.meas tran f3_6 FIND V(f3_bi_l0) AT=6.4750000
.meas tran f4_6 FIND V(f4_bi_l1) AT=6.4750000
.meas tran f5_6 FIND V(f5_pwave) AT=6.4750000
.meas tran f6_6 FIND V(f6_width) AT=6.4750000
.meas tran f7_6 FIND V(f7_slope) AT=6.4750000
.meas tran f8_6 FIND V(f8_symmetry) AT=6.4750000
.meas tran f1_7 FIND V(f1_rr_ratio) AT=9.0816667
.meas tran f2_7 FIND V(f2_rr_asym) AT=10.1377778
.meas tran f3_7 FIND V(f3_bi_l0) AT=9.1916667
.meas tran f4_7 FIND V(f4_bi_l1) AT=9.1916667
.meas tran f5_7 FIND V(f5_pwave) AT=9.1916667
.meas tran f6_7 FIND V(f6_width) AT=9.1916667
.meas tran f7_7 FIND V(f7_slope) AT=9.1916667
.meas tran f8_7 FIND V(f8_symmetry) AT=9.1916667
.meas tran f1_8 FIND V(f1_rr_ratio) AT=10.1927778
.meas tran f2_8 FIND V(f2_rr_asym) AT=10.8544444
.meas tran f3_8 FIND V(f3_bi_l0) AT=10.3027778
.meas tran f4_8 FIND V(f4_bi_l1) AT=10.3027778
.meas tran f5_8 FIND V(f5_pwave) AT=10.3027778
.meas tran f6_8 FIND V(f6_width) AT=10.3027778
.meas tran f7_8 FIND V(f7_slope) AT=10.3027778
.meas tran f8_8 FIND V(f8_symmetry) AT=10.3027778
.meas tran f1_9 FIND V(f1_rr_ratio) AT=10.9094444
.meas tran f2_9 FIND V(f2_rr_asym) AT=11.4350000
.meas tran f3_9 FIND V(f3_bi_l0) AT=11.0194444
.meas tran f4_9 FIND V(f4_bi_l1) AT=11.0194444
.meas tran f5_9 FIND V(f5_pwave) AT=11.0194444
.meas tran f6_9 FIND V(f6_width) AT=11.0194444
.meas tran f7_9 FIND V(f7_slope) AT=11.0194444
.meas tran f8_9 FIND V(f8_symmetry) AT=11.0194444
.meas tran f1_10 FIND V(f1_rr_ratio) AT=11.4900000
.meas tran f2_10 FIND V(f2_rr_asym) AT=12.2711111
.meas tran f3_10 FIND V(f3_bi_l0) AT=11.6000000
.meas tran f4_10 FIND V(f4_bi_l1) AT=11.6000000
.meas tran f5_10 FIND V(f5_pwave) AT=11.6000000
.meas tran f6_10 FIND V(f6_width) AT=11.6000000
.meas tran f7_10 FIND V(f7_slope) AT=11.6000000
.meas tran f8_10 FIND V(f8_symmetry) AT=11.6000000
.meas tran f1_11 FIND V(f1_rr_ratio) AT=12.3261111
.meas tran f2_11 FIND V(f2_rr_asym) AT=12.9738889
.meas tran f3_11 FIND V(f3_bi_l0) AT=12.4361111
.meas tran f4_11 FIND V(f4_bi_l1) AT=12.4361111
.meas tran f5_11 FIND V(f5_pwave) AT=12.4361111
.meas tran f6_11 FIND V(f6_width) AT=12.4361111
.meas tran f7_11 FIND V(f7_slope) AT=12.4361111
.meas tran f8_11 FIND V(f8_symmetry) AT=12.4361111
.meas tran f1_12 FIND V(f1_rr_ratio) AT=13.0288889
.meas tran f2_12 FIND V(f2_rr_asym) AT=13.6933333
.meas tran f3_12 FIND V(f3_bi_l0) AT=13.1388889
.meas tran f4_12 FIND V(f4_bi_l1) AT=13.1388889
.meas tran f5_12 FIND V(f5_pwave) AT=13.1388889
.meas tran f6_12 FIND V(f6_width) AT=13.1388889
.meas tran f7_12 FIND V(f7_slope) AT=13.1388889
.meas tran f8_12 FIND V(f8_symmetry) AT=13.1388889
.meas tran f1_13 FIND V(f1_rr_ratio) AT=13.7483333
.meas tran f2_13 FIND V(f2_rr_asym) AT=15.6266667
.meas tran f3_13 FIND V(f3_bi_l0) AT=13.8583333
.meas tran f4_13 FIND V(f4_bi_l1) AT=13.8583333
.meas tran f5_13 FIND V(f5_pwave) AT=13.8583333
.meas tran f6_13 FIND V(f6_width) AT=13.8583333
.meas tran f7_13 FIND V(f7_slope) AT=13.8583333
.meas tran f8_13 FIND V(f8_symmetry) AT=13.8583333
.meas tran f1_14 FIND V(f1_rr_ratio) AT=15.6816667
.meas tran f2_14 FIND V(f2_rr_asym) AT=16.3127778
.meas tran f3_14 FIND V(f3_bi_l0) AT=15.7916667
.meas tran f4_14 FIND V(f4_bi_l1) AT=15.7916667
.meas tran f5_14 FIND V(f5_pwave) AT=15.7916667
.meas tran f6_14 FIND V(f6_width) AT=15.7916667
.meas tran f7_14 FIND V(f7_slope) AT=15.7916667
.meas tran f8_14 FIND V(f8_symmetry) AT=15.7916667
.meas tran f1_15 FIND V(f1_rr_ratio) AT=16.3677778
.meas tran f2_15 FIND V(f2_rr_asym) AT=17.0377778
.meas tran f3_15 FIND V(f3_bi_l0) AT=16.4777778
.meas tran f4_15 FIND V(f4_bi_l1) AT=16.4777778
.meas tran f5_15 FIND V(f5_pwave) AT=16.4777778
.meas tran f6_15 FIND V(f6_width) AT=16.4777778
.meas tran f7_15 FIND V(f7_slope) AT=16.4777778
.meas tran f8_15 FIND V(f8_symmetry) AT=16.4777778
.meas tran f1_16 FIND V(f1_rr_ratio) AT=17.0927778
.meas tran f2_16 FIND V(f2_rr_asym) AT=17.7544444
.meas tran f3_16 FIND V(f3_bi_l0) AT=17.2027778
.meas tran f4_16 FIND V(f4_bi_l1) AT=17.2027778
.meas tran f5_16 FIND V(f5_pwave) AT=17.2027778
.meas tran f6_16 FIND V(f6_width) AT=17.2027778
.meas tran f7_16 FIND V(f7_slope) AT=17.2027778
.meas tran f8_16 FIND V(f8_symmetry) AT=17.2027778
.meas tran f1_17 FIND V(f1_rr_ratio) AT=17.8094444
.meas tran f2_17 FIND V(f2_rr_asym) AT=20.2433333
.meas tran f3_17 FIND V(f3_bi_l0) AT=17.9194444
.meas tran f4_17 FIND V(f4_bi_l1) AT=17.9194444
.meas tran f5_17 FIND V(f5_pwave) AT=17.9194444
.meas tran f6_17 FIND V(f6_width) AT=17.9194444
.meas tran f7_17 FIND V(f7_slope) AT=17.9194444
.meas tran f8_17 FIND V(f8_symmetry) AT=17.9194444
.meas tran f1_18 FIND V(f1_rr_ratio) AT=20.2983333
.meas tran f2_18 FIND V(f2_rr_asym) AT=21.5988889
.meas tran f3_18 FIND V(f3_bi_l0) AT=20.4083333
.meas tran f4_18 FIND V(f4_bi_l1) AT=20.4083333
.meas tran f5_18 FIND V(f5_pwave) AT=20.4083333
.meas tran f6_18 FIND V(f6_width) AT=20.4083333
.meas tran f7_18 FIND V(f7_slope) AT=20.4083333
.meas tran f8_18 FIND V(f8_symmetry) AT=20.4083333
.meas tran f1_19 FIND V(f1_rr_ratio) AT=21.6538889
.meas tran f2_19 FIND V(f2_rr_asym) AT=22.2933333
.meas tran f3_19 FIND V(f3_bi_l0) AT=21.7638889
.meas tran f4_19 FIND V(f4_bi_l1) AT=21.7638889
.meas tran f5_19 FIND V(f5_pwave) AT=21.7638889
.meas tran f6_19 FIND V(f6_width) AT=21.7638889
.meas tran f7_19 FIND V(f7_slope) AT=21.7638889
.meas tran f8_19 FIND V(f8_symmetry) AT=21.7638889
.meas tran f1_20 FIND V(f1_rr_ratio) AT=22.3483333
.meas tran f2_20 FIND V(f2_rr_asym) AT=23.0350000
.meas tran f3_20 FIND V(f3_bi_l0) AT=22.4583333
.meas tran f4_20 FIND V(f4_bi_l1) AT=22.4583333
.meas tran f5_20 FIND V(f5_pwave) AT=22.4583333
.meas tran f6_20 FIND V(f6_width) AT=22.4583333
.meas tran f7_20 FIND V(f7_slope) AT=22.4583333
.meas tran f8_20 FIND V(f8_symmetry) AT=22.4583333
.meas tran f1_21 FIND V(f1_rr_ratio) AT=23.0900000
.meas tran f2_21 FIND V(f2_rr_asym) AT=23.7516667
.meas tran f3_21 FIND V(f3_bi_l0) AT=23.2000000
.meas tran f4_21 FIND V(f4_bi_l1) AT=23.2000000
.meas tran f5_21 FIND V(f5_pwave) AT=23.2000000
.meas tran f6_21 FIND V(f6_width) AT=23.2000000
.meas tran f7_21 FIND V(f7_slope) AT=23.2000000
.meas tran f8_21 FIND V(f8_symmetry) AT=23.2000000
.meas tran f1_22 FIND V(f1_rr_ratio) AT=23.8066667
.meas tran f2_22 FIND V(f2_rr_asym) AT=24.4905556
.meas tran f3_22 FIND V(f3_bi_l0) AT=23.9166667
.meas tran f4_22 FIND V(f4_bi_l1) AT=23.9166667
.meas tran f5_22 FIND V(f5_pwave) AT=23.9166667
.meas tran f6_22 FIND V(f6_width) AT=23.9166667
.meas tran f7_22 FIND V(f7_slope) AT=23.9166667
.meas tran f8_22 FIND V(f8_symmetry) AT=23.9166667
.meas tran f1_23 FIND V(f1_rr_ratio) AT=24.5455556
.meas tran f2_23 FIND V(f2_rr_asym) AT=25.2405556
.meas tran f3_23 FIND V(f3_bi_l0) AT=24.6555556
.meas tran f4_23 FIND V(f4_bi_l1) AT=24.6555556
.meas tran f5_23 FIND V(f5_pwave) AT=24.6555556
.meas tran f6_23 FIND V(f6_width) AT=24.6555556
.meas tran f7_23 FIND V(f7_slope) AT=24.6555556
.meas tran f8_23 FIND V(f8_symmetry) AT=24.6555556
.meas tran f1_24 FIND V(f1_rr_ratio) AT=25.2955556
.meas tran f2_24 FIND V(f2_rr_asym) AT=25.9711111
.meas tran f3_24 FIND V(f3_bi_l0) AT=25.4055556
.meas tran f4_24 FIND V(f4_bi_l1) AT=25.4055556
.meas tran f5_24 FIND V(f5_pwave) AT=25.4055556
.meas tran f6_24 FIND V(f6_width) AT=25.4055556
.meas tran f7_24 FIND V(f7_slope) AT=25.4055556
.meas tran f8_24 FIND V(f8_symmetry) AT=25.4055556
.meas tran f1_25 FIND V(f1_rr_ratio) AT=26.0261111
.meas tran f2_25 FIND V(f2_rr_asym) AT=26.7072222
.meas tran f3_25 FIND V(f3_bi_l0) AT=26.1361111
.meas tran f4_25 FIND V(f4_bi_l1) AT=26.1361111
.meas tran f5_25 FIND V(f5_pwave) AT=26.1361111
.meas tran f6_25 FIND V(f6_width) AT=26.1361111
.meas tran f7_25 FIND V(f7_slope) AT=26.1361111
.meas tran f8_25 FIND V(f8_symmetry) AT=26.1361111
.meas tran f1_26 FIND V(f1_rr_ratio) AT=26.7622222
.meas tran f2_26 FIND V(f2_rr_asym) AT=27.4294444
.meas tran f3_26 FIND V(f3_bi_l0) AT=26.8722222
.meas tran f4_26 FIND V(f4_bi_l1) AT=26.8722222
.meas tran f5_26 FIND V(f5_pwave) AT=26.8722222
.meas tran f6_26 FIND V(f6_width) AT=26.8722222
.meas tran f7_26 FIND V(f7_slope) AT=26.8722222
.meas tran f8_26 FIND V(f8_symmetry) AT=26.8722222
.meas tran f1_27 FIND V(f1_rr_ratio) AT=27.4844444
.meas tran f2_27 FIND V(f2_rr_asym) AT=28.1822222
.meas tran f3_27 FIND V(f3_bi_l0) AT=27.5944444
.meas tran f4_27 FIND V(f4_bi_l1) AT=27.5944444
.meas tran f5_27 FIND V(f5_pwave) AT=27.5944444
.meas tran f6_27 FIND V(f6_width) AT=27.5944444
.meas tran f7_27 FIND V(f7_slope) AT=27.5944444
.meas tran f8_27 FIND V(f8_symmetry) AT=27.5944444
.meas tran f1_28 FIND V(f1_rr_ratio) AT=28.2372222
.meas tran f2_28 FIND V(f2_rr_asym) AT=31.3405556
.meas tran f3_28 FIND V(f3_bi_l0) AT=28.3472222
.meas tran f4_28 FIND V(f4_bi_l1) AT=28.3472222
.meas tran f5_28 FIND V(f5_pwave) AT=28.3472222
.meas tran f6_28 FIND V(f6_width) AT=28.3472222
.meas tran f7_28 FIND V(f7_slope) AT=28.3472222
.meas tran f8_28 FIND V(f8_symmetry) AT=28.3472222
.meas tran f1_29 FIND V(f1_rr_ratio) AT=31.3955556
.meas tran f2_29 FIND V(f2_rr_asym) AT=32.5738889
.meas tran f3_29 FIND V(f3_bi_l0) AT=31.5055556
.meas tran f4_29 FIND V(f4_bi_l1) AT=31.5055556
.meas tran f5_29 FIND V(f5_pwave) AT=31.5055556
.meas tran f6_29 FIND V(f6_width) AT=31.5055556
.meas tran f7_29 FIND V(f7_slope) AT=31.5055556
.meas tran f8_29 FIND V(f8_symmetry) AT=31.5055556
.meas tran f1_30 FIND V(f1_rr_ratio) AT=32.6288889
.meas tran f2_30 FIND V(f2_rr_asym) AT=33.2877778
.meas tran f3_30 FIND V(f3_bi_l0) AT=32.7388889
.meas tran f4_30 FIND V(f4_bi_l1) AT=32.7388889
.meas tran f5_30 FIND V(f5_pwave) AT=32.7388889
.meas tran f6_30 FIND V(f6_width) AT=32.7388889
.meas tran f7_30 FIND V(f7_slope) AT=32.7388889
.meas tran f8_30 FIND V(f8_symmetry) AT=32.7388889
.meas tran f1_31 FIND V(f1_rr_ratio) AT=33.3427778
.meas tran f2_31 FIND V(f2_rr_asym) AT=34.0488889
.meas tran f3_31 FIND V(f3_bi_l0) AT=33.4527778
.meas tran f4_31 FIND V(f4_bi_l1) AT=33.4527778
.meas tran f5_31 FIND V(f5_pwave) AT=33.4527778
.meas tran f6_31 FIND V(f6_width) AT=33.4527778
.meas tran f7_31 FIND V(f7_slope) AT=33.4527778
.meas tran f8_31 FIND V(f8_symmetry) AT=33.4527778
.meas tran f1_32 FIND V(f1_rr_ratio) AT=34.1038889
.meas tran f2_32 FIND V(f2_rr_asym) AT=34.7766667
.meas tran f3_32 FIND V(f3_bi_l0) AT=34.2138889
.meas tran f4_32 FIND V(f4_bi_l1) AT=34.2138889
.meas tran f5_32 FIND V(f5_pwave) AT=34.2138889
.meas tran f6_32 FIND V(f6_width) AT=34.2138889
.meas tran f7_32 FIND V(f7_slope) AT=34.2138889
.meas tran f8_32 FIND V(f8_symmetry) AT=34.2138889
.meas tran f1_33 FIND V(f1_rr_ratio) AT=34.8316667
.meas tran f2_33 FIND V(f2_rr_asym) AT=35.5072222
.meas tran f3_33 FIND V(f3_bi_l0) AT=34.9416667
.meas tran f4_33 FIND V(f4_bi_l1) AT=34.9416667
.meas tran f5_33 FIND V(f5_pwave) AT=34.9416667
.meas tran f6_33 FIND V(f6_width) AT=34.9416667
.meas tran f7_33 FIND V(f7_slope) AT=34.9416667
.meas tran f8_33 FIND V(f8_symmetry) AT=34.9416667
.meas tran f1_34 FIND V(f1_rr_ratio) AT=35.5622222
.meas tran f2_34 FIND V(f2_rr_asym) AT=36.2405556
.meas tran f3_34 FIND V(f3_bi_l0) AT=35.6722222
.meas tran f4_34 FIND V(f4_bi_l1) AT=35.6722222
.meas tran f5_34 FIND V(f5_pwave) AT=35.6722222
.meas tran f6_34 FIND V(f6_width) AT=35.6722222
.meas tran f7_34 FIND V(f7_slope) AT=35.6722222
.meas tran f8_34 FIND V(f8_symmetry) AT=35.6722222
.meas tran f1_35 FIND V(f1_rr_ratio) AT=36.2955556
.meas tran f2_35 FIND V(f2_rr_asym) AT=36.9877778
.meas tran f3_35 FIND V(f3_bi_l0) AT=36.4055556
.meas tran f4_35 FIND V(f4_bi_l1) AT=36.4055556
.meas tran f5_35 FIND V(f5_pwave) AT=36.4055556
.meas tran f6_35 FIND V(f6_width) AT=36.4055556
.meas tran f7_35 FIND V(f7_slope) AT=36.4055556
.meas tran f8_35 FIND V(f8_symmetry) AT=36.4055556
.meas tran f1_36 FIND V(f1_rr_ratio) AT=37.0427778
.meas tran f2_36 FIND V(f2_rr_asym) AT=38.7377778
.meas tran f3_36 FIND V(f3_bi_l0) AT=37.1527778
.meas tran f4_36 FIND V(f4_bi_l1) AT=37.1527778
.meas tran f5_36 FIND V(f5_pwave) AT=37.1527778
.meas tran f6_36 FIND V(f6_width) AT=37.1527778
.meas tran f7_36 FIND V(f7_slope) AT=37.1527778
.meas tran f8_36 FIND V(f8_symmetry) AT=37.1527778
.meas tran f1_37 FIND V(f1_rr_ratio) AT=38.7927778
.meas tran f2_37 FIND V(f2_rr_asym) AT=39.4044444
.meas tran f3_37 FIND V(f3_bi_l0) AT=38.9027778
.meas tran f4_37 FIND V(f4_bi_l1) AT=38.9027778
.meas tran f5_37 FIND V(f5_pwave) AT=38.9027778
.meas tran f6_37 FIND V(f6_width) AT=38.9027778
.meas tran f7_37 FIND V(f7_slope) AT=38.9027778
.meas tran f8_37 FIND V(f8_symmetry) AT=38.9027778
.meas tran f1_38 FIND V(f1_rr_ratio) AT=39.4594444
.meas tran f2_38 FIND V(f2_rr_asym) AT=40.1488889
.meas tran f3_38 FIND V(f3_bi_l0) AT=39.5694444
.meas tran f4_38 FIND V(f4_bi_l1) AT=39.5694444
.meas tran f5_38 FIND V(f5_pwave) AT=39.5694444
.meas tran f6_38 FIND V(f6_width) AT=39.5694444
.meas tran f7_38 FIND V(f7_slope) AT=39.5694444
.meas tran f8_38 FIND V(f8_symmetry) AT=39.5694444
.meas tran f1_39 FIND V(f1_rr_ratio) AT=40.2038889
.meas tran f3_39 FIND V(f3_bi_l0) AT=40.3138889
.meas tran f4_39 FIND V(f4_bi_l1) AT=40.3138889
.meas tran f5_39 FIND V(f5_pwave) AT=40.3138889
.meas tran f6_39 FIND V(f6_width) AT=40.3138889
.meas tran f7_39 FIND V(f7_slope) AT=40.3138889
.meas tran f8_39 FIND V(f8_symmetry) AT=40.3138889
.meas tran ic_rr_ewma FIND V(xrr.ewma_node) AT=40.3138889
.meas tran ic_rr_esamp FIND V(xrr.esamp_node) AT=40.3138889
.meas tran ic_rr_prev FIND V(xrr.prev_node) AT=40.3138889
.meas tran ic_bi0_prev FIND V(xbi0.prev_node) AT=40.3138889
.meas tran ic_bi0_esamp FIND V(xbi0.esamp_node) AT=40.3138889
.meas tran ic_bi1_prev FIND V(xbi1.prev_node) AT=40.3138889
.meas tran ic_bi1_esamp FIND V(xbi1.esamp_node) AT=40.3138889

.end
