.title qrs_slope_cf_test_109
.lib "C:\Users\kadhi\OneDrive\Desktop\amux\verilogLearning\Leaky-Integrate-Fire---SNN-model-on-FPGA\experiments\frontend_optimization\ngspice_frontend\sky130_minimal.lib.spice" tt
.option scale=1.0u method=gear reltol=0.01 gmin=1e-15
.temp 27
.include "qrs_slope.spice"

Vdd vdd 0 0.9
Vss vss 0 0
Vbias vbias 0 0.35
Vecg ecg_in 0 PWL(0.0000000 0.300000 1.9344444 0.300000 1.9444444 0.264194 1.9472222 0.264695 1.9500000 0.266197 1.9527778 0.270203 1.9555556 0.275462 1.9583333 0.280720 1.9611111 0.285728 1.9638889 0.289734 1.9666667 0.291236 1.9694444 0.292989 1.9722222 0.296244 1.9750000 0.301002 1.9777778 0.305258 1.9805556 0.309515 1.9833333 0.313020 1.9861111 0.316025 1.9888889 0.318779 1.9916667 0.319030 1.9944444 0.318028 1.9972222 0.317527 2.0000000 0.316275 2.0027778 0.315775 2.0055556 0.315023 2.0083333 0.311518 2.0111111 0.307261 2.0138889 0.302754 2.0166667 0.299750 2.0194444 0.297246 2.0222222 0.292739 2.0250000 0.287480 2.0277778 0.279468 2.0305556 0.272207 2.0333333 0.264945 2.0361111 0.259186 2.0388889 0.253678 2.0416667 0.249421 2.0444444 0.245915 2.0472222 0.243662 2.0500000 0.242160 2.0527778 0.241909 2.0555556 0.241909 2.0583333 0.242160 2.0611111 0.242160 2.0638889 0.241659 2.0666667 0.243161 2.0694444 0.244914 2.0722222 0.247167 2.0750000 0.248169 2.0777778 0.249171 2.0805556 0.249421 2.0833333 0.250673 2.0861111 0.251925 2.0888889 0.253177 2.0916667 0.254930 2.0944444 0.255180 2.0972222 0.254429 2.1000000 0.255931 2.1027778 0.256682 2.1055556 0.258685 2.1083333 0.259186 2.1211111 0.300000 2.5900000 0.300000 2.6000000 0.271455 2.6027778 0.274710 2.6055556 0.279718 2.6083333 0.285978 2.6111111 0.292488 2.6138889 0.300000 2.6166667 0.305759 2.6194444 0.307261 2.6222222 0.307011 2.6250000 0.307512 2.6277778 0.308764 2.6305556 0.310266 2.6333333 0.312520 2.6361111 0.316025 2.6388889 0.320532 2.6416667 0.323036 2.6444444 0.324038 2.6472222 0.323787 2.6500000 0.323537 2.6527778 0.324038 2.6555556 0.323787 2.6583333 0.322034 2.6611111 0.317527 2.6638889 0.312770 2.6666667 0.308513 2.6694444 0.304507 2.6722222 0.301753 2.6750000 0.297246 2.6777778 0.290986 2.6805556 0.282973 2.6833333 0.275712 2.6861111 0.269452 2.6888889 0.264695 2.6916667 0.259186 2.6944444 0.254178 2.6972222 0.249171 2.7000000 0.246917 2.7027778 0.245915 2.7055556 0.245665 2.7083333 0.245665 2.7111111 0.245415 2.7138889 0.245915 2.7166667 0.246166 2.7194444 0.247167 2.7222222 0.248169 2.7250000 0.248670 2.7277778 0.250423 2.7305556 0.251674 2.7333333 0.253678 2.7361111 0.255430 2.7388889 0.257183 2.7416667 0.258185 2.7444444 0.258435 2.7472222 0.259186 2.7500000 0.260939 2.7527778 0.262191 2.7555556 0.263944 2.7583333 0.264945 2.7611111 0.265446 2.7638889 0.265696 2.7766667 0.300000 3.2622222 0.300000 3.2722222 0.276213 3.2750000 0.276714 3.2777778 0.278717 3.2805556 0.281972 3.2833333 0.287731 3.2861111 0.294742 3.2888889 0.301753 3.2916667 0.307011 3.2944444 0.311768 3.2972222 0.314022 3.3000000 0.315274 3.3027778 0.316526 3.3055556 0.319030 3.3083333 0.322034 3.3111111 0.325790 3.3138889 0.328294 3.3166667 0.332801 3.3194444 0.335806 3.3222222 0.336557 3.3250000 0.336056 3.3277778 0.334304 3.3305556 0.331800 3.3333333 0.329296 3.3361111 0.326541 3.3388889 0.322786 3.3416667 0.317277 3.3444444 0.312019 3.3472222 0.308013 3.3500000 0.303505 3.3527778 0.298498 3.3555556 0.292989 3.3583333 0.286980 3.3611111 0.280469 3.3638889 0.272958 3.3666667 0.266448 3.3694444 0.260939 3.3722222 0.256682 3.3750000 0.251925 3.3777778 0.246667 3.3805556 0.242911 3.3833333 0.241659 3.3861111 0.241408 3.3888889 0.242410 3.3916667 0.243412 3.3944444 0.243412 3.3972222 0.243412 3.4000000 0.244163 3.4027778 0.245415 3.4055556 0.247418 3.4083333 0.249171 3.4111111 0.249171 3.4138889 0.250673 3.4166667 0.252676 3.4194444 0.254429 3.4222222 0.256182 3.4250000 0.257684 3.4277778 0.258685 3.4305556 0.259186 3.4333333 0.260689 3.4361111 0.262191 3.4488889 0.300000 3.8983333 0.300000 3.9083333 0.280469 3.9111111 0.277966 3.9138889 0.275462 3.9166667 0.274210 3.9194444 0.274460 3.9222222 0.277715 3.9250000 0.283224 3.9277778 0.289484 3.9305556 0.295493 3.9333333 0.301502 3.9361111 0.305759 3.9388889 0.309014 3.9416667 0.309515 3.9444444 0.312269 3.9472222 0.314523 3.9500000 0.316526 3.9527778 0.318028 3.9555556 0.320532 3.9583333 0.321283 3.9611111 0.321784 3.9638889 0.320031 3.9666667 0.318279 3.9694444 0.318028 3.9722222 0.317027 3.9750000 0.315023 3.9777778 0.310767 3.9805556 0.307762 3.9833333 0.304507 3.9861111 0.302254 3.9888889 0.299249 3.9916667 0.295493 3.9944444 0.290736 3.9972222 0.283975 4.0000000 0.277715 4.0027778 0.272207 4.0055556 0.267700 4.0083333 0.262441 4.0111111 0.256432 4.0138889 0.251925 4.0166667 0.250673 4.0194444 0.251674 4.0222222 0.252676 4.0250000 0.252676 4.0277778 0.250673 4.0305556 0.249671 4.0333333 0.250172 4.0361111 0.252175 4.0388889 0.255430 4.0416667 0.257934 4.0444444 0.259186 4.0472222 0.258185 4.0500000 0.257433 4.0527778 0.256682 4.0555556 0.256682 4.0583333 0.258185 4.0611111 0.260689 4.0638889 0.264194 4.0666667 0.267199 4.0694444 0.267950 4.0722222 0.267700 4.0850000 0.300000 4.5233333 0.300000 4.5333333 0.278967 4.5361111 0.278967 4.5388889 0.278466 4.5416667 0.278216 4.5444444 0.277715 4.5472222 0.279218 4.5500000 0.283725 4.5527778 0.290736 4.5555556 0.296495 4.5583333 0.300000 4.5611111 0.301252 4.5638889 0.301753 4.5666667 0.304757 4.5694444 0.309264 4.5722222 0.315023 4.5750000 0.319280 4.5777778 0.321784 4.5805556 0.321534 4.5833333 0.321784 4.5861111 0.321534 4.5888889 0.321534 4.5916667 0.320282 4.5944444 0.318028 4.5972222 0.313772 4.6000000 0.310516 4.6027778 0.308013 4.6055556 0.305759 4.6083333 0.302254 4.6111111 0.297746 4.6138889 0.291487 4.6166667 0.285477 4.6194444 0.279468 4.6222222 0.273208 4.6250000 0.266448 4.6277778 0.261189 4.6305556 0.257183 4.6333333 0.255430 4.6361111 0.254178 4.6388889 0.253928 4.6416667 0.253928 4.6444444 0.255180 4.6472222 0.254679 4.6500000 0.253928 4.6527778 0.254930 4.6555556 0.257433 4.6583333 0.259937 4.6611111 0.260939 4.6638889 0.261690 4.6666667 0.262191 4.6694444 0.263944 4.6722222 0.266197 4.6750000 0.267449 4.6777778 0.267700 4.6805556 0.268451 4.6833333 0.269703 4.6861111 0.270454 4.6888889 0.270704 4.6916667 0.271205 4.6944444 0.271205 4.6972222 0.270955 4.7100000 0.300000 5.1233333 0.300000 5.1333333 0.279718 5.1361111 0.279718 5.1388889 0.279218 5.1416667 0.278967 5.1444444 0.278717 5.1472222 0.281221 5.1500000 0.287230 5.1527778 0.293239 5.1555556 0.299249 5.1583333 0.303005 5.1611111 0.304006 5.1638889 0.304507 5.1666667 0.308013 5.1694444 0.313521 5.1722222 0.319781 5.1750000 0.324538 5.1777778 0.327793 5.1805556 0.329546 5.1833333 0.330798 5.1861111 0.330798 5.1888889 0.330297 5.1916667 0.329045 5.1944444 0.326291 5.1972222 0.321534 5.2000000 0.317778 5.2027778 0.314773 5.2055556 0.312019 5.2083333 0.308263 5.2111111 0.303005 5.2138889 0.295243 5.2166667 0.287230 5.2194444 0.279969 5.2222222 0.273709 5.2250000 0.267449 5.2277778 0.261690 5.2305556 0.258185 5.2333333 0.256432 5.2361111 0.255931 5.2388889 0.256432 5.2416667 0.255931 5.2444444 0.255931 5.2472222 0.255430 5.2500000 0.255931 5.2527778 0.256432 5.2555556 0.258185 5.2583333 0.260188 5.2611111 0.260689 5.2638889 0.261941 5.2666667 0.263443 5.2694444 0.264695 5.2722222 0.266448 5.2750000 0.267449 5.2777778 0.267449 5.2805556 0.268200 5.2833333 0.269703 5.2861111 0.271205 5.2888889 0.272207 5.2916667 0.272457 5.2944444 0.272207 5.2972222 0.271956 5.3100000 0.300000 5.7511111 0.300000 5.7611111 0.283725 5.7638889 0.288232 5.7666667 0.292739 5.7694444 0.296495 5.7722222 0.297997 5.7750000 0.300250 5.7777778 0.303255 5.7805556 0.307011 5.7833333 0.311518 5.7861111 0.316526 5.7888889 0.320282 5.7916667 0.321784 5.7944444 0.323036 5.7972222 0.326041 5.8000000 0.331299 5.8027778 0.334804 5.8055556 0.335055 5.8083333 0.332551 5.8111111 0.329797 5.8138889 0.328795 5.8166667 0.329797 5.8194444 0.330047 5.8222222 0.327543 5.8250000 0.323787 5.8277778 0.320282 5.8305556 0.316526 5.8333333 0.313271 5.8361111 0.309765 5.8388889 0.305008 5.8416667 0.297746 5.8444444 0.289233 5.8472222 0.279718 5.8500000 0.271956 5.8527778 0.265446 5.8555556 0.262441 5.8583333 0.259937 5.8611111 0.257433 5.8638889 0.253928 5.8666667 0.252676 5.8694444 0.252175 5.8722222 0.252676 5.8750000 0.254178 5.8777778 0.253427 5.8805556 0.253928 5.8833333 0.256682 5.8861111 0.259437 5.8888889 0.261440 5.8916667 0.262942 5.8944444 0.264194 5.8972222 0.265947 5.9000000 0.266698 5.9027778 0.268951 5.9055556 0.269953 5.9083333 0.270454 5.9111111 0.270704 5.9138889 0.271956 5.9166667 0.274710 5.9194444 0.275962 5.9222222 0.276213 5.9250000 0.275962 5.9377778 0.300000 6.3677778 0.300000 6.3777778 0.283224 6.3805556 0.284476 6.3833333 0.288232 6.3861111 0.294491 6.3888889 0.299750 6.3916667 0.304257 6.3944444 0.308263 6.3972222 0.310266 6.4000000 0.310016 6.4027778 0.310016 6.4055556 0.312520 6.4083333 0.317277 6.4111111 0.322285 6.4138889 0.327042 6.4166667 0.331800 6.4194444 0.336307 6.4222222 0.339812 6.4250000 0.340313 6.4277778 0.339562 6.4305556 0.337809 6.4333333 0.337308 6.4361111 0.336307 6.4388889 0.334053 6.4416667 0.328545 6.4444444 0.324288 6.4472222 0.321283 6.4500000 0.318028 6.4527778 0.314523 6.4555556 0.310016 6.4583333 0.303255 6.4611111 0.296244 6.4638889 0.289233 6.4666667 0.283725 6.4694444 0.278466 6.4722222 0.273459 6.4750000 0.269202 6.4777778 0.265196 6.4805556 0.262692 6.4833333 0.261189 6.4861111 0.260689 6.4888889 0.259937 6.4916667 0.259937 6.4944444 0.260188 6.4972222 0.260188 6.5000000 0.259937 6.5027778 0.259437 6.5055556 0.260689 6.5083333 0.261690 6.5111111 0.263693 6.5138889 0.265196 6.5166667 0.267199 6.5194444 0.268701 6.5222222 0.269703 6.5250000 0.270454 6.5277778 0.270454 6.5305556 0.270454 6.5333333 0.271956 6.5361111 0.273208 6.5388889 0.274460 6.5416667 0.276213 6.5544444 0.300000 7.0150000 0.300000 7.0250000 0.286729 7.0277778 0.286479 7.0305556 0.287480 7.0333333 0.292238 7.0361111 0.297997 7.0388889 0.302504 7.0416667 0.307512 7.0444444 0.310767 7.0472222 0.313772 7.0500000 0.316025 7.0527778 0.319531 7.0555556 0.324538 7.0583333 0.329797 7.0611111 0.334554 7.0638889 0.339061 7.0666667 0.343067 7.0694444 0.346823 7.0722222 0.348576 7.0750000 0.349077 7.0777778 0.347574 7.0805556 0.347074 7.0833333 0.345822 7.0861111 0.344069 7.0888889 0.340063 7.0916667 0.334304 7.0944444 0.329296 7.0972222 0.324789 7.1000000 0.320532 7.1027778 0.315775 7.1055556 0.310016 7.1083333 0.303505 7.1111111 0.294992 7.1138889 0.286729 7.1166667 0.281221 7.1194444 0.275962 7.1222222 0.270454 7.1250000 0.265947 7.1277778 0.262441 7.1305556 0.260438 7.1333333 0.258685 7.1361111 0.258435 7.1388889 0.258185 7.1416667 0.258185 7.1444444 0.258435 7.1472222 0.257684 7.1500000 0.257684 7.1527778 0.258936 7.1555556 0.261189 7.1583333 0.262191 7.1611111 0.263443 7.1638889 0.264945 7.1666667 0.266448 7.1694444 0.267449 7.1722222 0.268701 7.1750000 0.269452 7.1777778 0.269703 7.1805556 0.270454 7.1833333 0.272207 7.1861111 0.274210 7.1888889 0.275462 7.2016667 0.300000 7.6705556 0.300000 7.6805556 0.282222 7.6833333 0.282473 7.6861111 0.284726 7.6888889 0.288983 7.6916667 0.294491 7.6944444 0.301002 7.6972222 0.306009 7.7000000 0.310016 7.7027778 0.314272 7.7055556 0.317277 7.7083333 0.319781 7.7111111 0.321534 7.7138889 0.324789 7.7166667 0.328294 7.7194444 0.332801 7.7222222 0.337058 7.7250000 0.340313 7.7277778 0.341064 7.7305556 0.339812 7.7333333 0.337809 7.7361111 0.336557 7.7388889 0.335055 7.7416667 0.332551 7.7444444 0.328044 7.7472222 0.322285 7.7500000 0.318279 7.7527778 0.314773 7.7555556 0.310516 7.7583333 0.305509 7.7611111 0.300250 7.7638889 0.292488 7.7666667 0.284726 7.7694444 0.277465 7.7722222 0.272207 7.7750000 0.266948 7.7777778 0.261440 7.7805556 0.256432 7.7833333 0.253678 7.7861111 0.252426 7.7888889 0.251424 7.7916667 0.251925 7.7944444 0.251174 7.7972222 0.251174 7.8000000 0.252426 7.8027778 0.252926 7.8055556 0.254178 7.8083333 0.255180 7.8111111 0.256933 7.8138889 0.257934 7.8166667 0.258936 7.8194444 0.261189 7.8222222 0.262441 7.8250000 0.263944 7.8277778 0.263693 7.8305556 0.264695 7.8333333 0.265696 7.8361111 0.267950 7.8388889 0.269452 7.8416667 0.269452 7.8444444 0.269953 7.8572222 0.300000 8.3205556 0.300000 8.3305556 0.280469 8.3333333 0.281721 8.3361111 0.283975 8.3388889 0.289734 8.3416667 0.295994 8.3444444 0.301252 8.3472222 0.304257 8.3500000 0.307261 8.3527778 0.308513 8.3555556 0.309765 8.3583333 0.312019 8.3611111 0.314773 8.3638889 0.317778 8.3666667 0.321534 8.3694444 0.325540 8.3722222 0.329296 8.3750000 0.329797 8.3777778 0.329546 8.3805556 0.327543 8.3833333 0.327293 8.3861111 0.327042 8.3888889 0.326541 8.3916667 0.325290 8.3944444 0.321784 8.3972222 0.318028 8.4000000 0.315023 8.4027778 0.311768 8.4055556 0.308764 8.4083333 0.305509 8.4111111 0.300000 8.4138889 0.293740 8.4166667 0.287731 8.4194444 0.282222 8.4222222 0.276714 8.4250000 0.270203 8.4277778 0.264945 8.4305556 0.260438 8.4333333 0.257934 8.4361111 0.257183 8.4388889 0.256682 8.4416667 0.256432 8.4444444 0.255681 8.4472222 0.255430 8.4500000 0.255430 8.4527778 0.256182 8.4555556 0.257183 8.4583333 0.257934 8.4611111 0.258685 8.4638889 0.260438 8.4666667 0.262191 8.4694444 0.263693 8.4722222 0.264695 8.4750000 0.265446 8.4777778 0.265696 8.4805556 0.266448 8.4833333 0.268200 8.4861111 0.269953 8.4888889 0.270704 8.4916667 0.271205 8.4944444 0.271706 8.5072222 0.300000 8.9511111 0.300000 8.9611111 0.279718 8.9638889 0.279468 8.9666667 0.281471 8.9694444 0.285477 8.9722222 0.291487 8.9750000 0.296745 8.9777778 0.300751 8.9805556 0.302754 8.9833333 0.304006 8.9861111 0.305759 8.9888889 0.309765 8.9916667 0.313772 8.9944444 0.318279 8.9972222 0.321784 9.0000000 0.325290 9.0027778 0.328545 9.0055556 0.330548 9.0083333 0.331299 9.0111111 0.330548 9.0138889 0.330047 9.0166667 0.330047 9.0194444 0.328294 9.0222222 0.325790 9.0250000 0.321283 9.0277778 0.317027 9.0305556 0.313772 9.0333333 0.311518 9.0361111 0.308513 9.0388889 0.303255 9.0416667 0.297496 9.0444444 0.290235 9.0472222 0.283474 9.0500000 0.276714 9.0527778 0.270955 9.0555556 0.266698 9.0583333 0.263693 9.0611111 0.260689 9.0638889 0.258685 9.0666667 0.257433 9.0694444 0.257183 9.0722222 0.256933 9.0750000 0.257934 9.0777778 0.257433 9.0805556 0.256432 9.0833333 0.256432 9.0861111 0.257684 9.0888889 0.259437 9.0916667 0.261189 9.0944444 0.262191 9.0972222 0.261941 9.1000000 0.264194 9.1027778 0.265196 9.1055556 0.265947 9.1083333 0.267449 9.1111111 0.267950 9.1138889 0.269202 9.1166667 0.270203 9.1194444 0.271455 9.1222222 0.272707 9.1250000 0.272958 9.1377778 0.300000 9.5844444 0.300000 9.5944444 0.278717 9.5972222 0.278717 9.6000000 0.280970 9.6027778 0.284977 9.6055556 0.289984 9.6083333 0.295493 9.6111111 0.300250 9.6138889 0.303756 9.6166667 0.306260 9.6194444 0.308263 9.6222222 0.312269 9.6250000 0.317277 9.6277778 0.322786 9.6305556 0.326792 9.6333333 0.332050 9.6361111 0.336307 9.6388889 0.339311 9.6416667 0.341064 9.6444444 0.341064 9.6472222 0.339812 9.6500000 0.338811 9.6527778 0.337809 9.6555556 0.335055 9.6583333 0.330047 9.6611111 0.325039 9.6638889 0.320532 9.6666667 0.316526 9.6694444 0.313521 9.6722222 0.308513 9.6750000 0.302504 9.6777778 0.294742 9.6805556 0.286729 9.6833333 0.280720 9.6861111 0.274961 9.6888889 0.268951 9.6916667 0.262692 9.6944444 0.259437 9.6972222 0.256933 9.7000000 0.255180 9.7027778 0.254679 9.7055556 0.254930 9.7083333 0.254930 9.7111111 0.254178 9.7138889 0.253427 9.7166667 0.254178 9.7194444 0.255180 9.7222222 0.257183 9.7250000 0.258936 9.7277778 0.260689 9.7305556 0.261189 9.7333333 0.262692 9.7361111 0.264194 9.7388889 0.264444 9.7416667 0.265947 9.7444444 0.266448 9.7472222 0.266448 9.7500000 0.268200 9.7527778 0.269452 9.7555556 0.270955 9.7583333 0.271706 9.7711111 0.300000 10.2038889 0.300000 10.2138889 0.279969 10.2166667 0.279718 10.2194444 0.278717 10.2222222 0.279218 10.2250000 0.279969 10.2277778 0.281471 10.2305556 0.287230 10.2333333 0.294992 10.2361111 0.303505 10.2388889 0.309264 10.2416667 0.313521 10.2444444 0.316025 10.2472222 0.318779 10.2500000 0.324538 10.2527778 0.330548 10.2555556 0.335806 10.2583333 0.341064 10.2611111 0.345070 10.2638889 0.346072 10.2666667 0.346573 10.2694444 0.345571 10.2722222 0.344319 10.2750000 0.340814 10.2777778 0.335305 10.2805556 0.328545 10.2833333 0.322034 10.2861111 0.316275 10.2888889 0.312019 10.2916667 0.305509 10.2944444 0.298748 10.2972222 0.289734 10.3000000 0.281221 10.3027778 0.274210 10.3055556 0.267700 10.3083333 0.260689 10.3111111 0.254930 10.3138889 0.250923 10.3166667 0.249421 10.3194444 0.248419 10.3222222 0.247919 10.3250000 0.248920 10.3277778 0.249171 10.3305556 0.248670 10.3333333 0.249421 10.3361111 0.250423 10.3388889 0.252175 10.3416667 0.254679 10.3444444 0.256432 10.3472222 0.257934 10.3500000 0.258435 10.3527778 0.260438 10.3555556 0.260939 10.3583333 0.262441 10.3611111 0.263192 10.3638889 0.264194 10.3666667 0.265696 10.3694444 0.267199 10.3722222 0.268451 10.3750000 0.268951 10.3777778 0.268951 10.3905556 0.300000 10.8038889 0.300000 10.8138889 0.277715 10.8166667 0.277715 10.8194444 0.278216 10.8222222 0.279218 10.8250000 0.281471 10.8277778 0.285978 10.8305556 0.291987 10.8333333 0.299249 10.8361111 0.305008 10.8388889 0.309765 10.8416667 0.313020 10.8444444 0.313772 10.8472222 0.315274 10.8500000 0.319280 10.8527778 0.324288 10.8555556 0.328795 10.8583333 0.332050 10.8611111 0.334804 10.8638889 0.334804 10.8666667 0.333803 10.8694444 0.332050 10.8722222 0.330548 10.8750000 0.328545 10.8777778 0.325290 10.8805556 0.320031 10.8833333 0.315524 10.8861111 0.311268 10.8888889 0.306761 10.8916667 0.302754 10.8944444 0.297496 10.8972222 0.290485 10.9000000 0.282723 10.9027778 0.275962 10.9055556 0.269703 10.9083333 0.263192 10.9111111 0.257183 10.9138889 0.252676 10.9166667 0.249922 10.9194444 0.249171 10.9222222 0.248419 10.9250000 0.248419 10.9277778 0.248419 10.9305556 0.248419 10.9333333 0.248670 10.9361111 0.249671 10.9388889 0.251424 10.9416667 0.253177 10.9444444 0.254679 10.9472222 0.255681 10.9500000 0.257433 10.9527778 0.258936 10.9555556 0.259437 10.9583333 0.260188 10.9611111 0.260939 10.9638889 0.262191 10.9666667 0.264444 10.9694444 0.265947 10.9722222 0.266948 10.9750000 0.267449 10.9777778 0.267199 10.9905556 0.300000 11.3872222 0.300000 11.3972222 0.278967 11.4000000 0.278967 11.4027778 0.279218 11.4055556 0.280469 11.4083333 0.284726 11.4111111 0.290736 11.4138889 0.296745 11.4166667 0.302003 11.4194444 0.305509 11.4222222 0.307011 11.4250000 0.307762 11.4277778 0.310767 11.4305556 0.315274 11.4333333 0.320282 11.4361111 0.324789 11.4388889 0.328795 11.4416667 0.331549 11.4444444 0.332801 11.4472222 0.332050 11.4500000 0.331549 11.4527778 0.331299 11.4555556 0.331299 11.4583333 0.328795 11.4611111 0.325039 11.4638889 0.320031 11.4666667 0.316275 11.4694444 0.314022 11.4722222 0.310516 11.4750000 0.307261 11.4777778 0.302003 11.4805556 0.295493 11.4833333 0.288732 11.4861111 0.280970 11.4888889 0.275712 11.4916667 0.268701 11.4944444 0.262942 11.4972222 0.258936 11.5000000 0.256432 11.5027778 0.255681 11.5055556 0.254930 11.5083333 0.253678 11.5111111 0.253427 11.5138889 0.253177 11.5166667 0.254178 11.5194444 0.254178 11.5222222 0.255180 11.5250000 0.256432 11.5277778 0.257433 11.5305556 0.258936 11.5333333 0.260438 11.5361111 0.262692 11.5388889 0.263443 11.5416667 0.264194 11.5444444 0.263944 11.5472222 0.265196 11.5500000 0.266948 11.5527778 0.268451 11.5555556 0.269703 11.5583333 0.270203 11.5611111 0.270454 11.5738889 0.300000 11.9927778 0.300000 12.0027778 0.280970 12.0055556 0.280219 12.0083333 0.281221 12.0111111 0.282723 12.0138889 0.286479 12.0166667 0.293740 12.0194444 0.299750 12.0222222 0.304257 12.0250000 0.306260 12.0277778 0.307261 12.0305556 0.309264 12.0333333 0.314773 12.0361111 0.320282 12.0388889 0.326291 12.0416667 0.330798 12.0444444 0.334804 12.0472222 0.337308 12.0500000 0.339311 12.0527778 0.340563 12.0555556 0.341064 12.0583333 0.340814 12.0611111 0.338811 12.0638889 0.335806 12.0666667 0.331299 12.0694444 0.326541 12.0722222 0.322786 12.0750000 0.319531 12.0777778 0.314523 12.0805556 0.308013 12.0833333 0.302754 12.0861111 0.296495 12.0888889 0.288983 12.0916667 0.280970 12.0944444 0.273208 12.0972222 0.267199 12.1000000 0.262942 12.1027778 0.261189 12.1055556 0.259687 12.1083333 0.257684 12.1111111 0.256933 12.1138889 0.255931 12.1166667 0.256182 12.1194444 0.256432 12.1222222 0.256682 12.1250000 0.256682 12.1277778 0.257433 12.1305556 0.257934 12.1333333 0.260438 12.1361111 0.262441 12.1388889 0.264194 12.1416667 0.264695 12.1444444 0.264945 12.1472222 0.265696 12.1500000 0.267199 12.1527778 0.268451 12.1555556 0.270454 12.1583333 0.270955 12.1611111 0.271455 12.1638889 0.271706 12.1666667 0.272958 12.1794444 0.300000 12.6038889 0.300000 12.6138889 0.280219 12.6166667 0.279718 12.6194444 0.280720 12.6222222 0.283975 12.6250000 0.289233 12.6277778 0.295493 12.6305556 0.301502 12.6333333 0.305759 12.6361111 0.309264 12.6388889 0.311518 12.6416667 0.314773 12.6444444 0.319531 12.6472222 0.325039 12.6500000 0.331049 12.6527778 0.336056 12.6555556 0.340814 12.6583333 0.344570 12.6611111 0.346573 12.6638889 0.346823 12.6666667 0.347324 12.6694444 0.346573 12.6722222 0.344820 12.6750000 0.340563 12.6777778 0.334304 12.6805556 0.328044 12.6833333 0.323787 12.6861111 0.320031 12.6888889 0.315023 12.6916667 0.308263 12.6944444 0.299499 12.6972222 0.291236 12.7000000 0.282473 12.7027778 0.276213 12.7055556 0.269202 12.7083333 0.263443 12.7111111 0.260188 12.7138889 0.257433 12.7166667 0.256432 12.7194444 0.255180 12.7222222 0.254679 12.7250000 0.254930 12.7277778 0.254930 12.7305556 0.254679 12.7333333 0.254429 12.7361111 0.256432 12.7388889 0.257934 12.7416667 0.259937 12.7444444 0.260689 12.7472222 0.262191 12.7500000 0.263693 12.7527778 0.265196 12.7555556 0.266197 12.7583333 0.267199 12.7611111 0.267449 12.7638889 0.268451 12.7666667 0.269703 12.7694444 0.271455 12.7722222 0.272207 12.7750000 0.272958 12.7777778 0.272707 12.7905556 0.300000 13.2427778 0.300000 13.2527778 0.280219 13.2555556 0.280219 13.2583333 0.280469 13.2611111 0.282473 13.2638889 0.286228 13.2666667 0.293490 13.2694444 0.300751 13.2722222 0.307261 13.2750000 0.312269 13.2777778 0.315775 13.2805556 0.317527 13.2833333 0.320782 13.2861111 0.326291 13.2888889 0.331800 13.2916667 0.337058 13.2944444 0.341315 13.2972222 0.345822 13.3000000 0.350579 13.3027778 0.352833 13.3055556 0.353333 13.3083333 0.352081 13.3111111 0.350829 13.3138889 0.348576 13.3166667 0.344570 13.3194444 0.339311 13.3222222 0.332551 13.3250000 0.326291 13.3277778 0.321033 13.3305556 0.315274 13.3333333 0.309765 13.3361111 0.304507 13.3388889 0.296995 13.3416667 0.287731 13.3444444 0.279218 13.3472222 0.271455 13.3500000 0.265196 13.3527778 0.259437 13.3555556 0.254679 13.3583333 0.251174 13.3611111 0.249421 13.3638889 0.247418 13.3666667 0.247668 13.3694444 0.248169 13.3722222 0.248920 13.3750000 0.248419 13.3777778 0.248169 13.3805556 0.248419 13.3833333 0.250423 13.3861111 0.253177 13.3888889 0.255180 13.3916667 0.256182 13.3944444 0.257934 13.3972222 0.258435 13.4000000 0.260438 13.4027778 0.261440 13.4055556 0.262692 13.4083333 0.264194 13.4111111 0.264695 13.4138889 0.265696 13.4166667 0.266948 13.4294444 0.300000 13.8927778 0.300000 13.9027778 0.279718 13.9055556 0.281221 13.9083333 0.283975 13.9111111 0.288482 13.9138889 0.295493 13.9166667 0.301502 13.9194444 0.306761 13.9222222 0.311518 13.9250000 0.313271 13.9277778 0.314272 13.9305556 0.316275 13.9333333 0.320532 13.9361111 0.325790 13.9388889 0.330047 13.9416667 0.333803 13.9444444 0.336307 13.9472222 0.338560 13.9500000 0.340313 13.9527778 0.340313 13.9555556 0.339061 13.9583333 0.337809 13.9611111 0.336056 13.9638889 0.334304 13.9666667 0.330798 13.9694444 0.327042 13.9722222 0.322285 13.9750000 0.318279 13.9777778 0.314523 13.9805556 0.310266 13.9833333 0.307011 13.9861111 0.302504 13.9888889 0.297746 13.9916667 0.290736 13.9944444 0.282973 13.9972222 0.276213 14.0000000 0.270704 14.0027778 0.265446 14.0055556 0.260939 14.0083333 0.256432 14.0111111 0.252926 14.0138889 0.250673 14.0166667 0.249922 14.0194444 0.249922 14.0222222 0.249421 14.0250000 0.249671 14.0277778 0.249171 14.0305556 0.249171 14.0333333 0.249922 14.0361111 0.251174 14.0388889 0.252426 14.0416667 0.254429 14.0444444 0.255681 14.0472222 0.256933 14.0500000 0.258185 14.0527778 0.260438 14.0555556 0.261440 14.0583333 0.261690 14.0611111 0.262692 14.0638889 0.263443 14.0666667 0.265446 14.0794444 0.300000 14.5261111 0.300000 14.5361111 0.278967 14.5388889 0.279718 14.5416667 0.281471 14.5444444 0.283474 14.5472222 0.288983 14.5500000 0.295994 14.5527778 0.302003 14.5555556 0.306761 14.5583333 0.308513 14.5611111 0.309765 14.5638889 0.312269 14.5666667 0.317277 14.5694444 0.324789 14.5722222 0.330548 14.5750000 0.334554 14.5777778 0.338811 14.5805556 0.340814 14.5833333 0.342066 14.5861111 0.342817 14.5888889 0.342567 14.5916667 0.341315 14.5944444 0.339562 14.5972222 0.337058 14.6000000 0.332050 14.6027778 0.328044 14.6055556 0.324288 14.6083333 0.321033 14.6111111 0.316526 14.6138889 0.311768 14.6166667 0.306510 14.6194444 0.300250 14.6222222 0.293490 14.6250000 0.286228 14.6277778 0.278967 14.6305556 0.271956 14.6333333 0.265446 14.6361111 0.261440 14.6388889 0.258685 14.6416667 0.256682 14.6444444 0.253928 14.6472222 0.253427 14.6500000 0.253177 14.6527778 0.253427 14.6555556 0.253678 14.6583333 0.253678 14.6611111 0.253177 14.6638889 0.253427 14.6666667 0.255180 14.6694444 0.256933 14.6722222 0.258936 14.6750000 0.260438 14.6777778 0.261690 14.6805556 0.261690 14.6833333 0.262942 14.6861111 0.264194 14.6888889 0.265446 14.6916667 0.266948 14.6944444 0.266948 14.6972222 0.268701 14.7000000 0.269452 14.7127778 0.300000 15.1566667 0.300000 15.1666667 0.279468 15.1694444 0.279718 15.1722222 0.279468 15.1750000 0.280970 15.1777778 0.284726 15.1805556 0.289984 15.1833333 0.296495 15.1861111 0.302754 15.1888889 0.306510 15.1916667 0.309014 15.1944444 0.312019 15.1972222 0.315775 15.2000000 0.323036 15.2027778 0.329546 15.2055556 0.335305 15.2083333 0.339562 15.2111111 0.342817 15.2138889 0.345571 15.2166667 0.347324 15.2194444 0.348826 15.2222222 0.348326 15.2250000 0.346823 15.2277778 0.343568 15.2305556 0.338059 15.2333333 0.332300 15.2361111 0.327543 15.2388889 0.323286 15.2416667 0.318279 15.2444444 0.311518 15.2472222 0.305008 15.2500000 0.297246 15.2527778 0.288732 15.2555556 0.281972 15.2583333 0.274210 15.2611111 0.267700 15.2638889 0.262692 15.2666667 0.259937 15.2694444 0.257934 15.2722222 0.255931 15.2750000 0.255180 15.2777778 0.254679 15.2805556 0.254429 15.2833333 0.254930 15.2861111 0.255180 15.2888889 0.255430 15.2916667 0.256432 15.2944444 0.257433 15.2972222 0.259186 15.3000000 0.260689 15.3027778 0.262942 15.3055556 0.263944 15.3083333 0.264194 15.3111111 0.265196 15.3138889 0.266698 15.3166667 0.267950 15.3194444 0.268701 15.3222222 0.270454 15.3250000 0.270955 15.3277778 0.270955 15.3305556 0.270955 15.3433333 0.300000 15.7455556 0.300000 15.7555556 0.275962 15.7583333 0.275211 15.7611111 0.272457 15.7638889 0.270704 15.7666667 0.269703 15.7694444 0.269452 15.7722222 0.269953 15.7750000 0.273208 15.7777778 0.278216 15.7805556 0.286228 15.7833333 0.295743 15.7861111 0.304757 15.7888889 0.311268 15.7916667 0.314272 15.7944444 0.318529 15.7972222 0.326041 15.8000000 0.336557 15.8027778 0.348075 15.8055556 0.358842 15.8083333 0.368357 15.8111111 0.375117 15.8138889 0.377872 15.8166667 0.374366 15.8194444 0.367355 15.8222222 0.357089 15.8250000 0.344570 15.8277778 0.331800 15.8305556 0.316526 15.8333333 0.301502 15.8361111 0.291987 15.8388889 0.285728 15.8416667 0.280219 15.8444444 0.277715 15.8472222 0.276964 15.8500000 0.276964 15.8527778 0.277465 15.8555556 0.277214 15.8583333 0.276714 15.8611111 0.276463 15.8638889 0.275712 15.8666667 0.276463 15.8694444 0.276213 15.8722222 0.276213 15.8750000 0.275962 15.8777778 0.275462 15.8805556 0.275211 15.8833333 0.275462 15.8861111 0.275462 15.8888889 0.275712 15.8916667 0.275462 15.8944444 0.275211 15.8972222 0.274210 15.9000000 0.274710 15.9027778 0.274710 15.9055556 0.275211 15.9083333 0.274460 15.9111111 0.273709 15.9138889 0.273459 15.9166667 0.272958 15.9194444 0.273709 15.9322222 0.300000 16.3650000 0.300000 16.3750000 0.279969 16.3777778 0.279468 16.3805556 0.279969 16.3833333 0.283224 16.3861111 0.289233 16.3888889 0.296495 16.3916667 0.303005 16.3944444 0.309264 16.3972222 0.314022 16.4000000 0.317778 16.4027778 0.321283 16.4055556 0.326541 16.4083333 0.333552 16.4111111 0.338811 16.4138889 0.343818 16.4166667 0.348576 16.4194444 0.353584 16.4222222 0.357089 16.4250000 0.358592 16.4277778 0.358091 16.4305556 0.357590 16.4333333 0.354836 16.4361111 0.352833 16.4388889 0.348576 16.4416667 0.341064 16.4444444 0.333302 16.4472222 0.326041 16.4500000 0.321784 16.4527778 0.316776 16.4555556 0.311017 16.4583333 0.303505 16.4611111 0.295493 16.4638889 0.287230 16.4666667 0.280219 16.4694444 0.272207 16.4722222 0.265696 16.4750000 0.258685 16.4777778 0.253928 16.4805556 0.249922 16.4833333 0.247919 16.4861111 0.246667 16.4888889 0.246917 16.4916667 0.245915 16.4944444 0.246166 16.4972222 0.245915 16.5000000 0.246667 16.5027778 0.246667 16.5055556 0.247919 16.5083333 0.249421 16.5111111 0.251174 16.5138889 0.252926 16.5166667 0.255180 16.5194444 0.256933 16.5222222 0.257934 16.5250000 0.258936 16.5277778 0.258685 16.5305556 0.260188 16.5333333 0.262191 16.5361111 0.263443 16.5388889 0.264695 16.5516667 0.300000 16.9594444 0.300000 16.9694444 0.277214 16.9722222 0.276714 16.9750000 0.276213 16.9777778 0.275712 16.9805556 0.276714 16.9833333 0.280720 16.9861111 0.287981 16.9888889 0.295743 16.9916667 0.302003 16.9944444 0.307261 16.9972222 0.310516 17.0000000 0.313020 17.0027778 0.316776 17.0055556 0.321534 17.0083333 0.327543 17.0111111 0.332050 17.0138889 0.336808 17.0166667 0.341565 17.0194444 0.344069 17.0222222 0.344319 17.0250000 0.343067 17.0277778 0.341565 17.0305556 0.339311 17.0333333 0.336056 17.0361111 0.331299 17.0388889 0.324538 17.0416667 0.319280 17.0444444 0.314773 17.0472222 0.309515 17.0500000 0.303756 17.0527778 0.297746 17.0555556 0.290235 17.0583333 0.281221 17.0611111 0.273208 17.0638889 0.265947 17.0666667 0.259937 17.0694444 0.254429 17.0722222 0.250923 17.0750000 0.248670 17.0777778 0.247167 17.0805556 0.246416 17.0833333 0.246166 17.0861111 0.247919 17.0888889 0.248419 17.0916667 0.247919 17.0944444 0.248419 17.0972222 0.249421 17.1000000 0.251925 17.1027778 0.253678 17.1055556 0.256182 17.1083333 0.257433 17.1111111 0.257934 17.1138889 0.258435 17.1166667 0.259937 17.1194444 0.261440 17.1222222 0.263443 17.1250000 0.264194 17.1277778 0.264194 17.1305556 0.264695 17.1333333 0.265446 17.1461111 0.300000 17.5761111 0.300000 17.5861111 0.277214 17.5888889 0.277465 17.5916667 0.277214 17.5944444 0.278466 17.5972222 0.282973 17.6000000 0.289484 17.6027778 0.296745 17.6055556 0.302254 17.6083333 0.306510 17.6111111 0.308513 17.6138889 0.310767 17.6166667 0.316275 17.6194444 0.322786 17.6222222 0.329546 17.6250000 0.334804 17.6277778 0.339311 17.6305556 0.342567 17.6333333 0.345070 17.6361111 0.346072 17.6388889 0.346573 17.6416667 0.345070 17.6444444 0.343067 17.6472222 0.339061 17.6500000 0.333803 17.6527778 0.328294 17.6555556 0.324038 17.6583333 0.319531 17.6611111 0.314773 17.6638889 0.307762 17.6666667 0.300501 17.6694444 0.293740 17.6722222 0.285728 17.6750000 0.277715 17.6777778 0.270203 17.6805556 0.263192 17.6833333 0.259186 17.6861111 0.256432 17.6888889 0.254178 17.6916667 0.252175 17.6944444 0.250673 17.6972222 0.250172 17.7000000 0.250923 17.7027778 0.251424 17.7055556 0.252426 17.7083333 0.252926 17.7111111 0.253928 17.7138889 0.255681 17.7166667 0.257934 17.7194444 0.259937 17.7222222 0.261440 17.7250000 0.261941 17.7277778 0.262441 17.7305556 0.264194 17.7333333 0.265696 17.7361111 0.266948 17.7388889 0.267700 17.7416667 0.268701 17.7444444 0.268951 17.7472222 0.268451 17.7500000 0.268951 17.7627778 0.300000 18.1761111 0.300000 18.1861111 0.277966 18.1888889 0.278216 18.1916667 0.278216 18.1944444 0.280469 18.1972222 0.284225 18.2000000 0.291487 18.2027778 0.298498 18.2055556 0.303756 18.2083333 0.307261 18.2111111 0.309515 18.2138889 0.312770 18.2166667 0.319030 18.2194444 0.325790 18.2222222 0.332801 18.2250000 0.338059 18.2277778 0.343067 18.2305556 0.346322 18.2333333 0.349577 18.2361111 0.351581 18.2388889 0.352332 18.2416667 0.351330 18.2444444 0.349327 18.2472222 0.346322 18.2500000 0.340563 18.2527778 0.334804 18.2555556 0.329797 18.2583333 0.325039 18.2611111 0.319781 18.2638889 0.313271 18.2666667 0.306510 18.2694444 0.300000 18.2722222 0.291987 18.2750000 0.283474 18.2777778 0.274961 18.2805556 0.267449 18.2833333 0.261941 18.2861111 0.258936 18.2888889 0.256182 18.2916667 0.253678 18.2944444 0.252175 18.2972222 0.250673 18.3000000 0.251424 18.3027778 0.252175 18.3055556 0.252426 18.3083333 0.251674 18.3111111 0.251925 18.3138889 0.253177 18.3166667 0.255931 18.3194444 0.258435 18.3222222 0.259437 18.3250000 0.260939 18.3277778 0.261690 18.3305556 0.262191 18.3333333 0.263944 18.3361111 0.265446 18.3388889 0.266948 18.3416667 0.267199 18.3444444 0.268451 18.3472222 0.268451 18.3500000 0.269202 18.3627778 0.300000 18.7955556 0.300000 18.8055556 0.277715 18.8083333 0.277465 18.8111111 0.278216 18.8138889 0.280970 18.8166667 0.286228 18.8194444 0.292989 18.8222222 0.298998 18.8250000 0.304757 18.8277778 0.308513 18.8305556 0.311017 18.8333333 0.315775 18.8361111 0.322034 18.8388889 0.329045 18.8416667 0.335305 18.8444444 0.340814 18.8472222 0.345571 18.8500000 0.350579 18.8527778 0.354335 18.8555556 0.355336 18.8583333 0.356338 18.8611111 0.355837 18.8638889 0.354085 18.8666667 0.351080 18.8694444 0.347324 18.8722222 0.340313 18.8750000 0.333552 18.8777778 0.328294 18.8805556 0.323286 18.8833333 0.318279 18.8861111 0.312520 18.8888889 0.305008 18.8916667 0.296745 18.8944444 0.288232 18.8972222 0.278967 18.9000000 0.271706 18.9027778 0.266448 18.9055556 0.261440 18.9083333 0.257684 18.9111111 0.254429 18.9138889 0.251925 18.9166667 0.250673 18.9194444 0.250172 18.9222222 0.250423 18.9250000 0.250423 18.9277778 0.250923 18.9305556 0.250423 18.9333333 0.250673 18.9361111 0.251424 18.9388889 0.253177 18.9416667 0.254930 18.9444444 0.256432 18.9472222 0.258185 18.9500000 0.259437 18.9527778 0.260438 18.9555556 0.261690 18.9583333 0.262191 18.9611111 0.263192 18.9638889 0.264695 18.9666667 0.265947 18.9694444 0.267449 18.9822222 0.300000 19.4261111 0.300000 19.4361111 0.278717 19.4388889 0.278967 19.4416667 0.280720 19.4444444 0.284476 19.4472222 0.290736 19.4500000 0.297997 19.4527778 0.305008 19.4555556 0.310266 19.4583333 0.314523 19.4611111 0.317527 19.4638889 0.320782 19.4666667 0.326792 19.4694444 0.332801 19.4722222 0.338811 19.4750000 0.344069 19.4777778 0.348826 19.4805556 0.353834 19.4833333 0.357840 19.4861111 0.360344 19.4888889 0.360845 19.4916667 0.360094 19.4944444 0.357840 19.4972222 0.354335 19.5000000 0.351080 19.5027778 0.345321 19.5055556 0.337559 19.5083333 0.329797 19.5111111 0.323537 19.5138889 0.317527 19.5166667 0.312269 19.5194444 0.305008 19.5222222 0.296995 19.5250000 0.287731 19.5277778 0.279218 19.5305556 0.271205 19.5333333 0.264695 19.5361111 0.259437 19.5388889 0.254930 19.5416667 0.251925 19.5444444 0.248670 19.5472222 0.247418 19.5500000 0.247919 19.5527778 0.248169 19.5555556 0.248920 19.5583333 0.249171 19.5611111 0.249171 19.5638889 0.248670 19.5666667 0.250172 19.5694444 0.251925 19.5722222 0.253678 19.5750000 0.255931 19.5777778 0.257183 19.5805556 0.257684 19.5833333 0.258685 19.5861111 0.261189 19.5888889 0.260939 19.5916667 0.261690 19.5944444 0.262441 19.5972222 0.264444 19.6000000 0.265196 19.6127778 0.300000 20.0927778 0.300000 20.1027778 0.279218 20.1055556 0.279969 20.1083333 0.281721 20.1111111 0.285728 20.1138889 0.291987 20.1166667 0.299750 20.1194444 0.306260 20.1222222 0.312019 20.1250000 0.315775 20.1277778 0.317778 20.1305556 0.320031 20.1333333 0.325790 20.1361111 0.331549 20.1388889 0.336307 20.1416667 0.341565 20.1444444 0.346322 20.1472222 0.350329 20.1500000 0.353083 20.1527778 0.354085 20.1555556 0.353333 20.1583333 0.352332 20.1611111 0.350078 20.1638889 0.347324 20.1666667 0.343067 20.1694444 0.337809 20.1722222 0.331049 20.1750000 0.325039 20.1777778 0.319781 20.1805556 0.314523 20.1833333 0.309014 20.1861111 0.302504 20.1888889 0.293991 20.1916667 0.285227 20.1944444 0.277214 20.1972222 0.270203 20.2000000 0.263944 20.2027778 0.258685 20.2055556 0.255430 20.2083333 0.252676 20.2111111 0.249922 20.2138889 0.249671 20.2166667 0.248920 20.2194444 0.249922 20.2222222 0.250172 20.2250000 0.250923 20.2277778 0.249922 20.2305556 0.250423 20.2333333 0.252175 20.2361111 0.253928 20.2388889 0.256182 20.2416667 0.257934 20.2444444 0.258685 20.2472222 0.258936 20.2500000 0.260939 20.2527778 0.261690 20.2555556 0.262942 20.2583333 0.263693 20.2611111 0.264945 20.2638889 0.265696 20.2666667 0.266948 20.2794444 0.300000 22.1583333 0.300000)
Vs14 sample14_trig 0 PWL(0.0000000 0.000000 2.0133889 0.000000 2.0138889 0.900000 2.0148889 0.900000 2.0153889 0.000000 2.6689444 0.000000 2.6694444 0.900000 2.6704444 0.900000 2.6709444 0.000000 3.3411667 0.000000 3.3416667 0.900000 3.3426667 0.900000 3.3431667 0.000000 3.9772778 0.000000 3.9777778 0.900000 3.9787778 0.900000 3.9792778 0.000000 4.6022778 0.000000 4.6027778 0.900000 4.6037778 0.900000 4.6042778 0.000000 5.2022778 0.000000 5.2027778 0.900000 5.2037778 0.900000 5.2042778 0.000000 5.8300556 0.000000 5.8305556 0.900000 5.8315556 0.900000 5.8320556 0.000000 6.4467222 0.000000 6.4472222 0.900000 6.4482222 0.900000 6.4487222 0.000000 7.0939444 0.000000 7.0944444 0.900000 7.0954444 0.900000 7.0959444 0.000000 7.7495000 0.000000 7.7500000 0.900000 7.7510000 0.900000 7.7515000 0.000000 8.3995000 0.000000 8.4000000 0.900000 8.4010000 0.900000 8.4015000 0.000000 9.0300556 0.000000 9.0305556 0.900000 9.0315556 0.900000 9.0320556 0.000000 9.6633889 0.000000 9.6638889 0.900000 9.6648889 0.900000 9.6653889 0.000000 10.2828333 0.000000 10.2833333 0.900000 10.2843333 0.900000 10.2848333 0.000000 10.8828333 0.000000 10.8833333 0.900000 10.8843333 0.900000 10.8848333 0.000000 11.4661667 0.000000 11.4666667 0.900000 11.4676667 0.900000 11.4681667 0.000000 12.0717222 0.000000 12.0722222 0.900000 12.0732222 0.900000 12.0737222 0.000000 12.6828333 0.000000 12.6833333 0.900000 12.6843333 0.900000 12.6848333 0.000000 13.3217222 0.000000 13.3222222 0.900000 13.3232222 0.900000 13.3237222 0.000000 13.9717222 0.000000 13.9722222 0.900000 13.9732222 0.900000 13.9737222 0.000000 14.6050556 0.000000 14.6055556 0.900000 14.6065556 0.900000 14.6070556 0.000000 15.2356111 0.000000 15.2361111 0.900000 15.2371111 0.900000 15.2376111 0.000000 15.8245000 0.000000 15.8250000 0.900000 15.8260000 0.900000 15.8265000 0.000000 16.4439444 0.000000 16.4444444 0.900000 16.4454444 0.900000 16.4459444 0.000000 17.0383889 0.000000 17.0388889 0.900000 17.0398889 0.900000 17.0403889 0.000000 17.6550556 0.000000 17.6555556 0.900000 17.6565556 0.900000 17.6570556 0.000000 18.2550556 0.000000 18.2555556 0.900000 18.2565556 0.900000 18.2570556 0.000000 18.8745000 0.000000 18.8750000 0.900000 18.8760000 0.900000 18.8765000 0.000000 19.5050556 0.000000 19.5055556 0.900000 19.5065556 0.900000 19.5070556 0.000000 20.1717222 0.000000 20.1722222 0.900000 20.1732222 0.900000 20.1737222 0.000000 22.1583333 0.000000)
Vs69 sample69_trig 0 PWL(0.0000000 0.000000 2.0689444 0.000000 2.0694444 0.900000 2.0704444 0.900000 2.0709444 0.000000 2.7245000 0.000000 2.7250000 0.900000 2.7260000 0.900000 2.7265000 0.000000 3.3967222 0.000000 3.3972222 0.900000 3.3982222 0.900000 3.3987222 0.000000 4.0328333 0.000000 4.0333333 0.900000 4.0343333 0.900000 4.0348333 0.000000 4.6578333 0.000000 4.6583333 0.900000 4.6593333 0.900000 4.6598333 0.000000 5.2578333 0.000000 5.2583333 0.900000 5.2593333 0.900000 5.2598333 0.000000 5.8856111 0.000000 5.8861111 0.900000 5.8871111 0.900000 5.8876111 0.000000 6.5022778 0.000000 6.5027778 0.900000 6.5037778 0.900000 6.5042778 0.000000 7.1495000 0.000000 7.1500000 0.900000 7.1510000 0.900000 7.1515000 0.000000 7.8050556 0.000000 7.8055556 0.900000 7.8065556 0.900000 7.8070556 0.000000 8.4550556 0.000000 8.4555556 0.900000 8.4565556 0.900000 8.4570556 0.000000 9.0856111 0.000000 9.0861111 0.900000 9.0871111 0.900000 9.0876111 0.000000 9.7189444 0.000000 9.7194444 0.900000 9.7204444 0.900000 9.7209444 0.000000 10.3383889 0.000000 10.3388889 0.900000 10.3398889 0.900000 10.3403889 0.000000 10.9383889 0.000000 10.9388889 0.900000 10.9398889 0.900000 10.9403889 0.000000 11.5217222 0.000000 11.5222222 0.900000 11.5232222 0.900000 11.5237222 0.000000 12.1272778 0.000000 12.1277778 0.900000 12.1287778 0.900000 12.1292778 0.000000 12.7383889 0.000000 12.7388889 0.900000 12.7398889 0.900000 12.7403889 0.000000 13.3772778 0.000000 13.3777778 0.900000 13.3787778 0.900000 13.3792778 0.000000 14.0272778 0.000000 14.0277778 0.900000 14.0287778 0.900000 14.0292778 0.000000 14.6606111 0.000000 14.6611111 0.900000 14.6621111 0.900000 14.6626111 0.000000 15.2911667 0.000000 15.2916667 0.900000 15.2926667 0.900000 15.2931667 0.000000 15.8800556 0.000000 15.8805556 0.900000 15.8815556 0.900000 15.8820556 0.000000 16.4995000 0.000000 16.5000000 0.900000 16.5010000 0.900000 16.5015000 0.000000 17.0939444 0.000000 17.0944444 0.900000 17.0954444 0.900000 17.0959444 0.000000 17.7106111 0.000000 17.7111111 0.900000 17.7121111 0.900000 17.7126111 0.000000 18.3106111 0.000000 18.3111111 0.900000 18.3121111 0.900000 18.3126111 0.000000 18.9300556 0.000000 18.9305556 0.900000 18.9315556 0.900000 18.9320556 0.000000 19.5606111 0.000000 19.5611111 0.900000 19.5621111 0.900000 19.5626111 0.000000 20.2272778 0.000000 20.2277778 0.900000 20.2287778 0.900000 20.2292778 0.000000 22.1583333 0.000000)

Xslope ecg_in sample14_trig sample69_trig slope_out vdd vss vbias qrs_slope

.tran 0.1m 22.1583

.meas tran slope_b0 FIND V(slope_out) AT=2.0804444
.meas tran slope_b1 FIND V(slope_out) AT=2.7360000
.meas tran slope_b2 FIND V(slope_out) AT=3.4082222
.meas tran slope_b3 FIND V(slope_out) AT=4.0443333
.meas tran slope_b4 FIND V(slope_out) AT=4.6693333
.meas tran slope_b5 FIND V(slope_out) AT=5.2693333
.meas tran slope_b6 FIND V(slope_out) AT=5.8971111
.meas tran slope_b7 FIND V(slope_out) AT=6.5137778
.meas tran slope_b8 FIND V(slope_out) AT=7.1610000
.meas tran slope_b9 FIND V(slope_out) AT=7.8165556
.meas tran slope_b10 FIND V(slope_out) AT=8.4665556
.meas tran slope_b11 FIND V(slope_out) AT=9.0971111
.meas tran slope_b12 FIND V(slope_out) AT=9.7304444
.meas tran slope_b13 FIND V(slope_out) AT=10.3498889
.meas tran slope_b14 FIND V(slope_out) AT=10.9498889
.meas tran slope_b15 FIND V(slope_out) AT=11.5332222
.meas tran slope_b16 FIND V(slope_out) AT=12.1387778
.meas tran slope_b17 FIND V(slope_out) AT=12.7498889
.meas tran slope_b18 FIND V(slope_out) AT=13.3887778
.meas tran slope_b19 FIND V(slope_out) AT=14.0387778
.meas tran slope_b20 FIND V(slope_out) AT=14.6721111
.meas tran slope_b21 FIND V(slope_out) AT=15.3026667
.meas tran slope_b22 FIND V(slope_out) AT=15.8915556
.meas tran slope_b23 FIND V(slope_out) AT=16.5110000
.meas tran slope_b24 FIND V(slope_out) AT=17.1054444
.meas tran slope_b25 FIND V(slope_out) AT=17.7221111
.meas tran slope_b26 FIND V(slope_out) AT=18.3221111
.meas tran slope_b27 FIND V(slope_out) AT=18.9415556
.meas tran slope_b28 FIND V(slope_out) AT=19.5721111
.meas tran slope_b29 FIND V(slope_out) AT=20.2387778

.end
