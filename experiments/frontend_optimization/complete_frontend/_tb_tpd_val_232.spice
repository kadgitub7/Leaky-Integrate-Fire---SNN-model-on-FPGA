* ============================================================
* TESTBENCH: v6 true_peak_detector multi-record validation
* Record 232, 30 beats
* Scaling: v = 0.411523 * sig + 0.569547
*   [V_LOW=0.3, V_HIGH=0.8]
*   seg_min=-0.6550, seg_max=0.5600
* ============================================================

.lib "C:\Users\kadhi\OneDrive\Desktop\amux\verilogLearning\Leaky-Integrate-Fire---SNN-model-on-FPGA\experiments\frontend_optimization\ngspice_frontend/sky130_minimal.lib.spice" tt
.option scale=1.0u method=gear reltol=0.003 gmin=1e-15 itl4=200

Vdd vdd 0 0.9
Vss vss 0 0

Xbias vbias vref vdd vss bias_gen
.ic V(xbias.iref)=0.3

* === REAL ECG (Record 232, samples 467-12262) ===
Vecg ecg_in 0 PWL(
+ 1.2972222 0.491358
+ 1.3000000 0.489300
+ 1.3027778 0.485185
+ 1.3055556 0.481070
+ 1.3083333 0.476955
+ 1.3111111 0.476955
+ 1.3138889 0.479012
+ 1.3166667 0.483128
+ 1.3194444 0.489300
+ 1.3222222 0.493416
+ 1.3250000 0.497531
+ 1.3277778 0.497531
+ 1.3305556 0.491358
+ 1.3333333 0.491358
+ 1.3361111 0.491358
+ 1.3388889 0.503704
+ 1.3416667 0.516049
+ 1.3444444 0.532510
+ 1.3472222 0.551029
+ 1.3500000 0.561317
+ 1.3527778 0.573663
+ 1.3555556 0.590123
+ 1.3583333 0.616872
+ 1.3611111 0.655967
+ 1.3638889 0.690947
+ 1.3666667 0.709465
+ 1.3694444 0.697119
+ 1.3722222 0.647737
+ 1.3750000 0.565432
+ 1.3777778 0.479012
+ 1.3805556 0.409053
+ 1.3833333 0.372016
+ 1.3861111 0.355556
+ 1.3888889 0.361728
+ 1.3916667 0.372016
+ 1.3944444 0.388477
+ 1.3972222 0.396708
+ 1.4000000 0.404938
+ 1.4027778 0.402881
+ 1.4055556 0.394650
+ 1.4083333 0.384362
+ 1.4111111 0.372016
+ 1.4138889 0.363786
+ 1.4166667 0.363786
+ 1.4194444 0.369959
+ 1.4222222 0.382305
+ 1.4250000 0.402881
+ 1.4277778 0.425514
+ 1.4305556 0.431687
+ 1.4333333 0.444033
+ 1.4361111 0.435802
+ 1.4388889 0.423457
+ 1.4416667 0.406996
+ 1.4444444 0.402881
+ 1.4472222 0.400823
+ 1.4500000 0.404938
+ 1.4527778 0.415226
+ 1.4555556 0.423457
+ 1.4583333 0.423457
+ 1.4611111 0.437860
+ 1.4638889 0.448148
+ 1.4666667 0.462551
+ 1.4694444 0.479012
+ 1.4722222 0.495473
+ 1.4750000 0.495473
+ 1.4777778 0.497531
+ 1.4805556 0.493416
+ 1.4833333 0.489300
+ 1.4861111 0.479012
+ 1.4888889 0.474897
+ 1.4916667 0.476955
+ 1.4944444 0.479012
+ 1.4972222 0.483128
+ 1.5000000 0.483128
+ 1.5027778 0.485185
+ 1.5055556 0.489300
+ 1.5083333 0.491358
+ 1.5111111 0.489300
+ 1.5138889 0.495473
+ 1.5166667 0.489300
+ 1.5194444 0.485185
+ 1.5222222 0.476955
+ 1.5250000 0.479012
+ 1.5277778 0.489300
+ 1.5305556 0.493416
+ 1.5333333 0.501646
+ 1.5361111 0.499588
+ 1.5388889 0.503704
+ 1.5416667 0.495473
+ 1.5444444 0.491358
+ 1.5472222 0.489300
+ 1.5500000 0.495473
+ 1.5527778 0.507819
+ 1.5555556 0.522222
+ 1.5583333 0.528395
+ 1.5611111 0.524280
+ 1.5638889 0.505761
+ 1.5666667 0.487243
+ 1.5694444 0.481070
+ 1.5722222 0.485185
+ 1.5750000 0.491358
+ 1.5777778 0.499588
+ 1.5805556 0.511934
+ 1.5833333 0.518107
+ 1.5861111 0.513992
+ 1.5888889 0.511934
+ 1.5916667 0.509877
+ 1.5944444 0.509877
+ 1.5972222 0.516049
+ 1.6000000 0.520165
+ 1.6027778 0.518107
+ 1.6055556 0.518107
+ 1.6083333 0.524280
+ 1.6111111 0.526337
+ 1.6138889 0.530453
+ 1.6166667 0.530453
+ 1.6194444 0.532510
+ 1.6222222 0.536626
+ 1.6250000 0.534568
+ 1.6277778 0.536626
+ 1.6305556 0.530453
+ 1.6333333 0.538683
+ 1.6361111 0.548971
+ 1.6388889 0.557202
+ 1.6416667 0.565432
+ 1.6444444 0.567490
+ 1.6472222 0.569547
+ 1.6500000 0.565432
+ 1.6527778 0.561317
+ 1.6555556 0.555144
+ 1.6583333 0.557202
+ 1.6611111 0.557202
+ 1.6638889 0.571605
+ 1.6666667 0.581893
+ 1.6694444 0.590123
+ 1.6722222 0.596296
+ 1.6750000 0.594239
+ 1.6777778 0.590123
+ 1.6805556 0.577778
+ 1.6833333 0.571605
+ 1.6861111 0.565432
+ 1.6888889 0.563374
+ 1.6916667 0.561317
+ 1.6944444 0.569547
+ 1.6972222 0.575720
+ 1.7000000 0.583951
+ 1.7027778 0.592181
+ 1.7055556 0.596296
+ 1.7083333 0.594239
+ 1.7111111 0.586008
+ 1.7138889 0.573663
+ 1.7166667 0.557202
+ 1.7194444 0.553086
+ 1.7222222 0.553086
+ 1.7250000 0.555144
+ 1.7277778 0.559259
+ 1.7305556 0.561317
+ 1.7333333 0.559259
+ 1.7361111 0.546914
+ 1.7388889 0.542798
+ 1.7416667 0.530453
+ 1.7444444 0.526337
+ 1.7472222 0.522222
+ 1.7500000 0.528395
+ 1.7527778 0.526337
+ 1.7555556 0.522222
+ 1.7583333 0.513992
+ 1.7611111 0.509877
+ 1.7638889 0.503704
+ 1.7666667 0.501646
+ 1.7694444 0.495473
+ 1.7722222 0.501646
+ 1.7750000 0.507819
+ 1.7777778 0.505761
+ 1.7805556 0.507819
+ 1.7833333 0.505761
+ 1.7861111 0.497531
+ 1.7888889 0.485185
+ 1.7916667 0.481070
+ 1.7944444 0.474897
+ 1.7972222 0.476955
+ 1.8000000 0.483128
+ 1.8027778 0.491358
+ 1.8055556 0.497531
+ 1.8083333 0.499588
+ 1.8111111 0.501646
+ 1.8138889 0.499588
+ 1.8166667 0.495473
+ 1.8194444 0.495473
+ 1.8222222 0.491358
+ 1.8250000 0.485185
+ 1.8277778 0.493416
+ 1.8305556 0.499588
+ 1.8333333 0.505761
+ 1.8361111 0.505761
+ 1.8388889 0.513992
+ 1.8416667 0.513992
+ 1.8444444 0.518107
+ 1.8472222 0.526337
+ 1.8500000 0.526337
+ 1.8527778 0.524280
+ 1.8555556 0.522222
+ 1.8583333 0.518107
+ 1.8611111 0.511934
+ 1.8638889 0.509877
+ 1.8666667 0.509877
+ 1.8694444 0.509877
+ 1.8722222 0.516049
+ 1.8750000 0.520165
+ 1.8777778 0.520165
+ 1.8805556 0.520165
+ 1.8833333 0.520165
+ 1.8861111 0.516049
+ 1.8888889 0.503704
+ 1.8916667 0.497531
+ 1.8944444 0.499588
+ 1.8972222 0.505761
+ 1.9000000 0.513992
+ 1.9027778 0.532510
+ 1.9055556 0.544856
+ 1.9083333 0.544856
+ 1.9111111 0.528395
+ 1.9138889 0.520165
+ 1.9166667 0.516049
+ 1.9194444 0.507819
+ 1.9222222 0.507819
+ 1.9250000 0.507819
+ 1.9277778 0.516049
+ 1.9305556 0.518107
+ 1.9333333 0.520165
+ 1.9361111 0.522222
+ 1.9388889 0.520165
+ 1.9416667 0.516049
+ 1.9444444 0.511934
+ 1.9472222 0.505761
+ 1.9500000 0.499588
+ 1.9527778 0.505761
+ 1.9555556 0.505761
+ 1.9583333 0.509877
+ 1.9611111 0.516049
+ 1.9638889 0.518107
+ 1.9666667 0.520165
+ 1.9694444 0.516049
+ 1.9722222 0.522222
+ 1.9750000 0.524280
+ 1.9777778 0.524280
+ 1.9805556 0.528395
+ 1.9833333 0.528395
+ 1.9861111 0.524280
+ 1.9888889 0.509877
+ 1.9916667 0.499588
+ 1.9944444 0.497531
+ 1.9972222 0.501646
+ 2.0000000 0.518107
+ 2.0027778 0.522222
+ 2.0055556 0.522222
+ 2.0083333 0.513992
+ 2.0111111 0.507819
+ 2.0138889 0.507819
+ 2.0166667 0.516049
+ 2.0194444 0.522222
+ 2.0222222 0.526337
+ 2.0250000 0.528395
+ 2.0277778 0.534568
+ 2.0305556 0.538683
+ 2.0333333 0.551029
+ 2.0361111 0.573663
+ 2.0388889 0.614815
+ 2.0416667 0.666255
+ 2.0444444 0.719753
+ 2.0472222 0.762963
+ 2.0500000 0.773251
+ 2.0527778 0.750617
+ 2.0555556 0.676543
+ 2.0583333 0.577778
+ 2.0611111 0.489300
+ 2.0638889 0.423457
+ 2.0666667 0.390535
+ 2.0694444 0.388477
+ 2.0722222 0.398765
+ 2.0750000 0.409053
+ 2.0777778 0.429630
+ 2.0805556 0.444033
+ 2.0833333 0.444033
+ 2.0861111 0.437860
+ 2.0888889 0.423457
+ 2.0916667 0.406996
+ 2.0944444 0.404938
+ 2.0972222 0.413169
+ 2.1000000 0.425514
+ 2.1027778 0.446091
+ 2.1055556 0.464609
+ 2.1083333 0.464609
+ 2.1111111 0.454321
+ 2.1138889 0.435802
+ 2.1166667 0.411111
+ 2.1194444 0.400823
+ 2.1222222 0.398765
+ 2.1250000 0.406996
+ 2.1277778 0.425514
+ 2.1305556 0.446091
+ 2.1333333 0.452263
+ 2.1361111 0.460494
+ 2.1388889 0.462551
+ 2.1416667 0.464609
+ 2.1444444 0.470782
+ 2.1472222 0.481070
+ 2.1500000 0.495473
+ 2.1527778 0.507819
+ 2.1555556 0.507819
+ 2.1583333 0.505761
+ 2.1611111 0.509877
+ 2.1638889 0.501646
+ 2.1666667 0.507819
+ 2.1694444 0.513992
+ 2.1722222 0.518107
+ 2.1750000 0.526337
+ 2.1777778 0.530453
+ 2.1805556 0.528395
+ 2.1833333 0.530453
+ 2.1861111 0.526337
+ 2.1888889 0.518107
+ 2.1916667 0.509877
+ 2.1944444 0.501646
+ 2.1972222 0.505761
+ 2.2000000 0.505761
+ 2.2027778 0.511934
+ 2.2055556 0.520165
+ 2.2083333 0.518107
+ 2.2111111 0.524280
+ 2.2138889 0.513992
+ 2.2166667 0.509877
+ 2.2194444 0.507819
+ 2.2222222 0.511934
+ 2.2250000 0.518107
+ 2.2277778 0.520165
+ 2.2305556 0.516049
+ 2.2333333 0.513992
+ 2.2361111 0.511934
+ 2.2388889 0.518107
+ 2.2416667 0.518107
+ 2.2444444 0.528395
+ 2.2472222 0.534568
+ 2.2500000 0.534568
+ 2.2527778 0.524280
+ 2.2555556 0.526337
+ 2.2583333 0.522222
+ 2.2611111 0.524280
+ 2.2638889 0.534568
+ 2.2666667 0.546914
+ 2.2694444 0.551029
+ 2.2722222 0.551029
+ 2.2750000 0.557202
+ 2.2777778 0.561317
+ 2.2805556 0.561317
+ 2.2833333 0.559259
+ 2.2861111 0.565432
+ 2.2888889 0.565432
+ 2.2916667 0.565432
+ 2.2944444 0.571605
+ 2.2972222 0.573663
+ 2.3000000 0.581893
+ 2.3027778 0.592181
+ 2.3055556 0.602469
+ 2.3083333 0.610700
+ 2.3111111 0.612757
+ 2.3138889 0.618930
+ 2.3166667 0.620988
+ 2.3194444 0.610700
+ 2.3222222 0.600412
+ 2.3250000 0.592181
+ 2.3277778 0.594239
+ 2.3305556 0.598354
+ 2.3333333 0.608642
+ 2.3361111 0.623045
+ 2.3388889 0.625103
+ 2.3416667 0.623045
+ 2.3444444 0.620988
+ 2.3472222 0.618930
+ 2.3500000 0.623045
+ 2.3527778 0.620988
+ 2.3555556 0.620988
+ 2.3583333 0.618930
+ 2.3611111 0.610700
+ 2.3638889 0.604527
+ 2.3666667 0.594239
+ 2.3694444 0.588066
+ 2.3722222 0.579835
+ 2.3750000 0.583951
+ 2.3777778 0.581893
+ 2.3805556 0.581893
+ 2.3833333 0.575720
+ 2.3861111 0.567490
+ 2.3888889 0.559259
+ 2.3916667 0.557202
+ 2.3944444 0.557202
+ 2.3972222 0.544856
+ 2.4000000 0.528395
+ 2.4027778 0.518107
+ 2.4055556 0.520165
+ 2.4083333 0.526337
+ 2.4111111 0.532510
+ 2.4138889 0.532510
+ 2.4166667 0.528395
+ 2.4194444 0.516049
+ 2.4222222 0.509877
+ 2.4250000 0.505761
+ 2.4277778 0.505761
+ 2.4305556 0.503704
+ 2.4333333 0.509877
+ 2.4361111 0.513992
+ 2.4388889 0.513992
+ 2.4416667 0.516049
+ 2.4444444 0.513992
+ 2.4472222 0.509877
+ 2.4500000 0.505761
+ 2.4527778 0.499588
+ 2.4555556 0.493416
+ 2.4583333 0.489300
+ 2.4611111 0.493416
+ 2.4638889 0.493416
+ 2.4666667 0.499588
+ 2.4694444 0.501646
+ 2.4722222 0.505761
+ 2.4750000 0.509877
+ 2.4777778 0.518107
+ 2.4805556 0.516049
+ 2.4833333 0.509877
+ 2.4861111 0.503704
+ 2.4888889 0.501646
+ 2.4916667 0.499588
+ 2.4944444 0.503704
+ 2.4972222 0.503704
+ 2.5000000 0.507819
+ 2.5027778 0.513992
+ 2.5055556 0.522222
+ 2.5083333 0.516049
+ 2.5111111 0.513992
+ 2.5138889 0.495473
+ 2.5166667 0.491358
+ 2.5194444 0.487243
+ 2.5222222 0.485185
+ 2.5250000 0.489300
+ 2.5277778 0.489300
+ 2.5305556 0.499588
+ 2.5333333 0.499588
+ 2.5361111 0.501646
+ 2.5388889 0.513992
+ 2.5416667 0.513992
+ 2.5444444 0.520165
+ 2.5472222 0.522222
+ 2.5500000 0.524280
+ 2.5527778 0.520165
+ 2.5555556 0.509877
+ 2.5583333 0.501646
+ 2.5611111 0.489300
+ 2.5638889 0.483128
+ 2.5666667 0.474897
+ 2.5694444 0.481070
+ 2.5722222 0.483128
+ 2.5750000 0.495473
+ 2.5777778 0.503704
+ 2.5805556 0.516049
+ 2.5833333 0.528395
+ 2.5861111 0.532510
+ 2.5888889 0.524280
+ 2.5916667 0.524280
+ 2.5944444 0.518107
+ 2.5972222 0.516049
+ 2.6000000 0.520165
+ 2.6027778 0.522222
+ 2.6055556 0.522222
+ 2.6083333 0.522222
+ 2.6111111 0.513992
+ 2.6138889 0.507819
+ 2.6166667 0.499588
+ 2.6194444 0.485185
+ 2.6222222 0.483128
+ 2.6250000 0.481070
+ 2.6277778 0.476955
+ 2.6305556 0.476955
+ 2.6333333 0.476955
+ 2.6361111 0.483128
+ 2.6388889 0.489300
+ 2.6416667 0.495473
+ 2.6444444 0.505761
+ 2.6472222 0.503704
+ 2.6500000 0.505761
+ 2.6527778 0.503704
+ 2.6555556 0.495473
+ 2.6583333 0.495473
+ 2.6611111 0.501646
+ 2.6638889 0.505761
+ 2.6666667 0.509877
+ 2.6694444 0.513992
+ 2.6722222 0.520165
+ 2.6750000 0.520165
+ 2.6777778 0.518107
+ 2.6805556 0.516049
+ 2.6833333 0.511934
+ 2.6861111 0.516049
+ 2.6888889 0.518107
+ 2.6916667 0.520165
+ 2.6944444 0.518107
+ 2.6972222 0.511934
+ 2.7000000 0.507819
+ 2.7027778 0.503704
+ 2.7055556 0.513992
+ 2.7083333 0.518107
+ 2.7111111 0.522222
+ 2.7138889 0.509877
+ 2.7166667 0.495473
+ 2.7194444 0.493416
+ 2.7222222 0.493416
+ 2.7250000 0.499588
+ 2.7277778 0.505761
+ 2.7305556 0.505761
+ 2.7333333 0.511934
+ 2.7361111 0.518107
+ 2.7388889 0.513992
+ 2.7416667 0.516049
+ 2.7444444 0.513992
+ 2.7472222 0.507819
+ 2.7500000 0.507819
+ 2.7527778 0.509877
+ 2.7555556 0.518107
+ 2.7583333 0.530453
+ 2.7611111 0.548971
+ 2.7638889 0.563374
+ 2.7666667 0.581893
+ 2.7694444 0.616872
+ 2.7722222 0.649794
+ 2.7750000 0.732099
+ 2.7777778 0.769136
+ 2.7805556 0.795885
+ 2.7833333 0.791770
+ 2.7861111 0.750617
+ 2.7888889 0.666255
+ 2.7916667 0.557202
+ 2.7944444 0.450206
+ 2.7972222 0.378189
+ 2.8000000 0.341152
+ 2.8027778 0.330864
+ 2.8055556 0.345267
+ 2.8083333 0.365844
+ 2.8111111 0.388477
+ 2.8138889 0.409053
+ 2.8166667 0.425514
+ 2.8194444 0.433745
+ 2.8222222 0.433745
+ 2.8250000 0.421399
+ 2.8277778 0.400823
+ 2.8305556 0.382305
+ 2.8333333 0.376132
+ 2.8361111 0.378189
+ 2.8388889 0.392593
+ 2.8416667 0.409053
+ 2.8444444 0.427572
+ 2.8472222 0.437860
+ 2.8500000 0.433745
+ 2.8527778 0.429630
+ 2.8555556 0.423457
+ 2.8583333 0.417284
+ 2.8611111 0.419342
+ 2.8638889 0.431687
+ 2.8666667 0.437860
+ 2.8694444 0.452263
+ 2.8722222 0.462551
+ 2.8750000 0.462551
+ 2.8777778 0.460494
+ 2.8805556 0.458436
+ 2.8833333 0.454321
+ 2.8861111 0.454321
+ 2.8888889 0.460494
+ 2.8916667 0.474897
+ 2.8944444 0.487243
+ 2.8972222 0.499588
+ 2.9000000 0.511934
+ 2.9027778 0.518107
+ 2.9055556 0.522222
+ 2.9083333 0.530453
+ 2.9111111 0.540741
+ 2.9138889 0.548971
+ 2.9166667 0.540741
+ 2.9194444 0.526337
+ 2.9222222 0.501646
+ 2.9250000 0.470782
+ 2.9277778 0.450206
+ 2.9305556 0.450206
+ 2.9333333 0.462551
+ 2.9361111 0.483128
+ 2.9388889 0.503704
+ 2.9416667 0.516049
+ 2.9444444 0.520165
+ 2.9472222 0.518107
+ 2.9500000 0.522222
+ 2.9527778 0.518107
+ 2.9555556 0.518107
+ 2.9583333 0.520165
+ 2.9611111 0.524280
+ 2.9638889 0.520165
+ 2.9666667 0.516049
+ 2.9694444 0.513992
+ 2.9722222 0.511934
+ 2.9750000 0.501646
+ 2.9777778 0.509877
+ 2.9805556 0.509877
+ 2.9833333 0.522222
+ 2.9861111 0.522222
+ 2.9888889 0.524280
+ 2.9916667 0.526337
+ 2.9944444 0.526337
+ 2.9972222 0.528395
+ 3.0000000 0.530453
+ 3.0027778 0.524280
+ 3.0055556 0.518107
+ 3.0083333 0.513992
+ 3.0111111 0.518107
+ 3.0138889 0.524280
+ 3.0166667 0.530453
+ 3.0194444 0.532510
+ 3.0222222 0.542798
+ 3.0250000 0.548971
+ 3.0277778 0.553086
+ 3.0305556 0.559259
+ 3.0333333 0.565432
+ 3.0361111 0.579835
+ 3.0388889 0.581893
+ 3.0416667 0.590123
+ 3.0444444 0.598354
+ 3.0472222 0.596296
+ 3.0500000 0.590123
+ 3.0527778 0.592181
+ 3.0555556 0.592181
+ 3.0583333 0.590123
+ 3.0611111 0.588066
+ 3.0638889 0.590123
+ 3.0666667 0.594239
+ 3.0694444 0.600412
+ 3.0722222 0.604527
+ 3.0750000 0.604527
+ 3.0777778 0.614815
+ 3.0805556 0.604527
+ 3.0833333 0.602469
+ 3.0861111 0.598354
+ 3.0888889 0.598354
+ 3.0916667 0.604527
+ 3.0944444 0.604527
+ 3.0972222 0.604527
+ 3.1000000 0.598354
+ 3.1027778 0.598354
+ 3.1055556 0.588066
+ 3.1083333 0.577778
+ 3.1111111 0.573663
+ 3.1138889 0.569547
+ 3.1166667 0.567490
+ 3.1194444 0.567490
+ 3.1222222 0.551029
+ 3.1250000 0.536626
+ 3.1277778 0.528395
+ 3.1305556 0.524280
+ 3.1333333 0.522222
+ 3.1361111 0.536626
+ 3.1388889 0.542798
+ 3.1416667 0.548971
+ 3.1444444 0.553086
+ 3.1472222 0.544856
+ 3.1500000 0.532510
+ 3.1527778 0.507819
+ 3.1555556 0.489300
+ 3.1583333 0.481070
+ 3.1611111 0.476955
+ 3.1638889 0.481070
+ 3.1666667 0.491358
+ 3.1694444 0.507819
+ 3.1722222 0.516049
+ 3.1750000 0.520165
+ 3.1777778 0.518107
+ 3.1805556 0.511934
+ 3.1833333 0.507819
+ 3.1861111 0.499588
+ 3.1888889 0.493416
+ 3.1916667 0.491358
+ 3.1944444 0.495473
+ 3.1972222 0.491358
+ 3.2000000 0.489300
+ 3.2027778 0.489300
+ 3.2055556 0.483128
+ 3.2083333 0.485185
+ 3.2111111 0.491358
+ 3.2138889 0.499588
+ 3.2166667 0.503704
+ 3.2194444 0.505761
+ 3.2222222 0.507819
+ 3.2250000 0.499588
+ 3.2277778 0.489300
+ 3.2305556 0.487243
+ 3.2333333 0.479012
+ 3.2361111 0.485185
+ 3.2388889 0.491358
+ 3.2416667 0.503704
+ 3.2444444 0.518107
+ 3.2472222 0.528395
+ 3.2500000 0.534568
+ 3.2527778 0.530453
+ 3.2555556 0.518107
+ 3.2583333 0.505761
+ 3.2611111 0.501646
+ 3.2638889 0.501646
+ 3.2666667 0.497531
+ 3.2694444 0.507819
+ 3.2722222 0.511934
+ 3.2750000 0.516049
+ 3.2777778 0.526337
+ 3.2805556 0.520165
+ 3.2833333 0.520165
+ 3.2861111 0.509877
+ 3.2888889 0.503704
+ 3.2916667 0.493416
+ 3.2944444 0.487243
+ 3.2972222 0.493416
+ 3.3000000 0.491358
+ 3.3027778 0.491358
+ 3.3055556 0.495473
+ 3.3083333 0.503704
+ 3.3111111 0.513992
+ 3.3138889 0.511934
+ 3.3166667 0.516049
+ 3.3194444 0.509877
+ 3.3222222 0.499588
+ 3.3250000 0.483128
+ 3.3277778 0.479012
+ 3.3305556 0.491358
+ 3.3333333 0.497531
+ 3.3361111 0.505761
+ 3.3388889 0.509877
+ 3.3416667 0.505761
+ 3.3444444 0.501646
+ 3.3472222 0.503704
+ 3.3500000 0.499588
+ 3.3527778 0.497531
+ 3.3555556 0.501646
+ 3.3583333 0.507819
+ 3.3611111 0.509877
+ 3.3638889 0.505761
+ 3.3666667 0.499588
+ 3.3694444 0.487243
+ 3.3722222 0.479012
+ 3.3750000 0.466667
+ 3.3777778 0.466667
+ 3.3805556 0.462551
+ 3.3833333 0.466667
+ 3.3861111 0.474897
+ 3.3888889 0.485185
+ 3.3916667 0.495473
+ 3.3944444 0.505761
+ 3.3972222 0.518107
+ 3.4000000 0.528395
+ 3.4027778 0.530453
+ 3.4055556 0.524280
+ 3.4083333 0.501646
+ 3.4111111 0.481070
+ 3.4138889 0.466667
+ 3.4166667 0.458436
+ 3.4194444 0.456379
+ 3.4222222 0.466667
+ 3.4250000 0.472840
+ 3.4277778 0.485185
+ 3.4305556 0.491358
+ 3.4333333 0.493416
+ 3.4361111 0.493416
+ 3.4388889 0.493416
+ 3.4416667 0.489300
+ 3.4444444 0.485185
+ 3.4472222 0.487243
+ 3.4500000 0.493416
+ 3.4527778 0.495473
+ 3.4555556 0.505761
+ 3.4583333 0.526337
+ 3.4611111 0.551029
+ 3.4638889 0.567490
+ 3.4666667 0.551029
+ 3.4694444 0.507819
+ 3.4722222 0.460494
+ 3.4750000 0.415226
+ 3.4777778 0.400823
+ 3.4805556 0.415226
+ 3.4833333 0.437860
+ 3.4861111 0.466667
+ 3.4888889 0.485185
+ 3.4916667 0.499588
+ 3.4944444 0.499588
+ 3.4972222 0.501646
+ 3.5000000 0.499588
+ 3.5027778 0.503704
+ 3.5055556 0.501646
+ 3.5083333 0.511934
+ 3.5111111 0.520165
+ 3.5138889 0.532510
+ 3.5166667 0.530453
+ 3.5194444 0.530453
+ 3.5222222 0.518107
+ 3.5250000 0.499588
+ 3.5277778 0.472840
+ 3.5305556 0.441975
+ 3.5333333 0.429630
+ 3.5361111 0.429630
+ 3.5388889 0.444033
+ 3.5416667 0.464609
+ 3.5444444 0.485185
+ 3.5472222 0.501646
+ 3.5500000 0.509877
+ 3.5527778 0.511934
+ 3.5555556 0.507819
+ 3.5583333 0.501646
+ 3.5611111 0.501646
+ 3.5638889 0.503704
+ 3.5666667 0.501646
+ 3.5694444 0.501646
+ 3.5722222 0.499588
+ 3.5750000 0.489300
+ 3.5777778 0.483128
+ 3.5805556 0.479012
+ 3.5833333 0.479012
+ 3.5861111 0.483128
+ 3.5888889 0.487243
+ 3.5916667 0.489300
+ 3.5944444 0.495473
+ 3.5972222 0.497531
+ 3.6000000 0.499588
+ 3.6027778 0.503704
+ 3.6055556 0.503704
+ 3.6083333 0.499588
+ 3.6111111 0.497531
+ 3.6138889 0.491358
+ 3.6166667 0.487243
+ 3.6194444 0.483128
+ 3.6222222 0.481070
+ 3.6250000 0.481070
+ 3.6277778 0.485185
+ 3.6305556 0.487243
+ 3.6333333 0.485185
+ 3.6361111 0.485185
+ 3.6388889 0.483128
+ 3.6416667 0.481070
+ 3.6444444 0.483128
+ 3.6472222 0.487243
+ 3.6500000 0.491358
+ 3.6527778 0.495473
+ 3.6555556 0.503704
+ 3.6583333 0.507819
+ 3.6611111 0.513992
+ 3.6638889 0.511934
+ 3.6666667 0.501646
+ 3.6694444 0.487243
+ 3.6722222 0.466667
+ 3.6750000 0.460494
+ 3.6777778 0.454321
+ 3.6805556 0.460494
+ 3.6833333 0.468724
+ 3.6861111 0.474897
+ 3.6888889 0.487243
+ 3.6916667 0.489300
+ 3.6944444 0.489300
+ 3.6972222 0.489300
+ 3.7000000 0.489300
+ 3.7027778 0.493416
+ 3.7055556 0.497531
+ 3.7083333 0.499588
+ 3.7111111 0.505761
+ 3.7138889 0.505761
+ 3.7166667 0.505761
+ 3.7194444 0.493416
+ 3.7222222 0.487243
+ 3.7250000 0.487243
+ 3.7277778 0.489300
+ 3.7305556 0.499588
+ 3.7333333 0.509877
+ 3.7361111 0.522222
+ 3.7388889 0.520165
+ 3.7416667 0.516049
+ 3.7444444 0.509877
+ 3.7472222 0.503704
+ 3.7500000 0.495473
+ 3.7527778 0.476955
+ 3.7555556 0.458436
+ 3.7583333 0.448148
+ 3.7611111 0.450206
+ 3.7638889 0.452263
+ 3.7666667 0.474897
+ 3.7694444 0.489300
+ 3.7722222 0.497531
+ 3.7750000 0.499588
+ 3.7777778 0.497531
+ 3.7805556 0.487243
+ 3.7833333 0.481070
+ 3.7861111 0.468724
+ 3.7888889 0.470782
+ 3.7916667 0.483128
+ 3.7944444 0.491358
+ 3.7972222 0.505761
+ 3.8000000 0.516049
+ 3.8027778 0.520165
+ 3.8055556 0.513992
+ 3.8083333 0.503704
+ 3.8111111 0.489300
+ 3.8138889 0.481070
+ 3.8166667 0.470782
+ 3.8194444 0.470782
+ 3.8222222 0.476955
+ 3.8250000 0.485185
+ 3.8277778 0.491358
+ 3.8305556 0.487243
+ 3.8333333 0.483128
+ 3.8361111 0.487243
+ 3.8388889 0.483128
+ 3.8416667 0.479012
+ 3.8444444 0.474897
+ 3.8472222 0.472840
+ 3.8500000 0.472840
+ 3.8527778 0.468724
+ 3.8555556 0.483128
+ 3.8583333 0.491358
+ 3.8611111 0.501646
+ 3.8638889 0.507819
+ 3.8666667 0.507819
+ 3.8694444 0.503704
+ 3.8722222 0.499588
+ 3.8750000 0.497531
+ 3.8777778 0.491358
+ 3.8805556 0.481070
+ 3.8833333 0.468724
+ 3.8861111 0.464609
+ 3.8888889 0.462551
+ 3.8916667 0.464609
+ 3.8944444 0.470782
+ 3.8972222 0.481070
+ 3.9000000 0.489300
+ 3.9027778 0.493416
+ 3.9055556 0.501646
+ 3.9083333 0.497531
+ 3.9111111 0.485185
+ 3.9138889 0.462551
+ 3.9166667 0.452263
+ 3.9194444 0.446091
+ 3.9222222 0.441975
+ 3.9250000 0.444033
+ 3.9277778 0.460494
+ 3.9305556 0.472840
+ 3.9333333 0.489300
+ 3.9361111 0.495473
+ 3.9388889 0.495473
+ 3.9416667 0.483128
+ 3.9444444 0.470782
+ 3.9472222 0.460494
+ 3.9500000 0.454321
+ 3.9527778 0.460494
+ 3.9555556 0.464609
+ 3.9583333 0.476955
+ 3.9611111 0.481070
+ 3.9638889 0.489300
+ 3.9666667 0.491358
+ 3.9694444 0.497531
+ 3.9722222 0.489300
+ 3.9750000 0.483128
+ 3.9777778 0.481070
+ 3.9805556 0.472840
+ 3.9833333 0.474897
+ 3.9861111 0.472840
+ 3.9888889 0.470782
+ 3.9916667 0.466667
+ 3.9944444 0.462551
+ 3.9972222 0.464609
+ 4.0000000 0.464609
+ 4.0027778 0.468724
+ 4.0055556 0.468724
+ 4.0083333 0.466667
+ 4.0111111 0.470782
+ 4.0138889 0.476955
+ 4.0166667 0.481070
+ 4.0194444 0.481070
+ 4.0222222 0.479012
+ 4.0250000 0.476955
+ 4.0277778 0.472840
+ 4.0305556 0.470782
+ 4.0333333 0.472840
+ 4.0361111 0.479012
+ 4.0388889 0.483128
+ 4.0416667 0.479012
+ 4.0444444 0.483128
+ 4.0472222 0.476955
+ 4.0500000 0.476955
+ 4.0527778 0.464609
+ 4.0555556 0.462551
+ 4.0583333 0.466667
+ 4.0611111 0.470782
+ 4.0638889 0.487243
+ 4.0666667 0.497531
+ 4.0694444 0.503704
+ 4.0722222 0.493416
+ 4.0750000 0.479012
+ 4.0777778 0.472840
+ 4.0805556 0.464609
+ 4.0833333 0.452263
+ 4.0861111 0.444033
+ 4.0888889 0.448148
+ 4.0916667 0.458436
+ 4.0944444 0.466667
+ 4.0972222 0.479012
+ 4.1000000 0.483128
+ 4.1027778 0.487243
+ 4.1055556 0.479012
+ 4.1083333 0.476955
+ 4.1111111 0.474897
+ 4.1138889 0.479012
+ 4.1166667 0.479012
+ 4.1194444 0.474897
+ 4.1222222 0.468724
+ 4.1250000 0.470782
+ 4.1277778 0.474897
+ 4.1305556 0.476955
+ 4.1333333 0.483128
+ 4.1361111 0.481070
+ 4.1388889 0.470782
+ 4.1416667 0.464609
+ 4.1444444 0.462551
+ 4.1472222 0.462551
+ 4.1500000 0.466667
+ 4.1527778 0.468724
+ 4.1555556 0.466667
+ 4.1583333 0.460494
+ 4.1611111 0.452263
+ 4.1638889 0.458436
+ 4.1666667 0.466667
+ 4.1694444 0.479012
+ 4.1722222 0.489300
+ 4.1750000 0.493416
+ 4.1777778 0.495473
+ 4.1805556 0.485185
+ 4.1833333 0.483128
+ 4.1861111 0.476955
+ 4.1888889 0.470782
+ 4.1916667 0.466667
+ 4.1944444 0.462551
+ 4.1972222 0.466667
+ 4.2000000 0.474897
+ 4.2027778 0.485185
+ 4.2055556 0.491358
+ 4.2083333 0.487243
+ 4.2111111 0.487243
+ 4.2138889 0.483128
+ 4.2166667 0.470782
+ 4.2194444 0.464609
+ 4.2222222 0.462551
+ 4.2250000 0.468724
+ 4.2277778 0.476955
+ 4.2305556 0.479012
+ 4.2333333 0.483128
+ 4.2361111 0.485185
+ 4.2388889 0.485185
+ 4.2416667 0.483128
+ 4.2444444 0.481070
+ 4.2472222 0.468724
+ 4.2500000 0.460494
+ 4.2527778 0.454321
+ 4.2555556 0.460494
+ 4.2583333 0.468724
+ 4.2611111 0.476955
+ 4.2638889 0.485185
+ 4.2666667 0.481070
+ 4.2694444 0.474897
+ 4.2722222 0.470782
+ 4.2750000 0.472840
+ 4.2777778 0.487243
+ 4.2805556 0.493416
+ 4.2833333 0.499588
+ 4.2861111 0.497531
+ 4.2888889 0.485185
+ 4.2916667 0.472840
+ 4.2944444 0.458436
+ 4.2972222 0.458436
+ 4.3000000 0.462551
+ 4.3027778 0.464609
+ 4.3055556 0.468724
+ 4.3083333 0.476955
+ 4.3111111 0.487243
+ 4.3138889 0.491358
+ 4.3166667 0.495473
+ 4.3194444 0.491358
+ 4.3222222 0.487243
+ 4.3250000 0.485185
+ 4.3277778 0.485185
+ 4.3305556 0.485185
+ 4.3333333 0.489300
+ 4.3361111 0.491358
+ 4.3388889 0.491358
+ 4.3416667 0.485185
+ 4.3444444 0.483128
+ 4.3472222 0.476955
+ 4.3500000 0.470782
+ 4.3527778 0.468724
+ 4.3555556 0.468724
+ 4.3583333 0.476955
+ 4.3611111 0.479012
+ 4.3638889 0.491358
+ 4.3666667 0.497531
+ 4.3694444 0.499588
+ 4.3722222 0.499588
+ 4.3750000 0.491358
+ 4.3777778 0.485185
+ 4.3805556 0.472840
+ 4.3833333 0.472840
+ 4.3861111 0.472840
+ 4.3888889 0.481070
+ 4.3916667 0.489300
+ 4.3944444 0.495473
+ 4.3972222 0.505761
+ 4.4000000 0.513992
+ 4.4027778 0.513992
+ 4.4055556 0.516049
+ 4.4083333 0.511934
+ 4.4111111 0.501646
+ 4.4138889 0.499588
+ 4.4166667 0.499588
+ 4.4194444 0.501646
+ 4.4222222 0.509877
+ 4.4250000 0.513992
+ 4.4277778 0.526337
+ 4.4305556 0.528395
+ 4.4333333 0.528395
+ 4.4361111 0.516049
+ 4.4388889 0.503704
+ 4.4416667 0.487243
+ 4.4444444 0.476955
+ 4.4472222 0.468724
+ 4.4500000 0.466667
+ 4.4527778 0.470782
+ 4.4555556 0.479012
+ 4.4583333 0.493416
+ 4.4611111 0.497531
+ 4.4638889 0.509877
+ 4.4666667 0.520165
+ 4.4694444 0.526337
+ 4.4722222 0.524280
+ 4.4750000 0.513992
+ 4.4777778 0.497531
+ 4.4805556 0.474897
+ 4.4833333 0.454321
+ 4.4861111 0.435802
+ 4.4888889 0.427572
+ 4.4916667 0.427572
+ 4.4944444 0.435802
+ 4.4972222 0.446091
+ 4.5000000 0.458436
+ 4.5027778 0.470782
+ 4.5055556 0.476955
+ 4.5083333 0.485185
+ 4.5111111 0.485185
+ 4.5138889 0.487243
+ 4.5166667 0.485185
+ 4.5194444 0.479012
+ 4.5222222 0.470782
+ 4.5250000 0.460494
+ 4.5277778 0.452263
+ 4.5305556 0.452263
+ 4.5333333 0.452263
+ 4.5361111 0.454321
+ 4.5388889 0.466667
+ 4.5416667 0.472840
+ 4.5444444 0.472840
+ 4.5472222 0.479012
+ 4.5500000 0.485185
+ 4.5527778 0.503704
+ 4.5555556 0.511934
+ 4.5583333 0.516049
+ 4.5611111 0.499588
+ 4.5638889 0.476955
+ 4.5666667 0.454321
+ 4.5694444 0.437860
+ 4.5722222 0.437860
+ 4.5750000 0.437860
+ 4.5777778 0.456379
+ 4.5805556 0.470782
+ 4.5833333 0.487243
+ 4.5861111 0.503704
+ 4.5888889 0.509877
+ 4.5916667 0.530453
+ 4.5944444 0.561317
+ 4.5972222 0.602469
+ 4.6000000 0.655967
+ 4.6027778 0.709465
+ 4.6055556 0.750617
+ 4.6083333 0.785597
+ 4.6111111 0.797942
+ 4.6138889 0.777366
+ 4.6166667 0.715638
+ 4.6194444 0.608642
+ 4.6222222 0.491358
+ 4.6250000 0.396708
+ 4.6277778 0.332922
+ 4.6305556 0.312346
+ 4.6333333 0.314403
+ 4.6361111 0.328807
+ 4.6388889 0.347325
+ 4.6416667 0.361728
+ 4.6444444 0.369959
+ 4.6472222 0.374074
+ 4.6500000 0.361728
+ 4.6527778 0.355556
+ 4.6555556 0.345267
+ 4.6583333 0.347325
+ 4.6611111 0.353498
+ 4.6638889 0.363786
+ 4.6666667 0.380247
+ 4.6694444 0.396708
+ 4.6722222 0.406996
+ 4.6750000 0.411111
+ 4.6777778 0.419342
+ 4.6805556 0.415226
+ 4.6833333 0.406996
+ 4.6861111 0.388477
+ 4.6888889 0.372016
+ 4.6916667 0.361728
+ 4.6944444 0.359671
+ 4.6972222 0.369959
+ 4.7000000 0.386420
+ 4.7027778 0.406996
+ 4.7055556 0.429630
+ 4.7083333 0.446091
+ 4.7111111 0.466667
+ 4.7138889 0.481070
+ 4.7166667 0.489300
+ 4.7194444 0.485185
+ 4.7222222 0.481070
+ 4.7250000 0.466667
+ 4.7277778 0.454321
+ 4.7305556 0.448148
+ 4.7333333 0.450206
+ 4.7361111 0.460494
+ 4.7388889 0.474897
+ 4.7416667 0.489300
+ 4.7444444 0.493416
+ 4.7472222 0.493416
+ 4.7500000 0.483128
+ 4.7527778 0.472840
+ 4.7555556 0.462551
+ 4.7583333 0.454321
+ 4.7611111 0.446091
+ 4.7638889 0.437860
+ 4.7666667 0.439918
+ 4.7694444 0.452263
+ 4.7722222 0.462551
+ 4.7750000 0.470782
+ 4.7777778 0.476955
+ 4.7805556 0.485185
+ 4.7833333 0.491358
+ 4.7861111 0.493416
+ 4.7888889 0.489300
+ 4.7916667 0.481070
+ 4.7944444 0.468724
+ 4.7972222 0.468724
+ 4.8000000 0.464609
+ 4.8027778 0.472840
+ 4.8055556 0.489300
+ 4.8083333 0.497531
+ 4.8111111 0.507819
+ 4.8138889 0.518107
+ 4.8166667 0.513992
+ 4.8194444 0.516049
+ 4.8222222 0.509877
+ 4.8250000 0.497531
+ 4.8277778 0.491358
+ 4.8305556 0.493416
+ 4.8333333 0.493416
+ 4.8361111 0.497531
+ 4.8388889 0.503704
+ 4.8416667 0.491358
+ 4.8444444 0.489300
+ 4.8472222 0.495473
+ 4.8500000 0.501646
+ 4.8527778 0.516049
+ 4.8555556 0.526337
+ 4.8583333 0.530453
+ 4.8611111 0.528395
+ 4.8638889 0.528395
+ 4.8666667 0.526337
+ 4.8694444 0.532510
+ 4.8722222 0.528395
+ 4.8750000 0.526337
+ 4.8777778 0.526337
+ 4.8805556 0.528395
+ 4.8833333 0.538683
+ 4.8861111 0.548971
+ 4.8888889 0.555144
+ 4.8916667 0.563374
+ 4.8944444 0.571605
+ 4.8972222 0.579835
+ 4.9000000 0.577778
+ 4.9027778 0.581893
+ 4.9055556 0.581893
+ 4.9083333 0.573663
+ 4.9111111 0.567490
+ 4.9138889 0.561317
+ 4.9166667 0.559259
+ 4.9194444 0.557202
+ 4.9222222 0.561317
+ 4.9250000 0.569547
+ 4.9277778 0.583951
+ 4.9305556 0.598354
+ 4.9333333 0.604527
+ 4.9361111 0.600412
+ 4.9388889 0.586008
+ 4.9416667 0.561317
+ 4.9444444 0.542798
+ 4.9472222 0.534568
+ 4.9500000 0.534568
+ 4.9527778 0.534568
+ 4.9555556 0.540741
+ 4.9583333 0.553086
+ 4.9611111 0.557202
+ 4.9638889 0.557202
+ 4.9666667 0.553086
+ 4.9694444 0.551029
+ 4.9722222 0.557202
+ 4.9750000 0.557202
+ 4.9777778 0.551029
+ 4.9805556 0.544856
+ 4.9833333 0.532510
+ 4.9861111 0.509877
+ 4.9888889 0.501646
+ 4.9916667 0.491358
+ 4.9944444 0.493416
+ 4.9972222 0.495473
+ 5.0000000 0.497531
+ 5.0027778 0.495473
+ 5.0055556 0.493416
+ 5.0083333 0.491358
+ 5.0111111 0.495473
+ 5.0138889 0.501646
+ 5.0166667 0.503704
+ 5.0194444 0.495473
+ 5.0222222 0.483128
+ 5.0250000 0.464609
+ 5.0277778 0.462551
+ 5.0305556 0.460494
+ 5.0333333 0.464609
+ 5.0361111 0.470782
+ 5.0388889 0.468724
+ 5.0416667 0.458436
+ 5.0444444 0.456379
+ 5.0472222 0.456379
+ 5.0500000 0.466667
+ 5.0527778 0.468724
+ 5.0555556 0.466667
+ 5.0583333 0.468724
+ 5.0611111 0.468724
+ 5.0638889 0.474897
+ 5.0666667 0.479012
+ 5.0694444 0.489300
+ 5.0722222 0.499588
+ 5.0750000 0.503704
+ 5.0777778 0.507819
+ 5.0805556 0.501646
+ 5.0833333 0.497531
+ 5.0861111 0.497531
+ 5.0888889 0.497531
+ 5.0916667 0.487243
+ 5.0944444 0.481070
+ 5.0972222 0.481070
+ 5.1000000 0.485185
+ 5.1027778 0.487243
+ 5.1055556 0.487243
+ 5.1083333 0.493416
+ 5.1111111 0.497531
+ 5.1138889 0.497531
+ 5.1166667 0.503704
+ 5.1194444 0.503704
+ 5.1222222 0.505761
+ 5.1250000 0.493416
+ 5.1277778 0.481070
+ 5.1305556 0.476955
+ 5.1333333 0.481070
+ 5.1361111 0.495473
+ 5.1388889 0.505761
+ 5.1416667 0.511934
+ 5.1444444 0.513992
+ 5.1472222 0.513992
+ 5.1500000 0.509877
+ 5.1527778 0.503704
+ 5.1555556 0.495473
+ 5.1583333 0.497531
+ 5.1611111 0.495473
+ 5.1638889 0.499588
+ 5.1666667 0.499588
+ 5.1694444 0.501646
+ 5.1722222 0.509877
+ 5.1750000 0.509877
+ 5.1777778 0.499588
+ 5.1805556 0.483128
+ 5.1833333 0.479012
+ 5.1861111 0.481070
+ 5.1888889 0.485185
+ 5.1916667 0.491358
+ 5.1944444 0.497531
+ 5.1972222 0.493416
+ 5.2000000 0.489300
+ 5.2027778 0.483128
+ 5.2055556 0.481070
+ 5.2083333 0.487243
+ 5.2111111 0.493416
+ 5.2138889 0.499588
+ 5.2166667 0.501646
+ 5.2194444 0.499588
+ 5.2222222 0.491358
+ 5.2250000 0.481070
+ 5.2277778 0.472840
+ 5.2305556 0.474897
+ 5.2333333 0.483128
+ 5.2361111 0.493416
+ 5.2388889 0.501646
+ 5.2416667 0.497531
+ 5.2444444 0.495473
+ 5.2472222 0.493416
+ 5.2500000 0.487243
+ 5.2527778 0.487243
+ 5.2555556 0.487243
+ 5.2583333 0.491358
+ 5.2611111 0.493416
+ 5.2638889 0.495473
+ 5.2666667 0.503704
+ 5.2694444 0.522222
+ 5.2722222 0.553086
+ 5.2750000 0.594239
+ 5.2777778 0.643621
+ 5.2805556 0.699177
+ 5.2833333 0.750617
+ 5.2861111 0.787654
+ 5.2888889 0.800000
+ 5.2916667 0.781481
+ 5.2944444 0.705350
+ 5.2972222 0.596296
+ 5.3000000 0.485185
+ 5.3027778 0.402881
+ 5.3055556 0.353498
+ 5.3083333 0.334979
+ 5.3111111 0.341152
+ 5.3138889 0.349383
+ 5.3166667 0.361728
+ 5.3194444 0.372016
+ 5.3222222 0.384362
+ 5.3250000 0.386420
+ 5.3277778 0.390535
+ 5.3305556 0.382305
+ 5.3333333 0.367901
+ 5.3361111 0.365844
+ 5.3388889 0.367901
+ 5.3416667 0.382305
+ 5.3444444 0.396708
+ 5.3472222 0.409053
+ 5.3500000 0.415226
+ 5.3527778 0.415226
+ 5.3555556 0.402881
+ 5.3583333 0.396708
+ 5.3611111 0.396708
+ 5.3638889 0.402881
+ 5.3666667 0.402881
+ 5.3694444 0.409053
+ 5.3722222 0.413169
+ 5.3750000 0.425514
+ 5.3777778 0.435802
+ 5.3805556 0.454321
+ 5.3833333 0.474897
+ 5.3861111 0.495473
+ 5.3888889 0.513992
+ 5.3916667 0.509877
+ 5.3944444 0.501646
+ 5.3972222 0.493416
+ 5.4000000 0.487243
+ 5.4027778 0.483128
+ 5.4055556 0.489300
+ 5.4083333 0.485185
+ 5.4111111 0.485185
+ 5.4138889 0.483128
+ 5.4166667 0.479012
+ 5.4194444 0.468724
+ 5.4222222 0.472840
+ 5.4250000 0.481070
+ 5.4277778 0.491358
+ 5.4305556 0.495473
+ 5.4333333 0.497531
+ 5.4361111 0.503704
+ 5.4388889 0.497531
+ 5.4416667 0.491358
+ 5.4444444 0.487243
+ 5.4472222 0.485185
+ 5.4500000 0.485185
+ 5.4527778 0.485185
+ 5.4555556 0.487243
+ 5.4583333 0.493416
+ 5.4611111 0.503704
+ 5.4638889 0.513992
+ 5.4666667 0.520165
+ 5.4694444 0.524280
+ 5.4722222 0.511934
+ 5.4750000 0.511934
+ 5.4777778 0.505761
+ 5.4805556 0.503704
+ 5.4833333 0.497531
+ 5.4861111 0.497531
+ 5.4888889 0.493416
+ 5.4916667 0.487243
+ 5.4944444 0.493416
+ 5.4972222 0.507819
+ 5.5000000 0.518107
+ 5.5027778 0.532510
+ 5.5055556 0.534568
+ 5.5083333 0.536626
+ 5.5111111 0.530453
+ 5.5138889 0.520165
+ 5.5166667 0.518107
+ 5.5194444 0.520165
+ 5.5222222 0.528395
+ 5.5250000 0.534568
+ 5.5277778 0.548971
+ 5.5305556 0.563374
+ 5.5333333 0.577778
+ 5.5361111 0.590123
+ 5.5388889 0.596296
+ 5.5416667 0.588066
+ 5.5444444 0.575720
+ 5.5472222 0.561317
+ 5.5500000 0.548971
+ 5.5527778 0.551029
+ 5.5555556 0.553086
+ 5.5583333 0.569547
+ 5.5611111 0.575720
+ 5.5638889 0.588066
+ 5.5666667 0.588066
+ 5.5694444 0.592181
+ 5.5722222 0.592181
+ 5.5750000 0.594239
+ 5.5777778 0.592181
+ 5.5805556 0.588066
+ 5.5833333 0.586008
+ 5.5861111 0.588066
+ 5.5888889 0.590123
+ 5.5916667 0.588066
+ 5.5944444 0.577778
+ 5.5972222 0.567490
+ 5.6000000 0.561317
+ 5.6027778 0.555144
+ 5.6055556 0.551029
+ 5.6083333 0.540741
+ 5.6111111 0.542798
+ 5.6138889 0.534568
+ 5.6166667 0.526337
+ 5.6194444 0.513992
+ 5.6222222 0.507819
+ 5.6250000 0.507819
+ 5.6277778 0.509877
+ 5.6305556 0.513992
+ 5.6333333 0.513992
+ 5.6361111 0.513992
+ 5.6388889 0.516049
+ 5.6416667 0.509877
+ 5.6444444 0.497531
+ 5.6472222 0.481070
+ 5.6500000 0.464609
+ 5.6527778 0.458436
+ 5.6555556 0.446091
+ 5.6583333 0.448148
+ 5.6611111 0.454321
+ 5.6638889 0.464609
+ 5.6666667 0.470782
+ 5.6694444 0.483128
+ 5.6722222 0.493416
+ 5.6750000 0.497531
+ 5.6777778 0.511934
+ 5.6805556 0.520165
+ 5.6833333 0.534568
+ 5.6861111 0.526337
+ 5.6888889 0.507819
+ 5.6916667 0.462551
+ 5.6944444 0.419342
+ 5.6972222 0.392593
+ 5.7000000 0.396708
+ 5.7027778 0.415226
+ 5.7055556 0.444033
+ 5.7083333 0.474897
+ 5.7111111 0.491358
+ 5.7138889 0.497531
+ 5.7166667 0.495473
+ 5.7194444 0.487243
+ 5.7222222 0.472840
+ 5.7250000 0.454321
+ 5.7277778 0.456379
+ 5.7305556 0.454321
+ 5.7333333 0.462551
+ 5.7361111 0.470782
+ 5.7388889 0.472840
+ 5.7416667 0.470782
+ 5.7444444 0.466667
+ 5.7472222 0.460494
+ 5.7500000 0.454321
+ 5.7527778 0.454321
+ 5.7555556 0.460494
+ 5.7583333 0.468724
+ 5.7611111 0.470782
+ 5.7638889 0.462551
+ 5.7666667 0.458436
+ 5.7694444 0.456379
+ 5.7722222 0.460494
+ 5.7750000 0.476955
+ 5.7777778 0.489300
+ 5.7805556 0.497531
+ 5.7833333 0.489300
+ 5.7861111 0.476955
+ 5.7888889 0.460494
+ 5.7916667 0.452263
+ 5.7944444 0.452263
+ 5.7972222 0.456379
+ 5.8000000 0.472840
+ 5.8027778 0.479012
+ 5.8055556 0.483128
+ 5.8083333 0.481070
+ 5.8111111 0.483128
+ 5.8138889 0.489300
+ 5.8166667 0.491358
+ 5.8194444 0.493416
+ 5.8222222 0.499588
+ 5.8250000 0.497531
+ 5.8277778 0.489300
+ 5.8305556 0.483128
+ 5.8333333 0.479012
+ 5.8361111 0.462551
+ 5.8388889 0.452263
+ 5.8416667 0.452263
+ 5.8444444 0.458436
+ 5.8472222 0.468724
+ 5.8500000 0.476955
+ 5.8527778 0.476955
+ 5.8555556 0.474897
+ 5.8583333 0.474897
+ 5.8611111 0.481070
+ 5.8638889 0.479012
+ 5.8666667 0.481070
+ 5.8694444 0.474897
+ 5.8722222 0.468724
+ 5.8750000 0.464609
+ 5.8777778 0.464609
+ 5.8805556 0.464609
+ 5.8833333 0.470782
+ 5.8861111 0.474897
+ 5.8888889 0.472840
+ 5.8916667 0.474897
+ 5.8944444 0.479012
+ 5.8972222 0.474897
+ 5.9000000 0.468724
+ 5.9027778 0.462551
+ 5.9055556 0.458436
+ 5.9083333 0.464609
+ 5.9111111 0.464609
+ 5.9138889 0.472840
+ 5.9166667 0.479012
+ 5.9194444 0.483128
+ 5.9222222 0.483128
+ 5.9250000 0.487243
+ 5.9277778 0.479012
+ 5.9305556 0.479012
+ 5.9333333 0.476955
+ 5.9361111 0.476955
+ 5.9388889 0.466667
+ 5.9416667 0.466667
+ 5.9444444 0.460494
+ 5.9472222 0.460494
+ 5.9500000 0.464609
+ 5.9527778 0.476955
+ 5.9555556 0.485185
+ 5.9583333 0.489300
+ 5.9611111 0.491358
+ 5.9638889 0.491358
+ 5.9666667 0.491358
+ 5.9694444 0.495473
+ 5.9722222 0.501646
+ 5.9750000 0.520165
+ 5.9777778 0.536626
+ 5.9805556 0.561317
+ 5.9833333 0.590123
+ 5.9861111 0.635391
+ 5.9888889 0.672428
+ 5.9916667 0.715638
+ 5.9944444 0.725926
+ 5.9972222 0.707407
+ 6.0000000 0.649794
+ 6.0027778 0.553086
+ 6.0055556 0.450206
+ 6.0083333 0.369959
+ 6.0111111 0.326749
+ 6.0138889 0.316461
+ 6.0166667 0.326749
+ 6.0194444 0.347325
+ 6.0222222 0.363786
+ 6.0250000 0.378189
+ 6.0277778 0.390535
+ 6.0305556 0.398765
+ 6.0333333 0.404938
+ 6.0361111 0.409053
+ 6.0388889 0.406996
+ 6.0416667 0.398765
+ 6.0444444 0.388477
+ 6.0472222 0.372016
+ 6.0500000 0.363786
+ 6.0527778 0.361728
+ 6.0555556 0.357613
+ 6.0583333 0.357613
+ 6.0611111 0.359671
+ 6.0638889 0.367901
+ 6.0666667 0.378189
+ 6.0694444 0.398765
+ 6.0722222 0.409053
+ 6.0750000 0.417284
+ 6.0777778 0.425514
+ 6.0805556 0.429630
+ 6.0833333 0.439918
+ 6.0861111 0.439918
+ 6.0888889 0.441975
+ 6.0916667 0.452263
+ 6.0944444 0.454321
+ 6.0972222 0.462551
+ 6.1000000 0.460494
+ 6.1027778 0.460494
+ 6.1055556 0.462551
+ 6.1083333 0.466667
+ 6.1111111 0.470782
+ 6.1138889 0.472840
+ 6.1166667 0.470782
+ 6.1194444 0.476955
+ 6.1222222 0.483128
+ 6.1250000 0.493416
+ 6.1277778 0.503704
+ 6.1305556 0.505761
+ 6.1333333 0.503704
+ 6.1361111 0.501646
+ 6.1388889 0.493416
+ 6.1416667 0.472840
+ 6.1444444 0.452263
+ 6.1472222 0.431687
+ 6.1500000 0.433745
+ 6.1527778 0.441975
+ 6.1555556 0.452263
+ 6.1583333 0.470782
+ 6.1611111 0.483128
+ 6.1638889 0.493416
+ 6.1666667 0.499588
+ 6.1694444 0.497531
+ 6.1722222 0.497531
+ 6.1750000 0.495473
+ 6.1777778 0.493416
+ 6.1805556 0.485185
+ 6.1833333 0.479012
+ 6.1861111 0.472840
+ 6.1888889 0.466667
+ 6.1916667 0.474897
+ 6.1944444 0.476955
+ 6.1972222 0.487243
+ 6.2000000 0.493416
+ 6.2027778 0.497531
+ 6.2055556 0.507819
+ 6.2083333 0.522222
+ 6.2111111 0.532510
+ 6.2138889 0.546914
+ 6.2166667 0.542798
+ 6.2194444 0.518107
+ 6.2222222 0.493416
+ 6.2250000 0.474897
+ 6.2277778 0.466667
+ 6.2305556 0.472840
+ 6.2333333 0.487243
+ 6.2361111 0.509877
+ 6.2388889 0.526337
+ 6.2416667 0.542798
+ 6.2444444 0.551029
+ 6.2472222 0.546914
+ 6.2500000 0.544856
+ 6.2527778 0.557202
+ 6.2555556 0.565432
+ 6.2583333 0.577778
+ 6.2611111 0.579835
+ 6.2638889 0.583951
+ 6.2666667 0.577778
+ 6.2694444 0.561317
+ 6.2722222 0.548971
+ 6.2750000 0.538683
+ 6.2777778 0.536626
+ 6.2805556 0.540741
+ 6.2833333 0.553086
+ 6.2861111 0.561317
+ 6.2888889 0.575720
+ 6.2916667 0.590123
+ 6.2944444 0.600412
+ 6.2972222 0.600412
+ 6.3000000 0.586008
+ 6.3027778 0.579835
+ 6.3055556 0.573663
+ 6.3083333 0.565432
+ 6.3111111 0.563374
+ 6.3138889 0.555144
+ 6.3166667 0.542798
+ 6.3194444 0.526337
+ 6.3222222 0.513992
+ 6.3250000 0.516049
+ 6.3277778 0.516049
+ 6.3305556 0.518107
+ 6.3333333 0.526337
+ 6.3361111 0.530453
+ 6.3388889 0.528395
+ 6.3416667 0.520165
+ 6.3444444 0.520165
+ 6.3472222 0.518107
+ 6.3500000 0.522222
+ 6.3527778 0.528395
+ 6.3555556 0.532510
+ 6.3583333 0.530453
+ 6.3611111 0.513992
+ 6.3638889 0.485185
+ 6.3666667 0.454321
+ 6.3694444 0.435802
+ 6.3722222 0.433745
+ 6.3750000 0.441975
+ 6.3777778 0.454321
+ 6.3805556 0.466667
+ 6.3833333 0.476955
+ 6.3861111 0.481070
+ 6.3888889 0.481070
+ 6.3916667 0.487243
+ 6.3944444 0.481070
+ 6.3972222 0.491358
+ 6.4000000 0.503704
+ 6.4027778 0.524280
+ 6.4055556 0.530453
+ 6.4083333 0.509877
+ 6.4111111 0.481070
+ 6.4138889 0.435802
+ 6.4166667 0.406996
+ 6.4194444 0.402881
+ 6.4222222 0.415226
+ 6.4250000 0.441975
+ 6.4277778 0.464609
+ 6.4305556 0.483128
+ 6.4333333 0.491358
+ 6.4361111 0.495473
+ 6.4388889 0.501646
+ 6.4416667 0.491358
+ 6.4444444 0.485185
+ 6.4472222 0.483128
+ 6.4500000 0.466667
+ 6.4527778 0.462551
+ 6.4555556 0.454321
+ 6.4583333 0.456379
+ 6.4611111 0.460494
+ 6.4638889 0.464609
+ 6.4666667 0.476955
+ 6.4694444 0.489300
+ 6.4722222 0.491358
+ 6.4750000 0.487243
+ 6.4777778 0.479012
+ 6.4805556 0.481070
+ 6.4833333 0.479012
+ 6.4861111 0.472840
+ 6.4888889 0.474897
+ 6.4916667 0.483128
+ 6.4944444 0.487243
+ 6.4972222 0.485185
+ 6.5000000 0.481070
+ 6.5027778 0.481070
+ 6.5055556 0.479012
+ 6.5083333 0.479012
+ 6.5111111 0.483128
+ 6.5138889 0.481070
+ 6.5166667 0.479012
+ 6.5194444 0.470782
+ 6.5222222 0.466667
+ 6.5250000 0.466667
+ 6.5277778 0.466667
+ 6.5305556 0.468724
+ 6.5333333 0.472840
+ 6.5361111 0.476955
+ 6.5388889 0.483128
+ 6.5416667 0.489300
+ 6.5444444 0.489300
+ 6.5472222 0.489300
+ 6.5500000 0.483128
+ 6.5527778 0.474897
+ 6.5555556 0.468724
+ 6.5583333 0.464609
+ 6.5611111 0.464609
+ 6.5638889 0.460494
+ 6.5666667 0.466667
+ 6.5694444 0.468724
+ 6.5722222 0.466667
+ 6.5750000 0.470782
+ 6.5777778 0.474897
+ 6.5805556 0.481070
+ 6.5833333 0.481070
+ 6.5861111 0.476955
+ 6.5888889 0.472840
+ 6.5916667 0.470782
+ 6.5944444 0.466667
+ 6.5972222 0.474897
+ 6.6000000 0.468724
+ 6.6027778 0.472840
+ 6.6055556 0.466667
+ 6.6083333 0.462551
+ 6.6111111 0.460494
+ 6.6138889 0.468724
+ 6.6166667 0.472840
+ 6.6194444 0.470782
+ 6.6222222 0.466667
+ 6.6250000 0.468724
+ 6.6277778 0.460494
+ 6.6305556 0.456379
+ 6.6333333 0.464609
+ 6.6361111 0.472840
+ 6.6388889 0.479012
+ 6.6416667 0.476955
+ 6.6444444 0.474897
+ 6.6472222 0.468724
+ 6.6500000 0.466667
+ 6.6527778 0.466667
+ 6.6555556 0.460494
+ 6.6583333 0.452263
+ 6.6611111 0.446091
+ 6.6638889 0.450206
+ 6.6666667 0.454321
+ 6.6694444 0.468724
+ 6.6722222 0.470782
+ 6.6750000 0.468724
+ 6.6777778 0.470782
+ 6.6805556 0.468724
+ 6.6833333 0.470782
+ 6.6861111 0.466667
+ 6.6888889 0.462551
+ 6.6916667 0.462551
+ 6.6944444 0.462551
+ 6.6972222 0.468724
+ 6.7000000 0.468724
+ 6.7027778 0.466667
+ 6.7055556 0.470782
+ 6.7083333 0.460494
+ 6.7111111 0.462551
+ 6.7138889 0.464609
+ 6.7166667 0.466667
+ 6.7194444 0.472840
+ 6.7222222 0.476955
+ 6.7250000 0.472840
+ 6.7277778 0.466667
+ 6.7305556 0.458436
+ 6.7333333 0.456379
+ 6.7361111 0.460494
+ 6.7388889 0.474897
+ 6.7416667 0.481070
+ 6.7444444 0.485185
+ 6.7472222 0.479012
+ 6.7500000 0.472840
+ 6.7527778 0.458436
+ 6.7555556 0.458436
+ 6.7583333 0.462551
+ 6.7611111 0.464609
+ 6.7638889 0.470782
+ 6.7666667 0.468724
+ 6.7694444 0.466667
+ 6.7722222 0.462551
+ 6.7750000 0.466667
+ 6.7777778 0.464609
+ 6.7805556 0.466667
+ 6.7833333 0.472840
+ 6.7861111 0.474897
+ 6.7888889 0.468724
+ 6.7916667 0.470782
+ 6.7944444 0.464609
+ 6.7972222 0.466667
+ 6.8000000 0.468724
+ 6.8027778 0.470782
+ 6.8055556 0.476955
+ 6.8083333 0.476955
+ 6.8111111 0.487243
+ 6.8138889 0.483128
+ 6.8166667 0.485185
+ 6.8194444 0.468724
+ 6.8222222 0.458436
+ 6.8250000 0.448148
+ 6.8277778 0.446091
+ 6.8305556 0.450206
+ 6.8333333 0.464609
+ 6.8361111 0.472840
+ 6.8388889 0.479012
+ 6.8416667 0.476955
+ 6.8444444 0.479012
+ 6.8472222 0.470782
+ 6.8500000 0.470782
+ 6.8527778 0.476955
+ 6.8555556 0.472840
+ 6.8583333 0.470782
+ 6.8611111 0.464609
+ 6.8638889 0.470782
+ 6.8666667 0.464609
+ 6.8694444 0.466667
+ 6.8722222 0.468724
+ 6.8750000 0.464609
+ 6.8777778 0.452263
+ 6.8805556 0.446091
+ 6.8833333 0.446091
+ 6.8861111 0.452263
+ 6.8888889 0.456379
+ 6.8916667 0.464609
+ 6.8944444 0.470782
+ 6.8972222 0.474897
+ 6.9000000 0.474897
+ 6.9027778 0.470782
+ 6.9055556 0.466667
+ 6.9083333 0.462551
+ 6.9111111 0.466667
+ 6.9138889 0.466667
+ 6.9166667 0.468724
+ 6.9194444 0.466667
+ 6.9222222 0.466667
+ 6.9250000 0.470782
+ 6.9277778 0.470782
+ 6.9305556 0.472840
+ 6.9333333 0.468724
+ 6.9361111 0.466667
+ 6.9388889 0.466667
+ 6.9416667 0.464609
+ 6.9444444 0.466667
+ 6.9472222 0.474897
+ 6.9500000 0.481070
+ 6.9527778 0.483128
+ 6.9555556 0.474897
+ 6.9583333 0.462551
+ 6.9611111 0.456379
+ 6.9638889 0.448148
+ 6.9666667 0.452263
+ 6.9694444 0.460494
+ 6.9722222 0.464609
+ 6.9750000 0.470782
+ 6.9777778 0.474897
+ 6.9805556 0.470782
+ 6.9833333 0.466667
+ 6.9861111 0.458436
+ 6.9888889 0.452263
+ 6.9916667 0.452263
+ 6.9944444 0.454321
+ 6.9972222 0.462551
+ 7.0000000 0.470782
+ 7.0027778 0.487243
+ 7.0055556 0.491358
+ 7.0083333 0.487243
+ 7.0111111 0.479012
+ 7.0138889 0.468724
+ 7.0166667 0.458436
+ 7.0194444 0.458436
+ 7.0222222 0.460494
+ 7.0250000 0.464609
+ 7.0277778 0.464609
+ 7.0305556 0.452263
+ 7.0333333 0.454321
+ 7.0361111 0.458436
+ 7.0388889 0.466667
+ 7.0416667 0.476955
+ 7.0444444 0.483128
+ 7.0472222 0.491358
+ 7.0500000 0.491358
+ 7.0527778 0.481070
+ 7.0555556 0.462551
+ 7.0583333 0.454321
+ 7.0611111 0.450206
+ 7.0638889 0.448148
+ 7.0666667 0.448148
+ 7.0694444 0.458436
+ 7.0722222 0.464609
+ 7.0750000 0.460494
+ 7.0777778 0.460494
+ 7.0805556 0.458436
+ 7.0833333 0.448148
+ 7.0861111 0.450206
+ 7.0888889 0.452263
+ 7.0916667 0.456379
+ 7.0944444 0.464609
+ 7.0972222 0.481070
+ 7.1000000 0.491358
+ 7.1027778 0.503704
+ 7.1055556 0.505761
+ 7.1083333 0.497531
+ 7.1111111 0.493416
+ 7.1138889 0.479012
+ 7.1166667 0.466667
+ 7.1194444 0.452263
+ 7.1222222 0.444033
+ 7.1250000 0.441975
+ 7.1277778 0.437860
+ 7.1305556 0.444033
+ 7.1333333 0.456379
+ 7.1361111 0.462551
+ 7.1388889 0.470782
+ 7.1416667 0.470782
+ 7.1444444 0.474897
+ 7.1472222 0.468724
+ 7.1500000 0.472840
+ 7.1527778 0.479012
+ 7.1555556 0.485185
+ 7.1583333 0.495473
+ 7.1611111 0.495473
+ 7.1638889 0.501646
+ 7.1666667 0.485185
+ 7.1694444 0.472840
+ 7.1722222 0.462551
+ 7.1750000 0.454321
+ 7.1777778 0.452263
+ 7.1805556 0.448148
+ 7.1833333 0.458436
+ 7.1861111 0.458436
+ 7.1888889 0.464609
+ 7.1916667 0.470782
+ 7.1944444 0.472840
+ 7.1972222 0.485185
+ 7.2000000 0.485185
+ 7.2027778 0.485185
+ 7.2055556 0.479012
+ 7.2083333 0.476955
+ 7.2111111 0.470782
+ 7.2138889 0.466667
+ 7.2166667 0.470782
+ 7.2194444 0.468724
+ 7.2222222 0.474897
+ 7.2250000 0.476955
+ 7.2277778 0.479012
+ 7.2305556 0.474897
+ 7.2333333 0.468724
+ 7.2361111 0.464609
+ 7.2388889 0.462551
+ 7.2416667 0.468724
+ 7.2444444 0.472840
+ 7.2472222 0.476955
+ 7.2500000 0.476955
+ 7.2527778 0.476955
+ 7.2555556 0.483128
+ 7.2583333 0.476955
+ 7.2611111 0.472840
+ 7.2638889 0.472840
+ 7.2666667 0.472840
+ 7.2694444 0.470782
+ 7.2722222 0.466667
+ 7.2750000 0.470782
+ 7.2777778 0.470782
+ 7.2805556 0.479012
+ 7.2833333 0.479012
+ 7.2861111 0.462551
+ 7.2888889 0.456379
+ 7.2916667 0.448148
+ 7.2944444 0.444033
+ 7.2972222 0.441975
+ 7.3000000 0.456379
+ 7.3027778 0.468724
+ 7.3055556 0.474897
+ 7.3083333 0.487243
+ 7.3111111 0.493416
+ 7.3138889 0.491358
+ 7.3166667 0.493416
+ 7.3194444 0.493416
+ 7.3222222 0.483128
+ 7.3250000 0.487243
+ 7.3277778 0.491358
+ 7.3305556 0.489300
+ 7.3333333 0.487243
+ 7.3361111 0.481070
+ 7.3388889 0.462551
+ 7.3416667 0.452263
+ 7.3444444 0.450206
+ 7.3472222 0.450206
+ 7.3500000 0.458436
+ 7.3527778 0.464609
+ 7.3555556 0.470782
+ 7.3583333 0.472840
+ 7.3611111 0.472840
+ 7.3638889 0.468724
+ 7.3666667 0.470782
+ 7.3694444 0.476955
+ 7.3722222 0.483128
+ 7.3750000 0.479012
+ 7.3777778 0.481070
+ 7.3805556 0.481070
+ 7.3833333 0.479012
+ 7.3861111 0.479012
+ 7.3888889 0.474897
+ 7.3916667 0.472840
+ 7.3944444 0.474897
+ 7.3972222 0.481070
+ 7.4000000 0.479012
+ 7.4027778 0.487243
+ 7.4055556 0.481070
+ 7.4083333 0.479012
+ 7.4111111 0.476955
+ 7.4138889 0.468724
+ 7.4166667 0.472840
+ 7.4194444 0.481070
+ 7.4222222 0.491358
+ 7.4250000 0.493416
+ 7.4277778 0.491358
+ 7.4305556 0.479012
+ 7.4333333 0.472840
+ 7.4361111 0.464609
+ 7.4388889 0.468724
+ 7.4416667 0.472840
+ 7.4444444 0.464609
+ 7.4472222 0.464609
+ 7.4500000 0.464609
+ 7.4527778 0.466667
+ 7.4555556 0.474897
+ 7.4583333 0.479012
+ 7.4611111 0.481070
+ 7.4638889 0.485185
+ 7.4666667 0.479012
+ 7.4694444 0.470782
+ 7.4722222 0.466667
+ 7.4750000 0.460494
+ 7.4777778 0.462551
+ 7.4805556 0.476955
+ 7.4833333 0.481070
+ 7.4861111 0.483128
+ 7.4888889 0.487243
+ 7.4916667 0.483128
+ 7.4944444 0.474897
+ 7.4972222 0.470782
+ 7.5000000 0.466667
+ 7.5027778 0.464609
+ 7.5055556 0.472840
+ 7.5083333 0.476955
+ 7.5111111 0.485185
+ 7.5138889 0.485185
+ 7.5166667 0.476955
+ 7.5194444 0.479012
+ 7.5222222 0.476955
+ 7.5250000 0.481070
+ 7.5277778 0.476955
+ 7.5305556 0.479012
+ 7.5333333 0.476955
+ 7.5361111 0.474897
+ 7.5388889 0.476955
+ 7.5416667 0.468724
+ 7.5444444 0.460494
+ 7.5472222 0.458436
+ 7.5500000 0.466667
+ 7.5527778 0.472840
+ 7.5555556 0.474897
+ 7.5583333 0.476955
+ 7.5611111 0.476955
+ 7.5638889 0.472840
+ 7.5666667 0.472840
+ 7.5694444 0.468724
+ 7.5722222 0.468724
+ 7.5750000 0.466667
+ 7.5777778 0.476955
+ 7.5805556 0.481070
+ 7.5833333 0.487243
+ 7.5861111 0.487243
+ 7.5888889 0.491358
+ 7.5916667 0.479012
+ 7.5944444 0.468724
+ 7.5972222 0.464609
+ 7.6000000 0.466667
+ 7.6027778 0.474897
+ 7.6055556 0.487243
+ 7.6083333 0.497531
+ 7.6111111 0.503704
+ 7.6138889 0.499588
+ 7.6166667 0.485185
+ 7.6194444 0.470782
+ 7.6222222 0.460494
+ 7.6250000 0.458436
+ 7.6277778 0.460494
+ 7.6305556 0.470782
+ 7.6333333 0.479012
+ 7.6361111 0.487243
+ 7.6388889 0.495473
+ 7.6416667 0.503704
+ 7.6444444 0.509877
+ 7.6472222 0.505761
+ 7.6500000 0.520165
+ 7.6527778 0.526337
+ 7.6555556 0.520165
+ 7.6583333 0.509877
+ 7.6611111 0.493416
+ 7.6638889 0.485185
+ 7.6666667 0.487243
+ 7.6694444 0.487243
+ 7.6722222 0.495473
+ 7.6750000 0.501646
+ 7.6777778 0.497531
+ 7.6805556 0.499588
+ 7.6833333 0.497531
+ 7.6861111 0.499588
+ 7.6888889 0.495473
+ 7.6916667 0.489300
+ 7.6944444 0.489300
+ 7.6972222 0.491358
+ 7.7000000 0.495473
+ 7.7027778 0.495473
+ 7.7055556 0.495473
+ 7.7083333 0.497531
+ 7.7111111 0.491358
+ 7.7138889 0.487243
+ 7.7166667 0.487243
+ 7.7194444 0.485185
+ 7.7222222 0.483128
+ 7.7250000 0.483128
+ 7.7277778 0.491358
+ 7.7305556 0.487243
+ 7.7333333 0.483128
+ 7.7361111 0.485185
+ 7.7388889 0.479012
+ 7.7416667 0.470782
+ 7.7444444 0.468724
+ 7.7472222 0.462551
+ 7.7500000 0.460494
+ 7.7527778 0.454321
+ 7.7555556 0.450206
+ 7.7583333 0.458436
+ 7.7611111 0.466667
+ 7.7638889 0.470782
+ 7.7666667 0.474897
+ 7.7694444 0.474897
+ 7.7722222 0.472840
+ 7.7750000 0.468724
+ 7.7777778 0.462551
+ 7.7805556 0.462551
+ 7.7833333 0.462551
+ 7.7861111 0.468724
+ 7.7888889 0.468724
+ 7.7916667 0.481070
+ 7.7944444 0.483128
+ 7.7972222 0.483128
+ 7.8000000 0.481070
+ 7.8027778 0.474897
+ 7.8055556 0.472840
+ 7.8083333 0.474897
+ 7.8111111 0.479012
+ 7.8138889 0.483128
+ 7.8166667 0.487243
+ 7.8194444 0.479012
+ 7.8222222 0.472840
+ 7.8250000 0.464609
+ 7.8277778 0.466667
+ 7.8305556 0.470782
+ 7.8333333 0.479012
+ 7.8361111 0.489300
+ 7.8388889 0.499588
+ 7.8416667 0.503704
+ 7.8444444 0.522222
+ 7.8472222 0.538683
+ 7.8500000 0.563374
+ 7.8527778 0.600412
+ 7.8555556 0.637449
+ 7.8583333 0.676543
+ 7.8611111 0.688889
+ 7.8638889 0.668313
+ 7.8666667 0.606584
+ 7.8694444 0.522222
+ 7.8722222 0.441975
+ 7.8750000 0.382305
+ 7.8777778 0.353498
+ 7.8805556 0.345267
+ 7.8833333 0.349383
+ 7.8861111 0.355556
+ 7.8888889 0.369959
+ 7.8916667 0.380247
+ 7.8944444 0.388477
+ 7.8972222 0.392593
+ 7.9000000 0.386420
+ 7.9027778 0.380247
+ 7.9055556 0.374074
+ 7.9083333 0.376132
+ 7.9111111 0.382305
+ 7.9138889 0.390535
+ 7.9166667 0.392593
+ 7.9194444 0.392593
+ 7.9222222 0.384362
+ 7.9250000 0.388477
+ 7.9277778 0.388477
+ 7.9305556 0.390535
+ 7.9333333 0.394650
+ 7.9361111 0.400823
+ 7.9388889 0.398765
+ 7.9416667 0.394650
+ 7.9444444 0.398765
+ 7.9472222 0.406996
+ 7.9500000 0.413169
+ 7.9527778 0.421399
+ 7.9555556 0.433745
+ 7.9583333 0.444033
+ 7.9611111 0.454321
+ 7.9638889 0.468724
+ 7.9666667 0.479012
+ 7.9694444 0.487243
+ 7.9722222 0.485185
+ 7.9750000 0.476955
+ 7.9777778 0.470782
+ 7.9805556 0.464609
+ 7.9833333 0.468724
+ 7.9861111 0.470782
+ 7.9888889 0.476955
+ 7.9916667 0.481070
+ 7.9944444 0.476955
+ 7.9972222 0.470782
+ 8.0000000 0.468724
+ 8.0027778 0.462551
+ 8.0055556 0.454321
+ 8.0083333 0.456379
+ 8.0111111 0.456379
+ 8.0138889 0.462551
+ 8.0166667 0.466667
+ 8.0194444 0.472840
+ 8.0222222 0.476955
+ 8.0250000 0.485185
+ 8.0277778 0.487243
+ 8.0305556 0.489300
+ 8.0333333 0.489300
+ 8.0361111 0.489300
+ 8.0388889 0.489300
+ 8.0416667 0.485185
+ 8.0444444 0.479012
+ 8.0472222 0.476955
+ 8.0500000 0.481070
+ 8.0527778 0.485185
+ 8.0555556 0.495473
+ 8.0583333 0.501646
+ 8.0611111 0.497531
+ 8.0638889 0.487243
+ 8.0666667 0.472840
+ 8.0694444 0.460494
+ 8.0722222 0.466667
+ 8.0750000 0.474897
+ 8.0777778 0.487243
+ 8.0805556 0.497531
+ 8.0833333 0.505761
+ 8.0861111 0.507819
+ 8.0888889 0.505761
+ 8.0916667 0.513992
+ 8.0944444 0.520165
+ 8.0972222 0.528395
+ 8.1000000 0.528395
+ 8.1027778 0.526337
+ 8.1055556 0.518107
+ 8.1083333 0.507819
+ 8.1111111 0.513992
+ 8.1138889 0.520165
+ 8.1166667 0.534568
+ 8.1194444 0.540741
+ 8.1222222 0.546914
+ 8.1250000 0.553086
+ 8.1277778 0.548971
+ 8.1305556 0.553086
+ 8.1333333 0.551029
+ 8.1361111 0.555144
+ 8.1388889 0.559259
+ 8.1416667 0.559259
+ 8.1444444 0.557202
+ 8.1472222 0.555144
+ 8.1500000 0.551029
+ 8.1527778 0.551029
+ 8.1555556 0.542798
+ 8.1583333 0.544856
+ 8.1611111 0.544856
+ 8.1638889 0.542798
+ 8.1666667 0.553086
+ 8.1694444 0.565432
+ 8.1722222 0.575720
+ 8.1750000 0.581893
+ 8.1777778 0.586008
+ 8.1805556 0.573663
+ 8.1833333 0.563374
+ 8.1861111 0.548971
+ 8.1888889 0.536626
+ 8.1916667 0.534568
+ 8.1944444 0.532510
+ 8.1972222 0.540741
+ 8.2000000 0.546914
+ 8.2027778 0.548971
+ 8.2055556 0.548971
+ 8.2083333 0.536626
+ 8.2111111 0.536626
+ 8.2138889 0.536626
+ 8.2166667 0.546914
+ 8.2194444 0.544856
+ 8.2222222 0.536626
+ 8.2250000 0.524280
+ 8.2277778 0.511934
+ 8.2305556 0.509877
+ 8.2333333 0.513992
+ 8.2361111 0.518107
+ 8.2388889 0.520165
+ 8.2416667 0.513992
+ 8.2444444 0.511934
+ 8.2472222 0.493416
+ 8.2500000 0.481070
+ 8.2527778 0.472840
+ 8.2555556 0.468724
+ 8.2583333 0.468724
+ 8.2611111 0.472840
+ 8.2638889 0.470782
+ 8.2666667 0.466667
+ 8.2694444 0.462551
+ 8.2722222 0.468724
+ 8.2750000 0.474897
+ 8.2777778 0.487243
+ 8.2805556 0.487243
+ 8.2833333 0.474897
+ 8.2861111 0.460494
+ 8.2888889 0.452263
+ 8.2916667 0.450206
+ 8.2944444 0.456379
+ 8.2972222 0.464609
+ 8.3000000 0.479012
+ 8.3027778 0.491358
+ 8.3055556 0.499588
+ 8.3083333 0.503704
+ 8.3111111 0.509877
+ 8.3138889 0.507819
+ 8.3166667 0.503704
+ 8.3194444 0.501646
+ 8.3222222 0.497531
+ 8.3250000 0.505761
+ 8.3277778 0.505761
+ 8.3305556 0.509877
+ 8.3333333 0.507819
+ 8.3361111 0.509877
+ 8.3388889 0.507819
+ 8.3416667 0.507819
+ 8.3444444 0.505761
+ 8.3472222 0.499588
+ 8.3500000 0.499588
+ 8.3527778 0.491358
+ 8.3555556 0.483128
+ 8.3583333 0.479012
+ 8.3611111 0.474897
+ 8.3638889 0.487243
+ 8.3666667 0.493416
+ 8.3694444 0.503704
+ 8.3722222 0.503704
+ 8.3750000 0.497531
+ 8.3777778 0.489300
+ 8.3805556 0.489300
+ 8.3833333 0.493416
+ 8.3861111 0.491358
+ 8.3888889 0.497531
+ 8.3916667 0.497531
+ 8.3944444 0.495473
+ 8.3972222 0.493416
+ 8.4000000 0.493416
+ 8.4027778 0.497531
+ 8.4055556 0.495473
+ 8.4083333 0.499588
+ 8.4111111 0.507819
+ 8.4138889 0.509877
+ 8.4166667 0.509877
+ 8.4194444 0.505761
+ 8.4222222 0.493416
+ 8.4250000 0.483128
+ 8.4277778 0.487243
+ 8.4305556 0.491358
+ 8.4333333 0.497531
+ 8.4361111 0.505761
+ 8.4388889 0.511934
+ 8.4416667 0.511934
+ 8.4444444 0.511934
+ 8.4472222 0.503704
+ 8.4500000 0.491358
+ 8.4527778 0.476955
+ 8.4555556 0.468724
+ 8.4583333 0.466667
+ 8.4611111 0.472840
+ 8.4638889 0.479012
+ 8.4666667 0.485185
+ 8.4694444 0.495473
+ 8.4722222 0.509877
+ 8.4750000 0.505761
+ 8.4777778 0.507819
+ 8.4805556 0.501646
+ 8.4833333 0.497531
+ 8.4861111 0.491358
+ 8.4888889 0.491358
+ 8.4916667 0.481070
+ 8.4944444 0.489300
+ 8.4972222 0.499588
+ 8.5000000 0.509877
+ 8.5027778 0.526337
+ 8.5055556 0.553086
+ 8.5083333 0.575720
+ 8.5111111 0.608642
+ 8.5138889 0.645679
+ 8.5166667 0.670370
+ 8.5194444 0.684774
+ 8.5222222 0.662140
+ 8.5250000 0.616872
+ 8.5277778 0.546914
+ 8.5305556 0.479012
+ 8.5333333 0.421399
+ 8.5361111 0.388477
+ 8.5388889 0.378189
+ 8.5416667 0.365844
+ 8.5444444 0.372016
+ 8.5472222 0.380247
+ 8.5500000 0.396708
+ 8.5527778 0.411111
+ 8.5555556 0.419342
+ 8.5583333 0.421399
+ 8.5611111 0.415226
+ 8.5638889 0.402881
+ 8.5666667 0.388477
+ 8.5694444 0.384362
+ 8.5722222 0.394650
+ 8.5750000 0.404938
+ 8.5777778 0.419342
+ 8.5805556 0.415226
+ 8.5833333 0.409053
+ 8.5861111 0.396708
+ 8.5888889 0.390535
+ 8.5916667 0.394650
+ 8.5944444 0.396708
+ 8.5972222 0.400823
+ 8.6000000 0.417284
+ 8.6027778 0.435802
+ 8.6055556 0.444033
+ 8.6083333 0.450206
+ 8.6111111 0.454321
+ 8.6138889 0.454321
+ 8.6166667 0.448148
+ 8.6194444 0.444033
+ 8.6222222 0.441975
+ 8.6250000 0.452263
+ 8.6277778 0.466667
+ 8.6305556 0.483128
+ 8.6333333 0.491358
+ 8.6361111 0.503704
+ 8.6388889 0.503704
+ 8.6416667 0.501646
+ 8.6444444 0.493416
+ 8.6472222 0.481070
+ 8.6500000 0.476955
+ 8.6527778 0.466667
+ 8.6555556 0.466667
+ 8.6583333 0.470782
+ 8.6611111 0.472840
+ 8.6638889 0.479012
+ 8.6666667 0.481070
+ 8.6694444 0.487243
+ 8.6722222 0.487243
+ 8.6750000 0.489300
+ 8.6777778 0.493416
+ 8.6805556 0.495473
+ 8.6833333 0.495473
+ 8.6861111 0.497531
+ 8.6888889 0.491358
+ 8.6916667 0.499588
+ 8.6944444 0.503704
+ 8.6972222 0.499588
+ 8.7000000 0.491358
+ 8.7027778 0.483128
+ 8.7055556 0.481070
+ 8.7083333 0.472840
+ 8.7111111 0.479012
+ 8.7138889 0.487243
+ 8.7166667 0.493416
+ 8.7194444 0.497531
+ 8.7222222 0.497531
+ 8.7250000 0.493416
+ 8.7277778 0.491358
+ 8.7305556 0.491358
+ 8.7333333 0.493416
+ 8.7361111 0.493416
+ 8.7388889 0.503704
+ 8.7416667 0.509877
+ 8.7444444 0.516049
+ 8.7472222 0.513992
+ 8.7500000 0.513992
+ 8.7527778 0.516049
+ 8.7555556 0.516049
+ 8.7583333 0.518107
+ 8.7611111 0.522222
+ 8.7638889 0.528395
+ 8.7666667 0.536626
+ 8.7694444 0.536626
+ 8.7722222 0.540741
+ 8.7750000 0.540741
+ 8.7777778 0.546914
+ 8.7805556 0.542798
+ 8.7833333 0.544856
+ 8.7861111 0.544856
+ 8.7888889 0.544856
+ 8.7916667 0.546914
+ 8.7944444 0.557202
+ 8.7972222 0.563374
+ 8.8000000 0.575720
+ 8.8027778 0.577778
+ 8.8055556 0.581893
+ 8.8083333 0.573663
+ 8.8111111 0.559259
+ 8.8138889 0.553086
+ 8.8166667 0.546914
+ 8.8194444 0.544856
+ 8.8222222 0.542798
+ 8.8250000 0.546914
+ 8.8277778 0.544856
+ 8.8305556 0.555144
+ 8.8333333 0.555144
+ 8.8361111 0.557202
+ 8.8388889 0.553086
+ 8.8416667 0.553086
+ 8.8444444 0.546914
+ 8.8472222 0.530453
+ 8.8500000 0.522222
+ 8.8527778 0.516049
+ 8.8555556 0.511934
+ 8.8583333 0.511934
+ 8.8611111 0.516049
+ 8.8638889 0.513992
+ 8.8666667 0.509877
+ 8.8694444 0.513992
+ 8.8722222 0.511934
+ 8.8750000 0.499588
+ 8.8777778 0.501646
+ 8.8805556 0.497531
+ 8.8833333 0.491358
+ 8.8861111 0.487243
+ 8.8888889 0.483128
+ 8.8916667 0.479012
+ 8.8944444 0.474897
+ 8.8972222 0.474897
+ 8.9000000 0.483128
+ 8.9027778 0.491358
+ 8.9055556 0.487243
+ 8.9083333 0.476955
+ 8.9111111 0.466667
+ 8.9138889 0.458436
+ 8.9166667 0.452263
+ 8.9194444 0.460494
+ 8.9222222 0.466667
+ 8.9250000 0.481070
+ 8.9277778 0.489300
+ 8.9305556 0.495473
+ 8.9333333 0.509877
+ 8.9361111 0.509877
+ 8.9388889 0.511934
+ 8.9416667 0.511934
+ 8.9444444 0.503704
+ 8.9472222 0.483128
+ 8.9500000 0.470782
+ 8.9527778 0.452263
+ 8.9555556 0.450206
+ 8.9583333 0.456379
+ 8.9611111 0.464609
+ 8.9638889 0.472840
+ 8.9666667 0.487243
+ 8.9694444 0.493416
+ 8.9722222 0.505761
+ 8.9750000 0.507819
+ 8.9777778 0.511934
+ 8.9805556 0.509877
+ 8.9833333 0.495473
+ 8.9861111 0.476955
+ 8.9888889 0.468724
+ 8.9916667 0.456379
+ 8.9944444 0.462551
+ 8.9972222 0.470782
+ 9.0000000 0.476955
+ 9.0027778 0.485185
+ 9.0055556 0.491358
+ 9.0083333 0.493416
+ 9.0111111 0.485185
+ 9.0138889 0.495473
+ 9.0166667 0.495473
+ 9.0194444 0.491358
+ 9.0222222 0.489300
+ 9.0250000 0.485185
+ 9.0277778 0.485185
+ 9.0305556 0.483128
+ 9.0333333 0.487243
+ 9.0361111 0.493416
+ 9.0388889 0.493416
+ 9.0416667 0.481070
+ 9.0444444 0.479012
+ 9.0472222 0.476955
+ 9.0500000 0.476955
+ 9.0527778 0.474897
+ 9.0555556 0.468724
+ 9.0583333 0.470782
+ 9.0611111 0.472840
+ 9.0638889 0.479012
+ 9.0666667 0.487243
+ 9.0694444 0.489300
+ 9.0722222 0.481070
+ 9.0750000 0.472840
+ 9.0777778 0.470782
+ 9.0805556 0.466667
+ 9.0833333 0.468724
+ 9.0861111 0.474897
+ 9.0888889 0.472840
+ 9.0916667 0.476955
+ 9.0944444 0.468724
+ 9.0972222 0.474897
+ 9.1000000 0.474897
+ 9.1027778 0.474897
+ 9.1055556 0.474897
+ 9.1083333 0.472840
+ 9.1111111 0.472840
+ 9.1138889 0.468724
+ 9.1166667 0.466667
+ 9.1194444 0.462551
+ 9.1222222 0.464609
+ 9.1250000 0.462551
+ 9.1277778 0.470782
+ 9.1305556 0.476955
+ 9.1333333 0.485185
+ 9.1361111 0.485185
+ 9.1388889 0.483128
+ 9.1416667 0.474897
+ 9.1444444 0.472840
+ 9.1472222 0.462551
+ 9.1500000 0.456379
+ 9.1527778 0.454321
+ 9.1555556 0.454321
+ 9.1583333 0.460494
+ 9.1611111 0.472840
+ 9.1638889 0.476955
+ 9.1666667 0.485185
+ 9.1694444 0.483128
+ 9.1722222 0.487243
+ 9.1750000 0.483128
+ 9.1777778 0.483128
+ 9.1805556 0.476955
+ 9.1833333 0.466667
+ 9.1861111 0.462551
+ 9.1888889 0.458436
+ 9.1916667 0.462551
+ 9.1944444 0.464609
+ 9.1972222 0.470782
+ 9.2000000 0.468724
+ 9.2027778 0.466667
+ 9.2055556 0.466667
+ 9.2083333 0.464609
+ 9.2111111 0.474897
+ 9.2138889 0.474897
+ 9.2166667 0.476955
+ 9.2194444 0.470782
+ 9.2222222 0.468724
+ 9.2250000 0.468724
+ 9.2277778 0.472840
+ 9.2305556 0.479012
+ 9.2333333 0.476955
+ 9.2361111 0.468724
+ 9.2388889 0.464609
+ 9.2416667 0.464609
+ 9.2444444 0.462551
+ 9.2472222 0.464609
+ 9.2500000 0.464609
+ 9.2527778 0.460494
+ 9.2555556 0.460494
+ 9.2583333 0.464609
+ 9.2611111 0.468724
+ 9.2638889 0.479012
+ 9.2666667 0.485185
+ 9.2694444 0.485185
+ 9.2722222 0.476955
+ 9.2750000 0.466667
+ 9.2777778 0.460494
+ 9.2805556 0.456379
+ 9.2833333 0.454321
+ 9.2861111 0.458436
+ 9.2888889 0.460494
+ 9.2916667 0.464609
+ 9.2944444 0.466667
+ 9.2972222 0.462551
+ 9.3000000 0.458436
+ 9.3027778 0.464609
+ 9.3055556 0.474897
+ 9.3083333 0.479012
+ 9.3111111 0.476955
+ 9.3138889 0.476955
+ 9.3166667 0.472840
+ 9.3194444 0.464609
+ 9.3222222 0.460494
+ 9.3250000 0.464609
+ 9.3277778 0.468724
+ 9.3305556 0.474897
+ 9.3333333 0.474897
+ 9.3361111 0.476955
+ 9.3388889 0.470782
+ 9.3416667 0.466667
+ 9.3444444 0.460494
+ 9.3472222 0.452263
+ 9.3500000 0.452263
+ 9.3527778 0.448148
+ 9.3555556 0.452263
+ 9.3583333 0.456379
+ 9.3611111 0.464609
+ 9.3638889 0.470782
+ 9.3666667 0.470782
+ 9.3694444 0.470782
+ 9.3722222 0.466667
+ 9.3750000 0.462551
+ 9.3777778 0.460494
+ 9.3805556 0.456379
+ 9.3833333 0.462551
+ 9.3861111 0.462551
+ 9.3888889 0.472840
+ 9.3916667 0.472840
+ 9.3944444 0.466667
+ 9.3972222 0.460494
+ 9.4000000 0.456379
+ 9.4027778 0.452263
+ 9.4055556 0.454321
+ 9.4083333 0.456379
+ 9.4111111 0.462551
+ 9.4138889 0.464609
+ 9.4166667 0.470782
+ 9.4194444 0.476955
+ 9.4222222 0.481070
+ 9.4250000 0.476955
+ 9.4277778 0.470782
+ 9.4305556 0.470782
+ 9.4333333 0.462551
+ 9.4361111 0.450206
+ 9.4388889 0.444033
+ 9.4416667 0.446091
+ 9.4444444 0.448148
+ 9.4472222 0.460494
+ 9.4500000 0.466667
+ 9.4527778 0.464609
+ 9.4555556 0.458436
+ 9.4583333 0.458436
+ 9.4611111 0.462551
+ 9.4638889 0.462551
+ 9.4666667 0.468724
+ 9.4694444 0.483128
+ 9.4722222 0.485185
+ 9.4750000 0.479012
+ 9.4777778 0.466667
+ 9.4805556 0.454321
+ 9.4833333 0.452263
+ 9.4861111 0.452263
+ 9.4888889 0.466667
+ 9.4916667 0.479012
+ 9.4944444 0.481070
+ 9.4972222 0.481070
+ 9.5000000 0.462551
+ 9.5027778 0.448148
+ 9.5055556 0.437860
+ 9.5083333 0.437860
+ 9.5111111 0.446091
+ 9.5138889 0.460494
+ 9.5166667 0.468724
+ 9.5194444 0.474897
+ 9.5222222 0.476955
+ 9.5250000 0.476955
+ 9.5277778 0.468724
+ 9.5305556 0.462551
+ 9.5333333 0.456379
+ 9.5361111 0.462551
+ 9.5388889 0.468724
+ 9.5416667 0.468724
+ 9.5444444 0.476955
+ 9.5472222 0.474897
+ 9.5500000 0.468724
+ 9.5527778 0.468724
+ 9.5555556 0.458436
+ 9.5583333 0.452263
+ 9.5611111 0.452263
+ 9.5638889 0.452263
+ 9.5666667 0.464609
+ 9.5694444 0.472840
+ 9.5722222 0.474897
+ 9.5750000 0.479012
+ 9.5777778 0.481070
+ 9.5805556 0.474897
+ 9.5833333 0.472840
+ 9.5861111 0.472840
+ 9.5888889 0.468724
+ 9.5916667 0.460494
+ 9.5944444 0.454321
+ 9.5972222 0.456379
+ 9.6000000 0.458436
+ 9.6027778 0.458436
+ 9.6055556 0.462551
+ 9.6083333 0.458436
+ 9.6111111 0.460494
+ 9.6138889 0.464609
+ 9.6166667 0.466667
+ 9.6194444 0.466667
+ 9.6222222 0.466667
+ 9.6250000 0.466667
+ 9.6277778 0.458436
+ 9.6305556 0.460494
+ 9.6333333 0.462551
+ 9.6361111 0.466667
+ 9.6388889 0.472840
+ 9.6416667 0.474897
+ 9.6444444 0.479012
+ 9.6472222 0.474897
+ 9.6500000 0.468724
+ 9.6527778 0.454321
+ 9.6555556 0.450206
+ 9.6583333 0.452263
+ 9.6611111 0.452263
+ 9.6638889 0.452263
+ 9.6666667 0.441975
+ 9.6694444 0.452263
+ 9.6722222 0.458436
+ 9.6750000 0.462551
+ 9.6777778 0.466667
+ 9.6805556 0.468724
+ 9.6833333 0.460494
+ 9.6861111 0.464609
+ 9.6888889 0.458436
+ 9.6916667 0.454321
+ 9.6944444 0.452263
+ 9.6972222 0.448148
+ 9.7000000 0.450206
+ 9.7027778 0.452263
+ 9.7055556 0.462551
+ 9.7083333 0.458436
+ 9.7111111 0.460494
+ 9.7138889 0.460494
+ 9.7166667 0.450206
+ 9.7194444 0.456379
+ 9.7222222 0.450206
+ 9.7250000 0.448148
+ 9.7277778 0.454321
+ 9.7305556 0.454321
+ 9.7333333 0.458436
+ 9.7361111 0.460494
+ 9.7388889 0.468724
+ 9.7416667 0.474897
+ 9.7444444 0.476955
+ 9.7472222 0.472840
+ 9.7500000 0.458436
+ 9.7527778 0.446091
+ 9.7555556 0.437860
+ 9.7583333 0.439918
+ 9.7611111 0.448148
+ 9.7638889 0.452263
+ 9.7666667 0.456379
+ 9.7694444 0.458436
+ 9.7722222 0.464609
+ 9.7750000 0.466667
+ 9.7777778 0.470782
+ 9.7805556 0.462551
+ 9.7833333 0.456379
+ 9.7861111 0.456379
+ 9.7888889 0.448148
+ 9.7916667 0.448148
+ 9.7944444 0.450206
+ 9.7972222 0.450206
+ 9.8000000 0.458436
+ 9.8027778 0.464609
+ 9.8055556 0.466667
+ 9.8083333 0.470782
+ 9.8111111 0.468724
+ 9.8138889 0.466667
+ 9.8166667 0.464609
+ 9.8194444 0.456379
+ 9.8222222 0.454321
+ 9.8250000 0.448148
+ 9.8277778 0.450206
+ 9.8305556 0.448148
+ 9.8333333 0.450206
+ 9.8361111 0.452263
+ 9.8388889 0.454321
+ 9.8416667 0.460494
+ 9.8444444 0.460494
+ 9.8472222 0.460494
+ 9.8500000 0.458436
+ 9.8527778 0.454321
+ 9.8555556 0.448148
+ 9.8583333 0.448148
+ 9.8611111 0.446091
+ 9.8638889 0.448148
+ 9.8666667 0.452263
+ 9.8694444 0.458436
+ 9.8722222 0.464609
+ 9.8750000 0.472840
+ 9.8777778 0.479012
+ 9.8805556 0.485185
+ 9.8833333 0.481070
+ 9.8861111 0.474897
+ 9.8888889 0.460494
+ 9.8916667 0.446091
+ 9.8944444 0.441975
+ 9.8972222 0.439918
+ 9.9000000 0.444033
+ 9.9027778 0.454321
+ 9.9055556 0.460494
+ 9.9083333 0.456379
+ 9.9111111 0.458436
+ 9.9138889 0.446091
+ 9.9166667 0.439918
+ 9.9194444 0.435802
+ 9.9222222 0.439918
+ 9.9250000 0.454321
+ 9.9277778 0.462551
+ 9.9305556 0.474897
+ 9.9333333 0.481070
+ 9.9361111 0.485185
+ 9.9388889 0.474897
+ 9.9416667 0.464609
+ 9.9444444 0.456379
+ 9.9472222 0.448148
+ 9.9500000 0.450206
+ 9.9527778 0.462551
+ 9.9555556 0.468724
+ 9.9583333 0.479012
+ 9.9611111 0.485185
+ 9.9638889 0.476955
+ 9.9666667 0.474897
+ 9.9694444 0.470782
+ 9.9722222 0.479012
+ 9.9750000 0.487243
+ 9.9777778 0.503704
+ 9.9805556 0.505761
+ 9.9833333 0.507819
+ 9.9861111 0.499588
+ 9.9888889 0.487243
+ 9.9916667 0.474897
+ 9.9944444 0.458436
+ 9.9972222 0.458436
+ 10.0000000 0.458436
+ 10.0027778 0.466667
+ 10.0055556 0.479012
+ 10.0083333 0.487243
+ 10.0111111 0.489300
+ 10.0138889 0.491358
+ 10.0166667 0.495473
+ 10.0194444 0.493416
+ 10.0222222 0.489300
+ 10.0250000 0.476955
+ 10.0277778 0.470782
+ 10.0305556 0.470782
+ 10.0333333 0.474897
+ 10.0361111 0.476955
+ 10.0388889 0.479012
+ 10.0416667 0.472840
+ 10.0444444 0.468724
+ 10.0472222 0.466667
+ 10.0500000 0.466667
+ 10.0527778 0.468724
+ 10.0555556 0.464609
+ 10.0583333 0.460494
+ 10.0611111 0.454321
+ 10.0638889 0.446091
+ 10.0666667 0.448148
+ 10.0694444 0.450206
+ 10.0722222 0.454321
+ 10.0750000 0.450206
+ 10.0777778 0.458436
+ 10.0805556 0.454321
+ 10.0833333 0.456379
+ 10.0861111 0.446091
+ 10.0888889 0.435802
+ 10.0916667 0.435802
+ 10.0944444 0.433745
+ 10.0972222 0.441975
+ 10.1000000 0.452263
+ 10.1027778 0.462551
+ 10.1055556 0.470782
+ 10.1083333 0.468724
+ 10.1111111 0.466667
+ 10.1138889 0.452263
+ 10.1166667 0.450206
+ 10.1194444 0.444033
+ 10.1222222 0.441975
+ 10.1250000 0.444033
+ 10.1277778 0.454321
+ 10.1305556 0.464609
+ 10.1333333 0.466667
+ 10.1361111 0.472840
+ 10.1388889 0.472840
+ 10.1416667 0.462551
+ 10.1444444 0.458436
+ 10.1472222 0.448148
+ 10.1500000 0.446091
+ 10.1527778 0.446091
+ 10.1555556 0.458436
+ 10.1583333 0.458436
+ 10.1611111 0.464609
+ 10.1638889 0.470782
+ 10.1666667 0.474897
+ 10.1694444 0.489300
+ 10.1722222 0.503704
+ 10.1750000 0.518107
+ 10.1777778 0.548971
+ 10.1805556 0.573663
+ 10.1833333 0.602469
+ 10.1861111 0.620988
+ 10.1888889 0.631276
+ 10.1916667 0.625103
+ 10.1944444 0.598354
+ 10.1972222 0.559259
+ 10.2000000 0.503704
+ 10.2027778 0.444033
+ 10.2055556 0.386420
+ 10.2083333 0.353498
+ 10.2111111 0.339095
+ 10.2138889 0.337037
+ 10.2166667 0.337037
+ 10.2194444 0.341152
+ 10.2222222 0.334979
+ 10.2250000 0.341152
+ 10.2277778 0.347325
+ 10.2305556 0.359671
+ 10.2333333 0.359671
+ 10.2361111 0.367901
+ 10.2388889 0.365844
+ 10.2416667 0.355556
+ 10.2444444 0.357613
+ 10.2472222 0.367901
+ 10.2500000 0.382305
+ 10.2527778 0.396708
+ 10.2555556 0.394650
+ 10.2583333 0.398765
+ 10.2611111 0.396708
+ 10.2638889 0.390535
+ 10.2666667 0.376132
+ 10.2694444 0.378189
+ 10.2722222 0.378189
+ 10.2750000 0.386420
+ 10.2777778 0.396708
+ 10.2805556 0.406996
+ 10.2833333 0.409053
+ 10.2861111 0.419342
+ 10.2888889 0.429630
+ 10.2916667 0.441975
+ 10.2944444 0.450206
+ 10.2972222 0.456379
+ 10.3000000 0.456379
+ 10.3027778 0.458436
+ 10.3055556 0.462551
+ 10.3083333 0.468724
+ 10.3111111 0.472840
+ 10.3138889 0.481070
+ 10.3166667 0.481070
+ 10.3194444 0.479012
+ 10.3222222 0.476955
+ 10.3250000 0.474897
+ 10.3277778 0.466667
+ 10.3305556 0.458436
+ 10.3333333 0.452263
+ 10.3361111 0.450206
+ 10.3388889 0.456379
+ 10.3416667 0.458436
+ 10.3444444 0.460494
+ 10.3472222 0.454321
+ 10.3500000 0.452263
+ 10.3527778 0.450206
+ 10.3555556 0.448148
+ 10.3583333 0.456379
+ 10.3611111 0.456379
+ 10.3638889 0.462551
+ 10.3666667 0.468724
+ 10.3694444 0.474897
+ 10.3722222 0.474897
+ 10.3750000 0.483128
+ 10.3777778 0.489300
+ 10.3805556 0.487243
+ 10.3833333 0.485185
+ 10.3861111 0.481070
+ 10.3888889 0.476955
+ 10.3916667 0.472840
+ 10.3944444 0.464609
+ 10.3972222 0.456379
+ 10.4000000 0.460494
+ 10.4027778 0.468724
+ 10.4055556 0.476955
+ 10.4083333 0.483128
+ 10.4111111 0.491358
+ 10.4138889 0.489300
+ 10.4166667 0.489300
+ 10.4194444 0.493416
+ 10.4222222 0.497531
+ 10.4250000 0.509877
+ 10.4277778 0.522222
+ 10.4305556 0.524280
+ 10.4333333 0.511934
+ 10.4361111 0.503704
+ 10.4388889 0.489300
+ 10.4416667 0.485185
+ 10.4444444 0.495473
+ 10.4472222 0.503704
+ 10.4500000 0.516049
+ 10.4527778 0.520165
+ 10.4555556 0.509877
+ 10.4583333 0.499588
+ 10.4611111 0.495473
+ 10.4638889 0.503704
+ 10.4666667 0.513992
+ 10.4694444 0.522222
+ 10.4722222 0.530453
+ 10.4750000 0.538683
+ 10.4777778 0.540741
+ 10.4805556 0.553086
+ 10.4833333 0.557202
+ 10.4861111 0.559259
+ 10.4888889 0.555144
+ 10.4916667 0.553086
+ 10.4944444 0.544856
+ 10.4972222 0.536626
+ 10.5000000 0.532510
+ 10.5027778 0.546914
+ 10.5055556 0.553086
+ 10.5083333 0.561317
+ 10.5111111 0.571605
+ 10.5138889 0.573663
+ 10.5166667 0.567490
+ 10.5194444 0.542798
+ 10.5222222 0.520165
+ 10.5250000 0.503704
+ 10.5277778 0.503704
+ 10.5305556 0.513992
+ 10.5333333 0.528395
+ 10.5361111 0.538683
+ 10.5388889 0.546914
+ 10.5416667 0.544856
+ 10.5444444 0.540741
+ 10.5472222 0.524280
+ 10.5500000 0.505761
+ 10.5527778 0.495473
+ 10.5555556 0.489300
+ 10.5583333 0.485185
+ 10.5611111 0.485185
+ 10.5638889 0.487243
+ 10.5666667 0.485185
+ 10.5694444 0.481070
+ 10.5722222 0.489300
+ 10.5750000 0.485185
+ 10.5777778 0.485185
+ 10.5805556 0.483128
+ 10.5833333 0.479012
+ 10.5861111 0.468724
+ 10.5888889 0.464609
+ 10.5916667 0.458436
+ 10.5944444 0.456379
+ 10.5972222 0.458436
+ 10.6000000 0.454321
+ 10.6027778 0.456379
+ 10.6055556 0.454321
+ 10.6083333 0.450206
+ 10.6111111 0.439918
+ 10.6138889 0.437860
+ 10.6166667 0.429630
+ 10.6194444 0.433745
+ 10.6222222 0.435802
+ 10.6250000 0.435802
+ 10.6277778 0.435802
+ 10.6305556 0.437860
+ 10.6333333 0.441975
+ 10.6361111 0.446091
+ 10.6388889 0.450206
+ 10.6416667 0.450206
+ 10.6444444 0.448148
+ 10.6472222 0.448148
+ 10.6500000 0.452263
+ 10.6527778 0.454321
+ 10.6555556 0.456379
+ 10.6583333 0.462551
+ 10.6611111 0.468724
+ 10.6638889 0.470782
+ 10.6666667 0.468724
+ 10.6694444 0.468724
+ 10.6722222 0.470782
+ 10.6750000 0.464609
+ 10.6777778 0.472840
+ 10.6805556 0.466667
+ 10.6833333 0.462551
+ 10.6861111 0.458436
+ 10.6888889 0.448148
+ 10.6916667 0.452263
+ 10.6944444 0.458436
+ 10.6972222 0.466667
+ 10.7000000 0.472840
+ 10.7027778 0.472840
+ 10.7055556 0.479012
+ 10.7083333 0.481070
+ 10.7111111 0.481070
+ 10.7138889 0.470782
+ 10.7166667 0.456379
+ 10.7194444 0.452263
+ 10.7222222 0.452263
+ 10.7250000 0.456379
+ 10.7277778 0.460494
+ 10.7305556 0.466667
+ 10.7333333 0.476955
+ 10.7361111 0.481070
+ 10.7388889 0.489300
+ 10.7416667 0.487243
+ 10.7444444 0.479012
+ 10.7472222 0.474897
+ 10.7500000 0.466667
+ 10.7527778 0.458436
+ 10.7555556 0.448148
+ 10.7583333 0.441975
+ 10.7611111 0.444033
+ 10.7638889 0.456379
+ 10.7666667 0.462551
+ 10.7694444 0.474897
+ 10.7722222 0.481070
+ 10.7750000 0.487243
+ 10.7777778 0.487243
+ 10.7805556 0.487243
+ 10.7833333 0.472840
+ 10.7861111 0.456379
+ 10.7888889 0.446091
+ 10.7916667 0.441975
+ 10.7944444 0.448148
+ 10.7972222 0.458436
+ 10.8000000 0.458436
+ 10.8027778 0.460494
+ 10.8055556 0.454321
+ 10.8083333 0.452263
+ 10.8111111 0.450206
+ 10.8138889 0.446091
+ 10.8166667 0.448148
+ 10.8194444 0.452263
+ 10.8222222 0.456379
+ 10.8250000 0.460494
+ 10.8277778 0.472840
+ 10.8305556 0.476955
+ 10.8333333 0.481070
+ 10.8361111 0.479012
+ 10.8388889 0.476955
+ 10.8416667 0.479012
+ 10.8444444 0.476955
+ 10.8472222 0.497531
+ 10.8500000 0.526337
+ 10.8527778 0.563374
+ 10.8555556 0.606584
+ 10.8583333 0.649794
+ 10.8611111 0.674486
+ 10.8638889 0.680658
+ 10.8666667 0.643621
+ 10.8694444 0.575720
+ 10.8722222 0.495473
+ 10.8750000 0.411111
+ 10.8777778 0.357613
+ 10.8805556 0.328807
+ 10.8833333 0.322634
+ 10.8861111 0.337037
+ 10.8888889 0.347325
+ 10.8916667 0.363786
+ 10.8944444 0.388477
+ 10.8972222 0.394650
+ 10.9000000 0.394650
+ 10.9027778 0.378189
+ 10.9055556 0.361728
+ 10.9083333 0.343210
+ 10.9111111 0.347325
+ 10.9138889 0.357613
+ 10.9166667 0.376132
+ 10.9194444 0.394650
+ 10.9222222 0.398765
+ 10.9250000 0.400823
+ 10.9277778 0.390535
+ 10.9305556 0.380247
+ 10.9333333 0.378189
+ 10.9361111 0.376132
+ 10.9388889 0.390535
+ 10.9416667 0.396708
+ 10.9444444 0.398765
+ 10.9472222 0.406996
+ 10.9500000 0.409053
+ 10.9527778 0.406996
+ 10.9555556 0.413169
+ 10.9583333 0.417284
+ 10.9611111 0.419342
+ 10.9638889 0.427572
+ 10.9666667 0.433745
+ 10.9694444 0.454321
+ 10.9722222 0.464609
+ 10.9750000 0.476955
+ 10.9777778 0.485185
+ 10.9805556 0.491358
+ 10.9833333 0.497531
+ 10.9861111 0.487243
+ 10.9888889 0.466667
+ 10.9916667 0.450206
+ 10.9944444 0.427572
+ 10.9972222 0.411111
+ 11.0000000 0.411111
+ 11.0027778 0.421399
+ 11.0055556 0.437860
+ 11.0083333 0.444033
+ 11.0111111 0.454321
+ 11.0138889 0.458436
+ 11.0166667 0.456379
+ 11.0194444 0.462551
+ 11.0222222 0.476955
+ 11.0250000 0.493416
+ 11.0277778 0.505761
+ 11.0305556 0.511934
+ 11.0333333 0.499588
+ 11.0361111 0.470782
+ 11.0388889 0.446091
+ 11.0416667 0.425514
+ 11.0444444 0.421399
+ 11.0472222 0.429630
+ 11.0500000 0.435802
+ 11.0527778 0.452263
+ 11.0555556 0.452263
+ 11.0583333 0.466667
+ 11.0611111 0.466667
+ 11.0638889 0.470782
+ 11.0666667 0.472840
+ 11.0694444 0.481070
+ 11.0722222 0.487243
+ 11.0750000 0.485185
+ 11.0777778 0.489300
+ 11.0805556 0.489300
+ 11.0833333 0.495473
+ 11.0861111 0.499588
+ 11.0888889 0.513992
+ 11.0916667 0.524280
+ 11.0944444 0.520165
+ 11.0972222 0.499588
+ 11.1000000 0.479012
+ 11.1027778 0.466667
+ 11.1055556 0.462551
+ 11.1083333 0.472840
+ 11.1111111 0.491358
+ 11.1138889 0.505761
+ 11.1166667 0.516049
+ 11.1194444 0.520165
+ 11.1222222 0.522222
+ 11.1250000 0.520165
+ 11.1277778 0.524280
+ 11.1305556 0.534568
+ 11.1333333 0.542798
+ 11.1361111 0.548971
+ 11.1388889 0.557202
+ 11.1416667 0.559259
+ 11.1444444 0.553086
+ 11.1472222 0.563374
+ 11.1500000 0.559259
+ 11.1527778 0.548971
+ 11.1555556 0.536626
+ 11.1583333 0.526337
+ 11.1611111 0.516049
+ 11.1638889 0.509877
+ 11.1666667 0.511934
+ 11.1694444 0.518107
+ 11.1722222 0.524280
+ 11.1750000 0.528395
+ 11.1777778 0.534568
+ 11.1805556 0.532510
+ 11.1833333 0.522222
+ 11.1861111 0.516049
+ 11.1888889 0.513992
+ 11.1916667 0.518107
+ 11.1944444 0.518107
+ 11.1972222 0.513992
+ 11.2000000 0.495473
+ 11.2027778 0.491358
+ 11.2055556 0.476955
+ 11.2083333 0.468724
+ 11.2111111 0.468724
+ 11.2138889 0.460494
+ 11.2166667 0.458436
+ 11.2194444 0.448148
+ 11.2222222 0.441975
+ 11.2250000 0.441975
+ 11.2277778 0.448148
+ 11.2305556 0.456379
+ 11.2333333 0.466667
+ 11.2361111 0.470782
+ 11.2388889 0.476955
+ 11.2416667 0.472840
+ 11.2444444 0.472840
+ 11.2472222 0.464609
+ 11.2500000 0.450206
+ 11.2527778 0.441975
+ 11.2555556 0.431687
+ 11.2583333 0.421399
+ 11.2611111 0.421399
+ 11.2638889 0.419342
+ 11.2666667 0.423457
+ 11.2694444 0.439918
+ 11.2722222 0.450206
+ 11.2750000 0.452263
+ 11.2777778 0.456379
+ 11.2805556 0.452263
+ 11.2833333 0.454321
+ 11.2861111 0.446091
+ 11.2888889 0.441975
+ 11.2916667 0.446091
+ 11.2944444 0.448148
+ 11.2972222 0.460494
+ 11.3000000 0.462551
+ 11.3027778 0.466667
+ 11.3055556 0.466667
+ 11.3083333 0.466667
+ 11.3111111 0.460494
+ 11.3138889 0.452263
+ 11.3166667 0.448148
+ 11.3194444 0.441975
+ 11.3222222 0.439918
+ 11.3250000 0.441975
+ 11.3277778 0.446091
+ 11.3305556 0.456379
+ 11.3333333 0.462551
+ 11.3361111 0.468724
+ 11.3388889 0.470782
+ 11.3416667 0.466667
+ 11.3444444 0.458436
+ 11.3472222 0.452263
+ 11.3500000 0.444033
+ 11.3527778 0.435802
+ 11.3555556 0.429630
+ 11.3583333 0.437860
+ 11.3611111 0.435802
+ 11.3638889 0.439918
+ 11.3666667 0.444033
+ 11.3694444 0.450206
+ 11.3722222 0.458436
+ 11.3750000 0.458436
+ 11.3777778 0.464609
+ 11.3805556 0.464609
+ 11.3833333 0.460494
+ 11.3861111 0.458436
+ 11.3888889 0.458436
+ 11.3916667 0.460494
+ 11.3944444 0.458436
+ 11.3972222 0.462551
+ 11.4000000 0.458436
+ 11.4027778 0.450206
+ 11.4055556 0.446091
+ 11.4083333 0.437860
+ 11.4111111 0.441975
+ 11.4138889 0.448148
+ 11.4166667 0.456379
+ 11.4194444 0.464609
+ 11.4222222 0.460494
+ 11.4250000 0.458436
+ 11.4277778 0.452263
+ 11.4305556 0.444033
+ 11.4333333 0.439918
+ 11.4361111 0.439918
+ 11.4388889 0.437860
+ 11.4416667 0.437860
+ 11.4444444 0.439918
+ 11.4472222 0.441975
+ 11.4500000 0.441975
+ 11.4527778 0.444033
+ 11.4555556 0.446091
+ 11.4583333 0.452263
+ 11.4611111 0.458436
+ 11.4638889 0.464609
+ 11.4666667 0.462551
+ 11.4694444 0.450206
+ 11.4722222 0.439918
+ 11.4750000 0.423457
+ 11.4777778 0.423457
+ 11.4805556 0.421399
+ 11.4833333 0.421399
+ 11.4861111 0.429630
+ 11.4888889 0.429630
+ 11.4916667 0.439918
+ 11.4944444 0.450206
+ 11.4972222 0.452263
+ 11.5000000 0.460494
+ 11.5027778 0.474897
+ 11.5055556 0.499588
+ 11.5083333 0.509877
+ 11.5111111 0.501646
+ 11.5138889 0.470782
+ 11.5166667 0.423457
+ 11.5194444 0.386420
+ 11.5222222 0.363786
+ 11.5250000 0.369959
+ 11.5277778 0.386420
+ 11.5305556 0.417284
+ 11.5333333 0.439918
+ 11.5361111 0.456379
+ 11.5388889 0.464609
+ 11.5416667 0.462551
+ 11.5444444 0.456379
+ 11.5472222 0.444033
+ 11.5500000 0.439918
+ 11.5527778 0.437860
+ 11.5555556 0.433745
+ 11.5583333 0.435802
+ 11.5611111 0.441975
+ 11.5638889 0.446091
+ 11.5666667 0.456379
+ 11.5694444 0.460494
+ 11.5722222 0.474897
+ 11.5750000 0.476955
+ 11.5777778 0.483128
+ 11.5805556 0.470782
+ 11.5833333 0.456379
+ 11.5861111 0.435802
+ 11.5888889 0.427572
+ 11.5916667 0.413169
+ 11.5944444 0.404938
+ 11.5972222 0.406996
+ 11.6000000 0.411111
+ 11.6027778 0.429630
+ 11.6055556 0.441975
+ 11.6083333 0.452263
+ 11.6111111 0.456379
+ 11.6138889 0.456379
+ 11.6166667 0.456379
+ 11.6194444 0.444033
+ 11.6222222 0.437860
+ 11.6250000 0.433745
+ 11.6277778 0.429630
+ 11.6305556 0.429630
+ 11.6333333 0.433745
+ 11.6361111 0.437860
+ 11.6388889 0.439918
+ 11.6416667 0.444033
+ 11.6444444 0.444033
+ 11.6472222 0.444033
+ 11.6500000 0.441975
+ 11.6527778 0.441975
+ 11.6555556 0.437860
+ 11.6583333 0.439918
+ 11.6611111 0.448148
+ 11.6638889 0.450206
+ 11.6666667 0.458436
+ 11.6694444 0.472840
+ 11.6722222 0.476955
+ 11.6750000 0.462551
+ 11.6777778 0.452263
+ 11.6805556 0.437860
+ 11.6833333 0.427572
+ 11.6861111 0.419342
+ 11.6888889 0.413169
+ 11.6916667 0.415226
+ 11.6944444 0.419342
+ 11.6972222 0.423457
+ 11.7000000 0.433745
+ 11.7027778 0.450206
+ 11.7055556 0.468724
+ 11.7083333 0.476955
+ 11.7111111 0.472840
+ 11.7138889 0.464609
+ 11.7166667 0.452263
+ 11.7194444 0.439918
+ 11.7222222 0.427572
+ 11.7250000 0.419342
+ 11.7277778 0.415226
+ 11.7305556 0.419342
+ 11.7333333 0.417284
+ 11.7361111 0.423457
+ 11.7388889 0.431687
+ 11.7416667 0.439918
+ 11.7444444 0.444033
+ 11.7472222 0.448148
+ 11.7500000 0.452263
+ 11.7527778 0.454321
+ 11.7555556 0.456379
+ 11.7583333 0.452263
+ 11.7611111 0.452263
+ 11.7638889 0.450206
+ 11.7666667 0.450206
+ 11.7694444 0.446091
+ 11.7722222 0.446091
+ 11.7750000 0.444033
+ 11.7777778 0.446091
+ 11.7805556 0.448148
+ 11.7833333 0.448148
+ 11.7861111 0.452263
+ 11.7888889 0.454321
+ 11.7916667 0.462551
+ 11.7944444 0.468724
+ 11.7972222 0.468724
+ 11.8000000 0.462551
+ 11.8027778 0.456379
+ 11.8055556 0.441975
+ 11.8083333 0.431687
+ 11.8111111 0.435802
+ 11.8138889 0.441975
+ 11.8166667 0.439918
+ 11.8194444 0.448148
+ 11.8222222 0.450206
+ 11.8250000 0.450206
+ 11.8277778 0.456379
+ 11.8305556 0.460494
+ 11.8333333 0.458436
+ 11.8361111 0.450206
+ 11.8388889 0.446091
+ 11.8416667 0.435802
+ 11.8444444 0.439918
+ 11.8472222 0.446091
+ 11.8500000 0.452263
+ 11.8527778 0.450206
+ 11.8555556 0.444033
+ 11.8583333 0.452263
+ 11.8611111 0.452263
+ 11.8638889 0.452263
+ 11.8666667 0.458436
+ 11.8694444 0.466667
+ 11.8722222 0.458436
+ 11.8750000 0.454321
+ 11.8777778 0.444033
+ 11.8805556 0.439918
+ 11.8833333 0.429630
+ 11.8861111 0.429630
+ 11.8888889 0.441975
+ 11.8916667 0.448148
+ 11.8944444 0.454321
+ 11.8972222 0.458436
+ 11.9000000 0.468724
+ 11.9027778 0.474897
+ 11.9055556 0.472840
+ 11.9083333 0.472840
+ 11.9111111 0.456379
+ 11.9138889 0.441975
+ 11.9166667 0.427572
+ 11.9194444 0.423457
+ 11.9222222 0.433745
+ 11.9250000 0.448148
+ 11.9277778 0.458436
+ 11.9305556 0.464609
+ 11.9333333 0.464609
+ 11.9361111 0.454321
+ 11.9388889 0.450206
+ 11.9416667 0.441975
+ 11.9444444 0.437860
+ 11.9472222 0.439918
+ 11.9500000 0.448148
+ 11.9527778 0.448148
+ 11.9555556 0.452263
+ 11.9583333 0.448148
+ 11.9611111 0.452263
+ 11.9638889 0.450206
+ 11.9666667 0.446091
+ 11.9694444 0.448148
+ 11.9722222 0.446091
+ 11.9750000 0.450206
+ 11.9777778 0.450206
+ 11.9805556 0.454321
+ 11.9833333 0.454321
+ 11.9861111 0.452263
+ 11.9888889 0.450206
+ 11.9916667 0.452263
+ 11.9944444 0.462551
+ 11.9972222 0.472840
+ 12.0000000 0.476955
+ 12.0027778 0.479012
+ 12.0055556 0.483128
+ 12.0083333 0.468724
+ 12.0111111 0.450206
+ 12.0138889 0.435802
+ 12.0166667 0.427572
+ 12.0194444 0.429630
+ 12.0222222 0.427572
+ 12.0250000 0.431687
+ 12.0277778 0.444033
+ 12.0305556 0.450206
+ 12.0333333 0.460494
+ 12.0361111 0.466667
+ 12.0388889 0.462551
+ 12.0416667 0.468724
+ 12.0444444 0.470782
+ 12.0472222 0.470782
+ 12.0500000 0.470782
+ 12.0527778 0.472840
+ 12.0555556 0.466667
+ 12.0583333 0.466667
+ 12.0611111 0.462551
+ 12.0638889 0.454321
+ 12.0666667 0.448148
+ 12.0694444 0.444033
+ 12.0722222 0.450206
+ 12.0750000 0.452263
+ 12.0777778 0.460494
+ 12.0805556 0.466667
+ 12.0833333 0.468724
+ 12.0861111 0.466667
+ 12.0888889 0.470782
+ 12.0916667 0.472840
+ 12.0944444 0.474897
+ 12.0972222 0.474897
+ 12.1000000 0.468724
+ 12.1027778 0.466667
+ 12.1055556 0.466667
+ 12.1083333 0.466667
+ 12.1111111 0.466667
+ 12.1138889 0.464609
+ 12.1166667 0.460494
+ 12.1194444 0.460494
+ 12.1222222 0.452263
+ 12.1250000 0.450206
+ 12.1277778 0.452263
+ 12.1305556 0.456379
+ 12.1333333 0.454321
+ 12.1361111 0.464609
+ 12.1388889 0.464609
+ 12.1416667 0.462551
+ 12.1444444 0.462551
+ 12.1472222 0.456379
+ 12.1500000 0.452263
+ 12.1527778 0.452263
+ 12.1555556 0.450206
+ 12.1583333 0.446091
+ 12.1611111 0.456379
+ 12.1638889 0.458436
+ 12.1666667 0.460494
+ 12.1694444 0.462551
+ 12.1722222 0.468724
+ 12.1750000 0.466667
+ 12.1777778 0.466667
+ 12.1805556 0.472840
+ 12.1833333 0.464609
+ 12.1861111 0.460494
+ 12.1888889 0.454321
+ 12.1916667 0.452263
+ 12.1944444 0.452263
+ 12.1972222 0.452263
+ 12.2000000 0.460494
+ 12.2027778 0.470782
+ 12.2055556 0.474897
+ 12.2083333 0.470782
+ 12.2111111 0.468724
+ 12.2138889 0.458436
+ 12.2166667 0.456379
+ 12.2194444 0.458436
+ 12.2222222 0.458436
+ 12.2250000 0.462551
+ 12.2277778 0.462551
+ 12.2305556 0.462551
+ 12.2333333 0.464609
+ 12.2361111 0.464609
+ 12.2388889 0.474897
+ 12.2416667 0.470782
+ 12.2444444 0.468724
+ 12.2472222 0.464609
+ 12.2500000 0.452263
+ 12.2527778 0.444033
+ 12.2555556 0.439918
+ 12.2583333 0.441975
+ 12.2611111 0.450206
+ 12.2638889 0.460494
+ 12.2666667 0.468724
+ 12.2694444 0.476955
+ 12.2722222 0.481070
+ 12.2750000 0.483128
+ 12.2777778 0.487243
+ 12.2805556 0.481070
+ 12.2833333 0.479012
+ 12.2861111 0.472840
+ 12.2888889 0.466667
+ 12.2916667 0.460494
+ 12.2944444 0.460494
+ 12.2972222 0.460494
+ 12.3000000 0.462551
+ 12.3027778 0.470782
+ 12.3055556 0.479012
+ 12.3083333 0.489300
+ 12.3111111 0.491358
+ 12.3138889 0.495473
+ 12.3166667 0.497531
+ 12.3194444 0.499588
+ 12.3222222 0.495473
+ 12.3250000 0.499588
+ 12.3277778 0.495473
+ 12.3305556 0.491358
+ 12.3333333 0.485185
+ 12.3361111 0.485185
+ 12.3388889 0.491358
+ 12.3416667 0.497531
+ 12.3444444 0.499588
+ 12.3472222 0.505761
+ 12.3500000 0.509877
+ 12.3527778 0.513992
+ 12.3555556 0.505761
+ 12.3583333 0.491358
+ 12.3611111 0.479012
+ 12.3638889 0.466667
+ 12.3666667 0.460494
+ 12.3694444 0.454321
+ 12.3722222 0.460494
+ 12.3750000 0.466667
+ 12.3777778 0.481070
+ 12.3805556 0.489300
+ 12.3833333 0.495473
+ 12.3861111 0.493416
+ 12.3888889 0.487243
+ 12.3916667 0.481070
+ 12.3944444 0.476955
+ 12.3972222 0.462551
+ 12.4000000 0.460494
+ 12.4027778 0.458436
+ 12.4055556 0.462551
+ 12.4083333 0.466667
+ 12.4111111 0.460494
+ 12.4138889 0.470782
+ 12.4166667 0.472840
+ 12.4194444 0.474897
+ 12.4222222 0.479012
+ 12.4250000 0.470782
+ 12.4277778 0.460494
+ 12.4305556 0.450206
+ 12.4333333 0.446091
+ 12.4361111 0.448148
+ 12.4388889 0.454321
+ 12.4416667 0.458436
+ 12.4444444 0.460494
+ 12.4472222 0.464609
+ 12.4500000 0.460494
+ 12.4527778 0.460494
+ 12.4555556 0.454321
+ 12.4583333 0.450206
+ 12.4611111 0.446091
+ 12.4638889 0.456379
+ 12.4666667 0.464609
+ 12.4694444 0.462551
+ 12.4722222 0.464609
+ 12.4750000 0.460494
+ 12.4777778 0.456379
+ 12.4805556 0.448148
+ 12.4833333 0.446091
+ 12.4861111 0.441975
+ 12.4888889 0.446091
+ 12.4916667 0.454321
+ 12.4944444 0.466667
+ 12.4972222 0.476955
+ 12.5000000 0.483128
+ 12.5027778 0.493416
+ 12.5055556 0.497531
+ 12.5083333 0.501646
+ 12.5111111 0.505761
+ 12.5138889 0.511934
+ 12.5166667 0.520165
+ 12.5194444 0.524280
+ 12.5222222 0.540741
+ 12.5250000 0.575720
+ 12.5277778 0.618930
+ 12.5305556 0.662140
+ 12.5333333 0.690947
+ 12.5361111 0.693004
+ 12.5388889 0.651852
+ 12.5416667 0.569547
+ 12.5444444 0.476955
+ 12.5472222 0.394650
+ 12.5500000 0.347325
+ 12.5527778 0.324691
+ 12.5555556 0.324691
+ 12.5583333 0.343210
+ 12.5611111 0.355556
+ 12.5638889 0.361728
+ 12.5666667 0.372016
+ 12.5694444 0.374074
+ 12.5722222 0.376132
+ 12.5750000 0.374074
+ 12.5777778 0.374074
+ 12.5805556 0.365844
+ 12.5833333 0.359671
+ 12.5861111 0.363786
+ 12.5888889 0.372016
+ 12.5916667 0.388477
+ 12.5944444 0.392593
+ 12.5972222 0.398765
+ 12.6000000 0.402881
+ 12.6027778 0.400823
+ 12.6055556 0.398765
+ 12.6083333 0.390535
+ 12.6111111 0.386420
+ 12.6138889 0.380247
+ 12.6166667 0.372016
+ 12.6194444 0.369959
+ 12.6222222 0.372016
+ 12.6250000 0.382305
+ 12.6277778 0.396708
+ 12.6305556 0.411111
+ 12.6333333 0.433745
+ 12.6361111 0.446091
+ 12.6388889 0.458436
+ 12.6416667 0.458436
+ 12.6444444 0.462551
+ 12.6472222 0.460494
+ 12.6500000 0.452263
+ 12.6527778 0.450206
+ 12.6555556 0.452263
+ 12.6583333 0.452263
+ 12.6611111 0.456379
+ 12.6638889 0.462551
+ 12.6666667 0.470782
+ 12.6694444 0.479012
+ 12.6722222 0.479012
+ 12.6750000 0.479012
+ 12.6777778 0.472840
+ 12.6805556 0.466667
+ 12.6833333 0.460494
+ 12.6861111 0.456379
+ 12.6888889 0.452263
+ 12.6916667 0.454321
+ 12.6944444 0.456379
+ 12.6972222 0.456379
+ 12.7000000 0.462551
+ 12.7027778 0.470782
+ 12.7055556 0.483128
+ 12.7083333 0.487243
+ 12.7111111 0.487243
+ 12.7138889 0.476955
+ 12.7166667 0.464609
+ 12.7194444 0.456379
+ 12.7222222 0.450206
+ 12.7250000 0.454321
+ 12.7277778 0.468724
+ 12.7305556 0.487243
+ 12.7333333 0.497531
+ 12.7361111 0.499588
+ 12.7388889 0.491358
+ 12.7416667 0.472840
+ 12.7444444 0.460494
+ 12.7472222 0.456379
+ 12.7500000 0.462551
+ 12.7527778 0.472840
+ 12.7555556 0.485185
+ 12.7583333 0.493416
+ 12.7611111 0.499588
+ 12.7638889 0.489300
+ 12.7666667 0.491358
+ 12.7694444 0.489300
+ 12.7722222 0.493416
+ 12.7750000 0.491358
+ 12.7777778 0.491358
+ 12.7805556 0.497531
+ 12.7833333 0.503704
+ 12.7861111 0.507819
+ 12.7888889 0.507819
+ 12.7916667 0.520165
+ 12.7944444 0.526337
+ 12.7972222 0.520165
+ 12.8000000 0.526337
+ 12.8027778 0.524280
+ 12.8055556 0.534568
+ 12.8083333 0.538683
+ 12.8111111 0.538683
+ 12.8138889 0.542798
+ 12.8166667 0.542798
+ 12.8194444 0.536626
+ 12.8222222 0.530453
+ 12.8250000 0.528395
+ 12.8277778 0.526337
+ 12.8305556 0.532510
+ 12.8333333 0.532510
+ 12.8361111 0.540741
+ 12.8388889 0.551029
+ 12.8416667 0.559259
+ 12.8444444 0.561317
+ 12.8472222 0.557202
+ 12.8500000 0.551029
+ 12.8527778 0.548971
+ 12.8555556 0.542798
+ 12.8583333 0.544856
+ 12.8611111 0.542798
+ 12.8638889 0.544856
+ 12.8666667 0.542798
+ 12.8694444 0.544856
+ 12.8722222 0.546914
+ 12.8750000 0.546914
+ 12.8777778 0.544856
+ 12.8805556 0.548971
+ 12.8833333 0.544856
+ 12.8861111 0.546914
+ 12.8888889 0.544856
+ 12.8916667 0.544856
+ 12.8944444 0.540741
+ 12.8972222 0.534568
+ 12.9000000 0.528395
+ 12.9027778 0.522222
+ 12.9055556 0.518107
+ 12.9083333 0.509877
+ 12.9111111 0.501646
+ 12.9138889 0.497531
+ 12.9166667 0.503704
+ 12.9194444 0.499588
+ 12.9222222 0.499588
+ 12.9250000 0.495473
+ 12.9277778 0.499588
+ 12.9305556 0.493416
+ 12.9333333 0.491358
+ 12.9361111 0.476955
+ 12.9388889 0.470782
+ 12.9416667 0.458436
+ 12.9444444 0.456379
+ 12.9472222 0.460494
+ 12.9500000 0.460494
+ 12.9527778 0.462551
+ 12.9555556 0.460494
+ 12.9583333 0.458436
+ 12.9611111 0.454321
+ 12.9638889 0.454321
+ 12.9666667 0.452263
+ 12.9694444 0.454321
+ 12.9722222 0.456379
+ 12.9750000 0.454321
+ 12.9777778 0.462551
+ 12.9805556 0.464609
+ 12.9833333 0.464609
+ 12.9861111 0.462551
+ 12.9888889 0.466667
+ 12.9916667 0.470782
+ 12.9944444 0.483128
+ 12.9972222 0.493416
+ 13.0000000 0.501646
+ 13.0027778 0.503704
+ 13.0055556 0.499588
+ 13.0083333 0.495473
+ 13.0111111 0.487243
+ 13.0138889 0.483128
+ 13.0166667 0.479012
+ 13.0194444 0.472840
+ 13.0222222 0.468724
+ 13.0250000 0.468724
+ 13.0277778 0.470782
+ 13.0305556 0.479012
+ 13.0333333 0.479012
+ 13.0361111 0.487243
+ 13.0388889 0.491358
+ 13.0416667 0.493416
+ 13.0444444 0.491358
+ 13.0472222 0.491358
+ 13.0500000 0.495473
+ 13.0527778 0.499588
+ 13.0555556 0.497531
+ 13.0583333 0.497531
+ 13.0611111 0.491358
+ 13.0638889 0.479012
+ 13.0666667 0.466667
+ 13.0694444 0.464609
+ 13.0722222 0.466667
+ 13.0750000 0.472840
+ 13.0777778 0.485185
+ 13.0805556 0.497531
+ 13.0833333 0.507819
+ 13.0861111 0.501646
+ 13.0888889 0.497531
+ 13.0916667 0.481070
+ 13.0944444 0.470782
+ 13.0972222 0.466667
+ 13.1000000 0.460494
+ 13.1027778 0.468724
+ 13.1055556 0.481070
+ 13.1083333 0.487243
+ 13.1111111 0.497531
+ 13.1138889 0.501646
+ 13.1166667 0.493416
+ 13.1194444 0.485185
+ 13.1222222 0.472840
+ 13.1250000 0.460494
+ 13.1277778 0.464609
+ 13.1305556 0.468724
+ 13.1333333 0.474897
+ 13.1361111 0.479012
+ 13.1388889 0.485185
+ 13.1416667 0.487243
+ 13.1444444 0.493416
+ 13.1472222 0.491358
+ 13.1500000 0.493416
+ 13.1527778 0.493416
+ 13.1555556 0.493416
+ 13.1583333 0.491358
+ 13.1611111 0.479012
+ 13.1638889 0.470782
+ 13.1666667 0.464609
+ 13.1694444 0.470782
+ 13.1722222 0.470782
+ 13.1750000 0.474897
+ 13.1777778 0.479012
+ 13.1805556 0.476955
+ 13.1833333 0.487243
+ 13.1861111 0.511934
+ 13.1888889 0.542798
+ 13.1916667 0.590123
+ 13.1944444 0.643621
+ 13.1972222 0.676543
+ 13.2000000 0.697119
+ 13.2027778 0.674486
+ 13.2055556 0.620988
+ 13.2083333 0.540741
+ 13.2111111 0.456379
+ 13.2138889 0.380247
+ 13.2166667 0.345267
+ 13.2194444 0.341152
+ 13.2222222 0.349383
+ 13.2250000 0.367901
+ 13.2277778 0.394650
+ 13.2305556 0.406996
+ 13.2333333 0.409053
+ 13.2361111 0.415226
+ 13.2388889 0.413169
+ 13.2416667 0.404938
+ 13.2444444 0.404938
+ 13.2472222 0.409053
+ 13.2500000 0.415226
+ 13.2527778 0.419342
+ 13.2555556 0.423457
+ 13.2583333 0.417284
+ 13.2611111 0.406996
+ 13.2638889 0.394650
+ 13.2666667 0.384362
+ 13.2694444 0.380247
+ 13.2722222 0.378189
+ 13.2750000 0.382305
+ 13.2777778 0.386420
+ 13.2805556 0.388477
+ 13.2833333 0.392593
+ 13.2861111 0.400823
+ 13.2888889 0.411111
+ 13.2916667 0.423457
+ 13.2944444 0.435802
+ 13.2972222 0.462551
+ 13.3000000 0.485185
+ 13.3027778 0.509877
+ 13.3055556 0.513992
+ 13.3083333 0.503704
+ 13.3111111 0.487243
+ 13.3138889 0.468724
+ 13.3166667 0.444033
+ 13.3194444 0.433745
+ 13.3222222 0.437860
+ 13.3250000 0.441975
+ 13.3277778 0.452263
+ 13.3305556 0.466667
+ 13.3333333 0.470782
+ 13.3361111 0.481070
+ 13.3388889 0.483128
+ 13.3416667 0.479012
+ 13.3444444 0.483128
+ 13.3472222 0.485185
+ 13.3500000 0.489300
+ 13.3527778 0.487243
+ 13.3555556 0.479012
+ 13.3583333 0.466667
+ 13.3611111 0.464609
+ 13.3638889 0.462551
+ 13.3666667 0.470782
+ 13.3694444 0.481070
+ 13.3722222 0.483128
+ 13.3750000 0.487243
+ 13.3777778 0.493416
+ 13.3805556 0.487243
+ 13.3833333 0.476955
+ 13.3861111 0.468724
+ 13.3888889 0.460494
+ 13.3916667 0.458436
+ 13.3944444 0.466667
+ 13.3972222 0.474897
+ 13.4000000 0.479012
+ 13.4027778 0.493416
+ 13.4055556 0.497531
+ 13.4083333 0.507819
+ 13.4111111 0.505761
+ 13.4138889 0.505761
+ 13.4166667 0.499588
+ 13.4194444 0.491358
+ 13.4222222 0.487243
+ 13.4250000 0.483128
+ 13.4277778 0.487243
+ 13.4305556 0.497531
+ 13.4333333 0.513992
+ 13.4361111 0.524280
+ 13.4388889 0.526337
+ 13.4416667 0.524280
+ 13.4444444 0.522222
+ 13.4472222 0.516049
+ 13.4500000 0.520165
+ 13.4527778 0.530453
+ 13.4555556 0.534568
+ 13.4583333 0.544856
+ 13.4611111 0.546914
+ 13.4638889 0.551029
+ 13.4666667 0.542798
+ 13.4694444 0.538683
+ 13.4722222 0.536626
+ 13.4750000 0.538683
+ 13.4777778 0.542798
+ 13.4805556 0.544856
+ 13.4833333 0.551029
+ 13.4861111 0.555144
+ 13.4888889 0.553086
+ 13.4916667 0.546914
+ 13.4944444 0.538683
+ 13.4972222 0.534568
+ 13.5000000 0.538683
+ 13.5027778 0.544856
+ 13.5055556 0.553086
+ 13.5083333 0.557202
+ 13.5111111 0.553086
+ 13.5138889 0.548971
+ 13.5166667 0.544856
+ 13.5194444 0.538683
+ 13.5222222 0.530453
+ 13.5250000 0.534568
+ 13.5277778 0.534568
+ 13.5305556 0.530453
+ 13.5333333 0.524280
+ 13.5361111 0.516049
+ 13.5388889 0.505761
+ 13.5416667 0.495473
+ 13.5444444 0.487243
+ 13.5472222 0.485185
+ 13.5500000 0.487243
+ 13.5527778 0.495473
+ 13.5555556 0.501646
+ 13.5583333 0.501646
+ 13.5611111 0.489300
+ 13.5638889 0.474897
+ 13.5666667 0.476955
+ 13.5694444 0.472840
+ 13.5722222 0.468724
+ 13.5750000 0.462551
+ 13.5777778 0.456379
+ 13.5805556 0.448148
+ 13.5833333 0.450206
+ 13.5861111 0.452263
+ 13.5888889 0.458436
+ 13.5916667 0.464609
+ 13.5944444 0.466667
+ 13.5972222 0.462551
+ 13.6000000 0.452263
+ 13.6027778 0.452263
+ 13.6055556 0.456379
+ 13.6083333 0.462551
+ 13.6111111 0.464609
+ 13.6138889 0.470782
+ 13.6166667 0.466667
+ 13.6194444 0.470782
+ 13.6222222 0.470782
+ 13.6250000 0.474897
+ 13.6277778 0.476955
+ 13.6305556 0.470782
+ 13.6333333 0.468724
+ 13.6361111 0.470782
+ 13.6388889 0.464609
+ 13.6416667 0.468724
+ 13.6444444 0.470782
+ 13.6472222 0.468724
+ 13.6500000 0.468724
+ 13.6527778 0.466667
+ 13.6555556 0.462551
+ 13.6583333 0.464609
+ 13.6611111 0.466667
+ 13.6638889 0.470782
+ 13.6666667 0.476955
+ 13.6694444 0.476955
+ 13.6722222 0.472840
+ 13.6750000 0.468724
+ 13.6777778 0.470782
+ 13.6805556 0.464609
+ 13.6833333 0.466667
+ 13.6861111 0.466667
+ 13.6888889 0.468724
+ 13.6916667 0.468724
+ 13.6944444 0.470782
+ 13.6972222 0.474897
+ 13.7000000 0.474897
+ 13.7027778 0.481070
+ 13.7055556 0.487243
+ 13.7083333 0.489300
+ 13.7111111 0.487243
+ 13.7138889 0.476955
+ 13.7166667 0.464609
+ 13.7194444 0.458436
+ 13.7222222 0.456379
+ 13.7250000 0.460494
+ 13.7277778 0.470782
+ 13.7305556 0.474897
+ 13.7333333 0.479012
+ 13.7361111 0.472840
+ 13.7388889 0.468724
+ 13.7416667 0.464609
+ 13.7444444 0.462551
+ 13.7472222 0.452263
+ 13.7500000 0.456379
+ 13.7527778 0.458436
+ 13.7555556 0.460494
+ 13.7583333 0.466667
+ 13.7611111 0.470782
+ 13.7638889 0.472840
+ 13.7666667 0.468724
+ 13.7694444 0.462551
+ 13.7722222 0.470782
+ 13.7750000 0.468724
+ 13.7777778 0.470782
+ 13.7805556 0.481070
+ 13.7833333 0.472840
+ 13.7861111 0.470782
+ 13.7888889 0.466667
+ 13.7916667 0.466667
+ 13.7944444 0.468724
+ 13.7972222 0.470782
+ 13.8000000 0.462551
+ 13.8027778 0.460494
+ 13.8055556 0.462551
+ 13.8083333 0.456379
+ 13.8111111 0.462551
+ 13.8138889 0.460494
+ 13.8166667 0.464609
+ 13.8194444 0.460494
+ 13.8222222 0.460494
+ 13.8250000 0.456379
+ 13.8277778 0.452263
+ 13.8305556 0.456379
+ 13.8333333 0.460494
+ 13.8361111 0.468724
+ 13.8388889 0.476955
+ 13.8416667 0.476955
+ 13.8444444 0.472840
+ 13.8472222 0.466667
+ 13.8500000 0.460494
+ 13.8527778 0.458436
+ 13.8555556 0.458436
+ 13.8583333 0.464609
+ 13.8611111 0.462551
+ 13.8638889 0.466667
+ 13.8666667 0.468724
+ 13.8694444 0.470782
+ 13.8722222 0.474897
+ 13.8750000 0.474897
+ 13.8777778 0.474897
+ 13.8805556 0.474897
+ 13.8833333 0.468724
+ 13.8861111 0.466667
+ 13.8888889 0.464609
+ 13.8916667 0.460494
+ 13.8944444 0.464609
+ 13.8972222 0.468724
+ 13.9000000 0.470782
+ 13.9027778 0.470782
+ 13.9055556 0.466667
+ 13.9083333 0.472840
+ 13.9111111 0.472840
+ 13.9138889 0.470782
+ 13.9166667 0.464609
+ 13.9194444 0.462551
+ 13.9222222 0.460494
+ 13.9250000 0.462551
+ 13.9277778 0.464609
+ 13.9305556 0.460494
+ 13.9333333 0.464609
+ 13.9361111 0.462551
+ 13.9388889 0.470782
+ 13.9416667 0.470782
+ 13.9444444 0.470782
+ 13.9472222 0.468724
+ 13.9500000 0.456379
+ 13.9527778 0.446091
+ 13.9555556 0.437860
+ 13.9583333 0.439918
+ 13.9611111 0.450206
+ 13.9638889 0.458436
+ 13.9666667 0.466667
+ 13.9694444 0.474897
+ 13.9722222 0.485185
+ 13.9750000 0.481070
+ 13.9777778 0.483128
+ 13.9805556 0.479012
+ 13.9833333 0.472840
+ 13.9861111 0.466667
+ 13.9888889 0.464609
+ 13.9916667 0.450206
+ 13.9944444 0.437860
+ 13.9972222 0.435802
+ 14.0000000 0.437860
+ 14.0027778 0.446091
+ 14.0055556 0.460494
+ 14.0083333 0.470782
+ 14.0111111 0.481070
+ 14.0138889 0.485185
+ 14.0166667 0.476955
+ 14.0194444 0.462551
+ 14.0222222 0.444033
+ 14.0250000 0.441975
+ 14.0277778 0.448148
+ 14.0305556 0.454321
+ 14.0333333 0.462551
+ 14.0361111 0.472840
+ 14.0388889 0.481070
+ 14.0416667 0.479012
+ 14.0444444 0.470782
+ 14.0472222 0.466667
+ 14.0500000 0.460494
+ 14.0527778 0.452263
+ 14.0555556 0.456379
+ 14.0583333 0.456379
+ 14.0611111 0.456379
+ 14.0638889 0.464609
+ 14.0666667 0.466667
+ 14.0694444 0.464609
+ 14.0722222 0.468724
+ 14.0750000 0.470782
+ 14.0777778 0.481070
+ 14.0805556 0.485185
+ 14.0833333 0.489300
+ 14.0861111 0.487243
+ 14.0888889 0.476955
+ 14.0916667 0.470782
+ 14.0944444 0.452263
+ 14.0972222 0.448148
+ 14.1000000 0.439918
+ 14.1027778 0.441975
+ 14.1055556 0.454321
+ 14.1083333 0.460494
+ 14.1111111 0.474897
+ 14.1138889 0.476955
+ 14.1166667 0.474897
+ 14.1194444 0.466667
+ 14.1222222 0.458436
+ 14.1250000 0.460494
+ 14.1277778 0.466667
+ 14.1305556 0.470782
+ 14.1333333 0.468724
+ 14.1361111 0.464609
+ 14.1388889 0.462551
+ 14.1416667 0.452263
+ 14.1444444 0.456379
+ 14.1472222 0.462551
+ 14.1500000 0.458436
+ 14.1527778 0.460494
+ 14.1555556 0.458436
+ 14.1583333 0.466667
+ 14.1611111 0.470782
+ 14.1638889 0.476955
+ 14.1666667 0.481070
+ 14.1694444 0.481070
+ 14.1722222 0.476955
+ 14.1750000 0.470782
+ 14.1777778 0.464609
+ 14.1805556 0.462551
+ 14.1833333 0.460494
+ 14.1861111 0.458436
+ 14.1888889 0.460494
+ 14.1916667 0.464609
+ 14.1944444 0.462551
+ 14.1972222 0.458436
+ 14.2000000 0.460494
+ 14.2027778 0.456379
+ 14.2055556 0.460494
+ 14.2083333 0.462551
+ 14.2111111 0.460494
+ 14.2138889 0.464609
+ 14.2166667 0.466667
+ 14.2194444 0.468724
+ 14.2222222 0.474897
+ 14.2250000 0.479012
+ 14.2277778 0.479012
+ 14.2305556 0.476955
+ 14.2333333 0.466667
+ 14.2361111 0.456379
+ 14.2388889 0.452263
+ 14.2416667 0.452263
+ 14.2444444 0.462551
+ 14.2472222 0.472840
+ 14.2500000 0.476955
+ 14.2527778 0.474897
+ 14.2555556 0.468724
+ 14.2583333 0.462551
+ 14.2611111 0.460494
+ 14.2638889 0.462551
+ 14.2666667 0.474897
+ 14.2694444 0.479012
+ 14.2722222 0.485185
+ 14.2750000 0.481070
+ 14.2777778 0.481070
+ 14.2805556 0.483128
+ 14.2833333 0.476955
+ 14.2861111 0.470782
+ 14.2888889 0.462551
+ 14.2916667 0.452263
+ 14.2944444 0.452263
+ 14.2972222 0.458436
+ 14.3000000 0.468724
+ 14.3027778 0.479012
+ 14.3055556 0.481070
+ 14.3083333 0.476955
+ 14.3111111 0.470782
+ 14.3138889 0.470782
+ 14.3166667 0.462551
+ 14.3194444 0.462551
+ 14.3222222 0.460494
+ 14.3250000 0.466667
+ 14.3277778 0.470782
+ 14.3305556 0.468724
+ 14.3333333 0.472840
+ 14.3361111 0.470782
+ 14.3388889 0.470782
+ 14.3416667 0.468724
+ 14.3444444 0.470782
+ 14.3472222 0.472840
+ 14.3500000 0.464609
+ 14.3527778 0.462551
+ 14.3555556 0.468724
+ 14.3583333 0.470782
+ 14.3611111 0.479012
+ 14.3638889 0.479012
+ 14.3666667 0.481070
+ 14.3694444 0.474897
+ 14.3722222 0.474897
+ 14.3750000 0.468724
+ 14.3777778 0.470782
+ 14.3805556 0.474897
+ 14.3833333 0.464609
+ 14.3861111 0.462551
+ 14.3888889 0.458436
+ 14.3916667 0.439918
+ 14.3944444 0.450206
+ 14.3972222 0.460494
+ 14.4000000 0.470782
+ 14.4027778 0.487243
+ 14.4055556 0.495473
+ 14.4083333 0.497531
+ 14.4111111 0.476955
+ 14.4138889 0.464609
+ 14.4166667 0.446091
+ 14.4194444 0.437860
+ 14.4222222 0.439918
+ 14.4250000 0.448148
+ 14.4277778 0.456379
+ 14.4305556 0.468724
+ 14.4333333 0.474897
+ 14.4361111 0.481070
+ 14.4388889 0.491358
+ 14.4416667 0.497531
+ 14.4444444 0.493416
+ 14.4472222 0.485185
+ 14.4500000 0.472840
+ 14.4527778 0.462551
+ 14.4555556 0.458436
+ 14.4583333 0.458436
+ 14.4611111 0.450206
+ 14.4638889 0.448148
+ 14.4666667 0.444033
+ 14.4694444 0.448148
+ 14.4722222 0.458436
+ 14.4750000 0.468724
+ 14.4777778 0.472840
+ 14.4805556 0.481070
+ 14.4833333 0.483128
+ 14.4861111 0.483128
+ 14.4888889 0.479012
+ 14.4916667 0.479012
+ 14.4944444 0.483128
+ 14.4972222 0.485185
+ 14.5000000 0.474897
+ 14.5027778 0.460494
+ 14.5055556 0.454321
+ 14.5083333 0.439918
+ 14.5111111 0.441975
+ 14.5138889 0.448148
+ 14.5166667 0.454321
+ 14.5194444 0.462551
+ 14.5222222 0.468724
+ 14.5250000 0.466667
+ 14.5277778 0.468724
+ 14.5305556 0.470782
+ 14.5333333 0.472840
+ 14.5361111 0.483128
+ 14.5388889 0.491358
+ 14.5416667 0.493416
+ 14.5444444 0.493416
+ 14.5472222 0.479012
+ 14.5500000 0.460494
+ 14.5527778 0.448148
+ 14.5555556 0.448148
+ 14.5583333 0.450206
+ 14.5611111 0.454321
+ 14.5638889 0.456379
+ 14.5666667 0.456379
+ 14.5694444 0.468724
+ 14.5722222 0.474897
+ 14.5750000 0.481070
+ 14.5777778 0.489300
+ 14.5805556 0.491358
+ 14.5833333 0.485185
+ 14.5861111 0.472840
+ 14.5888889 0.460494
+ 14.5916667 0.454321
+ 14.5944444 0.460494
+ 14.5972222 0.458436
+ 14.6000000 0.464609
+ 14.6027778 0.470782
+ 14.6055556 0.481070
+ 14.6083333 0.483128
+ 14.6111111 0.479012
+ 14.6138889 0.481070
+ 14.6166667 0.485185
+ 14.6194444 0.485185
+ 14.6222222 0.491358
+ 14.6250000 0.493416
+ 14.6277778 0.499588
+ 14.6305556 0.503704
+ 14.6333333 0.503704
+ 14.6361111 0.507819
+ 14.6388889 0.507819
+ 14.6416667 0.503704
+ 14.6444444 0.499588
+ 14.6472222 0.493416
+ 14.6500000 0.499588
+ 14.6527778 0.497531
+ 14.6555556 0.501646
+ 14.6583333 0.499588
+ 14.6611111 0.493416
+ 14.6638889 0.489300
+ 14.6666667 0.489300
+ 14.6694444 0.491358
+ 14.6722222 0.499588
+ 14.6750000 0.503704
+ 14.6777778 0.501646
+ 14.6805556 0.493416
+ 14.6833333 0.479012
+ 14.6861111 0.472840
+ 14.6888889 0.470782
+ 14.6916667 0.476955
+ 14.6944444 0.472840
+ 14.6972222 0.474897
+ 14.7000000 0.470782
+ 14.7027778 0.470782
+ 14.7055556 0.472840
+ 14.7083333 0.468724
+ 14.7111111 0.470782
+ 14.7138889 0.470782
+ 14.7166667 0.468724
+ 14.7194444 0.466667
+ 14.7222222 0.464609
+ 14.7250000 0.464609
+ 14.7277778 0.456379
+ 14.7305556 0.464609
+ 14.7333333 0.470782
+ 14.7361111 0.474897
+ 14.7388889 0.479012
+ 14.7416667 0.483128
+ 14.7444444 0.483128
+ 14.7472222 0.479012
+ 14.7500000 0.479012
+ 14.7527778 0.470782
+ 14.7555556 0.466667
+ 14.7583333 0.458436
+ 14.7611111 0.452263
+ 14.7638889 0.458436
+ 14.7666667 0.456379
+ 14.7694444 0.460494
+ 14.7722222 0.468724
+ 14.7750000 0.474897
+ 14.7777778 0.476955
+ 14.7805556 0.476955
+ 14.7833333 0.466667
+ 14.7861111 0.460494
+ 14.7888889 0.458436
+ 14.7916667 0.450206
+ 14.7944444 0.456379
+ 14.7972222 0.456379
+ 14.8000000 0.464609
+ 14.8027778 0.485185
+ 14.8055556 0.493416
+ 14.8083333 0.501646
+ 14.8111111 0.509877
+ 14.8138889 0.520165
+ 14.8166667 0.526337
+ 14.8194444 0.524280
+ 14.8222222 0.518107
+ 14.8250000 0.518107
+ 14.8277778 0.530453
+ 14.8305556 0.544856
+ 14.8333333 0.571605
+ 14.8361111 0.602469
+ 14.8388889 0.639506
+ 14.8416667 0.660082
+ 14.8444444 0.645679
+ 14.8472222 0.600412
+ 14.8500000 0.522222
+ 14.8527778 0.444033
+ 14.8555556 0.384362
+ 14.8583333 0.353498
+ 14.8611111 0.349383
+ 14.8638889 0.351440
+ 14.8666667 0.367901
+ 14.8694444 0.376132
+ 14.8722222 0.382305
+ 14.8750000 0.386420
+ 14.8777778 0.384362
+ 14.8805556 0.378189
+ 14.8833333 0.376132
+ 14.8861111 0.369959
+ 14.8888889 0.365844
+ 14.8916667 0.376132
+ 14.8944444 0.386420
+ 14.8972222 0.402881
+ 14.9000000 0.413169
+ 14.9027778 0.415226
+ 14.9055556 0.406996
+ 14.9083333 0.396708
+ 14.9111111 0.382305
+ 14.9138889 0.380247
+ 14.9166667 0.380247
+ 14.9194444 0.384362
+ 14.9222222 0.390535
+ 14.9250000 0.402881
+ 14.9277778 0.409053
+ 14.9305556 0.419342
+ 14.9333333 0.431687
+ 14.9361111 0.437860
+ 14.9388889 0.446091
+ 14.9416667 0.450206
+ 14.9444444 0.458436
+ 14.9472222 0.468724
+ 14.9500000 0.472840
+ 14.9527778 0.476955
+ 14.9555556 0.476955
+ 14.9583333 0.470782
+ 14.9611111 0.468724
+ 14.9638889 0.474897
+ 14.9666667 0.483128
+ 14.9694444 0.487243
+ 14.9722222 0.479012
+ 14.9750000 0.464609
+ 14.9777778 0.464609
+ 14.9805556 0.466667
+ 14.9833333 0.470782
+ 14.9861111 0.468724
+ 14.9888889 0.472840
+ 14.9916667 0.472840
+ 14.9944444 0.472840
+ 14.9972222 0.483128
+ 15.0000000 0.481070
+ 15.0027778 0.489300
+ 15.0055556 0.489300
+ 15.0083333 0.489300
+ 15.0111111 0.487243
+ 15.0138889 0.476955
+ 15.0166667 0.472840
+ 15.0194444 0.468724
+ 15.0222222 0.460494
+ 15.0250000 0.466667
+ 15.0277778 0.472840
+ 15.0305556 0.487243
+ 15.0333333 0.497531
+ 15.0361111 0.499588
+ 15.0388889 0.493416
+ 15.0416667 0.489300
+ 15.0444444 0.483128
+ 15.0472222 0.489300
+ 15.0500000 0.493416
+ 15.0527778 0.499588
+ 15.0555556 0.497531
+ 15.0583333 0.493416
+ 15.0611111 0.487243
+ 15.0638889 0.483128
+ 15.0666667 0.483128
+ 15.0694444 0.497531
+ 15.0722222 0.505761
+ 15.0750000 0.516049
+ 15.0777778 0.516049
+ 15.0805556 0.511934
+ 15.0833333 0.507819
+ 15.0861111 0.507819
+ 15.0888889 0.511934
+ 15.0916667 0.513992
+ 15.0944444 0.522222
+ 15.0972222 0.522222
+ 15.1000000 0.522222
+ 15.1027778 0.524280
+ 15.1055556 0.526337
+ 15.1083333 0.528395
+ 15.1111111 0.528395
+ 15.1138889 0.536626
+ 15.1166667 0.534568
+ 15.1194444 0.534568
+ 15.1222222 0.534568
+ 15.1250000 0.536626
+ 15.1277778 0.536626
+ 15.1305556 0.540741
+ 15.1333333 0.544856
+ 15.1361111 0.546914
+ 15.1388889 0.548971
+ 15.1416667 0.546914
+ 15.1444444 0.546914
+ 15.1472222 0.542798
+ 15.1500000 0.544856
+ 15.1527778 0.555144
+ 15.1555556 0.553086
+ 15.1583333 0.551029
+ 15.1611111 0.546914
+ 15.1638889 0.542798
+ 15.1666667 0.544856
+ 15.1694444 0.548971
+ 15.1722222 0.553086
+ 15.1750000 0.555144
+ 15.1777778 0.559259
+ 15.1805556 0.557202
+ 15.1833333 0.551029
+ 15.1861111 0.544856
+ 15.1888889 0.534568
+ 15.1916667 0.524280
+ 15.1944444 0.513992
+ 15.1972222 0.507819
+ 15.2000000 0.505761
+ 15.2027778 0.507819
+ 15.2055556 0.516049
+ 15.2083333 0.518107
+ 15.2111111 0.522222
+ 15.2138889 0.520165
+ 15.2166667 0.516049
+ 15.2194444 0.513992
+ 15.2222222 0.505761
+ 15.2250000 0.501646
+ 15.2277778 0.495473
+ 15.2305556 0.495473
+ 15.2333333 0.493416
+ 15.2361111 0.489300
+ 15.2388889 0.483128
+ 15.2416667 0.470782
+ 15.2444444 0.470782
+ 15.2472222 0.472840
+ 15.2500000 0.470782
+ 15.2527778 0.468724
+ 15.2555556 0.466667
+ 15.2583333 0.464609
+ 15.2611111 0.466667
+ 15.2638889 0.466667
+ 15.2666667 0.479012
+ 15.2694444 0.491358
+ 15.2722222 0.497531
+ 15.2750000 0.493416
+ 15.2777778 0.487243
+ 15.2805556 0.483128
+ 15.2833333 0.474897
+ 15.2861111 0.476955
+ 15.2888889 0.483128
+ 15.2916667 0.499588
+ 15.2944444 0.516049
+ 15.2972222 0.524280
+ 15.3000000 0.526337
+ 15.3027778 0.509877
+ 15.3055556 0.495473
+ 15.3083333 0.481070
+ 15.3111111 0.468724
+ 15.3138889 0.470782
+ 15.3166667 0.483128
+ 15.3194444 0.493416
+ 15.3222222 0.503704
+ 15.3250000 0.509877
+ 15.3277778 0.513992
+ 15.3305556 0.511934
+ 15.3333333 0.507819
+ 15.3361111 0.503704
+ 15.3388889 0.503704
+ 15.3416667 0.497531
+ 15.3444444 0.497531
+ 15.3472222 0.493416
+ 15.3500000 0.497531
+ 15.3527778 0.501646
+ 15.3555556 0.507819
+ 15.3583333 0.509877
+ 15.3611111 0.509877
+ 15.3638889 0.516049
+ 15.3666667 0.516049
+ 15.3694444 0.513992
+ 15.3722222 0.520165
+ 15.3750000 0.520165
+ 15.3777778 0.513992
+ 15.3805556 0.511934
+ 15.3833333 0.511934
+ 15.3861111 0.503704
+ 15.3888889 0.507819
+ 15.3916667 0.513992
+ 15.3944444 0.516049
+ 15.3972222 0.516049
+ 15.4000000 0.516049
+ 15.4027778 0.516049
+ 15.4055556 0.516049
+ 15.4083333 0.522222
+ 15.4111111 0.534568
+ 15.4138889 0.538683
+ 15.4166667 0.532510
+ 15.4194444 0.524280
+ 15.4222222 0.516049
+ 15.4250000 0.503704
+ 15.4277778 0.495473
+ 15.4305556 0.503704
+ 15.4333333 0.513992
+ 15.4361111 0.526337
+ 15.4388889 0.530453
+ 15.4416667 0.526337
+ 15.4444444 0.520165
+ 15.4472222 0.518107
+ 15.4500000 0.516049
+ 15.4527778 0.511934
+ 15.4555556 0.503704
+ 15.4583333 0.497531
+ 15.4611111 0.509877
+ 15.4638889 0.516049
+ 15.4666667 0.526337
+ 15.4694444 0.524280
+ 15.4722222 0.518107
+ 15.4750000 0.511934
+ 15.4777778 0.513992
+ 15.4805556 0.524280
+ 15.4833333 0.534568
+ 15.4861111 0.540741
+ 15.4888889 0.536626
+ 15.4916667 0.530453
+ 15.4944444 0.530453
+ 15.4972222 0.528395
+ 15.5000000 0.542798
+ 15.5027778 0.571605
+ 15.5055556 0.608642
+ 15.5083333 0.643621
+ 15.5111111 0.668313
+ 15.5138889 0.699177
+ 15.5166667 0.701235
+ 15.5194444 0.676543
+ 15.5222222 0.616872
+ 15.5250000 0.538683
+ 15.5277778 0.466667
+ 15.5305556 0.411111
+ 15.5333333 0.390535
+ 15.5361111 0.398765
+ 15.5388889 0.425514
+ 15.5416667 0.450206
+ 15.5444444 0.464609
+ 15.5472222 0.468724
+ 15.5500000 0.462551
+ 15.5527778 0.448148
+ 15.5555556 0.421399
+ 15.5583333 0.404938
+ 15.5611111 0.392593
+ 15.5638889 0.404938
+ 15.5666667 0.425514
+ 15.5694444 0.456379
+ 15.5722222 0.481070
+ 15.5750000 0.485185
+ 15.5777778 0.481070
+ 15.5805556 0.466667
+ 15.5833333 0.458436
+ 15.5861111 0.435802
+ 15.5888889 0.423457
+ 15.5916667 0.411111
+ 15.5944444 0.417284
+ 15.5972222 0.425514
+ 15.6000000 0.448148
+ 15.6027778 0.464609
+ 15.6055556 0.483128
+ 15.6083333 0.495473
+ 15.6111111 0.501646
+ 15.6138889 0.503704
+ 15.6166667 0.509877
+ 15.6194444 0.516049
+ 15.6222222 0.530453
+ 15.6250000 0.534568
+ 15.6277778 0.536626
+ 15.6305556 0.538683
+ 15.6333333 0.526337
+ 15.6361111 0.513992
+ 15.6388889 0.507819
+ 15.6416667 0.499588
+ 15.6444444 0.499588
+ 15.6472222 0.505761
+ 15.6500000 0.522222
+ 15.6527778 0.534568
+ 15.6555556 0.542798
+ 15.6583333 0.536626
+ 15.6611111 0.526337
+ 15.6638889 0.516049
+ 15.6666667 0.511934
+ 15.6694444 0.507819
+ 15.6722222 0.513992
+ 15.6750000 0.518107
+ 15.6777778 0.526337
+ 15.6805556 0.536626
+ 15.6833333 0.536626
+ 15.6861111 0.538683
+ 15.6888889 0.534568
+ 15.6916667 0.528395
+ 15.6944444 0.528395
+ 15.6972222 0.526337
+ 15.7000000 0.534568
+ 15.7027778 0.536626
+ 15.7055556 0.544856
+ 15.7083333 0.546914
+ 15.7111111 0.544856
+ 15.7138889 0.546914
+ 15.7166667 0.534568
+ 15.7194444 0.536626
+ 15.7222222 0.538683
+ 15.7250000 0.534568
+ 15.7277778 0.542798
+ 15.7305556 0.540741
+ 15.7333333 0.540741
+ 15.7361111 0.538683
+ 15.7388889 0.544856
+ 15.7416667 0.551029
+ 15.7444444 0.553086
+ 15.7472222 0.561317
+ 15.7500000 0.559259
+ 15.7527778 0.561317
+ 15.7555556 0.561317
+ 15.7583333 0.559259
+ 15.7611111 0.567490
+ 15.7638889 0.575720
+ 15.7666667 0.577778
+ 15.7694444 0.581893
+ 15.7722222 0.588066
+ 15.7750000 0.590123
+ 15.7777778 0.592181
+ 15.7805556 0.590123
+ 15.7833333 0.592181
+ 15.7861111 0.590123
+ 15.7888889 0.594239
+ 15.7916667 0.606584
+ 15.7944444 0.610700
+ 15.7972222 0.612757
+ 15.8000000 0.602469
+ 15.8027778 0.600412
+ 15.8055556 0.596296
+ 15.8083333 0.606584
+ 15.8111111 0.614815
+ 15.8138889 0.612757
+ 15.8166667 0.616872
+ 15.8194444 0.616872
+ 15.8222222 0.612757
+ 15.8250000 0.610700
+ 15.8277778 0.604527
+ 15.8305556 0.600412
+ 15.8333333 0.600412
+ 15.8361111 0.602469
+ 15.8388889 0.602469
+ 15.8416667 0.598354
+ 15.8444444 0.592181
+ 15.8472222 0.590123
+ 15.8500000 0.588066
+ 15.8527778 0.588066
+ 15.8555556 0.577778
+ 15.8583333 0.573663
+ 15.8611111 0.571605
+ 15.8638889 0.563374
+ 15.8666667 0.553086
+ 15.8694444 0.548971
+ 15.8722222 0.544856
+ 15.8750000 0.542798
+ 15.8777778 0.540741
+ 15.8805556 0.540741
+ 15.8833333 0.538683
+ 15.8861111 0.534568
+ 15.8888889 0.534568
+ 15.8916667 0.532510
+ 15.8944444 0.536626
+ 15.8972222 0.536626
+ 15.9000000 0.530453
+ 15.9027778 0.524280
+ 15.9055556 0.520165
+ 15.9083333 0.516049
+ 15.9111111 0.522222
+ 15.9138889 0.526337
+ 15.9166667 0.524280
+ 15.9194444 0.516049
+ 15.9222222 0.505761
+ 15.9250000 0.491358
+ 15.9277778 0.487243
+ 15.9305556 0.485185
+ 15.9333333 0.491358
+ 15.9361111 0.495473
+ 15.9388889 0.503704
+ 15.9416667 0.507819
+ 15.9444444 0.516049
+ 15.9472222 0.518107
+ 15.9500000 0.516049
+ 15.9527778 0.511934
+ 15.9555556 0.509877
+ 15.9583333 0.507819
+ 15.9611111 0.507819
+ 15.9638889 0.509877
+ 15.9666667 0.516049
+ 15.9694444 0.526337
+ 15.9722222 0.532510
+ 15.9750000 0.530453
+ 15.9777778 0.516049
+ 15.9805556 0.511934
+ 15.9833333 0.499588
+ 15.9861111 0.489300
+ 15.9888889 0.495473
+ 15.9916667 0.503704
+ 15.9944444 0.520165
+ 15.9972222 0.526337
+ 16.0000000 0.513992
+ 16.0027778 0.511934
+ 16.0055556 0.501646
+ 16.0083333 0.493416
+ 16.0111111 0.487243
+ 16.0138889 0.487243
+ 16.0166667 0.487243
+ 16.0194444 0.481070
+ 16.0222222 0.479012
+ 16.0250000 0.481070
+ 16.0277778 0.483128
+ 16.0305556 0.481070
+ 16.0333333 0.491358
+ 16.0361111 0.497531
+ 16.0388889 0.501646
+ 16.0416667 0.495473
+ 16.0444444 0.495473
+ 16.0472222 0.489300
+ 16.0500000 0.491358
+ 16.0527778 0.493416
+ 16.0555556 0.495473
+ 16.0583333 0.507819
+ 16.0611111 0.522222
+ 16.0638889 0.530453
+ 16.0666667 0.532510
+ 16.0694444 0.528395
+ 16.0722222 0.513992
+ 16.0750000 0.501646
+ 16.0777778 0.493416
+ 16.0805556 0.491358
+ 16.0833333 0.499588
+ 16.0861111 0.503704
+ 16.0888889 0.507819
+ 16.0916667 0.511934
+ 16.0944444 0.507819
+ 16.0972222 0.499588
+ 16.1000000 0.499588
+ 16.1027778 0.499588
+ 16.1055556 0.499588
+ 16.1083333 0.497531
+ 16.1111111 0.495473
+ 16.1138889 0.481070
+ 16.1166667 0.472840
+ 16.1194444 0.468724
+ 16.1222222 0.481070
+ 16.1250000 0.491358
+ 16.1277778 0.501646
+ 16.1305556 0.507819
+ 16.1333333 0.518107
+ 16.1361111 0.520165
+ 16.1388889 0.513992
+ 16.1416667 0.499588
+ 16.1444444 0.485185
+ 16.1472222 0.474897
+ 16.1500000 0.464609
+ 16.1527778 0.468724
+ 16.1555556 0.476955
+ 16.1583333 0.487243
+ 16.1611111 0.493416
+ 16.1638889 0.503704
+ 16.1666667 0.507819
+ 16.1694444 0.516049
+ 16.1722222 0.526337
+ 16.1750000 0.532510
+ 16.1777778 0.526337
+ 16.1805556 0.509877
+ 16.1833333 0.491358
+ 16.1861111 0.464609
+ 16.1888889 0.458436
+ 16.1916667 0.454321
+ 16.1944444 0.454321
+ 16.1972222 0.466667
+ 16.2000000 0.483128
+ 16.2027778 0.495473
+ 16.2055556 0.503704
+ 16.2083333 0.513992
+ 16.2111111 0.524280
+ 16.2138889 0.540741
+ 16.2166667 0.544856
+ 16.2194444 0.536626
+ 16.2222222 0.520165
+ 16.2250000 0.495473
+ 16.2277778 0.466667
+ 16.2305556 0.456379
+ 16.2333333 0.458436
+ 16.2361111 0.472840
+ 16.2388889 0.487243
+ 16.2416667 0.509877
+ 16.2444444 0.524280
+ 16.2472222 0.538683
+ 16.2500000 0.555144
+ 16.2527778 0.567490
+ 16.2555556 0.594239
+ 16.2583333 0.623045
+ 16.2611111 0.655967
+ 16.2638889 0.693004
+ 16.2666667 0.725926
+ 16.2694444 0.736214
+ 16.2722222 0.711523
+ 16.2750000 0.633333
+ 16.2777778 0.526337
+ 16.2805556 0.433745
+ 16.2833333 0.367901
+ 16.2861111 0.341152
+ 16.2888889 0.337037
+ 16.2916667 0.349383
+ 16.2944444 0.369959
+ 16.2972222 0.388477
+ 16.3000000 0.404938
+ 16.3027778 0.427572
+ 16.3055556 0.437860
+ 16.3083333 0.433745
+ 16.3111111 0.421399
+ 16.3138889 0.402881
+ 16.3166667 0.382305
+ 16.3194444 0.374074
+ 16.3222222 0.380247
+ 16.3250000 0.392593
+ 16.3277778 0.409053
+ 16.3305556 0.423457
+ 16.3333333 0.429630
+ 16.3361111 0.423457
+ 16.3388889 0.417284
+ 16.3416667 0.409053
+ 16.3444444 0.406996
+ 16.3472222 0.400823
+ 16.3500000 0.404938
+ 16.3527778 0.411111
+ 16.3555556 0.415226
+ 16.3583333 0.425514
+ 16.3611111 0.441975
+ 16.3638889 0.458436
+ 16.3666667 0.474897
+ 16.3694444 0.481070
+ 16.3722222 0.493416
+ 16.3750000 0.499588
+ 16.3777778 0.509877
+ 16.3805556 0.509877
+ 16.3833333 0.503704
+ 16.3861111 0.491358
+ 16.3888889 0.470782
+ 16.3916667 0.464609
+ 16.3944444 0.462551
+ 16.3972222 0.468724
+ 16.4000000 0.481070
+ 16.4027778 0.491358
+ 16.4055556 0.505761
+ 16.4083333 0.505761
+ 16.4111111 0.509877
+ 16.4138889 0.495473
+ 16.4166667 0.491358
+ 16.4194444 0.483128
+ 16.4222222 0.476955
+ 16.4250000 0.474897
+ 16.4277778 0.479012
+ 16.4305556 0.481070
+ 16.4333333 0.487243
+ 16.4361111 0.493416
+ 16.4388889 0.501646
+ 16.4416667 0.503704
+ 16.4444444 0.505761
+ 16.4472222 0.497531
+ 16.4500000 0.493416
+ 16.4527778 0.489300
+ 16.4555556 0.483128
+ 16.4583333 0.491358
+ 16.4611111 0.499588
+ 16.4638889 0.497531
+ 16.4666667 0.497531
+ 16.4694444 0.495473
+ 16.4722222 0.499588
+ 16.4750000 0.509877
+ 16.4777778 0.513992
+ 16.4805556 0.530453
+ 16.4833333 0.544856
+ 16.4861111 0.546914
+ 16.4888889 0.536626
+ 16.4916667 0.520165
+ 16.4944444 0.501646
+ 16.4972222 0.487243
+ 16.5000000 0.479012
+ 16.5027778 0.485185
+ 16.5055556 0.495473
+ 16.5083333 0.505761
+ 16.5111111 0.522222
+ 16.5138889 0.532510
+ 16.5166667 0.546914
+ 16.5194444 0.548971
+ 16.5222222 0.559259
+ 16.5250000 0.567490
+ 16.5277778 0.573663
+ 16.5305556 0.575720
+ 16.5333333 0.561317
+ 16.5361111 0.548971
+ 16.5388889 0.544856
+ 16.5416667 0.542798
+ 16.5444444 0.551029
+ 16.5472222 0.561317
+ 16.5500000 0.569547
+ 16.5527778 0.581893
+ 16.5555556 0.581893
+ 16.5583333 0.577778
+ 16.5611111 0.571605
+ 16.5638889 0.571605
+ 16.5666667 0.571605
+ 16.5694444 0.575720
+ 16.5722222 0.581893
+ 16.5750000 0.588066
+ 16.5777778 0.588066
+ 16.5805556 0.579835
+ 16.5833333 0.567490
+ 16.5861111 0.551029
+ 16.5888889 0.544856
+ 16.5916667 0.538683
+ 16.5944444 0.538683
+ 16.5972222 0.540741
+ 16.6000000 0.534568
+ 16.6027778 0.532510
+ 16.6055556 0.536626
+ 16.6083333 0.540741
+ 16.6111111 0.542798
+ 16.6138889 0.536626
+ 16.6166667 0.526337
+ 16.6194444 0.511934
+ 16.6222222 0.503704
+ 16.6250000 0.499588
+ 16.6277778 0.493416
+ 16.6305556 0.495473
+ 16.6333333 0.499588
+ 16.6361111 0.501646
+ 16.6388889 0.501646
+ 16.6416667 0.499588
+ 16.6444444 0.491358
+ 16.6472222 0.495473
+ 16.6500000 0.489300
+ 16.6527778 0.485185
+ 16.6555556 0.485185
+ 16.6583333 0.481070
+ 16.6611111 0.485185
+ 16.6638889 0.491358
+ 16.6666667 0.501646
+ 16.6694444 0.505761
+ 16.6722222 0.509877
+ 16.6750000 0.501646
+ 16.6777778 0.493416
+ 16.6805556 0.487243
+ 16.6833333 0.481070
+ 16.6861111 0.474897
+ 16.6888889 0.479012
+ 16.6916667 0.476955
+ 16.6944444 0.481070
+ 16.6972222 0.476955
+ 16.7000000 0.481070
+ 16.7027778 0.479012
+ 16.7055556 0.481070
+ 16.7083333 0.483128
+ 16.7111111 0.487243
+ 16.7138889 0.489300
+ 16.7166667 0.491358
+ 16.7194444 0.493416
+ 16.7222222 0.497531
+ 16.7250000 0.499588
+ 16.7277778 0.503704
+ 16.7305556 0.505761
+ 16.7333333 0.503704
+ 16.7361111 0.501646
+ 16.7388889 0.497531
+ 16.7416667 0.497531
+ 16.7444444 0.497531
+ 16.7472222 0.499588
+ 16.7500000 0.501646
+ 16.7527778 0.505761
+ 16.7555556 0.505761
+ 16.7583333 0.497531
+ 16.7611111 0.495473
+ 16.7638889 0.489300
+ 16.7666667 0.485185
+ 16.7694444 0.491358
+ 16.7722222 0.499588
+ 16.7750000 0.507819
+ 16.7777778 0.507819
+ 16.7805556 0.507819
+ 16.7833333 0.507819
+ 16.7861111 0.497531
+ 16.7888889 0.487243
+ 16.7916667 0.476955
+ 16.7944444 0.470782
+ 16.7972222 0.474897
+ 16.8000000 0.479012
+ 16.8027778 0.485185
+ 16.8055556 0.485185
+ 16.8083333 0.489300
+ 16.8111111 0.497531
+ 16.8138889 0.503704
+ 16.8166667 0.503704
+ 16.8194444 0.501646
+ 16.8222222 0.497531
+ 16.8250000 0.491358
+ 16.8277778 0.485185
+ 16.8305556 0.489300
+ 16.8333333 0.487243
+ 16.8361111 0.489300
+ 16.8388889 0.491358
+ 16.8416667 0.485185
+ 16.8444444 0.485185
+ 16.8472222 0.483128
+ 16.8500000 0.476955
+ 16.8527778 0.472840
+ 16.8555556 0.474897
+ 16.8583333 0.474897
+ 16.8611111 0.479012
+ 16.8638889 0.485185
+ 16.8666667 0.487243
+ 16.8694444 0.487243
+ 16.8722222 0.485185
+ 16.8750000 0.481070
+ 16.8777778 0.476955
+ 16.8805556 0.481070
+ 16.8833333 0.476955
+ 16.8861111 0.485185
+ 16.8888889 0.497531
+ 16.8916667 0.503704
+ 16.8944444 0.507819
+ 16.8972222 0.505761
+ 16.9000000 0.491358
+ 16.9027778 0.474897
+ 16.9055556 0.470782
+ 16.9083333 0.466667
+ 16.9111111 0.472840
+ 16.9138889 0.487243
+ 16.9166667 0.499588
+ 16.9194444 0.497531
+ 16.9222222 0.489300
+ 16.9250000 0.479012
+ 16.9277778 0.472840
+ 16.9305556 0.470782
+ 16.9333333 0.479012
+ 16.9361111 0.481070
+ 16.9388889 0.493416
+ 16.9416667 0.495473
+ 16.9444444 0.495473
+ 16.9472222 0.491358
+ 16.9500000 0.483128
+ 16.9527778 0.481070
+ 16.9555556 0.479012
+ 16.9583333 0.476955
+ 16.9611111 0.476955
+ 16.9638889 0.474897
+ 16.9666667 0.479012
+ 16.9694444 0.479012
+ 16.9722222 0.489300
+ 16.9750000 0.489300
+ 16.9777778 0.493416
+ 16.9805556 0.499588
+ 16.9833333 0.503704
+ 16.9861111 0.503704
+ 16.9888889 0.491358
+ 16.9916667 0.481070
+ 16.9944444 0.476955
+ 16.9972222 0.476955
+ 17.0000000 0.483128
+ 17.0027778 0.483128
+ 17.0055556 0.487243
+ 17.0083333 0.476955
+ 17.0111111 0.474897
+ 17.0138889 0.470782
+ 17.0166667 0.470782
+ 17.0194444 0.470782
+ 17.0222222 0.476955
+ 17.0250000 0.481070
+ 17.0277778 0.489300
+ 17.0305556 0.497531
+ 17.0333333 0.503704
+ 17.0361111 0.499588
+ 17.0388889 0.495473
+ 17.0416667 0.487243
+ 17.0444444 0.479012
+ 17.0472222 0.483128
+ 17.0500000 0.479012
+ 17.0527778 0.468724
+ 17.0555556 0.470782
+ 17.0583333 0.468724
+ 17.0611111 0.472840
+ 17.0638889 0.479012
+ 17.0666667 0.476955
+ 17.0694444 0.474897
+ 17.0722222 0.476955
+ 17.0750000 0.481070
+ 17.0777778 0.487243
+ 17.0805556 0.489300
+ 17.0833333 0.489300
+ 17.0861111 0.485185
+ 17.0888889 0.481070
+ 17.0916667 0.479012
+ 17.0944444 0.483128
+ 17.0972222 0.483128
+ 17.1000000 0.483128
+ 17.1027778 0.487243
+ 17.1055556 0.485185
+ 17.1083333 0.483128
+ 17.1111111 0.479012
+ 17.1138889 0.485185
+ 17.1166667 0.481070
+ 17.1194444 0.479012
+ 17.1222222 0.481070
+ 17.1250000 0.481070
+ 17.1277778 0.489300
+ 17.1305556 0.487243
+ 17.1333333 0.483128
+ 17.1361111 0.483128
+ 17.1388889 0.479012
+ 17.1416667 0.476955
+ 17.1444444 0.483128
+ 17.1472222 0.489300
+ 17.1500000 0.491358
+ 17.1527778 0.493416
+ 17.1555556 0.497531
+ 17.1583333 0.489300
+ 17.1611111 0.487243
+ 17.1638889 0.483128
+ 17.1666667 0.479012
+ 17.1694444 0.472840
+ 17.1722222 0.474897
+ 17.1750000 0.479012
+ 17.1777778 0.485185
+ 17.1805556 0.489300
+ 17.1833333 0.491358
+ 17.1861111 0.491358
+ 17.1888889 0.487243
+ 17.1916667 0.489300
+ 17.1944444 0.489300
+ 17.1972222 0.491358
+ 17.2000000 0.497531
+ 17.2027778 0.493416
+ 17.2055556 0.483128
+ 17.2083333 0.474897
+ 17.2111111 0.468724
+ 17.2138889 0.464609
+ 17.2166667 0.470782
+ 17.2194444 0.470782
+ 17.2222222 0.479012
+ 17.2250000 0.487243
+ 17.2277778 0.489300
+ 17.2305556 0.485185
+ 17.2333333 0.481070
+ 17.2361111 0.476955
+ 17.2388889 0.479012
+ 17.2416667 0.485185
+ 17.2444444 0.487243
+ 17.2472222 0.485185
+ 17.2500000 0.485185
+ 17.2527778 0.485185
+ 17.2555556 0.481070
+ 17.2583333 0.483128
+ 17.2611111 0.481070
+ 17.2638889 0.472840
+ 17.2666667 0.466667
+ 17.2694444 0.468724
+ 17.2722222 0.472840
+ 17.2750000 0.476955
+ 17.2777778 0.487243
+ 17.2805556 0.497531
+ 17.2833333 0.499588
+ 17.2861111 0.501646
+ 17.2888889 0.491358
+ 17.2916667 0.489300
+ 17.2944444 0.481070
+ 17.2972222 0.481070
+ 17.3000000 0.487243
+ 17.3027778 0.493416
+ 17.3055556 0.493416
+ 17.3083333 0.487243
+ 17.3111111 0.483128
+ 17.3138889 0.468724
+ 17.3166667 0.456379
+ 17.3194444 0.450206
+ 17.3222222 0.450206
+ 17.3250000 0.462551
+ 17.3277778 0.470782
+ 17.3305556 0.479012
+ 17.3333333 0.489300
+ 17.3361111 0.495473
+ 17.3388889 0.493416
+ 17.3416667 0.483128
+ 17.3444444 0.476955
+ 17.3472222 0.472840
+ 17.3500000 0.470782
+ 17.3527778 0.470782
+ 17.3555556 0.479012
+ 17.3583333 0.479012
+ 17.3611111 0.481070
+ 17.3638889 0.481070
+ 17.3666667 0.474897
+ 17.3694444 0.472840
+ 17.3722222 0.481070
+ 17.3750000 0.481070
+ 17.3777778 0.489300
+ 17.3805556 0.489300
+ 17.3833333 0.487243
+ 17.3861111 0.485185
+ 17.3888889 0.479012
+ 17.3916667 0.470782
+ 17.3944444 0.476955
+ 17.3972222 0.483128
+ 17.4000000 0.483128
+ 17.4027778 0.476955
+ 17.4055556 0.481070
+ 17.4083333 0.481070
+ 17.4111111 0.485185
+ 17.4138889 0.489300
+ 17.4166667 0.481070
+ 17.4194444 0.474897
+ 17.4222222 0.468724
+ 17.4250000 0.468724
+ 17.4277778 0.464609
+ 17.4305556 0.476955
+ 17.4333333 0.481070
+ 17.4361111 0.485185
+ 17.4388889 0.491358
+ 17.4416667 0.489300
+ 17.4444444 0.489300
+ 17.4472222 0.483128
+ 17.4500000 0.479012
+ 17.4527778 0.470782
+ 17.4555556 0.472840
+ 17.4583333 0.476955
+ 17.4611111 0.485185
+ 17.4638889 0.489300
+ 17.4666667 0.491358
+ 17.4694444 0.489300
+ 17.4722222 0.485185
+ 17.4750000 0.485185
+ 17.4777778 0.485185
+ 17.4805556 0.487243
+ 17.4833333 0.476955
+ 17.4861111 0.474897
+ 17.4888889 0.476955
+ 17.4916667 0.479012
+ 17.4944444 0.485185
+ 17.4972222 0.481070
+ 17.5000000 0.491358
+ 17.5027778 0.489300
+ 17.5055556 0.497531
+ 17.5083333 0.489300
+ 17.5111111 0.483128
+ 17.5138889 0.476955
+ 17.5166667 0.470782
+ 17.5194444 0.464609
+ 17.5222222 0.462551
+ 17.5250000 0.466667
+ 17.5277778 0.468724
+ 17.5305556 0.476955
+ 17.5333333 0.487243
+ 17.5361111 0.489300
+ 17.5388889 0.495473
+ 17.5416667 0.501646
+ 17.5444444 0.505761
+ 17.5472222 0.499588
+ 17.5500000 0.489300
+ 17.5527778 0.472840
+ 17.5555556 0.464609
+ 17.5583333 0.458436
+ 17.5611111 0.460494
+ 17.5638889 0.466667
+ 17.5666667 0.474897
+ 17.5694444 0.479012
+ 17.5722222 0.491358
+ 17.5750000 0.495473
+ 17.5777778 0.499588
+ 17.5805556 0.505761
+ 17.5833333 0.501646
+ 17.5861111 0.493416
+ 17.5888889 0.485185
+ 17.5916667 0.476955
+ 17.5944444 0.464609
+ 17.5972222 0.466667
+ 17.6000000 0.474897
+ 17.6027778 0.487243
+ 17.6055556 0.495473
+ 17.6083333 0.491358
+ 17.6111111 0.481070
+ 17.6138889 0.468724
+ 17.6166667 0.472840
+ 17.6194444 0.468724
+ 17.6222222 0.466667
+ 17.6250000 0.466667
+ 17.6277778 0.476955
+ 17.6305556 0.487243
+ 17.6333333 0.491358
+ 17.6361111 0.499588
+ 17.6388889 0.507819
+ 17.6416667 0.511934
+ 17.6444444 0.503704
+ 17.6472222 0.495473
+ 17.6500000 0.481070
+ 17.6527778 0.460494
+ 17.6555556 0.452263
+ 17.6583333 0.454321
+ 17.6611111 0.466667
+ 17.6638889 0.472840
+ 17.6666667 0.485185
+ 17.6694444 0.491358
+ 17.6722222 0.491358
+ 17.6750000 0.485185
+ 17.6777778 0.472840
+ 17.6805556 0.462551
+ 17.6833333 0.450206
+ 17.6861111 0.444033
+ 17.6888889 0.444033
+ 17.6916667 0.454321
+ 17.6944444 0.470782
+ 17.6972222 0.479012
+ 17.7000000 0.487243
+ 17.7027778 0.491358
+ 17.7055556 0.485185
+ 17.7083333 0.481070
+ 17.7111111 0.474897
+ 17.7138889 0.466667
+ 17.7166667 0.458436
+ 17.7194444 0.460494
+ 17.7222222 0.466667
+ 17.7250000 0.481070
+ 17.7277778 0.495473
+ 17.7305556 0.501646
+ 17.7333333 0.503704
+ 17.7361111 0.501646
+ 17.7388889 0.493416
+ 17.7416667 0.487243
+ 17.7444444 0.481070
+ 17.7472222 0.476955
+ 17.7500000 0.476955
+ 17.7527778 0.474897
+ 17.7555556 0.474897
+ 17.7583333 0.474897
+ 17.7611111 0.474897
+ 17.7638889 0.481070
+ 17.7666667 0.489300
+ 17.7694444 0.493416
+ 17.7722222 0.497531
+ 17.7750000 0.487243
+ 17.7777778 0.479012
+ 17.7805556 0.470782
+ 17.7833333 0.466667
+ 17.7861111 0.466667
+ 17.7888889 0.474897
+ 17.7916667 0.481070
+ 17.7944444 0.499588
+ 17.7972222 0.503704
+ 17.8000000 0.505761
+ 17.8027778 0.505761
+ 17.8055556 0.503704
+ 17.8083333 0.507819
+ 17.8111111 0.511934
+ 17.8138889 0.513992
+ 17.8166667 0.509877
+ 17.8194444 0.507819
+ 17.8222222 0.503704
+ 17.8250000 0.495473
+ 17.8277778 0.493416
+ 17.8305556 0.497531
+ 17.8333333 0.503704
+ 17.8361111 0.507819
+ 17.8388889 0.509877
+ 17.8416667 0.505761
+ 17.8444444 0.497531
+ 17.8472222 0.485185
+ 17.8500000 0.481070
+ 17.8527778 0.474897
+ 17.8555556 0.474897
+ 17.8583333 0.479012
+ 17.8611111 0.487243
+ 17.8638889 0.491358
+ 17.8666667 0.491358
+ 17.8694444 0.493416
+ 17.8722222 0.495473
+ 17.8750000 0.495473
+ 17.8777778 0.485185
+ 17.8805556 0.481070
+ 17.8833333 0.470782
+ 17.8861111 0.472840
+ 17.8888889 0.474897
+ 17.8916667 0.479012
+ 17.8944444 0.479012
+ 17.8972222 0.481070
+ 17.9000000 0.476955
+ 17.9027778 0.476955
+ 17.9055556 0.468724
+ 17.9083333 0.464609
+ 17.9111111 0.464609
+ 17.9138889 0.466667
+ 17.9166667 0.464609
+ 17.9194444 0.460494
+ 17.9222222 0.472840
+ 17.9250000 0.474897
+ 17.9277778 0.479012
+ 17.9305556 0.476955
+ 17.9333333 0.472840
+ 17.9361111 0.468724
+ 17.9388889 0.479012
+ 17.9416667 0.481070
+ 17.9444444 0.487243
+ 17.9472222 0.481070
+ 17.9500000 0.474897
+ 17.9527778 0.464609
+ 17.9555556 0.456379
+ 17.9583333 0.452263
+ 17.9611111 0.460494
+ 17.9638889 0.466667
+ 17.9666667 0.476955
+ 17.9694444 0.487243
+ 17.9722222 0.489300
+ 17.9750000 0.479012
+ 17.9777778 0.464609
+ 17.9805556 0.458436
+ 17.9833333 0.466667
+ 17.9861111 0.483128
+ 17.9888889 0.503704
+ 17.9916667 0.522222
+ 17.9944444 0.536626
+ 17.9972222 0.559259
+ 18.0000000 0.583951
+ 18.0027778 0.618930
+ 18.0055556 0.649794
+ 18.0083333 0.670370
+ 18.0111111 0.666255
+ 18.0138889 0.631276
+ 18.0166667 0.555144
+ 18.0194444 0.470782
+ 18.0222222 0.396708
+ 18.0250000 0.355556
+ 18.0277778 0.343210
+ 18.0305556 0.353498
+ 18.0333333 0.369959
+ 18.0361111 0.378189
+ 18.0388889 0.386420
+ 18.0416667 0.386420
+ 18.0444444 0.386420
+ 18.0472222 0.380247
+ 18.0500000 0.369959
+ 18.0527778 0.363786
+ 18.0555556 0.359671
+ 18.0583333 0.361728
+ 18.0611111 0.374074
+ 18.0638889 0.386420
+ 18.0666667 0.396708
+ 18.0694444 0.409053
+ 18.0722222 0.406996
+ 18.0750000 0.402881
+ 18.0777778 0.388477
+ 18.0805556 0.386420
+ 18.0833333 0.378189
+ 18.0861111 0.378189
+ 18.0888889 0.382305
+ 18.0916667 0.390535
+ 18.0944444 0.406996
+ 18.0972222 0.413169
+ 18.1000000 0.421399
+ 18.1027778 0.433745
+ 18.1055556 0.444033
+ 18.1083333 0.460494
+ 18.1111111 0.470782
+ 18.1138889 0.483128
+ 18.1166667 0.483128
+ 18.1194444 0.483128
+ 18.1222222 0.468724
+ 18.1250000 0.466667
+ 18.1277778 0.470782
+ 18.1305556 0.479012
+ 18.1333333 0.491358
+ 18.1361111 0.491358
+ 18.1388889 0.481070
+ 18.1416667 0.466667
+ 18.1444444 0.450206
+ 18.1472222 0.454321
+ 18.1500000 0.456379
+ 18.1527778 0.460494
+ 18.1555556 0.464609
+ 18.1583333 0.462551
+ 18.1611111 0.460494
+ 18.1638889 0.458436
+ 18.1666667 0.456379
+ 18.1694444 0.460494
+ 18.1722222 0.462551
+ 18.1750000 0.464609
+ 18.1777778 0.468724
+ 18.1805556 0.466667
+ 18.1833333 0.474897
+ 18.1861111 0.474897
+ 18.1888889 0.470782
+ 18.1916667 0.481070
+ 18.1944444 0.485185
+ 18.1972222 0.483128
+ 18.2000000 0.483128
+ 18.2027778 0.489300
+ 18.2055556 0.489300
+ 18.2083333 0.479012
+ 18.2111111 0.485185
+ 18.2138889 0.487243
+ 18.2166667 0.491358
+ 18.2194444 0.507819
+ 18.2222222 0.511934
+ 18.2250000 0.503704
+ 18.2277778 0.489300
+ 18.2305556 0.468724
+ 18.2333333 0.464609
+ 18.2361111 0.474897
+ 18.2388889 0.487243
+ 18.2416667 0.499588
+ 18.2444444 0.516049
+ 18.2472222 0.518107
+ 18.2500000 0.507819
+ 18.2527778 0.503704
+ 18.2555556 0.499588
+ 18.2583333 0.495473
+ 18.2611111 0.499588
+ 18.2638889 0.509877
+ 18.2666667 0.520165
+ 18.2694444 0.528395
+ 18.2722222 0.538683
+ 18.2750000 0.530453
+ 18.2777778 0.526337
+ 18.2805556 0.522222
+ 18.2833333 0.534568
+ 18.2861111 0.540741
+ 18.2888889 0.540741
+ 18.2916667 0.536626
+ 18.2944444 0.540741
+ 18.2972222 0.540741
+ 18.3000000 0.542798
+ 18.3027778 0.542798
+ 18.3055556 0.544856
+ 18.3083333 0.546914
+ 18.3111111 0.540741
+ 18.3138889 0.538683
+ 18.3166667 0.534568
+ 18.3194444 0.538683
+ 18.3222222 0.544856
+ 18.3250000 0.546914
+ 18.3277778 0.555144
+ 18.3305556 0.553086
+ 18.3333333 0.548971
+ 18.3361111 0.540741
+ 18.3388889 0.551029
+ 18.3416667 0.553086
+ 18.3444444 0.557202
+ 18.3472222 0.548971
+ 18.3500000 0.540741
+ 18.3527778 0.530453
+ 18.3555556 0.522222
+ 18.3583333 0.526337
+ 18.3611111 0.530453
+ 18.3638889 0.520165
+ 18.3666667 0.509877
+ 18.3694444 0.503704
+ 18.3722222 0.507819
+ 18.3750000 0.509877
+ 18.3777778 0.503704
+ 18.3805556 0.503704
+ 18.3833333 0.499588
+ 18.3861111 0.493416
+ 18.3888889 0.493416
+ 18.3916667 0.491358
+ 18.3944444 0.487243
+ 18.3972222 0.479012
+ 18.4000000 0.474897
+ 18.4027778 0.470782
+ 18.4055556 0.472840
+ 18.4083333 0.462551
+ 18.4111111 0.446091
+ 18.4138889 0.433745
+ 18.4166667 0.427572
+ 18.4194444 0.423457
+ 18.4222222 0.427572
+ 18.4250000 0.439918
+ 18.4277778 0.452263
+ 18.4305556 0.460494
+ 18.4333333 0.466667
+ 18.4361111 0.466667
+ 18.4388889 0.464609
+ 18.4416667 0.466667
+ 18.4444444 0.464609
+ 18.4472222 0.464609
+ 18.4500000 0.456379
+ 18.4527778 0.456379
+ 18.4555556 0.456379
+ 18.4583333 0.462551
+ 18.4611111 0.472840
+ 18.4638889 0.479012
+ 18.4666667 0.479012
+ 18.4694444 0.481070
+ 18.4722222 0.479012
+ 18.4750000 0.476955
+ 18.4777778 0.468724
+ 18.4805556 0.472840
+ 18.4833333 0.462551
+ 18.4861111 0.460494
+ 18.4888889 0.454321
+ 18.4916667 0.458436
+ 18.4944444 0.462551
+ 18.4972222 0.474897
+ 18.5000000 0.481070
+ 18.5027778 0.483128
+ 18.5055556 0.483128
+ 18.5083333 0.481070
+ 18.5111111 0.470782
+ 18.5138889 0.468724
+ 18.5166667 0.460494
+ 18.5194444 0.462551
+ 18.5222222 0.466667
+ 18.5250000 0.476955
+ 18.5277778 0.485185
+ 18.5305556 0.487243
+ 18.5333333 0.487243
+ 18.5361111 0.479012
+ 18.5388889 0.474897
+ 18.5416667 0.470782
+ 18.5444444 0.472840
+ 18.5472222 0.476955
+ 18.5500000 0.479012
+ 18.5527778 0.487243
+ 18.5555556 0.491358
+ 18.5583333 0.487243
+ 18.5611111 0.481070
+ 18.5638889 0.468724
+ 18.5666667 0.460494
+ 18.5694444 0.462551
+ 18.5722222 0.468724
+ 18.5750000 0.481070
+ 18.5777778 0.493416
+ 18.5805556 0.497531
+ 18.5833333 0.485185
+ 18.5861111 0.472840
+ 18.5888889 0.452263
+ 18.5916667 0.448148
+ 18.5944444 0.446091
+ 18.5972222 0.452263
+ 18.6000000 0.460494
+ 18.6027778 0.468724
+ 18.6055556 0.476955
+ 18.6083333 0.479012
+ 18.6111111 0.476955
+ 18.6138889 0.476955
+ 18.6166667 0.464609
+ 18.6194444 0.462551
+ 18.6222222 0.462551
+ 18.6250000 0.466667
+ 18.6277778 0.472840
+ 18.6305556 0.483128
+ 18.6333333 0.485185
+ 18.6361111 0.487243
+ 18.6388889 0.489300
+ 18.6416667 0.489300
+ 18.6444444 0.489300
+ 18.6472222 0.485185
+ 18.6500000 0.474897
+ 18.6527778 0.462551
+ 18.6555556 0.470782
+ 18.6583333 0.493416
+ 18.6611111 0.528395
+ 18.6638889 0.567490
+ 18.6666667 0.608642
+ 18.6694444 0.629218
+ 18.6722222 0.639506
+ 18.6750000 0.620988
+ 18.6777778 0.581893
+ 18.6805556 0.520165
+ 18.6833333 0.456379
+ 18.6861111 0.406996
+ 18.6888889 0.372016
+ 18.6916667 0.361728
+ 18.6944444 0.363786
+ 18.6972222 0.382305
+ 18.7000000 0.390535
+ 18.7027778 0.402881
+ 18.7055556 0.413169
+ 18.7083333 0.419342
+ 18.7111111 0.417284
+ 18.7138889 0.415226
+ 18.7166667 0.411111
+ 18.7194444 0.398765
+ 18.7222222 0.382305
+ 18.7250000 0.376132
+ 18.7277778 0.372016
+ 18.7305556 0.376132
+ 18.7333333 0.380247
+ 18.7361111 0.388477
+ 18.7388889 0.392593
+ 18.7416667 0.394650
+ 18.7444444 0.394650
+ 18.7472222 0.404938
+ 18.7500000 0.404938
+ 18.7527778 0.400823
+ 18.7555556 0.398765
+ 18.7583333 0.409053
+ 18.7611111 0.417284
+ 18.7638889 0.433745
+ 18.7666667 0.446091
+ 18.7694444 0.462551
+ 18.7722222 0.481070
+ 18.7750000 0.501646
+ 18.7777778 0.507819
+ 18.7805556 0.511934
+ 18.7833333 0.499588
+ 18.7861111 0.483128
+ 18.7888889 0.468724
+ 18.7916667 0.462551
+ 18.7944444 0.456379
+ 18.7972222 0.458436
+ 18.8000000 0.466667
+ 18.8027778 0.483128
+ 18.8055556 0.489300
+ 18.8083333 0.481070
+ 18.8111111 0.470782
+ 18.8138889 0.466667
+ 18.8166667 0.458436
+ 18.8194444 0.464609
+ 18.8222222 0.470782
+ 18.8250000 0.464609
+ 18.8277778 0.470782
+ 18.8305556 0.472840
+ 18.8333333 0.472840
+ 18.8361111 0.479012
+ 18.8388889 0.485185
+ 18.8416667 0.489300
+ 18.8444444 0.493416
+ 18.8472222 0.503704
+ 18.8500000 0.497531
+ 18.8527778 0.493416
+ 18.8555556 0.487243
+ 18.8583333 0.481070
+ 18.8611111 0.485185
+ 18.8638889 0.491358
+ 18.8666667 0.501646
+ 18.8694444 0.503704
+ 18.8722222 0.503704
+ 18.8750000 0.503704
+ 18.8777778 0.495473
+ 18.8805556 0.497531
+ 18.8833333 0.499588
+ 18.8861111 0.507819
+ 18.8888889 0.513992
+ 18.8916667 0.524280
+ 18.8944444 0.530453
+ 18.8972222 0.522222
+ 18.9000000 0.516049
+ 18.9027778 0.505761
+ 18.9055556 0.507819
+ 18.9083333 0.505761
+ 18.9111111 0.509877
+ 18.9138889 0.518107
+ 18.9166667 0.526337
+ 18.9194444 0.534568
+ 18.9222222 0.534568
+ 18.9250000 0.538683
+ 18.9277778 0.551029
+ 18.9305556 0.561317
+ 18.9333333 0.565432
+ 18.9361111 0.573663
+ 18.9388889 0.573663
+ 18.9416667 0.581893
+ 18.9444444 0.583951
+ 18.9472222 0.590123
+ 18.9500000 0.586008
+ 18.9527778 0.586008
+ 18.9555556 0.567490
+ 18.9583333 0.555144
+ 18.9611111 0.546914
+ 18.9638889 0.548971
+ 18.9666667 0.555144
+ 18.9694444 0.565432
+ 18.9722222 0.579835
+ 18.9750000 0.590123
+ 18.9777778 0.598354
+ 18.9805556 0.588066
+ 18.9833333 0.573663
+ 18.9861111 0.559259
+ 18.9888889 0.546914
+ 18.9916667 0.540741
+ 18.9944444 0.542798
+ 18.9972222 0.548971
+ 19.0000000 0.557202
+ 19.0027778 0.555144
+ 19.0055556 0.551029
+ 19.0083333 0.534568
+ 19.0111111 0.518107
+ 19.0138889 0.503704
+ 19.0166667 0.491358
+ 19.0194444 0.483128
+ 19.0222222 0.470782
+ 19.0250000 0.470782
+ 19.0277778 0.474897
+ 19.0305556 0.485185
+ 19.0333333 0.491358
+ 19.0361111 0.497531
+ 19.0388889 0.501646
+ 19.0416667 0.497531
+ 19.0444444 0.495473
+ 19.0472222 0.489300
+ 19.0500000 0.481070
+ 19.0527778 0.474897
+ 19.0555556 0.472840
+ 19.0583333 0.472840
+ 19.0611111 0.481070
+ 19.0638889 0.481070
+ 19.0666667 0.481070
+ 19.0694444 0.481070
+ 19.0722222 0.485185
+ 19.0750000 0.483128
+ 19.0777778 0.481070
+ 19.0805556 0.485185
+ 19.0833333 0.474897
+ 19.0861111 0.464609
+ 19.0888889 0.468724
+ 19.0916667 0.468724
+ 19.0944444 0.472840
+ 19.0972222 0.472840
+ 19.1000000 0.479012
+ 19.1027778 0.483128
+ 19.1055556 0.487243
+ 19.1083333 0.487243
+ 19.1111111 0.489300
+ 19.1138889 0.491358
+ 19.1166667 0.485185
+ 19.1194444 0.479012
+ 19.1222222 0.483128
+ 19.1250000 0.487243
+ 19.1277778 0.487243
+ 19.1305556 0.487243
+ 19.1333333 0.489300
+ 19.1361111 0.476955
+ 19.1388889 0.466667
+ 19.1416667 0.458436
+ 19.1444444 0.450206
+ 19.1472222 0.454321
+ 19.1500000 0.456379
+ 19.1527778 0.460494
+ 19.1555556 0.466667
+ 19.1583333 0.468724
+ 19.1611111 0.466667
+ 19.1638889 0.468724
+ 19.1666667 0.468724
+ 19.1694444 0.468724
+ 19.1722222 0.474897
+ 19.1750000 0.472840
+ 19.1777778 0.474897
+ 19.1805556 0.472840
+ 19.1833333 0.470782
+ 19.1861111 0.485185
+ 19.1888889 0.485185
+ 19.1916667 0.489300
+ 19.1944444 0.487243
+ 19.1972222 0.489300
+ 19.2000000 0.495473
+ 19.2027778 0.499588
+ 19.2055556 0.503704
+ 19.2083333 0.499588
+ 19.2111111 0.495473
+ 19.2138889 0.489300
+ 19.2166667 0.483128
+ 19.2194444 0.479012
+ 19.2222222 0.472840
+ 19.2250000 0.472840
+ 19.2277778 0.474897
+ 19.2305556 0.474897
+ 19.2333333 0.479012
+ 19.2361111 0.485185
+ 19.2388889 0.493416
+ 19.2416667 0.495473
+ 19.2444444 0.499588
+ 19.2472222 0.499588
+ 19.2500000 0.495473
+ 19.2527778 0.493416
+ 19.2555556 0.491358
+ 19.2583333 0.483128
+ 19.2611111 0.483128
+ 19.2638889 0.470782
+ 19.2666667 0.468724
+ 19.2694444 0.464609
+ 19.2722222 0.476955
+ 19.2750000 0.481070
+ 19.2777778 0.481070
+ 19.2805556 0.479012
+ 19.2833333 0.479012
+ 19.2861111 0.472840
+ 19.2888889 0.474897
+ 19.2916667 0.474897
+ 19.2944444 0.479012
+ 19.2972222 0.481070
+ 19.3000000 0.481070
+ 19.3027778 0.487243
+ 19.3055556 0.493416
+ 19.3083333 0.487243
+ 19.3111111 0.491358
+ 19.3138889 0.491358
+ 19.3166667 0.487243
+ 19.3194444 0.489300
+ 19.3222222 0.485185
+ 19.3250000 0.485185
+ 19.3277778 0.483128
+ 19.3305556 0.485185
+ 19.3333333 0.493416
+ 19.3361111 0.495473
+ 19.3388889 0.501646
+ 19.3416667 0.505761
+ 19.3444444 0.505761
+ 19.3472222 0.499588
+ 19.3500000 0.499588
+ 19.3527778 0.497531
+ 19.3555556 0.497531
+ 19.3583333 0.499588
+ 19.3611111 0.505761
+ 19.3638889 0.513992
+ 19.3666667 0.518107
+ 19.3694444 0.526337
+ 19.3722222 0.526337
+ 19.3750000 0.518107
+ 19.3777778 0.518107
+ 19.3805556 0.530453
+ 19.3833333 0.553086
+ 19.3861111 0.590123
+ 19.3888889 0.635391
+ 19.3916667 0.676543
+ 19.3944444 0.717695
+ 19.3972222 0.736214
+ 19.4000000 0.723868
+ 19.4027778 0.668313
+ 19.4055556 0.581893
+ 19.4083333 0.481070
+ 19.4111111 0.404938
+ 19.4138889 0.355556
+ 19.4166667 0.334979
+ 19.4194444 0.339095
+ 19.4222222 0.355556
+ 19.4250000 0.376132
+ 19.4277778 0.392593
+ 19.4305556 0.406996
+ 19.4333333 0.413169
+ 19.4361111 0.409053
+ 19.4388889 0.409053
+ 19.4416667 0.396708
+ 19.4444444 0.400823
+ 19.4472222 0.415226
+ 19.4500000 0.427572
+ 19.4527778 0.441975
+ 19.4555556 0.452263
+ 19.4583333 0.450206
+ 19.4611111 0.441975
+ 19.4638889 0.429630
+ 19.4666667 0.413169
+ 19.4694444 0.406996
+ 19.4722222 0.406996
+ 19.4750000 0.421399
+ 19.4777778 0.427572
+ 19.4805556 0.439918
+ 19.4833333 0.450206
+ 19.4861111 0.458436
+ 19.4888889 0.460494
+ 19.4916667 0.468724
+ 19.4944444 0.474897
+ 19.4972222 0.479012
+ 19.5000000 0.487243
+ 19.5027778 0.489300
+ 19.5055556 0.497531
+ 19.5083333 0.487243
+ 19.5111111 0.493416
+ 19.5138889 0.493416
+ 19.5166667 0.497531
+ 19.5194444 0.499588
+ 19.5222222 0.501646
+ 19.5250000 0.495473
+ 19.5277778 0.485185
+ 19.5305556 0.474897
+ 19.5333333 0.472840
+ 19.5361111 0.472840
+ 19.5388889 0.491358
+ 19.5416667 0.499588
+ 19.5444444 0.505761
+ 19.5472222 0.509877
+ 19.5500000 0.507819
+ 19.5527778 0.511934
+ 19.5555556 0.505761
+ 19.5583333 0.497531
+ 19.5611111 0.495473
+ 19.5638889 0.497531
+ 19.5666667 0.497531
+ 19.5694444 0.493416
+ 19.5722222 0.503704
+ 19.5750000 0.513992
+ 19.5777778 0.520165
+ 19.5805556 0.520165
+ 19.5833333 0.518107
+ 19.5861111 0.513992
+ 19.5888889 0.501646
+ 19.5916667 0.497531
+ 19.5944444 0.501646
+ 19.5972222 0.507819
+ 19.6000000 0.516049
+ 19.6027778 0.516049
+ 19.6055556 0.522222
+ 19.6083333 0.526337
+ 19.6111111 0.532510
+ 19.6138889 0.534568
+ 19.6166667 0.522222
+ 19.6194444 0.511934
+ 19.6222222 0.501646
+ 19.6250000 0.505761
+ 19.6277778 0.522222
+ 19.6305556 0.538683
+ 19.6333333 0.555144
+ 19.6361111 0.569547
+ 19.6388889 0.567490
+ 19.6416667 0.563374
+ 19.6444444 0.559259
+ 19.6472222 0.559259
+ 19.6500000 0.563374
+ 19.6527778 0.573663
+ 19.6555556 0.577778
+ 19.6583333 0.583951
+ 19.6611111 0.583951
+ 19.6638889 0.577778
+ 19.6666667 0.569547
+ 19.6694444 0.571605
+ 19.6722222 0.575720
+ 19.6750000 0.581893
+ 19.6777778 0.583951
+ 19.6805556 0.590123
+ 19.6833333 0.592181
+ 19.6861111 0.586008
+ 19.6888889 0.583951
+ 19.6916667 0.579835
+ 19.6944444 0.581893
+ 19.6972222 0.575720
+ 19.7000000 0.573663
+ 19.7027778 0.577778
+ 19.7055556 0.573663
+ 19.7083333 0.571605
+ 19.7111111 0.573663
+ 19.7138889 0.573663
+ 19.7166667 0.577778
+ 19.7194444 0.573663
+ 19.7222222 0.561317
+ 19.7250000 0.544856
+ 19.7277778 0.532510
+ 19.7305556 0.513992
+ 19.7333333 0.503704
+ 19.7361111 0.499588
+ 19.7388889 0.501646
+ 19.7416667 0.501646
+ 19.7444444 0.501646
+ 19.7472222 0.507819
+ 19.7500000 0.505761
+ 19.7527778 0.505761
+ 19.7555556 0.503704
+ 19.7583333 0.501646
+ 19.7611111 0.497531
+ 19.7638889 0.495473
+ 19.7666667 0.491358
+ 19.7694444 0.497531
+ 19.7722222 0.497531
+ 19.7750000 0.497531
+ 19.7777778 0.493416
+ 19.7805556 0.495473
+ 19.7833333 0.493416
+ 19.7861111 0.487243
+ 19.7888889 0.493416
+ 19.7916667 0.495473
+ 19.7944444 0.499588
+ 19.7972222 0.501646
+ 19.8000000 0.497531
+ 19.8027778 0.489300
+ 19.8055556 0.479012
+ 19.8083333 0.470782
+ 19.8111111 0.470782
+ 19.8138889 0.476955
+ 19.8166667 0.481070
+ 19.8194444 0.481070
+ 19.8222222 0.472840
+ 19.8250000 0.474897
+ 19.8277778 0.468724
+ 19.8305556 0.470782
+ 19.8333333 0.460494
+ 19.8361111 0.466667
+ 19.8388889 0.468724
+ 19.8416667 0.474897
+ 19.8444444 0.472840
+ 19.8472222 0.485185
+ 19.8500000 0.485185
+ 19.8527778 0.485185
+ 19.8555556 0.485185
+ 19.8583333 0.485185
+ 19.8611111 0.487243
+ 19.8638889 0.481070
+ 19.8666667 0.479012
+ 19.8694444 0.474897
+ 19.8722222 0.474897
+ 19.8750000 0.472840
+ 19.8777778 0.476955
+ 19.8805556 0.485185
+ 19.8833333 0.489300
+ 19.8861111 0.501646
+ 19.8888889 0.509877
+ 19.8916667 0.511934
+ 19.8944444 0.505761
+ 19.8972222 0.501646
+ 19.9000000 0.495473
+ 19.9027778 0.485185
+ 19.9055556 0.487243
+ 19.9083333 0.487243
+ 19.9111111 0.491358
+ 19.9138889 0.493416
+ 19.9166667 0.493416
+ 19.9194444 0.497531
+ 19.9222222 0.497531
+ 19.9250000 0.497531
+ 19.9277778 0.491358
+ 19.9305556 0.481070
+ 19.9333333 0.476955
+ 19.9361111 0.462551
+ 19.9388889 0.464609
+ 19.9416667 0.464609
+ 19.9444444 0.470782
+ 19.9472222 0.485185
+ 19.9500000 0.499588
+ 19.9527778 0.511934
+ 19.9555556 0.507819
+ 19.9583333 0.495473
+ 19.9611111 0.489300
+ 19.9638889 0.474897
+ 19.9666667 0.470782
+ 19.9694444 0.472840
+ 19.9722222 0.472840
+ 19.9750000 0.474897
+ 19.9777778 0.474897
+ 19.9805556 0.476955
+ 19.9833333 0.483128
+ 19.9861111 0.479012
+ 19.9888889 0.481070
+ 19.9916667 0.487243
+ 19.9944444 0.493416
+ 19.9972222 0.495473
+ 20.0000000 0.489300
+ 20.0027778 0.493416
+ 20.0055556 0.491358
+ 20.0083333 0.485185
+ 20.0111111 0.483128
+ 20.0138889 0.483128
+ 20.0166667 0.487243
+ 20.0194444 0.497531
+ 20.0222222 0.503704
+ 20.0250000 0.505761
+ 20.0277778 0.499588
+ 20.0305556 0.485185
+ 20.0333333 0.464609
+ 20.0361111 0.464609
+ 20.0388889 0.468724
+ 20.0416667 0.470782
+ 20.0444444 0.476955
+ 20.0472222 0.481070
+ 20.0500000 0.485185
+ 20.0527778 0.489300
+ 20.0555556 0.489300
+ 20.0583333 0.493416
+ 20.0611111 0.499588
+ 20.0638889 0.507819
+ 20.0666667 0.516049
+ 20.0694444 0.522222
+ 20.0722222 0.534568
+ 20.0750000 0.555144
+ 20.0777778 0.579835
+ 20.0805556 0.625103
+ 20.0833333 0.672428
+ 20.0861111 0.719753
+ 20.0888889 0.756790
+ 20.0916667 0.781481
+ 20.0944444 0.779424
+ 20.0972222 0.740329
+ 20.1000000 0.660082
+ 20.1027778 0.559259
+ 20.1055556 0.462551
+ 20.1083333 0.394650
+ 20.1111111 0.357613
+ 20.1138889 0.347325
+ 20.1166667 0.349383
+ 20.1194444 0.359671
+ 20.1222222 0.367901
+ 20.1250000 0.376132
+ 20.1277778 0.386420
+ 20.1305556 0.388477
+ 20.1333333 0.394650
+ 20.1361111 0.392593
+ 20.1388889 0.384362
+ 20.1416667 0.378189
+ 20.1444444 0.372016
+ 20.1472222 0.378189
+ 20.1500000 0.398765
+ 20.1527778 0.411111
+ 20.1555556 0.421399
+ 20.1583333 0.429630
+ 20.1611111 0.427572
+ 20.1638889 0.423457
+ 20.1666667 0.411111
+ 20.1694444 0.411111
+ 20.1722222 0.409053
+ 20.1750000 0.406996
+ 20.1777778 0.402881
+ 20.1805556 0.400823
+ 20.1833333 0.404938
+ 20.1861111 0.411111
+ 20.1888889 0.417284
+ 20.1916667 0.429630
+ 20.1944444 0.441975
+ 20.1972222 0.460494
+ 20.2000000 0.476955
+ 20.2027778 0.483128
+ 20.2055556 0.481070
+ 20.2083333 0.483128
+ 20.2111111 0.483128
+ 20.2138889 0.485185
+ 20.2166667 0.487243
+ 20.2194444 0.493416
+ 20.2222222 0.489300
+ 20.2250000 0.483128
+ 20.2277778 0.468724
+ 20.2305556 0.468724
+ 20.2333333 0.464609
+ 20.2361111 0.464609
+ 20.2388889 0.472840
+ 20.2416667 0.485185
+ 20.2444444 0.491358
+ 20.2472222 0.495473
+ 20.2500000 0.491358
+ 20.2527778 0.491358
+ 20.2555556 0.483128
+ 20.2583333 0.474897
+ 20.2611111 0.462551
+ 20.2638889 0.456379
+ 20.2666667 0.462551
+ 20.2694444 0.460494
+ 20.2722222 0.472840
+ 20.2750000 0.476955
+ 20.2777778 0.479012
+ 20.2805556 0.485185
+ 20.2833333 0.483128
+ 20.2861111 0.485185
+ 20.2888889 0.485185
+ 20.2916667 0.476955
+ 20.2944444 0.476955
+ 20.2972222 0.483128
+ 20.3000000 0.489300
+ 20.3027778 0.497531
+ 20.3055556 0.507819
+ 20.3083333 0.513992
+ 20.3111111 0.518107
+ 20.3138889 0.518107
+ 20.3166667 0.511934
+ 20.3194444 0.505761
+ 20.3222222 0.501646
+ 20.3250000 0.499588
+ 20.3277778 0.511934
+ 20.3305556 0.509877
+ 20.3333333 0.520165
+ 20.3361111 0.524280
+ 20.3388889 0.534568
+ 20.3416667 0.536626
+ 20.3444444 0.544856
+ 20.3472222 0.548971
+ 20.3500000 0.551029
+ 20.3527778 0.557202
+ 20.3555556 0.557202
+ 20.3583333 0.559259
+ 20.3611111 0.565432
+ 20.3638889 0.573663
+ 20.3666667 0.575720
+ 20.3694444 0.575720
+ 20.3722222 0.575720
+ 20.3750000 0.573663
+ 20.3777778 0.569547
+ 20.3805556 0.569547
+ 20.3833333 0.567490
+ 20.3861111 0.569547
+ 20.3888889 0.571605
+ 20.3916667 0.579835
+ 20.3944444 0.579835
+ 20.3972222 0.586008
+ 20.4000000 0.586008
+ 20.4027778 0.588066
+ 20.4055556 0.583951
+ 20.4083333 0.573663
+ 20.4111111 0.565432
+ 20.4138889 0.559259
+ 20.4166667 0.553086
+ 20.4194444 0.548971
+ 20.4222222 0.551029
+ 20.4250000 0.544856
+ 20.4277778 0.536626
+ 20.4305556 0.528395
+ 20.4333333 0.524280
+ 20.4361111 0.522222
+ 20.4388889 0.516049
+ 20.4416667 0.509877
+ 20.4444444 0.507819
+ 20.4472222 0.505761
+ 20.4500000 0.507819
+ 20.4527778 0.503704
+ 20.4555556 0.505761
+ 20.4583333 0.499588
+ 20.4611111 0.493416
+ 20.4638889 0.489300
+ 20.4666667 0.497531
+ 20.4694444 0.495473
+ 20.4722222 0.501646
+ 20.4750000 0.505761
+ 20.4777778 0.499588
+ 20.4805556 0.499588
+ 20.4833333 0.485185
+ 20.4861111 0.474897
+ 20.4888889 0.476955
+ 20.4916667 0.476955
+ 20.4944444 0.474897
+ 20.4972222 0.476955
+ 20.5000000 0.470782
+ 20.5027778 0.470782
+ 20.5055556 0.466667
+ 20.5083333 0.462551
+ 20.5111111 0.468724
+ 20.5138889 0.468724
+ 20.5166667 0.462551
+ 20.5194444 0.458436
+ 20.5222222 0.450206
+ 20.5250000 0.446091
+ 20.5277778 0.450206
+ 20.5305556 0.454321
+ 20.5333333 0.460494
+ 20.5361111 0.468724
+ 20.5388889 0.474897
+ 20.5416667 0.468724
+ 20.5444444 0.468724
+ 20.5472222 0.468724
+ 20.5500000 0.464609
+ 20.5527778 0.460494
+ 20.5555556 0.456379
+ 20.5583333 0.454321
+ 20.5611111 0.452263
+ 20.5638889 0.446091
+ 20.5666667 0.450206
+ 20.5694444 0.458436
+ 20.5722222 0.464609
+ 20.5750000 0.464609
+ 20.5777778 0.460494
+ 20.5805556 0.456379
+ 20.5833333 0.456379
+ 20.5861111 0.454321
+ 20.5888889 0.460494
+ 20.5916667 0.464609
+ 20.5944444 0.470782
+ 20.5972222 0.481070
+ 20.6000000 0.481070
+ 20.6027778 0.485185
+ 20.6055556 0.479012
+ 20.6083333 0.470782
+ 20.6111111 0.470782
+ 20.6138889 0.470782
+ 20.6166667 0.474897
+ 20.6194444 0.474897
+ 20.6222222 0.479012
+ 20.6250000 0.476955
+ 20.6277778 0.476955
+ 20.6305556 0.476955
+ 20.6333333 0.476955
+ 20.6361111 0.476955
+ 20.6388889 0.481070
+ 20.6416667 0.472840
+ 20.6444444 0.470782
+ 20.6472222 0.472840
+ 20.6500000 0.464609
+ 20.6527778 0.460494
+ 20.6555556 0.462551
+ 20.6583333 0.470782
+ 20.6611111 0.479012
+ 20.6638889 0.485185
+ 20.6666667 0.493416
+ 20.6694444 0.485185
+ 20.6722222 0.479012
+ 20.6750000 0.468724
+ 20.6777778 0.456379
+ 20.6805556 0.456379
+ 20.6833333 0.460494
+ 20.6861111 0.464609
+ 20.6888889 0.466667
+ 20.6916667 0.468724
+ 20.6944444 0.470782
+ 20.6972222 0.474897
+ 20.7000000 0.479012
+ 20.7027778 0.479012
+ 20.7055556 0.476955
+ 20.7083333 0.474897
+ 20.7111111 0.470782
+ 20.7138889 0.470782
+ 20.7166667 0.464609
+ 20.7194444 0.462551
+ 20.7222222 0.460494
+ 20.7250000 0.456379
+ 20.7277778 0.458436
+ 20.7305556 0.460494
+ 20.7333333 0.456379
+ 20.7361111 0.464609
+ 20.7388889 0.468724
+ 20.7416667 0.472840
+ 20.7444444 0.479012
+ 20.7472222 0.483128
+ 20.7500000 0.483128
+ 20.7527778 0.476955
+ 20.7555556 0.468724
+ 20.7583333 0.460494
+ 20.7611111 0.454321
+ 20.7638889 0.458436
+ 20.7666667 0.466667
+ 20.7694444 0.472840
+ 20.7722222 0.487243
+ 20.7750000 0.493416
+ 20.7777778 0.499588
+ 20.7805556 0.503704
+ 20.7833333 0.503704
+ 20.7861111 0.503704
+ 20.7888889 0.505761
+ 20.7916667 0.505761
+ 20.7944444 0.509877
+ 20.7972222 0.532510
+ 20.8000000 0.555144
+ 20.8027778 0.592181
+ 20.8055556 0.641564
+ 20.8083333 0.682716
+ 20.8111111 0.721811
+ 20.8138889 0.756790
+ 20.8166667 0.771193
+ 20.8194444 0.758848
+ 20.8222222 0.699177
+ 20.8250000 0.608642
+ 20.8277778 0.499588
+ 20.8305556 0.413169
+ 20.8333333 0.349383
+ 20.8361111 0.318519
+ 20.8388889 0.308230
+ 20.8416667 0.316461
+ 20.8444444 0.339095
+ 20.8472222 0.363786
+ 20.8500000 0.382305
+ 20.8527778 0.396708
+ 20.8555556 0.394650
+ 20.8583333 0.382305
+ 20.8611111 0.369959
+ 20.8638889 0.361728
+ 20.8666667 0.357613
+ 20.8694444 0.365844
+ 20.8722222 0.386420
+ 20.8750000 0.406996
+ 20.8777778 0.425514
+ 20.8805556 0.427572
+ 20.8833333 0.419342
+ 20.8861111 0.402881
+ 20.8888889 0.390535
+ 20.8916667 0.382305
+ 20.8944444 0.376132
+ 20.8972222 0.378189
+ 20.9000000 0.388477
+ 20.9027778 0.390535
+ 20.9055556 0.402881
+ 20.9083333 0.406996
+ 20.9111111 0.421399
+ 20.9138889 0.429630
+ 20.9166667 0.454321
+ 20.9194444 0.468724
+ 20.9222222 0.489300
+ 20.9250000 0.499588
+ 20.9277778 0.507819
+ 20.9305556 0.503704
+ 20.9333333 0.491358
+ 20.9361111 0.472840
+ 20.9388889 0.458436
+ 20.9416667 0.450206
+ 20.9444444 0.448148
+ 20.9472222 0.454321
+ 20.9500000 0.462551
+ 20.9527778 0.460494
+ 20.9555556 0.466667
+ 20.9583333 0.464609
+ 20.9611111 0.470782
+ 20.9638889 0.479012
+ 20.9666667 0.483128
+ 20.9694444 0.487243
+ 20.9722222 0.507819
+ 20.9750000 0.511934
+ 20.9777778 0.501646
+ 20.9805556 0.487243
+ 20.9833333 0.472840
+ 20.9861111 0.462551
+ 20.9888889 0.458436
+ 20.9916667 0.454321
+ 20.9944444 0.456379
+ 20.9972222 0.458436
+ 21.0000000 0.460494
+ 21.0027778 0.468724
+ 21.0055556 0.476955
+ 21.0083333 0.483128
+ 21.0111111 0.489300
+ 21.0138889 0.491358
+ 21.0166667 0.495473
+ 21.0194444 0.495473
+ 21.0222222 0.499588
+ 21.0250000 0.493416
+ 21.0277778 0.487243
+ 21.0305556 0.483128
+ 21.0333333 0.485185
+ 21.0361111 0.491358
+ 21.0388889 0.509877
+ 21.0416667 0.524280
+ 21.0444444 0.530453
+ 21.0472222 0.524280
+ 21.0500000 0.522222
+ 21.0527778 0.520165
+ 21.0555556 0.511934
+ 21.0583333 0.507819
+ 21.0611111 0.511934
+ 21.0638889 0.511934
+ 21.0666667 0.534568
+ 21.0694444 0.548971
+ 21.0722222 0.563374
+ 21.0750000 0.567490
+ 21.0777778 0.567490
+ 21.0805556 0.569547
+ 21.0833333 0.567490
+ 21.0861111 0.565432
+ 21.0888889 0.565432
+ 21.0916667 0.565432
+ 21.0944444 0.563374
+ 21.0972222 0.569547
+ 21.1000000 0.575720
+ 21.1027778 0.575720
+ 21.1055556 0.577778
+ 21.1083333 0.581893
+ 21.1111111 0.583951
+ 21.1138889 0.586008
+ 21.1166667 0.588066
+ 21.1194444 0.592181
+ 21.1222222 0.586008
+ 21.1250000 0.586008
+ 21.1277778 0.575720
+ 21.1305556 0.569547
+ 21.1333333 0.561317
+ 21.1361111 0.555144
+ 21.1388889 0.557202
+ 21.1416667 0.555144
+ 21.1444444 0.548971
+ 21.1472222 0.548971
+ 21.1500000 0.542798
+ 21.1527778 0.532510
+ 21.1555556 0.522222
+ 21.1583333 0.520165
+ 21.1611111 0.518107
+ 21.1638889 0.516049
+ 21.1666667 0.499588
+ 21.1694444 0.495473
+ 21.1722222 0.493416
+ 21.1750000 0.491358
+ 21.1777778 0.493416
+ 21.1805556 0.503704
+ 21.1833333 0.497531
+ 21.1861111 0.497531
+ 21.1888889 0.487243
+ 21.1916667 0.481070
+ 21.1944444 0.476955
+ 21.1972222 0.476955
+ 21.2000000 0.481070
+ 21.2027778 0.479012
+ 21.2055556 0.476955
+ 21.2083333 0.476955
+ 21.2111111 0.476955
+ 21.2138889 0.481070
+ 21.2166667 0.470782
+ 21.2194444 0.460494
+ 21.2222222 0.448148
+ 21.2250000 0.441975
+ 21.2277778 0.444033
+ 21.2305556 0.458436
+ 21.2333333 0.472840
+ 21.2361111 0.483128
+ 21.2388889 0.487243
+ 21.2416667 0.479012
+ 21.2444444 0.464609
+ 21.2472222 0.452263
+ 21.2500000 0.435802
+ 21.2527778 0.431687
+ 21.2555556 0.425514
+ 21.2583333 0.427572
+ 21.2611111 0.437860
+ 21.2638889 0.448148
+ 21.2666667 0.452263
+ 21.2694444 0.462551
+ 21.2722222 0.466667
+ 21.2750000 0.470782
+ 21.2777778 0.472840
+ 21.2805556 0.458436
+ 21.2833333 0.446091
+ 21.2861111 0.429630
+ 21.2888889 0.417284
+ 21.2916667 0.421399
+ 21.2944444 0.419342
+ 21.2972222 0.427572
+ 21.3000000 0.439918
+ 21.3027778 0.446091
+ 21.3055556 0.454321
+ 21.3083333 0.458436
+ 21.3111111 0.462551
+ 21.3138889 0.470782
+ 21.3166667 0.470782
+ 21.3194444 0.472840
+ 21.3222222 0.458436
+ 21.3250000 0.460494
+ 21.3277778 0.462551
+ 21.3305556 0.470782
+ 21.3333333 0.470782
+ 21.3361111 0.470782
+ 21.3388889 0.466667
+ 21.3416667 0.468724
+ 21.3444444 0.468724
+ 21.3472222 0.472840
+ 21.3500000 0.472840
+ 21.3527778 0.476955
+ 21.3555556 0.474897
+ 21.3583333 0.483128
+ 21.3611111 0.489300
+ 21.3638889 0.489300
+ 21.3666667 0.479012
+ 21.3694444 0.464609
+ 21.3722222 0.444033
+ 21.3750000 0.435802
+ 21.3777778 0.427572
+ 21.3805556 0.433745
+ 21.3833333 0.441975
+ 21.3861111 0.452263
+ 21.3888889 0.462551
+ 21.3916667 0.470782
+ 21.3944444 0.476955
+ 21.3972222 0.481070
+ 21.4000000 0.485185
+ 21.4027778 0.489300
+ 21.4055556 0.495473
+ 21.4083333 0.497531
+ 21.4111111 0.495473
+ 21.4138889 0.489300
+ 21.4166667 0.476955
+ 21.4194444 0.466667
+ 21.4222222 0.448148
+ 21.4250000 0.431687
+ 21.4277778 0.433745
+ 21.4305556 0.437860
+ 21.4333333 0.446091
+ 21.4361111 0.462551
+ 21.4388889 0.479012
+ 21.4416667 0.489300
+ 21.4444444 0.491358
+ 21.4472222 0.491358
+ 21.4500000 0.489300
+ 21.4527778 0.489300
+ 21.4555556 0.487243
+ 21.4583333 0.479012
+ 21.4611111 0.472840
+ 21.4638889 0.470782
+ 21.4666667 0.464609
+ 21.4694444 0.462551
+ 21.4722222 0.454321
+ 21.4750000 0.456379
+ 21.4777778 0.450206
+ 21.4805556 0.456379
+ 21.4833333 0.462551
+ 21.4861111 0.470782
+ 21.4888889 0.474897
+ 21.4916667 0.472840
+ 21.4944444 0.468724
+ 21.4972222 0.481070
+ 21.5000000 0.481070
+ 21.5027778 0.489300
+ 21.5055556 0.491358
+ 21.5083333 0.499588
+ 21.5111111 0.503704
+ 21.5138889 0.507819
+ 21.5166667 0.509877
+ 21.5194444 0.518107
+ 21.5222222 0.534568
+ 21.5250000 0.569547
+ 21.5277778 0.608642
+ 21.5305556 0.651852
+ 21.5333333 0.699177
+ 21.5361111 0.738272
+ 21.5388889 0.769136
+ 21.5416667 0.781481
+ 21.5444444 0.758848
+ 21.5472222 0.693004
+ 21.5500000 0.594239
+ 21.5527778 0.497531
+ 21.5555556 0.413169
+ 21.5583333 0.353498
+ 21.5611111 0.322634
+ 21.5638889 0.304115
+ 21.5666667 0.314403
+ 21.5694444 0.326749
+ 21.5722222 0.347325
+ 21.5750000 0.365844
+ 21.5777778 0.369959
+ 21.5805556 0.380247
+ 21.5833333 0.374074
+ 21.5861111 0.369959
+ 21.5888889 0.363786
+ 21.5916667 0.365844
+ 21.5944444 0.369959
+ 21.5972222 0.378189
+ 21.6000000 0.396708
+ 21.6027778 0.413169
+ 21.6055556 0.419342
+ 21.6083333 0.415226
+ 21.6111111 0.413169
+ 21.6138889 0.406996
+ 21.6166667 0.406996
+ 21.6194444 0.398765
+ 21.6222222 0.400823
+ 21.6250000 0.394650
+ 21.6277778 0.388477
+ 21.6305556 0.392593
+ 21.6333333 0.411111
+ 21.6361111 0.427572
+ 21.6388889 0.446091
+ 21.6416667 0.466667
+ 21.6444444 0.479012
+ 21.6472222 0.483128
+ 21.6500000 0.479012
+ 21.6527778 0.479012
+ 21.6555556 0.472840
+ 21.6583333 0.468724
+ 21.6611111 0.472840
+ 21.6638889 0.468724
+ 21.6666667 0.468724
+ 21.6694444 0.466667
+ 21.6722222 0.464609
+ 21.6750000 0.468724
+ 21.6777778 0.472840
+ 21.6805556 0.476955
+ 21.6833333 0.479012
+ 21.6861111 0.483128
+ 21.6888889 0.483128
+ 21.6916667 0.474897
+ 21.6944444 0.474897
+ 21.6972222 0.470782
+ 21.7000000 0.472840
+ 21.7027778 0.468724
+ 21.7055556 0.472840
+ 21.7083333 0.472840
+ 21.7111111 0.474897
+ 21.7138889 0.481070
+ 21.7166667 0.481070
+ 21.7194444 0.481070
+ 21.7222222 0.481070
+ 21.7250000 0.476955
+ 21.7277778 0.485185
+ 21.7305556 0.491358
+ 21.7333333 0.499588
+ 21.7361111 0.503704
+ 21.7388889 0.507819
+ 21.7416667 0.507819
+ 21.7444444 0.507819
+ 21.7472222 0.503704
+ 21.7500000 0.497531
+ 21.7527778 0.499588
+ 21.7555556 0.495473
+ 21.7583333 0.501646
+ 21.7611111 0.501646
+ 21.7638889 0.511934
+ 21.7666667 0.513992
+ 21.7694444 0.524280
+ 21.7722222 0.526337
+ 21.7750000 0.526337
+ 21.7777778 0.526337
+ 21.7805556 0.536626
+ 21.7833333 0.542798
+ 21.7861111 0.548971
+ 21.7888889 0.555144
+ 21.7916667 0.559259
+ 21.7944444 0.561317
+ 21.7972222 0.567490
+ 21.8000000 0.573663
+ 21.8027778 0.579835
+ 21.8055556 0.579835
+ 21.8083333 0.581893
+ 21.8111111 0.581893
+ 21.8138889 0.586008
+ 21.8166667 0.586008
+ 21.8194444 0.581893
+ 21.8222222 0.579835
+ 21.8250000 0.571605
+ 21.8277778 0.567490
+ 21.8305556 0.565432
+ 21.8333333 0.575720
+ 21.8361111 0.579835
+ 21.8388889 0.588066
+ 21.8416667 0.588066
+ 21.8444444 0.575720
+ 21.8472222 0.567490
+ 21.8500000 0.561317
+ 21.8527778 0.546914
+ 21.8555556 0.542798
+ 21.8583333 0.540741
+ 21.8611111 0.532510
+ 21.8638889 0.524280
+ 21.8666667 0.518107
+ 21.8694444 0.509877
+ 21.8722222 0.511934
+ 21.8750000 0.516049
+ 21.8777778 0.513992
+ 21.8805556 0.516049
+ 21.8833333 0.507819
+ 21.8861111 0.501646
+ 21.8888889 0.485185
+ 21.8916667 0.483128
+ 21.8944444 0.485185
+ 21.8972222 0.483128
+ 21.9000000 0.481070
+ 21.9027778 0.476955
+ 21.9055556 0.476955
+ 21.9083333 0.466667
+ 21.9111111 0.462551
+ 21.9138889 0.462551
+ 21.9166667 0.462551
+ 21.9194444 0.462551
+ 21.9222222 0.456379
+ 21.9250000 0.460494
+ 21.9277778 0.462551
+ 21.9305556 0.460494
+ 21.9333333 0.470782
+ 21.9361111 0.481070
+ 21.9388889 0.491358
+ 21.9416667 0.493416
+ 21.9444444 0.479012
+ 21.9472222 0.464609
+ 21.9500000 0.448148
+ 21.9527778 0.437860
+ 21.9555556 0.429630
+ 21.9583333 0.429630
+ 21.9611111 0.439918
+ 21.9638889 0.444033
+ 21.9666667 0.454321
+ 21.9694444 0.450206
+ 21.9722222 0.460494
+ 21.9750000 0.456379
+ 21.9777778 0.448148
+ 21.9805556 0.433745
+ 21.9833333 0.429630
+ 21.9861111 0.433745
+ 21.9888889 0.431687
+ 21.9916667 0.427572
+ 21.9944444 0.435802
+ 21.9972222 0.437860
+ 22.0000000 0.448148
+ 22.0027778 0.460494
+ 22.0055556 0.464609
+ 22.0083333 0.464609
+ 22.0111111 0.454321
+ 22.0138889 0.441975
+ 22.0166667 0.433745
+ 22.0194444 0.425514
+ 22.0222222 0.425514
+ 22.0250000 0.431687
+ 22.0277778 0.441975
+ 22.0305556 0.456379
+ 22.0333333 0.464609
+ 22.0361111 0.479012
+ 22.0388889 0.485185
+ 22.0416667 0.487243
+ 22.0444444 0.476955
+ 22.0472222 0.470782
+ 22.0500000 0.464609
+ 22.0527778 0.458436
+ 22.0555556 0.446091
+ 22.0583333 0.446091
+ 22.0611111 0.452263
+ 22.0638889 0.458436
+ 22.0666667 0.458436
+ 22.0694444 0.460494
+ 22.0722222 0.462551
+ 22.0750000 0.462551
+ 22.0777778 0.456379
+ 22.0805556 0.458436
+ 22.0833333 0.458436
+ 22.0861111 0.458436
+ 22.0888889 0.464609
+ 22.0916667 0.466667
+ 22.0944444 0.468724
+ 22.0972222 0.468724
+ 22.1000000 0.468724
+ 22.1027778 0.462551
+ 22.1055556 0.460494
+ 22.1083333 0.460494
+ 22.1111111 0.456379
+ 22.1138889 0.454321
+ 22.1166667 0.450206
+ 22.1194444 0.446091
+ 22.1222222 0.441975
+ 22.1250000 0.441975
+ 22.1277778 0.454321
+ 22.1305556 0.458436
+ 22.1333333 0.464609
+ 22.1361111 0.468724
+ 22.1388889 0.474897
+ 22.1416667 0.474897
+ 22.1444444 0.470782
+ 22.1472222 0.464609
+ 22.1500000 0.468724
+ 22.1527778 0.476955
+ 22.1555556 0.474897
+ 22.1583333 0.470782
+ 22.1611111 0.470782
+ 22.1638889 0.466667
+ 22.1666667 0.458436
+ 22.1694444 0.454321
+ 22.1722222 0.448148
+ 22.1750000 0.454321
+ 22.1777778 0.456379
+ 22.1805556 0.470782
+ 22.1833333 0.476955
+ 22.1861111 0.476955
+ 22.1888889 0.476955
+ 22.1916667 0.470782
+ 22.1944444 0.468724
+ 22.1972222 0.470782
+ 22.2000000 0.476955
+ 22.2027778 0.487243
+ 22.2055556 0.497531
+ 22.2083333 0.503704
+ 22.2111111 0.509877
+ 22.2138889 0.526337
+ 22.2166667 0.538683
+ 22.2194444 0.567490
+ 22.2222222 0.604527
+ 22.2250000 0.647737
+ 22.2277778 0.690947
+ 22.2305556 0.736214
+ 22.2333333 0.758848
+ 22.2361111 0.746502
+ 22.2388889 0.695062
+ 22.2416667 0.600412
+ 22.2444444 0.487243
+ 22.2472222 0.394650
+ 22.2500000 0.326749
+ 22.2527778 0.300000
+ 22.2555556 0.302058
+ 22.2583333 0.318519
+ 22.2611111 0.334979
+ 22.2638889 0.343210
+ 22.2666667 0.351440
+ 22.2694444 0.353498
+ 22.2722222 0.351440
+ 22.2750000 0.353498
+ 22.2777778 0.357613
+ 22.2805556 0.361728
+ 22.2833333 0.365844
+ 22.2861111 0.384362
+ 22.2888889 0.394650
+ 22.2916667 0.404938
+ 22.2944444 0.415226
+ 22.2972222 0.421399
+ 22.3000000 0.427572
+ 22.3027778 0.427572
+ 22.3055556 0.423457
+ 22.3083333 0.402881
+ 22.3111111 0.390535
+ 22.3138889 0.365844
+ 22.3166667 0.357613
+ 22.3194444 0.355556
+ 22.3222222 0.363786
+ 22.3250000 0.382305
+ 22.3277778 0.402881
+ 22.3305556 0.427572
+ 22.3333333 0.450206
+ 22.3361111 0.472840
+ 22.3388889 0.483128
+ 22.3416667 0.481070
+ 22.3444444 0.476955
+ 22.3472222 0.470782
+ 22.3500000 0.470782
+ 22.3527778 0.470782
+ 22.3555556 0.474897
+ 22.3583333 0.485185
+ 22.3611111 0.499588
+ 22.3638889 0.499588
+ 22.3666667 0.485185
+ 22.3694444 0.462551
+ 22.3722222 0.446091
+ 22.3750000 0.429630
+ 22.3777778 0.429630
+ 22.3805556 0.437860
+ 22.3833333 0.446091
+ 22.3861111 0.462551
+ 22.3888889 0.470782
+ 22.3916667 0.479012
+ 22.3944444 0.481070
+ 22.3972222 0.485185
+ 22.4000000 0.487243
+ 22.4027778 0.495473
+ 22.4055556 0.497531
+ 22.4083333 0.493416
+ 22.4111111 0.476955
+ 22.4138889 0.464609
+ 22.4166667 0.452263
+ 22.4194444 0.444033
+ 22.4222222 0.448148
+ 22.4250000 0.450206
+ 22.4277778 0.456379
+ 22.4305556 0.468724
+ 22.4333333 0.476955
+ 22.4361111 0.485185
+ 22.4388889 0.489300
+ 22.4416667 0.495473
+ 22.4444444 0.495473
+ 22.4472222 0.493416
+ 22.4500000 0.495473
+ 22.4527778 0.499588
+ 22.4555556 0.501646
+ 22.4583333 0.499588
+ 22.4611111 0.501646
+ 22.4638889 0.503704
+ 22.4666667 0.509877
+ 22.4694444 0.513992
+ 22.4722222 0.516049
+ 22.4750000 0.526337
+ 22.4777778 0.532510
+ 22.4805556 0.538683
+ 22.4833333 0.542798
+ 22.4861111 0.546914
+ 22.4888889 0.553086
+ 22.4916667 0.553086
+ 22.4944444 0.557202
+ 22.4972222 0.567490
+ 22.5000000 0.575720
+ 22.5027778 0.579835
+ 22.5055556 0.588066
+ 22.5083333 0.588066
+ 22.5111111 0.590123
+ 22.5138889 0.586008
+ 22.5166667 0.581893
+ 22.5194444 0.571605
+ 22.5222222 0.559259
+ 22.5250000 0.544856
+ 22.5277778 0.538683
+ 22.5305556 0.544856
+ 22.5333333 0.546914
+ 22.5361111 0.561317
+ 22.5388889 0.565432
+ 22.5416667 0.567490
+ 22.5444444 0.565432
+ 22.5472222 0.565432
+ 22.5500000 0.559259
+ 22.5527778 0.553086
+ 22.5555556 0.548971
+ 22.5583333 0.540741
+ 22.5611111 0.530453
+ 22.5638889 0.522222
+ 22.5666667 0.516049
+ 22.5694444 0.516049
+ 22.5722222 0.511934
+ 22.5750000 0.511934
+ 22.5777778 0.501646
+ 22.5805556 0.499588
+ 22.5833333 0.487243
+ 22.5861111 0.479012
+ 22.5888889 0.470782
+ 22.5916667 0.474897
+ 22.5944444 0.476955
+ 22.5972222 0.481070
+ 22.6000000 0.483128
+ 22.6027778 0.485185
+ 22.6055556 0.481070
+ 22.6083333 0.474897
+ 22.6111111 0.476955
+ 22.6138889 0.479012
+ 22.6166667 0.472840
+ 22.6194444 0.470782
+ 22.6222222 0.470782
+ 22.6250000 0.474897
+ 22.6277778 0.470782
+ 22.6305556 0.470782
+ 22.6333333 0.454321
+ 22.6361111 0.444033
+ 22.6388889 0.441975
+ 22.6416667 0.437860
+ 22.6444444 0.437860
+ 22.6472222 0.439918
+ 22.6500000 0.444033
+ 22.6527778 0.446091
+ 22.6555556 0.446091
+ 22.6583333 0.448148
+ 22.6611111 0.446091
+ 22.6638889 0.439918
+ 22.6666667 0.441975
+ 22.6694444 0.444033
+ 22.6722222 0.444033
+ 22.6750000 0.441975
+ 22.6777778 0.437860
+ 22.6805556 0.433745
+ 22.6833333 0.429630
+ 22.6861111 0.427572
+ 22.6888889 0.433745
+ 22.6916667 0.435802
+ 22.6944444 0.437860
+ 22.6972222 0.435802
+ 22.7000000 0.439918
+ 22.7027778 0.439918
+ 22.7055556 0.441975
+ 22.7083333 0.452263
+ 22.7111111 0.454321
+ 22.7138889 0.458436
+ 22.7166667 0.460494
+ 22.7194444 0.462551
+ 22.7222222 0.460494
+ 22.7250000 0.458436
+ 22.7277778 0.458436
+ 22.7305556 0.458436
+ 22.7333333 0.458436
+ 22.7361111 0.458436
+ 22.7388889 0.466667
+ 22.7416667 0.470782
+ 22.7444444 0.472840
+ 22.7472222 0.470782
+ 22.7500000 0.466667
+ 22.7527778 0.462551
+ 22.7555556 0.458436
+ 22.7583333 0.458436
+ 22.7611111 0.464609
+ 22.7638889 0.468724
+ 22.7666667 0.466667
+ 22.7694444 0.468724
+ 22.7722222 0.466667
+ 22.7750000 0.458436
+ 22.7777778 0.458436
+ 22.7805556 0.458436
+ 22.7833333 0.458436
+ 22.7861111 0.458436
+ 22.7888889 0.460494
+ 22.7916667 0.466667
+ 22.7944444 0.472840
+ 22.7972222 0.476955
+ 22.8000000 0.485185
+ 22.8027778 0.483128
+ 22.8055556 0.479012
+ 22.8083333 0.479012
+ 22.8111111 0.470782
+ 22.8138889 0.472840
+ 22.8166667 0.464609
+ 22.8194444 0.462551
+ 22.8222222 0.462551
+ 22.8250000 0.458436
+ 22.8277778 0.454321
+ 22.8305556 0.452263
+ 22.8333333 0.454321
+ 22.8361111 0.460494
+ 22.8388889 0.462551
+ 22.8416667 0.468724
+ 22.8444444 0.470782
+ 22.8472222 0.474897
+ 22.8500000 0.474897
+ 22.8527778 0.476955
+ 22.8555556 0.481070
+ 22.8583333 0.481070
+ 22.8611111 0.470782
+ 22.8638889 0.466667
+ 22.8666667 0.464609
+ 22.8694444 0.466667
+ 22.8722222 0.468724
+ 22.8750000 0.481070
+ 22.8777778 0.483128
+ 22.8805556 0.491358
+ 22.8833333 0.491358
+ 22.8861111 0.493416
+ 22.8888889 0.491358
+ 22.8916667 0.485185
+ 22.8944444 0.481070
+ 22.8972222 0.472840
+ 22.9000000 0.479012
+ 22.9027778 0.485185
+ 22.9055556 0.503704
+ 22.9083333 0.524280
+ 22.9111111 0.544856
+ 22.9138889 0.561317
+ 22.9166667 0.577778
+ 22.9194444 0.594239
+ 22.9222222 0.606584
+ 22.9250000 0.645679
+ 22.9277778 0.690947
+ 22.9305556 0.732099
+ 22.9333333 0.756790
+ 22.9361111 0.734156
+ 22.9388889 0.690947
+ 22.9416667 0.592181
+ 22.9444444 0.487243
+ 22.9472222 0.404938
+ 22.9500000 0.349383
+ 22.9527778 0.320576
+ 22.9555556 0.314403
+ 22.9583333 0.324691
+ 22.9611111 0.345267
+ 22.9638889 0.359671
+ 22.9666667 0.378189
+ 22.9694444 0.386420
+ 22.9722222 0.382305
+ 22.9750000 0.378189
+ 22.9777778 0.376132
+ 22.9805556 0.372016
+ 22.9833333 0.374074
+ 22.9861111 0.386420
+ 22.9888889 0.400823
+ 22.9916667 0.413169
+ 22.9944444 0.429630
+ 22.9972222 0.429630
+ 23.0000000 0.429630
+ 23.0027778 0.417284
+ 23.0055556 0.421399
+ 23.0083333 0.419342
+ 23.0111111 0.404938
+ 23.0138889 0.398765
+ 23.0166667 0.394650
+ 23.0194444 0.398765
+ 23.0222222 0.406996
+ 23.0250000 0.425514
+ 23.0277778 0.444033
+ 23.0305556 0.458436
+ 23.0333333 0.468724
+ 23.0361111 0.476955
+ 23.0388889 0.474897
+ 23.0416667 0.479012
+ 23.0444444 0.481070
+ 23.0472222 0.481070
+ 23.0500000 0.483128
+ 23.0527778 0.481070
+ 23.0555556 0.479012
+ 23.0583333 0.481070
+ 23.0611111 0.479012
+ 23.0638889 0.474897
+ 23.0666667 0.470782
+ 23.0694444 0.466667
+ 23.0722222 0.462551
+ 23.0750000 0.462551
+ 23.0777778 0.462551
+ 23.0805556 0.466667
+ 23.0833333 0.474897
+ 23.0861111 0.483128
+ 23.0888889 0.485185
+ 23.0916667 0.476955
+ 23.0944444 0.472840
+ 23.0972222 0.460494
+ 23.1000000 0.462551
+ 23.1027778 0.462551
+ 23.1055556 0.472840
+ 23.1083333 0.489300
+ 23.1111111 0.499588
+ 23.1138889 0.503704
+ 23.1166667 0.495473
+ 23.1194444 0.487243
+ 23.1222222 0.470782
+ 23.1250000 0.456379
+ 23.1277778 0.460494
+ 23.1305556 0.468724
+ 23.1333333 0.481070
+ 23.1361111 0.495473
+ 23.1388889 0.503704
+ 23.1416667 0.507819
+ 23.1444444 0.513992
+ 23.1472222 0.516049
+ 23.1500000 0.524280
+ 23.1527778 0.530453
+ 23.1555556 0.530453
+ 23.1583333 0.536626
+ 23.1611111 0.534568
+ 23.1638889 0.528395
+ 23.1666667 0.528395
+ 23.1694444 0.524280
+ 23.1722222 0.524280
+ 23.1750000 0.524280
+ 23.1777778 0.530453
+ 23.1805556 0.538683
+ 23.1833333 0.555144
+ 23.1861111 0.565432
+ 23.1888889 0.586008
+ 23.1916667 0.594239
+ 23.1944444 0.592181
+ 23.1972222 0.575720
+ 23.2000000 0.563374
+ 23.2027778 0.557202
+ 23.2055556 0.559259
+ 23.2083333 0.571605
+ 23.2111111 0.581893
+ 23.2138889 0.592181
+ 23.2166667 0.594239
+ 23.2194444 0.590123
+ 23.2222222 0.581893
+ 23.2250000 0.577778
+ 23.2277778 0.579835
+ 23.2305556 0.586008
+ 23.2333333 0.588066
+ 23.2361111 0.586008
+ 23.2388889 0.571605
+ 23.2416667 0.557202
+ 23.2444444 0.542798
+ 23.2472222 0.536626
+ 23.2500000 0.530453
+ 23.2527778 0.532510
+ 23.2555556 0.526337
+ 23.2583333 0.526337
+ 23.2611111 0.524280
+ 23.2638889 0.526337
+ 23.2666667 0.528395
+ 23.2694444 0.528395
+ 23.2722222 0.526337
+ 23.2750000 0.532510
+ 23.2777778 0.518107
+ 23.2805556 0.507819
+ 23.2833333 0.487243
+ 23.2861111 0.472840
+ 23.2888889 0.456379
+ 23.2916667 0.450206
+ 23.2944444 0.441975
+ 23.2972222 0.450206
+ 23.3000000 0.456379
+ 23.3027778 0.468724
+ 23.3055556 0.472840
+ 23.3083333 0.485185
+ 23.3111111 0.489300
+ 23.3138889 0.489300
+ 23.3166667 0.491358
+ 23.3194444 0.489300
+ 23.3222222 0.485185
+ 23.3250000 0.476955
+ 23.3277778 0.464609
+ 23.3305556 0.458436
+ 23.3333333 0.446091
+ 23.3361111 0.441975
+ 23.3388889 0.433745
+ 23.3416667 0.441975
+ 23.3444444 0.456379
+ 23.3472222 0.470782
+ 23.3500000 0.470782
+ 23.3527778 0.481070
+ 23.3555556 0.472840
+ 23.3583333 0.470782
+ 23.3611111 0.466667
+ 23.3638889 0.464609
+ 23.3666667 0.468724
+ 23.3694444 0.464609
+ 23.3722222 0.464609
+ 23.3750000 0.458436
+ 23.3777778 0.454321
+ 23.3805556 0.460494
+ 23.3833333 0.464609
+ 23.3861111 0.470782
+ 23.3888889 0.479012
+ 23.3916667 0.487243
+ 23.3944444 0.485185
+ 23.3972222 0.479012
+ 23.4000000 0.474897
+ 23.4027778 0.468724
+ 23.4055556 0.464609
+ 23.4083333 0.466667
+ 23.4111111 0.472840
+ 23.4138889 0.474897
+ 23.4166667 0.479012
+ 23.4194444 0.476955
+ 23.4222222 0.472840
+ 23.4250000 0.466667
+ 23.4277778 0.464609
+ 23.4305556 0.458436
+ 23.4333333 0.462551
+ 23.4361111 0.460494
+ 23.4388889 0.470782
+ 23.4416667 0.472840
+ 23.4444444 0.476955
+ 23.4472222 0.474897
+ 23.4500000 0.468724
+ 23.4527778 0.466667
+ 23.4555556 0.470782
+ 23.4583333 0.474897
+ 23.4611111 0.476955
+ 23.4638889 0.476955
+ 23.4666667 0.476955
+ 23.4694444 0.474897
+ 23.4722222 0.470782
+ 23.4750000 0.470782
+ 23.4777778 0.472840
+ 23.4805556 0.472840
+ 23.4833333 0.472840
+ 23.4861111 0.476955
+ 23.4888889 0.466667
+ 23.4916667 0.458436
+ 23.4944444 0.456379
+ 23.4972222 0.454321
+ 23.5000000 0.460494
+ 23.5027778 0.468724
+ 23.5055556 0.470782
+ 23.5083333 0.481070
+ 23.5111111 0.472840
+ 23.5138889 0.464609
+ 23.5166667 0.464609
+ 23.5194444 0.466667
+ 23.5222222 0.462551
+ 23.5250000 0.458436
+ 23.5277778 0.464609
+ 23.5305556 0.458436
+ 23.5333333 0.458436
+ 23.5361111 0.456379
+ 23.5388889 0.456379
+ 23.5416667 0.462551
+ 23.5444444 0.468724
+ 23.5472222 0.472840
+ 23.5500000 0.474897
+ 23.5527778 0.470782
+ 23.5555556 0.472840
+ 23.5583333 0.466667
+ 23.5611111 0.466667
+ 23.5638889 0.460494
+ 23.5666667 0.460494
+ 23.5694444 0.456379
+ 23.5722222 0.464609
+ 23.5750000 0.466667
+ 23.5777778 0.472840
+ 23.5805556 0.479012
+ 23.5833333 0.470782
+ 23.5861111 0.468724
+ 23.5888889 0.464609
+ 23.5916667 0.462551
+ 23.5944444 0.460494
+ 23.5972222 0.460494
+ 23.6000000 0.460494
+ 23.6027778 0.462551
+ 23.6055556 0.460494
+ 23.6083333 0.458436
+ 23.6111111 0.456379
+ 23.6138889 0.464609
+ 23.6166667 0.468724
+ 23.6194444 0.472840
+ 23.6222222 0.476955
+ 23.6250000 0.476955
+ 23.6277778 0.476955
+ 23.6305556 0.474897
+ 23.6333333 0.481070
+ 23.6361111 0.483128
+ 23.6388889 0.487243
+ 23.6416667 0.476955
+ 23.6444444 0.466667
+ 23.6472222 0.456379
+ 23.6500000 0.446091
+ 23.6527778 0.439918
+ 23.6555556 0.444033
+ 23.6583333 0.446091
+ 23.6611111 0.452263
+ 23.6638889 0.448148
+ 23.6666667 0.458436
+ 23.6694444 0.460494
+ 23.6722222 0.474897
+ 23.6750000 0.481070
+ 23.6777778 0.481070
+ 23.6805556 0.487243
+ 23.6833333 0.485185
+ 23.6861111 0.479012
+ 23.6888889 0.472840
+ 23.6916667 0.464609
+ 23.6944444 0.458436
+ 23.6972222 0.441975
+ 23.7000000 0.444033
+ 23.7027778 0.439918
+ 23.7055556 0.452263
+ 23.7083333 0.464609
+ 23.7111111 0.474897
+ 23.7138889 0.483128
+ 23.7166667 0.487243
+ 23.7194444 0.491358
+ 23.7222222 0.489300
+ 23.7250000 0.487243
+ 23.7277778 0.474897
+ 23.7305556 0.462551
+ 23.7333333 0.450206
+ 23.7361111 0.444033
+ 23.7388889 0.446091
+ 23.7416667 0.450206
+ 23.7444444 0.450206
+ 23.7472222 0.456379
+ 23.7500000 0.462551
+ 23.7527778 0.470782
+ 23.7555556 0.464609
+ 23.7583333 0.472840
+ 23.7611111 0.476955
+ 23.7638889 0.487243
+ 23.7666667 0.497531
+ 23.7694444 0.501646
+ 23.7722222 0.495473
+ 23.7750000 0.476955
+ 23.7777778 0.460494
+ 23.7805556 0.452263
+ 23.7833333 0.452263
+ 23.7861111 0.456379
+ 23.7888889 0.464609
+ 23.7916667 0.464609
+ 23.7944444 0.468724
+ 23.7972222 0.468724
+ 23.8000000 0.472840
+ 23.8027778 0.479012
+ 23.8055556 0.483128
+ 23.8083333 0.483128
+ 23.8111111 0.479012
+ 23.8138889 0.470782
+ 23.8166667 0.460494
+ 23.8194444 0.460494
+ 23.8222222 0.460494
+ 23.8250000 0.458436
+ 23.8277778 0.470782
+ 23.8305556 0.476955
+ 23.8333333 0.483128
+ 23.8361111 0.481070
+ 23.8388889 0.485185
+ 23.8416667 0.479012
+ 23.8444444 0.476955
+ 23.8472222 0.470782
+ 23.8500000 0.468724
+ 23.8527778 0.468724
+ 23.8555556 0.464609
+ 23.8583333 0.462551
+ 23.8611111 0.470782
+ 23.8638889 0.470782
+ 23.8666667 0.479012
+ 23.8694444 0.483128
+ 23.8722222 0.476955
+ 23.8750000 0.470782
+ 23.8777778 0.460494
+ 23.8805556 0.464609
+ 23.8833333 0.462551
+ 23.8861111 0.456379
+ 23.8888889 0.462551
+ 23.8916667 0.464609
+ 23.8944444 0.460494
+ 23.8972222 0.466667
+ 23.9000000 0.466667
+ 23.9027778 0.470782
+ 23.9055556 0.474897
+ 23.9083333 0.474897
+ 23.9111111 0.474897
+ 23.9138889 0.476955
+ 23.9166667 0.470782
+ 23.9194444 0.472840
+ 23.9222222 0.468724
+ 23.9250000 0.468724
+ 23.9277778 0.470782
+ 23.9305556 0.470782
+ 23.9333333 0.474897
+ 23.9361111 0.474897
+ 23.9388889 0.479012
+ 23.9416667 0.474897
+ 23.9444444 0.470782
+ 23.9472222 0.470782
+ 23.9500000 0.464609
+ 23.9527778 0.466667
+ 23.9555556 0.464609
+ 23.9583333 0.464609
+ 23.9611111 0.462551
+ 23.9638889 0.464609
+ 23.9666667 0.468724
+ 23.9694444 0.474897
+ 23.9722222 0.479012
+ 23.9750000 0.481070
+ 23.9777778 0.476955
+ 23.9805556 0.474897
+ 23.9833333 0.470782
+ 23.9861111 0.468724
+ 23.9888889 0.462551
+ 23.9916667 0.460494
+ 23.9944444 0.462551
+ 23.9972222 0.462551
+ 24.0000000 0.464609
+ 24.0027778 0.466667
+ 24.0055556 0.474897
+ 24.0083333 0.474897
+ 24.0111111 0.470782
+ 24.0138889 0.470782
+ 24.0166667 0.470782
+ 24.0194444 0.468724
+ 24.0222222 0.464609
+ 24.0250000 0.464609
+ 24.0277778 0.472840
+ 24.0305556 0.474897
+ 24.0333333 0.476955
+ 24.0361111 0.481070
+ 24.0388889 0.479012
+ 24.0416667 0.479012
+ 24.0444444 0.472840
+ 24.0472222 0.472840
+ 24.0500000 0.466667
+ 24.0527778 0.468724
+ 24.0555556 0.464609
+ 24.0583333 0.464609
+ 24.0611111 0.472840
+ 24.0638889 0.481070
+ 24.0666667 0.489300
+ 24.0694444 0.489300
+ 24.0722222 0.489300
+ 24.0750000 0.485185
+ 24.0777778 0.479012
+ 24.0805556 0.476955
+ 24.0833333 0.466667
+ 24.0861111 0.464609
+ 24.0888889 0.462551
+ 24.0916667 0.466667
+ 24.0944444 0.462551
+ 24.0972222 0.464609
+ 24.1000000 0.466667
+ 24.1027778 0.470782
+ 24.1055556 0.476955
+ 24.1083333 0.483128
+ 24.1111111 0.483128
+ 24.1138889 0.487243
+ 24.1166667 0.485185
+ 24.1194444 0.476955
+ 24.1222222 0.476955
+ 24.1250000 0.470782
+ 24.1277778 0.476955
+ 24.1305556 0.474897
+ 24.1333333 0.476955
+ 24.1361111 0.472840
+ 24.1388889 0.472840
+ 24.1416667 0.472840
+ 24.1444444 0.472840
+ 24.1472222 0.479012
+ 24.1500000 0.483128
+ 24.1527778 0.485185
+ 24.1555556 0.481070
+ 24.1583333 0.481070
+ 24.1611111 0.474897
+ 24.1638889 0.470782
+ 24.1666667 0.474897
+ 24.1694444 0.472840
+ 24.1722222 0.479012
+ 24.1750000 0.472840
+ 24.1777778 0.476955
+ 24.1805556 0.479012
+ 24.1833333 0.479012
+ 24.1861111 0.481070
+ 24.1888889 0.485185
+ 24.1916667 0.489300
+ 24.1944444 0.493416
+ 24.1972222 0.499588
+ 24.2000000 0.495473
+ 24.2027778 0.485185
+ 24.2055556 0.474897
+ 24.2083333 0.472840
+ 24.2111111 0.464609
+ 24.2138889 0.462551
+ 24.2166667 0.462551
+ 24.2194444 0.470782
+ 24.2222222 0.470782
+ 24.2250000 0.470782
+ 24.2277778 0.476955
+ 24.2305556 0.481070
+ 24.2333333 0.479012
+ 24.2361111 0.483128
+ 24.2388889 0.485185
+ 24.2416667 0.487243
+ 24.2444444 0.487243
+ 24.2472222 0.483128
+ 24.2500000 0.479012
+ 24.2527778 0.470782
+ 24.2555556 0.462551
+ 24.2583333 0.458436
+ 24.2611111 0.458436
+ 24.2638889 0.462551
+ 24.2666667 0.472840
+ 24.2694444 0.476955
+ 24.2722222 0.476955
+ 24.2750000 0.472840
+ 24.2777778 0.474897
+ 24.2805556 0.479012
+ 24.2833333 0.487243
+ 24.2861111 0.491358
+ 24.2888889 0.499588
+ 24.2916667 0.493416
+ 24.2944444 0.487243
+ 24.2972222 0.474897
+ 24.3000000 0.466667
+ 24.3027778 0.456379
+ 24.3055556 0.460494
+ 24.3083333 0.464609
+ 24.3111111 0.474897
+ 24.3138889 0.483128
+ 24.3166667 0.483128
+ 24.3194444 0.485185
+ 24.3222222 0.485185
+ 24.3250000 0.485185
+ 24.3277778 0.479012
+ 24.3305556 0.485185
+ 24.3333333 0.485185
+ 24.3361111 0.485185
+ 24.3388889 0.483128
+ 24.3416667 0.485185
+ 24.3444444 0.474897
+ 24.3472222 0.479012
+ 24.3500000 0.479012
+ 24.3527778 0.481070
+ 24.3555556 0.479012
+ 24.3583333 0.476955
+ 24.3611111 0.481070
+ 24.3638889 0.476955
+ 24.3666667 0.476955
+ 24.3694444 0.487243
+ 24.3722222 0.491358
+ 24.3750000 0.493416
+ 24.3777778 0.491358
+ 24.3805556 0.493416
+ 24.3833333 0.489300
+ 24.3861111 0.483128
+ 24.3888889 0.479012
+ 24.3916667 0.470782
+ 24.3944444 0.468724
+ 24.3972222 0.476955
+ 24.4000000 0.474897
+ 24.4027778 0.476955
+ 24.4055556 0.474897
+ 24.4083333 0.466667
+ 24.4111111 0.464609
+ 24.4138889 0.466667
+ 24.4166667 0.472840
+ 24.4194444 0.476955
+ 24.4222222 0.483128
+ 24.4250000 0.491358
+ 24.4277778 0.489300
+ 24.4305556 0.495473
+ 24.4333333 0.485185
+ 24.4361111 0.487243
+ 24.4388889 0.479012
+ 24.4416667 0.483128
+ 24.4444444 0.485185
+ 24.4472222 0.489300
+ 24.4500000 0.487243
+ 24.4527778 0.479012
+ 24.4555556 0.474897
+ 24.4583333 0.470782
+ 24.4611111 0.470782
+ 24.4638889 0.474897
+ 24.4666667 0.479012
+ 24.4694444 0.483128
+ 24.4722222 0.489300
+ 24.4750000 0.495473
+ 24.4777778 0.495473
+ 24.4805556 0.497531
+ 24.4833333 0.495473
+ 24.4861111 0.487243
+ 24.4888889 0.476955
+ 24.4916667 0.468724
+ 24.4944444 0.468724
+ 24.4972222 0.472840
+ 24.5000000 0.472840
+ 24.5027778 0.474897
+ 24.5055556 0.472840
+ 24.5083333 0.476955
+ 24.5111111 0.472840
+ 24.5138889 0.481070
+ 24.5166667 0.483128
+ 24.5194444 0.487243
+ 24.5222222 0.485185
+ 24.5250000 0.481070
+ 24.5277778 0.481070
+ 24.5305556 0.485185
+ 24.5333333 0.479012
+ 24.5361111 0.476955
+ 24.5388889 0.485185
+ 24.5416667 0.481070
+ 24.5444444 0.481070
+ 24.5472222 0.479012
+ 24.5500000 0.481070
+ 24.5527778 0.483128
+ 24.5555556 0.481070
+ 24.5583333 0.483128
+ 24.5611111 0.483128
+ 24.5638889 0.474897
+ 24.5666667 0.476955
+ 24.5694444 0.483128
+ 24.5722222 0.487243
+ 24.5750000 0.485185
+ 24.5777778 0.487243
+ 24.5805556 0.489300
+ 24.5833333 0.487243
+ 24.5861111 0.489300
+ 24.5888889 0.487243
+ 24.5916667 0.491358
+ 24.5944444 0.495473
+ 24.5972222 0.497531
+ 24.6000000 0.501646
+ 24.6027778 0.499588
+ 24.6055556 0.489300
+ 24.6083333 0.483128
+ 24.6111111 0.481070
+ 24.6138889 0.487243
+ 24.6166667 0.493416
+ 24.6194444 0.507819
+ 24.6222222 0.513992
+ 24.6250000 0.522222
+ 24.6277778 0.516049
+ 24.6305556 0.513992
+ 24.6333333 0.505761
+ 24.6361111 0.497531
+ 24.6388889 0.499588
+ 24.6416667 0.507819
+ 24.6444444 0.507819
+ 24.6472222 0.513992
+ 24.6500000 0.513992
+ 24.6527778 0.513992
+ 24.6555556 0.505761
+ 24.6583333 0.499588
+ 24.6611111 0.499588
+ 24.6638889 0.495473
+ 24.6666667 0.501646
+ 24.6694444 0.501646
+ 24.6722222 0.505761
+ 24.6750000 0.513992
+ 24.6777778 0.511934
+ 24.6805556 0.511934
+ 24.6833333 0.507819
+ 24.6861111 0.501646
+ 24.6888889 0.485185
+ 24.6916667 0.479012
+ 24.6944444 0.479012
+ 24.6972222 0.476955
+ 24.7000000 0.485185
+ 24.7027778 0.489300
+ 24.7055556 0.495473
+ 24.7083333 0.497531
+ 24.7111111 0.493416
+ 24.7138889 0.485185
+ 24.7166667 0.472840
+ 24.7194444 0.458436
+ 24.7222222 0.452263
+ 24.7250000 0.448148
+ 24.7277778 0.452263
+ 24.7305556 0.460494
+ 24.7333333 0.466667
+ 24.7361111 0.474897
+ 24.7388889 0.476955
+ 24.7416667 0.483128
+ 24.7444444 0.485185
+ 24.7472222 0.485185
+ 24.7500000 0.483128
+ 24.7527778 0.481070
+ 24.7555556 0.472840
+ 24.7583333 0.468724
+ 24.7611111 0.462551
+ 24.7638889 0.462551
+ 24.7666667 0.458436
+ 24.7694444 0.464609
+ 24.7722222 0.464609
+ 24.7750000 0.468724
+ 24.7777778 0.474897
+ 24.7805556 0.481070
+ 24.7833333 0.483128
+ 24.7861111 0.487243
+ 24.7888889 0.485185
+ 24.7916667 0.491358
+ 24.7944444 0.489300
+ 24.7972222 0.483128
+ 24.8000000 0.479012
+ 24.8027778 0.466667
+ 24.8055556 0.470782
+ 24.8083333 0.472840
+ 24.8111111 0.487243
+ 24.8138889 0.505761
+ 24.8166667 0.520165
+ 24.8194444 0.538683
+ 24.8222222 0.559259
+ 24.8250000 0.581893
+ 24.8277778 0.612757
+ 24.8305556 0.655967
+ 24.8333333 0.693004
+ 24.8361111 0.723868
+ 24.8388889 0.754733
+ 24.8416667 0.752675
+ 24.8444444 0.711523
+ 24.8472222 0.633333
+ 24.8500000 0.522222
+ 24.8527778 0.433745
+ 24.8555556 0.363786
+ 24.8583333 0.330864
+ 24.8611111 0.326749
+ 24.8638889 0.334979
+ 24.8666667 0.349383
+ 24.8694444 0.363786
+ 24.8722222 0.372016
+ 24.8750000 0.374074
+ 24.8777778 0.378189
+ 24.8805556 0.378189
+ 24.8833333 0.374074
+ 24.8861111 0.369959
+ 24.8888889 0.367901
+ 24.8916667 0.363786
+ 24.8944444 0.365844
+ 24.8972222 0.374074
+ 24.9000000 0.386420
+ 24.9027778 0.398765
+ 24.9055556 0.406996
+ 24.9083333 0.406996
+ 24.9111111 0.396708
+ 24.9138889 0.382305
+ 24.9166667 0.386420
+ 24.9194444 0.386420
+ 24.9222222 0.388477
+ 24.9250000 0.398765
+ 24.9277778 0.409053
+ 24.9305556 0.421399
+ 24.9333333 0.431687
+ 24.9361111 0.446091
+ 24.9388889 0.462551
+ 24.9416667 0.479012
+ 24.9444444 0.476955
+ 24.9472222 0.483128
+ 24.9500000 0.479012
+ 24.9527778 0.481070
+ 24.9555556 0.476955
+ 24.9583333 0.479012
+ 24.9611111 0.479012
+ 24.9638889 0.472840
+ 24.9666667 0.470782
+ 24.9694444 0.460494
+ 24.9722222 0.464609
+ 24.9750000 0.468724
+ 24.9777778 0.472840
+ 24.9805556 0.481070
+ 24.9833333 0.481070
+ 24.9861111 0.479012
+ 24.9888889 0.476955
+ 24.9916667 0.464609
+ 24.9944444 0.456379
+ 24.9972222 0.460494
+ 25.0000000 0.468724
+ 25.0027778 0.470782
+ 25.0055556 0.485185
+ 25.0083333 0.491358
+ 25.0111111 0.491358
+ 25.0138889 0.491358
+ 25.0166667 0.491358
+ 25.0194444 0.487243
+ 25.0222222 0.476955
+ 25.0250000 0.474897
+ 25.0277778 0.474897
+ 25.0305556 0.481070
+ 25.0333333 0.483128
+ 25.0361111 0.485185
+ 25.0388889 0.487243
+ 25.0416667 0.491358
+ 25.0444444 0.487243
+ 25.0472222 0.491358
+ 25.0500000 0.491358
+ 25.0527778 0.495473
+ 25.0555556 0.503704
+ 25.0583333 0.505761
+ 25.0611111 0.507819
+ 25.0638889 0.509877
+ 25.0666667 0.509877
+ 25.0694444 0.505761
+ 25.0722222 0.509877
+ 25.0750000 0.507819
+ 25.0777778 0.505761
+ 25.0805556 0.505761
+ 25.0833333 0.503704
+ 25.0861111 0.499588
+ 25.0888889 0.499588
+ 25.0916667 0.507819
+ 25.0944444 0.518107
+ 25.0972222 0.530453
+ 25.1000000 0.538683
+ 25.1027778 0.544856
+ 25.1055556 0.553086
+ 25.1083333 0.548971
+ 25.1111111 0.546914
+ 25.1138889 0.551029
+ 25.1166667 0.551029
+ 25.1194444 0.555144
+ 25.1222222 0.557202
+ 25.1250000 0.557202
+ 25.1277778 0.561317
+ 25.1305556 0.561317
+ 25.1333333 0.563374
+ 25.1361111 0.569547
+ 25.1388889 0.571605
+ 25.1416667 0.577778
+ 25.1444444 0.575720
+ 25.1472222 0.569547
+ 25.1500000 0.575720
+ 25.1527778 0.575720
+ 25.1555556 0.579835
+ 25.1583333 0.575720
+ 25.1611111 0.573663
+ 25.1638889 0.569547
+ 25.1666667 0.567490
+ 25.1694444 0.563374
+ 25.1722222 0.565432
+ 25.1750000 0.563374
+ 25.1777778 0.555144
+ 25.1805556 0.559259
+ 25.1833333 0.553086
+ 25.1861111 0.553086
+ 25.1888889 0.546914
+ 25.1916667 0.540741
+ 25.1944444 0.532510
+ 25.1972222 0.520165
+ 25.2000000 0.518107
+ 25.2027778 0.522222
+ 25.2055556 0.524280
+ 25.2083333 0.530453
+ 25.2111111 0.528395
+ 25.2138889 0.526337
+ 25.2166667 0.520165
+ 25.2194444 0.511934
+ 25.2222222 0.497531
+ 25.2250000 0.493416
+ 25.2277778 0.487243
+ 25.2305556 0.489300
+ 25.2333333 0.487243
+ 25.2361111 0.489300
+ 25.2388889 0.487243
+ 25.2416667 0.497531
+ 25.2444444 0.491358
+ 25.2472222 0.491358
+ 25.2500000 0.491358
+ 25.2527778 0.485185
+ 25.2555556 0.483128
+ 25.2583333 0.493416
+ 25.2611111 0.489300
+ 25.2638889 0.489300
+ 25.2666667 0.491358
+ 25.2694444 0.495473
+ 25.2722222 0.493416
+ 25.2750000 0.491358
+ 25.2777778 0.483128
+ 25.2805556 0.479012
+ 25.2833333 0.487243
+ 25.2861111 0.493416
+ 25.2888889 0.495473
+ 25.2916667 0.491358
+ 25.2944444 0.487243
+ 25.2972222 0.483128
+ 25.3000000 0.479012
+ 25.3027778 0.470782
+ 25.3055556 0.476955
+ 25.3083333 0.485185
+ 25.3111111 0.489300
+ 25.3138889 0.493416
+ 25.3166667 0.491358
+ 25.3194444 0.491358
+ 25.3222222 0.489300
+ 25.3250000 0.485185
+ 25.3277778 0.487243
+ 25.3305556 0.485185
+ 25.3333333 0.485185
+ 25.3361111 0.491358
+ 25.3388889 0.499588
+ 25.3416667 0.495473
+ 25.3444444 0.495473
+ 25.3472222 0.499588
+ 25.3500000 0.501646
+ 25.3527778 0.499588
+ 25.3555556 0.497531
+ 25.3583333 0.497531
+ 25.3611111 0.493416
+ 25.3638889 0.493416
+ 25.3666667 0.491358
+ 25.3694444 0.485185
+ 25.3722222 0.485185
+ 25.3750000 0.487243
+ 25.3777778 0.493416
+ 25.3805556 0.501646
+ 25.3833333 0.509877
+ 25.3861111 0.509877
+ 25.3888889 0.497531
+ 25.3916667 0.483128
+ 25.3944444 0.479012
+ 25.3972222 0.474897
+ 25.4000000 0.483128
+ 25.4027778 0.493416
+ 25.4055556 0.501646
+ 25.4083333 0.505761
+ 25.4111111 0.499588
+ 25.4138889 0.489300
+ 25.4166667 0.481070
+ 25.4194444 0.479012
+ 25.4222222 0.476955
+ 25.4250000 0.476955
+ 25.4277778 0.483128
+ 25.4305556 0.485185
+ 25.4333333 0.487243
+ 25.4361111 0.489300
+ 25.4388889 0.491358
+ 25.4416667 0.489300
+ 25.4444444 0.489300
+ 25.4472222 0.489300
+ 25.4500000 0.485185
+ 25.4527778 0.489300
+ 25.4555556 0.479012
+ 25.4583333 0.476955
+ 25.4611111 0.472840
+ 25.4638889 0.474897
+ 25.4666667 0.479012
+ 25.4694444 0.485185
+ 25.4722222 0.489300
+ 25.4750000 0.483128
+ 25.4777778 0.479012
+ 25.4805556 0.479012
+ 25.4833333 0.481070
+ 25.4861111 0.485185
+ 25.4888889 0.481070
+ 25.4916667 0.483128
+ 25.4944444 0.479012
+ 25.4972222 0.474897
+ 25.5000000 0.466667
+ 25.5027778 0.464609
+ 25.5055556 0.464609
+ 25.5083333 0.464609
+ 25.5111111 0.472840
+ 25.5138889 0.479012
+ 25.5166667 0.483128
+ 25.5194444 0.487243
+ 25.5222222 0.487243
+ 25.5250000 0.481070
+ 25.5277778 0.485185
+ 25.5305556 0.483128
+ 25.5333333 0.481070
+ 25.5361111 0.476955
+ 25.5388889 0.474897
+ 25.5416667 0.476955
+ 25.5444444 0.476955
+ 25.5472222 0.483128
+ 25.5500000 0.489300
+ 25.5527778 0.491358
+ 25.5555556 0.491358
+ 25.5583333 0.479012
+ 25.5611111 0.474897
+ 25.5638889 0.466667
+ 25.5666667 0.468724
+ 25.5694444 0.472840
+ 25.5722222 0.472840
+ 25.5750000 0.476955
+ 25.5777778 0.472840
+ 25.5805556 0.476955
+ 25.5833333 0.479012
+ 25.5861111 0.485185
+ 25.5888889 0.487243
+ 25.5916667 0.487243
+ 25.5944444 0.491358
+ 25.5972222 0.485185
+ 25.6000000 0.481070
+ 25.6027778 0.472840
+ 25.6055556 0.470782
+ 25.6083333 0.468724
+ 25.6111111 0.470782
+ 25.6138889 0.472840
+ 25.6166667 0.479012
+ 25.6194444 0.485185
+ 25.6222222 0.485185
+ 25.6250000 0.485185
+ 25.6277778 0.487243
+ 25.6305556 0.483128
+ 25.6333333 0.476955
+ 25.6361111 0.470782
+ 25.6388889 0.474897
+ 25.6416667 0.470782
+ 25.6444444 0.470782
+ 25.6472222 0.472840
+ 25.6500000 0.474897
+ 25.6527778 0.472840
+ 25.6555556 0.468724
+ 25.6583333 0.472840
+ 25.6611111 0.479012
+ 25.6638889 0.483128
+ 25.6666667 0.491358
+ 25.6694444 0.493416
+ 25.6722222 0.491358
+ 25.6750000 0.487243
+ 25.6777778 0.476955
+ 25.6805556 0.466667
+ 25.6833333 0.464609
+ 25.6861111 0.462551
+ 25.6888889 0.466667
+ 25.6916667 0.464609
+ 25.6944444 0.468724
+ 25.6972222 0.474897
+ 25.7000000 0.479012
+ 25.7027778 0.474897
+ 25.7055556 0.483128
+ 25.7083333 0.489300
+ 25.7111111 0.499588
+ 25.7138889 0.511934
+ 25.7166667 0.507819
+ 25.7194444 0.493416
+ 25.7222222 0.479012
+ 25.7250000 0.464609
+ 25.7277778 0.458436
+ 25.7305556 0.454321
+ 25.7333333 0.458436
+ 25.7361111 0.458436
+ 25.7388889 0.466667
+ 25.7416667 0.474897
+ 25.7444444 0.479012
+ 25.7472222 0.481070
+ 25.7500000 0.476955
+ 25.7527778 0.474897
+ 25.7555556 0.470782
+ 25.7583333 0.470782
+ 25.7611111 0.476955
+ 25.7638889 0.479012
+ 25.7666667 0.485185
+ 25.7694444 0.491358
+ 25.7722222 0.507819
+ 25.7750000 0.509877
+ 25.7777778 0.509877
+ 25.7805556 0.497531
+ 25.7833333 0.483128
+ 25.7861111 0.462551
+ 25.7888889 0.450206
+ 25.7916667 0.446091
+ 25.7944444 0.446091
+ 25.7972222 0.450206
+ 25.8000000 0.464609
+ 25.8027778 0.479012
+ 25.8055556 0.491358
+ 25.8083333 0.495473
+ 25.8111111 0.493416
+ 25.8138889 0.495473
+ 25.8166667 0.487243
+ 25.8194444 0.487243
+ 25.8222222 0.472840
+ 25.8250000 0.462551
+ 25.8277778 0.458436
+ 25.8305556 0.456379
+ 25.8333333 0.464609
+ 25.8361111 0.476955
+ 25.8388889 0.485185
+ 25.8416667 0.493416
+ 25.8444444 0.491358
+ 25.8472222 0.487243
+ 25.8500000 0.479012
+ 25.8527778 0.470782
+ 25.8555556 0.464609
+ 25.8583333 0.460494
+ 25.8611111 0.466667
+ 25.8638889 0.466667
+ 25.8666667 0.472840
+ 25.8694444 0.481070
+ 25.8722222 0.483128
+ 25.8750000 0.489300
+ 25.8777778 0.485185
+ 25.8805556 0.483128
+ 25.8833333 0.474897
+ 25.8861111 0.466667
+ 25.8888889 0.460494
+ 25.8916667 0.462551
+ 25.8944444 0.462551
+ 25.8972222 0.472840
+ 25.9000000 0.476955
+ 25.9027778 0.483128
+ 25.9055556 0.485185
+ 25.9083333 0.487243
+ 25.9111111 0.491358
+ 25.9138889 0.495473
+ 25.9166667 0.487243
+ 25.9194444 0.472840
+ 25.9222222 0.458436
+ 25.9250000 0.452263
+ 25.9277778 0.454321
+ 25.9305556 0.458436
+ 25.9333333 0.472840
+ 25.9361111 0.483128
+ 25.9388889 0.489300
+ 25.9416667 0.491358
+ 25.9444444 0.485185
+ 25.9472222 0.489300
+ 25.9500000 0.487243
+ 25.9527778 0.485185
+ 25.9555556 0.476955
+ 25.9583333 0.474897
+ 25.9611111 0.466667
+ 25.9638889 0.466667
+ 25.9666667 0.474897
+ 25.9694444 0.464609
+ 25.9722222 0.464609
+ 25.9750000 0.460494
+ 25.9777778 0.458436
+ 25.9805556 0.466667
+ 25.9833333 0.468724
+ 25.9861111 0.470782
+ 25.9888889 0.474897
+ 25.9916667 0.474897
+ 25.9944444 0.472840
+ 25.9972222 0.472840
+ 26.0000000 0.476955
+ 26.0027778 0.481070
+ 26.0055556 0.491358
+ 26.0083333 0.491358
+ 26.0111111 0.493416
+ 26.0138889 0.489300
+ 26.0166667 0.481070
+ 26.0194444 0.468724
+ 26.0222222 0.456379
+ 26.0250000 0.456379
+ 26.0277778 0.454321
+ 26.0305556 0.460494
+ 26.0333333 0.468724
+ 26.0361111 0.476955
+ 26.0388889 0.487243
+ 26.0416667 0.493416
+ 26.0444444 0.489300
+ 26.0472222 0.489300
+ 26.0500000 0.481070
+ 26.0527778 0.470782
+ 26.0555556 0.464609
+ 26.0583333 0.460494
+ 26.0611111 0.466667
+ 26.0638889 0.466667
+ 26.0666667 0.476955
+ 26.0694444 0.481070
+ 26.0722222 0.481070
+ 26.0750000 0.483128
+ 26.0777778 0.479012
+ 26.0805556 0.476955
+ 26.0833333 0.470782
+ 26.0861111 0.470782
+ 26.0888889 0.474897
+ 26.0916667 0.474897
+ 26.0944444 0.476955
+ 26.0972222 0.476955
+ 26.1000000 0.472840
+ 26.1027778 0.474897
+ 26.1055556 0.474897
+ 26.1083333 0.481070
+ 26.1111111 0.479012
+ 26.1138889 0.472840
+ 26.1166667 0.466667
+ 26.1194444 0.470782
+ 26.1222222 0.468724
+ 26.1250000 0.470782
+ 26.1277778 0.472840
+ 26.1305556 0.476955
+ 26.1333333 0.476955
+ 26.1361111 0.479012
+ 26.1388889 0.481070
+ 26.1416667 0.483128
+ 26.1444444 0.481070
+ 26.1472222 0.485185
+ 26.1500000 0.481070
+ 26.1527778 0.476955
+ 26.1555556 0.472840
+ 26.1583333 0.468724
+ 26.1611111 0.468724
+ 26.1638889 0.468724
+ 26.1666667 0.474897
+ 26.1694444 0.479012
+ 26.1722222 0.483128
+ 26.1750000 0.485185
+ 26.1777778 0.479012
+ 26.1805556 0.468724
+ 26.1833333 0.462551
+ 26.1861111 0.460494
+ 26.1888889 0.460494
+ 26.1916667 0.464609
+ 26.1944444 0.468724
+ 26.1972222 0.474897
+ 26.2000000 0.470782
+ 26.2027778 0.470782
+ 26.2055556 0.479012
+ 26.2083333 0.476955
+ 26.2111111 0.476955
+ 26.2138889 0.479012
+ 26.2166667 0.481070
+ 26.2194444 0.476955
+ 26.2222222 0.474897
+ 26.2250000 0.468724
+ 26.2277778 0.468724
+ 26.2305556 0.470782
+ 26.2333333 0.472840
+ 26.2361111 0.468724
+ 26.2388889 0.468724
+ 26.2416667 0.470782
+ 26.2444444 0.466667
+ 26.2472222 0.472840
+ 26.2500000 0.485185
+ 26.2527778 0.487243
+ 26.2555556 0.487243
+ 26.2583333 0.485185
+ 26.2611111 0.474897
+ 26.2638889 0.468724
+ 26.2666667 0.468724
+ 26.2694444 0.472840
+ 26.2722222 0.479012
+ 26.2750000 0.485185
+ 26.2777778 0.479012
+ 26.2805556 0.479012
+ 26.2833333 0.474897
+ 26.2861111 0.470782
+ 26.2888889 0.464609
+ 26.2916667 0.468724
+ 26.2944444 0.472840
+ 26.2972222 0.472840
+ 26.3000000 0.481070
+ 26.3027778 0.481070
+ 26.3055556 0.487243
+ 26.3083333 0.485185
+ 26.3111111 0.483128
+ 26.3138889 0.481070
+ 26.3166667 0.479012
+ 26.3194444 0.476955
+ 26.3222222 0.472840
+ 26.3250000 0.479012
+ 26.3277778 0.481070
+ 26.3305556 0.479012
+ 26.3333333 0.479012
+ 26.3361111 0.479012
+ 26.3388889 0.481070
+ 26.3416667 0.476955
+ 26.3444444 0.472840
+ 26.3472222 0.468724
+ 26.3500000 0.468724
+ 26.3527778 0.464609
+ 26.3555556 0.466667
+ 26.3583333 0.468724
+ 26.3611111 0.474897
+ 26.3638889 0.483128
+ 26.3666667 0.487243
+ 26.3694444 0.489300
+ 26.3722222 0.485185
+ 26.3750000 0.483128
+ 26.3777778 0.474897
+ 26.3805556 0.466667
+ 26.3833333 0.466667
+ 26.3861111 0.462551
+ 26.3888889 0.468724
+ 26.3916667 0.470782
+ 26.3944444 0.476955
+ 26.3972222 0.481070
+ 26.4000000 0.485185
+ 26.4027778 0.487243
+ 26.4055556 0.487243
+ 26.4083333 0.491358
+ 26.4111111 0.481070
+ 26.4138889 0.481070
+ 26.4166667 0.468724
+ 26.4194444 0.466667
+ 26.4222222 0.464609
+ 26.4250000 0.466667
+ 26.4277778 0.470782
+ 26.4305556 0.468724
+ 26.4333333 0.474897
+ 26.4361111 0.470782
+ 26.4388889 0.472840
+ 26.4416667 0.476955
+ 26.4444444 0.485185
+ 26.4472222 0.491358
+ 26.4500000 0.495473
+ 26.4527778 0.493416
+ 26.4555556 0.489300
+ 26.4583333 0.489300
+ 26.4611111 0.483128
+ 26.4638889 0.481070
+ 26.4666667 0.476955
+ 26.4694444 0.470782
+ 26.4722222 0.470782
+ 26.4750000 0.476955
+ 26.4777778 0.483128
+ 26.4805556 0.481070
+ 26.4833333 0.476955
+ 26.4861111 0.468724
+ 26.4888889 0.464609
+ 26.4916667 0.466667
+ 26.4944444 0.472840
+ 26.4972222 0.487243
+ 26.5000000 0.487243
+ 26.5027778 0.491358
+ 26.5055556 0.491358
+ 26.5083333 0.487243
+ 26.5111111 0.485185
+ 26.5138889 0.479012
+ 26.5166667 0.479012
+ 26.5194444 0.476955
+ 26.5222222 0.476955
+ 26.5250000 0.476955
+ 26.5277778 0.481070
+ 26.5305556 0.483128
+ 26.5333333 0.487243
+ 26.5361111 0.479012
+ 26.5388889 0.481070
+ 26.5416667 0.485185
+ 26.5444444 0.479012
+ 26.5472222 0.483128
+ 26.5500000 0.483128
+ 26.5527778 0.487243
+ 26.5555556 0.489300
+ 26.5583333 0.491358
+ 26.5611111 0.485185
+ 26.5638889 0.489300
+ 26.5666667 0.491358
+ 26.5694444 0.491358
+ 26.5722222 0.491358
+ 26.5750000 0.493416
+ 26.5777778 0.491358
+ 26.5805556 0.487243
+ 26.5833333 0.483128
+ 26.5861111 0.481070
+ 26.5888889 0.476955
+ 26.5916667 0.472840
+ 26.5944444 0.470782
+ 26.5972222 0.476955
+ 26.6000000 0.483128
+ 26.6027778 0.487243
+ 26.6055556 0.491358
+ 26.6083333 0.495473
+ 26.6111111 0.485185
+ 26.6138889 0.485185
+ 26.6166667 0.485185
+ 26.6194444 0.485185
+ 26.6222222 0.485185
+ 26.6250000 0.483128
+ 26.6277778 0.481070
+ 26.6305556 0.472840
+ 26.6333333 0.481070
+ 26.6361111 0.481070
+ 26.6388889 0.485185
+ 26.6416667 0.495473
+ 26.6444444 0.503704
+ 26.6472222 0.501646
+ 26.6500000 0.499588
+ 26.6527778 0.493416
+ 26.6555556 0.489300
+ 26.6583333 0.485185
+ 26.6611111 0.481070
+ 26.6638889 0.481070
+ 26.6666667 0.479012
+ 26.6694444 0.489300
+ 26.6722222 0.487243
+ 26.6750000 0.491358
+ 26.6777778 0.489300
+ 26.6805556 0.491358
+ 26.6833333 0.493416
+ 26.6861111 0.493416
+ 26.6888889 0.493416
+ 26.6916667 0.495473
+ 26.6944444 0.493416
+ 26.6972222 0.497531
+ 26.7000000 0.497531
+ 26.7027778 0.499588
+ 26.7055556 0.495473
+ 26.7083333 0.501646
+ 26.7111111 0.495473
+ 26.7138889 0.497531
+ 26.7166667 0.495473
+ 26.7194444 0.485185
+ 26.7222222 0.481070
+ 26.7250000 0.476955
+ 26.7277778 0.476955
+ 26.7305556 0.483128
+ 26.7333333 0.497531
+ 26.7361111 0.505761
+ 26.7388889 0.507819
+ 26.7416667 0.507819
+ 26.7444444 0.497531
+ 26.7472222 0.495473
+ 26.7500000 0.491358
+ 26.7527778 0.487243
+ 26.7555556 0.489300
+ 26.7583333 0.497531
+ 26.7611111 0.499588
+ 26.7638889 0.493416
+ 26.7666667 0.489300
+ 26.7694444 0.481070
+ 26.7722222 0.479012
+ 26.7750000 0.485185
+ 26.7777778 0.487243
+ 26.7805556 0.491358
+ 26.7833333 0.487243
+ 26.7861111 0.491358
+ 26.7888889 0.491358
+ 26.7916667 0.491358
+ 26.7944444 0.489300
+ 26.7972222 0.483128
+ 26.8000000 0.483128
+ 26.8027778 0.476955
+ 26.8055556 0.481070
+ 26.8083333 0.489300
+ 26.8111111 0.493416
+ 26.8138889 0.505761
+ 26.8166667 0.505761
+ 26.8194444 0.499588
+ 26.8222222 0.497531
+ 26.8250000 0.491358
+ 26.8277778 0.485185
+ 26.8305556 0.481070
+ 26.8333333 0.487243
+ 26.8361111 0.487243
+ 26.8388889 0.489300
+ 26.8416667 0.489300
+ 26.8444444 0.491358
+ 26.8472222 0.491358
+ 26.8500000 0.489300
+ 26.8527778 0.497531
+ 26.8555556 0.499588
+ 26.8583333 0.495473
+ 26.8611111 0.495473
+ 26.8638889 0.501646
+ 26.8666667 0.503704
+ 26.8694444 0.501646
+ 26.8722222 0.499588
+ 26.8750000 0.491358
+ 26.8777778 0.483128
+ 26.8805556 0.485185
+ 26.8833333 0.483128
+ 26.8861111 0.483128
+ 26.8888889 0.483128
+ 26.8916667 0.479012
+ 26.8944444 0.483128
+ 26.8972222 0.483128
+ 26.9000000 0.489300
+ 26.9027778 0.489300
+ 26.9055556 0.493416
+ 26.9083333 0.501646
+ 26.9111111 0.503704
+ 26.9138889 0.505761
+ 26.9166667 0.503704
+ 26.9194444 0.499588
+ 26.9222222 0.495473
+ 26.9250000 0.493416
+ 26.9277778 0.491358
+ 26.9305556 0.491358
+ 26.9333333 0.487243
+ 26.9361111 0.479012
+ 26.9388889 0.483128
+ 26.9416667 0.489300
+ 26.9444444 0.487243
+ 26.9472222 0.489300
+ 26.9500000 0.491358
+ 26.9527778 0.485185
+ 26.9555556 0.485185
+ 26.9583333 0.489300
+ 26.9611111 0.489300
+ 26.9638889 0.487243
+ 26.9666667 0.491358
+ 26.9694444 0.487243
+ 26.9722222 0.491358
+ 26.9750000 0.491358
+ 26.9777778 0.485185
+ 26.9805556 0.489300
+ 26.9833333 0.481070
+ 26.9861111 0.481070
+ 26.9888889 0.483128
+ 26.9916667 0.485185
+ 26.9944444 0.487243
+ 26.9972222 0.497531
+ 27.0000000 0.501646
+ 27.0027778 0.503704
+ 27.0055556 0.497531
+ 27.0083333 0.491358
+ 27.0111111 0.481070
+ 27.0138889 0.481070
+ 27.0166667 0.487243
+ 27.0194444 0.489300
+ 27.0222222 0.493416
+ 27.0250000 0.501646
+ 27.0277778 0.503704
+ 27.0305556 0.511934
+ 27.0333333 0.513992
+ 27.0361111 0.505761
+ 27.0388889 0.493416
+ 27.0416667 0.487243
+ 27.0444444 0.476955
+ 27.0472222 0.481070
+ 27.0500000 0.487243
+ 27.0527778 0.495473
+ 27.0555556 0.495473
+ 27.0583333 0.495473
+ 27.0611111 0.493416
+ 27.0638889 0.491358
+ 27.0666667 0.487243
+ 27.0694444 0.487243
+ 27.0722222 0.489300
+ 27.0750000 0.493416
+ 27.0777778 0.495473
+ 27.0805556 0.497531
+ 27.0833333 0.499588
+ 27.0861111 0.497531
+ 27.0888889 0.493416
+ 27.0916667 0.491358
+ 27.0944444 0.483128
+ 27.0972222 0.485185
+ 27.1000000 0.485185
+ 27.1027778 0.489300
+ 27.1055556 0.491358
+ 27.1083333 0.497531
+ 27.1111111 0.503704
+ 27.1138889 0.499588
+ 27.1166667 0.499588
+ 27.1194444 0.497531
+ 27.1222222 0.489300
+ 27.1250000 0.479012
+ 27.1277778 0.474897
+ 27.1305556 0.472840
+ 27.1333333 0.479012
+ 27.1361111 0.487243
+ 27.1388889 0.491358
+ 27.1416667 0.497531
+ 27.1444444 0.493416
+ 27.1472222 0.489300
+ 27.1500000 0.481070
+ 27.1527778 0.474897
+ 27.1555556 0.476955
+ 27.1583333 0.466667
+ 27.1611111 0.476955
+ 27.1638889 0.483128
+ 27.1666667 0.485185
+ 27.1694444 0.495473
+ 27.1722222 0.499588
+ 27.1750000 0.503704
+ 27.1777778 0.499588
+ 27.1805556 0.499588
+ 27.1833333 0.493416
+ 27.1861111 0.483128
+ 27.1888889 0.476955
+ 27.1916667 0.474897
+ 27.1944444 0.476955
+ 27.1972222 0.479012
+ 27.2000000 0.489300
+ 27.2027778 0.485185
+ 27.2055556 0.495473
+ 27.2083333 0.499588
+ 27.2111111 0.497531
+ 27.2138889 0.507819
+ 27.2166667 0.507819
+ 27.2194444 0.507819
+ 27.2222222 0.503704
+ 27.2250000 0.491358
+ 27.2277778 0.481070
+ 27.2305556 0.474897
+ 27.2333333 0.485185
+ 27.2361111 0.483128
+ 27.2388889 0.491358
+ 27.2416667 0.485185
+ 27.2444444 0.483128
+ 27.2472222 0.485185
+ 27.2500000 0.487243
+ 27.2527778 0.491358
+ 27.2555556 0.499588
+ 27.2583333 0.505761
+ 27.2611111 0.507819
+ 27.2638889 0.505761
+ 27.2666667 0.509877
+ 27.2694444 0.511934
+ 27.2722222 0.511934
+ 27.2750000 0.516049
+ 27.2777778 0.516049
+ 27.2805556 0.526337
+ 27.2833333 0.532510
+ 27.2861111 0.532510
+ 27.2888889 0.530453
+ 27.2916667 0.526337
+ 27.2944444 0.524280
+ 27.2972222 0.518107
+ 27.3000000 0.518107
+ 27.3027778 0.513992
+ 27.3055556 0.516049
+ 27.3083333 0.516049
+ 27.3111111 0.516049
+ 27.3138889 0.518107
+ 27.3166667 0.513992
+ 27.3194444 0.511934
+ 27.3222222 0.503704
+ 27.3250000 0.505761
+ 27.3277778 0.503704
+ 27.3305556 0.505761
+ 27.3333333 0.503704
+ 27.3361111 0.499588
+ 27.3388889 0.495473
+ 27.3416667 0.499588
+ 27.3444444 0.501646
+ 27.3472222 0.503704
+ 27.3500000 0.503704
+ 27.3527778 0.499588
+ 27.3555556 0.489300
+ 27.3583333 0.487243
+ 27.3611111 0.481070
+ 27.3638889 0.476955
+ 27.3666667 0.479012
+ 27.3694444 0.474897
+ 27.3722222 0.479012
+ 27.3750000 0.489300
+ 27.3777778 0.491358
+ 27.3805556 0.493416
+ 27.3833333 0.489300
+ 27.3861111 0.485185
+ 27.3888889 0.479012
+ 27.3916667 0.472840
+ 27.3944444 0.476955
+ 27.3972222 0.479012
+ 27.4000000 0.479012
+ 27.4027778 0.483128
+ 27.4055556 0.489300
+ 27.4083333 0.491358
+ 27.4111111 0.495473
+ 27.4138889 0.491358
+ 27.4166667 0.487243
+ 27.4194444 0.485185
+ 27.4222222 0.481070
+ 27.4250000 0.476955
+ 27.4277778 0.476955
+ 27.4305556 0.479012
+ 27.4333333 0.483128
+ 27.4361111 0.485185
+ 27.4388889 0.497531
+ 27.4416667 0.511934
+ 27.4444444 0.522222
+ 27.4472222 0.532510
+ 27.4500000 0.538683
+ 27.4527778 0.536626
+ 27.4555556 0.528395
+ 27.4583333 0.528395
+ 27.4611111 0.538683
+ 27.4638889 0.559259
+ 27.4666667 0.594239
+ 27.4694444 0.633333
+ 27.4722222 0.674486
+ 27.4750000 0.701235
+ 27.4777778 0.699177
+ 27.4805556 0.664198
+ 27.4833333 0.590123
+ 27.4861111 0.503704
+ 27.4888889 0.427572
+ 27.4916667 0.384362
+ 27.4944444 0.367901
+ 27.4972222 0.363786
+ 27.5000000 0.367901
+ 27.5027778 0.369959
+ 27.5055556 0.380247
+ 27.5083333 0.388477
+ 27.5111111 0.400823
+ 27.5138889 0.411111
+ 27.5166667 0.409053
+ 27.5194444 0.396708
+ 27.5222222 0.376132
+ 27.5250000 0.357613
+ 27.5277778 0.367901
+ 27.5305556 0.380247
+ 27.5333333 0.398765
+ 27.5361111 0.411111
+ 27.5388889 0.421399
+ 27.5416667 0.417284
+ 27.5444444 0.411111
+ 27.5472222 0.402881
+ 27.5500000 0.396708
+ 27.5527778 0.388477
+ 27.5555556 0.386420
+ 27.5583333 0.394650
+ 27.5611111 0.413169
+ 27.5638889 0.433745
+ 27.5666667 0.458436
+ 27.5694444 0.476955
+ 27.5722222 0.489300
+ 27.5750000 0.487243
+ 27.5777778 0.481070
+ 27.5805556 0.470782
+ 27.5833333 0.466667
+ 27.5861111 0.460494
+ 27.5888889 0.460494
+ 27.5916667 0.466667
+ 27.5944444 0.474897
+ 27.5972222 0.483128
+ 27.6000000 0.487243
+ 27.6027778 0.487243
+ 27.6055556 0.489300
+ 27.6083333 0.476955
+ 27.6111111 0.470782
+ 27.6138889 0.464609
+ 27.6166667 0.468724
+ 27.6194444 0.464609
+ 27.6222222 0.470782
+ 27.6250000 0.470782
+ 27.6277778 0.472840
+ 27.6305556 0.476955
+ 27.6333333 0.483128
+ 27.6361111 0.476955
+ 27.6388889 0.485185
+ 27.6416667 0.489300
+ 27.6444444 0.495473
+ 27.6472222 0.497531
+ 27.6500000 0.491358
+ 27.6527778 0.487243
+ 27.6555556 0.479012
+ 27.6583333 0.476955
+ 27.6611111 0.483128
+ 27.6638889 0.487243
+ 27.6666667 0.487243
+ 27.6694444 0.474897
+ 27.6722222 0.464609
+ 27.6750000 0.464609
+ 27.6777778 0.466667
+ 27.6805556 0.474897
+ 27.6833333 0.481070
+ 27.6861111 0.491358
+ 27.6888889 0.497531
+ 27.6916667 0.499588
+ 27.6944444 0.503704
+ 27.6972222 0.501646
+ 27.7000000 0.497531
+ 27.7027778 0.501646
+ 27.7055556 0.501646
+ 27.7083333 0.501646
+ 27.7111111 0.495473
+ 27.7138889 0.499588
+ 27.7166667 0.495473
+ 27.7194444 0.495473
+ 27.7222222 0.491358
+ 27.7250000 0.493416
+ 27.7277778 0.495473
+ 27.7305556 0.507819
+ 27.7333333 0.516049
+ 27.7361111 0.524280
+ 27.7388889 0.534568
+ 27.7416667 0.540741
+ 27.7444444 0.544856
+ 27.7472222 0.544856
+ 27.7500000 0.542798
+ 27.7527778 0.528395
+ 27.7555556 0.528395
+ 27.7583333 0.526337
+ 27.7611111 0.530453
+ 27.7638889 0.534568
+ 27.7666667 0.534568
+ 27.7694444 0.540741
+ 27.7722222 0.542798
+ 27.7750000 0.551029
+ 27.7777778 0.553086
+ 27.7805556 0.559259
+ 27.7833333 0.563374
+ 27.7861111 0.563374
+ 27.7888889 0.565432
+ 27.7916667 0.555144
+ 27.7944444 0.546914
+ 27.7972222 0.542798
+ 27.8000000 0.538683
+ 27.8027778 0.544856
+ 27.8055556 0.548971
+ 27.8083333 0.553086
+ 27.8111111 0.548971
+ 27.8138889 0.546914
+ 27.8166667 0.538683
+ 27.8194444 0.530453
+ 27.8222222 0.518107
+ 27.8250000 0.530453
+ 27.8277778 0.530453
+ 27.8305556 0.530453
+ 27.8333333 0.534568
+ 27.8361111 0.530453
+ 27.8388889 0.532510
+ 27.8416667 0.530453
+ 27.8444444 0.528395
+ 27.8472222 0.524280
+ 27.8500000 0.518107
+ 27.8527778 0.511934
+ 27.8555556 0.509877
+ 27.8583333 0.503704
+ 27.8611111 0.503704
+ 27.8638889 0.493416
+ 27.8666667 0.491358
+ 27.8694444 0.487243
+ 27.8722222 0.487243
+ 27.8750000 0.491358
+ 27.8777778 0.497531
+ 27.8805556 0.499588
+ 27.8833333 0.505761
+ 27.8861111 0.499588
+ 27.8888889 0.493416
+ 27.8916667 0.489300
+ 27.8944444 0.491358
+ 27.8972222 0.489300
+ 27.9000000 0.479012
+ 27.9027778 0.472840
+ 27.9055556 0.476955
+ 27.9083333 0.476955
+ 27.9111111 0.479012
+ 27.9138889 0.481070
+ 27.9166667 0.474897
+ 27.9194444 0.464609
+ 27.9222222 0.458436
+ 27.9250000 0.456379
+ 27.9277778 0.466667
+ 27.9305556 0.474897
+ 27.9333333 0.483128
+ 27.9361111 0.493416
+ 27.9388889 0.499588
+ 27.9416667 0.503704
+ 27.9444444 0.507819
+ 27.9472222 0.509877
+ 27.9500000 0.509877
+ 27.9527778 0.511934
+ 27.9555556 0.503704
+ 27.9583333 0.493416
+ 27.9611111 0.487243
+ 27.9638889 0.476955
+ 27.9666667 0.481070
+ 27.9694444 0.487243
+ 27.9722222 0.493416
+ 27.9750000 0.499588
+ 27.9777778 0.497531
+ 27.9805556 0.495473
+ 27.9833333 0.493416
+ 27.9861111 0.491358
+ 27.9888889 0.487243
+ 27.9916667 0.485185
+ 27.9944444 0.489300
+ 27.9972222 0.493416
+ 28.0000000 0.503704
+ 28.0027778 0.509877
+ 28.0055556 0.520165
+ 28.0083333 0.522222
+ 28.0111111 0.516049
+ 28.0138889 0.505761
+ 28.0166667 0.495473
+ 28.0194444 0.485185
+ 28.0222222 0.474897
+ 28.0250000 0.481070
+ 28.0277778 0.476955
+ 28.0305556 0.491358
+ 28.0333333 0.493416
+ 28.0361111 0.499588
+ 28.0388889 0.509877
+ 28.0416667 0.511934
+ 28.0444444 0.516049
+ 28.0472222 0.516049
+ 28.0500000 0.511934
+ 28.0527778 0.503704
+ 28.0555556 0.491358
+ 28.0583333 0.483128
+ 28.0611111 0.487243
+ 28.0638889 0.491358
+ 28.0666667 0.497531
+ 28.0694444 0.497531
+ 28.0722222 0.497531
+ 28.0750000 0.495473
+ 28.0777778 0.485185
+ 28.0805556 0.489300
+ 28.0833333 0.491358
+ 28.0861111 0.491358
+ 28.0888889 0.487243
+ 28.0916667 0.481070
+ 28.0944444 0.474897
+ 28.0972222 0.479012
+ 28.1000000 0.483128
+ 28.1027778 0.493416
+ 28.1055556 0.503704
+ 28.1083333 0.511934
+ 28.1111111 0.509877
+ 28.1138889 0.503704
+ 28.1166667 0.489300
+ 28.1194444 0.485185
+ 28.1222222 0.479012
+ 28.1250000 0.474897
+ 28.1277778 0.470782
+ 28.1305556 0.472840
+ 28.1333333 0.474897
+ 28.1361111 0.479012
+ 28.1388889 0.474897
+ 28.1416667 0.481070
+ 28.1444444 0.483128
+ 28.1472222 0.483128
+ 28.1500000 0.495473
+ 28.1527778 0.485185
+ 28.1555556 0.489300
+ 28.1583333 0.483128
+ 28.1611111 0.485185
+ 28.1638889 0.483128
+ 28.1666667 0.483128
+ 28.1694444 0.485185
+ 28.1722222 0.481070
+ 28.1750000 0.479012
+ 28.1777778 0.476955
+ 28.1805556 0.481070
+ 28.1833333 0.483128
+ 28.1861111 0.487243
+ 28.1888889 0.487243
+ 28.1916667 0.474897
+ 28.1944444 0.470782
+ 28.1972222 0.466667
+ 28.2000000 0.468724
+ 28.2027778 0.479012
+ 28.2055556 0.487243
+ 28.2083333 0.493416
+ 28.2111111 0.481070
+ 28.2138889 0.479012
+ 28.2166667 0.474897
+ 28.2194444 0.470782
+ 28.2222222 0.474897
+ 28.2250000 0.476955
+ 28.2277778 0.489300
+ 28.2305556 0.493416
+ 28.2333333 0.499588
+ 28.2361111 0.501646
+ 28.2388889 0.491358
+ 28.2416667 0.476955
+ 28.2444444 0.468724
+ 28.2472222 0.460494
+ 28.2500000 0.464609
+ 28.2527778 0.464609
+ 28.2555556 0.470782
+ 28.2583333 0.470782
+ 28.2611111 0.479012
+ 28.2638889 0.481070
+ 28.2666667 0.481070
+ 28.2694444 0.479012
+ 28.2722222 0.483128
+ 28.2750000 0.483128
+ 28.2777778 0.481070
+ 28.2805556 0.476955
+ 28.2833333 0.479012
+ 28.2861111 0.479012
+ 28.2888889 0.476955
+ 28.2916667 0.479012
+ 28.2944444 0.476955
+ 28.2972222 0.474897
+ 28.3000000 0.481070
+ 28.3027778 0.485185
+ 28.3055556 0.483128
+ 28.3083333 0.481070
+ 28.3111111 0.487243
+ 28.3138889 0.495473
+ 28.3166667 0.489300
+ 28.3194444 0.483128
+ 28.3222222 0.476955
+ 28.3250000 0.468724
+ 28.3277778 0.466667
+ 28.3305556 0.468724
+ 28.3333333 0.470782
+ 28.3361111 0.474897
+ 28.3388889 0.472840
+ 28.3416667 0.474897
+ 28.3444444 0.468724
+ 28.3472222 0.470782
+ 28.3500000 0.474897
+ 28.3527778 0.472840
+ 28.3555556 0.472840
+ 28.3583333 0.476955
+ 28.3611111 0.476955
+ 28.3638889 0.487243
+ 28.3666667 0.493416
+ 28.3694444 0.501646
+ 28.3722222 0.507819
+ 28.3750000 0.513992
+ 28.3777778 0.513992
+ 28.3805556 0.509877
+ 28.3833333 0.503704
+ 28.3861111 0.495473
+ 28.3888889 0.499588
+ 28.3916667 0.499588
+ 28.3944444 0.491358
+ 28.3972222 0.495473
+ 28.4000000 0.499588
+ 28.4027778 0.509877
+ 28.4055556 0.516049
+ 28.4083333 0.520165
+ 28.4111111 0.526337
+ 28.4138889 0.532510
+ 28.4166667 0.526337
+ 28.4194444 0.516049
+ 28.4222222 0.503704
+ 28.4250000 0.487243
+ 28.4277778 0.476955
+ 28.4305556 0.470782
+ 28.4333333 0.474897
+ 28.4361111 0.483128
+ 28.4388889 0.495473
+ 28.4416667 0.511934
+ 28.4444444 0.516049
+ 28.4472222 0.513992
+ 28.4500000 0.495473
+ 28.4527778 0.485185
+ 28.4555556 0.476955
+ 28.4583333 0.476955
+ 28.4611111 0.476955
+ 28.4638889 0.479012
+ 28.4666667 0.476955
+ 28.4694444 0.476955
+ 28.4722222 0.479012
+ 28.4750000 0.479012
+ 28.4777778 0.472840
+ 28.4805556 0.464609
+ 28.4833333 0.456379
+ 28.4861111 0.452263
+ 28.4888889 0.454321
+ 28.4916667 0.448148
+ 28.4944444 0.456379
+ 28.4972222 0.458436
+ 28.5000000 0.466667
+ 28.5027778 0.472840
+ 28.5055556 0.481070
+ 28.5083333 0.487243
+ 28.5111111 0.481070
+ 28.5138889 0.479012
+ 28.5166667 0.472840
+ 28.5194444 0.464609
+ 28.5222222 0.460494
+ 28.5250000 0.464609
+ 28.5277778 0.476955
+ 28.5305556 0.483128
+ 28.5333333 0.481070
+ 28.5361111 0.472840
+ 28.5388889 0.454321
+ 28.5416667 0.446091
+ 28.5444444 0.433745
+ 28.5472222 0.444033
+ 28.5500000 0.452263
+ 28.5527778 0.460494
+ 28.5555556 0.474897
+ 28.5583333 0.476955
+ 28.5611111 0.476955
+ 28.5638889 0.476955
+ 28.5666667 0.481070
+ 28.5694444 0.474897
+ 28.5722222 0.474897
+ 28.5750000 0.479012
+ 28.5777778 0.487243
+ 28.5805556 0.503704
+ 28.5833333 0.530453
+ 28.5861111 0.565432
+ 28.5888889 0.600412
+ 28.5916667 0.643621
+ 28.5944444 0.682716
+ 28.5972222 0.715638
+ 28.6000000 0.725926
+ 28.6027778 0.705350
+ 28.6055556 0.645679
+ 28.6083333 0.555144
+ 28.6111111 0.462551
+ 28.6138889 0.398765
+ 28.6166667 0.355556
+ 28.6194444 0.341152
+ 28.6222222 0.341152
+ 28.6250000 0.349383
+ 28.6277778 0.355556
+ 28.6305556 0.367901
+ 28.6333333 0.376132
+ 28.6361111 0.384362
+ 28.6388889 0.390535
+ 28.6416667 0.394650
+ 28.6444444 0.390535
+ 28.6472222 0.382305
+ 28.6500000 0.390535
+ 28.6527778 0.398765
+ 28.6555556 0.411111
+ 28.6583333 0.417284
+ 28.6611111 0.417284
+ 28.6638889 0.398765
+ 28.6666667 0.386420
+ 28.6694444 0.380247
+ 28.6722222 0.382305
+ 28.6750000 0.388477
+ 28.6777778 0.394650
+ 28.6805556 0.404938
+ 28.6833333 0.400823
+ 28.6861111 0.409053
+ 28.6888889 0.413169
+ 28.6916667 0.413169
+ 28.6944444 0.413169
+ 28.6972222 0.419342
+ 28.7000000 0.427572
+ 28.7027778 0.444033
+ 28.7055556 0.456379
+ 28.7083333 0.466667
+ 28.7111111 0.472840
+ 28.7138889 0.476955
+ 28.7166667 0.474897
+ 28.7194444 0.470782
+ 28.7222222 0.468724
+ 28.7250000 0.464609
+ 28.7277778 0.472840
+ 28.7305556 0.476955
+ 28.7333333 0.479012
+ 28.7361111 0.483128
+ 28.7388889 0.481070
+ 28.7416667 0.479012
+ 28.7444444 0.476955
+ 28.7472222 0.476955
+ 28.7500000 0.476955
+ 28.7527778 0.472840
+ 28.7555556 0.462551
+ 28.7583333 0.458436
+ 28.7611111 0.460494
+ 28.7638889 0.462551
+ 28.7666667 0.468724
+ 28.7694444 0.472840
+ 28.7722222 0.479012
+ 28.7750000 0.474897
+ 28.7777778 0.470782
+ 28.7805556 0.472840
+ 28.7833333 0.479012
+ 28.7861111 0.474897
+ 28.7888889 0.476955
+ 28.7916667 0.476955
+ 28.7944444 0.479012
+ 28.7972222 0.485185
+ 28.8000000 0.483128
+ 28.8027778 0.483128
+ 28.8055556 0.485185
+ 28.8083333 0.487243
+ 28.8111111 0.493416
+ 28.8138889 0.497531
+ 28.8166667 0.497531
+ 28.8194444 0.493416
+ 28.8222222 0.487243
+ 28.8250000 0.485185
+ 28.8277778 0.487243
+ 28.8305556 0.489300
+ 28.8333333 0.499588
+ 28.8361111 0.505761
+ 28.8388889 0.511934
+ 28.8416667 0.518107
+ 28.8444444 0.522222
+ 28.8472222 0.530453
+ 28.8500000 0.536626
+ 28.8527778 0.534568
+ 28.8555556 0.532510
+ 28.8583333 0.520165
+ 28.8611111 0.520165
+ 28.8638889 0.530453
+ 28.8666667 0.540741
+ 28.8694444 0.553086
+ 28.8722222 0.557202
+ 28.8750000 0.567490
+ 28.8777778 0.561317
+ 28.8805556 0.555144
+ 28.8833333 0.546914
+ 28.8861111 0.544856
+ 28.8888889 0.544856
+ 28.8916667 0.542798
+ 28.8944444 0.544856
+ 28.8972222 0.551029
+ 28.9000000 0.559259
+ 28.9027778 0.569547
+ 28.9055556 0.577778
+ 28.9083333 0.586008
+ 28.9111111 0.588066
+ 28.9138889 0.586008
+ 28.9166667 0.581893
+ 28.9194444 0.573663
+ 28.9222222 0.567490
+ 28.9250000 0.563374
+ 28.9277778 0.559259
+ 28.9305556 0.546914
+ 28.9333333 0.540741
+ 28.9361111 0.536626
+ 28.9388889 0.534568
+ 28.9416667 0.534568
+ 28.9444444 0.528395
+ 28.9472222 0.532510
+ 28.9500000 0.532510
+ 28.9527778 0.536626
+ 28.9555556 0.524280
+ 28.9583333 0.509877
+ 28.9611111 0.505761
+ 28.9638889 0.499588
+ 28.9666667 0.501646
+ 28.9694444 0.499588
+ 28.9722222 0.495473
+ 28.9750000 0.493416
+ 28.9777778 0.489300
+ 28.9805556 0.483128
+ 28.9833333 0.476955
+ 28.9861111 0.464609
+ 28.9888889 0.458436
+ 28.9916667 0.452263
+ 28.9944444 0.448148
+ 28.9972222 0.454321
+ 29.0000000 0.464609
+ 29.0027778 0.472840
+ 29.0055556 0.472840
+ 29.0083333 0.474897
+ 29.0111111 0.468724
+ 29.0138889 0.464609
+ 29.0166667 0.454321
+ 29.0194444 0.450206
+ 29.0222222 0.441975
+ 29.0250000 0.437860
+ 29.0277778 0.441975
+ 29.0305556 0.439918
+ 29.0333333 0.448148
+ 29.0361111 0.450206
+ 29.0388889 0.450206
+ 29.0416667 0.456379
+ 29.0444444 0.454321
+ 29.0472222 0.456379
+ 29.0500000 0.456379
+ 29.0527778 0.450206
+ 29.0555556 0.446091
+ 29.0583333 0.446091
+ 29.0611111 0.460494
+ 29.0638889 0.462551
+ 29.0666667 0.476955
+ 29.0694444 0.495473
+ 29.0722222 0.507819
+ 29.0750000 0.511934
+ 29.0777778 0.509877
+ 29.0805556 0.495473
+ 29.0833333 0.476955
+ 29.0861111 0.450206
+ 29.0888889 0.439918
+ 29.0916667 0.425514
+ 29.0944444 0.435802
+ 29.0972222 0.452263
+ 29.1000000 0.468724
+ 29.1027778 0.485185
+ 29.1055556 0.497531
+ 29.1083333 0.499588
+ 29.1111111 0.491358
+ 29.1138889 0.481070
+ 29.1166667 0.476955
+ 29.1194444 0.476955
+ 29.1222222 0.479012
+ 29.1250000 0.485185
+ 29.1277778 0.489300
+ 29.1305556 0.489300
+ 29.1333333 0.485185
+ 29.1361111 0.487243
+ 29.1388889 0.487243
+ 29.1416667 0.487243
+ 29.1444444 0.485185
+ 29.1472222 0.483128
+ 29.1500000 0.481070
+ 29.1527778 0.479012
+ 29.1555556 0.476955
+ 29.1583333 0.483128
+ 29.1611111 0.485185
+ 29.1638889 0.487243
+ 29.1666667 0.487243
+ 29.1694444 0.481070
+ 29.1722222 0.472840
+ 29.1750000 0.466667
+ 29.1777778 0.464609
+ 29.1805556 0.460494
+ 29.1833333 0.462551
+ 29.1861111 0.460494
+ 29.1888889 0.462551
+ 29.1916667 0.464609
+ 29.1944444 0.466667
+ 29.1972222 0.470782
+ 29.2000000 0.489300
+ 29.2027778 0.495473
+ 29.2055556 0.481070
+ 29.2083333 0.483128
+ 29.2111111 0.470782
+ 29.2138889 0.462551
+ 29.2166667 0.462551
+ 29.2194444 0.460494
+ 29.2222222 0.462551
+ 29.2250000 0.464609
+ 29.2277778 0.468724
+ 29.2305556 0.474897
+ 29.2333333 0.476955
+ 29.2361111 0.487243
+ 29.2388889 0.487243
+ 29.2416667 0.483128
+ 29.2444444 0.474897
+ 29.2472222 0.472840
+ 29.2500000 0.466667
+ 29.2527778 0.468724
+ 29.2555556 0.479012
+ 29.2583333 0.489300
+ 29.2611111 0.497531
+ 29.2638889 0.511934
+ 29.2666667 0.538683
+ 29.2694444 0.571605
+ 29.2722222 0.614815
+ 29.2750000 0.647737
+ 29.2777778 0.674486
+ 29.2805556 0.699177
+ 29.2833333 0.699177
+ 29.2861111 0.678601
+ 29.2888889 0.623045
+ 29.2916667 0.540741
+ 29.2944444 0.452263
+ 29.2972222 0.388477
+ 29.3000000 0.349383
+ 29.3027778 0.345267
+ 29.3055556 0.359671
+ 29.3083333 0.376132
+ 29.3111111 0.382305
+ 29.3138889 0.386420
+ 29.3166667 0.390535
+ 29.3194444 0.384362
+ 29.3222222 0.388477
+ 29.3250000 0.382305
+ 29.3277778 0.369959
+ 29.3305556 0.363786
+ 29.3333333 0.374074
+ 29.3361111 0.384362
+ 29.3388889 0.400823
+ 29.3416667 0.419342
+ 29.3444444 0.425514
+ 29.3472222 0.425514
+ 29.3500000 0.421399
+ 29.3527778 0.409053
+ 29.3555556 0.384362
+ 29.3583333 0.363786
+ 29.3611111 0.355556
+ 29.3638889 0.359671
+ 29.3666667 0.376132
+ 29.3694444 0.400823
+ 29.3722222 0.427572
+ 29.3750000 0.452263
+ 29.3777778 0.466667
+ 29.3805556 0.479012
+ 29.3833333 0.476955
+ 29.3861111 0.476955
+ 29.3888889 0.474897
+ 29.3916667 0.474897
+ 29.3944444 0.476955
+ 29.3972222 0.470782
+ 29.4000000 0.468724
+ 29.4027778 0.464609
+ 29.4055556 0.456379
+ 29.4083333 0.454321
+ 29.4111111 0.450206
+ 29.4138889 0.448148
+ 29.4166667 0.458436
+ 29.4194444 0.466667
+ 29.4222222 0.472840
+ 29.4250000 0.474897
+ 29.4277778 0.479012
+ 29.4305556 0.476955
+ 29.4333333 0.474897
+ 29.4361111 0.474897
+ 29.4388889 0.464609
+ 29.4416667 0.472840
+ 29.4444444 0.474897
+ 29.4472222 0.481070
+ 29.4500000 0.487243
+ 29.4527778 0.474897
+ 29.4555556 0.474897
+ 29.4583333 0.470782
+ 29.4611111 0.468724
+ 29.4638889 0.474897
+ 29.4666667 0.485185
+ 29.4694444 0.491358
+ 29.4722222 0.495473
+ 29.4750000 0.489300
+ 29.4777778 0.487243
+ 29.4805556 0.479012
+ 29.4833333 0.481070
+ 29.4861111 0.485185
+ 29.4888889 0.479012
+ 29.4916667 0.483128
+ 29.4944444 0.485185
+ 29.4972222 0.489300
+ 29.5000000 0.491358
+ 29.5027778 0.489300
+ 29.5055556 0.497531
+ 29.5083333 0.509877
+ 29.5111111 0.511934
+ 29.5138889 0.520165
+ 29.5166667 0.520165
+ 29.5194444 0.520165
+ 29.5222222 0.524280
+ 29.5250000 0.524280
+ 29.5277778 0.530453
+ 29.5305556 0.522222
+ 29.5333333 0.520165
+ 29.5361111 0.522222
+ 29.5388889 0.536626
+ 29.5416667 0.548971
+ 29.5444444 0.555144
+ 29.5472222 0.559259
+ 29.5500000 0.561317
+ 29.5527778 0.557202
+ 29.5555556 0.557202
+ 29.5583333 0.555144
+ 29.5611111 0.559259
+ 29.5638889 0.565432
+ 29.5666667 0.567490
+ 29.5694444 0.569547
+ 29.5722222 0.575720
+ 29.5750000 0.575720
+ 29.5777778 0.575720
+ 29.5805556 0.571605
+ 29.5833333 0.567490
+ 29.5861111 0.565432
+ 29.5888889 0.563374
+ 29.5916667 0.565432
+ 29.5944444 0.563374
+ 29.5972222 0.557202
+ 29.6000000 0.551029
+ 29.6027778 0.538683
+ 29.6055556 0.528395
+ 29.6083333 0.522222
+ 29.6111111 0.516049
+ 29.6138889 0.507819
+ 29.6166667 0.513992
+ 29.6194444 0.511934
+ 29.6222222 0.509877
+ 29.6250000 0.511934
+ 29.6277778 0.509877
+ 29.6305556 0.503704
+ 29.6333333 0.499588
+ 29.6361111 0.491358
+ 29.6388889 0.489300
+ 29.6416667 0.483128
+ 29.6444444 0.483128
+ 29.6472222 0.479012
+ 29.6500000 0.474897
+ 29.6527778 0.464609
+ 29.6555556 0.452263
+ 29.6583333 0.450206
+ 29.6611111 0.448148
+ 29.6638889 0.452263
+ 29.6666667 0.458436
+ 29.6694444 0.464609
+ 29.6722222 0.462551
+ 29.6750000 0.462551
+ 29.6777778 0.452263
+ 29.6805556 0.450206
+ 29.6833333 0.450206
+ 29.6861111 0.458436
+ 29.6888889 0.460494
+ 29.6916667 0.462551
+ 29.6944444 0.466667
+ 29.6972222 0.470782
+ 29.7000000 0.474897
+ 29.7027778 0.470782
+ 29.7055556 0.458436
+ 29.7083333 0.454321
+ 29.7111111 0.446091
+ 29.7138889 0.448148
+ 29.7166667 0.450206
+ 29.7194444 0.456379
+ 29.7222222 0.458436
+ 29.7250000 0.458436
+ 29.7277778 0.454321
+ 29.7305556 0.458436
+ 29.7333333 0.462551
+ 29.7361111 0.458436
+ 29.7388889 0.470782
+ 29.7416667 0.483128
+ 29.7444444 0.485185
+ 29.7472222 0.485185
+ 29.7500000 0.476955
+ 29.7527778 0.468724
+ 29.7555556 0.458436
+ 29.7583333 0.446091
+ 29.7611111 0.433745
+ 29.7638889 0.435802
+ 29.7666667 0.431687
+ 29.7694444 0.439918
+ 29.7722222 0.454321
+ 29.7750000 0.466667
+ 29.7777778 0.476955
+ 29.7805556 0.483128
+ 29.7833333 0.485185
+ 29.7861111 0.487243
+ 29.7888889 0.485185
+ 29.7916667 0.481070
+ 29.7944444 0.470782
+ 29.7972222 0.464609
+ 29.8000000 0.464609
+ 29.8027778 0.464609
+ 29.8055556 0.466667
+ 29.8083333 0.474897
+ 29.8111111 0.476955
+ 29.8138889 0.489300
+ 29.8166667 0.493416
+ 29.8194444 0.487243
+ 29.8222222 0.487243
+ 29.8250000 0.481070
+ 29.8277778 0.474897
+ 29.8305556 0.466667
+ 29.8333333 0.454321
+ 29.8361111 0.452263
+ 29.8388889 0.444033
+ 29.8416667 0.446091
+ 29.8444444 0.458436
+ 29.8472222 0.466667
+ 29.8500000 0.476955
+ 29.8527778 0.485185
+ 29.8555556 0.491358
+ 29.8583333 0.479012
+ 29.8611111 0.464609
+ 29.8638889 0.456379
+ 29.8666667 0.448148
+ 29.8694444 0.450206
+ 29.8722222 0.456379
+ 29.8750000 0.464609
+ 29.8777778 0.468724
+ 29.8805556 0.468724
+ 29.8833333 0.472840
+ 29.8861111 0.470782
+ 29.8888889 0.468724
+ 29.8916667 0.460494
+ 29.8944444 0.454321
+ 29.8972222 0.452263
+ 29.9000000 0.452263
+ 29.9027778 0.456379
+ 29.9055556 0.464609
+ 29.9083333 0.470782
+ 29.9111111 0.470782
+ 29.9138889 0.472840
+ 29.9166667 0.472840
+ 29.9194444 0.470782
+ 29.9222222 0.470782
+ 29.9250000 0.466667
+ 29.9277778 0.472840
+ 29.9305556 0.474897
+ 29.9333333 0.470782
+ 29.9361111 0.472840
+ 29.9388889 0.479012
+ 29.9416667 0.485185
+ 29.9444444 0.483128
+ 29.9472222 0.485185
+ 29.9500000 0.479012
+ 29.9527778 0.472840
+ 29.9555556 0.466667
+ 29.9583333 0.460494
+ 29.9611111 0.462551
+ 29.9638889 0.464609
+ 29.9666667 0.479012
+ 29.9694444 0.485185
+ 29.9722222 0.489300
+ 29.9750000 0.505761
+ 29.9777778 0.522222
+ 29.9805556 0.555144
+ 29.9833333 0.583951
+ 29.9861111 0.625103
+ 29.9888889 0.662140
+ 29.9916667 0.684774
+ 29.9944444 0.670370
+ 29.9972222 0.612757
+ 30.0000000 0.532510
+ 30.0027778 0.444033
+ 30.0055556 0.384362
+ 30.0083333 0.349383
+ 30.0111111 0.339095
+ 30.0138889 0.345267
+ 30.0166667 0.361728
+ 30.0194444 0.376132
+ 30.0222222 0.382305
+ 30.0250000 0.386420
+ 30.0277778 0.386420
+ 30.0305556 0.386420
+ 30.0333333 0.382305
+ 30.0361111 0.378189
+ 30.0388889 0.369959
+ 30.0416667 0.365844
+ 30.0444444 0.372016
+ 30.0472222 0.384362
+ 30.0500000 0.402881
+ 30.0527778 0.409053
+ 30.0555556 0.404938
+ 30.0583333 0.400823
+ 30.0611111 0.390535
+ 30.0638889 0.376132
+ 30.0666667 0.374074
+ 30.0694444 0.369959
+ 30.0722222 0.380247
+ 30.0750000 0.388477
+ 30.0777778 0.398765
+ 30.0805556 0.413169
+ 30.0833333 0.425514
+ 30.0861111 0.446091
+ 30.0888889 0.462551
+ 30.0916667 0.470782
+ 30.0944444 0.470782
+ 30.0972222 0.460494
+ 30.1000000 0.456379
+ 30.1027778 0.452263
+ 30.1055556 0.454321
+ 30.1083333 0.462551
+ 30.1111111 0.464609
+ 30.1138889 0.470782
+ 30.1166667 0.476955
+ 30.1194444 0.470782
+ 30.1222222 0.462551
+ 30.1250000 0.458436
+ 30.1277778 0.454321
+ 30.1305556 0.458436
+ 30.1333333 0.462551
+ 30.1361111 0.466667
+ 30.1388889 0.472840
+ 30.1416667 0.479012
+ 30.1444444 0.476955
+ 30.1472222 0.474897
+ 30.1500000 0.470782
+ 30.1527778 0.466667
+ 30.1555556 0.464609
+ 30.1583333 0.462551
+ 30.1611111 0.466667
+ 30.1638889 0.472840
+ 30.1666667 0.481070
+ 30.1694444 0.481070
+ 30.1722222 0.476955
+ 30.1750000 0.466667
+ 30.1777778 0.464609
+ 30.1805556 0.458436
+ 30.1833333 0.464609
+ 30.1861111 0.466667
+ 30.1888889 0.470782
+ 30.1916667 0.472840
+ 30.1944444 0.472840
+ 30.1972222 0.476955
+ 30.2000000 0.489300
+ 30.2027778 0.495473
+ 30.2055556 0.499588
+ 30.2083333 0.501646
+ 30.2111111 0.493416
+ 30.2138889 0.476955
+ 30.2166667 0.466667
+ 30.2194444 0.464609
+ 30.2222222 0.470782
+ 30.2250000 0.474897
+ 30.2277778 0.487243
+ 30.2305556 0.501646
+ 30.2333333 0.513992
+ 30.2361111 0.516049
+ 30.2388889 0.522222
+ 30.2416667 0.528395
+ 30.2444444 0.538683
+ 30.2472222 0.548971
+ 30.2500000 0.553086
+ 30.2527778 0.536626
+ 30.2555556 0.516049
+ 30.2583333 0.501646
+ 30.2611111 0.499588
+ 30.2638889 0.509877
+ 30.2666667 0.528395
+ 30.2694444 0.538683
+ 30.2722222 0.548971
+ 30.2750000 0.544856
+ 30.2777778 0.534568
+ 30.2805556 0.528395
+ 30.2833333 0.526337
+ 30.2861111 0.528395
+ 30.2888889 0.532510
+ 30.2916667 0.540741
+ 30.2944444 0.553086
+ 30.2972222 0.557202
+ 30.3000000 0.567490
+ 30.3027778 0.569547
+ 30.3055556 0.571605
+ 30.3083333 0.563374
+ 30.3111111 0.553086
+ 30.3138889 0.546914
+ 30.3166667 0.540741
+ 30.3194444 0.542798
+ 30.3222222 0.542798
+ 30.3250000 0.544856
+ 30.3277778 0.540741
+ 30.3305556 0.534568
+ 30.3333333 0.526337
+ 30.3361111 0.520165
+ 30.3388889 0.518107
+ 30.3416667 0.520165
+ 30.3444444 0.518107
+ 30.3472222 0.518107
+ 30.3500000 0.511934
+ 30.3527778 0.505761
+ 30.3555556 0.495473
+ 30.3583333 0.483128
+ 30.3611111 0.485185
+ 30.3638889 0.483128
+ 30.3666667 0.483128
+ 30.3694444 0.485185
+ 30.3722222 0.491358
+ 30.3750000 0.487243
+ 30.3777778 0.491358
+ 30.3805556 0.483128
+ 30.3833333 0.481070
+ 30.3861111 0.472840
+ 30.3888889 0.456379
+ 30.3916667 0.454321
+ 30.3944444 0.446091
+ 30.3972222 0.446091
+ 30.4000000 0.452263
+ 30.4027778 0.462551
+ 30.4055556 0.470782
+ 30.4083333 0.481070
+ 30.4111111 0.487243
+ 30.4138889 0.489300
+ 30.4166667 0.487243
+ 30.4194444 0.476955
+ 30.4222222 0.466667
+ 30.4250000 0.452263
+ 30.4277778 0.448148
+ 30.4305556 0.441975
+ 30.4333333 0.448148
+ 30.4361111 0.448148
+ 30.4388889 0.456379
+ 30.4416667 0.468724
+ 30.4444444 0.479012
+ 30.4472222 0.489300
+ 30.4500000 0.487243
+ 30.4527778 0.487243
+ 30.4555556 0.481070
+ 30.4583333 0.472840
+ 30.4611111 0.460494
+ 30.4638889 0.460494
+ 30.4666667 0.462551
+ 30.4694444 0.470782
+ 30.4722222 0.470782
+ 30.4750000 0.479012
+ 30.4777778 0.476955
+ 30.4805556 0.479012
+ 30.4833333 0.476955
+ 30.4861111 0.476955
+ 30.4888889 0.481070
+ 30.4916667 0.485185
+ 30.4944444 0.489300
+ 30.4972222 0.495473
+ 30.5000000 0.495473
+ 30.5027778 0.489300
+ 30.5055556 0.481070
+ 30.5083333 0.474897
+ 30.5111111 0.468724
+ 30.5138889 0.468724
+ 30.5166667 0.466667
+ 30.5194444 0.470782
+ 30.5222222 0.474897
+ 30.5250000 0.479012
+ 30.5277778 0.487243
+ 30.5305556 0.499588
+ 30.5333333 0.503704
+ 30.5361111 0.499588
+ 30.5388889 0.489300
+ 30.5416667 0.472840
+ 30.5444444 0.460494
+ 30.5472222 0.456379
+ 30.5500000 0.452263
+ 30.5527778 0.452263
+ 30.5555556 0.460494
+ 30.5583333 0.460494
+ 30.5611111 0.462551
+ 30.5638889 0.470782
+ 30.5666667 0.481070
+ 30.5694444 0.481070
+ 30.5722222 0.476955
+ 30.5750000 0.479012
+ 30.5777778 0.470782
+ 30.5805556 0.466667
+ 30.5833333 0.458436
+ 30.5861111 0.462551
+ 30.5888889 0.458436
+ 30.5916667 0.460494
+ 30.5944444 0.454321
+ 30.5972222 0.454321
+ 30.6000000 0.458436
+ 30.6027778 0.460494
+ 30.6055556 0.472840
+ 30.6083333 0.485185
+ 30.6111111 0.495473
+ 30.6138889 0.497531
+ 30.6166667 0.485185
+ 30.6194444 0.472840
+ 30.6222222 0.450206
+ 30.6250000 0.439918
+ 30.6277778 0.450206
+ 30.6305556 0.460494
+ 30.6333333 0.472840
+ 30.6361111 0.474897
+ 30.6388889 0.468724
+ 30.6416667 0.460494
+ 30.6444444 0.458436
+ 30.6472222 0.448148
+ 30.6500000 0.454321
+ 30.6527778 0.462551
+ 30.6555556 0.466667
+ 30.6583333 0.472840
+ 30.6611111 0.470782
+ 30.6638889 0.474897
+ 30.6666667 0.476955
+ 30.6694444 0.479012
+ 30.6722222 0.474897
+ 30.6750000 0.462551
+ 30.6777778 0.450206
+ 30.6805556 0.448148
+ 30.6833333 0.441975
+ 30.6861111 0.448148
+ 30.6888889 0.454321
+ 30.6916667 0.460494
+ 30.6944444 0.462551
+ 30.6972222 0.462551
+ 30.7000000 0.464609
+ 30.7027778 0.466667
+ 30.7055556 0.470782
+ 30.7083333 0.470782
+ 30.7111111 0.476955
+ 30.7138889 0.470782
+ 30.7166667 0.468724
+ 30.7194444 0.466667
+ 30.7222222 0.472840
+ 30.7250000 0.474897
+ 30.7277778 0.474897
+ 30.7305556 0.472840
+ 30.7333333 0.462551
+ 30.7361111 0.454321
+ 30.7388889 0.458436
+ 30.7416667 0.458436
+ 30.7444444 0.462551
+ 30.7472222 0.460494
+ 30.7500000 0.462551
+ 30.7527778 0.460494
+ 30.7555556 0.460494
+ 30.7583333 0.458436
+ 30.7611111 0.452263
+ 30.7638889 0.450206
+ 30.7666667 0.462551
+ 30.7694444 0.464609
+ 30.7722222 0.466667
+ 30.7750000 0.462551
+ 30.7777778 0.458436
+ 30.7805556 0.450206
+ 30.7833333 0.452263
+ 30.7861111 0.448148
+ 30.7888889 0.454321
+ 30.7916667 0.464609
+ 30.7944444 0.472840
+ 30.7972222 0.474897
+ 30.8000000 0.479012
+ 30.8027778 0.479012
+ 30.8055556 0.474897
+ 30.8083333 0.472840
+ 30.8111111 0.474897
+ 30.8138889 0.470782
+ 30.8166667 0.458436
+ 30.8194444 0.454321
+ 30.8222222 0.448148
+ 30.8250000 0.448148
+ 30.8277778 0.450206
+ 30.8305556 0.456379
+ 30.8333333 0.458436
+ 30.8361111 0.458436
+ 30.8388889 0.454321
+ 30.8416667 0.466667
+ 30.8444444 0.470782
+ 30.8472222 0.476955
+ 30.8500000 0.464609
+ 30.8527778 0.460494
+ 30.8555556 0.452263
+ 30.8583333 0.444033
+ 30.8611111 0.450206
+ 30.8638889 0.454321
+ 30.8666667 0.456379
+ 30.8694444 0.464609
+ 30.8722222 0.458436
+ 30.8750000 0.462551
+ 30.8777778 0.462551
+ 30.8805556 0.464609
+ 30.8833333 0.460494
+ 30.8861111 0.458436
+ 30.8888889 0.464609
+ 30.8916667 0.462551
+ 30.8944444 0.456379
+ 30.8972222 0.454321
+ 30.9000000 0.458436
+ 30.9027778 0.464609
+ 30.9055556 0.470782
+ 30.9083333 0.476955
+ 30.9111111 0.476955
+ 30.9138889 0.479012
+ 30.9166667 0.470782
+ 30.9194444 0.462551
+ 30.9222222 0.454321
+ 30.9250000 0.450206
+ 30.9277778 0.448148
+ 30.9305556 0.452263
+ 30.9333333 0.458436
+ 30.9361111 0.464609
+ 30.9388889 0.476955
+ 30.9416667 0.487243
+ 30.9444444 0.491358
+ 30.9472222 0.487243
+ 30.9500000 0.474897
+ 30.9527778 0.462551
+ 30.9555556 0.450206
+ 30.9583333 0.448148
+ 30.9611111 0.454321
+ 30.9638889 0.464609
+ 30.9666667 0.472840
+ 30.9694444 0.481070
+ 30.9722222 0.476955
+ 30.9750000 0.468724
+ 30.9777778 0.460494
+ 30.9805556 0.452263
+ 30.9833333 0.450206
+ 30.9861111 0.450206
+ 30.9888889 0.448148
+ 30.9916667 0.450206
+ 30.9944444 0.450206
+ 30.9972222 0.454321
+ 31.0000000 0.460494
+ 31.0027778 0.466667
+ 31.0055556 0.472840
+ 31.0083333 0.479012
+ 31.0111111 0.472840
+ 31.0138889 0.470782
+ 31.0166667 0.466667
+ 31.0194444 0.464609
+ 31.0222222 0.466667
+ 31.0250000 0.470782
+ 31.0277778 0.468724
+ 31.0305556 0.470782
+ 31.0333333 0.462551
+ 31.0361111 0.452263
+ 31.0388889 0.444033
+ 31.0416667 0.452263
+ 31.0444444 0.466667
+ 31.0472222 0.472840
+ 31.0500000 0.468724
+ 31.0527778 0.462551
+ 31.0555556 0.452263
+ 31.0583333 0.439918
+ 31.0611111 0.439918
+ 31.0638889 0.437860
+ 31.0666667 0.446091
+ 31.0694444 0.456379
+ 31.0722222 0.458436
+ 31.0750000 0.462551
+ 31.0777778 0.462551
+ 31.0805556 0.462551
+ 31.0833333 0.460494
+ 31.0861111 0.458436
+ 31.0888889 0.460494
+ 31.0916667 0.458436
+ 31.0944444 0.462551
+ 31.0972222 0.462551
+ 31.1000000 0.464609
+ 31.1027778 0.462551
+ 31.1055556 0.466667
+ 31.1083333 0.470782
+ 31.1111111 0.476955
+ 31.1138889 0.468724
+ 31.1166667 0.474897
+ 31.1194444 0.468724
+ 31.1222222 0.464609
+ 31.1250000 0.458436
+ 31.1277778 0.460494
+ 31.1305556 0.460494
+ 31.1333333 0.454321
+ 31.1361111 0.458436
+ 31.1388889 0.464609
+ 31.1416667 0.470782
+ 31.1444444 0.479012
+ 31.1472222 0.483128
+ 31.1500000 0.483128
+ 31.1527778 0.479012
+ 31.1555556 0.468724
+ 31.1583333 0.452263
+ 31.1611111 0.450206
+ 31.1638889 0.450206
+ 31.1666667 0.456379
+ 31.1694444 0.462551
+ 31.1722222 0.466667
+ 31.1750000 0.466667
+ 31.1777778 0.462551
+ 31.1805556 0.454321
+ 31.1833333 0.450206
+ 31.1861111 0.446091
+ 31.1888889 0.441975
+ 31.1916667 0.444033
+ 31.1944444 0.454321
+ 31.1972222 0.460494
+ 31.2000000 0.464609
+ 31.2027778 0.466667
+ 31.2055556 0.468724
+ 31.2083333 0.468724
+ 31.2111111 0.472840
+ 31.2138889 0.468724
+ 31.2166667 0.470782
+ 31.2194444 0.466667
+ 31.2222222 0.468724
+ 31.2250000 0.468724
+ 31.2277778 0.470782
+ 31.2305556 0.468724
+ 31.2333333 0.460494
+ 31.2361111 0.458436
+ 31.2388889 0.468724
+ 31.2416667 0.470782
+ 31.2444444 0.474897
+ 31.2472222 0.479012
+ 31.2500000 0.474897
+ 31.2527778 0.470782
+ 31.2555556 0.470782
+ 31.2583333 0.470782
+ 31.2611111 0.476955
+ 31.2638889 0.470782
+ 31.2666667 0.458436
+ 31.2694444 0.446091
+ 31.2722222 0.439918
+ 31.2750000 0.444033
+ 31.2777778 0.446091
+ 31.2805556 0.454321
+ 31.2833333 0.458436
+ 31.2861111 0.466667
+ 31.2888889 0.470782
+ 31.2916667 0.468724
+ 31.2944444 0.468724
+ 31.2972222 0.464609
+ 31.3000000 0.466667
+ 31.3027778 0.468724
+ 31.3055556 0.468724
+ 31.3083333 0.464609
+ 31.3111111 0.474897
+ 31.3138889 0.479012
+ 31.3166667 0.476955
+ 31.3194444 0.476955
+ 31.3222222 0.474897
+ 31.3250000 0.466667
+ 31.3277778 0.458436
+ 31.3305556 0.458436
+ 31.3333333 0.462551
+ 31.3361111 0.466667
+ 31.3388889 0.472840
+ 31.3416667 0.474897
+ 31.3444444 0.470782
+ 31.3472222 0.466667
+ 31.3500000 0.462551
+ 31.3527778 0.458436
+ 31.3555556 0.464609
+ 31.3583333 0.460494
+ 31.3611111 0.464609
+ 31.3638889 0.464609
+ 31.3666667 0.464609
+ 31.3694444 0.472840
+ 31.3722222 0.472840
+ 31.3750000 0.476955
+ 31.3777778 0.483128
+ 31.3805556 0.487243
+ 31.3833333 0.497531
+ 31.3861111 0.489300
+ 31.3888889 0.474897
+ 31.3916667 0.458436
+ 31.3944444 0.448148
+ 31.3972222 0.441975
+ 31.4000000 0.439918
+ 31.4027778 0.450206
+ 31.4055556 0.456379
+ 31.4083333 0.462551
+ 31.4111111 0.464609
+ 31.4138889 0.468724
+ 31.4166667 0.468724
+ 31.4194444 0.472840
+ 31.4222222 0.466667
+ 31.4250000 0.468724
+ 31.4277778 0.470782
+ 31.4305556 0.468724
+ 31.4333333 0.466667
+ 31.4361111 0.466667
+ 31.4388889 0.462551
+ 31.4416667 0.468724
+ 31.4444444 0.472840
+ 31.4472222 0.476955
+ 31.4500000 0.481070
+ 31.4527778 0.476955
+ 31.4555556 0.476955
+ 31.4583333 0.474897
+ 31.4611111 0.474897
+ 31.4638889 0.474897
+ 31.4666667 0.462551
+ 31.4694444 0.468724
+ 31.4722222 0.472840
+ 31.4750000 0.481070
+ 31.4777778 0.483128
+ 31.4805556 0.474897
+ 31.4833333 0.468724
+ 31.4861111 0.458436
+ 31.4888889 0.458436
+ 31.4916667 0.462551
+ 31.4944444 0.466667
+ 31.4972222 0.464609
+ 31.5000000 0.462551
+ 31.5027778 0.464609
+ 31.5055556 0.464609
+ 31.5083333 0.468724
+ 31.5111111 0.472840
+ 31.5138889 0.472840
+ 31.5166667 0.479012
+ 31.5194444 0.476955
+ 31.5222222 0.472840
+ 31.5250000 0.472840
+ 31.5277778 0.476955
+ 31.5305556 0.474897
+ 31.5333333 0.476955
+ 31.5361111 0.476955
+ 31.5388889 0.474897
+ 31.5416667 0.472840
+ 31.5444444 0.470782
+ 31.5472222 0.468724
+ 31.5500000 0.470782
+ 31.5527778 0.466667
+ 31.5555556 0.464609
+ 31.5583333 0.470782
+ 31.5611111 0.472840
+ 31.5638889 0.474897
+ 31.5666667 0.479012
+ 31.5694444 0.476955
+ 31.5722222 0.483128
+ 31.5750000 0.483128
+ 31.5777778 0.485185
+ 31.5805556 0.491358
+ 31.5833333 0.487243
+ 31.5861111 0.487243
+ 31.5888889 0.485185
+ 31.5916667 0.476955
+ 31.5944444 0.474897
+ 31.5972222 0.474897
+ 31.6000000 0.479012
+ 31.6027778 0.481070
+ 31.6055556 0.476955
+ 31.6083333 0.472840
+ 31.6111111 0.472840
+ 31.6138889 0.474897
+ 31.6166667 0.479012
+ 31.6194444 0.483128
+ 31.6222222 0.485185
+ 31.6250000 0.481070
+ 31.6277778 0.489300
+ 31.6305556 0.487243
+ 31.6333333 0.491358
+ 31.6361111 0.497531
+ 31.6388889 0.501646
+ 31.6416667 0.503704
+ 31.6444444 0.503704
+ 31.6472222 0.503704
+ 31.6500000 0.503704
+ 31.6527778 0.499588
+ 31.6555556 0.505761
+ 31.6583333 0.509877
+ 31.6611111 0.516049
+ 31.6638889 0.520165
+ 31.6666667 0.522222
+ 31.6694444 0.522222
+ 31.6722222 0.524280
+ 31.6750000 0.520165
+ 31.6777778 0.516049
+ 31.6805556 0.505761
+ 31.6833333 0.497531
+ 31.6861111 0.493416
+ 31.6888889 0.493416
+ 31.6916667 0.487243
+ 31.6944444 0.493416
+ 31.6972222 0.495473
+ 31.7000000 0.497531
+ 31.7027778 0.495473
+ 31.7055556 0.487243
+ 31.7083333 0.487243
+ 31.7111111 0.485185
+ 31.7138889 0.485185
+ 31.7166667 0.487243
+ 31.7194444 0.491358
+ 31.7222222 0.491358
+ 31.7250000 0.493416
+ 31.7277778 0.487243
+ 31.7305556 0.489300
+ 31.7333333 0.485185
+ 31.7361111 0.485185
+ 31.7388889 0.481070
+ 31.7416667 0.487243
+ 31.7444444 0.483128
+ 31.7472222 0.474897
+ 31.7500000 0.466667
+ 31.7527778 0.462551
+ 31.7555556 0.454321
+ 31.7583333 0.460494
+ 31.7611111 0.464609
+ 31.7638889 0.470782
+ 31.7666667 0.479012
+ 31.7694444 0.491358
+ 31.7722222 0.497531
+ 31.7750000 0.499588
+ 31.7777778 0.491358
+ 31.7805556 0.483128
+ 31.7833333 0.476955
+ 31.7861111 0.460494
+ 31.7888889 0.458436
+ 31.7916667 0.456379
+ 31.7944444 0.460494
+ 31.7972222 0.474897
+ 31.8000000 0.487243
+ 31.8027778 0.483128
+ 31.8055556 0.489300
+ 31.8083333 0.493416
+ 31.8111111 0.495473
+ 31.8138889 0.501646
+ 31.8166667 0.497531
+ 31.8194444 0.503704
+ 31.8222222 0.503704
+ 31.8250000 0.518107
+ 31.8277778 0.540741
+ 31.8305556 0.579835
+ 31.8333333 0.625103
+ 31.8361111 0.666255
+ 31.8388889 0.699177
+ 31.8416667 0.721811
+ 31.8444444 0.701235
+ 31.8472222 0.643621
+ 31.8500000 0.565432
+ 31.8527778 0.479012
+ 31.8555556 0.409053
+ 31.8583333 0.378189
+ 31.8611111 0.357613
+ 31.8638889 0.367901
+ 31.8666667 0.382305
+ 31.8694444 0.392593
+ 31.8722222 0.409053
+ 31.8750000 0.415226
+ 31.8777778 0.415226
+ 31.8805556 0.411111
+ 31.8833333 0.400823
+ 31.8861111 0.388477
+ 31.8888889 0.388477
+ 31.8916667 0.384362
+ 31.8944444 0.390535
+ 31.8972222 0.396708
+ 31.9000000 0.404938
+ 31.9027778 0.415226
+ 31.9055556 0.423457
+ 31.9083333 0.425514
+ 31.9111111 0.423457
+ 31.9138889 0.415226
+ 31.9166667 0.411111
+ 31.9194444 0.400823
+ 31.9222222 0.400823
+ 31.9250000 0.400823
+ 31.9277778 0.409053
+ 31.9305556 0.415226
+ 31.9333333 0.429630
+ 31.9361111 0.452263
+ 31.9388889 0.464609
+ 31.9416667 0.470782
+ 31.9444444 0.476955
+ 31.9472222 0.483128
+ 31.9500000 0.485185
+ 31.9527778 0.487243
+ 31.9555556 0.487243
+ 31.9583333 0.485185
+ 31.9611111 0.481070
+ 31.9638889 0.474897
+ 31.9666667 0.476955
+ 31.9694444 0.474897
+ 31.9722222 0.474897
+ 31.9750000 0.483128
+ 31.9777778 0.485185
+ 31.9805556 0.485185
+ 31.9833333 0.491358
+ 31.9861111 0.495473
+ 31.9888889 0.497531
+ 31.9916667 0.495473
+ 31.9944444 0.493416
+ 31.9972222 0.487243
+ 32.0000000 0.479012
+ 32.0027778 0.479012
+ 32.0055556 0.483128
+ 32.0083333 0.483128
+ 32.0111111 0.487243
+ 32.0138889 0.489300
+ 32.0166667 0.485185
+ 32.0194444 0.485185
+ 32.0222222 0.483128
+ 32.0250000 0.489300
+ 32.0277778 0.489300
+ 32.0305556 0.495473
+ 32.0333333 0.495473
+ 32.0361111 0.495473
+ 32.0388889 0.499588
+ 32.0416667 0.503704
+ 32.0444444 0.497531
+ 32.0472222 0.499588
+ 32.0500000 0.503704
+ 32.0527778 0.503704
+ 32.0555556 0.497531
+ 32.0583333 0.491358
+ 32.0611111 0.493416
+ 32.0638889 0.497531
+ 32.0666667 0.509877
+ 32.0694444 0.516049
+ 32.0722222 0.522222
+ 32.0750000 0.528395
+ 32.0777778 0.532510
+ 32.0805556 0.522222
+ 32.0833333 0.518107
+ 32.0861111 0.516049
+ 32.0888889 0.518107
+ 32.0916667 0.520165
+ 32.0944444 0.532510
+ 32.0972222 0.544856
+ 32.1000000 0.559259
+ 32.1027778 0.571605
+ 32.1055556 0.563374
+ 32.1083333 0.557202
+ 32.1111111 0.544856
+ 32.1138889 0.538683
+ 32.1166667 0.536626
+ 32.1194444 0.536626
+ 32.1222222 0.542798
+ 32.1250000 0.548971
+ 32.1277778 0.557202
+ 32.1305556 0.563374
+ 32.1333333 0.571605
+ 32.1361111 0.577778
+ 32.1388889 0.575720
+ 32.1416667 0.583951
+ 32.1444444 0.579835
+ 32.1472222 0.573663
+ 32.1500000 0.573663
+ 32.1527778 0.563374
+ 32.1555556 0.565432
+ 32.1583333 0.561317
+ 32.1611111 0.563374
+ 32.1638889 0.563374
+ 32.1666667 0.567490
+ 32.1694444 0.573663
+ 32.1722222 0.577778
+ 32.1750000 0.583951
+ 32.1777778 0.579835
+ 32.1805556 0.575720
+ 32.1833333 0.561317
+ 32.1861111 0.548971
+ 32.1888889 0.536626
+ 32.1916667 0.532510
+ 32.1944444 0.526337
+ 32.1972222 0.520165
+ 32.2000000 0.518107
+ 32.2027778 0.518107
+ 32.2055556 0.516049
+ 32.2083333 0.524280
+ 32.2111111 0.522222
+ 32.2138889 0.520165
+ 32.2166667 0.513992
+ 32.2194444 0.501646
+ 32.2222222 0.495473
+ 32.2250000 0.489300
+ 32.2277778 0.489300
+ 32.2305556 0.493416
+ 32.2333333 0.497531
+ 32.2361111 0.501646
+ 32.2388889 0.501646
+ 32.2416667 0.493416
+ 32.2444444 0.483128
+ 32.2472222 0.472840
+ 32.2500000 0.472840
+ 32.2527778 0.474897
+ 32.2555556 0.474897
+ 32.2583333 0.479012
+ 32.2611111 0.472840
+ 32.2638889 0.474897
+ 32.2666667 0.481070
+ 32.2694444 0.493416
+ 32.2722222 0.497531
+ 32.2750000 0.493416
+ 32.2777778 0.481070
+ 32.2805556 0.466667
+ 32.2833333 0.464609
+ 32.2861111 0.468724
+ 32.2888889 0.479012
+ 32.2916667 0.479012
+ 32.2944444 0.487243
+ 32.2972222 0.491358
+ 32.3000000 0.497531
+ 32.3027778 0.501646
+ 32.3055556 0.509877
+ 32.3083333 0.513992
+ 32.3111111 0.518107
+ 32.3138889 0.509877
+ 32.3166667 0.509877
+ 32.3194444 0.503704
+ 32.3222222 0.497531
+ 32.3250000 0.495473
+ 32.3277778 0.491358
+ 32.3305556 0.495473
+ 32.3333333 0.497531
+ 32.3361111 0.507819
+ 32.3388889 0.518107
+ 32.3416667 0.528395
+ 32.3444444 0.528395
+ 32.3472222 0.526337
+ 32.3500000 0.522222
+ 32.3527778 0.513992
+ 32.3555556 0.505761
+ 32.3583333 0.505761
+ 32.3611111 0.503704
+ 32.3638889 0.499588
+ 32.3666667 0.497531
+ 32.3694444 0.499588
+ 32.3722222 0.491358
+ 32.3750000 0.485185
+ 32.3777778 0.476955
+ 32.3805556 0.474897
+ 32.3833333 0.479012
+ 32.3861111 0.481070
+ 32.3888889 0.485185
+ 32.3916667 0.495473
+ 32.3944444 0.503704
+ 32.3972222 0.511934
+ 32.4000000 0.513992
+ 32.4027778 0.516049
+ 32.4055556 0.509877
+ 32.4083333 0.505761
+ 32.4111111 0.501646
+ 32.4138889 0.497531
+ 32.4166667 0.495473
+ 32.4194444 0.481070
+ 32.4222222 0.485185
+ 32.4250000 0.489300
+ 32.4277778 0.499588
+ 32.4305556 0.501646
+ 32.4333333 0.507819
+ 32.4361111 0.509877
+ 32.4388889 0.505761
+ 32.4416667 0.501646
+ 32.4444444 0.491358
+ 32.4472222 0.483128
+ 32.4500000 0.487243
+ 32.4527778 0.481070
+ 32.4555556 0.485185
+ 32.4583333 0.481070
+ 32.4611111 0.479012
+ 32.4638889 0.481070
+ 32.4666667 0.483128
+ 32.4694444 0.487243
+ 32.4722222 0.499588
+ 32.4750000 0.509877
+ 32.4777778 0.516049
+ 32.4805556 0.513992
+ 32.4833333 0.507819
+ 32.4861111 0.497531
+ 32.4888889 0.491358
+ 32.4916667 0.491358
+ 32.4944444 0.513992
+ 32.4972222 0.544856
+ 32.5000000 0.596296
+ 32.5027778 0.645679
+ 32.5055556 0.697119
+ 32.5083333 0.738272
+ 32.5111111 0.771193
+ 32.5138889 0.781481
+ 32.5166667 0.769136
+ 32.5194444 0.717695
+ 32.5222222 0.625103
+ 32.5250000 0.524280
+ 32.5277778 0.435802
+ 32.5305556 0.378189
+ 32.5333333 0.357613
+ 32.5361111 0.357613
+ 32.5388889 0.374074
+ 32.5416667 0.394650
+ 32.5444444 0.411111
+ 32.5472222 0.427572
+ 32.5500000 0.431687
+ 32.5527778 0.425514
+ 32.5555556 0.415226
+ 32.5583333 0.402881
+ 32.5611111 0.388477
+ 32.5638889 0.380247
+ 32.5666667 0.386420
+ 32.5694444 0.398765
+ 32.5722222 0.417284
+ 32.5750000 0.431687
+ 32.5777778 0.441975
+ 32.5805556 0.448148
+ 32.5833333 0.448148
+ 32.5861111 0.441975
+ 32.5888889 0.429630
+ 32.5916667 0.425514
+ 32.5944444 0.421399
+ 32.5972222 0.421399
+ 32.6000000 0.419342
+ 32.6027778 0.421399
+ 32.6055556 0.431687
+ 32.6083333 0.448148
+ 32.6111111 0.466667
+ 32.6138889 0.476955
+ 32.6166667 0.487243
+ 32.6194444 0.489300
+ 32.6222222 0.493416
+ 32.6250000 0.491358
+ 32.6277778 0.485185
+ 32.6305556 0.485185
+ 32.6333333 0.483128
+ 32.6361111 0.485185
+ 32.6388889 0.483128
+ 32.6416667 0.485185
+ 32.6444444 0.491358
+ 32.6472222 0.493416
+ 32.6500000 0.495473
+ 32.6527778 0.491358
+ 32.6555556 0.487243
+ 32.6583333 0.479012
+ 32.6611111 0.474897
+ 32.6638889 0.474897
+ 32.6666667 0.483128
+ 32.6694444 0.491358
+ 32.6722222 0.503704
+ 32.6750000 0.507819
+ 32.6777778 0.501646
+ 32.6805556 0.497531
+ 32.6833333 0.497531
+ 32.6861111 0.497531
+ 32.6888889 0.499588
+ 32.6916667 0.503704
+ 32.6944444 0.505761
+ 32.6972222 0.505761
+ 32.7000000 0.509877
+ 32.7027778 0.518107
+ 32.7055556 0.522222
+ 32.7083333 0.522222
+ 32.7111111 0.516049
+ 32.7138889 0.499588
+ 32.7166667 0.483128
+ 32.7194444 0.487243
+ 32.7222222 0.493416
+ 32.7250000 0.511934
+ 32.7277778 0.520165
+ 32.7305556 0.534568
+ 32.7333333 0.536626
+ 32.7361111 0.528395
+ 32.7388889 0.518107
+ 32.7416667 0.520165
+ 32.7444444 0.526337
+ 32.7472222 0.534568
+ 32.7500000 0.540741
+ 32.7527778 0.544856
+ 32.7555556 0.553086
+ 32.7583333 0.546914
+ 32.7611111 0.546914
+ 32.7638889 0.540741
+ 32.7666667 0.544856
+ 32.7694444 0.557202
+ 32.7722222 0.571605
+ 32.7750000 0.586008
+ 32.7777778 0.592181
+ 32.7805556 0.583951
+ 32.7833333 0.575720
+ 32.7861111 0.567490
+ 32.7888889 0.563374
+ 32.7916667 0.567490
+ 32.7944444 0.575720
+ 32.7972222 0.581893
+ 32.8000000 0.596296
+ 32.8027778 0.602469
+ 32.8055556 0.598354
+ 32.8083333 0.594239
+ 32.8111111 0.590123
+ 32.8138889 0.588066
+ 32.8166667 0.588066
+ 32.8194444 0.586008
+ 32.8222222 0.590123
+ 32.8250000 0.588066
+ 32.8277778 0.586008
+ 32.8305556 0.586008
+ 32.8333333 0.590123
+ 32.8361111 0.588066
+ 32.8388889 0.586008
+ 32.8416667 0.579835
+ 32.8444444 0.575720
+ 32.8472222 0.567490
+ 32.8500000 0.561317
+ 32.8527778 0.561317
+ 32.8555556 0.559259
+ 32.8583333 0.553086
+ 32.8611111 0.542798
+ 32.8638889 0.532510
+ 32.8666667 0.524280
+ 32.8694444 0.518107
+ 32.8722222 0.516049
+ 32.8750000 0.524280
+ 32.8777778 0.520165
+ 32.8805556 0.516049
+ 32.8833333 0.505761
+ 32.8861111 0.495473
+ 32.8888889 0.487243
+ 32.8916667 0.489300
+ 32.8944444 0.491358
+ 32.8972222 0.489300
+ 32.9000000 0.495473
+ 32.9027778 0.497531
+ 32.9055556 0.487243
+ 32.9083333 0.487243
+ 32.9111111 0.479012
+ 32.9138889 0.474897
+ 32.9166667 0.481070
+ 32.9194444 0.481070
+ 32.9222222 0.479012
+ 32.9250000 0.474897
+ 32.9277778 0.468724
+ 32.9305556 0.468724
+ 32.9333333 0.470782
+ 32.9361111 0.474897
+ 32.9388889 0.476955
+ 32.9416667 0.485185
+ 32.9444444 0.489300
+ 32.9472222 0.493416
+ 32.9500000 0.487243
+ 32.9527778 0.481070
+ 32.9555556 0.476955
+ 32.9583333 0.476955
+ 32.9611111 0.479012
+ 32.9638889 0.489300
+ 32.9666667 0.489300
+ 32.9694444 0.497531
+ 32.9722222 0.495473
+ 32.9750000 0.497531
+ 32.9777778 0.489300
+ 32.9805556 0.472840
+ 32.9833333 0.464609
+ 32.9861111 0.454321
+ 32.9888889 0.452263
+ 32.9916667 0.458436
+ 32.9944444 0.460494
+ 32.9972222 0.466667
+ 33.0000000 0.472840
+ 33.0027778 0.476955
+ 33.0055556 0.479012
+ 33.0083333 0.485185
+ 33.0111111 0.479012
+ 33.0138889 0.470782
+ 33.0166667 0.470782
+ 33.0194444 0.462551
+ 33.0222222 0.460494
+ 33.0250000 0.464609
+ 33.0277778 0.472840
+ 33.0305556 0.472840
+ 33.0333333 0.474897
+ 33.0361111 0.472840
+ 33.0388889 0.476955
+ 33.0416667 0.483128
+ 33.0444444 0.493416
+ 33.0472222 0.497531
+ 33.0500000 0.503704
+ 33.0527778 0.495473
+ 33.0555556 0.487243
+ 33.0583333 0.476955
+ 33.0611111 0.472840
+ 33.0638889 0.476955
+ 33.0666667 0.479012
+ 33.0694444 0.485185
+ 33.0722222 0.497531
+ 33.0750000 0.501646
+ 33.0777778 0.501646
+ 33.0805556 0.497531
+ 33.0833333 0.485185
+ 33.0861111 0.468724
+ 33.0888889 0.462551
+ 33.0916667 0.462551
+ 33.0944444 0.464609
+ 33.0972222 0.474897
+ 33.1000000 0.483128
+ 33.1027778 0.483128
+ 33.1055556 0.481070
+ 33.1083333 0.483128
+ 33.1111111 0.483128
+ 33.1138889 0.481070
+ 33.1166667 0.481070
+ 33.1194444 0.483128
+ 33.1222222 0.481070
+ 33.1250000 0.479012
+ 33.1277778 0.479012
+ 33.1305556 0.476955
+ 33.1333333 0.470782
+ 33.1361111 0.468724
+ 33.1388889 0.470782
+ 33.1416667 0.474897
+ 33.1444444 0.476955
+ 33.1472222 0.479012
+ 33.1500000 0.483128
+ 33.1527778 0.489300
+ 33.1555556 0.495473
+ 33.1583333 0.495473
+ 33.1611111 0.495473
+ 33.1638889 0.489300
+ 33.1666667 0.485185
+ 33.1694444 0.489300
+ 33.1722222 0.489300
+ 33.1750000 0.489300
+ 33.1777778 0.483128
+ 33.1805556 0.468724
+ 33.1833333 0.462551
+ 33.1861111 0.452263
+ 33.1888889 0.452263
+ 33.1916667 0.458436
+ 33.1944444 0.464609
+ 33.1972222 0.472840
+ 33.2000000 0.472840
+ 33.2027778 0.472840
+ 33.2055556 0.470782
+ 33.2083333 0.476955
+ 33.2111111 0.479012
+ 33.2138889 0.487243
+ 33.2166667 0.495473
+ 33.2194444 0.495473
+ 33.2222222 0.495473
+ 33.2250000 0.489300
+ 33.2277778 0.487243
+ 33.2305556 0.485185
+ 33.2333333 0.489300
+ 33.2361111 0.495473
+ 33.2388889 0.501646
+ 33.2416667 0.513992
+ 33.2444444 0.540741
+ 33.2472222 0.573663
+ 33.2500000 0.618930
+ 33.2527778 0.668313
+ 33.2555556 0.713580
+ 33.2583333 0.750617
+ 33.2611111 0.775309
+ 33.2638889 0.781481
+ 33.2666667 0.750617
+ 33.2694444 0.680658
+ 33.2722222 0.575720
+ 33.2750000 0.479012
+ 33.2777778 0.404938
+ 33.2805556 0.357613
+ 33.2833333 0.339095
+ 33.2861111 0.332922
+ 33.2888889 0.337037
+ 33.2916667 0.341152
+ 33.2944444 0.349383
+ 33.2972222 0.363786
+ 33.3000000 0.380247
+ 33.3027778 0.390535
+ 33.3055556 0.392593
+ 33.3083333 0.384362
+ 33.3111111 0.378189
+ 33.3138889 0.372016
+ 33.3166667 0.376132
+ 33.3194444 0.384362
+ 33.3222222 0.400823
+ 33.3250000 0.415226
+ 33.3277778 0.423457
+ 33.3305556 0.425514
+ 33.3333333 0.421399
+ 33.3361111 0.415226
+ 33.3388889 0.413169
+ 33.3416667 0.411111
+ 33.3444444 0.409053
+ 33.3472222 0.396708
+ 33.3500000 0.398765
+ 33.3527778 0.394650
+ 33.3555556 0.398765
+ 33.3583333 0.406996
+ 33.3611111 0.423457
+ 33.3638889 0.439918
+ 33.3666667 0.456379
+ 33.3694444 0.479012
+ 33.3722222 0.483128
+ 33.3750000 0.491358
+ 33.3777778 0.493416
+ 33.3805556 0.489300
+ 33.3833333 0.487243
+ 33.3861111 0.485185
+ 33.3888889 0.485185
+ 33.3916667 0.476955
+ 33.3944444 0.470782
+ 33.3972222 0.466667
+ 33.4000000 0.462551
+ 33.4027778 0.462551
+ 33.4055556 0.466667
+ 33.4083333 0.468724
+ 33.4111111 0.468724
+ 33.4138889 0.474897
+ 33.4166667 0.472840
+ 33.4194444 0.474897
+ 33.4222222 0.470782
+ 33.4250000 0.470782
+ 33.4277778 0.472840
+ 33.4305556 0.470782
+ 33.4333333 0.474897
+ 33.4361111 0.483128
+ 33.4388889 0.481070
+ 33.4416667 0.491358
+ 33.4444444 0.493416
+ 33.4472222 0.505761
+ 33.4500000 0.505761
+ 33.4527778 0.509877
+ 33.4555556 0.503704
+ 33.4583333 0.495473
+ 33.4611111 0.483128
+ 33.4638889 0.479012
+ 33.4666667 0.472840
+ 33.4694444 0.474897
+ 33.4722222 0.474897
+ 33.4750000 0.483128
+ 33.4777778 0.489300
+ 33.4805556 0.497531
+ 33.4833333 0.507819
+ 33.4861111 0.507819
+ 33.4888889 0.507819
+ 33.4916667 0.507819
+ 33.4944444 0.505761
+ 33.4972222 0.495473
+ 33.5000000 0.499588
+ 33.5027778 0.499588
+ 33.5055556 0.505761
+ 33.5083333 0.518107
+ 33.5111111 0.526337
+ 33.5138889 0.538683
+ 33.5166667 0.544856
+ 33.5194444 0.551029
+ 33.5222222 0.548971
+ 33.5250000 0.544856
+ 33.5277778 0.546914
+ 33.5305556 0.551029
+ 33.5333333 0.553086
+ 33.5361111 0.561317
+ 33.5388889 0.565432
+ 33.5416667 0.571605
+ 33.5444444 0.571605
+ 33.5472222 0.573663
+ 33.5500000 0.575720
+ 33.5527778 0.579835
+ 33.5555556 0.579835
+ 33.5583333 0.571605
+ 33.5611111 0.563374
+ 33.5638889 0.561317
+ 33.5666667 0.563374
+ 33.5694444 0.563374
+ 33.5722222 0.571605
+ 33.5750000 0.573663
+ 33.5777778 0.573663
+ 33.5805556 0.563374
+ 33.5833333 0.569547
+ 33.5861111 0.563374
+ 33.5888889 0.567490
+ 33.5916667 0.569547
+ 33.5944444 0.565432
+ 33.5972222 0.561317
+ 33.6000000 0.553086
+ 33.6027778 0.553086
+ 33.6055556 0.551029
+ 33.6083333 0.551029
+ 33.6111111 0.540741
+ 33.6138889 0.524280
+ 33.6166667 0.509877
+ 33.6194444 0.495473
+ 33.6222222 0.491358
+ 33.6250000 0.497531
+ 33.6277778 0.495473
+ 33.6305556 0.501646
+ 33.6333333 0.501646
+ 33.6361111 0.499588
+ 33.6388889 0.497531
+ 33.6416667 0.501646
+ 33.6444444 0.509877
+ 33.6472222 0.505761
+ 33.6500000 0.499588
+ 33.6527778 0.485185
+ 33.6555556 0.466667
+ 33.6583333 0.458436
+ 33.6611111 0.458436
+ 33.6638889 0.460494
+ 33.6666667 0.466667
+ 33.6694444 0.474897
+ 33.6722222 0.476955
+ 33.6750000 0.481070
+ 33.6777778 0.481070
+ 33.6805556 0.468724
+ 33.6833333 0.456379
+ 33.6861111 0.446091
+ 33.6888889 0.441975
+ 33.6916667 0.448148
+ 33.6944444 0.456379
+ 33.6972222 0.464609
+ 33.7000000 0.474897
+ 33.7027778 0.487243
+ 33.7055556 0.495473
+ 33.7083333 0.491358
+ 33.7111111 0.481070
+ 33.7138889 0.470782
+ 33.7166667 0.454321
+ 33.7194444 0.444033
+ 33.7222222 0.433745
+ 33.7250000 0.431687
+ 33.7277778 0.433745
+ 33.7305556 0.435802
+ 33.7333333 0.450206
+ 33.7361111 0.460494
+ 33.7388889 0.468724
+ 33.7416667 0.472840
+ 33.7444444 0.470782
+ 33.7472222 0.460494
+ 33.7500000 0.458436
+ 33.7527778 0.454321
+ 33.7555556 0.454321
+ 33.7583333 0.458436
+ 33.7611111 0.460494
+ 33.7638889 0.464609
+ 33.7666667 0.466667
+ 33.7694444 0.466667
+ 33.7722222 0.468724
+ 33.7750000 0.479012
+ 33.7777778 0.481070
+ 33.7805556 0.487243
+ 33.7833333 0.487243
+ 33.7861111 0.479012
+ 33.7888889 0.468724
+ 33.7916667 0.462551
+ 33.7944444 0.460494
+ 33.7972222 0.464609
+ 33.8000000 0.468724
+ 33.8027778 0.474897
+ 33.8055556 0.481070
+ 33.8083333 0.485185
+ 33.8111111 0.476955
+ 33.8138889 0.483128
+ 33.8166667 0.481070
+ 33.8194444 0.479012
+ 33.8222222 0.476955
+ 33.8250000 0.472840
+ 33.8277778 0.468724
+ 33.8305556 0.466667
+ 33.8333333 0.458436
+ 33.8361111 0.458436
+ 33.8388889 0.458436
+ 33.8416667 0.464609
+ 33.8444444 0.476955
+ 33.8472222 0.476955
+ 33.8500000 0.479012
+ 33.8527778 0.472840
+ 33.8555556 0.468724
+ 33.8583333 0.462551
+ 33.8611111 0.454321
+ 33.8638889 0.444033
+ 33.8666667 0.446091
+ 33.8694444 0.454321
+ 33.8722222 0.458436
+ 33.8750000 0.472840
+ 33.8777778 0.479012
+ 33.8805556 0.476955
+ 33.8833333 0.476955
+ 33.8861111 0.474897
+ 33.8888889 0.474897
+ 33.8916667 0.470782
+ 33.8944444 0.464609
+ 33.8972222 0.460494
+ 33.9000000 0.458436
+ 33.9027778 0.462551
+ 33.9055556 0.468724
+ 33.9083333 0.470782
+ 33.9111111 0.479012
+ 33.9138889 0.472840
+ 33.9166667 0.462551
+ 33.9194444 0.460494
+ 33.9222222 0.456379
+ 33.9250000 0.460494
+ 33.9277778 0.462551
+ 33.9305556 0.466667
+ 33.9333333 0.481070
+ 33.9361111 0.487243
+ 33.9388889 0.489300
+ 33.9416667 0.487243
+ 33.9444444 0.487243
+ 33.9472222 0.483128
+ 33.9500000 0.485185
+ 33.9527778 0.476955
+ 33.9555556 0.481070
+ 33.9583333 0.479012
+ 33.9611111 0.483128
+ 33.9638889 0.489300
+ 33.9666667 0.493416
+ 33.9694444 0.499588
+ 33.9722222 0.503704
+ 33.9750000 0.520165
+ 33.9777778 0.551029
+ 33.9805556 0.600412
+ 33.9833333 0.653909
+ 33.9861111 0.697119
+ 33.9888889 0.738272
+ 33.9916667 0.765021
+ 33.9944444 0.773251
+ 33.9972222 0.746502
+ 34.0000000 0.672428
+ 34.0027778 0.579835
+ 34.0055556 0.481070
+ 34.0083333 0.400823
+ 34.0111111 0.345267
+ 34.0138889 0.318519
+ 34.0166667 0.312346
+ 34.0194444 0.322634
+ 34.0222222 0.332922
+ 34.0250000 0.355556
+ 34.0277778 0.372016
+ 34.0305556 0.386420
+ 34.0333333 0.384362
+ 34.0361111 0.380247
+ 34.0388889 0.374074
+ 34.0416667 0.365844
+ 34.0444444 0.365844
+ 34.0472222 0.374074
+ 34.0500000 0.384362
+ 34.0527778 0.398765
+ 34.0555556 0.394650
+ 34.0583333 0.390535
+ )

* === ARM SIGNAL (simulated rpeak_level_held) ===
Varm arm_signal 0 PWL(
+ 0 0
+ 2.0441222 0
+ 2.0442222 0.9
+ 2.1272222 0.9
+ 2.1273222 0
+ 2.7746778 0
+ 2.7747778 0.9
+ 2.8577778 0.9
+ 2.8578778 0
+ 4.6052333 0
+ 4.6053333 0.9
+ 4.6883333 0.9
+ 4.6884333 0
+ 5.2830111 0
+ 5.2831111 0.9
+ 5.3661111 0.9
+ 5.3662111 0
+ 5.9857889 0
+ 5.9858889 0.9
+ 6.0688889 0.9
+ 6.0689889 0
+ 7.8552333 0
+ 7.8553333 0.9
+ 7.9383333 0.9
+ 7.9384333 0
+ 8.5135667 0
+ 8.5136667 0.9
+ 8.5966667 0.9
+ 8.5967667 0
+ 10.1830111 0
+ 10.1831111 0.9
+ 10.2661111 0.9
+ 10.2662111 0
+ 10.8552333 0
+ 10.8553333 0.9
+ 10.9383333 0.9
+ 10.9384333 0
+ 12.5274556 0
+ 12.5275556 0.9
+ 12.6105556 0.9
+ 12.6106556 0
+ 13.1941222 0
+ 13.1942222 0.9
+ 13.2772222 0.9
+ 13.2773222 0
+ 14.8330111 0
+ 14.8331111 0.9
+ 14.9161111 0.9
+ 14.9162111 0
+ 15.5080111 0
+ 15.5081111 0.9
+ 15.5911111 0.9
+ 15.5912111 0
+ 16.2607889 0
+ 16.2608889 0.9
+ 16.3438889 0.9
+ 16.3439889 0
+ 18.0024556 0
+ 18.0025556 0.9
+ 18.0855556 0.9
+ 18.0856556 0
+ 18.6663444 0
+ 18.6664444 0.9
+ 18.7494444 0.9
+ 18.7495444 0
+ 19.3913444 0
+ 19.3914444 0.9
+ 19.4744444 0.9
+ 19.4745444 0
+ 20.0857889 0
+ 20.0858889 0.9
+ 20.1688889 0.9
+ 20.1689889 0
+ 20.8107889 0
+ 20.8108889 0.9
+ 20.8938889 0.9
+ 20.8939889 0
+ 21.5357889 0
+ 21.5358889 0.9
+ 21.6188889 0.9
+ 21.6189889 0
+ 22.2274556 0
+ 22.2275556 0.9
+ 22.3105556 0.9
+ 22.3106556 0
+ 22.9274556 0
+ 22.9275556 0.9
+ 23.0105556 0.9
+ 23.0106556 0
+ 24.8330111 0
+ 24.8331111 0.9
+ 24.9161111 0.9
+ 24.9162111 0
+ 27.4691222 0
+ 27.4692222 0.9
+ 27.5522222 0.9
+ 27.5523222 0
+ 28.5941222 0
+ 28.5942222 0.9
+ 28.6772222 0.9
+ 28.6773222 0
+ 29.2746778 0
+ 29.2747778 0.9
+ 29.3577778 0.9
+ 29.3578778 0
+ 29.9857889 0
+ 29.9858889 0.9
+ 30.0688889 0.9
+ 30.0689889 0
+ 31.8357889 0
+ 31.8358889 0.9
+ 31.9188889 0.9
+ 31.9189889 0
+ 32.5080111 0
+ 32.5081111 0.9
+ 32.5911111 0.9
+ 32.5912111 0
+ 33.2580111 0
+ 33.2581111 0.9
+ 33.3411111 0.9
+ 33.3412111 0
+ 34.5583333 0
+ )

* === DEVICE UNDER TEST ===
Xtpd ecg_in arm_signal peak_detected vdd vss vbias true_peak_detector
.ic V(xtpd.peak_hold)=0.51

* === MEASUREMENTS ===
.meas tran t_det_0 WHEN V(peak_detected)=0.45 RISE=1
.meas tran lat_0 PARAM='t_det_0 - 2.0472222'
.meas tran v_hold_0 FIND V(xtpd.peak_hold) AT=2.0472222
.meas tran v_ecg_0 FIND V(ecg_in) AT=2.0472222
.meas tran t_det_1 WHEN V(peak_detected)=0.45 RISE=2
.meas tran lat_1 PARAM='t_det_1 - 2.7777778'
.meas tran v_hold_1 FIND V(xtpd.peak_hold) AT=2.7777778
.meas tran v_ecg_1 FIND V(ecg_in) AT=2.7777778
.meas tran t_det_2 WHEN V(peak_detected)=0.45 RISE=3
.meas tran lat_2 PARAM='t_det_2 - 4.6083333'
.meas tran v_hold_2 FIND V(xtpd.peak_hold) AT=4.6083333
.meas tran v_ecg_2 FIND V(ecg_in) AT=4.6083333
.meas tran t_det_3 WHEN V(peak_detected)=0.45 RISE=4
.meas tran lat_3 PARAM='t_det_3 - 5.2861111'
.meas tran v_hold_3 FIND V(xtpd.peak_hold) AT=5.2861111
.meas tran v_ecg_3 FIND V(ecg_in) AT=5.2861111
.meas tran t_det_4 WHEN V(peak_detected)=0.45 RISE=5
.meas tran lat_4 PARAM='t_det_4 - 5.9888889'
.meas tran v_hold_4 FIND V(xtpd.peak_hold) AT=5.9888889
.meas tran v_ecg_4 FIND V(ecg_in) AT=5.9888889
.meas tran t_det_5 WHEN V(peak_detected)=0.45 RISE=6
.meas tran lat_5 PARAM='t_det_5 - 7.8583333'
.meas tran v_hold_5 FIND V(xtpd.peak_hold) AT=7.8583333
.meas tran v_ecg_5 FIND V(ecg_in) AT=7.8583333
.meas tran t_det_6 WHEN V(peak_detected)=0.45 RISE=7
.meas tran lat_6 PARAM='t_det_6 - 8.5166667'
.meas tran v_hold_6 FIND V(xtpd.peak_hold) AT=8.5166667
.meas tran v_ecg_6 FIND V(ecg_in) AT=8.5166667
.meas tran t_det_7 WHEN V(peak_detected)=0.45 RISE=8
.meas tran lat_7 PARAM='t_det_7 - 10.1861111'
.meas tran v_hold_7 FIND V(xtpd.peak_hold) AT=10.1861111
.meas tran v_ecg_7 FIND V(ecg_in) AT=10.1861111
.meas tran t_det_8 WHEN V(peak_detected)=0.45 RISE=9
.meas tran lat_8 PARAM='t_det_8 - 10.8583333'
.meas tran v_hold_8 FIND V(xtpd.peak_hold) AT=10.8583333
.meas tran v_ecg_8 FIND V(ecg_in) AT=10.8583333
.meas tran t_det_9 WHEN V(peak_detected)=0.45 RISE=10
.meas tran lat_9 PARAM='t_det_9 - 12.5305556'
.meas tran v_hold_9 FIND V(xtpd.peak_hold) AT=12.5305556
.meas tran v_ecg_9 FIND V(ecg_in) AT=12.5305556
.meas tran t_det_10 WHEN V(peak_detected)=0.45 RISE=11
.meas tran lat_10 PARAM='t_det_10 - 13.1972222'
.meas tran v_hold_10 FIND V(xtpd.peak_hold) AT=13.1972222
.meas tran v_ecg_10 FIND V(ecg_in) AT=13.1972222
.meas tran t_det_11 WHEN V(peak_detected)=0.45 RISE=12
.meas tran lat_11 PARAM='t_det_11 - 14.8361111'
.meas tran v_hold_11 FIND V(xtpd.peak_hold) AT=14.8361111
.meas tran v_ecg_11 FIND V(ecg_in) AT=14.8361111
.meas tran t_det_12 WHEN V(peak_detected)=0.45 RISE=13
.meas tran lat_12 PARAM='t_det_12 - 15.5111111'
.meas tran v_hold_12 FIND V(xtpd.peak_hold) AT=15.5111111
.meas tran v_ecg_12 FIND V(ecg_in) AT=15.5111111
.meas tran t_det_13 WHEN V(peak_detected)=0.45 RISE=14
.meas tran lat_13 PARAM='t_det_13 - 16.2638889'
.meas tran v_hold_13 FIND V(xtpd.peak_hold) AT=16.2638889
.meas tran v_ecg_13 FIND V(ecg_in) AT=16.2638889
.meas tran t_det_14 WHEN V(peak_detected)=0.45 RISE=15
.meas tran lat_14 PARAM='t_det_14 - 18.0055556'
.meas tran v_hold_14 FIND V(xtpd.peak_hold) AT=18.0055556
.meas tran v_ecg_14 FIND V(ecg_in) AT=18.0055556
.meas tran t_det_15 WHEN V(peak_detected)=0.45 RISE=16
.meas tran lat_15 PARAM='t_det_15 - 18.6694444'
.meas tran v_hold_15 FIND V(xtpd.peak_hold) AT=18.6694444
.meas tran v_ecg_15 FIND V(ecg_in) AT=18.6694444
.meas tran t_det_16 WHEN V(peak_detected)=0.45 RISE=17
.meas tran lat_16 PARAM='t_det_16 - 19.3944444'
.meas tran v_hold_16 FIND V(xtpd.peak_hold) AT=19.3944444
.meas tran v_ecg_16 FIND V(ecg_in) AT=19.3944444
.meas tran t_det_17 WHEN V(peak_detected)=0.45 RISE=18
.meas tran lat_17 PARAM='t_det_17 - 20.0888889'
.meas tran v_hold_17 FIND V(xtpd.peak_hold) AT=20.0888889
.meas tran v_ecg_17 FIND V(ecg_in) AT=20.0888889
.meas tran t_det_18 WHEN V(peak_detected)=0.45 RISE=19
.meas tran lat_18 PARAM='t_det_18 - 20.8138889'
.meas tran v_hold_18 FIND V(xtpd.peak_hold) AT=20.8138889
.meas tran v_ecg_18 FIND V(ecg_in) AT=20.8138889
.meas tran t_det_19 WHEN V(peak_detected)=0.45 RISE=20
.meas tran lat_19 PARAM='t_det_19 - 21.5388889'
.meas tran v_hold_19 FIND V(xtpd.peak_hold) AT=21.5388889
.meas tran v_ecg_19 FIND V(ecg_in) AT=21.5388889
.meas tran t_det_20 WHEN V(peak_detected)=0.45 RISE=21
.meas tran lat_20 PARAM='t_det_20 - 22.2305556'
.meas tran v_hold_20 FIND V(xtpd.peak_hold) AT=22.2305556
.meas tran v_ecg_20 FIND V(ecg_in) AT=22.2305556
.meas tran t_det_21 WHEN V(peak_detected)=0.45 RISE=22
.meas tran lat_21 PARAM='t_det_21 - 22.9305556'
.meas tran v_hold_21 FIND V(xtpd.peak_hold) AT=22.9305556
.meas tran v_ecg_21 FIND V(ecg_in) AT=22.9305556
.meas tran t_det_22 WHEN V(peak_detected)=0.45 RISE=23
.meas tran lat_22 PARAM='t_det_22 - 24.8361111'
.meas tran v_hold_22 FIND V(xtpd.peak_hold) AT=24.8361111
.meas tran v_ecg_22 FIND V(ecg_in) AT=24.8361111
.meas tran t_det_23 WHEN V(peak_detected)=0.45 RISE=24
.meas tran lat_23 PARAM='t_det_23 - 27.4722222'
.meas tran v_hold_23 FIND V(xtpd.peak_hold) AT=27.4722222
.meas tran v_ecg_23 FIND V(ecg_in) AT=27.4722222
.meas tran t_det_24 WHEN V(peak_detected)=0.45 RISE=25
.meas tran lat_24 PARAM='t_det_24 - 28.5972222'
.meas tran v_hold_24 FIND V(xtpd.peak_hold) AT=28.5972222
.meas tran v_ecg_24 FIND V(ecg_in) AT=28.5972222
.meas tran t_det_25 WHEN V(peak_detected)=0.45 RISE=26
.meas tran lat_25 PARAM='t_det_25 - 29.2777778'
.meas tran v_hold_25 FIND V(xtpd.peak_hold) AT=29.2777778
.meas tran v_ecg_25 FIND V(ecg_in) AT=29.2777778
.meas tran t_det_26 WHEN V(peak_detected)=0.45 RISE=27
.meas tran lat_26 PARAM='t_det_26 - 29.9888889'
.meas tran v_hold_26 FIND V(xtpd.peak_hold) AT=29.9888889
.meas tran v_ecg_26 FIND V(ecg_in) AT=29.9888889
.meas tran t_det_27 WHEN V(peak_detected)=0.45 RISE=28
.meas tran lat_27 PARAM='t_det_27 - 31.8388889'
.meas tran v_hold_27 FIND V(xtpd.peak_hold) AT=31.8388889
.meas tran v_ecg_27 FIND V(ecg_in) AT=31.8388889
.meas tran t_det_28 WHEN V(peak_detected)=0.45 RISE=29
.meas tran lat_28 PARAM='t_det_28 - 32.5111111'
.meas tran v_hold_28 FIND V(xtpd.peak_hold) AT=32.5111111
.meas tran v_ecg_28 FIND V(ecg_in) AT=32.5111111
.meas tran t_det_29 WHEN V(peak_detected)=0.45 RISE=30
.meas tran lat_29 PARAM='t_det_29 - 33.2611111'
.meas tran v_hold_29 FIND V(xtpd.peak_hold) AT=33.2611111
.meas tran v_ecg_29 FIND V(ecg_in) AT=33.2611111

.tran 10u 34.5583 UIC

.include "C:\Users\kadhi\OneDrive\Desktop\amux\verilogLearning\Leaky-Integrate-Fire---SNN-model-on-FPGA\experiments\frontend_optimization\complete_frontend/true_peak_detector.spice"
.include "C:\Users\kadhi\OneDrive\Desktop\amux\verilogLearning\Leaky-Integrate-Fire---SNN-model-on-FPGA\experiments\frontend_optimization\complete_frontend/bias_gen.spice"
.include "C:\Users\kadhi\OneDrive\Desktop\amux\verilogLearning\Leaky-Integrate-Fire---SNN-model-on-FPGA\experiments\frontend_optimization\complete_frontend/inverter.spice"

.control
run
wrdata C:\Users\kadhi\OneDrive\Desktop\amux\verilogLearning\Leaky-Integrate-Fire---SNN-model-on-FPGA\experiments\frontend_optimization\complete_frontend\validation_results/tpd_val_232.txt V(ecg_in) V(xtpd.peak_hold) V(peak_detected) V(xtpd.track_level) V(xtpd.charge_en) V(arm_signal)
print t_det_0 lat_0 v_hold_0 v_ecg_0
print t_det_1 lat_1 v_hold_1 v_ecg_1
print t_det_2 lat_2 v_hold_2 v_ecg_2
print t_det_3 lat_3 v_hold_3 v_ecg_3
print t_det_4 lat_4 v_hold_4 v_ecg_4
print t_det_5 lat_5 v_hold_5 v_ecg_5
print t_det_6 lat_6 v_hold_6 v_ecg_6
print t_det_7 lat_7 v_hold_7 v_ecg_7
print t_det_8 lat_8 v_hold_8 v_ecg_8
print t_det_9 lat_9 v_hold_9 v_ecg_9
print t_det_10 lat_10 v_hold_10 v_ecg_10
print t_det_11 lat_11 v_hold_11 v_ecg_11
print t_det_12 lat_12 v_hold_12 v_ecg_12
print t_det_13 lat_13 v_hold_13 v_ecg_13
print t_det_14 lat_14 v_hold_14 v_ecg_14
print t_det_15 lat_15 v_hold_15 v_ecg_15
print t_det_16 lat_16 v_hold_16 v_ecg_16
print t_det_17 lat_17 v_hold_17 v_ecg_17
print t_det_18 lat_18 v_hold_18 v_ecg_18
print t_det_19 lat_19 v_hold_19 v_ecg_19
print t_det_20 lat_20 v_hold_20 v_ecg_20
print t_det_21 lat_21 v_hold_21 v_ecg_21
print t_det_22 lat_22 v_hold_22 v_ecg_22
print t_det_23 lat_23 v_hold_23 v_ecg_23
print t_det_24 lat_24 v_hold_24 v_ecg_24
print t_det_25 lat_25 v_hold_25 v_ecg_25
print t_det_26 lat_26 v_hold_26 v_ecg_26
print t_det_27 lat_27 v_hold_27 v_ecg_27
print t_det_28 lat_28 v_hold_28 v_ecg_28
print t_det_29 lat_29 v_hold_29 v_ecg_29
quit
.endc

.end
