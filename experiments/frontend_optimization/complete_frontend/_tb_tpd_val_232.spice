* ============================================================
* TESTBENCH: v6 true_peak_detector multi-record validation
* Record 232, 15 beats
* Scaling: v = 0.421941 * sig + 0.563713
*   [V_LOW=0.3, V_HIGH=0.8]
*   seg_min=-0.6250, seg_max=0.5600
* ============================================================

.lib "C:\Users\kadhi\OneDrive\Desktop\amux\verilogLearning\Leaky-Integrate-Fire---SNN-model-on-FPGA\experiments\frontend_optimization\ngspice_frontend/sky130_minimal.lib.spice" tt
.option scale=1.0u method=gear reltol=0.003 gmin=1e-15 itl4=200

Vdd vdd 0 0.9
Vss vss 0 0

Xbias vbias vref vdd vss bias_gen
.ic V(xbias.iref)=0.3

* === REAL ECG (Record 232, samples 467-6770) ===
Vecg ecg_in 0 PWL(
+ 1.2972222 0.483544
+ 1.3000000 0.481435
+ 1.3027778 0.477215
+ 1.3055556 0.472996
+ 1.3083333 0.468776
+ 1.3111111 0.468776
+ 1.3138889 0.470886
+ 1.3166667 0.475105
+ 1.3194444 0.481435
+ 1.3222222 0.485654
+ 1.3250000 0.489873
+ 1.3277778 0.489873
+ 1.3305556 0.483544
+ 1.3333333 0.483544
+ 1.3361111 0.483544
+ 1.3388889 0.496203
+ 1.3416667 0.508861
+ 1.3444444 0.525738
+ 1.3472222 0.544726
+ 1.3500000 0.555274
+ 1.3527778 0.567932
+ 1.3555556 0.584810
+ 1.3583333 0.612236
+ 1.3611111 0.652321
+ 1.3638889 0.688186
+ 1.3666667 0.707173
+ 1.3694444 0.694515
+ 1.3722222 0.643882
+ 1.3750000 0.559494
+ 1.3777778 0.470886
+ 1.3805556 0.399156
+ 1.3833333 0.361181
+ 1.3861111 0.344304
+ 1.3888889 0.350633
+ 1.3916667 0.361181
+ 1.3944444 0.378059
+ 1.3972222 0.386498
+ 1.4000000 0.394937
+ 1.4027778 0.392827
+ 1.4055556 0.384388
+ 1.4083333 0.373840
+ 1.4111111 0.361181
+ 1.4138889 0.352743
+ 1.4166667 0.352743
+ 1.4194444 0.359072
+ 1.4222222 0.371730
+ 1.4250000 0.392827
+ 1.4277778 0.416034
+ 1.4305556 0.422363
+ 1.4333333 0.435021
+ 1.4361111 0.426582
+ 1.4388889 0.413924
+ 1.4416667 0.397046
+ 1.4444444 0.392827
+ 1.4472222 0.390717
+ 1.4500000 0.394937
+ 1.4527778 0.405485
+ 1.4555556 0.413924
+ 1.4583333 0.413924
+ 1.4611111 0.428692
+ 1.4638889 0.439241
+ 1.4666667 0.454008
+ 1.4694444 0.470886
+ 1.4722222 0.487764
+ 1.4750000 0.487764
+ 1.4777778 0.489873
+ 1.4805556 0.485654
+ 1.4833333 0.481435
+ 1.4861111 0.470886
+ 1.4888889 0.466667
+ 1.4916667 0.468776
+ 1.4944444 0.470886
+ 1.4972222 0.475105
+ 1.5000000 0.475105
+ 1.5027778 0.477215
+ 1.5055556 0.481435
+ 1.5083333 0.483544
+ 1.5111111 0.481435
+ 1.5138889 0.487764
+ 1.5166667 0.481435
+ 1.5194444 0.477215
+ 1.5222222 0.468776
+ 1.5250000 0.470886
+ 1.5277778 0.481435
+ 1.5305556 0.485654
+ 1.5333333 0.494093
+ 1.5361111 0.491983
+ 1.5388889 0.496203
+ 1.5416667 0.487764
+ 1.5444444 0.483544
+ 1.5472222 0.481435
+ 1.5500000 0.487764
+ 1.5527778 0.500422
+ 1.5555556 0.515190
+ 1.5583333 0.521519
+ 1.5611111 0.517300
+ 1.5638889 0.498312
+ 1.5666667 0.479325
+ 1.5694444 0.472996
+ 1.5722222 0.477215
+ 1.5750000 0.483544
+ 1.5777778 0.491983
+ 1.5805556 0.504641
+ 1.5833333 0.510970
+ 1.5861111 0.506751
+ 1.5888889 0.504641
+ 1.5916667 0.502532
+ 1.5944444 0.502532
+ 1.5972222 0.508861
+ 1.6000000 0.513080
+ 1.6027778 0.510970
+ 1.6055556 0.510970
+ 1.6083333 0.517300
+ 1.6111111 0.519409
+ 1.6138889 0.523629
+ 1.6166667 0.523629
+ 1.6194444 0.525738
+ 1.6222222 0.529958
+ 1.6250000 0.527848
+ 1.6277778 0.529958
+ 1.6305556 0.523629
+ 1.6333333 0.532068
+ 1.6361111 0.542616
+ 1.6388889 0.551055
+ 1.6416667 0.559494
+ 1.6444444 0.561603
+ 1.6472222 0.563713
+ 1.6500000 0.559494
+ 1.6527778 0.555274
+ 1.6555556 0.548945
+ 1.6583333 0.551055
+ 1.6611111 0.551055
+ 1.6638889 0.565823
+ 1.6666667 0.576371
+ 1.6694444 0.584810
+ 1.6722222 0.591139
+ 1.6750000 0.589030
+ 1.6777778 0.584810
+ 1.6805556 0.572152
+ 1.6833333 0.565823
+ 1.6861111 0.559494
+ 1.6888889 0.557384
+ 1.6916667 0.555274
+ 1.6944444 0.563713
+ 1.6972222 0.570042
+ 1.7000000 0.578481
+ 1.7027778 0.586920
+ 1.7055556 0.591139
+ 1.7083333 0.589030
+ 1.7111111 0.580591
+ 1.7138889 0.567932
+ 1.7166667 0.551055
+ 1.7194444 0.546835
+ 1.7222222 0.546835
+ 1.7250000 0.548945
+ 1.7277778 0.553165
+ 1.7305556 0.555274
+ 1.7333333 0.553165
+ 1.7361111 0.540506
+ 1.7388889 0.536287
+ 1.7416667 0.523629
+ 1.7444444 0.519409
+ 1.7472222 0.515190
+ 1.7500000 0.521519
+ 1.7527778 0.519409
+ 1.7555556 0.515190
+ 1.7583333 0.506751
+ 1.7611111 0.502532
+ 1.7638889 0.496203
+ 1.7666667 0.494093
+ 1.7694444 0.487764
+ 1.7722222 0.494093
+ 1.7750000 0.500422
+ 1.7777778 0.498312
+ 1.7805556 0.500422
+ 1.7833333 0.498312
+ 1.7861111 0.489873
+ 1.7888889 0.477215
+ 1.7916667 0.472996
+ 1.7944444 0.466667
+ 1.7972222 0.468776
+ 1.8000000 0.475105
+ 1.8027778 0.483544
+ 1.8055556 0.489873
+ 1.8083333 0.491983
+ 1.8111111 0.494093
+ 1.8138889 0.491983
+ 1.8166667 0.487764
+ 1.8194444 0.487764
+ 1.8222222 0.483544
+ 1.8250000 0.477215
+ 1.8277778 0.485654
+ 1.8305556 0.491983
+ 1.8333333 0.498312
+ 1.8361111 0.498312
+ 1.8388889 0.506751
+ 1.8416667 0.506751
+ 1.8444444 0.510970
+ 1.8472222 0.519409
+ 1.8500000 0.519409
+ 1.8527778 0.517300
+ 1.8555556 0.515190
+ 1.8583333 0.510970
+ 1.8611111 0.504641
+ 1.8638889 0.502532
+ 1.8666667 0.502532
+ 1.8694444 0.502532
+ 1.8722222 0.508861
+ 1.8750000 0.513080
+ 1.8777778 0.513080
+ 1.8805556 0.513080
+ 1.8833333 0.513080
+ 1.8861111 0.508861
+ 1.8888889 0.496203
+ 1.8916667 0.489873
+ 1.8944444 0.491983
+ 1.8972222 0.498312
+ 1.9000000 0.506751
+ 1.9027778 0.525738
+ 1.9055556 0.538397
+ 1.9083333 0.538397
+ 1.9111111 0.521519
+ 1.9138889 0.513080
+ 1.9166667 0.508861
+ 1.9194444 0.500422
+ 1.9222222 0.500422
+ 1.9250000 0.500422
+ 1.9277778 0.508861
+ 1.9305556 0.510970
+ 1.9333333 0.513080
+ 1.9361111 0.515190
+ 1.9388889 0.513080
+ 1.9416667 0.508861
+ 1.9444444 0.504641
+ 1.9472222 0.498312
+ 1.9500000 0.491983
+ 1.9527778 0.498312
+ 1.9555556 0.498312
+ 1.9583333 0.502532
+ 1.9611111 0.508861
+ 1.9638889 0.510970
+ 1.9666667 0.513080
+ 1.9694444 0.508861
+ 1.9722222 0.515190
+ 1.9750000 0.517300
+ 1.9777778 0.517300
+ 1.9805556 0.521519
+ 1.9833333 0.521519
+ 1.9861111 0.517300
+ 1.9888889 0.502532
+ 1.9916667 0.491983
+ 1.9944444 0.489873
+ 1.9972222 0.494093
+ 2.0000000 0.510970
+ 2.0027778 0.515190
+ 2.0055556 0.515190
+ 2.0083333 0.506751
+ 2.0111111 0.500422
+ 2.0138889 0.500422
+ 2.0166667 0.508861
+ 2.0194444 0.515190
+ 2.0222222 0.519409
+ 2.0250000 0.521519
+ 2.0277778 0.527848
+ 2.0305556 0.532068
+ 2.0333333 0.544726
+ 2.0361111 0.567932
+ 2.0388889 0.610127
+ 2.0416667 0.662869
+ 2.0444444 0.717722
+ 2.0472222 0.762025
+ 2.0500000 0.772574
+ 2.0527778 0.749367
+ 2.0555556 0.673418
+ 2.0583333 0.572152
+ 2.0611111 0.481435
+ 2.0638889 0.413924
+ 2.0666667 0.380169
+ 2.0694444 0.378059
+ 2.0722222 0.388608
+ 2.0750000 0.399156
+ 2.0777778 0.420253
+ 2.0805556 0.435021
+ 2.0833333 0.435021
+ 2.0861111 0.428692
+ 2.0888889 0.413924
+ 2.0916667 0.397046
+ 2.0944444 0.394937
+ 2.0972222 0.403376
+ 2.1000000 0.416034
+ 2.1027778 0.437131
+ 2.1055556 0.456118
+ 2.1083333 0.456118
+ 2.1111111 0.445570
+ 2.1138889 0.426582
+ 2.1166667 0.401266
+ 2.1194444 0.390717
+ 2.1222222 0.388608
+ 2.1250000 0.397046
+ 2.1277778 0.416034
+ 2.1305556 0.437131
+ 2.1333333 0.443460
+ 2.1361111 0.451899
+ 2.1388889 0.454008
+ 2.1416667 0.456118
+ 2.1444444 0.462447
+ 2.1472222 0.472996
+ 2.1500000 0.487764
+ 2.1527778 0.500422
+ 2.1555556 0.500422
+ 2.1583333 0.498312
+ 2.1611111 0.502532
+ 2.1638889 0.494093
+ 2.1666667 0.500422
+ 2.1694444 0.506751
+ 2.1722222 0.510970
+ 2.1750000 0.519409
+ 2.1777778 0.523629
+ 2.1805556 0.521519
+ 2.1833333 0.523629
+ 2.1861111 0.519409
+ 2.1888889 0.510970
+ 2.1916667 0.502532
+ 2.1944444 0.494093
+ 2.1972222 0.498312
+ 2.2000000 0.498312
+ 2.2027778 0.504641
+ 2.2055556 0.513080
+ 2.2083333 0.510970
+ 2.2111111 0.517300
+ 2.2138889 0.506751
+ 2.2166667 0.502532
+ 2.2194444 0.500422
+ 2.2222222 0.504641
+ 2.2250000 0.510970
+ 2.2277778 0.513080
+ 2.2305556 0.508861
+ 2.2333333 0.506751
+ 2.2361111 0.504641
+ 2.2388889 0.510970
+ 2.2416667 0.510970
+ 2.2444444 0.521519
+ 2.2472222 0.527848
+ 2.2500000 0.527848
+ 2.2527778 0.517300
+ 2.2555556 0.519409
+ 2.2583333 0.515190
+ 2.2611111 0.517300
+ 2.2638889 0.527848
+ 2.2666667 0.540506
+ 2.2694444 0.544726
+ 2.2722222 0.544726
+ 2.2750000 0.551055
+ 2.2777778 0.555274
+ 2.2805556 0.555274
+ 2.2833333 0.553165
+ 2.2861111 0.559494
+ 2.2888889 0.559494
+ 2.2916667 0.559494
+ 2.2944444 0.565823
+ 2.2972222 0.567932
+ 2.3000000 0.576371
+ 2.3027778 0.586920
+ 2.3055556 0.597468
+ 2.3083333 0.605907
+ 2.3111111 0.608017
+ 2.3138889 0.614346
+ 2.3166667 0.616456
+ 2.3194444 0.605907
+ 2.3222222 0.595359
+ 2.3250000 0.586920
+ 2.3277778 0.589030
+ 2.3305556 0.593249
+ 2.3333333 0.603797
+ 2.3361111 0.618565
+ 2.3388889 0.620675
+ 2.3416667 0.618565
+ 2.3444444 0.616456
+ 2.3472222 0.614346
+ 2.3500000 0.618565
+ 2.3527778 0.616456
+ 2.3555556 0.616456
+ 2.3583333 0.614346
+ 2.3611111 0.605907
+ 2.3638889 0.599578
+ 2.3666667 0.589030
+ 2.3694444 0.582700
+ 2.3722222 0.574262
+ 2.3750000 0.578481
+ 2.3777778 0.576371
+ 2.3805556 0.576371
+ 2.3833333 0.570042
+ 2.3861111 0.561603
+ 2.3888889 0.553165
+ 2.3916667 0.551055
+ 2.3944444 0.551055
+ 2.3972222 0.538397
+ 2.4000000 0.521519
+ 2.4027778 0.510970
+ 2.4055556 0.513080
+ 2.4083333 0.519409
+ 2.4111111 0.525738
+ 2.4138889 0.525738
+ 2.4166667 0.521519
+ 2.4194444 0.508861
+ 2.4222222 0.502532
+ 2.4250000 0.498312
+ 2.4277778 0.498312
+ 2.4305556 0.496203
+ 2.4333333 0.502532
+ 2.4361111 0.506751
+ 2.4388889 0.506751
+ 2.4416667 0.508861
+ 2.4444444 0.506751
+ 2.4472222 0.502532
+ 2.4500000 0.498312
+ 2.4527778 0.491983
+ 2.4555556 0.485654
+ 2.4583333 0.481435
+ 2.4611111 0.485654
+ 2.4638889 0.485654
+ 2.4666667 0.491983
+ 2.4694444 0.494093
+ 2.4722222 0.498312
+ 2.4750000 0.502532
+ 2.4777778 0.510970
+ 2.4805556 0.508861
+ 2.4833333 0.502532
+ 2.4861111 0.496203
+ 2.4888889 0.494093
+ 2.4916667 0.491983
+ 2.4944444 0.496203
+ 2.4972222 0.496203
+ 2.5000000 0.500422
+ 2.5027778 0.506751
+ 2.5055556 0.515190
+ 2.5083333 0.508861
+ 2.5111111 0.506751
+ 2.5138889 0.487764
+ 2.5166667 0.483544
+ 2.5194444 0.479325
+ 2.5222222 0.477215
+ 2.5250000 0.481435
+ 2.5277778 0.481435
+ 2.5305556 0.491983
+ 2.5333333 0.491983
+ 2.5361111 0.494093
+ 2.5388889 0.506751
+ 2.5416667 0.506751
+ 2.5444444 0.513080
+ 2.5472222 0.515190
+ 2.5500000 0.517300
+ 2.5527778 0.513080
+ 2.5555556 0.502532
+ 2.5583333 0.494093
+ 2.5611111 0.481435
+ 2.5638889 0.475105
+ 2.5666667 0.466667
+ 2.5694444 0.472996
+ 2.5722222 0.475105
+ 2.5750000 0.487764
+ 2.5777778 0.496203
+ 2.5805556 0.508861
+ 2.5833333 0.521519
+ 2.5861111 0.525738
+ 2.5888889 0.517300
+ 2.5916667 0.517300
+ 2.5944444 0.510970
+ 2.5972222 0.508861
+ 2.6000000 0.513080
+ 2.6027778 0.515190
+ 2.6055556 0.515190
+ 2.6083333 0.515190
+ 2.6111111 0.506751
+ 2.6138889 0.500422
+ 2.6166667 0.491983
+ 2.6194444 0.477215
+ 2.6222222 0.475105
+ 2.6250000 0.472996
+ 2.6277778 0.468776
+ 2.6305556 0.468776
+ 2.6333333 0.468776
+ 2.6361111 0.475105
+ 2.6388889 0.481435
+ 2.6416667 0.487764
+ 2.6444444 0.498312
+ 2.6472222 0.496203
+ 2.6500000 0.498312
+ 2.6527778 0.496203
+ 2.6555556 0.487764
+ 2.6583333 0.487764
+ 2.6611111 0.494093
+ 2.6638889 0.498312
+ 2.6666667 0.502532
+ 2.6694444 0.506751
+ 2.6722222 0.513080
+ 2.6750000 0.513080
+ 2.6777778 0.510970
+ 2.6805556 0.508861
+ 2.6833333 0.504641
+ 2.6861111 0.508861
+ 2.6888889 0.510970
+ 2.6916667 0.513080
+ 2.6944444 0.510970
+ 2.6972222 0.504641
+ 2.7000000 0.500422
+ 2.7027778 0.496203
+ 2.7055556 0.506751
+ 2.7083333 0.510970
+ 2.7111111 0.515190
+ 2.7138889 0.502532
+ 2.7166667 0.487764
+ 2.7194444 0.485654
+ 2.7222222 0.485654
+ 2.7250000 0.491983
+ 2.7277778 0.498312
+ 2.7305556 0.498312
+ 2.7333333 0.504641
+ 2.7361111 0.510970
+ 2.7388889 0.506751
+ 2.7416667 0.508861
+ 2.7444444 0.506751
+ 2.7472222 0.500422
+ 2.7500000 0.500422
+ 2.7527778 0.502532
+ 2.7555556 0.510970
+ 2.7583333 0.523629
+ 2.7611111 0.542616
+ 2.7638889 0.557384
+ 2.7666667 0.576371
+ 2.7694444 0.612236
+ 2.7722222 0.645992
+ 2.7750000 0.730380
+ 2.7777778 0.768354
+ 2.7805556 0.795781
+ 2.7833333 0.791561
+ 2.7861111 0.749367
+ 2.7888889 0.662869
+ 2.7916667 0.551055
+ 2.7944444 0.441350
+ 2.7972222 0.367511
+ 2.8000000 0.329536
+ 2.8027778 0.318987
+ 2.8055556 0.333755
+ 2.8083333 0.354852
+ 2.8111111 0.378059
+ 2.8138889 0.399156
+ 2.8166667 0.416034
+ 2.8194444 0.424473
+ 2.8222222 0.424473
+ 2.8250000 0.411814
+ 2.8277778 0.390717
+ 2.8305556 0.371730
+ 2.8333333 0.365401
+ 2.8361111 0.367511
+ 2.8388889 0.382278
+ 2.8416667 0.399156
+ 2.8444444 0.418143
+ 2.8472222 0.428692
+ 2.8500000 0.424473
+ 2.8527778 0.420253
+ 2.8555556 0.413924
+ 2.8583333 0.407595
+ 2.8611111 0.409705
+ 2.8638889 0.422363
+ 2.8666667 0.428692
+ 2.8694444 0.443460
+ 2.8722222 0.454008
+ 2.8750000 0.454008
+ 2.8777778 0.451899
+ 2.8805556 0.449789
+ 2.8833333 0.445570
+ 2.8861111 0.445570
+ 2.8888889 0.451899
+ 2.8916667 0.466667
+ 2.8944444 0.479325
+ 2.8972222 0.491983
+ 2.9000000 0.504641
+ 2.9027778 0.510970
+ 2.9055556 0.515190
+ 2.9083333 0.523629
+ 2.9111111 0.534177
+ 2.9138889 0.542616
+ 2.9166667 0.534177
+ 2.9194444 0.519409
+ 2.9222222 0.494093
+ 2.9250000 0.462447
+ 2.9277778 0.441350
+ 2.9305556 0.441350
+ 2.9333333 0.454008
+ 2.9361111 0.475105
+ 2.9388889 0.496203
+ 2.9416667 0.508861
+ 2.9444444 0.513080
+ 2.9472222 0.510970
+ 2.9500000 0.515190
+ 2.9527778 0.510970
+ 2.9555556 0.510970
+ 2.9583333 0.513080
+ 2.9611111 0.517300
+ 2.9638889 0.513080
+ 2.9666667 0.508861
+ 2.9694444 0.506751
+ 2.9722222 0.504641
+ 2.9750000 0.494093
+ 2.9777778 0.502532
+ 2.9805556 0.502532
+ 2.9833333 0.515190
+ 2.9861111 0.515190
+ 2.9888889 0.517300
+ 2.9916667 0.519409
+ 2.9944444 0.519409
+ 2.9972222 0.521519
+ 3.0000000 0.523629
+ 3.0027778 0.517300
+ 3.0055556 0.510970
+ 3.0083333 0.506751
+ 3.0111111 0.510970
+ 3.0138889 0.517300
+ 3.0166667 0.523629
+ 3.0194444 0.525738
+ 3.0222222 0.536287
+ 3.0250000 0.542616
+ 3.0277778 0.546835
+ 3.0305556 0.553165
+ 3.0333333 0.559494
+ 3.0361111 0.574262
+ 3.0388889 0.576371
+ 3.0416667 0.584810
+ 3.0444444 0.593249
+ 3.0472222 0.591139
+ 3.0500000 0.584810
+ 3.0527778 0.586920
+ 3.0555556 0.586920
+ 3.0583333 0.584810
+ 3.0611111 0.582700
+ 3.0638889 0.584810
+ 3.0666667 0.589030
+ 3.0694444 0.595359
+ 3.0722222 0.599578
+ 3.0750000 0.599578
+ 3.0777778 0.610127
+ 3.0805556 0.599578
+ 3.0833333 0.597468
+ 3.0861111 0.593249
+ 3.0888889 0.593249
+ 3.0916667 0.599578
+ 3.0944444 0.599578
+ 3.0972222 0.599578
+ 3.1000000 0.593249
+ 3.1027778 0.593249
+ 3.1055556 0.582700
+ 3.1083333 0.572152
+ 3.1111111 0.567932
+ 3.1138889 0.563713
+ 3.1166667 0.561603
+ 3.1194444 0.561603
+ 3.1222222 0.544726
+ 3.1250000 0.529958
+ 3.1277778 0.521519
+ 3.1305556 0.517300
+ 3.1333333 0.515190
+ 3.1361111 0.529958
+ 3.1388889 0.536287
+ 3.1416667 0.542616
+ 3.1444444 0.546835
+ 3.1472222 0.538397
+ 3.1500000 0.525738
+ 3.1527778 0.500422
+ 3.1555556 0.481435
+ 3.1583333 0.472996
+ 3.1611111 0.468776
+ 3.1638889 0.472996
+ 3.1666667 0.483544
+ 3.1694444 0.500422
+ 3.1722222 0.508861
+ 3.1750000 0.513080
+ 3.1777778 0.510970
+ 3.1805556 0.504641
+ 3.1833333 0.500422
+ 3.1861111 0.491983
+ 3.1888889 0.485654
+ 3.1916667 0.483544
+ 3.1944444 0.487764
+ 3.1972222 0.483544
+ 3.2000000 0.481435
+ 3.2027778 0.481435
+ 3.2055556 0.475105
+ 3.2083333 0.477215
+ 3.2111111 0.483544
+ 3.2138889 0.491983
+ 3.2166667 0.496203
+ 3.2194444 0.498312
+ 3.2222222 0.500422
+ 3.2250000 0.491983
+ 3.2277778 0.481435
+ 3.2305556 0.479325
+ 3.2333333 0.470886
+ 3.2361111 0.477215
+ 3.2388889 0.483544
+ 3.2416667 0.496203
+ 3.2444444 0.510970
+ 3.2472222 0.521519
+ 3.2500000 0.527848
+ 3.2527778 0.523629
+ 3.2555556 0.510970
+ 3.2583333 0.498312
+ 3.2611111 0.494093
+ 3.2638889 0.494093
+ 3.2666667 0.489873
+ 3.2694444 0.500422
+ 3.2722222 0.504641
+ 3.2750000 0.508861
+ 3.2777778 0.519409
+ 3.2805556 0.513080
+ 3.2833333 0.513080
+ 3.2861111 0.502532
+ 3.2888889 0.496203
+ 3.2916667 0.485654
+ 3.2944444 0.479325
+ 3.2972222 0.485654
+ 3.3000000 0.483544
+ 3.3027778 0.483544
+ 3.3055556 0.487764
+ 3.3083333 0.496203
+ 3.3111111 0.506751
+ 3.3138889 0.504641
+ 3.3166667 0.508861
+ 3.3194444 0.502532
+ 3.3222222 0.491983
+ 3.3250000 0.475105
+ 3.3277778 0.470886
+ 3.3305556 0.483544
+ 3.3333333 0.489873
+ 3.3361111 0.498312
+ 3.3388889 0.502532
+ 3.3416667 0.498312
+ 3.3444444 0.494093
+ 3.3472222 0.496203
+ 3.3500000 0.491983
+ 3.3527778 0.489873
+ 3.3555556 0.494093
+ 3.3583333 0.500422
+ 3.3611111 0.502532
+ 3.3638889 0.498312
+ 3.3666667 0.491983
+ 3.3694444 0.479325
+ 3.3722222 0.470886
+ 3.3750000 0.458228
+ 3.3777778 0.458228
+ 3.3805556 0.454008
+ 3.3833333 0.458228
+ 3.3861111 0.466667
+ 3.3888889 0.477215
+ 3.3916667 0.487764
+ 3.3944444 0.498312
+ 3.3972222 0.510970
+ 3.4000000 0.521519
+ 3.4027778 0.523629
+ 3.4055556 0.517300
+ 3.4083333 0.494093
+ 3.4111111 0.472996
+ 3.4138889 0.458228
+ 3.4166667 0.449789
+ 3.4194444 0.447679
+ 3.4222222 0.458228
+ 3.4250000 0.464557
+ 3.4277778 0.477215
+ 3.4305556 0.483544
+ 3.4333333 0.485654
+ 3.4361111 0.485654
+ 3.4388889 0.485654
+ 3.4416667 0.481435
+ 3.4444444 0.477215
+ 3.4472222 0.479325
+ 3.4500000 0.485654
+ 3.4527778 0.487764
+ 3.4555556 0.498312
+ 3.4583333 0.519409
+ 3.4611111 0.544726
+ 3.4638889 0.561603
+ 3.4666667 0.544726
+ 3.4694444 0.500422
+ 3.4722222 0.451899
+ 3.4750000 0.405485
+ 3.4777778 0.390717
+ 3.4805556 0.405485
+ 3.4833333 0.428692
+ 3.4861111 0.458228
+ 3.4888889 0.477215
+ 3.4916667 0.491983
+ 3.4944444 0.491983
+ 3.4972222 0.494093
+ 3.5000000 0.491983
+ 3.5027778 0.496203
+ 3.5055556 0.494093
+ 3.5083333 0.504641
+ 3.5111111 0.513080
+ 3.5138889 0.525738
+ 3.5166667 0.523629
+ 3.5194444 0.523629
+ 3.5222222 0.510970
+ 3.5250000 0.491983
+ 3.5277778 0.464557
+ 3.5305556 0.432911
+ 3.5333333 0.420253
+ 3.5361111 0.420253
+ 3.5388889 0.435021
+ 3.5416667 0.456118
+ 3.5444444 0.477215
+ 3.5472222 0.494093
+ 3.5500000 0.502532
+ 3.5527778 0.504641
+ 3.5555556 0.500422
+ 3.5583333 0.494093
+ 3.5611111 0.494093
+ 3.5638889 0.496203
+ 3.5666667 0.494093
+ 3.5694444 0.494093
+ 3.5722222 0.491983
+ 3.5750000 0.481435
+ 3.5777778 0.475105
+ 3.5805556 0.470886
+ 3.5833333 0.470886
+ 3.5861111 0.475105
+ 3.5888889 0.479325
+ 3.5916667 0.481435
+ 3.5944444 0.487764
+ 3.5972222 0.489873
+ 3.6000000 0.491983
+ 3.6027778 0.496203
+ 3.6055556 0.496203
+ 3.6083333 0.491983
+ 3.6111111 0.489873
+ 3.6138889 0.483544
+ 3.6166667 0.479325
+ 3.6194444 0.475105
+ 3.6222222 0.472996
+ 3.6250000 0.472996
+ 3.6277778 0.477215
+ 3.6305556 0.479325
+ 3.6333333 0.477215
+ 3.6361111 0.477215
+ 3.6388889 0.475105
+ 3.6416667 0.472996
+ 3.6444444 0.475105
+ 3.6472222 0.479325
+ 3.6500000 0.483544
+ 3.6527778 0.487764
+ 3.6555556 0.496203
+ 3.6583333 0.500422
+ 3.6611111 0.506751
+ 3.6638889 0.504641
+ 3.6666667 0.494093
+ 3.6694444 0.479325
+ 3.6722222 0.458228
+ 3.6750000 0.451899
+ 3.6777778 0.445570
+ 3.6805556 0.451899
+ 3.6833333 0.460338
+ 3.6861111 0.466667
+ 3.6888889 0.479325
+ 3.6916667 0.481435
+ 3.6944444 0.481435
+ 3.6972222 0.481435
+ 3.7000000 0.481435
+ 3.7027778 0.485654
+ 3.7055556 0.489873
+ 3.7083333 0.491983
+ 3.7111111 0.498312
+ 3.7138889 0.498312
+ 3.7166667 0.498312
+ 3.7194444 0.485654
+ 3.7222222 0.479325
+ 3.7250000 0.479325
+ 3.7277778 0.481435
+ 3.7305556 0.491983
+ 3.7333333 0.502532
+ 3.7361111 0.515190
+ 3.7388889 0.513080
+ 3.7416667 0.508861
+ 3.7444444 0.502532
+ 3.7472222 0.496203
+ 3.7500000 0.487764
+ 3.7527778 0.468776
+ 3.7555556 0.449789
+ 3.7583333 0.439241
+ 3.7611111 0.441350
+ 3.7638889 0.443460
+ 3.7666667 0.466667
+ 3.7694444 0.481435
+ 3.7722222 0.489873
+ 3.7750000 0.491983
+ 3.7777778 0.489873
+ 3.7805556 0.479325
+ 3.7833333 0.472996
+ 3.7861111 0.460338
+ 3.7888889 0.462447
+ 3.7916667 0.475105
+ 3.7944444 0.483544
+ 3.7972222 0.498312
+ 3.8000000 0.508861
+ 3.8027778 0.513080
+ 3.8055556 0.506751
+ 3.8083333 0.496203
+ 3.8111111 0.481435
+ 3.8138889 0.472996
+ 3.8166667 0.462447
+ 3.8194444 0.462447
+ 3.8222222 0.468776
+ 3.8250000 0.477215
+ 3.8277778 0.483544
+ 3.8305556 0.479325
+ 3.8333333 0.475105
+ 3.8361111 0.479325
+ 3.8388889 0.475105
+ 3.8416667 0.470886
+ 3.8444444 0.466667
+ 3.8472222 0.464557
+ 3.8500000 0.464557
+ 3.8527778 0.460338
+ 3.8555556 0.475105
+ 3.8583333 0.483544
+ 3.8611111 0.494093
+ 3.8638889 0.500422
+ 3.8666667 0.500422
+ 3.8694444 0.496203
+ 3.8722222 0.491983
+ 3.8750000 0.489873
+ 3.8777778 0.483544
+ 3.8805556 0.472996
+ 3.8833333 0.460338
+ 3.8861111 0.456118
+ 3.8888889 0.454008
+ 3.8916667 0.456118
+ 3.8944444 0.462447
+ 3.8972222 0.472996
+ 3.9000000 0.481435
+ 3.9027778 0.485654
+ 3.9055556 0.494093
+ 3.9083333 0.489873
+ 3.9111111 0.477215
+ 3.9138889 0.454008
+ 3.9166667 0.443460
+ 3.9194444 0.437131
+ 3.9222222 0.432911
+ 3.9250000 0.435021
+ 3.9277778 0.451899
+ 3.9305556 0.464557
+ 3.9333333 0.481435
+ 3.9361111 0.487764
+ 3.9388889 0.487764
+ 3.9416667 0.475105
+ 3.9444444 0.462447
+ 3.9472222 0.451899
+ 3.9500000 0.445570
+ 3.9527778 0.451899
+ 3.9555556 0.456118
+ 3.9583333 0.468776
+ 3.9611111 0.472996
+ 3.9638889 0.481435
+ 3.9666667 0.483544
+ 3.9694444 0.489873
+ 3.9722222 0.481435
+ 3.9750000 0.475105
+ 3.9777778 0.472996
+ 3.9805556 0.464557
+ 3.9833333 0.466667
+ 3.9861111 0.464557
+ 3.9888889 0.462447
+ 3.9916667 0.458228
+ 3.9944444 0.454008
+ 3.9972222 0.456118
+ 4.0000000 0.456118
+ 4.0027778 0.460338
+ 4.0055556 0.460338
+ 4.0083333 0.458228
+ 4.0111111 0.462447
+ 4.0138889 0.468776
+ 4.0166667 0.472996
+ 4.0194444 0.472996
+ 4.0222222 0.470886
+ 4.0250000 0.468776
+ 4.0277778 0.464557
+ 4.0305556 0.462447
+ 4.0333333 0.464557
+ 4.0361111 0.470886
+ 4.0388889 0.475105
+ 4.0416667 0.470886
+ 4.0444444 0.475105
+ 4.0472222 0.468776
+ 4.0500000 0.468776
+ 4.0527778 0.456118
+ 4.0555556 0.454008
+ 4.0583333 0.458228
+ 4.0611111 0.462447
+ 4.0638889 0.479325
+ 4.0666667 0.489873
+ 4.0694444 0.496203
+ 4.0722222 0.485654
+ 4.0750000 0.470886
+ 4.0777778 0.464557
+ 4.0805556 0.456118
+ 4.0833333 0.443460
+ 4.0861111 0.435021
+ 4.0888889 0.439241
+ 4.0916667 0.449789
+ 4.0944444 0.458228
+ 4.0972222 0.470886
+ 4.1000000 0.475105
+ 4.1027778 0.479325
+ 4.1055556 0.470886
+ 4.1083333 0.468776
+ 4.1111111 0.466667
+ 4.1138889 0.470886
+ 4.1166667 0.470886
+ 4.1194444 0.466667
+ 4.1222222 0.460338
+ 4.1250000 0.462447
+ 4.1277778 0.466667
+ 4.1305556 0.468776
+ 4.1333333 0.475105
+ 4.1361111 0.472996
+ 4.1388889 0.462447
+ 4.1416667 0.456118
+ 4.1444444 0.454008
+ 4.1472222 0.454008
+ 4.1500000 0.458228
+ 4.1527778 0.460338
+ 4.1555556 0.458228
+ 4.1583333 0.451899
+ 4.1611111 0.443460
+ 4.1638889 0.449789
+ 4.1666667 0.458228
+ 4.1694444 0.470886
+ 4.1722222 0.481435
+ 4.1750000 0.485654
+ 4.1777778 0.487764
+ 4.1805556 0.477215
+ 4.1833333 0.475105
+ 4.1861111 0.468776
+ 4.1888889 0.462447
+ 4.1916667 0.458228
+ 4.1944444 0.454008
+ 4.1972222 0.458228
+ 4.2000000 0.466667
+ 4.2027778 0.477215
+ 4.2055556 0.483544
+ 4.2083333 0.479325
+ 4.2111111 0.479325
+ 4.2138889 0.475105
+ 4.2166667 0.462447
+ 4.2194444 0.456118
+ 4.2222222 0.454008
+ 4.2250000 0.460338
+ 4.2277778 0.468776
+ 4.2305556 0.470886
+ 4.2333333 0.475105
+ 4.2361111 0.477215
+ 4.2388889 0.477215
+ 4.2416667 0.475105
+ 4.2444444 0.472996
+ 4.2472222 0.460338
+ 4.2500000 0.451899
+ 4.2527778 0.445570
+ 4.2555556 0.451899
+ 4.2583333 0.460338
+ 4.2611111 0.468776
+ 4.2638889 0.477215
+ 4.2666667 0.472996
+ 4.2694444 0.466667
+ 4.2722222 0.462447
+ 4.2750000 0.464557
+ 4.2777778 0.479325
+ 4.2805556 0.485654
+ 4.2833333 0.491983
+ 4.2861111 0.489873
+ 4.2888889 0.477215
+ 4.2916667 0.464557
+ 4.2944444 0.449789
+ 4.2972222 0.449789
+ 4.3000000 0.454008
+ 4.3027778 0.456118
+ 4.3055556 0.460338
+ 4.3083333 0.468776
+ 4.3111111 0.479325
+ 4.3138889 0.483544
+ 4.3166667 0.487764
+ 4.3194444 0.483544
+ 4.3222222 0.479325
+ 4.3250000 0.477215
+ 4.3277778 0.477215
+ 4.3305556 0.477215
+ 4.3333333 0.481435
+ 4.3361111 0.483544
+ 4.3388889 0.483544
+ 4.3416667 0.477215
+ 4.3444444 0.475105
+ 4.3472222 0.468776
+ 4.3500000 0.462447
+ 4.3527778 0.460338
+ 4.3555556 0.460338
+ 4.3583333 0.468776
+ 4.3611111 0.470886
+ 4.3638889 0.483544
+ 4.3666667 0.489873
+ 4.3694444 0.491983
+ 4.3722222 0.491983
+ 4.3750000 0.483544
+ 4.3777778 0.477215
+ 4.3805556 0.464557
+ 4.3833333 0.464557
+ 4.3861111 0.464557
+ 4.3888889 0.472996
+ 4.3916667 0.481435
+ 4.3944444 0.487764
+ 4.3972222 0.498312
+ 4.4000000 0.506751
+ 4.4027778 0.506751
+ 4.4055556 0.508861
+ 4.4083333 0.504641
+ 4.4111111 0.494093
+ 4.4138889 0.491983
+ 4.4166667 0.491983
+ 4.4194444 0.494093
+ 4.4222222 0.502532
+ 4.4250000 0.506751
+ 4.4277778 0.519409
+ 4.4305556 0.521519
+ 4.4333333 0.521519
+ 4.4361111 0.508861
+ 4.4388889 0.496203
+ 4.4416667 0.479325
+ 4.4444444 0.468776
+ 4.4472222 0.460338
+ 4.4500000 0.458228
+ 4.4527778 0.462447
+ 4.4555556 0.470886
+ 4.4583333 0.485654
+ 4.4611111 0.489873
+ 4.4638889 0.502532
+ 4.4666667 0.513080
+ 4.4694444 0.519409
+ 4.4722222 0.517300
+ 4.4750000 0.506751
+ 4.4777778 0.489873
+ 4.4805556 0.466667
+ 4.4833333 0.445570
+ 4.4861111 0.426582
+ 4.4888889 0.418143
+ 4.4916667 0.418143
+ 4.4944444 0.426582
+ 4.4972222 0.437131
+ 4.5000000 0.449789
+ 4.5027778 0.462447
+ 4.5055556 0.468776
+ 4.5083333 0.477215
+ 4.5111111 0.477215
+ 4.5138889 0.479325
+ 4.5166667 0.477215
+ 4.5194444 0.470886
+ 4.5222222 0.462447
+ 4.5250000 0.451899
+ 4.5277778 0.443460
+ 4.5305556 0.443460
+ 4.5333333 0.443460
+ 4.5361111 0.445570
+ 4.5388889 0.458228
+ 4.5416667 0.464557
+ 4.5444444 0.464557
+ 4.5472222 0.470886
+ 4.5500000 0.477215
+ 4.5527778 0.496203
+ 4.5555556 0.504641
+ 4.5583333 0.508861
+ 4.5611111 0.491983
+ 4.5638889 0.468776
+ 4.5666667 0.445570
+ 4.5694444 0.428692
+ 4.5722222 0.428692
+ 4.5750000 0.428692
+ 4.5777778 0.447679
+ 4.5805556 0.462447
+ 4.5833333 0.479325
+ 4.5861111 0.496203
+ 4.5888889 0.502532
+ 4.5916667 0.523629
+ 4.5944444 0.555274
+ 4.5972222 0.597468
+ 4.6000000 0.652321
+ 4.6027778 0.707173
+ 4.6055556 0.749367
+ 4.6083333 0.785232
+ 4.6111111 0.797890
+ 4.6138889 0.776793
+ 4.6166667 0.713502
+ 4.6194444 0.603797
+ 4.6222222 0.483544
+ 4.6250000 0.386498
+ 4.6277778 0.321097
+ 4.6305556 0.300000
+ 4.6333333 0.302110
+ 4.6361111 0.316878
+ 4.6388889 0.335865
+ 4.6416667 0.350633
+ 4.6444444 0.359072
+ 4.6472222 0.363291
+ 4.6500000 0.350633
+ 4.6527778 0.344304
+ 4.6555556 0.333755
+ 4.6583333 0.335865
+ 4.6611111 0.342194
+ 4.6638889 0.352743
+ 4.6666667 0.369620
+ 4.6694444 0.386498
+ 4.6722222 0.397046
+ 4.6750000 0.401266
+ 4.6777778 0.409705
+ 4.6805556 0.405485
+ 4.6833333 0.397046
+ 4.6861111 0.378059
+ 4.6888889 0.361181
+ 4.6916667 0.350633
+ 4.6944444 0.348523
+ 4.6972222 0.359072
+ 4.7000000 0.375949
+ 4.7027778 0.397046
+ 4.7055556 0.420253
+ 4.7083333 0.437131
+ 4.7111111 0.458228
+ 4.7138889 0.472996
+ 4.7166667 0.481435
+ 4.7194444 0.477215
+ 4.7222222 0.472996
+ 4.7250000 0.458228
+ 4.7277778 0.445570
+ 4.7305556 0.439241
+ 4.7333333 0.441350
+ 4.7361111 0.451899
+ 4.7388889 0.466667
+ 4.7416667 0.481435
+ 4.7444444 0.485654
+ 4.7472222 0.485654
+ 4.7500000 0.475105
+ 4.7527778 0.464557
+ 4.7555556 0.454008
+ 4.7583333 0.445570
+ 4.7611111 0.437131
+ 4.7638889 0.428692
+ 4.7666667 0.430802
+ 4.7694444 0.443460
+ 4.7722222 0.454008
+ 4.7750000 0.462447
+ 4.7777778 0.468776
+ 4.7805556 0.477215
+ 4.7833333 0.483544
+ 4.7861111 0.485654
+ 4.7888889 0.481435
+ 4.7916667 0.472996
+ 4.7944444 0.460338
+ 4.7972222 0.460338
+ 4.8000000 0.456118
+ 4.8027778 0.464557
+ 4.8055556 0.481435
+ 4.8083333 0.489873
+ 4.8111111 0.500422
+ 4.8138889 0.510970
+ 4.8166667 0.506751
+ 4.8194444 0.508861
+ 4.8222222 0.502532
+ 4.8250000 0.489873
+ 4.8277778 0.483544
+ 4.8305556 0.485654
+ 4.8333333 0.485654
+ 4.8361111 0.489873
+ 4.8388889 0.496203
+ 4.8416667 0.483544
+ 4.8444444 0.481435
+ 4.8472222 0.487764
+ 4.8500000 0.494093
+ 4.8527778 0.508861
+ 4.8555556 0.519409
+ 4.8583333 0.523629
+ 4.8611111 0.521519
+ 4.8638889 0.521519
+ 4.8666667 0.519409
+ 4.8694444 0.525738
+ 4.8722222 0.521519
+ 4.8750000 0.519409
+ 4.8777778 0.519409
+ 4.8805556 0.521519
+ 4.8833333 0.532068
+ 4.8861111 0.542616
+ 4.8888889 0.548945
+ 4.8916667 0.557384
+ 4.8944444 0.565823
+ 4.8972222 0.574262
+ 4.9000000 0.572152
+ 4.9027778 0.576371
+ 4.9055556 0.576371
+ 4.9083333 0.567932
+ 4.9111111 0.561603
+ 4.9138889 0.555274
+ 4.9166667 0.553165
+ 4.9194444 0.551055
+ 4.9222222 0.555274
+ 4.9250000 0.563713
+ 4.9277778 0.578481
+ 4.9305556 0.593249
+ 4.9333333 0.599578
+ 4.9361111 0.595359
+ 4.9388889 0.580591
+ 4.9416667 0.555274
+ 4.9444444 0.536287
+ 4.9472222 0.527848
+ 4.9500000 0.527848
+ 4.9527778 0.527848
+ 4.9555556 0.534177
+ 4.9583333 0.546835
+ 4.9611111 0.551055
+ 4.9638889 0.551055
+ 4.9666667 0.546835
+ 4.9694444 0.544726
+ 4.9722222 0.551055
+ 4.9750000 0.551055
+ 4.9777778 0.544726
+ 4.9805556 0.538397
+ 4.9833333 0.525738
+ 4.9861111 0.502532
+ 4.9888889 0.494093
+ 4.9916667 0.483544
+ 4.9944444 0.485654
+ 4.9972222 0.487764
+ 5.0000000 0.489873
+ 5.0027778 0.487764
+ 5.0055556 0.485654
+ 5.0083333 0.483544
+ 5.0111111 0.487764
+ 5.0138889 0.494093
+ 5.0166667 0.496203
+ 5.0194444 0.487764
+ 5.0222222 0.475105
+ 5.0250000 0.456118
+ 5.0277778 0.454008
+ 5.0305556 0.451899
+ 5.0333333 0.456118
+ 5.0361111 0.462447
+ 5.0388889 0.460338
+ 5.0416667 0.449789
+ 5.0444444 0.447679
+ 5.0472222 0.447679
+ 5.0500000 0.458228
+ 5.0527778 0.460338
+ 5.0555556 0.458228
+ 5.0583333 0.460338
+ 5.0611111 0.460338
+ 5.0638889 0.466667
+ 5.0666667 0.470886
+ 5.0694444 0.481435
+ 5.0722222 0.491983
+ 5.0750000 0.496203
+ 5.0777778 0.500422
+ 5.0805556 0.494093
+ 5.0833333 0.489873
+ 5.0861111 0.489873
+ 5.0888889 0.489873
+ 5.0916667 0.479325
+ 5.0944444 0.472996
+ 5.0972222 0.472996
+ 5.1000000 0.477215
+ 5.1027778 0.479325
+ 5.1055556 0.479325
+ 5.1083333 0.485654
+ 5.1111111 0.489873
+ 5.1138889 0.489873
+ 5.1166667 0.496203
+ 5.1194444 0.496203
+ 5.1222222 0.498312
+ 5.1250000 0.485654
+ 5.1277778 0.472996
+ 5.1305556 0.468776
+ 5.1333333 0.472996
+ 5.1361111 0.487764
+ 5.1388889 0.498312
+ 5.1416667 0.504641
+ 5.1444444 0.506751
+ 5.1472222 0.506751
+ 5.1500000 0.502532
+ 5.1527778 0.496203
+ 5.1555556 0.487764
+ 5.1583333 0.489873
+ 5.1611111 0.487764
+ 5.1638889 0.491983
+ 5.1666667 0.491983
+ 5.1694444 0.494093
+ 5.1722222 0.502532
+ 5.1750000 0.502532
+ 5.1777778 0.491983
+ 5.1805556 0.475105
+ 5.1833333 0.470886
+ 5.1861111 0.472996
+ 5.1888889 0.477215
+ 5.1916667 0.483544
+ 5.1944444 0.489873
+ 5.1972222 0.485654
+ 5.2000000 0.481435
+ 5.2027778 0.475105
+ 5.2055556 0.472996
+ 5.2083333 0.479325
+ 5.2111111 0.485654
+ 5.2138889 0.491983
+ 5.2166667 0.494093
+ 5.2194444 0.491983
+ 5.2222222 0.483544
+ 5.2250000 0.472996
+ 5.2277778 0.464557
+ 5.2305556 0.466667
+ 5.2333333 0.475105
+ 5.2361111 0.485654
+ 5.2388889 0.494093
+ 5.2416667 0.489873
+ 5.2444444 0.487764
+ 5.2472222 0.485654
+ 5.2500000 0.479325
+ 5.2527778 0.479325
+ 5.2555556 0.479325
+ 5.2583333 0.483544
+ 5.2611111 0.485654
+ 5.2638889 0.487764
+ 5.2666667 0.496203
+ 5.2694444 0.515190
+ 5.2722222 0.546835
+ 5.2750000 0.589030
+ 5.2777778 0.639662
+ 5.2805556 0.696624
+ 5.2833333 0.749367
+ 5.2861111 0.787342
+ 5.2888889 0.800000
+ 5.2916667 0.781013
+ 5.2944444 0.702954
+ 5.2972222 0.591139
+ 5.3000000 0.477215
+ 5.3027778 0.392827
+ 5.3055556 0.342194
+ 5.3083333 0.323207
+ 5.3111111 0.329536
+ 5.3138889 0.337975
+ 5.3166667 0.350633
+ 5.3194444 0.361181
+ 5.3222222 0.373840
+ 5.3250000 0.375949
+ 5.3277778 0.380169
+ 5.3305556 0.371730
+ 5.3333333 0.356962
+ 5.3361111 0.354852
+ 5.3388889 0.356962
+ 5.3416667 0.371730
+ 5.3444444 0.386498
+ 5.3472222 0.399156
+ 5.3500000 0.405485
+ 5.3527778 0.405485
+ 5.3555556 0.392827
+ 5.3583333 0.386498
+ 5.3611111 0.386498
+ 5.3638889 0.392827
+ 5.3666667 0.392827
+ 5.3694444 0.399156
+ 5.3722222 0.403376
+ 5.3750000 0.416034
+ 5.3777778 0.426582
+ 5.3805556 0.445570
+ 5.3833333 0.466667
+ 5.3861111 0.487764
+ 5.3888889 0.506751
+ 5.3916667 0.502532
+ 5.3944444 0.494093
+ 5.3972222 0.485654
+ 5.4000000 0.479325
+ 5.4027778 0.475105
+ 5.4055556 0.481435
+ 5.4083333 0.477215
+ 5.4111111 0.477215
+ 5.4138889 0.475105
+ 5.4166667 0.470886
+ 5.4194444 0.460338
+ 5.4222222 0.464557
+ 5.4250000 0.472996
+ 5.4277778 0.483544
+ 5.4305556 0.487764
+ 5.4333333 0.489873
+ 5.4361111 0.496203
+ 5.4388889 0.489873
+ 5.4416667 0.483544
+ 5.4444444 0.479325
+ 5.4472222 0.477215
+ 5.4500000 0.477215
+ 5.4527778 0.477215
+ 5.4555556 0.479325
+ 5.4583333 0.485654
+ 5.4611111 0.496203
+ 5.4638889 0.506751
+ 5.4666667 0.513080
+ 5.4694444 0.517300
+ 5.4722222 0.504641
+ 5.4750000 0.504641
+ 5.4777778 0.498312
+ 5.4805556 0.496203
+ 5.4833333 0.489873
+ 5.4861111 0.489873
+ 5.4888889 0.485654
+ 5.4916667 0.479325
+ 5.4944444 0.485654
+ 5.4972222 0.500422
+ 5.5000000 0.510970
+ 5.5027778 0.525738
+ 5.5055556 0.527848
+ 5.5083333 0.529958
+ 5.5111111 0.523629
+ 5.5138889 0.513080
+ 5.5166667 0.510970
+ 5.5194444 0.513080
+ 5.5222222 0.521519
+ 5.5250000 0.527848
+ 5.5277778 0.542616
+ 5.5305556 0.557384
+ 5.5333333 0.572152
+ 5.5361111 0.584810
+ 5.5388889 0.591139
+ 5.5416667 0.582700
+ 5.5444444 0.570042
+ 5.5472222 0.555274
+ 5.5500000 0.542616
+ 5.5527778 0.544726
+ 5.5555556 0.546835
+ 5.5583333 0.563713
+ 5.5611111 0.570042
+ 5.5638889 0.582700
+ 5.5666667 0.582700
+ 5.5694444 0.586920
+ 5.5722222 0.586920
+ 5.5750000 0.589030
+ 5.5777778 0.586920
+ 5.5805556 0.582700
+ 5.5833333 0.580591
+ 5.5861111 0.582700
+ 5.5888889 0.584810
+ 5.5916667 0.582700
+ 5.5944444 0.572152
+ 5.5972222 0.561603
+ 5.6000000 0.555274
+ 5.6027778 0.548945
+ 5.6055556 0.544726
+ 5.6083333 0.534177
+ 5.6111111 0.536287
+ 5.6138889 0.527848
+ 5.6166667 0.519409
+ 5.6194444 0.506751
+ 5.6222222 0.500422
+ 5.6250000 0.500422
+ 5.6277778 0.502532
+ 5.6305556 0.506751
+ 5.6333333 0.506751
+ 5.6361111 0.506751
+ 5.6388889 0.508861
+ 5.6416667 0.502532
+ 5.6444444 0.489873
+ 5.6472222 0.472996
+ 5.6500000 0.456118
+ 5.6527778 0.449789
+ 5.6555556 0.437131
+ 5.6583333 0.439241
+ 5.6611111 0.445570
+ 5.6638889 0.456118
+ 5.6666667 0.462447
+ 5.6694444 0.475105
+ 5.6722222 0.485654
+ 5.6750000 0.489873
+ 5.6777778 0.504641
+ 5.6805556 0.513080
+ 5.6833333 0.527848
+ 5.6861111 0.519409
+ 5.6888889 0.500422
+ 5.6916667 0.454008
+ 5.6944444 0.409705
+ 5.6972222 0.382278
+ 5.7000000 0.386498
+ 5.7027778 0.405485
+ 5.7055556 0.435021
+ 5.7083333 0.466667
+ 5.7111111 0.483544
+ 5.7138889 0.489873
+ 5.7166667 0.487764
+ 5.7194444 0.479325
+ 5.7222222 0.464557
+ 5.7250000 0.445570
+ 5.7277778 0.447679
+ 5.7305556 0.445570
+ 5.7333333 0.454008
+ 5.7361111 0.462447
+ 5.7388889 0.464557
+ 5.7416667 0.462447
+ 5.7444444 0.458228
+ 5.7472222 0.451899
+ 5.7500000 0.445570
+ 5.7527778 0.445570
+ 5.7555556 0.451899
+ 5.7583333 0.460338
+ 5.7611111 0.462447
+ 5.7638889 0.454008
+ 5.7666667 0.449789
+ 5.7694444 0.447679
+ 5.7722222 0.451899
+ 5.7750000 0.468776
+ 5.7777778 0.481435
+ 5.7805556 0.489873
+ 5.7833333 0.481435
+ 5.7861111 0.468776
+ 5.7888889 0.451899
+ 5.7916667 0.443460
+ 5.7944444 0.443460
+ 5.7972222 0.447679
+ 5.8000000 0.464557
+ 5.8027778 0.470886
+ 5.8055556 0.475105
+ 5.8083333 0.472996
+ 5.8111111 0.475105
+ 5.8138889 0.481435
+ 5.8166667 0.483544
+ 5.8194444 0.485654
+ 5.8222222 0.491983
+ 5.8250000 0.489873
+ 5.8277778 0.481435
+ 5.8305556 0.475105
+ 5.8333333 0.470886
+ 5.8361111 0.454008
+ 5.8388889 0.443460
+ 5.8416667 0.443460
+ 5.8444444 0.449789
+ 5.8472222 0.460338
+ 5.8500000 0.468776
+ 5.8527778 0.468776
+ 5.8555556 0.466667
+ 5.8583333 0.466667
+ 5.8611111 0.472996
+ 5.8638889 0.470886
+ 5.8666667 0.472996
+ 5.8694444 0.466667
+ 5.8722222 0.460338
+ 5.8750000 0.456118
+ 5.8777778 0.456118
+ 5.8805556 0.456118
+ 5.8833333 0.462447
+ 5.8861111 0.466667
+ 5.8888889 0.464557
+ 5.8916667 0.466667
+ 5.8944444 0.470886
+ 5.8972222 0.466667
+ 5.9000000 0.460338
+ 5.9027778 0.454008
+ 5.9055556 0.449789
+ 5.9083333 0.456118
+ 5.9111111 0.456118
+ 5.9138889 0.464557
+ 5.9166667 0.470886
+ 5.9194444 0.475105
+ 5.9222222 0.475105
+ 5.9250000 0.479325
+ 5.9277778 0.470886
+ 5.9305556 0.470886
+ 5.9333333 0.468776
+ 5.9361111 0.468776
+ 5.9388889 0.458228
+ 5.9416667 0.458228
+ 5.9444444 0.451899
+ 5.9472222 0.451899
+ 5.9500000 0.456118
+ 5.9527778 0.468776
+ 5.9555556 0.477215
+ 5.9583333 0.481435
+ 5.9611111 0.483544
+ 5.9638889 0.483544
+ 5.9666667 0.483544
+ 5.9694444 0.487764
+ 5.9722222 0.494093
+ 5.9750000 0.513080
+ 5.9777778 0.529958
+ 5.9805556 0.555274
+ 5.9833333 0.584810
+ 5.9861111 0.631224
+ 5.9888889 0.669198
+ 5.9916667 0.713502
+ 5.9944444 0.724051
+ 5.9972222 0.705063
+ 6.0000000 0.645992
+ 6.0027778 0.546835
+ 6.0055556 0.441350
+ 6.0083333 0.359072
+ 6.0111111 0.314768
+ 6.0138889 0.304219
+ 6.0166667 0.314768
+ 6.0194444 0.335865
+ 6.0222222 0.352743
+ 6.0250000 0.367511
+ 6.0277778 0.380169
+ 6.0305556 0.388608
+ 6.0333333 0.394937
+ 6.0361111 0.399156
+ 6.0388889 0.397046
+ 6.0416667 0.388608
+ 6.0444444 0.378059
+ 6.0472222 0.361181
+ 6.0500000 0.352743
+ 6.0527778 0.350633
+ 6.0555556 0.346414
+ 6.0583333 0.346414
+ 6.0611111 0.348523
+ 6.0638889 0.356962
+ 6.0666667 0.367511
+ 6.0694444 0.388608
+ 6.0722222 0.399156
+ 6.0750000 0.407595
+ 6.0777778 0.416034
+ 6.0805556 0.420253
+ 6.0833333 0.430802
+ 6.0861111 0.430802
+ 6.0888889 0.432911
+ 6.0916667 0.443460
+ 6.0944444 0.445570
+ 6.0972222 0.454008
+ 6.1000000 0.451899
+ 6.1027778 0.451899
+ 6.1055556 0.454008
+ 6.1083333 0.458228
+ 6.1111111 0.462447
+ 6.1138889 0.464557
+ 6.1166667 0.462447
+ 6.1194444 0.468776
+ 6.1222222 0.475105
+ 6.1250000 0.485654
+ 6.1277778 0.496203
+ 6.1305556 0.498312
+ 6.1333333 0.496203
+ 6.1361111 0.494093
+ 6.1388889 0.485654
+ 6.1416667 0.464557
+ 6.1444444 0.443460
+ 6.1472222 0.422363
+ 6.1500000 0.424473
+ 6.1527778 0.432911
+ 6.1555556 0.443460
+ 6.1583333 0.462447
+ 6.1611111 0.475105
+ 6.1638889 0.485654
+ 6.1666667 0.491983
+ 6.1694444 0.489873
+ 6.1722222 0.489873
+ 6.1750000 0.487764
+ 6.1777778 0.485654
+ 6.1805556 0.477215
+ 6.1833333 0.470886
+ 6.1861111 0.464557
+ 6.1888889 0.458228
+ 6.1916667 0.466667
+ 6.1944444 0.468776
+ 6.1972222 0.479325
+ 6.2000000 0.485654
+ 6.2027778 0.489873
+ 6.2055556 0.500422
+ 6.2083333 0.515190
+ 6.2111111 0.525738
+ 6.2138889 0.540506
+ 6.2166667 0.536287
+ 6.2194444 0.510970
+ 6.2222222 0.485654
+ 6.2250000 0.466667
+ 6.2277778 0.458228
+ 6.2305556 0.464557
+ 6.2333333 0.479325
+ 6.2361111 0.502532
+ 6.2388889 0.519409
+ 6.2416667 0.536287
+ 6.2444444 0.544726
+ 6.2472222 0.540506
+ 6.2500000 0.538397
+ 6.2527778 0.551055
+ 6.2555556 0.559494
+ 6.2583333 0.572152
+ 6.2611111 0.574262
+ 6.2638889 0.578481
+ 6.2666667 0.572152
+ 6.2694444 0.555274
+ 6.2722222 0.542616
+ 6.2750000 0.532068
+ 6.2777778 0.529958
+ 6.2805556 0.534177
+ 6.2833333 0.546835
+ 6.2861111 0.555274
+ 6.2888889 0.570042
+ 6.2916667 0.584810
+ 6.2944444 0.595359
+ 6.2972222 0.595359
+ 6.3000000 0.580591
+ 6.3027778 0.574262
+ 6.3055556 0.567932
+ 6.3083333 0.559494
+ 6.3111111 0.557384
+ 6.3138889 0.548945
+ 6.3166667 0.536287
+ 6.3194444 0.519409
+ 6.3222222 0.506751
+ 6.3250000 0.508861
+ 6.3277778 0.508861
+ 6.3305556 0.510970
+ 6.3333333 0.519409
+ 6.3361111 0.523629
+ 6.3388889 0.521519
+ 6.3416667 0.513080
+ 6.3444444 0.513080
+ 6.3472222 0.510970
+ 6.3500000 0.515190
+ 6.3527778 0.521519
+ 6.3555556 0.525738
+ 6.3583333 0.523629
+ 6.3611111 0.506751
+ 6.3638889 0.477215
+ 6.3666667 0.445570
+ 6.3694444 0.426582
+ 6.3722222 0.424473
+ 6.3750000 0.432911
+ 6.3777778 0.445570
+ 6.3805556 0.458228
+ 6.3833333 0.468776
+ 6.3861111 0.472996
+ 6.3888889 0.472996
+ 6.3916667 0.479325
+ 6.3944444 0.472996
+ 6.3972222 0.483544
+ 6.4000000 0.496203
+ 6.4027778 0.517300
+ 6.4055556 0.523629
+ 6.4083333 0.502532
+ 6.4111111 0.472996
+ 6.4138889 0.426582
+ 6.4166667 0.397046
+ 6.4194444 0.392827
+ 6.4222222 0.405485
+ 6.4250000 0.432911
+ 6.4277778 0.456118
+ 6.4305556 0.475105
+ 6.4333333 0.483544
+ 6.4361111 0.487764
+ 6.4388889 0.494093
+ 6.4416667 0.483544
+ 6.4444444 0.477215
+ 6.4472222 0.475105
+ 6.4500000 0.458228
+ 6.4527778 0.454008
+ 6.4555556 0.445570
+ 6.4583333 0.447679
+ 6.4611111 0.451899
+ 6.4638889 0.456118
+ 6.4666667 0.468776
+ 6.4694444 0.481435
+ 6.4722222 0.483544
+ 6.4750000 0.479325
+ 6.4777778 0.470886
+ 6.4805556 0.472996
+ 6.4833333 0.470886
+ 6.4861111 0.464557
+ 6.4888889 0.466667
+ 6.4916667 0.475105
+ 6.4944444 0.479325
+ 6.4972222 0.477215
+ 6.5000000 0.472996
+ 6.5027778 0.472996
+ 6.5055556 0.470886
+ 6.5083333 0.470886
+ 6.5111111 0.475105
+ 6.5138889 0.472996
+ 6.5166667 0.470886
+ 6.5194444 0.462447
+ 6.5222222 0.458228
+ 6.5250000 0.458228
+ 6.5277778 0.458228
+ 6.5305556 0.460338
+ 6.5333333 0.464557
+ 6.5361111 0.468776
+ 6.5388889 0.475105
+ 6.5416667 0.481435
+ 6.5444444 0.481435
+ 6.5472222 0.481435
+ 6.5500000 0.475105
+ 6.5527778 0.466667
+ 6.5555556 0.460338
+ 6.5583333 0.456118
+ 6.5611111 0.456118
+ 6.5638889 0.451899
+ 6.5666667 0.458228
+ 6.5694444 0.460338
+ 6.5722222 0.458228
+ 6.5750000 0.462447
+ 6.5777778 0.466667
+ 6.5805556 0.472996
+ 6.5833333 0.472996
+ 6.5861111 0.468776
+ 6.5888889 0.464557
+ 6.5916667 0.462447
+ 6.5944444 0.458228
+ 6.5972222 0.466667
+ 6.6000000 0.460338
+ 6.6027778 0.464557
+ 6.6055556 0.458228
+ 6.6083333 0.454008
+ 6.6111111 0.451899
+ 6.6138889 0.460338
+ 6.6166667 0.464557
+ 6.6194444 0.462447
+ 6.6222222 0.458228
+ 6.6250000 0.460338
+ 6.6277778 0.451899
+ 6.6305556 0.447679
+ 6.6333333 0.456118
+ 6.6361111 0.464557
+ 6.6388889 0.470886
+ 6.6416667 0.468776
+ 6.6444444 0.466667
+ 6.6472222 0.460338
+ 6.6500000 0.458228
+ 6.6527778 0.458228
+ 6.6555556 0.451899
+ 6.6583333 0.443460
+ 6.6611111 0.437131
+ 6.6638889 0.441350
+ 6.6666667 0.445570
+ 6.6694444 0.460338
+ 6.6722222 0.462447
+ 6.6750000 0.460338
+ 6.6777778 0.462447
+ 6.6805556 0.460338
+ 6.6833333 0.462447
+ 6.6861111 0.458228
+ 6.6888889 0.454008
+ 6.6916667 0.454008
+ 6.6944444 0.454008
+ 6.6972222 0.460338
+ 6.7000000 0.460338
+ 6.7027778 0.458228
+ 6.7055556 0.462447
+ 6.7083333 0.451899
+ 6.7111111 0.454008
+ 6.7138889 0.456118
+ 6.7166667 0.458228
+ 6.7194444 0.464557
+ 6.7222222 0.468776
+ 6.7250000 0.464557
+ 6.7277778 0.458228
+ 6.7305556 0.449789
+ 6.7333333 0.447679
+ 6.7361111 0.451899
+ 6.7388889 0.466667
+ 6.7416667 0.472996
+ 6.7444444 0.477215
+ 6.7472222 0.470886
+ 6.7500000 0.464557
+ 6.7527778 0.449789
+ 6.7555556 0.449789
+ 6.7583333 0.454008
+ 6.7611111 0.456118
+ 6.7638889 0.462447
+ 6.7666667 0.460338
+ 6.7694444 0.458228
+ 6.7722222 0.454008
+ 6.7750000 0.458228
+ 6.7777778 0.456118
+ 6.7805556 0.458228
+ 6.7833333 0.464557
+ 6.7861111 0.466667
+ 6.7888889 0.460338
+ 6.7916667 0.462447
+ 6.7944444 0.456118
+ 6.7972222 0.458228
+ 6.8000000 0.460338
+ 6.8027778 0.462447
+ 6.8055556 0.468776
+ 6.8083333 0.468776
+ 6.8111111 0.479325
+ 6.8138889 0.475105
+ 6.8166667 0.477215
+ 6.8194444 0.460338
+ 6.8222222 0.449789
+ 6.8250000 0.439241
+ 6.8277778 0.437131
+ 6.8305556 0.441350
+ 6.8333333 0.456118
+ 6.8361111 0.464557
+ 6.8388889 0.470886
+ 6.8416667 0.468776
+ 6.8444444 0.470886
+ 6.8472222 0.462447
+ 6.8500000 0.462447
+ 6.8527778 0.468776
+ 6.8555556 0.464557
+ 6.8583333 0.462447
+ 6.8611111 0.456118
+ 6.8638889 0.462447
+ 6.8666667 0.456118
+ 6.8694444 0.458228
+ 6.8722222 0.460338
+ 6.8750000 0.456118
+ 6.8777778 0.443460
+ 6.8805556 0.437131
+ 6.8833333 0.437131
+ 6.8861111 0.443460
+ 6.8888889 0.447679
+ 6.8916667 0.456118
+ 6.8944444 0.462447
+ 6.8972222 0.466667
+ 6.9000000 0.466667
+ 6.9027778 0.462447
+ 6.9055556 0.458228
+ 6.9083333 0.454008
+ 6.9111111 0.458228
+ 6.9138889 0.458228
+ 6.9166667 0.460338
+ 6.9194444 0.458228
+ 6.9222222 0.458228
+ 6.9250000 0.462447
+ 6.9277778 0.462447
+ 6.9305556 0.464557
+ 6.9333333 0.460338
+ 6.9361111 0.458228
+ 6.9388889 0.458228
+ 6.9416667 0.456118
+ 6.9444444 0.458228
+ 6.9472222 0.466667
+ 6.9500000 0.472996
+ 6.9527778 0.475105
+ 6.9555556 0.466667
+ 6.9583333 0.454008
+ 6.9611111 0.447679
+ 6.9638889 0.439241
+ 6.9666667 0.443460
+ 6.9694444 0.451899
+ 6.9722222 0.456118
+ 6.9750000 0.462447
+ 6.9777778 0.466667
+ 6.9805556 0.462447
+ 6.9833333 0.458228
+ 6.9861111 0.449789
+ 6.9888889 0.443460
+ 6.9916667 0.443460
+ 6.9944444 0.445570
+ 6.9972222 0.454008
+ 7.0000000 0.462447
+ 7.0027778 0.479325
+ 7.0055556 0.483544
+ 7.0083333 0.479325
+ 7.0111111 0.470886
+ 7.0138889 0.460338
+ 7.0166667 0.449789
+ 7.0194444 0.449789
+ 7.0222222 0.451899
+ 7.0250000 0.456118
+ 7.0277778 0.456118
+ 7.0305556 0.443460
+ 7.0333333 0.445570
+ 7.0361111 0.449789
+ 7.0388889 0.458228
+ 7.0416667 0.468776
+ 7.0444444 0.475105
+ 7.0472222 0.483544
+ 7.0500000 0.483544
+ 7.0527778 0.472996
+ 7.0555556 0.454008
+ 7.0583333 0.445570
+ 7.0611111 0.441350
+ 7.0638889 0.439241
+ 7.0666667 0.439241
+ 7.0694444 0.449789
+ 7.0722222 0.456118
+ 7.0750000 0.451899
+ 7.0777778 0.451899
+ 7.0805556 0.449789
+ 7.0833333 0.439241
+ 7.0861111 0.441350
+ 7.0888889 0.443460
+ 7.0916667 0.447679
+ 7.0944444 0.456118
+ 7.0972222 0.472996
+ 7.1000000 0.483544
+ 7.1027778 0.496203
+ 7.1055556 0.498312
+ 7.1083333 0.489873
+ 7.1111111 0.485654
+ 7.1138889 0.470886
+ 7.1166667 0.458228
+ 7.1194444 0.443460
+ 7.1222222 0.435021
+ 7.1250000 0.432911
+ 7.1277778 0.428692
+ 7.1305556 0.435021
+ 7.1333333 0.447679
+ 7.1361111 0.454008
+ 7.1388889 0.462447
+ 7.1416667 0.462447
+ 7.1444444 0.466667
+ 7.1472222 0.460338
+ 7.1500000 0.464557
+ 7.1527778 0.470886
+ 7.1555556 0.477215
+ 7.1583333 0.487764
+ 7.1611111 0.487764
+ 7.1638889 0.494093
+ 7.1666667 0.477215
+ 7.1694444 0.464557
+ 7.1722222 0.454008
+ 7.1750000 0.445570
+ 7.1777778 0.443460
+ 7.1805556 0.439241
+ 7.1833333 0.449789
+ 7.1861111 0.449789
+ 7.1888889 0.456118
+ 7.1916667 0.462447
+ 7.1944444 0.464557
+ 7.1972222 0.477215
+ 7.2000000 0.477215
+ 7.2027778 0.477215
+ 7.2055556 0.470886
+ 7.2083333 0.468776
+ 7.2111111 0.462447
+ 7.2138889 0.458228
+ 7.2166667 0.462447
+ 7.2194444 0.460338
+ 7.2222222 0.466667
+ 7.2250000 0.468776
+ 7.2277778 0.470886
+ 7.2305556 0.466667
+ 7.2333333 0.460338
+ 7.2361111 0.456118
+ 7.2388889 0.454008
+ 7.2416667 0.460338
+ 7.2444444 0.464557
+ 7.2472222 0.468776
+ 7.2500000 0.468776
+ 7.2527778 0.468776
+ 7.2555556 0.475105
+ 7.2583333 0.468776
+ 7.2611111 0.464557
+ 7.2638889 0.464557
+ 7.2666667 0.464557
+ 7.2694444 0.462447
+ 7.2722222 0.458228
+ 7.2750000 0.462447
+ 7.2777778 0.462447
+ 7.2805556 0.470886
+ 7.2833333 0.470886
+ 7.2861111 0.454008
+ 7.2888889 0.447679
+ 7.2916667 0.439241
+ 7.2944444 0.435021
+ 7.2972222 0.432911
+ 7.3000000 0.447679
+ 7.3027778 0.460338
+ 7.3055556 0.466667
+ 7.3083333 0.479325
+ 7.3111111 0.485654
+ 7.3138889 0.483544
+ 7.3166667 0.485654
+ 7.3194444 0.485654
+ 7.3222222 0.475105
+ 7.3250000 0.479325
+ 7.3277778 0.483544
+ 7.3305556 0.481435
+ 7.3333333 0.479325
+ 7.3361111 0.472996
+ 7.3388889 0.454008
+ 7.3416667 0.443460
+ 7.3444444 0.441350
+ 7.3472222 0.441350
+ 7.3500000 0.449789
+ 7.3527778 0.456118
+ 7.3555556 0.462447
+ 7.3583333 0.464557
+ 7.3611111 0.464557
+ 7.3638889 0.460338
+ 7.3666667 0.462447
+ 7.3694444 0.468776
+ 7.3722222 0.475105
+ 7.3750000 0.470886
+ 7.3777778 0.472996
+ 7.3805556 0.472996
+ 7.3833333 0.470886
+ 7.3861111 0.470886
+ 7.3888889 0.466667
+ 7.3916667 0.464557
+ 7.3944444 0.466667
+ 7.3972222 0.472996
+ 7.4000000 0.470886
+ 7.4027778 0.479325
+ 7.4055556 0.472996
+ 7.4083333 0.470886
+ 7.4111111 0.468776
+ 7.4138889 0.460338
+ 7.4166667 0.464557
+ 7.4194444 0.472996
+ 7.4222222 0.483544
+ 7.4250000 0.485654
+ 7.4277778 0.483544
+ 7.4305556 0.470886
+ 7.4333333 0.464557
+ 7.4361111 0.456118
+ 7.4388889 0.460338
+ 7.4416667 0.464557
+ 7.4444444 0.456118
+ 7.4472222 0.456118
+ 7.4500000 0.456118
+ 7.4527778 0.458228
+ 7.4555556 0.466667
+ 7.4583333 0.470886
+ 7.4611111 0.472996
+ 7.4638889 0.477215
+ 7.4666667 0.470886
+ 7.4694444 0.462447
+ 7.4722222 0.458228
+ 7.4750000 0.451899
+ 7.4777778 0.454008
+ 7.4805556 0.468776
+ 7.4833333 0.472996
+ 7.4861111 0.475105
+ 7.4888889 0.479325
+ 7.4916667 0.475105
+ 7.4944444 0.466667
+ 7.4972222 0.462447
+ 7.5000000 0.458228
+ 7.5027778 0.456118
+ 7.5055556 0.464557
+ 7.5083333 0.468776
+ 7.5111111 0.477215
+ 7.5138889 0.477215
+ 7.5166667 0.468776
+ 7.5194444 0.470886
+ 7.5222222 0.468776
+ 7.5250000 0.472996
+ 7.5277778 0.468776
+ 7.5305556 0.470886
+ 7.5333333 0.468776
+ 7.5361111 0.466667
+ 7.5388889 0.468776
+ 7.5416667 0.460338
+ 7.5444444 0.451899
+ 7.5472222 0.449789
+ 7.5500000 0.458228
+ 7.5527778 0.464557
+ 7.5555556 0.466667
+ 7.5583333 0.468776
+ 7.5611111 0.468776
+ 7.5638889 0.464557
+ 7.5666667 0.464557
+ 7.5694444 0.460338
+ 7.5722222 0.460338
+ 7.5750000 0.458228
+ 7.5777778 0.468776
+ 7.5805556 0.472996
+ 7.5833333 0.479325
+ 7.5861111 0.479325
+ 7.5888889 0.483544
+ 7.5916667 0.470886
+ 7.5944444 0.460338
+ 7.5972222 0.456118
+ 7.6000000 0.458228
+ 7.6027778 0.466667
+ 7.6055556 0.479325
+ 7.6083333 0.489873
+ 7.6111111 0.496203
+ 7.6138889 0.491983
+ 7.6166667 0.477215
+ 7.6194444 0.462447
+ 7.6222222 0.451899
+ 7.6250000 0.449789
+ 7.6277778 0.451899
+ 7.6305556 0.462447
+ 7.6333333 0.470886
+ 7.6361111 0.479325
+ 7.6388889 0.487764
+ 7.6416667 0.496203
+ 7.6444444 0.502532
+ 7.6472222 0.498312
+ 7.6500000 0.513080
+ 7.6527778 0.519409
+ 7.6555556 0.513080
+ 7.6583333 0.502532
+ 7.6611111 0.485654
+ 7.6638889 0.477215
+ 7.6666667 0.479325
+ 7.6694444 0.479325
+ 7.6722222 0.487764
+ 7.6750000 0.494093
+ 7.6777778 0.489873
+ 7.6805556 0.491983
+ 7.6833333 0.489873
+ 7.6861111 0.491983
+ 7.6888889 0.487764
+ 7.6916667 0.481435
+ 7.6944444 0.481435
+ 7.6972222 0.483544
+ 7.7000000 0.487764
+ 7.7027778 0.487764
+ 7.7055556 0.487764
+ 7.7083333 0.489873
+ 7.7111111 0.483544
+ 7.7138889 0.479325
+ 7.7166667 0.479325
+ 7.7194444 0.477215
+ 7.7222222 0.475105
+ 7.7250000 0.475105
+ 7.7277778 0.483544
+ 7.7305556 0.479325
+ 7.7333333 0.475105
+ 7.7361111 0.477215
+ 7.7388889 0.470886
+ 7.7416667 0.462447
+ 7.7444444 0.460338
+ 7.7472222 0.454008
+ 7.7500000 0.451899
+ 7.7527778 0.445570
+ 7.7555556 0.441350
+ 7.7583333 0.449789
+ 7.7611111 0.458228
+ 7.7638889 0.462447
+ 7.7666667 0.466667
+ 7.7694444 0.466667
+ 7.7722222 0.464557
+ 7.7750000 0.460338
+ 7.7777778 0.454008
+ 7.7805556 0.454008
+ 7.7833333 0.454008
+ 7.7861111 0.460338
+ 7.7888889 0.460338
+ 7.7916667 0.472996
+ 7.7944444 0.475105
+ 7.7972222 0.475105
+ 7.8000000 0.472996
+ 7.8027778 0.466667
+ 7.8055556 0.464557
+ 7.8083333 0.466667
+ 7.8111111 0.470886
+ 7.8138889 0.475105
+ 7.8166667 0.479325
+ 7.8194444 0.470886
+ 7.8222222 0.464557
+ 7.8250000 0.456118
+ 7.8277778 0.458228
+ 7.8305556 0.462447
+ 7.8333333 0.470886
+ 7.8361111 0.481435
+ 7.8388889 0.491983
+ 7.8416667 0.496203
+ 7.8444444 0.515190
+ 7.8472222 0.532068
+ 7.8500000 0.557384
+ 7.8527778 0.595359
+ 7.8555556 0.633333
+ 7.8583333 0.673418
+ 7.8611111 0.686076
+ 7.8638889 0.664979
+ 7.8666667 0.601688
+ 7.8694444 0.515190
+ 7.8722222 0.432911
+ 7.8750000 0.371730
+ 7.8777778 0.342194
+ 7.8805556 0.333755
+ 7.8833333 0.337975
+ 7.8861111 0.344304
+ 7.8888889 0.359072
+ 7.8916667 0.369620
+ 7.8944444 0.378059
+ 7.8972222 0.382278
+ 7.9000000 0.375949
+ 7.9027778 0.369620
+ 7.9055556 0.363291
+ 7.9083333 0.365401
+ 7.9111111 0.371730
+ 7.9138889 0.380169
+ 7.9166667 0.382278
+ 7.9194444 0.382278
+ 7.9222222 0.373840
+ 7.9250000 0.378059
+ 7.9277778 0.378059
+ 7.9305556 0.380169
+ 7.9333333 0.384388
+ 7.9361111 0.390717
+ 7.9388889 0.388608
+ 7.9416667 0.384388
+ 7.9444444 0.388608
+ 7.9472222 0.397046
+ 7.9500000 0.403376
+ 7.9527778 0.411814
+ 7.9555556 0.424473
+ 7.9583333 0.435021
+ 7.9611111 0.445570
+ 7.9638889 0.460338
+ 7.9666667 0.470886
+ 7.9694444 0.479325
+ 7.9722222 0.477215
+ 7.9750000 0.468776
+ 7.9777778 0.462447
+ 7.9805556 0.456118
+ 7.9833333 0.460338
+ 7.9861111 0.462447
+ 7.9888889 0.468776
+ 7.9916667 0.472996
+ 7.9944444 0.468776
+ 7.9972222 0.462447
+ 8.0000000 0.460338
+ 8.0027778 0.454008
+ 8.0055556 0.445570
+ 8.0083333 0.447679
+ 8.0111111 0.447679
+ 8.0138889 0.454008
+ 8.0166667 0.458228
+ 8.0194444 0.464557
+ 8.0222222 0.468776
+ 8.0250000 0.477215
+ 8.0277778 0.479325
+ 8.0305556 0.481435
+ 8.0333333 0.481435
+ 8.0361111 0.481435
+ 8.0388889 0.481435
+ 8.0416667 0.477215
+ 8.0444444 0.470886
+ 8.0472222 0.468776
+ 8.0500000 0.472996
+ 8.0527778 0.477215
+ 8.0555556 0.487764
+ 8.0583333 0.494093
+ 8.0611111 0.489873
+ 8.0638889 0.479325
+ 8.0666667 0.464557
+ 8.0694444 0.451899
+ 8.0722222 0.458228
+ 8.0750000 0.466667
+ 8.0777778 0.479325
+ 8.0805556 0.489873
+ 8.0833333 0.498312
+ 8.0861111 0.500422
+ 8.0888889 0.498312
+ 8.0916667 0.506751
+ 8.0944444 0.513080
+ 8.0972222 0.521519
+ 8.1000000 0.521519
+ 8.1027778 0.519409
+ 8.1055556 0.510970
+ 8.1083333 0.500422
+ 8.1111111 0.506751
+ 8.1138889 0.513080
+ 8.1166667 0.527848
+ 8.1194444 0.534177
+ 8.1222222 0.540506
+ 8.1250000 0.546835
+ 8.1277778 0.542616
+ 8.1305556 0.546835
+ 8.1333333 0.544726
+ 8.1361111 0.548945
+ 8.1388889 0.553165
+ 8.1416667 0.553165
+ 8.1444444 0.551055
+ 8.1472222 0.548945
+ 8.1500000 0.544726
+ 8.1527778 0.544726
+ 8.1555556 0.536287
+ 8.1583333 0.538397
+ 8.1611111 0.538397
+ 8.1638889 0.536287
+ 8.1666667 0.546835
+ 8.1694444 0.559494
+ 8.1722222 0.570042
+ 8.1750000 0.576371
+ 8.1777778 0.580591
+ 8.1805556 0.567932
+ 8.1833333 0.557384
+ 8.1861111 0.542616
+ 8.1888889 0.529958
+ 8.1916667 0.527848
+ 8.1944444 0.525738
+ 8.1972222 0.534177
+ 8.2000000 0.540506
+ 8.2027778 0.542616
+ 8.2055556 0.542616
+ 8.2083333 0.529958
+ 8.2111111 0.529958
+ 8.2138889 0.529958
+ 8.2166667 0.540506
+ 8.2194444 0.538397
+ 8.2222222 0.529958
+ 8.2250000 0.517300
+ 8.2277778 0.504641
+ 8.2305556 0.502532
+ 8.2333333 0.506751
+ 8.2361111 0.510970
+ 8.2388889 0.513080
+ 8.2416667 0.506751
+ 8.2444444 0.504641
+ 8.2472222 0.485654
+ 8.2500000 0.472996
+ 8.2527778 0.464557
+ 8.2555556 0.460338
+ 8.2583333 0.460338
+ 8.2611111 0.464557
+ 8.2638889 0.462447
+ 8.2666667 0.458228
+ 8.2694444 0.454008
+ 8.2722222 0.460338
+ 8.2750000 0.466667
+ 8.2777778 0.479325
+ 8.2805556 0.479325
+ 8.2833333 0.466667
+ 8.2861111 0.451899
+ 8.2888889 0.443460
+ 8.2916667 0.441350
+ 8.2944444 0.447679
+ 8.2972222 0.456118
+ 8.3000000 0.470886
+ 8.3027778 0.483544
+ 8.3055556 0.491983
+ 8.3083333 0.496203
+ 8.3111111 0.502532
+ 8.3138889 0.500422
+ 8.3166667 0.496203
+ 8.3194444 0.494093
+ 8.3222222 0.489873
+ 8.3250000 0.498312
+ 8.3277778 0.498312
+ 8.3305556 0.502532
+ 8.3333333 0.500422
+ 8.3361111 0.502532
+ 8.3388889 0.500422
+ 8.3416667 0.500422
+ 8.3444444 0.498312
+ 8.3472222 0.491983
+ 8.3500000 0.491983
+ 8.3527778 0.483544
+ 8.3555556 0.475105
+ 8.3583333 0.470886
+ 8.3611111 0.466667
+ 8.3638889 0.479325
+ 8.3666667 0.485654
+ 8.3694444 0.496203
+ 8.3722222 0.496203
+ 8.3750000 0.489873
+ 8.3777778 0.481435
+ 8.3805556 0.481435
+ 8.3833333 0.485654
+ 8.3861111 0.483544
+ 8.3888889 0.489873
+ 8.3916667 0.489873
+ 8.3944444 0.487764
+ 8.3972222 0.485654
+ 8.4000000 0.485654
+ 8.4027778 0.489873
+ 8.4055556 0.487764
+ 8.4083333 0.491983
+ 8.4111111 0.500422
+ 8.4138889 0.502532
+ 8.4166667 0.502532
+ 8.4194444 0.498312
+ 8.4222222 0.485654
+ 8.4250000 0.475105
+ 8.4277778 0.479325
+ 8.4305556 0.483544
+ 8.4333333 0.489873
+ 8.4361111 0.498312
+ 8.4388889 0.504641
+ 8.4416667 0.504641
+ 8.4444444 0.504641
+ 8.4472222 0.496203
+ 8.4500000 0.483544
+ 8.4527778 0.468776
+ 8.4555556 0.460338
+ 8.4583333 0.458228
+ 8.4611111 0.464557
+ 8.4638889 0.470886
+ 8.4666667 0.477215
+ 8.4694444 0.487764
+ 8.4722222 0.502532
+ 8.4750000 0.498312
+ 8.4777778 0.500422
+ 8.4805556 0.494093
+ 8.4833333 0.489873
+ 8.4861111 0.483544
+ 8.4888889 0.483544
+ 8.4916667 0.472996
+ 8.4944444 0.481435
+ 8.4972222 0.491983
+ 8.5000000 0.502532
+ 8.5027778 0.519409
+ 8.5055556 0.546835
+ 8.5083333 0.570042
+ 8.5111111 0.603797
+ 8.5138889 0.641772
+ 8.5166667 0.667089
+ 8.5194444 0.681857
+ 8.5222222 0.658650
+ 8.5250000 0.612236
+ 8.5277778 0.540506
+ 8.5305556 0.470886
+ 8.5333333 0.411814
+ 8.5361111 0.378059
+ 8.5388889 0.367511
+ 8.5416667 0.354852
+ 8.5444444 0.361181
+ 8.5472222 0.369620
+ 8.5500000 0.386498
+ 8.5527778 0.401266
+ 8.5555556 0.409705
+ 8.5583333 0.411814
+ 8.5611111 0.405485
+ 8.5638889 0.392827
+ 8.5666667 0.378059
+ 8.5694444 0.373840
+ 8.5722222 0.384388
+ 8.5750000 0.394937
+ 8.5777778 0.409705
+ 8.5805556 0.405485
+ 8.5833333 0.399156
+ 8.5861111 0.386498
+ 8.5888889 0.380169
+ 8.5916667 0.384388
+ 8.5944444 0.386498
+ 8.5972222 0.390717
+ 8.6000000 0.407595
+ 8.6027778 0.426582
+ 8.6055556 0.435021
+ 8.6083333 0.441350
+ 8.6111111 0.445570
+ 8.6138889 0.445570
+ 8.6166667 0.439241
+ 8.6194444 0.435021
+ 8.6222222 0.432911
+ 8.6250000 0.443460
+ 8.6277778 0.458228
+ 8.6305556 0.475105
+ 8.6333333 0.483544
+ 8.6361111 0.496203
+ 8.6388889 0.496203
+ 8.6416667 0.494093
+ 8.6444444 0.485654
+ 8.6472222 0.472996
+ 8.6500000 0.468776
+ 8.6527778 0.458228
+ 8.6555556 0.458228
+ 8.6583333 0.462447
+ 8.6611111 0.464557
+ 8.6638889 0.470886
+ 8.6666667 0.472996
+ 8.6694444 0.479325
+ 8.6722222 0.479325
+ 8.6750000 0.481435
+ 8.6777778 0.485654
+ 8.6805556 0.487764
+ 8.6833333 0.487764
+ 8.6861111 0.489873
+ 8.6888889 0.483544
+ 8.6916667 0.491983
+ 8.6944444 0.496203
+ 8.6972222 0.491983
+ 8.7000000 0.483544
+ 8.7027778 0.475105
+ 8.7055556 0.472996
+ 8.7083333 0.464557
+ 8.7111111 0.470886
+ 8.7138889 0.479325
+ 8.7166667 0.485654
+ 8.7194444 0.489873
+ 8.7222222 0.489873
+ 8.7250000 0.485654
+ 8.7277778 0.483544
+ 8.7305556 0.483544
+ 8.7333333 0.485654
+ 8.7361111 0.485654
+ 8.7388889 0.496203
+ 8.7416667 0.502532
+ 8.7444444 0.508861
+ 8.7472222 0.506751
+ 8.7500000 0.506751
+ 8.7527778 0.508861
+ 8.7555556 0.508861
+ 8.7583333 0.510970
+ 8.7611111 0.515190
+ 8.7638889 0.521519
+ 8.7666667 0.529958
+ 8.7694444 0.529958
+ 8.7722222 0.534177
+ 8.7750000 0.534177
+ 8.7777778 0.540506
+ 8.7805556 0.536287
+ 8.7833333 0.538397
+ 8.7861111 0.538397
+ 8.7888889 0.538397
+ 8.7916667 0.540506
+ 8.7944444 0.551055
+ 8.7972222 0.557384
+ 8.8000000 0.570042
+ 8.8027778 0.572152
+ 8.8055556 0.576371
+ 8.8083333 0.567932
+ 8.8111111 0.553165
+ 8.8138889 0.546835
+ 8.8166667 0.540506
+ 8.8194444 0.538397
+ 8.8222222 0.536287
+ 8.8250000 0.540506
+ 8.8277778 0.538397
+ 8.8305556 0.548945
+ 8.8333333 0.548945
+ 8.8361111 0.551055
+ 8.8388889 0.546835
+ 8.8416667 0.546835
+ 8.8444444 0.540506
+ 8.8472222 0.523629
+ 8.8500000 0.515190
+ 8.8527778 0.508861
+ 8.8555556 0.504641
+ 8.8583333 0.504641
+ 8.8611111 0.508861
+ 8.8638889 0.506751
+ 8.8666667 0.502532
+ 8.8694444 0.506751
+ 8.8722222 0.504641
+ 8.8750000 0.491983
+ 8.8777778 0.494093
+ 8.8805556 0.489873
+ 8.8833333 0.483544
+ 8.8861111 0.479325
+ 8.8888889 0.475105
+ 8.8916667 0.470886
+ 8.8944444 0.466667
+ 8.8972222 0.466667
+ 8.9000000 0.475105
+ 8.9027778 0.483544
+ 8.9055556 0.479325
+ 8.9083333 0.468776
+ 8.9111111 0.458228
+ 8.9138889 0.449789
+ 8.9166667 0.443460
+ 8.9194444 0.451899
+ 8.9222222 0.458228
+ 8.9250000 0.472996
+ 8.9277778 0.481435
+ 8.9305556 0.487764
+ 8.9333333 0.502532
+ 8.9361111 0.502532
+ 8.9388889 0.504641
+ 8.9416667 0.504641
+ 8.9444444 0.496203
+ 8.9472222 0.475105
+ 8.9500000 0.462447
+ 8.9527778 0.443460
+ 8.9555556 0.441350
+ 8.9583333 0.447679
+ 8.9611111 0.456118
+ 8.9638889 0.464557
+ 8.9666667 0.479325
+ 8.9694444 0.485654
+ 8.9722222 0.498312
+ 8.9750000 0.500422
+ 8.9777778 0.504641
+ 8.9805556 0.502532
+ 8.9833333 0.487764
+ 8.9861111 0.468776
+ 8.9888889 0.460338
+ 8.9916667 0.447679
+ 8.9944444 0.454008
+ 8.9972222 0.462447
+ 9.0000000 0.468776
+ 9.0027778 0.477215
+ 9.0055556 0.483544
+ 9.0083333 0.485654
+ 9.0111111 0.477215
+ 9.0138889 0.487764
+ 9.0166667 0.487764
+ 9.0194444 0.483544
+ 9.0222222 0.481435
+ 9.0250000 0.477215
+ 9.0277778 0.477215
+ 9.0305556 0.475105
+ 9.0333333 0.479325
+ 9.0361111 0.485654
+ 9.0388889 0.485654
+ 9.0416667 0.472996
+ 9.0444444 0.470886
+ 9.0472222 0.468776
+ 9.0500000 0.468776
+ 9.0527778 0.466667
+ 9.0555556 0.460338
+ 9.0583333 0.462447
+ 9.0611111 0.464557
+ 9.0638889 0.470886
+ 9.0666667 0.479325
+ 9.0694444 0.481435
+ 9.0722222 0.472996
+ 9.0750000 0.464557
+ 9.0777778 0.462447
+ 9.0805556 0.458228
+ 9.0833333 0.460338
+ 9.0861111 0.466667
+ 9.0888889 0.464557
+ 9.0916667 0.468776
+ 9.0944444 0.460338
+ 9.0972222 0.466667
+ 9.1000000 0.466667
+ 9.1027778 0.466667
+ 9.1055556 0.466667
+ 9.1083333 0.464557
+ 9.1111111 0.464557
+ 9.1138889 0.460338
+ 9.1166667 0.458228
+ 9.1194444 0.454008
+ 9.1222222 0.456118
+ 9.1250000 0.454008
+ 9.1277778 0.462447
+ 9.1305556 0.468776
+ 9.1333333 0.477215
+ 9.1361111 0.477215
+ 9.1388889 0.475105
+ 9.1416667 0.466667
+ 9.1444444 0.464557
+ 9.1472222 0.454008
+ 9.1500000 0.447679
+ 9.1527778 0.445570
+ 9.1555556 0.445570
+ 9.1583333 0.451899
+ 9.1611111 0.464557
+ 9.1638889 0.468776
+ 9.1666667 0.477215
+ 9.1694444 0.475105
+ 9.1722222 0.479325
+ 9.1750000 0.475105
+ 9.1777778 0.475105
+ 9.1805556 0.468776
+ 9.1833333 0.458228
+ 9.1861111 0.454008
+ 9.1888889 0.449789
+ 9.1916667 0.454008
+ 9.1944444 0.456118
+ 9.1972222 0.462447
+ 9.2000000 0.460338
+ 9.2027778 0.458228
+ 9.2055556 0.458228
+ 9.2083333 0.456118
+ 9.2111111 0.466667
+ 9.2138889 0.466667
+ 9.2166667 0.468776
+ 9.2194444 0.462447
+ 9.2222222 0.460338
+ 9.2250000 0.460338
+ 9.2277778 0.464557
+ 9.2305556 0.470886
+ 9.2333333 0.468776
+ 9.2361111 0.460338
+ 9.2388889 0.456118
+ 9.2416667 0.456118
+ 9.2444444 0.454008
+ 9.2472222 0.456118
+ 9.2500000 0.456118
+ 9.2527778 0.451899
+ 9.2555556 0.451899
+ 9.2583333 0.456118
+ 9.2611111 0.460338
+ 9.2638889 0.470886
+ 9.2666667 0.477215
+ 9.2694444 0.477215
+ 9.2722222 0.468776
+ 9.2750000 0.458228
+ 9.2777778 0.451899
+ 9.2805556 0.447679
+ 9.2833333 0.445570
+ 9.2861111 0.449789
+ 9.2888889 0.451899
+ 9.2916667 0.456118
+ 9.2944444 0.458228
+ 9.2972222 0.454008
+ 9.3000000 0.449789
+ 9.3027778 0.456118
+ 9.3055556 0.466667
+ 9.3083333 0.470886
+ 9.3111111 0.468776
+ 9.3138889 0.468776
+ 9.3166667 0.464557
+ 9.3194444 0.456118
+ 9.3222222 0.451899
+ 9.3250000 0.456118
+ 9.3277778 0.460338
+ 9.3305556 0.466667
+ 9.3333333 0.466667
+ 9.3361111 0.468776
+ 9.3388889 0.462447
+ 9.3416667 0.458228
+ 9.3444444 0.451899
+ 9.3472222 0.443460
+ 9.3500000 0.443460
+ 9.3527778 0.439241
+ 9.3555556 0.443460
+ 9.3583333 0.447679
+ 9.3611111 0.456118
+ 9.3638889 0.462447
+ 9.3666667 0.462447
+ 9.3694444 0.462447
+ 9.3722222 0.458228
+ 9.3750000 0.454008
+ 9.3777778 0.451899
+ 9.3805556 0.447679
+ 9.3833333 0.454008
+ 9.3861111 0.454008
+ 9.3888889 0.464557
+ 9.3916667 0.464557
+ 9.3944444 0.458228
+ 9.3972222 0.451899
+ 9.4000000 0.447679
+ 9.4027778 0.443460
+ 9.4055556 0.445570
+ 9.4083333 0.447679
+ 9.4111111 0.454008
+ 9.4138889 0.456118
+ 9.4166667 0.462447
+ 9.4194444 0.468776
+ 9.4222222 0.472996
+ 9.4250000 0.468776
+ 9.4277778 0.462447
+ 9.4305556 0.462447
+ 9.4333333 0.454008
+ 9.4361111 0.441350
+ 9.4388889 0.435021
+ 9.4416667 0.437131
+ 9.4444444 0.439241
+ 9.4472222 0.451899
+ 9.4500000 0.458228
+ 9.4527778 0.456118
+ 9.4555556 0.449789
+ 9.4583333 0.449789
+ 9.4611111 0.454008
+ 9.4638889 0.454008
+ 9.4666667 0.460338
+ 9.4694444 0.475105
+ 9.4722222 0.477215
+ 9.4750000 0.470886
+ 9.4777778 0.458228
+ 9.4805556 0.445570
+ 9.4833333 0.443460
+ 9.4861111 0.443460
+ 9.4888889 0.458228
+ 9.4916667 0.470886
+ 9.4944444 0.472996
+ 9.4972222 0.472996
+ 9.5000000 0.454008
+ 9.5027778 0.439241
+ 9.5055556 0.428692
+ 9.5083333 0.428692
+ 9.5111111 0.437131
+ 9.5138889 0.451899
+ 9.5166667 0.460338
+ 9.5194444 0.466667
+ 9.5222222 0.468776
+ 9.5250000 0.468776
+ 9.5277778 0.460338
+ 9.5305556 0.454008
+ 9.5333333 0.447679
+ 9.5361111 0.454008
+ 9.5388889 0.460338
+ 9.5416667 0.460338
+ 9.5444444 0.468776
+ 9.5472222 0.466667
+ 9.5500000 0.460338
+ 9.5527778 0.460338
+ 9.5555556 0.449789
+ 9.5583333 0.443460
+ 9.5611111 0.443460
+ 9.5638889 0.443460
+ 9.5666667 0.456118
+ 9.5694444 0.464557
+ 9.5722222 0.466667
+ 9.5750000 0.470886
+ 9.5777778 0.472996
+ 9.5805556 0.466667
+ 9.5833333 0.464557
+ 9.5861111 0.464557
+ 9.5888889 0.460338
+ 9.5916667 0.451899
+ 9.5944444 0.445570
+ 9.5972222 0.447679
+ 9.6000000 0.449789
+ 9.6027778 0.449789
+ 9.6055556 0.454008
+ 9.6083333 0.449789
+ 9.6111111 0.451899
+ 9.6138889 0.456118
+ 9.6166667 0.458228
+ 9.6194444 0.458228
+ 9.6222222 0.458228
+ 9.6250000 0.458228
+ 9.6277778 0.449789
+ 9.6305556 0.451899
+ 9.6333333 0.454008
+ 9.6361111 0.458228
+ 9.6388889 0.464557
+ 9.6416667 0.466667
+ 9.6444444 0.470886
+ 9.6472222 0.466667
+ 9.6500000 0.460338
+ 9.6527778 0.445570
+ 9.6555556 0.441350
+ 9.6583333 0.443460
+ 9.6611111 0.443460
+ 9.6638889 0.443460
+ 9.6666667 0.432911
+ 9.6694444 0.443460
+ 9.6722222 0.449789
+ 9.6750000 0.454008
+ 9.6777778 0.458228
+ 9.6805556 0.460338
+ 9.6833333 0.451899
+ 9.6861111 0.456118
+ 9.6888889 0.449789
+ 9.6916667 0.445570
+ 9.6944444 0.443460
+ 9.6972222 0.439241
+ 9.7000000 0.441350
+ 9.7027778 0.443460
+ 9.7055556 0.454008
+ 9.7083333 0.449789
+ 9.7111111 0.451899
+ 9.7138889 0.451899
+ 9.7166667 0.441350
+ 9.7194444 0.447679
+ 9.7222222 0.441350
+ 9.7250000 0.439241
+ 9.7277778 0.445570
+ 9.7305556 0.445570
+ 9.7333333 0.449789
+ 9.7361111 0.451899
+ 9.7388889 0.460338
+ 9.7416667 0.466667
+ 9.7444444 0.468776
+ 9.7472222 0.464557
+ 9.7500000 0.449789
+ 9.7527778 0.437131
+ 9.7555556 0.428692
+ 9.7583333 0.430802
+ 9.7611111 0.439241
+ 9.7638889 0.443460
+ 9.7666667 0.447679
+ 9.7694444 0.449789
+ 9.7722222 0.456118
+ 9.7750000 0.458228
+ 9.7777778 0.462447
+ 9.7805556 0.454008
+ 9.7833333 0.447679
+ 9.7861111 0.447679
+ 9.7888889 0.439241
+ 9.7916667 0.439241
+ 9.7944444 0.441350
+ 9.7972222 0.441350
+ 9.8000000 0.449789
+ 9.8027778 0.456118
+ 9.8055556 0.458228
+ 9.8083333 0.462447
+ 9.8111111 0.460338
+ 9.8138889 0.458228
+ 9.8166667 0.456118
+ 9.8194444 0.447679
+ 9.8222222 0.445570
+ 9.8250000 0.439241
+ 9.8277778 0.441350
+ 9.8305556 0.439241
+ 9.8333333 0.441350
+ 9.8361111 0.443460
+ 9.8388889 0.445570
+ 9.8416667 0.451899
+ 9.8444444 0.451899
+ 9.8472222 0.451899
+ 9.8500000 0.449789
+ 9.8527778 0.445570
+ 9.8555556 0.439241
+ 9.8583333 0.439241
+ 9.8611111 0.437131
+ 9.8638889 0.439241
+ 9.8666667 0.443460
+ 9.8694444 0.449789
+ 9.8722222 0.456118
+ 9.8750000 0.464557
+ 9.8777778 0.470886
+ 9.8805556 0.477215
+ 9.8833333 0.472996
+ 9.8861111 0.466667
+ 9.8888889 0.451899
+ 9.8916667 0.437131
+ 9.8944444 0.432911
+ 9.8972222 0.430802
+ 9.9000000 0.435021
+ 9.9027778 0.445570
+ 9.9055556 0.451899
+ 9.9083333 0.447679
+ 9.9111111 0.449789
+ 9.9138889 0.437131
+ 9.9166667 0.430802
+ 9.9194444 0.426582
+ 9.9222222 0.430802
+ 9.9250000 0.445570
+ 9.9277778 0.454008
+ 9.9305556 0.466667
+ 9.9333333 0.472996
+ 9.9361111 0.477215
+ 9.9388889 0.466667
+ 9.9416667 0.456118
+ 9.9444444 0.447679
+ 9.9472222 0.439241
+ 9.9500000 0.441350
+ 9.9527778 0.454008
+ 9.9555556 0.460338
+ 9.9583333 0.470886
+ 9.9611111 0.477215
+ 9.9638889 0.468776
+ 9.9666667 0.466667
+ 9.9694444 0.462447
+ 9.9722222 0.470886
+ 9.9750000 0.479325
+ 9.9777778 0.496203
+ 9.9805556 0.498312
+ 9.9833333 0.500422
+ 9.9861111 0.491983
+ 9.9888889 0.479325
+ 9.9916667 0.466667
+ 9.9944444 0.449789
+ 9.9972222 0.449789
+ 10.0000000 0.449789
+ 10.0027778 0.458228
+ 10.0055556 0.470886
+ 10.0083333 0.479325
+ 10.0111111 0.481435
+ 10.0138889 0.483544
+ 10.0166667 0.487764
+ 10.0194444 0.485654
+ 10.0222222 0.481435
+ 10.0250000 0.468776
+ 10.0277778 0.462447
+ 10.0305556 0.462447
+ 10.0333333 0.466667
+ 10.0361111 0.468776
+ 10.0388889 0.470886
+ 10.0416667 0.464557
+ 10.0444444 0.460338
+ 10.0472222 0.458228
+ 10.0500000 0.458228
+ 10.0527778 0.460338
+ 10.0555556 0.456118
+ 10.0583333 0.451899
+ 10.0611111 0.445570
+ 10.0638889 0.437131
+ 10.0666667 0.439241
+ 10.0694444 0.441350
+ 10.0722222 0.445570
+ 10.0750000 0.441350
+ 10.0777778 0.449789
+ 10.0805556 0.445570
+ 10.0833333 0.447679
+ 10.0861111 0.437131
+ 10.0888889 0.426582
+ 10.0916667 0.426582
+ 10.0944444 0.424473
+ 10.0972222 0.432911
+ 10.1000000 0.443460
+ 10.1027778 0.454008
+ 10.1055556 0.462447
+ 10.1083333 0.460338
+ 10.1111111 0.458228
+ 10.1138889 0.443460
+ 10.1166667 0.441350
+ 10.1194444 0.435021
+ 10.1222222 0.432911
+ 10.1250000 0.435021
+ 10.1277778 0.445570
+ 10.1305556 0.456118
+ 10.1333333 0.458228
+ 10.1361111 0.464557
+ 10.1388889 0.464557
+ 10.1416667 0.454008
+ 10.1444444 0.449789
+ 10.1472222 0.439241
+ 10.1500000 0.437131
+ 10.1527778 0.437131
+ 10.1555556 0.449789
+ 10.1583333 0.449789
+ 10.1611111 0.456118
+ 10.1638889 0.462447
+ 10.1666667 0.466667
+ 10.1694444 0.481435
+ 10.1722222 0.496203
+ 10.1750000 0.510970
+ 10.1777778 0.542616
+ 10.1805556 0.567932
+ 10.1833333 0.597468
+ 10.1861111 0.616456
+ 10.1888889 0.627004
+ 10.1916667 0.620675
+ 10.1944444 0.593249
+ 10.1972222 0.553165
+ 10.2000000 0.496203
+ 10.2027778 0.435021
+ 10.2055556 0.375949
+ 10.2083333 0.342194
+ 10.2111111 0.327426
+ 10.2138889 0.325316
+ 10.2166667 0.325316
+ 10.2194444 0.329536
+ 10.2222222 0.323207
+ 10.2250000 0.329536
+ 10.2277778 0.335865
+ 10.2305556 0.348523
+ 10.2333333 0.348523
+ 10.2361111 0.356962
+ 10.2388889 0.354852
+ 10.2416667 0.344304
+ 10.2444444 0.346414
+ 10.2472222 0.356962
+ 10.2500000 0.371730
+ 10.2527778 0.386498
+ 10.2555556 0.384388
+ 10.2583333 0.388608
+ 10.2611111 0.386498
+ 10.2638889 0.380169
+ 10.2666667 0.365401
+ 10.2694444 0.367511
+ 10.2722222 0.367511
+ 10.2750000 0.375949
+ 10.2777778 0.386498
+ 10.2805556 0.397046
+ 10.2833333 0.399156
+ 10.2861111 0.409705
+ 10.2888889 0.420253
+ 10.2916667 0.432911
+ 10.2944444 0.441350
+ 10.2972222 0.447679
+ 10.3000000 0.447679
+ 10.3027778 0.449789
+ 10.3055556 0.454008
+ 10.3083333 0.460338
+ 10.3111111 0.464557
+ 10.3138889 0.472996
+ 10.3166667 0.472996
+ 10.3194444 0.470886
+ 10.3222222 0.468776
+ 10.3250000 0.466667
+ 10.3277778 0.458228
+ 10.3305556 0.449789
+ 10.3333333 0.443460
+ 10.3361111 0.441350
+ 10.3388889 0.447679
+ 10.3416667 0.449789
+ 10.3444444 0.451899
+ 10.3472222 0.445570
+ 10.3500000 0.443460
+ 10.3527778 0.441350
+ 10.3555556 0.439241
+ 10.3583333 0.447679
+ 10.3611111 0.447679
+ 10.3638889 0.454008
+ 10.3666667 0.460338
+ 10.3694444 0.466667
+ 10.3722222 0.466667
+ 10.3750000 0.475105
+ 10.3777778 0.481435
+ 10.3805556 0.479325
+ 10.3833333 0.477215
+ 10.3861111 0.472996
+ 10.3888889 0.468776
+ 10.3916667 0.464557
+ 10.3944444 0.456118
+ 10.3972222 0.447679
+ 10.4000000 0.451899
+ 10.4027778 0.460338
+ 10.4055556 0.468776
+ 10.4083333 0.475105
+ 10.4111111 0.483544
+ 10.4138889 0.481435
+ 10.4166667 0.481435
+ 10.4194444 0.485654
+ 10.4222222 0.489873
+ 10.4250000 0.502532
+ 10.4277778 0.515190
+ 10.4305556 0.517300
+ 10.4333333 0.504641
+ 10.4361111 0.496203
+ 10.4388889 0.481435
+ 10.4416667 0.477215
+ 10.4444444 0.487764
+ 10.4472222 0.496203
+ 10.4500000 0.508861
+ 10.4527778 0.513080
+ 10.4555556 0.502532
+ 10.4583333 0.491983
+ 10.4611111 0.487764
+ 10.4638889 0.496203
+ 10.4666667 0.506751
+ 10.4694444 0.515190
+ 10.4722222 0.523629
+ 10.4750000 0.532068
+ 10.4777778 0.534177
+ 10.4805556 0.546835
+ 10.4833333 0.551055
+ 10.4861111 0.553165
+ 10.4888889 0.548945
+ 10.4916667 0.546835
+ 10.4944444 0.538397
+ 10.4972222 0.529958
+ 10.5000000 0.525738
+ 10.5027778 0.540506
+ 10.5055556 0.546835
+ 10.5083333 0.555274
+ 10.5111111 0.565823
+ 10.5138889 0.567932
+ 10.5166667 0.561603
+ 10.5194444 0.536287
+ 10.5222222 0.513080
+ 10.5250000 0.496203
+ 10.5277778 0.496203
+ 10.5305556 0.506751
+ 10.5333333 0.521519
+ 10.5361111 0.532068
+ 10.5388889 0.540506
+ 10.5416667 0.538397
+ 10.5444444 0.534177
+ 10.5472222 0.517300
+ 10.5500000 0.498312
+ 10.5527778 0.487764
+ 10.5555556 0.481435
+ 10.5583333 0.477215
+ 10.5611111 0.477215
+ 10.5638889 0.479325
+ 10.5666667 0.477215
+ 10.5694444 0.472996
+ 10.5722222 0.481435
+ 10.5750000 0.477215
+ 10.5777778 0.477215
+ 10.5805556 0.475105
+ 10.5833333 0.470886
+ 10.5861111 0.460338
+ 10.5888889 0.456118
+ 10.5916667 0.449789
+ 10.5944444 0.447679
+ 10.5972222 0.449789
+ 10.6000000 0.445570
+ 10.6027778 0.447679
+ 10.6055556 0.445570
+ 10.6083333 0.441350
+ 10.6111111 0.430802
+ 10.6138889 0.428692
+ 10.6166667 0.420253
+ 10.6194444 0.424473
+ 10.6222222 0.426582
+ 10.6250000 0.426582
+ 10.6277778 0.426582
+ 10.6305556 0.428692
+ 10.6333333 0.432911
+ 10.6361111 0.437131
+ 10.6388889 0.441350
+ 10.6416667 0.441350
+ 10.6444444 0.439241
+ 10.6472222 0.439241
+ 10.6500000 0.443460
+ 10.6527778 0.445570
+ 10.6555556 0.447679
+ 10.6583333 0.454008
+ 10.6611111 0.460338
+ 10.6638889 0.462447
+ 10.6666667 0.460338
+ 10.6694444 0.460338
+ 10.6722222 0.462447
+ 10.6750000 0.456118
+ 10.6777778 0.464557
+ 10.6805556 0.458228
+ 10.6833333 0.454008
+ 10.6861111 0.449789
+ 10.6888889 0.439241
+ 10.6916667 0.443460
+ 10.6944444 0.449789
+ 10.6972222 0.458228
+ 10.7000000 0.464557
+ 10.7027778 0.464557
+ 10.7055556 0.470886
+ 10.7083333 0.472996
+ 10.7111111 0.472996
+ 10.7138889 0.462447
+ 10.7166667 0.447679
+ 10.7194444 0.443460
+ 10.7222222 0.443460
+ 10.7250000 0.447679
+ 10.7277778 0.451899
+ 10.7305556 0.458228
+ 10.7333333 0.468776
+ 10.7361111 0.472996
+ 10.7388889 0.481435
+ 10.7416667 0.479325
+ 10.7444444 0.470886
+ 10.7472222 0.466667
+ 10.7500000 0.458228
+ 10.7527778 0.449789
+ 10.7555556 0.439241
+ 10.7583333 0.432911
+ 10.7611111 0.435021
+ 10.7638889 0.447679
+ 10.7666667 0.454008
+ 10.7694444 0.466667
+ 10.7722222 0.472996
+ 10.7750000 0.479325
+ 10.7777778 0.479325
+ 10.7805556 0.479325
+ 10.7833333 0.464557
+ 10.7861111 0.447679
+ 10.7888889 0.437131
+ 10.7916667 0.432911
+ 10.7944444 0.439241
+ 10.7972222 0.449789
+ 10.8000000 0.449789
+ 10.8027778 0.451899
+ 10.8055556 0.445570
+ 10.8083333 0.443460
+ 10.8111111 0.441350
+ 10.8138889 0.437131
+ 10.8166667 0.439241
+ 10.8194444 0.443460
+ 10.8222222 0.447679
+ 10.8250000 0.451899
+ 10.8277778 0.464557
+ 10.8305556 0.468776
+ 10.8333333 0.472996
+ 10.8361111 0.470886
+ 10.8388889 0.468776
+ 10.8416667 0.470886
+ 10.8444444 0.468776
+ 10.8472222 0.489873
+ 10.8500000 0.519409
+ 10.8527778 0.557384
+ 10.8555556 0.601688
+ 10.8583333 0.645992
+ 10.8611111 0.671308
+ 10.8638889 0.677637
+ 10.8666667 0.639662
+ 10.8694444 0.570042
+ 10.8722222 0.487764
+ 10.8750000 0.401266
+ 10.8777778 0.346414
+ 10.8805556 0.316878
+ 10.8833333 0.310549
+ 10.8861111 0.325316
+ 10.8888889 0.335865
+ 10.8916667 0.352743
+ 10.8944444 0.378059
+ 10.8972222 0.384388
+ 10.9000000 0.384388
+ 10.9027778 0.367511
+ 10.9055556 0.350633
+ 10.9083333 0.331646
+ 10.9111111 0.335865
+ 10.9138889 0.346414
+ 10.9166667 0.365401
+ 10.9194444 0.384388
+ 10.9222222 0.388608
+ 10.9250000 0.390717
+ 10.9277778 0.380169
+ 10.9305556 0.369620
+ 10.9333333 0.367511
+ 10.9361111 0.365401
+ 10.9388889 0.380169
+ 10.9416667 0.386498
+ 10.9444444 0.388608
+ 10.9472222 0.397046
+ 10.9500000 0.399156
+ 10.9527778 0.397046
+ 10.9555556 0.403376
+ 10.9583333 0.407595
+ 10.9611111 0.409705
+ 10.9638889 0.418143
+ 10.9666667 0.424473
+ 10.9694444 0.445570
+ 10.9722222 0.456118
+ 10.9750000 0.468776
+ 10.9777778 0.477215
+ 10.9805556 0.483544
+ 10.9833333 0.489873
+ 10.9861111 0.479325
+ 10.9888889 0.458228
+ 10.9916667 0.441350
+ 10.9944444 0.418143
+ 10.9972222 0.401266
+ 11.0000000 0.401266
+ 11.0027778 0.411814
+ 11.0055556 0.428692
+ 11.0083333 0.435021
+ 11.0111111 0.445570
+ 11.0138889 0.449789
+ 11.0166667 0.447679
+ 11.0194444 0.454008
+ 11.0222222 0.468776
+ 11.0250000 0.485654
+ 11.0277778 0.498312
+ 11.0305556 0.504641
+ 11.0333333 0.491983
+ 11.0361111 0.462447
+ 11.0388889 0.437131
+ 11.0416667 0.416034
+ 11.0444444 0.411814
+ 11.0472222 0.420253
+ 11.0500000 0.426582
+ 11.0527778 0.443460
+ 11.0555556 0.443460
+ 11.0583333 0.458228
+ 11.0611111 0.458228
+ 11.0638889 0.462447
+ 11.0666667 0.464557
+ 11.0694444 0.472996
+ 11.0722222 0.479325
+ 11.0750000 0.477215
+ 11.0777778 0.481435
+ 11.0805556 0.481435
+ 11.0833333 0.487764
+ 11.0861111 0.491983
+ 11.0888889 0.506751
+ 11.0916667 0.517300
+ 11.0944444 0.513080
+ 11.0972222 0.491983
+ 11.1000000 0.470886
+ 11.1027778 0.458228
+ 11.1055556 0.454008
+ 11.1083333 0.464557
+ 11.1111111 0.483544
+ 11.1138889 0.498312
+ 11.1166667 0.508861
+ 11.1194444 0.513080
+ 11.1222222 0.515190
+ 11.1250000 0.513080
+ 11.1277778 0.517300
+ 11.1305556 0.527848
+ 11.1333333 0.536287
+ 11.1361111 0.542616
+ 11.1388889 0.551055
+ 11.1416667 0.553165
+ 11.1444444 0.546835
+ 11.1472222 0.557384
+ 11.1500000 0.553165
+ 11.1527778 0.542616
+ 11.1555556 0.529958
+ 11.1583333 0.519409
+ 11.1611111 0.508861
+ 11.1638889 0.502532
+ 11.1666667 0.504641
+ 11.1694444 0.510970
+ 11.1722222 0.517300
+ 11.1750000 0.521519
+ 11.1777778 0.527848
+ 11.1805556 0.525738
+ 11.1833333 0.515190
+ 11.1861111 0.508861
+ 11.1888889 0.506751
+ 11.1916667 0.510970
+ 11.1944444 0.510970
+ 11.1972222 0.506751
+ 11.2000000 0.487764
+ 11.2027778 0.483544
+ 11.2055556 0.468776
+ 11.2083333 0.460338
+ 11.2111111 0.460338
+ 11.2138889 0.451899
+ 11.2166667 0.449789
+ 11.2194444 0.439241
+ 11.2222222 0.432911
+ 11.2250000 0.432911
+ 11.2277778 0.439241
+ 11.2305556 0.447679
+ 11.2333333 0.458228
+ 11.2361111 0.462447
+ 11.2388889 0.468776
+ 11.2416667 0.464557
+ 11.2444444 0.464557
+ 11.2472222 0.456118
+ 11.2500000 0.441350
+ 11.2527778 0.432911
+ 11.2555556 0.422363
+ 11.2583333 0.411814
+ 11.2611111 0.411814
+ 11.2638889 0.409705
+ 11.2666667 0.413924
+ 11.2694444 0.430802
+ 11.2722222 0.441350
+ 11.2750000 0.443460
+ 11.2777778 0.447679
+ 11.2805556 0.443460
+ 11.2833333 0.445570
+ 11.2861111 0.437131
+ 11.2888889 0.432911
+ 11.2916667 0.437131
+ 11.2944444 0.439241
+ 11.2972222 0.451899
+ 11.3000000 0.454008
+ 11.3027778 0.458228
+ 11.3055556 0.458228
+ 11.3083333 0.458228
+ 11.3111111 0.451899
+ 11.3138889 0.443460
+ 11.3166667 0.439241
+ 11.3194444 0.432911
+ 11.3222222 0.430802
+ 11.3250000 0.432911
+ 11.3277778 0.437131
+ 11.3305556 0.447679
+ 11.3333333 0.454008
+ 11.3361111 0.460338
+ 11.3388889 0.462447
+ 11.3416667 0.458228
+ 11.3444444 0.449789
+ 11.3472222 0.443460
+ 11.3500000 0.435021
+ 11.3527778 0.426582
+ 11.3555556 0.420253
+ 11.3583333 0.428692
+ 11.3611111 0.426582
+ 11.3638889 0.430802
+ 11.3666667 0.435021
+ 11.3694444 0.441350
+ 11.3722222 0.449789
+ 11.3750000 0.449789
+ 11.3777778 0.456118
+ 11.3805556 0.456118
+ 11.3833333 0.451899
+ 11.3861111 0.449789
+ 11.3888889 0.449789
+ 11.3916667 0.451899
+ 11.3944444 0.449789
+ 11.3972222 0.454008
+ 11.4000000 0.449789
+ 11.4027778 0.441350
+ 11.4055556 0.437131
+ 11.4083333 0.428692
+ 11.4111111 0.432911
+ 11.4138889 0.439241
+ 11.4166667 0.447679
+ 11.4194444 0.456118
+ 11.4222222 0.451899
+ 11.4250000 0.449789
+ 11.4277778 0.443460
+ 11.4305556 0.435021
+ 11.4333333 0.430802
+ 11.4361111 0.430802
+ 11.4388889 0.428692
+ 11.4416667 0.428692
+ 11.4444444 0.430802
+ 11.4472222 0.432911
+ 11.4500000 0.432911
+ 11.4527778 0.435021
+ 11.4555556 0.437131
+ 11.4583333 0.443460
+ 11.4611111 0.449789
+ 11.4638889 0.456118
+ 11.4666667 0.454008
+ 11.4694444 0.441350
+ 11.4722222 0.430802
+ 11.4750000 0.413924
+ 11.4777778 0.413924
+ 11.4805556 0.411814
+ 11.4833333 0.411814
+ 11.4861111 0.420253
+ 11.4888889 0.420253
+ 11.4916667 0.430802
+ 11.4944444 0.441350
+ 11.4972222 0.443460
+ 11.5000000 0.451899
+ 11.5027778 0.466667
+ 11.5055556 0.491983
+ 11.5083333 0.502532
+ 11.5111111 0.494093
+ 11.5138889 0.462447
+ 11.5166667 0.413924
+ 11.5194444 0.375949
+ 11.5222222 0.352743
+ 11.5250000 0.359072
+ 11.5277778 0.375949
+ 11.5305556 0.407595
+ 11.5333333 0.430802
+ 11.5361111 0.447679
+ 11.5388889 0.456118
+ 11.5416667 0.454008
+ 11.5444444 0.447679
+ 11.5472222 0.435021
+ 11.5500000 0.430802
+ 11.5527778 0.428692
+ 11.5555556 0.424473
+ 11.5583333 0.426582
+ 11.5611111 0.432911
+ 11.5638889 0.437131
+ 11.5666667 0.447679
+ 11.5694444 0.451899
+ 11.5722222 0.466667
+ 11.5750000 0.468776
+ 11.5777778 0.475105
+ 11.5805556 0.462447
+ 11.5833333 0.447679
+ 11.5861111 0.426582
+ 11.5888889 0.418143
+ 11.5916667 0.403376
+ 11.5944444 0.394937
+ 11.5972222 0.397046
+ 11.6000000 0.401266
+ 11.6027778 0.420253
+ 11.6055556 0.432911
+ 11.6083333 0.443460
+ 11.6111111 0.447679
+ 11.6138889 0.447679
+ 11.6166667 0.447679
+ 11.6194444 0.435021
+ 11.6222222 0.428692
+ 11.6250000 0.424473
+ 11.6277778 0.420253
+ 11.6305556 0.420253
+ 11.6333333 0.424473
+ 11.6361111 0.428692
+ 11.6388889 0.430802
+ 11.6416667 0.435021
+ 11.6444444 0.435021
+ 11.6472222 0.435021
+ 11.6500000 0.432911
+ 11.6527778 0.432911
+ 11.6555556 0.428692
+ 11.6583333 0.430802
+ 11.6611111 0.439241
+ 11.6638889 0.441350
+ 11.6666667 0.449789
+ 11.6694444 0.464557
+ 11.6722222 0.468776
+ 11.6750000 0.454008
+ 11.6777778 0.443460
+ 11.6805556 0.428692
+ 11.6833333 0.418143
+ 11.6861111 0.409705
+ 11.6888889 0.403376
+ 11.6916667 0.405485
+ 11.6944444 0.409705
+ 11.6972222 0.413924
+ 11.7000000 0.424473
+ 11.7027778 0.441350
+ 11.7055556 0.460338
+ 11.7083333 0.468776
+ 11.7111111 0.464557
+ 11.7138889 0.456118
+ 11.7166667 0.443460
+ 11.7194444 0.430802
+ 11.7222222 0.418143
+ 11.7250000 0.409705
+ 11.7277778 0.405485
+ 11.7305556 0.409705
+ 11.7333333 0.407595
+ 11.7361111 0.413924
+ 11.7388889 0.422363
+ 11.7416667 0.430802
+ 11.7444444 0.435021
+ 11.7472222 0.439241
+ 11.7500000 0.443460
+ 11.7527778 0.445570
+ 11.7555556 0.447679
+ 11.7583333 0.443460
+ 11.7611111 0.443460
+ 11.7638889 0.441350
+ 11.7666667 0.441350
+ 11.7694444 0.437131
+ 11.7722222 0.437131
+ 11.7750000 0.435021
+ 11.7777778 0.437131
+ 11.7805556 0.439241
+ 11.7833333 0.439241
+ 11.7861111 0.443460
+ 11.7888889 0.445570
+ 11.7916667 0.454008
+ 11.7944444 0.460338
+ 11.7972222 0.460338
+ 11.8000000 0.454008
+ 11.8027778 0.447679
+ 11.8055556 0.432911
+ 11.8083333 0.422363
+ 11.8111111 0.426582
+ 11.8138889 0.432911
+ 11.8166667 0.430802
+ 11.8194444 0.439241
+ 11.8222222 0.441350
+ 11.8250000 0.441350
+ 11.8277778 0.447679
+ 11.8305556 0.451899
+ 11.8333333 0.449789
+ 11.8361111 0.441350
+ 11.8388889 0.437131
+ 11.8416667 0.426582
+ 11.8444444 0.430802
+ 11.8472222 0.437131
+ 11.8500000 0.443460
+ 11.8527778 0.441350
+ 11.8555556 0.435021
+ 11.8583333 0.443460
+ 11.8611111 0.443460
+ 11.8638889 0.443460
+ 11.8666667 0.449789
+ 11.8694444 0.458228
+ 11.8722222 0.449789
+ 11.8750000 0.445570
+ 11.8777778 0.435021
+ 11.8805556 0.430802
+ 11.8833333 0.420253
+ 11.8861111 0.420253
+ 11.8888889 0.432911
+ 11.8916667 0.439241
+ 11.8944444 0.445570
+ 11.8972222 0.449789
+ 11.9000000 0.460338
+ 11.9027778 0.466667
+ 11.9055556 0.464557
+ 11.9083333 0.464557
+ 11.9111111 0.447679
+ 11.9138889 0.432911
+ 11.9166667 0.418143
+ 11.9194444 0.413924
+ 11.9222222 0.424473
+ 11.9250000 0.439241
+ 11.9277778 0.449789
+ 11.9305556 0.456118
+ 11.9333333 0.456118
+ 11.9361111 0.445570
+ 11.9388889 0.441350
+ 11.9416667 0.432911
+ 11.9444444 0.428692
+ 11.9472222 0.430802
+ 11.9500000 0.439241
+ 11.9527778 0.439241
+ 11.9555556 0.443460
+ 11.9583333 0.439241
+ 11.9611111 0.443460
+ 11.9638889 0.441350
+ 11.9666667 0.437131
+ 11.9694444 0.439241
+ 11.9722222 0.437131
+ 11.9750000 0.441350
+ 11.9777778 0.441350
+ 11.9805556 0.445570
+ 11.9833333 0.445570
+ 11.9861111 0.443460
+ 11.9888889 0.441350
+ 11.9916667 0.443460
+ 11.9944444 0.454008
+ 11.9972222 0.464557
+ 12.0000000 0.468776
+ 12.0027778 0.470886
+ 12.0055556 0.475105
+ 12.0083333 0.460338
+ 12.0111111 0.441350
+ 12.0138889 0.426582
+ 12.0166667 0.418143
+ 12.0194444 0.420253
+ 12.0222222 0.418143
+ 12.0250000 0.422363
+ 12.0277778 0.435021
+ 12.0305556 0.441350
+ 12.0333333 0.451899
+ 12.0361111 0.458228
+ 12.0388889 0.454008
+ 12.0416667 0.460338
+ 12.0444444 0.462447
+ 12.0472222 0.462447
+ 12.0500000 0.462447
+ 12.0527778 0.464557
+ 12.0555556 0.458228
+ 12.0583333 0.458228
+ 12.0611111 0.454008
+ 12.0638889 0.445570
+ 12.0666667 0.439241
+ 12.0694444 0.435021
+ 12.0722222 0.441350
+ 12.0750000 0.443460
+ 12.0777778 0.451899
+ 12.0805556 0.458228
+ 12.0833333 0.460338
+ 12.0861111 0.458228
+ 12.0888889 0.462447
+ 12.0916667 0.464557
+ 12.0944444 0.466667
+ 12.0972222 0.466667
+ 12.1000000 0.460338
+ 12.1027778 0.458228
+ 12.1055556 0.458228
+ 12.1083333 0.458228
+ 12.1111111 0.458228
+ 12.1138889 0.456118
+ 12.1166667 0.451899
+ 12.1194444 0.451899
+ 12.1222222 0.443460
+ 12.1250000 0.441350
+ 12.1277778 0.443460
+ 12.1305556 0.447679
+ 12.1333333 0.445570
+ 12.1361111 0.456118
+ 12.1388889 0.456118
+ 12.1416667 0.454008
+ 12.1444444 0.454008
+ 12.1472222 0.447679
+ 12.1500000 0.443460
+ 12.1527778 0.443460
+ 12.1555556 0.441350
+ 12.1583333 0.437131
+ 12.1611111 0.447679
+ 12.1638889 0.449789
+ 12.1666667 0.451899
+ 12.1694444 0.454008
+ 12.1722222 0.460338
+ 12.1750000 0.458228
+ 12.1777778 0.458228
+ 12.1805556 0.464557
+ 12.1833333 0.456118
+ 12.1861111 0.451899
+ 12.1888889 0.445570
+ 12.1916667 0.443460
+ 12.1944444 0.443460
+ 12.1972222 0.443460
+ 12.2000000 0.451899
+ 12.2027778 0.462447
+ 12.2055556 0.466667
+ 12.2083333 0.462447
+ 12.2111111 0.460338
+ 12.2138889 0.449789
+ 12.2166667 0.447679
+ 12.2194444 0.449789
+ 12.2222222 0.449789
+ 12.2250000 0.454008
+ 12.2277778 0.454008
+ 12.2305556 0.454008
+ 12.2333333 0.456118
+ 12.2361111 0.456118
+ 12.2388889 0.466667
+ 12.2416667 0.462447
+ 12.2444444 0.460338
+ 12.2472222 0.456118
+ 12.2500000 0.443460
+ 12.2527778 0.435021
+ 12.2555556 0.430802
+ 12.2583333 0.432911
+ 12.2611111 0.441350
+ 12.2638889 0.451899
+ 12.2666667 0.460338
+ 12.2694444 0.468776
+ 12.2722222 0.472996
+ 12.2750000 0.475105
+ 12.2777778 0.479325
+ 12.2805556 0.472996
+ 12.2833333 0.470886
+ 12.2861111 0.464557
+ 12.2888889 0.458228
+ 12.2916667 0.451899
+ 12.2944444 0.451899
+ 12.2972222 0.451899
+ 12.3000000 0.454008
+ 12.3027778 0.462447
+ 12.3055556 0.470886
+ 12.3083333 0.481435
+ 12.3111111 0.483544
+ 12.3138889 0.487764
+ 12.3166667 0.489873
+ 12.3194444 0.491983
+ 12.3222222 0.487764
+ 12.3250000 0.491983
+ 12.3277778 0.487764
+ 12.3305556 0.483544
+ 12.3333333 0.477215
+ 12.3361111 0.477215
+ 12.3388889 0.483544
+ 12.3416667 0.489873
+ 12.3444444 0.491983
+ 12.3472222 0.498312
+ 12.3500000 0.502532
+ 12.3527778 0.506751
+ 12.3555556 0.498312
+ 12.3583333 0.483544
+ 12.3611111 0.470886
+ 12.3638889 0.458228
+ 12.3666667 0.451899
+ 12.3694444 0.445570
+ 12.3722222 0.451899
+ 12.3750000 0.458228
+ 12.3777778 0.472996
+ 12.3805556 0.481435
+ 12.3833333 0.487764
+ 12.3861111 0.485654
+ 12.3888889 0.479325
+ 12.3916667 0.472996
+ 12.3944444 0.468776
+ 12.3972222 0.454008
+ 12.4000000 0.451899
+ 12.4027778 0.449789
+ 12.4055556 0.454008
+ 12.4083333 0.458228
+ 12.4111111 0.451899
+ 12.4138889 0.462447
+ 12.4166667 0.464557
+ 12.4194444 0.466667
+ 12.4222222 0.470886
+ 12.4250000 0.462447
+ 12.4277778 0.451899
+ 12.4305556 0.441350
+ 12.4333333 0.437131
+ 12.4361111 0.439241
+ 12.4388889 0.445570
+ 12.4416667 0.449789
+ 12.4444444 0.451899
+ 12.4472222 0.456118
+ 12.4500000 0.451899
+ 12.4527778 0.451899
+ 12.4555556 0.445570
+ 12.4583333 0.441350
+ 12.4611111 0.437131
+ 12.4638889 0.447679
+ 12.4666667 0.456118
+ 12.4694444 0.454008
+ 12.4722222 0.456118
+ 12.4750000 0.451899
+ 12.4777778 0.447679
+ 12.4805556 0.439241
+ 12.4833333 0.437131
+ 12.4861111 0.432911
+ 12.4888889 0.437131
+ 12.4916667 0.445570
+ 12.4944444 0.458228
+ 12.4972222 0.468776
+ 12.5000000 0.475105
+ 12.5027778 0.485654
+ 12.5055556 0.489873
+ 12.5083333 0.494093
+ 12.5111111 0.498312
+ 12.5138889 0.504641
+ 12.5166667 0.513080
+ 12.5194444 0.517300
+ 12.5222222 0.534177
+ 12.5250000 0.570042
+ 12.5277778 0.614346
+ 12.5305556 0.658650
+ 12.5333333 0.688186
+ 12.5361111 0.690295
+ 12.5388889 0.648101
+ 12.5416667 0.563713
+ 12.5444444 0.468776
+ 12.5472222 0.384388
+ 12.5500000 0.335865
+ 12.5527778 0.312658
+ 12.5555556 0.312658
+ 12.5583333 0.331646
+ 12.5611111 0.344304
+ 12.5638889 0.350633
+ 12.5666667 0.361181
+ 12.5694444 0.363291
+ 12.5722222 0.365401
+ 12.5750000 0.363291
+ 12.5777778 0.363291
+ 12.5805556 0.354852
+ 12.5833333 0.348523
+ 12.5861111 0.352743
+ 12.5888889 0.361181
+ 12.5916667 0.378059
+ 12.5944444 0.382278
+ 12.5972222 0.388608
+ 12.6000000 0.392827
+ 12.6027778 0.390717
+ 12.6055556 0.388608
+ 12.6083333 0.380169
+ 12.6111111 0.375949
+ 12.6138889 0.369620
+ 12.6166667 0.361181
+ 12.6194444 0.359072
+ 12.6222222 0.361181
+ 12.6250000 0.371730
+ 12.6277778 0.386498
+ 12.6305556 0.401266
+ 12.6333333 0.424473
+ 12.6361111 0.437131
+ 12.6388889 0.449789
+ 12.6416667 0.449789
+ 12.6444444 0.454008
+ 12.6472222 0.451899
+ 12.6500000 0.443460
+ 12.6527778 0.441350
+ 12.6555556 0.443460
+ 12.6583333 0.443460
+ 12.6611111 0.447679
+ 12.6638889 0.454008
+ 12.6666667 0.462447
+ 12.6694444 0.470886
+ 12.6722222 0.470886
+ 12.6750000 0.470886
+ 12.6777778 0.464557
+ 12.6805556 0.458228
+ 12.6833333 0.451899
+ 12.6861111 0.447679
+ 12.6888889 0.443460
+ 12.6916667 0.445570
+ 12.6944444 0.447679
+ 12.6972222 0.447679
+ 12.7000000 0.454008
+ 12.7027778 0.462447
+ 12.7055556 0.475105
+ 12.7083333 0.479325
+ 12.7111111 0.479325
+ 12.7138889 0.468776
+ 12.7166667 0.456118
+ 12.7194444 0.447679
+ 12.7222222 0.441350
+ 12.7250000 0.445570
+ 12.7277778 0.460338
+ 12.7305556 0.479325
+ 12.7333333 0.489873
+ 12.7361111 0.491983
+ 12.7388889 0.483544
+ 12.7416667 0.464557
+ 12.7444444 0.451899
+ 12.7472222 0.447679
+ 12.7500000 0.454008
+ 12.7527778 0.464557
+ 12.7555556 0.477215
+ 12.7583333 0.485654
+ 12.7611111 0.491983
+ 12.7638889 0.481435
+ 12.7666667 0.483544
+ 12.7694444 0.481435
+ 12.7722222 0.485654
+ 12.7750000 0.483544
+ 12.7777778 0.483544
+ 12.7805556 0.489873
+ 12.7833333 0.496203
+ 12.7861111 0.500422
+ 12.7888889 0.500422
+ 12.7916667 0.513080
+ 12.7944444 0.519409
+ 12.7972222 0.513080
+ 12.8000000 0.519409
+ 12.8027778 0.517300
+ 12.8055556 0.527848
+ 12.8083333 0.532068
+ 12.8111111 0.532068
+ 12.8138889 0.536287
+ 12.8166667 0.536287
+ 12.8194444 0.529958
+ 12.8222222 0.523629
+ 12.8250000 0.521519
+ 12.8277778 0.519409
+ 12.8305556 0.525738
+ 12.8333333 0.525738
+ 12.8361111 0.534177
+ 12.8388889 0.544726
+ 12.8416667 0.553165
+ 12.8444444 0.555274
+ 12.8472222 0.551055
+ 12.8500000 0.544726
+ 12.8527778 0.542616
+ 12.8555556 0.536287
+ 12.8583333 0.538397
+ 12.8611111 0.536287
+ 12.8638889 0.538397
+ 12.8666667 0.536287
+ 12.8694444 0.538397
+ 12.8722222 0.540506
+ 12.8750000 0.540506
+ 12.8777778 0.538397
+ 12.8805556 0.542616
+ 12.8833333 0.538397
+ 12.8861111 0.540506
+ 12.8888889 0.538397
+ 12.8916667 0.538397
+ 12.8944444 0.534177
+ 12.8972222 0.527848
+ 12.9000000 0.521519
+ 12.9027778 0.515190
+ 12.9055556 0.510970
+ 12.9083333 0.502532
+ 12.9111111 0.494093
+ 12.9138889 0.489873
+ 12.9166667 0.496203
+ 12.9194444 0.491983
+ 12.9222222 0.491983
+ 12.9250000 0.487764
+ 12.9277778 0.491983
+ 12.9305556 0.485654
+ 12.9333333 0.483544
+ 12.9361111 0.468776
+ 12.9388889 0.462447
+ 12.9416667 0.449789
+ 12.9444444 0.447679
+ 12.9472222 0.451899
+ 12.9500000 0.451899
+ 12.9527778 0.454008
+ 12.9555556 0.451899
+ 12.9583333 0.449789
+ 12.9611111 0.445570
+ 12.9638889 0.445570
+ 12.9666667 0.443460
+ 12.9694444 0.445570
+ 12.9722222 0.447679
+ 12.9750000 0.445570
+ 12.9777778 0.454008
+ 12.9805556 0.456118
+ 12.9833333 0.456118
+ 12.9861111 0.454008
+ 12.9888889 0.458228
+ 12.9916667 0.462447
+ 12.9944444 0.475105
+ 12.9972222 0.485654
+ 13.0000000 0.494093
+ 13.0027778 0.496203
+ 13.0055556 0.491983
+ 13.0083333 0.487764
+ 13.0111111 0.479325
+ 13.0138889 0.475105
+ 13.0166667 0.470886
+ 13.0194444 0.464557
+ 13.0222222 0.460338
+ 13.0250000 0.460338
+ 13.0277778 0.462447
+ 13.0305556 0.470886
+ 13.0333333 0.470886
+ 13.0361111 0.479325
+ 13.0388889 0.483544
+ 13.0416667 0.485654
+ 13.0444444 0.483544
+ 13.0472222 0.483544
+ 13.0500000 0.487764
+ 13.0527778 0.491983
+ 13.0555556 0.489873
+ 13.0583333 0.489873
+ 13.0611111 0.483544
+ 13.0638889 0.470886
+ 13.0666667 0.458228
+ 13.0694444 0.456118
+ 13.0722222 0.458228
+ 13.0750000 0.464557
+ 13.0777778 0.477215
+ 13.0805556 0.489873
+ 13.0833333 0.500422
+ 13.0861111 0.494093
+ 13.0888889 0.489873
+ 13.0916667 0.472996
+ 13.0944444 0.462447
+ 13.0972222 0.458228
+ 13.1000000 0.451899
+ 13.1027778 0.460338
+ 13.1055556 0.472996
+ 13.1083333 0.479325
+ 13.1111111 0.489873
+ 13.1138889 0.494093
+ 13.1166667 0.485654
+ 13.1194444 0.477215
+ 13.1222222 0.464557
+ 13.1250000 0.451899
+ 13.1277778 0.456118
+ 13.1305556 0.460338
+ 13.1333333 0.466667
+ 13.1361111 0.470886
+ 13.1388889 0.477215
+ 13.1416667 0.479325
+ 13.1444444 0.485654
+ 13.1472222 0.483544
+ 13.1500000 0.485654
+ 13.1527778 0.485654
+ 13.1555556 0.485654
+ 13.1583333 0.483544
+ 13.1611111 0.470886
+ 13.1638889 0.462447
+ 13.1666667 0.456118
+ 13.1694444 0.462447
+ 13.1722222 0.462447
+ 13.1750000 0.466667
+ 13.1777778 0.470886
+ 13.1805556 0.468776
+ 13.1833333 0.479325
+ 13.1861111 0.504641
+ 13.1888889 0.536287
+ 13.1916667 0.584810
+ 13.1944444 0.639662
+ 13.1972222 0.673418
+ 13.2000000 0.694515
+ 13.2027778 0.671308
+ 13.2055556 0.616456
+ 13.2083333 0.534177
+ 13.2111111 0.447679
+ 13.2138889 0.369620
+ 13.2166667 0.333755
+ 13.2194444 0.329536
+ 13.2222222 0.337975
+ 13.2250000 0.356962
+ 13.2277778 0.384388
+ 13.2305556 0.397046
+ 13.2333333 0.399156
+ 13.2361111 0.405485
+ 13.2388889 0.403376
+ 13.2416667 0.394937
+ 13.2444444 0.394937
+ 13.2472222 0.399156
+ 13.2500000 0.405485
+ 13.2527778 0.409705
+ 13.2555556 0.413924
+ 13.2583333 0.407595
+ 13.2611111 0.397046
+ 13.2638889 0.384388
+ 13.2666667 0.373840
+ 13.2694444 0.369620
+ 13.2722222 0.367511
+ 13.2750000 0.371730
+ 13.2777778 0.375949
+ 13.2805556 0.378059
+ 13.2833333 0.382278
+ 13.2861111 0.390717
+ 13.2888889 0.401266
+ 13.2916667 0.413924
+ 13.2944444 0.426582
+ 13.2972222 0.454008
+ 13.3000000 0.477215
+ 13.3027778 0.502532
+ 13.3055556 0.506751
+ 13.3083333 0.496203
+ 13.3111111 0.479325
+ 13.3138889 0.460338
+ 13.3166667 0.435021
+ 13.3194444 0.424473
+ 13.3222222 0.428692
+ 13.3250000 0.432911
+ 13.3277778 0.443460
+ 13.3305556 0.458228
+ 13.3333333 0.462447
+ 13.3361111 0.472996
+ 13.3388889 0.475105
+ 13.3416667 0.470886
+ 13.3444444 0.475105
+ 13.3472222 0.477215
+ 13.3500000 0.481435
+ 13.3527778 0.479325
+ 13.3555556 0.470886
+ 13.3583333 0.458228
+ 13.3611111 0.456118
+ 13.3638889 0.454008
+ 13.3666667 0.462447
+ 13.3694444 0.472996
+ 13.3722222 0.475105
+ 13.3750000 0.479325
+ 13.3777778 0.485654
+ 13.3805556 0.479325
+ 13.3833333 0.468776
+ 13.3861111 0.460338
+ 13.3888889 0.451899
+ 13.3916667 0.449789
+ 13.3944444 0.458228
+ 13.3972222 0.466667
+ 13.4000000 0.470886
+ 13.4027778 0.485654
+ 13.4055556 0.489873
+ 13.4083333 0.500422
+ 13.4111111 0.498312
+ 13.4138889 0.498312
+ 13.4166667 0.491983
+ 13.4194444 0.483544
+ 13.4222222 0.479325
+ 13.4250000 0.475105
+ 13.4277778 0.479325
+ 13.4305556 0.489873
+ 13.4333333 0.506751
+ 13.4361111 0.517300
+ 13.4388889 0.519409
+ 13.4416667 0.517300
+ 13.4444444 0.515190
+ 13.4472222 0.508861
+ 13.4500000 0.513080
+ 13.4527778 0.523629
+ 13.4555556 0.527848
+ 13.4583333 0.538397
+ 13.4611111 0.540506
+ 13.4638889 0.544726
+ 13.4666667 0.536287
+ 13.4694444 0.532068
+ 13.4722222 0.529958
+ 13.4750000 0.532068
+ 13.4777778 0.536287
+ 13.4805556 0.538397
+ 13.4833333 0.544726
+ 13.4861111 0.548945
+ 13.4888889 0.546835
+ 13.4916667 0.540506
+ 13.4944444 0.532068
+ 13.4972222 0.527848
+ 13.5000000 0.532068
+ 13.5027778 0.538397
+ 13.5055556 0.546835
+ 13.5083333 0.551055
+ 13.5111111 0.546835
+ 13.5138889 0.542616
+ 13.5166667 0.538397
+ 13.5194444 0.532068
+ 13.5222222 0.523629
+ 13.5250000 0.527848
+ 13.5277778 0.527848
+ 13.5305556 0.523629
+ 13.5333333 0.517300
+ 13.5361111 0.508861
+ 13.5388889 0.498312
+ 13.5416667 0.487764
+ 13.5444444 0.479325
+ 13.5472222 0.477215
+ 13.5500000 0.479325
+ 13.5527778 0.487764
+ 13.5555556 0.494093
+ 13.5583333 0.494093
+ 13.5611111 0.481435
+ 13.5638889 0.466667
+ 13.5666667 0.468776
+ 13.5694444 0.464557
+ 13.5722222 0.460338
+ 13.5750000 0.454008
+ 13.5777778 0.447679
+ 13.5805556 0.439241
+ 13.5833333 0.441350
+ 13.5861111 0.443460
+ 13.5888889 0.449789
+ 13.5916667 0.456118
+ 13.5944444 0.458228
+ 13.5972222 0.454008
+ 13.6000000 0.443460
+ 13.6027778 0.443460
+ 13.6055556 0.447679
+ 13.6083333 0.454008
+ 13.6111111 0.456118
+ 13.6138889 0.462447
+ 13.6166667 0.458228
+ 13.6194444 0.462447
+ 13.6222222 0.462447
+ 13.6250000 0.466667
+ 13.6277778 0.468776
+ 13.6305556 0.462447
+ 13.6333333 0.460338
+ 13.6361111 0.462447
+ 13.6388889 0.456118
+ 13.6416667 0.460338
+ 13.6444444 0.462447
+ 13.6472222 0.460338
+ 13.6500000 0.460338
+ 13.6527778 0.458228
+ 13.6555556 0.454008
+ 13.6583333 0.456118
+ 13.6611111 0.458228
+ 13.6638889 0.462447
+ 13.6666667 0.468776
+ 13.6694444 0.468776
+ 13.6722222 0.464557
+ 13.6750000 0.460338
+ 13.6777778 0.462447
+ 13.6805556 0.456118
+ 13.6833333 0.458228
+ 13.6861111 0.458228
+ 13.6888889 0.460338
+ 13.6916667 0.460338
+ 13.6944444 0.462447
+ 13.6972222 0.466667
+ 13.7000000 0.466667
+ 13.7027778 0.472996
+ 13.7055556 0.479325
+ 13.7083333 0.481435
+ 13.7111111 0.479325
+ 13.7138889 0.468776
+ 13.7166667 0.456118
+ 13.7194444 0.449789
+ 13.7222222 0.447679
+ 13.7250000 0.451899
+ 13.7277778 0.462447
+ 13.7305556 0.466667
+ 13.7333333 0.470886
+ 13.7361111 0.464557
+ 13.7388889 0.460338
+ 13.7416667 0.456118
+ 13.7444444 0.454008
+ 13.7472222 0.443460
+ 13.7500000 0.447679
+ 13.7527778 0.449789
+ 13.7555556 0.451899
+ 13.7583333 0.458228
+ 13.7611111 0.462447
+ 13.7638889 0.464557
+ 13.7666667 0.460338
+ 13.7694444 0.454008
+ 13.7722222 0.462447
+ 13.7750000 0.460338
+ 13.7777778 0.462447
+ 13.7805556 0.472996
+ 13.7833333 0.464557
+ 13.7861111 0.462447
+ 13.7888889 0.458228
+ 13.7916667 0.458228
+ 13.7944444 0.460338
+ 13.7972222 0.462447
+ 13.8000000 0.454008
+ 13.8027778 0.451899
+ 13.8055556 0.454008
+ 13.8083333 0.447679
+ 13.8111111 0.454008
+ 13.8138889 0.451899
+ 13.8166667 0.456118
+ 13.8194444 0.451899
+ 13.8222222 0.451899
+ 13.8250000 0.447679
+ 13.8277778 0.443460
+ 13.8305556 0.447679
+ 13.8333333 0.451899
+ 13.8361111 0.460338
+ 13.8388889 0.468776
+ 13.8416667 0.468776
+ 13.8444444 0.464557
+ 13.8472222 0.458228
+ 13.8500000 0.451899
+ 13.8527778 0.449789
+ 13.8555556 0.449789
+ 13.8583333 0.456118
+ 13.8611111 0.454008
+ 13.8638889 0.458228
+ 13.8666667 0.460338
+ 13.8694444 0.462447
+ 13.8722222 0.466667
+ 13.8750000 0.466667
+ 13.8777778 0.466667
+ 13.8805556 0.466667
+ 13.8833333 0.460338
+ 13.8861111 0.458228
+ 13.8888889 0.456118
+ 13.8916667 0.451899
+ 13.8944444 0.456118
+ 13.8972222 0.460338
+ 13.9000000 0.462447
+ 13.9027778 0.462447
+ 13.9055556 0.458228
+ 13.9083333 0.464557
+ 13.9111111 0.464557
+ 13.9138889 0.462447
+ 13.9166667 0.456118
+ 13.9194444 0.454008
+ 13.9222222 0.451899
+ 13.9250000 0.454008
+ 13.9277778 0.456118
+ 13.9305556 0.451899
+ 13.9333333 0.456118
+ 13.9361111 0.454008
+ 13.9388889 0.462447
+ 13.9416667 0.462447
+ 13.9444444 0.462447
+ 13.9472222 0.460338
+ 13.9500000 0.447679
+ 13.9527778 0.437131
+ 13.9555556 0.428692
+ 13.9583333 0.430802
+ 13.9611111 0.441350
+ 13.9638889 0.449789
+ 13.9666667 0.458228
+ 13.9694444 0.466667
+ 13.9722222 0.477215
+ 13.9750000 0.472996
+ 13.9777778 0.475105
+ 13.9805556 0.470886
+ 13.9833333 0.464557
+ 13.9861111 0.458228
+ 13.9888889 0.456118
+ 13.9916667 0.441350
+ 13.9944444 0.428692
+ 13.9972222 0.426582
+ 14.0000000 0.428692
+ 14.0027778 0.437131
+ 14.0055556 0.451899
+ 14.0083333 0.462447
+ 14.0111111 0.472996
+ 14.0138889 0.477215
+ 14.0166667 0.468776
+ 14.0194444 0.454008
+ 14.0222222 0.435021
+ 14.0250000 0.432911
+ 14.0277778 0.439241
+ 14.0305556 0.445570
+ 14.0333333 0.454008
+ 14.0361111 0.464557
+ 14.0388889 0.472996
+ 14.0416667 0.470886
+ 14.0444444 0.462447
+ 14.0472222 0.458228
+ 14.0500000 0.451899
+ 14.0527778 0.443460
+ 14.0555556 0.447679
+ 14.0583333 0.447679
+ 14.0611111 0.447679
+ 14.0638889 0.456118
+ 14.0666667 0.458228
+ 14.0694444 0.456118
+ 14.0722222 0.460338
+ 14.0750000 0.462447
+ 14.0777778 0.472996
+ 14.0805556 0.477215
+ 14.0833333 0.481435
+ 14.0861111 0.479325
+ 14.0888889 0.468776
+ 14.0916667 0.462447
+ 14.0944444 0.443460
+ 14.0972222 0.439241
+ 14.1000000 0.430802
+ 14.1027778 0.432911
+ 14.1055556 0.445570
+ 14.1083333 0.451899
+ 14.1111111 0.466667
+ 14.1138889 0.468776
+ 14.1166667 0.466667
+ 14.1194444 0.458228
+ 14.1222222 0.449789
+ 14.1250000 0.451899
+ 14.1277778 0.458228
+ 14.1305556 0.462447
+ 14.1333333 0.460338
+ 14.1361111 0.456118
+ 14.1388889 0.454008
+ 14.1416667 0.443460
+ 14.1444444 0.447679
+ 14.1472222 0.454008
+ 14.1500000 0.449789
+ 14.1527778 0.451899
+ 14.1555556 0.449789
+ 14.1583333 0.458228
+ 14.1611111 0.462447
+ 14.1638889 0.468776
+ 14.1666667 0.472996
+ 14.1694444 0.472996
+ 14.1722222 0.468776
+ 14.1750000 0.462447
+ 14.1777778 0.456118
+ 14.1805556 0.454008
+ 14.1833333 0.451899
+ 14.1861111 0.449789
+ 14.1888889 0.451899
+ 14.1916667 0.456118
+ 14.1944444 0.454008
+ 14.1972222 0.449789
+ 14.2000000 0.451899
+ 14.2027778 0.447679
+ 14.2055556 0.451899
+ 14.2083333 0.454008
+ 14.2111111 0.451899
+ 14.2138889 0.456118
+ 14.2166667 0.458228
+ 14.2194444 0.460338
+ 14.2222222 0.466667
+ 14.2250000 0.470886
+ 14.2277778 0.470886
+ 14.2305556 0.468776
+ 14.2333333 0.458228
+ 14.2361111 0.447679
+ 14.2388889 0.443460
+ 14.2416667 0.443460
+ 14.2444444 0.454008
+ 14.2472222 0.464557
+ 14.2500000 0.468776
+ 14.2527778 0.466667
+ 14.2555556 0.460338
+ 14.2583333 0.454008
+ 14.2611111 0.451899
+ 14.2638889 0.454008
+ 14.2666667 0.466667
+ 14.2694444 0.470886
+ 14.2722222 0.477215
+ 14.2750000 0.472996
+ 14.2777778 0.472996
+ 14.2805556 0.475105
+ 14.2833333 0.468776
+ 14.2861111 0.462447
+ 14.2888889 0.454008
+ 14.2916667 0.443460
+ 14.2944444 0.443460
+ 14.2972222 0.449789
+ 14.3000000 0.460338
+ 14.3027778 0.470886
+ 14.3055556 0.472996
+ 14.3083333 0.468776
+ 14.3111111 0.462447
+ 14.3138889 0.462447
+ 14.3166667 0.454008
+ 14.3194444 0.454008
+ 14.3222222 0.451899
+ 14.3250000 0.458228
+ 14.3277778 0.462447
+ 14.3305556 0.460338
+ 14.3333333 0.464557
+ 14.3361111 0.462447
+ 14.3388889 0.462447
+ 14.3416667 0.460338
+ 14.3444444 0.462447
+ 14.3472222 0.464557
+ 14.3500000 0.456118
+ 14.3527778 0.454008
+ 14.3555556 0.460338
+ 14.3583333 0.462447
+ 14.3611111 0.470886
+ 14.3638889 0.470886
+ 14.3666667 0.472996
+ 14.3694444 0.466667
+ 14.3722222 0.466667
+ 14.3750000 0.460338
+ 14.3777778 0.462447
+ 14.3805556 0.466667
+ 14.3833333 0.456118
+ 14.3861111 0.454008
+ 14.3888889 0.449789
+ 14.3916667 0.430802
+ 14.3944444 0.441350
+ 14.3972222 0.451899
+ 14.4000000 0.462447
+ 14.4027778 0.479325
+ 14.4055556 0.487764
+ 14.4083333 0.489873
+ 14.4111111 0.468776
+ 14.4138889 0.456118
+ 14.4166667 0.437131
+ 14.4194444 0.428692
+ 14.4222222 0.430802
+ 14.4250000 0.439241
+ 14.4277778 0.447679
+ 14.4305556 0.460338
+ 14.4333333 0.466667
+ 14.4361111 0.472996
+ 14.4388889 0.483544
+ 14.4416667 0.489873
+ 14.4444444 0.485654
+ 14.4472222 0.477215
+ 14.4500000 0.464557
+ 14.4527778 0.454008
+ 14.4555556 0.449789
+ 14.4583333 0.449789
+ 14.4611111 0.441350
+ 14.4638889 0.439241
+ 14.4666667 0.435021
+ 14.4694444 0.439241
+ 14.4722222 0.449789
+ 14.4750000 0.460338
+ 14.4777778 0.464557
+ 14.4805556 0.472996
+ 14.4833333 0.475105
+ 14.4861111 0.475105
+ 14.4888889 0.470886
+ 14.4916667 0.470886
+ 14.4944444 0.475105
+ 14.4972222 0.477215
+ 14.5000000 0.466667
+ 14.5027778 0.451899
+ 14.5055556 0.445570
+ 14.5083333 0.430802
+ 14.5111111 0.432911
+ 14.5138889 0.439241
+ 14.5166667 0.445570
+ 14.5194444 0.454008
+ 14.5222222 0.460338
+ 14.5250000 0.458228
+ 14.5277778 0.460338
+ 14.5305556 0.462447
+ 14.5333333 0.464557
+ 14.5361111 0.475105
+ 14.5388889 0.483544
+ 14.5416667 0.485654
+ 14.5444444 0.485654
+ 14.5472222 0.470886
+ 14.5500000 0.451899
+ 14.5527778 0.439241
+ 14.5555556 0.439241
+ 14.5583333 0.441350
+ 14.5611111 0.445570
+ 14.5638889 0.447679
+ 14.5666667 0.447679
+ 14.5694444 0.460338
+ 14.5722222 0.466667
+ 14.5750000 0.472996
+ 14.5777778 0.481435
+ 14.5805556 0.483544
+ 14.5833333 0.477215
+ 14.5861111 0.464557
+ 14.5888889 0.451899
+ 14.5916667 0.445570
+ 14.5944444 0.451899
+ 14.5972222 0.449789
+ 14.6000000 0.456118
+ 14.6027778 0.462447
+ 14.6055556 0.472996
+ 14.6083333 0.475105
+ 14.6111111 0.470886
+ 14.6138889 0.472996
+ 14.6166667 0.477215
+ 14.6194444 0.477215
+ 14.6222222 0.483544
+ 14.6250000 0.485654
+ 14.6277778 0.491983
+ 14.6305556 0.496203
+ 14.6333333 0.496203
+ 14.6361111 0.500422
+ 14.6388889 0.500422
+ 14.6416667 0.496203
+ 14.6444444 0.491983
+ 14.6472222 0.485654
+ 14.6500000 0.491983
+ 14.6527778 0.489873
+ 14.6555556 0.494093
+ 14.6583333 0.491983
+ 14.6611111 0.485654
+ 14.6638889 0.481435
+ 14.6666667 0.481435
+ 14.6694444 0.483544
+ 14.6722222 0.491983
+ 14.6750000 0.496203
+ 14.6777778 0.494093
+ 14.6805556 0.485654
+ 14.6833333 0.470886
+ 14.6861111 0.464557
+ 14.6888889 0.462447
+ 14.6916667 0.468776
+ 14.6944444 0.464557
+ 14.6972222 0.466667
+ 14.7000000 0.462447
+ 14.7027778 0.462447
+ 14.7055556 0.464557
+ 14.7083333 0.460338
+ 14.7111111 0.462447
+ 14.7138889 0.462447
+ 14.7166667 0.460338
+ 14.7194444 0.458228
+ 14.7222222 0.456118
+ 14.7250000 0.456118
+ 14.7277778 0.447679
+ 14.7305556 0.456118
+ 14.7333333 0.462447
+ 14.7361111 0.466667
+ 14.7388889 0.470886
+ 14.7416667 0.475105
+ 14.7444444 0.475105
+ 14.7472222 0.470886
+ 14.7500000 0.470886
+ 14.7527778 0.462447
+ 14.7555556 0.458228
+ 14.7583333 0.449789
+ 14.7611111 0.443460
+ 14.7638889 0.449789
+ 14.7666667 0.447679
+ 14.7694444 0.451899
+ 14.7722222 0.460338
+ 14.7750000 0.466667
+ 14.7777778 0.468776
+ 14.7805556 0.468776
+ 14.7833333 0.458228
+ 14.7861111 0.451899
+ 14.7888889 0.449789
+ 14.7916667 0.441350
+ 14.7944444 0.447679
+ 14.7972222 0.447679
+ 14.8000000 0.456118
+ 14.8027778 0.477215
+ 14.8055556 0.485654
+ 14.8083333 0.494093
+ 14.8111111 0.502532
+ 14.8138889 0.513080
+ 14.8166667 0.519409
+ 14.8194444 0.517300
+ 14.8222222 0.510970
+ 14.8250000 0.510970
+ 14.8277778 0.523629
+ 14.8305556 0.538397
+ 14.8333333 0.565823
+ 14.8361111 0.597468
+ 14.8388889 0.635443
+ 14.8416667 0.656540
+ 14.8444444 0.641772
+ 14.8472222 0.595359
+ 14.8500000 0.515190
+ 14.8527778 0.435021
+ 14.8555556 0.373840
+ 14.8583333 0.342194
+ 14.8611111 0.337975
+ 14.8638889 0.340084
+ 14.8666667 0.356962
+ 14.8694444 0.365401
+ 14.8722222 0.371730
+ 14.8750000 0.375949
+ 14.8777778 0.373840
+ 14.8805556 0.367511
+ 14.8833333 0.365401
+ 14.8861111 0.359072
+ 14.8888889 0.354852
+ 14.8916667 0.365401
+ 14.8944444 0.375949
+ 14.8972222 0.392827
+ 14.9000000 0.403376
+ 14.9027778 0.405485
+ 14.9055556 0.397046
+ 14.9083333 0.386498
+ 14.9111111 0.371730
+ 14.9138889 0.369620
+ 14.9166667 0.369620
+ 14.9194444 0.373840
+ 14.9222222 0.380169
+ 14.9250000 0.392827
+ 14.9277778 0.399156
+ 14.9305556 0.409705
+ 14.9333333 0.422363
+ 14.9361111 0.428692
+ 14.9388889 0.437131
+ 14.9416667 0.441350
+ 14.9444444 0.449789
+ 14.9472222 0.460338
+ 14.9500000 0.464557
+ 14.9527778 0.468776
+ 14.9555556 0.468776
+ 14.9583333 0.462447
+ 14.9611111 0.460338
+ 14.9638889 0.466667
+ 14.9666667 0.475105
+ 14.9694444 0.479325
+ 14.9722222 0.470886
+ 14.9750000 0.456118
+ 14.9777778 0.456118
+ 14.9805556 0.458228
+ 14.9833333 0.462447
+ 14.9861111 0.460338
+ 14.9888889 0.464557
+ 14.9916667 0.464557
+ 14.9944444 0.464557
+ 14.9972222 0.475105
+ 15.0000000 0.472996
+ 15.0027778 0.481435
+ 15.0055556 0.481435
+ 15.0083333 0.481435
+ 15.0111111 0.479325
+ 15.0138889 0.468776
+ 15.0166667 0.464557
+ 15.0194444 0.460338
+ 15.0222222 0.451899
+ 15.0250000 0.458228
+ 15.0277778 0.464557
+ 15.0305556 0.479325
+ 15.0333333 0.489873
+ 15.0361111 0.491983
+ 15.0388889 0.485654
+ 15.0416667 0.481435
+ 15.0444444 0.475105
+ 15.0472222 0.481435
+ 15.0500000 0.485654
+ 15.0527778 0.491983
+ 15.0555556 0.489873
+ 15.0583333 0.485654
+ 15.0611111 0.479325
+ 15.0638889 0.475105
+ 15.0666667 0.475105
+ 15.0694444 0.489873
+ 15.0722222 0.498312
+ 15.0750000 0.508861
+ 15.0777778 0.508861
+ 15.0805556 0.504641
+ 15.0833333 0.500422
+ 15.0861111 0.500422
+ 15.0888889 0.504641
+ 15.0916667 0.506751
+ 15.0944444 0.515190
+ 15.0972222 0.515190
+ 15.1000000 0.515190
+ 15.1027778 0.517300
+ 15.1055556 0.519409
+ 15.1083333 0.521519
+ 15.1111111 0.521519
+ 15.1138889 0.529958
+ 15.1166667 0.527848
+ 15.1194444 0.527848
+ 15.1222222 0.527848
+ 15.1250000 0.529958
+ 15.1277778 0.529958
+ 15.1305556 0.534177
+ 15.1333333 0.538397
+ 15.1361111 0.540506
+ 15.1388889 0.542616
+ 15.1416667 0.540506
+ 15.1444444 0.540506
+ 15.1472222 0.536287
+ 15.1500000 0.538397
+ 15.1527778 0.548945
+ 15.1555556 0.546835
+ 15.1583333 0.544726
+ 15.1611111 0.540506
+ 15.1638889 0.536287
+ 15.1666667 0.538397
+ 15.1694444 0.542616
+ 15.1722222 0.546835
+ 15.1750000 0.548945
+ 15.1777778 0.553165
+ 15.1805556 0.551055
+ 15.1833333 0.544726
+ 15.1861111 0.538397
+ 15.1888889 0.527848
+ 15.1916667 0.517300
+ 15.1944444 0.506751
+ 15.1972222 0.500422
+ 15.2000000 0.498312
+ 15.2027778 0.500422
+ 15.2055556 0.508861
+ 15.2083333 0.510970
+ 15.2111111 0.515190
+ 15.2138889 0.513080
+ 15.2166667 0.508861
+ 15.2194444 0.506751
+ 15.2222222 0.498312
+ 15.2250000 0.494093
+ 15.2277778 0.487764
+ 15.2305556 0.487764
+ 15.2333333 0.485654
+ 15.2361111 0.481435
+ 15.2388889 0.475105
+ 15.2416667 0.462447
+ 15.2444444 0.462447
+ 15.2472222 0.464557
+ 15.2500000 0.462447
+ 15.2527778 0.460338
+ 15.2555556 0.458228
+ 15.2583333 0.456118
+ 15.2611111 0.458228
+ 15.2638889 0.458228
+ 15.2666667 0.470886
+ 15.2694444 0.483544
+ 15.2722222 0.489873
+ 15.2750000 0.485654
+ 15.2777778 0.479325
+ 15.2805556 0.475105
+ 15.2833333 0.466667
+ 15.2861111 0.468776
+ 15.2888889 0.475105
+ 15.2916667 0.491983
+ 15.2944444 0.508861
+ 15.2972222 0.517300
+ 15.3000000 0.519409
+ 15.3027778 0.502532
+ 15.3055556 0.487764
+ 15.3083333 0.472996
+ 15.3111111 0.460338
+ 15.3138889 0.462447
+ 15.3166667 0.475105
+ 15.3194444 0.485654
+ 15.3222222 0.496203
+ 15.3250000 0.502532
+ 15.3277778 0.506751
+ 15.3305556 0.504641
+ 15.3333333 0.500422
+ 15.3361111 0.496203
+ 15.3388889 0.496203
+ 15.3416667 0.489873
+ 15.3444444 0.489873
+ 15.3472222 0.485654
+ 15.3500000 0.489873
+ 15.3527778 0.494093
+ 15.3555556 0.500422
+ 15.3583333 0.502532
+ 15.3611111 0.502532
+ 15.3638889 0.508861
+ 15.3666667 0.508861
+ 15.3694444 0.506751
+ 15.3722222 0.513080
+ 15.3750000 0.513080
+ 15.3777778 0.506751
+ 15.3805556 0.504641
+ 15.3833333 0.504641
+ 15.3861111 0.496203
+ 15.3888889 0.500422
+ 15.3916667 0.506751
+ 15.3944444 0.508861
+ 15.3972222 0.508861
+ 15.4000000 0.508861
+ 15.4027778 0.508861
+ 15.4055556 0.508861
+ 15.4083333 0.515190
+ 15.4111111 0.527848
+ 15.4138889 0.532068
+ 15.4166667 0.525738
+ 15.4194444 0.517300
+ 15.4222222 0.508861
+ 15.4250000 0.496203
+ 15.4277778 0.487764
+ 15.4305556 0.496203
+ 15.4333333 0.506751
+ 15.4361111 0.519409
+ 15.4388889 0.523629
+ 15.4416667 0.519409
+ 15.4444444 0.513080
+ 15.4472222 0.510970
+ 15.4500000 0.508861
+ 15.4527778 0.504641
+ 15.4555556 0.496203
+ 15.4583333 0.489873
+ 15.4611111 0.502532
+ 15.4638889 0.508861
+ 15.4666667 0.519409
+ 15.4694444 0.517300
+ 15.4722222 0.510970
+ 15.4750000 0.504641
+ 15.4777778 0.506751
+ 15.4805556 0.517300
+ 15.4833333 0.527848
+ 15.4861111 0.534177
+ 15.4888889 0.529958
+ 15.4916667 0.523629
+ 15.4944444 0.523629
+ 15.4972222 0.521519
+ 15.5000000 0.536287
+ 15.5027778 0.565823
+ 15.5055556 0.603797
+ 15.5083333 0.639662
+ 15.5111111 0.664979
+ 15.5138889 0.696624
+ 15.5166667 0.698734
+ 15.5194444 0.673418
+ 15.5222222 0.612236
+ 15.5250000 0.532068
+ 15.5277778 0.458228
+ 15.5305556 0.401266
+ 15.5333333 0.380169
+ 15.5361111 0.388608
+ 15.5388889 0.416034
+ 15.5416667 0.441350
+ 15.5444444 0.456118
+ 15.5472222 0.460338
+ 15.5500000 0.454008
+ 15.5527778 0.439241
+ 15.5555556 0.411814
+ 15.5583333 0.394937
+ 15.5611111 0.382278
+ 15.5638889 0.394937
+ 15.5666667 0.416034
+ 15.5694444 0.447679
+ 15.5722222 0.472996
+ 15.5750000 0.477215
+ 15.5777778 0.472996
+ 15.5805556 0.458228
+ 15.5833333 0.449789
+ 15.5861111 0.426582
+ 15.5888889 0.413924
+ 15.5916667 0.401266
+ 15.5944444 0.407595
+ 15.5972222 0.416034
+ 15.6000000 0.439241
+ 15.6027778 0.456118
+ 15.6055556 0.475105
+ 15.6083333 0.487764
+ 15.6111111 0.494093
+ 15.6138889 0.496203
+ 15.6166667 0.502532
+ 15.6194444 0.508861
+ 15.6222222 0.523629
+ 15.6250000 0.527848
+ 15.6277778 0.529958
+ 15.6305556 0.532068
+ 15.6333333 0.519409
+ 15.6361111 0.506751
+ 15.6388889 0.500422
+ 15.6416667 0.491983
+ 15.6444444 0.491983
+ 15.6472222 0.498312
+ 15.6500000 0.515190
+ 15.6527778 0.527848
+ 15.6555556 0.536287
+ 15.6583333 0.529958
+ 15.6611111 0.519409
+ 15.6638889 0.508861
+ 15.6666667 0.504641
+ 15.6694444 0.500422
+ 15.6722222 0.506751
+ 15.6750000 0.510970
+ 15.6777778 0.519409
+ 15.6805556 0.529958
+ 15.6833333 0.529958
+ 15.6861111 0.532068
+ 15.6888889 0.527848
+ 15.6916667 0.521519
+ 15.6944444 0.521519
+ 15.6972222 0.519409
+ 15.7000000 0.527848
+ 15.7027778 0.529958
+ 15.7055556 0.538397
+ 15.7083333 0.540506
+ 15.7111111 0.538397
+ 15.7138889 0.540506
+ 15.7166667 0.527848
+ 15.7194444 0.529958
+ 15.7222222 0.532068
+ 15.7250000 0.527848
+ 15.7277778 0.536287
+ 15.7305556 0.534177
+ 15.7333333 0.534177
+ 15.7361111 0.532068
+ 15.7388889 0.538397
+ 15.7416667 0.544726
+ 15.7444444 0.546835
+ 15.7472222 0.555274
+ 15.7500000 0.553165
+ 15.7527778 0.555274
+ 15.7555556 0.555274
+ 15.7583333 0.553165
+ 15.7611111 0.561603
+ 15.7638889 0.570042
+ 15.7666667 0.572152
+ 15.7694444 0.576371
+ 15.7722222 0.582700
+ 15.7750000 0.584810
+ 15.7777778 0.586920
+ 15.7805556 0.584810
+ 15.7833333 0.586920
+ 15.7861111 0.584810
+ 15.7888889 0.589030
+ 15.7916667 0.601688
+ 15.7944444 0.605907
+ 15.7972222 0.608017
+ 15.8000000 0.597468
+ 15.8027778 0.595359
+ 15.8055556 0.591139
+ 15.8083333 0.601688
+ 15.8111111 0.610127
+ 15.8138889 0.608017
+ 15.8166667 0.612236
+ 15.8194444 0.612236
+ 15.8222222 0.608017
+ 15.8250000 0.605907
+ 15.8277778 0.599578
+ 15.8305556 0.595359
+ 15.8333333 0.595359
+ 15.8361111 0.597468
+ 15.8388889 0.597468
+ 15.8416667 0.593249
+ 15.8444444 0.586920
+ 15.8472222 0.584810
+ 15.8500000 0.582700
+ 15.8527778 0.582700
+ 15.8555556 0.572152
+ 15.8583333 0.567932
+ 15.8611111 0.565823
+ 15.8638889 0.557384
+ 15.8666667 0.546835
+ 15.8694444 0.542616
+ 15.8722222 0.538397
+ 15.8750000 0.536287
+ 15.8777778 0.534177
+ 15.8805556 0.534177
+ 15.8833333 0.532068
+ 15.8861111 0.527848
+ 15.8888889 0.527848
+ 15.8916667 0.525738
+ 15.8944444 0.529958
+ 15.8972222 0.529958
+ 15.9000000 0.523629
+ 15.9027778 0.517300
+ 15.9055556 0.513080
+ 15.9083333 0.508861
+ 15.9111111 0.515190
+ 15.9138889 0.519409
+ 15.9166667 0.517300
+ 15.9194444 0.508861
+ 15.9222222 0.498312
+ 15.9250000 0.483544
+ 15.9277778 0.479325
+ 15.9305556 0.477215
+ 15.9333333 0.483544
+ 15.9361111 0.487764
+ 15.9388889 0.496203
+ 15.9416667 0.500422
+ 15.9444444 0.508861
+ 15.9472222 0.510970
+ 15.9500000 0.508861
+ 15.9527778 0.504641
+ 15.9555556 0.502532
+ 15.9583333 0.500422
+ 15.9611111 0.500422
+ 15.9638889 0.502532
+ 15.9666667 0.508861
+ 15.9694444 0.519409
+ 15.9722222 0.525738
+ 15.9750000 0.523629
+ 15.9777778 0.508861
+ 15.9805556 0.504641
+ 15.9833333 0.491983
+ 15.9861111 0.481435
+ 15.9888889 0.487764
+ 15.9916667 0.496203
+ 15.9944444 0.513080
+ 15.9972222 0.519409
+ 16.0000000 0.506751
+ 16.0027778 0.504641
+ 16.0055556 0.494093
+ 16.0083333 0.485654
+ 16.0111111 0.479325
+ 16.0138889 0.479325
+ 16.0166667 0.479325
+ 16.0194444 0.472996
+ 16.0222222 0.470886
+ 16.0250000 0.472996
+ 16.0277778 0.475105
+ 16.0305556 0.472996
+ 16.0333333 0.483544
+ 16.0361111 0.489873
+ 16.0388889 0.494093
+ 16.0416667 0.487764
+ 16.0444444 0.487764
+ 16.0472222 0.481435
+ 16.0500000 0.483544
+ 16.0527778 0.485654
+ 16.0555556 0.487764
+ 16.0583333 0.500422
+ 16.0611111 0.515190
+ 16.0638889 0.523629
+ 16.0666667 0.525738
+ 16.0694444 0.521519
+ 16.0722222 0.506751
+ 16.0750000 0.494093
+ 16.0777778 0.485654
+ 16.0805556 0.483544
+ 16.0833333 0.491983
+ 16.0861111 0.496203
+ 16.0888889 0.500422
+ 16.0916667 0.504641
+ 16.0944444 0.500422
+ 16.0972222 0.491983
+ 16.1000000 0.491983
+ 16.1027778 0.491983
+ 16.1055556 0.491983
+ 16.1083333 0.489873
+ 16.1111111 0.487764
+ 16.1138889 0.472996
+ 16.1166667 0.464557
+ 16.1194444 0.460338
+ 16.1222222 0.472996
+ 16.1250000 0.483544
+ 16.1277778 0.494093
+ 16.1305556 0.500422
+ 16.1333333 0.510970
+ 16.1361111 0.513080
+ 16.1388889 0.506751
+ 16.1416667 0.491983
+ 16.1444444 0.477215
+ 16.1472222 0.466667
+ 16.1500000 0.456118
+ 16.1527778 0.460338
+ 16.1555556 0.468776
+ 16.1583333 0.479325
+ 16.1611111 0.485654
+ 16.1638889 0.496203
+ 16.1666667 0.500422
+ 16.1694444 0.508861
+ 16.1722222 0.519409
+ 16.1750000 0.525738
+ 16.1777778 0.519409
+ 16.1805556 0.502532
+ 16.1833333 0.483544
+ 16.1861111 0.456118
+ 16.1888889 0.449789
+ 16.1916667 0.445570
+ 16.1944444 0.445570
+ 16.1972222 0.458228
+ 16.2000000 0.475105
+ 16.2027778 0.487764
+ 16.2055556 0.496203
+ 16.2083333 0.506751
+ 16.2111111 0.517300
+ 16.2138889 0.534177
+ 16.2166667 0.538397
+ 16.2194444 0.529958
+ 16.2222222 0.513080
+ 16.2250000 0.487764
+ 16.2277778 0.458228
+ 16.2305556 0.447679
+ 16.2333333 0.449789
+ 16.2361111 0.464557
+ 16.2388889 0.479325
+ 16.2416667 0.502532
+ 16.2444444 0.517300
+ 16.2472222 0.532068
+ 16.2500000 0.548945
+ 16.2527778 0.561603
+ 16.2555556 0.589030
+ 16.2583333 0.618565
+ 16.2611111 0.652321
+ 16.2638889 0.690295
+ 16.2666667 0.724051
+ 16.2694444 0.734599
+ 16.2722222 0.709283
+ 16.2750000 0.629114
+ 16.2777778 0.519409
+ 16.2805556 0.424473
+ 16.2833333 0.356962
+ 16.2861111 0.329536
+ 16.2888889 0.325316
+ 16.2916667 0.337975
+ 16.2944444 0.359072
+ 16.2972222 0.378059
+ 16.3000000 0.394937
+ 16.3027778 0.418143
+ 16.3055556 0.428692
+ 16.3083333 0.424473
+ 16.3111111 0.411814
+ 16.3138889 0.392827
+ 16.3166667 0.371730
+ 16.3194444 0.363291
+ 16.3222222 0.369620
+ 16.3250000 0.382278
+ 16.3277778 0.399156
+ 16.3305556 0.413924
+ 16.3333333 0.420253
+ 16.3361111 0.413924
+ 16.3388889 0.407595
+ 16.3416667 0.399156
+ 16.3444444 0.397046
+ 16.3472222 0.390717
+ 16.3500000 0.394937
+ 16.3527778 0.401266
+ 16.3555556 0.405485
+ 16.3583333 0.416034
+ 16.3611111 0.432911
+ 16.3638889 0.449789
+ 16.3666667 0.466667
+ 16.3694444 0.472996
+ 16.3722222 0.485654
+ 16.3750000 0.491983
+ 16.3777778 0.502532
+ 16.3805556 0.502532
+ 16.3833333 0.496203
+ 16.3861111 0.483544
+ 16.3888889 0.462447
+ 16.3916667 0.456118
+ 16.3944444 0.454008
+ 16.3972222 0.460338
+ 16.4000000 0.472996
+ 16.4027778 0.483544
+ 16.4055556 0.498312
+ 16.4083333 0.498312
+ 16.4111111 0.502532
+ 16.4138889 0.487764
+ 16.4166667 0.483544
+ 16.4194444 0.475105
+ 16.4222222 0.468776
+ 16.4250000 0.466667
+ 16.4277778 0.470886
+ 16.4305556 0.472996
+ 16.4333333 0.479325
+ 16.4361111 0.485654
+ 16.4388889 0.494093
+ 16.4416667 0.496203
+ 16.4444444 0.498312
+ 16.4472222 0.489873
+ 16.4500000 0.485654
+ 16.4527778 0.481435
+ 16.4555556 0.475105
+ 16.4583333 0.483544
+ 16.4611111 0.491983
+ 16.4638889 0.489873
+ 16.4666667 0.489873
+ 16.4694444 0.487764
+ 16.4722222 0.491983
+ 16.4750000 0.502532
+ 16.4777778 0.506751
+ 16.4805556 0.523629
+ 16.4833333 0.538397
+ 16.4861111 0.540506
+ 16.4888889 0.529958
+ 16.4916667 0.513080
+ 16.4944444 0.494093
+ 16.4972222 0.479325
+ 16.5000000 0.470886
+ 16.5027778 0.477215
+ 16.5055556 0.487764
+ 16.5083333 0.498312
+ 16.5111111 0.515190
+ 16.5138889 0.525738
+ 16.5166667 0.540506
+ 16.5194444 0.542616
+ 16.5222222 0.553165
+ 16.5250000 0.561603
+ 16.5277778 0.567932
+ 16.5305556 0.570042
+ 16.5333333 0.555274
+ 16.5361111 0.542616
+ 16.5388889 0.538397
+ 16.5416667 0.536287
+ 16.5444444 0.544726
+ 16.5472222 0.555274
+ 16.5500000 0.563713
+ 16.5527778 0.576371
+ 16.5555556 0.576371
+ 16.5583333 0.572152
+ 16.5611111 0.565823
+ 16.5638889 0.565823
+ 16.5666667 0.565823
+ 16.5694444 0.570042
+ 16.5722222 0.576371
+ 16.5750000 0.582700
+ 16.5777778 0.582700
+ 16.5805556 0.574262
+ 16.5833333 0.561603
+ 16.5861111 0.544726
+ 16.5888889 0.538397
+ 16.5916667 0.532068
+ 16.5944444 0.532068
+ 16.5972222 0.534177
+ 16.6000000 0.527848
+ 16.6027778 0.525738
+ 16.6055556 0.529958
+ 16.6083333 0.534177
+ 16.6111111 0.536287
+ 16.6138889 0.529958
+ 16.6166667 0.519409
+ 16.6194444 0.504641
+ 16.6222222 0.496203
+ 16.6250000 0.491983
+ 16.6277778 0.485654
+ 16.6305556 0.487764
+ 16.6333333 0.491983
+ 16.6361111 0.494093
+ 16.6388889 0.494093
+ 16.6416667 0.491983
+ 16.6444444 0.483544
+ 16.6472222 0.487764
+ 16.6500000 0.481435
+ 16.6527778 0.477215
+ 16.6555556 0.477215
+ 16.6583333 0.472996
+ 16.6611111 0.477215
+ 16.6638889 0.483544
+ 16.6666667 0.494093
+ 16.6694444 0.498312
+ 16.6722222 0.502532
+ 16.6750000 0.494093
+ 16.6777778 0.485654
+ 16.6805556 0.479325
+ 16.6833333 0.472996
+ 16.6861111 0.466667
+ 16.6888889 0.470886
+ 16.6916667 0.468776
+ 16.6944444 0.472996
+ 16.6972222 0.468776
+ 16.7000000 0.472996
+ 16.7027778 0.470886
+ 16.7055556 0.472996
+ 16.7083333 0.475105
+ 16.7111111 0.479325
+ 16.7138889 0.481435
+ 16.7166667 0.483544
+ 16.7194444 0.485654
+ 16.7222222 0.489873
+ 16.7250000 0.491983
+ 16.7277778 0.496203
+ 16.7305556 0.498312
+ 16.7333333 0.496203
+ 16.7361111 0.494093
+ 16.7388889 0.489873
+ 16.7416667 0.489873
+ 16.7444444 0.489873
+ 16.7472222 0.491983
+ 16.7500000 0.494093
+ 16.7527778 0.498312
+ 16.7555556 0.498312
+ 16.7583333 0.489873
+ 16.7611111 0.487764
+ 16.7638889 0.481435
+ 16.7666667 0.477215
+ 16.7694444 0.483544
+ 16.7722222 0.491983
+ 16.7750000 0.500422
+ 16.7777778 0.500422
+ 16.7805556 0.500422
+ 16.7833333 0.500422
+ 16.7861111 0.489873
+ 16.7888889 0.479325
+ 16.7916667 0.468776
+ 16.7944444 0.462447
+ 16.7972222 0.466667
+ 16.8000000 0.470886
+ 16.8027778 0.477215
+ 16.8055556 0.477215
+ 16.8083333 0.481435
+ 16.8111111 0.489873
+ 16.8138889 0.496203
+ 16.8166667 0.496203
+ 16.8194444 0.494093
+ 16.8222222 0.489873
+ 16.8250000 0.483544
+ 16.8277778 0.477215
+ 16.8305556 0.481435
+ 16.8333333 0.479325
+ 16.8361111 0.481435
+ 16.8388889 0.483544
+ 16.8416667 0.477215
+ 16.8444444 0.477215
+ 16.8472222 0.475105
+ 16.8500000 0.468776
+ 16.8527778 0.464557
+ 16.8555556 0.466667
+ 16.8583333 0.466667
+ 16.8611111 0.470886
+ 16.8638889 0.477215
+ 16.8666667 0.479325
+ 16.8694444 0.479325
+ 16.8722222 0.477215
+ 16.8750000 0.472996
+ 16.8777778 0.468776
+ 16.8805556 0.472996
+ 16.8833333 0.468776
+ 16.8861111 0.477215
+ 16.8888889 0.489873
+ 16.8916667 0.496203
+ 16.8944444 0.500422
+ 16.8972222 0.498312
+ 16.9000000 0.483544
+ 16.9027778 0.466667
+ 16.9055556 0.462447
+ 16.9083333 0.458228
+ 16.9111111 0.464557
+ 16.9138889 0.479325
+ 16.9166667 0.491983
+ 16.9194444 0.489873
+ 16.9222222 0.481435
+ 16.9250000 0.470886
+ 16.9277778 0.464557
+ 16.9305556 0.462447
+ 16.9333333 0.470886
+ 16.9361111 0.472996
+ 16.9388889 0.485654
+ 16.9416667 0.487764
+ 16.9444444 0.487764
+ 16.9472222 0.483544
+ 16.9500000 0.475105
+ 16.9527778 0.472996
+ 16.9555556 0.470886
+ 16.9583333 0.468776
+ 16.9611111 0.468776
+ 16.9638889 0.466667
+ 16.9666667 0.470886
+ 16.9694444 0.470886
+ 16.9722222 0.481435
+ 16.9750000 0.481435
+ 16.9777778 0.485654
+ 16.9805556 0.491983
+ 16.9833333 0.496203
+ 16.9861111 0.496203
+ 16.9888889 0.483544
+ 16.9916667 0.472996
+ 16.9944444 0.468776
+ 16.9972222 0.468776
+ 17.0000000 0.475105
+ 17.0027778 0.475105
+ 17.0055556 0.479325
+ 17.0083333 0.468776
+ 17.0111111 0.466667
+ 17.0138889 0.462447
+ 17.0166667 0.462447
+ 17.0194444 0.462447
+ 17.0222222 0.468776
+ 17.0250000 0.472996
+ 17.0277778 0.481435
+ 17.0305556 0.489873
+ 17.0333333 0.496203
+ 17.0361111 0.491983
+ 17.0388889 0.487764
+ 17.0416667 0.479325
+ 17.0444444 0.470886
+ 17.0472222 0.475105
+ 17.0500000 0.470886
+ 17.0527778 0.460338
+ 17.0555556 0.462447
+ 17.0583333 0.460338
+ 17.0611111 0.464557
+ 17.0638889 0.470886
+ 17.0666667 0.468776
+ 17.0694444 0.466667
+ 17.0722222 0.468776
+ 17.0750000 0.472996
+ 17.0777778 0.479325
+ 17.0805556 0.481435
+ 17.0833333 0.481435
+ 17.0861111 0.477215
+ 17.0888889 0.472996
+ 17.0916667 0.470886
+ 17.0944444 0.475105
+ 17.0972222 0.475105
+ 17.1000000 0.475105
+ 17.1027778 0.479325
+ 17.1055556 0.477215
+ 17.1083333 0.475105
+ 17.1111111 0.470886
+ 17.1138889 0.477215
+ 17.1166667 0.472996
+ 17.1194444 0.470886
+ 17.1222222 0.472996
+ 17.1250000 0.472996
+ 17.1277778 0.481435
+ 17.1305556 0.479325
+ 17.1333333 0.475105
+ 17.1361111 0.475105
+ 17.1388889 0.470886
+ 17.1416667 0.468776
+ 17.1444444 0.475105
+ 17.1472222 0.481435
+ 17.1500000 0.483544
+ 17.1527778 0.485654
+ 17.1555556 0.489873
+ 17.1583333 0.481435
+ 17.1611111 0.479325
+ 17.1638889 0.475105
+ 17.1666667 0.470886
+ 17.1694444 0.464557
+ 17.1722222 0.466667
+ 17.1750000 0.470886
+ 17.1777778 0.477215
+ 17.1805556 0.481435
+ 17.1833333 0.483544
+ 17.1861111 0.483544
+ 17.1888889 0.479325
+ 17.1916667 0.481435
+ 17.1944444 0.481435
+ 17.1972222 0.483544
+ 17.2000000 0.489873
+ 17.2027778 0.485654
+ 17.2055556 0.475105
+ 17.2083333 0.466667
+ 17.2111111 0.460338
+ 17.2138889 0.456118
+ 17.2166667 0.462447
+ 17.2194444 0.462447
+ 17.2222222 0.470886
+ 17.2250000 0.479325
+ 17.2277778 0.481435
+ 17.2305556 0.477215
+ 17.2333333 0.472996
+ 17.2361111 0.468776
+ 17.2388889 0.470886
+ 17.2416667 0.477215
+ 17.2444444 0.479325
+ 17.2472222 0.477215
+ 17.2500000 0.477215
+ 17.2527778 0.477215
+ 17.2555556 0.472996
+ 17.2583333 0.475105
+ 17.2611111 0.472996
+ 17.2638889 0.464557
+ 17.2666667 0.458228
+ 17.2694444 0.460338
+ 17.2722222 0.464557
+ 17.2750000 0.468776
+ 17.2777778 0.479325
+ 17.2805556 0.489873
+ 17.2833333 0.491983
+ 17.2861111 0.494093
+ 17.2888889 0.483544
+ 17.2916667 0.481435
+ 17.2944444 0.472996
+ 17.2972222 0.472996
+ 17.3000000 0.479325
+ 17.3027778 0.485654
+ 17.3055556 0.485654
+ 17.3083333 0.479325
+ 17.3111111 0.475105
+ 17.3138889 0.460338
+ 17.3166667 0.447679
+ 17.3194444 0.441350
+ 17.3222222 0.441350
+ 17.3250000 0.454008
+ 17.3277778 0.462447
+ 17.3305556 0.470886
+ 17.3333333 0.481435
+ 17.3361111 0.487764
+ 17.3388889 0.485654
+ 17.3416667 0.475105
+ 17.3444444 0.468776
+ 17.3472222 0.464557
+ 17.3500000 0.462447
+ 17.3527778 0.462447
+ 17.3555556 0.470886
+ 17.3583333 0.470886
+ 17.3611111 0.472996
+ 17.3638889 0.472996
+ 17.3666667 0.466667
+ 17.3694444 0.464557
+ 17.3722222 0.472996
+ 17.3750000 0.472996
+ 17.3777778 0.481435
+ 17.3805556 0.481435
+ 17.3833333 0.479325
+ 17.3861111 0.477215
+ 17.3888889 0.470886
+ 17.3916667 0.462447
+ 17.3944444 0.468776
+ 17.3972222 0.475105
+ 17.4000000 0.475105
+ 17.4027778 0.468776
+ 17.4055556 0.472996
+ 17.4083333 0.472996
+ 17.4111111 0.477215
+ 17.4138889 0.481435
+ 17.4166667 0.472996
+ 17.4194444 0.466667
+ 17.4222222 0.460338
+ 17.4250000 0.460338
+ 17.4277778 0.456118
+ 17.4305556 0.468776
+ 17.4333333 0.472996
+ 17.4361111 0.477215
+ 17.4388889 0.483544
+ 17.4416667 0.481435
+ 17.4444444 0.481435
+ 17.4472222 0.475105
+ 17.4500000 0.470886
+ 17.4527778 0.462447
+ 17.4555556 0.464557
+ 17.4583333 0.468776
+ 17.4611111 0.477215
+ 17.4638889 0.481435
+ 17.4666667 0.483544
+ 17.4694444 0.481435
+ 17.4722222 0.477215
+ 17.4750000 0.477215
+ 17.4777778 0.477215
+ 17.4805556 0.479325
+ 17.4833333 0.468776
+ 17.4861111 0.466667
+ 17.4888889 0.468776
+ 17.4916667 0.470886
+ 17.4944444 0.477215
+ 17.4972222 0.472996
+ 17.5000000 0.483544
+ 17.5027778 0.481435
+ 17.5055556 0.489873
+ 17.5083333 0.481435
+ 17.5111111 0.475105
+ 17.5138889 0.468776
+ 17.5166667 0.462447
+ 17.5194444 0.456118
+ 17.5222222 0.454008
+ 17.5250000 0.458228
+ 17.5277778 0.460338
+ 17.5305556 0.468776
+ 17.5333333 0.479325
+ 17.5361111 0.481435
+ 17.5388889 0.487764
+ 17.5416667 0.494093
+ 17.5444444 0.498312
+ 17.5472222 0.491983
+ 17.5500000 0.481435
+ 17.5527778 0.464557
+ 17.5555556 0.456118
+ 17.5583333 0.449789
+ 17.5611111 0.451899
+ 17.5638889 0.458228
+ 17.5666667 0.466667
+ 17.5694444 0.470886
+ 17.5722222 0.483544
+ 17.5750000 0.487764
+ 17.5777778 0.491983
+ 17.5805556 0.498312
+ 17.5833333 0.494093
+ 17.5861111 0.485654
+ 17.5888889 0.477215
+ 17.5916667 0.468776
+ 17.5944444 0.456118
+ 17.5972222 0.458228
+ 17.6000000 0.466667
+ 17.6027778 0.479325
+ 17.6055556 0.487764
+ 17.6083333 0.483544
+ 17.6111111 0.472996
+ 17.6138889 0.460338
+ 17.6166667 0.464557
+ 17.6194444 0.460338
+ 17.6222222 0.458228
+ 17.6250000 0.458228
+ 17.6277778 0.468776
+ 17.6305556 0.479325
+ 17.6333333 0.483544
+ 17.6361111 0.491983
+ 17.6388889 0.500422
+ 17.6416667 0.504641
+ 17.6444444 0.496203
+ 17.6472222 0.487764
+ 17.6500000 0.472996
+ 17.6527778 0.451899
+ 17.6555556 0.443460
+ 17.6583333 0.445570
+ 17.6611111 0.458228
+ 17.6638889 0.464557
+ 17.6666667 0.477215
+ 17.6694444 0.483544
+ 17.6722222 0.483544
+ 17.6750000 0.477215
+ 17.6777778 0.464557
+ 17.6805556 0.454008
+ 17.6833333 0.441350
+ 17.6861111 0.435021
+ 17.6888889 0.435021
+ 17.6916667 0.445570
+ 17.6944444 0.462447
+ 17.6972222 0.470886
+ 17.7000000 0.479325
+ 17.7027778 0.483544
+ 17.7055556 0.477215
+ 17.7083333 0.472996
+ 17.7111111 0.466667
+ 17.7138889 0.458228
+ 17.7166667 0.449789
+ 17.7194444 0.451899
+ 17.7222222 0.458228
+ 17.7250000 0.472996
+ 17.7277778 0.487764
+ 17.7305556 0.494093
+ 17.7333333 0.496203
+ 17.7361111 0.494093
+ 17.7388889 0.485654
+ 17.7416667 0.479325
+ 17.7444444 0.472996
+ 17.7472222 0.468776
+ 17.7500000 0.468776
+ 17.7527778 0.466667
+ 17.7555556 0.466667
+ 17.7583333 0.466667
+ 17.7611111 0.466667
+ 17.7638889 0.472996
+ 17.7666667 0.481435
+ 17.7694444 0.485654
+ 17.7722222 0.489873
+ 17.7750000 0.479325
+ 17.7777778 0.470886
+ 17.7805556 0.462447
+ 17.7833333 0.458228
+ 17.7861111 0.458228
+ 17.7888889 0.466667
+ 17.7916667 0.472996
+ 17.7944444 0.491983
+ 17.7972222 0.496203
+ 17.8000000 0.498312
+ 17.8027778 0.498312
+ 17.8055556 0.496203
+ 17.8083333 0.500422
+ 17.8111111 0.504641
+ 17.8138889 0.506751
+ 17.8166667 0.502532
+ 17.8194444 0.500422
+ 17.8222222 0.496203
+ 17.8250000 0.487764
+ 17.8277778 0.485654
+ 17.8305556 0.489873
+ 17.8333333 0.496203
+ 17.8361111 0.500422
+ 17.8388889 0.502532
+ 17.8416667 0.498312
+ 17.8444444 0.489873
+ 17.8472222 0.477215
+ 17.8500000 0.472996
+ 17.8527778 0.466667
+ 17.8555556 0.466667
+ 17.8583333 0.470886
+ 17.8611111 0.479325
+ 17.8638889 0.483544
+ 17.8666667 0.483544
+ 17.8694444 0.485654
+ 17.8722222 0.487764
+ 17.8750000 0.487764
+ 17.8777778 0.477215
+ 17.8805556 0.472996
+ 17.8833333 0.462447
+ 17.8861111 0.464557
+ 17.8888889 0.466667
+ 17.8916667 0.470886
+ 17.8944444 0.470886
+ 17.8972222 0.472996
+ 17.9000000 0.468776
+ 17.9027778 0.468776
+ 17.9055556 0.460338
+ 17.9083333 0.456118
+ 17.9111111 0.456118
+ 17.9138889 0.458228
+ 17.9166667 0.456118
+ 17.9194444 0.451899
+ 17.9222222 0.464557
+ 17.9250000 0.466667
+ 17.9277778 0.470886
+ 17.9305556 0.468776
+ 17.9333333 0.464557
+ 17.9361111 0.460338
+ 17.9388889 0.470886
+ 17.9416667 0.472996
+ 17.9444444 0.479325
+ 17.9472222 0.472996
+ 17.9500000 0.466667
+ 17.9527778 0.456118
+ 17.9555556 0.447679
+ 17.9583333 0.443460
+ 17.9611111 0.451899
+ 17.9638889 0.458228
+ 17.9666667 0.468776
+ 17.9694444 0.479325
+ 17.9722222 0.481435
+ 17.9750000 0.470886
+ 17.9777778 0.456118
+ 17.9805556 0.449789
+ 17.9833333 0.458228
+ 17.9861111 0.475105
+ 17.9888889 0.496203
+ 17.9916667 0.515190
+ 17.9944444 0.529958
+ 17.9972222 0.553165
+ 18.0000000 0.578481
+ 18.0027778 0.614346
+ 18.0055556 0.645992
+ 18.0083333 0.667089
+ 18.0111111 0.662869
+ 18.0138889 0.627004
+ 18.0166667 0.548945
+ 18.0194444 0.462447
+ 18.0222222 0.386498
+ 18.0250000 0.344304
+ 18.0277778 0.331646
+ 18.0305556 0.342194
+ 18.0333333 0.359072
+ 18.0361111 0.367511
+ 18.0388889 0.375949
+ 18.0416667 0.375949
+ 18.0444444 0.375949
+ 18.0472222 0.369620
+ 18.0500000 0.359072
+ 18.0527778 0.352743
+ 18.0555556 0.348523
+ 18.0583333 0.350633
+ 18.0611111 0.363291
+ 18.0638889 0.375949
+ 18.0666667 0.386498
+ 18.0694444 0.399156
+ 18.0722222 0.397046
+ 18.0750000 0.392827
+ 18.0777778 0.378059
+ 18.0805556 0.375949
+ 18.0833333 0.367511
+ 18.0861111 0.367511
+ 18.0888889 0.371730
+ 18.0916667 0.380169
+ 18.0944444 0.397046
+ 18.0972222 0.403376
+ 18.1000000 0.411814
+ 18.1027778 0.424473
+ 18.1055556 0.435021
+ 18.1083333 0.451899
+ 18.1111111 0.462447
+ 18.1138889 0.475105
+ 18.1166667 0.475105
+ 18.1194444 0.475105
+ 18.1222222 0.460338
+ 18.1250000 0.458228
+ 18.1277778 0.462447
+ 18.1305556 0.470886
+ 18.1333333 0.483544
+ 18.1361111 0.483544
+ 18.1388889 0.472996
+ 18.1416667 0.458228
+ 18.1444444 0.441350
+ 18.1472222 0.445570
+ 18.1500000 0.447679
+ 18.1527778 0.451899
+ 18.1555556 0.456118
+ 18.1583333 0.454008
+ 18.1611111 0.451899
+ 18.1638889 0.449789
+ 18.1666667 0.447679
+ 18.1694444 0.451899
+ 18.1722222 0.454008
+ 18.1750000 0.456118
+ 18.1777778 0.460338
+ 18.1805556 0.458228
+ 18.1833333 0.466667
+ 18.1861111 0.466667
+ 18.1888889 0.462447
+ 18.1916667 0.472996
+ 18.1944444 0.477215
+ 18.1972222 0.475105
+ 18.2000000 0.475105
+ 18.2027778 0.481435
+ 18.2055556 0.481435
+ 18.2083333 0.470886
+ 18.2111111 0.477215
+ 18.2138889 0.479325
+ 18.2166667 0.483544
+ 18.2194444 0.500422
+ 18.2222222 0.504641
+ 18.2250000 0.496203
+ 18.2277778 0.481435
+ 18.2305556 0.460338
+ 18.2333333 0.456118
+ 18.2361111 0.466667
+ 18.2388889 0.479325
+ 18.2416667 0.491983
+ 18.2444444 0.508861
+ 18.2472222 0.510970
+ 18.2500000 0.500422
+ 18.2527778 0.496203
+ 18.2555556 0.491983
+ 18.2583333 0.487764
+ 18.2611111 0.491983
+ 18.2638889 0.502532
+ 18.2666667 0.513080
+ 18.2694444 0.521519
+ 18.2722222 0.532068
+ 18.2750000 0.523629
+ 18.2777778 0.519409
+ 18.2805556 0.515190
+ 18.2833333 0.527848
+ 18.2861111 0.534177
+ 18.2888889 0.534177
+ 18.2916667 0.529958
+ 18.2944444 0.534177
+ 18.2972222 0.534177
+ 18.3000000 0.536287
+ 18.3027778 0.536287
+ 18.3055556 0.538397
+ 18.3083333 0.540506
+ 18.3111111 0.534177
+ 18.3138889 0.532068
+ 18.3166667 0.527848
+ 18.3194444 0.532068
+ 18.3222222 0.538397
+ 18.3250000 0.540506
+ 18.3277778 0.548945
+ 18.3305556 0.546835
+ 18.3333333 0.542616
+ 18.3361111 0.534177
+ 18.3388889 0.544726
+ 18.3416667 0.546835
+ 18.3444444 0.551055
+ 18.3472222 0.542616
+ 18.3500000 0.534177
+ 18.3527778 0.523629
+ 18.3555556 0.515190
+ 18.3583333 0.519409
+ 18.3611111 0.523629
+ 18.3638889 0.513080
+ 18.3666667 0.502532
+ 18.3694444 0.496203
+ 18.3722222 0.500422
+ 18.3750000 0.502532
+ 18.3777778 0.496203
+ 18.3805556 0.496203
+ 18.3833333 0.491983
+ 18.3861111 0.485654
+ 18.3888889 0.485654
+ 18.3916667 0.483544
+ 18.3944444 0.479325
+ 18.3972222 0.470886
+ 18.4000000 0.466667
+ 18.4027778 0.462447
+ 18.4055556 0.464557
+ 18.4083333 0.454008
+ 18.4111111 0.437131
+ 18.4138889 0.424473
+ 18.4166667 0.418143
+ 18.4194444 0.413924
+ 18.4222222 0.418143
+ 18.4250000 0.430802
+ 18.4277778 0.443460
+ 18.4305556 0.451899
+ 18.4333333 0.458228
+ 18.4361111 0.458228
+ 18.4388889 0.456118
+ 18.4416667 0.458228
+ 18.4444444 0.456118
+ 18.4472222 0.456118
+ 18.4500000 0.447679
+ 18.4527778 0.447679
+ 18.4555556 0.447679
+ 18.4583333 0.454008
+ 18.4611111 0.464557
+ 18.4638889 0.470886
+ 18.4666667 0.470886
+ 18.4694444 0.472996
+ 18.4722222 0.470886
+ 18.4750000 0.468776
+ 18.4777778 0.460338
+ 18.4805556 0.464557
+ 18.4833333 0.454008
+ 18.4861111 0.451899
+ 18.4888889 0.445570
+ 18.4916667 0.449789
+ 18.4944444 0.454008
+ 18.4972222 0.466667
+ 18.5000000 0.472996
+ 18.5027778 0.475105
+ 18.5055556 0.475105
+ 18.5083333 0.472996
+ 18.5111111 0.462447
+ 18.5138889 0.460338
+ 18.5166667 0.451899
+ 18.5194444 0.454008
+ 18.5222222 0.458228
+ 18.5250000 0.468776
+ 18.5277778 0.477215
+ 18.5305556 0.479325
+ 18.5333333 0.479325
+ 18.5361111 0.470886
+ 18.5388889 0.466667
+ 18.5416667 0.462447
+ 18.5444444 0.464557
+ 18.5472222 0.468776
+ 18.5500000 0.470886
+ 18.5527778 0.479325
+ 18.5555556 0.483544
+ 18.5583333 0.479325
+ 18.5611111 0.472996
+ 18.5638889 0.460338
+ 18.5666667 0.451899
+ 18.5694444 0.454008
+ 18.5722222 0.460338
+ 18.5750000 0.472996
+ 18.5777778 0.485654
+ 18.5805556 0.489873
+ 18.5833333 0.477215
+ 18.5861111 0.464557
+ 18.5888889 0.443460
+ 18.5916667 0.439241
+ 18.5944444 0.437131
+ 18.5972222 0.443460
+ 18.6000000 0.451899
+ 18.6027778 0.460338
+ 18.6055556 0.468776
+ 18.6083333 0.470886
+ 18.6111111 0.468776
+ 18.6138889 0.468776
+ 18.6166667 0.456118
+ 18.6194444 0.454008
+ 18.6222222 0.454008
+ 18.6250000 0.458228
+ 18.6277778 0.464557
+ 18.6305556 0.475105
+ 18.6333333 0.477215
+ 18.6361111 0.479325
+ 18.6388889 0.481435
+ 18.6416667 0.481435
+ 18.6444444 0.481435
+ 18.6472222 0.477215
+ 18.6500000 0.466667
+ 18.6527778 0.454008
+ 18.6555556 0.462447
+ 18.6583333 0.485654
+ 18.6611111 0.521519
+ 18.6638889 0.561603
+ 18.6666667 0.603797
+ 18.6694444 0.624895
+ 18.6722222 0.635443
+ 18.6750000 0.616456
+ 18.6777778 0.576371
+ 18.6805556 0.513080
+ 18.6833333 0.447679
+ 18.6861111 0.397046
+ 18.6888889 0.361181
+ 18.6916667 0.350633
+ 18.6944444 0.352743
+ 18.6972222 0.371730
+ 18.7000000 0.380169
+ 18.7027778 0.392827
+ 18.7055556 0.403376
+ 18.7083333 0.409705
+ 18.7111111 0.407595
+ 18.7138889 0.405485
+ 18.7166667 0.401266
+ 18.7194444 0.388608
+ 18.7222222 0.371730
+ 18.7250000 0.365401
+ 18.7277778 0.361181
+ 18.7305556 0.365401
+ 18.7333333 0.369620
+ 18.7361111 0.378059
+ 18.7388889 0.382278
+ 18.7416667 0.384388
+ 18.7444444 0.384388
+ 18.7472222 0.394937
+ 18.7500000 0.394937
+ 18.7527778 0.390717
+ 18.7555556 0.388608
+ 18.7583333 0.399156
+ 18.7611111 0.407595
+ 18.7638889 0.424473
+ 18.7666667 0.437131
+ 18.7694444 0.454008
+ 18.7722222 0.472996
+ 18.7750000 0.494093
+ 18.7777778 0.500422
+ 18.7805556 0.504641
+ 18.7833333 0.491983
+ 18.7861111 0.475105
+ 18.7888889 0.460338
+ 18.7916667 0.454008
+ 18.7944444 0.447679
+ 18.7972222 0.449789
+ 18.8000000 0.458228
+ 18.8027778 0.475105
+ )

* === ARM SIGNAL (simulated rpeak_level_held) ===
Varm arm_signal 0 PWL(
+ 0 0
+ 2.0441222 0
+ 2.0442222 0.9
+ 2.1272222 0.9
+ 2.1273222 0
+ 2.7746778 0
+ 2.7747778 0.9
+ 2.8577778 0.9
+ 2.8578778 0
+ 4.6052333 0
+ 4.6053333 0.9
+ 4.6883333 0.9
+ 4.6884333 0
+ 5.2830111 0
+ 5.2831111 0.9
+ 5.3661111 0.9
+ 5.3662111 0
+ 5.9857889 0
+ 5.9858889 0.9
+ 6.0688889 0.9
+ 6.0689889 0
+ 7.8552333 0
+ 7.8553333 0.9
+ 7.9383333 0.9
+ 7.9384333 0
+ 8.5135667 0
+ 8.5136667 0.9
+ 8.5966667 0.9
+ 8.5967667 0
+ 10.1830111 0
+ 10.1831111 0.9
+ 10.2661111 0.9
+ 10.2662111 0
+ 10.8552333 0
+ 10.8553333 0.9
+ 10.9383333 0.9
+ 10.9384333 0
+ 12.5274556 0
+ 12.5275556 0.9
+ 12.6105556 0.9
+ 12.6106556 0
+ 13.1941222 0
+ 13.1942222 0.9
+ 13.2772222 0.9
+ 13.2773222 0
+ 14.8330111 0
+ 14.8331111 0.9
+ 14.9161111 0.9
+ 14.9162111 0
+ 15.5080111 0
+ 15.5081111 0.9
+ 15.5911111 0.9
+ 15.5912111 0
+ 16.2607889 0
+ 16.2608889 0.9
+ 16.3438889 0.9
+ 16.3439889 0
+ 18.0024556 0
+ 18.0025556 0.9
+ 18.0855556 0.9
+ 18.0856556 0
+ 19.3027778 0
+ )

* === DEVICE UNDER TEST ===
Xtpd ecg_in arm_signal peak_detected vdd vss vbias true_peak_detector
.ic V(xtpd.peak_hold)=0.50

* === MEASUREMENTS ===
.meas tran t_det_0 WHEN V(peak_detected)=0.45 RISE=1
.meas tran lat_0 PARAM='t_det_0 - 2.0472222'
.meas tran v_hold_0 FIND V(xtpd.peak_hold) AT=2.0472222
.meas tran v_ecg_0 FIND V(ecg_in) AT=2.0472222
.meas tran t_det_1 WHEN V(peak_detected)=0.45 RISE=2
.meas tran lat_1 PARAM='t_det_1 - 2.7777778'
.meas tran v_hold_1 FIND V(xtpd.peak_hold) AT=2.7777778
.meas tran v_ecg_1 FIND V(ecg_in) AT=2.7777778
.meas tran t_det_2 WHEN V(peak_detected)=0.45 RISE=3
.meas tran lat_2 PARAM='t_det_2 - 4.6083333'
.meas tran v_hold_2 FIND V(xtpd.peak_hold) AT=4.6083333
.meas tran v_ecg_2 FIND V(ecg_in) AT=4.6083333
.meas tran t_det_3 WHEN V(peak_detected)=0.45 RISE=4
.meas tran lat_3 PARAM='t_det_3 - 5.2861111'
.meas tran v_hold_3 FIND V(xtpd.peak_hold) AT=5.2861111
.meas tran v_ecg_3 FIND V(ecg_in) AT=5.2861111
.meas tran t_det_4 WHEN V(peak_detected)=0.45 RISE=5
.meas tran lat_4 PARAM='t_det_4 - 5.9888889'
.meas tran v_hold_4 FIND V(xtpd.peak_hold) AT=5.9888889
.meas tran v_ecg_4 FIND V(ecg_in) AT=5.9888889
.meas tran t_det_5 WHEN V(peak_detected)=0.45 RISE=6
.meas tran lat_5 PARAM='t_det_5 - 7.8583333'
.meas tran v_hold_5 FIND V(xtpd.peak_hold) AT=7.8583333
.meas tran v_ecg_5 FIND V(ecg_in) AT=7.8583333
.meas tran t_det_6 WHEN V(peak_detected)=0.45 RISE=7
.meas tran lat_6 PARAM='t_det_6 - 8.5166667'
.meas tran v_hold_6 FIND V(xtpd.peak_hold) AT=8.5166667
.meas tran v_ecg_6 FIND V(ecg_in) AT=8.5166667
.meas tran t_det_7 WHEN V(peak_detected)=0.45 RISE=8
.meas tran lat_7 PARAM='t_det_7 - 10.1861111'
.meas tran v_hold_7 FIND V(xtpd.peak_hold) AT=10.1861111
.meas tran v_ecg_7 FIND V(ecg_in) AT=10.1861111
.meas tran t_det_8 WHEN V(peak_detected)=0.45 RISE=9
.meas tran lat_8 PARAM='t_det_8 - 10.8583333'
.meas tran v_hold_8 FIND V(xtpd.peak_hold) AT=10.8583333
.meas tran v_ecg_8 FIND V(ecg_in) AT=10.8583333
.meas tran t_det_9 WHEN V(peak_detected)=0.45 RISE=10
.meas tran lat_9 PARAM='t_det_9 - 12.5305556'
.meas tran v_hold_9 FIND V(xtpd.peak_hold) AT=12.5305556
.meas tran v_ecg_9 FIND V(ecg_in) AT=12.5305556
.meas tran t_det_10 WHEN V(peak_detected)=0.45 RISE=11
.meas tran lat_10 PARAM='t_det_10 - 13.1972222'
.meas tran v_hold_10 FIND V(xtpd.peak_hold) AT=13.1972222
.meas tran v_ecg_10 FIND V(ecg_in) AT=13.1972222
.meas tran t_det_11 WHEN V(peak_detected)=0.45 RISE=12
.meas tran lat_11 PARAM='t_det_11 - 14.8361111'
.meas tran v_hold_11 FIND V(xtpd.peak_hold) AT=14.8361111
.meas tran v_ecg_11 FIND V(ecg_in) AT=14.8361111
.meas tran t_det_12 WHEN V(peak_detected)=0.45 RISE=13
.meas tran lat_12 PARAM='t_det_12 - 15.5111111'
.meas tran v_hold_12 FIND V(xtpd.peak_hold) AT=15.5111111
.meas tran v_ecg_12 FIND V(ecg_in) AT=15.5111111
.meas tran t_det_13 WHEN V(peak_detected)=0.45 RISE=14
.meas tran lat_13 PARAM='t_det_13 - 16.2638889'
.meas tran v_hold_13 FIND V(xtpd.peak_hold) AT=16.2638889
.meas tran v_ecg_13 FIND V(ecg_in) AT=16.2638889
.meas tran t_det_14 WHEN V(peak_detected)=0.45 RISE=15
.meas tran lat_14 PARAM='t_det_14 - 18.0055556'
.meas tran v_hold_14 FIND V(xtpd.peak_hold) AT=18.0055556
.meas tran v_ecg_14 FIND V(ecg_in) AT=18.0055556

.tran 10u 19.3028 UIC

.include "C:\Users\kadhi\OneDrive\Desktop\amux\verilogLearning\Leaky-Integrate-Fire---SNN-model-on-FPGA\experiments\frontend_optimization\complete_frontend/true_peak_detector.spice"
.include "C:\Users\kadhi\OneDrive\Desktop\amux\verilogLearning\Leaky-Integrate-Fire---SNN-model-on-FPGA\experiments\frontend_optimization\complete_frontend/bias_gen.spice"
.include "C:\Users\kadhi\OneDrive\Desktop\amux\verilogLearning\Leaky-Integrate-Fire---SNN-model-on-FPGA\experiments\frontend_optimization\complete_frontend/inverter.spice"

.control
run
print t_det_0 lat_0 v_hold_0 v_ecg_0
print t_det_1 lat_1 v_hold_1 v_ecg_1
print t_det_2 lat_2 v_hold_2 v_ecg_2
print t_det_3 lat_3 v_hold_3 v_ecg_3
print t_det_4 lat_4 v_hold_4 v_ecg_4
print t_det_5 lat_5 v_hold_5 v_ecg_5
print t_det_6 lat_6 v_hold_6 v_ecg_6
print t_det_7 lat_7 v_hold_7 v_ecg_7
print t_det_8 lat_8 v_hold_8 v_ecg_8
print t_det_9 lat_9 v_hold_9 v_ecg_9
print t_det_10 lat_10 v_hold_10 v_ecg_10
print t_det_11 lat_11 v_hold_11 v_ecg_11
print t_det_12 lat_12 v_hold_12 v_ecg_12
print t_det_13 lat_13 v_hold_13 v_ecg_13
print t_det_14 lat_14 v_hold_14 v_ecg_14
quit
.endc

.end
