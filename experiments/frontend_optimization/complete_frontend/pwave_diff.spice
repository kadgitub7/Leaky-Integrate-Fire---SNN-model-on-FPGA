* FEATURE 5: P-wave Signed Difference — Lead 0
*
* Proxy: ECG_L0@R-131ms - ECG_L0@R-206ms (signed, no abs)
* Two S&H capture ECG at baseline and P-wave peak, diff pair outputs difference.
* RF accuracy: 95.11% combined (only -0.37% from Python BPF reference)
*
* Triggers: sample_base_trig (R-206ms), sample_peak_trig (R-131ms)

.subckt pwave_diff ecg_in sample_base_trig sample_peak_trig pw_out vdd vss vbias

XMsb ecg_in sample_base_trig shb vss sky130_fd_pr__nfet_01v8 L=0.5 W=2 nf=1
XCsb shb vss sky130_fd_pr__cap_mim_m3_1 W=32 L=32

XMsp ecg_in sample_peak_trig shp vss sky130_fd_pr__nfet_01v8 L=0.5 W=2 nf=1
XCsp shp vss sky130_fd_pr__cap_mim_m3_1 W=32 L=32

XMd_tail dtail vbias vss vss sky130_fd_pr__nfet_01v8 L=8 W=0.42 nf=1
XMd1 dnet shb dtail vss sky130_fd_pr__nfet_01v8 L=1 W=8 nf=1
XMd2 pw_out shp dtail vss sky130_fd_pr__nfet_01v8 L=1 W=8 nf=1
XMd3 dnet dnet vdd vdd sky130_fd_pr__pfet_01v8 L=1 W=4 nf=1
XMd4 pw_out dnet vdd vdd sky130_fd_pr__pfet_01v8 L=1 W=4 nf=1

.ends pwave_diff
