* ============================================================
* POST-R-PEAK DELAY TIMER & TRIGGER GENERATOR
* ============================================================
*
* After R-peak detection, generates trigger pulses at specific
* delays for the feature extraction S&H circuits.
*
* Topology: Discharging cap + source follower + comparators
*   At R-peak, PMOS switch precharges timer cap to VDD.
*   Constant current (vbias-controlled NFET) discharges cap.
*   Source follower shifts timer voltage down by ~Vgs (~0.4V)
*   to the 0.1-0.5V range where NFET diff pair comparators
*   operate correctly at picoamp bias currents.
*   Comparators fire triggers when sf_timer drops below threshold.
*
* Timer equation: V_sf(t) ≈ (VDD-Vgs_sf) - I_discharge * t / C_timer
*   With I ≈ 63pA (measured), C = 100pF, Vgs_sf ≈ 0.40V:
*     sf(0ms)   ≈ 0.500V
*     sf(14ms)  ≈ 0.491V  → slope_14ms trigger
*     sf(28ms)  ≈ 0.482V  → width trigger
*     sf(69ms)  ≈ 0.456V  → slope_69ms trigger
*
*   External thresholds (vth_*) must be set to SF-shifted values.
*
* Pin: rpeak_pulse
*      trig_s14 trig_s69 trig_wid trig_bi_copy trig_rr_copy
*      vdd vss vbias_delay
*      vth_14 vth_69 vth_83 vth_300 vth_10
* ============================================================

.subckt delay_timer rpeak_pulse trig_s14 trig_s69 trig_wid trig_bi_copy trig_rr_copy vdd vss vbias_delay vth_14 vth_69 vth_83 vth_300 vth_10

* inverter_sub must be included by the top-level netlist

* Invert R-peak pulse for PMOS precharge switch
Xinv rpeak_pulse rpeak_bar vdd vss inverter_sub

* === MAIN DELAY TIMER ===
* PMOS precharge: charges timer_node to VDD at R-peak
XMcharge timer_node rpeak_bar vdd vdd sky130_fd_pr__pfet_01v8 L=0.5 W=2 nf=1
* NFET discharge: constant current
XMdischarge timer_node vbias_delay vss vss sky130_fd_pr__nfet_01v8 L=8 W=0.84 nf=1
* Timer cap: 100pF
XCtimer timer_node vss sky130_fd_pr__cap_mim_m3_1 W=224 L=224

* Source follower: shifts timer voltage down to 0.1-0.5V range
XMsf vdd timer_node sf_timer vss sky130_fd_pr__nfet_01v8 L=8 W=0.42 nf=1
XMsf_bias sf_timer vbias_delay vss vss sky130_fd_pr__nfet_01v8 L=8 W=0.42 nf=1

* === COMPARATORS ===
* Same topology as validated rr_timing diff pairs.
* NFET diff pair (L=4 W=2) + PMOS current mirror loads (L=4 W=2)
* Output goes HIGH when sf_timer drops below threshold.

* Comparator for S14 (14ms)
XMc1_1 cn1 vth_14 ct1 vss sky130_fd_pr__nfet_01v8 L=4 W=2 nf=1
XMc1_2 trig_s14 sf_timer ct1 vss sky130_fd_pr__nfet_01v8 L=4 W=2 nf=1
XMc1_3 cn1 cn1 vdd vdd sky130_fd_pr__pfet_01v8 L=4 W=2 nf=1
XMc1_4 trig_s14 cn1 vdd vdd sky130_fd_pr__pfet_01v8 L=4 W=2 nf=1
XMc1_5 ct1 vbias_delay vss vss sky130_fd_pr__nfet_01v8 L=8 W=0.42 nf=1

* Comparator for S69 (69ms)
XMc2_1 cn2 vth_69 ct2 vss sky130_fd_pr__nfet_01v8 L=4 W=2 nf=1
XMc2_2 trig_s69 sf_timer ct2 vss sky130_fd_pr__nfet_01v8 L=4 W=2 nf=1
XMc2_3 cn2 cn2 vdd vdd sky130_fd_pr__pfet_01v8 L=4 W=2 nf=1
XMc2_4 trig_s69 cn2 vdd vdd sky130_fd_pr__pfet_01v8 L=4 W=2 nf=1
XMc2_5 ct2 vbias_delay vss vss sky130_fd_pr__nfet_01v8 L=8 W=0.42 nf=1

* Comparator for width (28ms)
XMc3_1 cn3 vth_83 ct3 vss sky130_fd_pr__nfet_01v8 L=4 W=2 nf=1
XMc3_2 trig_wid sf_timer ct3 vss sky130_fd_pr__nfet_01v8 L=4 W=2 nf=1
XMc3_3 cn3 cn3 vdd vdd sky130_fd_pr__pfet_01v8 L=4 W=2 nf=1
XMc3_4 trig_wid cn3 vdd vdd sky130_fd_pr__pfet_01v8 L=4 W=2 nf=1
XMc3_5 ct3 vbias_delay vss vss sky130_fd_pr__nfet_01v8 L=8 W=0.42 nf=1

* Comparator for bi_copy (300ms)
XMc4_1 cn4 vth_300 ct4 vss sky130_fd_pr__nfet_01v8 L=4 W=2 nf=1
XMc4_2 trig_bi_copy sf_timer ct4 vss sky130_fd_pr__nfet_01v8 L=4 W=2 nf=1
XMc4_3 cn4 cn4 vdd vdd sky130_fd_pr__pfet_01v8 L=4 W=2 nf=1
XMc4_4 trig_bi_copy cn4 vdd vdd sky130_fd_pr__pfet_01v8 L=4 W=2 nf=1
XMc4_5 ct4 vbias_delay vss vss sky130_fd_pr__nfet_01v8 L=8 W=0.42 nf=1

* === FAST DELAY FOR RR COPY (10ms) ===
* Separate small cap with faster discharge
XMch2 timer2 rpeak_bar vdd vdd sky130_fd_pr__pfet_01v8 L=0.5 W=2 nf=1
XMdis2 timer2 vbias_delay vss vss sky130_fd_pr__nfet_01v8 L=8 W=0.84 nf=1
XCt2 timer2 vss sky130_fd_pr__cap_mim_m3_1 W=32 L=32

* Source follower for fast timer
XMsf2 vdd timer2 sf_timer2 vss sky130_fd_pr__nfet_01v8 L=8 W=0.42 nf=1
XMsf2_bias sf_timer2 vbias_delay vss vss sky130_fd_pr__nfet_01v8 L=8 W=0.42 nf=1

* Comparator for rr_copy (10ms)
XMc5_1 cn5 vth_10 ct5 vss sky130_fd_pr__nfet_01v8 L=4 W=2 nf=1
XMc5_2 trig_rr_copy sf_timer2 ct5 vss sky130_fd_pr__nfet_01v8 L=4 W=2 nf=1
XMc5_3 cn5 cn5 vdd vdd sky130_fd_pr__pfet_01v8 L=4 W=2 nf=1
XMc5_4 trig_rr_copy cn5 vdd vdd sky130_fd_pr__pfet_01v8 L=4 W=2 nf=1
XMc5_5 ct5 vbias_delay vss vss sky130_fd_pr__nfet_01v8 L=8 W=0.42 nf=1

.ends delay_timer
