* ============================================================
* POST-R-PEAK DELAY TIMER & TRIGGER GENERATOR
* ============================================================
*
* After R-peak detection, generates trigger pulses at specific
* delays for the feature extraction S&H circuits.
*
* Topology: Discharging cap + comparators
*   At R-peak, PMOS switch precharges timer cap to VDD.
*   Constant current (vbias-controlled NFET) discharges cap.
*   Comparators at different threshold voltages fire triggers
*   at the corresponding delays.
*
* Timer equation: V(t) = VDD - I_discharge * t / C_timer
*   With I ≈ 300pA, C = 100pF:
*     V(14ms)  = 0.858V   → slope_14ms trigger
*     V(28ms)  = 0.816V   → width trigger (validated at R+28ms)
*     V(69ms)  = 0.693V   → slope_69ms trigger
*     V(300ms) = 0.000V   → bi_copy trigger
*
* For RR copy (10ms): uses a separate small RC delay.
*
* The R-peak pulse itself directly triggers:
*   - QRS symmetry S&H (at R)
*   - Beat instability capture S&H (at R)
*
* Pin: rpeak_pulse
*      trig_s14 trig_s69 trig_wid trig_bi_copy trig_rr_copy
*      vdd vss vbias_delay
* ============================================================

.subckt delay_timer rpeak_pulse trig_s14 trig_s69 trig_wid trig_bi_copy trig_rr_copy vdd vss vbias_delay vth_14 vth_69 vth_83 vth_300 vth_10

* inverter_sub must be included by the testbench before this file

* Invert R-peak pulse for PMOS precharge switch
Xinv rpeak_pulse rpeak_bar vdd vss inverter_sub

* === MAIN DELAY TIMER ===
* PMOS precharge: charges timer_node to VDD at R-peak
XMcharge timer_node rpeak_bar vdd vdd sky130_fd_pr__pfet_01v8 L=0.5 W=2 nf=1
* NFET discharge: constant current ~300pA
XMdischarge timer_node vbias_delay vss vss sky130_fd_pr__nfet_01v8 L=8 W=0.84 nf=1
* Timer cap: 100pF
XCtimer timer_node vss sky130_fd_pr__cap_mim_m3_1 W=224 L=224

* === COMPARATORS (detect threshold crossings) ===
* Each comparator outputs HIGH when timer drops below its threshold.
* Threshold voltages generated by resistor divider or set externally.

* Threshold for 14ms delay: V_th ≈ 0.86V
* Using a PMOS diode string or cap divider for reference:
* (For simplicity, use fixed bias voltages in testbench)

* Comparator for S14 (14ms): timer < V_th_14ms
XMc1_1 cn1 vth_14 ct1 vss sky130_fd_pr__nfet_01v8 L=2 W=4 nf=1
XMc1_2 trig_s14 timer_node ct1 vss sky130_fd_pr__nfet_01v8 L=2 W=4 nf=1
XMc1_3 cn1 cn1 vdd vdd sky130_fd_pr__pfet_01v8 L=2 W=4 nf=1
XMc1_4 trig_s14 cn1 vdd vdd sky130_fd_pr__pfet_01v8 L=2 W=4 nf=1
XMc1_5 ct1 vbias_delay vss vss sky130_fd_pr__nfet_01v8 L=8 W=0.42 nf=1

* Comparator for S69 (69ms): timer < V_th_69ms
XMc2_1 cn2 vth_69 ct2 vss sky130_fd_pr__nfet_01v8 L=2 W=4 nf=1
XMc2_2 trig_s69 timer_node ct2 vss sky130_fd_pr__nfet_01v8 L=2 W=4 nf=1
XMc2_3 cn2 cn2 vdd vdd sky130_fd_pr__pfet_01v8 L=2 W=4 nf=1
XMc2_4 trig_s69 cn2 vdd vdd sky130_fd_pr__pfet_01v8 L=2 W=4 nf=1
XMc2_5 ct2 vbias_delay vss vss sky130_fd_pr__nfet_01v8 L=8 W=0.42 nf=1

* Comparator for width (83ms): timer < V_th_83ms
XMc3_1 cn3 vth_83 ct3 vss sky130_fd_pr__nfet_01v8 L=2 W=4 nf=1
XMc3_2 trig_wid timer_node ct3 vss sky130_fd_pr__nfet_01v8 L=2 W=4 nf=1
XMc3_3 cn3 cn3 vdd vdd sky130_fd_pr__pfet_01v8 L=2 W=4 nf=1
XMc3_4 trig_wid cn3 vdd vdd sky130_fd_pr__pfet_01v8 L=2 W=4 nf=1
XMc3_5 ct3 vbias_delay vss vss sky130_fd_pr__nfet_01v8 L=8 W=0.42 nf=1

* Comparator for bi_copy (300ms): timer < V_th_300ms
XMc4_1 cn4 vth_300 ct4 vss sky130_fd_pr__nfet_01v8 L=2 W=4 nf=1
XMc4_2 trig_bi_copy timer_node ct4 vss sky130_fd_pr__nfet_01v8 L=2 W=4 nf=1
XMc4_3 cn4 cn4 vdd vdd sky130_fd_pr__pfet_01v8 L=2 W=4 nf=1
XMc4_4 trig_bi_copy cn4 vdd vdd sky130_fd_pr__pfet_01v8 L=2 W=4 nf=1
XMc4_5 ct4 vbias_delay vss vss sky130_fd_pr__nfet_01v8 L=8 W=0.42 nf=1

* === FAST DELAY FOR RR COPY (10ms) ===
* Separate small cap with faster discharge
XMch2 timer2 rpeak_bar vdd vdd sky130_fd_pr__pfet_01v8 L=0.5 W=2 nf=1
XMdis2 timer2 vbias_delay vss vss sky130_fd_pr__nfet_01v8 L=8 W=0.84 nf=1
XCt2 timer2 vss sky130_fd_pr__cap_mim_m3_1 W=32 L=32

* Comparator for rr_copy (10ms)
XMc5_1 cn5 vth_10 ct5 vss sky130_fd_pr__nfet_01v8 L=2 W=4 nf=1
XMc5_2 trig_rr_copy timer2 ct5 vss sky130_fd_pr__nfet_01v8 L=2 W=4 nf=1
XMc5_3 cn5 cn5 vdd vdd sky130_fd_pr__pfet_01v8 L=2 W=4 nf=1
XMc5_4 trig_rr_copy cn5 vdd vdd sky130_fd_pr__pfet_01v8 L=2 W=4 nf=1
XMc5_5 ct5 vbias_delay vss vss sky130_fd_pr__nfet_01v8 L=8 W=0.42 nf=1

* Threshold voltage nodes (set externally via resistor divider or bias):
*   vth_14  ≈ 0.858V
*   vth_69  ≈ 0.693V
*   vth_83  ≈ 0.651V
*   vth_300 ≈ 0.010V
*   vth_10  ≈ adjusted for smaller timer2 cap

.ends delay_timer
