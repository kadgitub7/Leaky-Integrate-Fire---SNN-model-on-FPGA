* ============================================================
* POST-R-PEAK DELAY TIMER & TRIGGER GENERATOR
* ============================================================
*
* After R-peak detection, generates trigger pulses at specific
* delays for the feature extraction S&H circuits.
*
* Topology: Discharging cap + source follower + comparators
*   At R-peak, PMOS switch precharges timer cap to VDD.
*   Constant current (vbias-controlled NFET) discharges cap.
*   Source follower shifts timer voltage down by ~Vgs (~0.4V)
*   to the 0.1-0.5V range where NFET diff pair comparators
*   operate correctly at picoamp bias currents.
*   Comparators fire triggers when sf_timer drops below threshold.
*
* Timer equation: V_sf(t) ≈ (VDD-Vgs_sf) - I_discharge * t / C_timer
*   With I ≈ 63pA (measured), C = 100pF, Vgs_sf ≈ 0.40V:
*     sf(0ms)   ≈ 0.500V
*     sf(14ms)  ≈ 0.491V  → slope_14ms trigger
*     sf(28ms)  ≈ 0.482V  → width trigger
*     sf(69ms)  ≈ 0.456V  → slope_69ms trigger
*
*   External thresholds (vth_*) must be set to SF-shifted values.
*
* Pin: rpeak_pulse
*      trig_s14 trig_s69 trig_wid trig_bi_copy trig_rr_copy
*      sf_out
*      vdd vss vbias_delay
*      vth_14_fast vth_69 vth_83 vth_300 vth_10
*
* Note: s14 uses the FAST timer (2pF) for accurate short-delay timing.
*   Main timer (100pF, 0.42mV/ms) gives <0.5mV differential at 5ms →
*   comparator resolves in ~7ms = unacceptable for 14ms target.
*   Fast timer (2pF, ~21mV/ms) gives ~80mV differential → <1ms resolve.
*   sf_out exposes main timer SF for pwave prediction comparators.
* ============================================================

.subckt delay_timer rpeak_pulse trig_s14 trig_s69 trig_wid trig_bi_copy trig_rr_copy trig_rpk_delayed sf_out vdd vss vbias_delay vth_14_fast vth_69 vth_83 vth_300 vth_10 vth_rpk_del

* Expose main timer SF for external pwave prediction comparators
R_sf_out sf_timer sf_out 0

* inverter_sub must be included by the top-level netlist

* Invert R-peak pulse for PMOS precharge switch
Xinv rpeak_pulse rpeak_bar vdd vss inverter_sub

* === MAIN DELAY TIMER ===
* PMOS precharge: charges timer_node to VDD at R-peak
XMcharge timer_node rpeak_bar vdd vdd sky130_fd_pr__pfet_01v8 L=0.5 W=2 nf=1
* NFET discharge: constant current
XMdischarge timer_node vbias_delay vss vss sky130_fd_pr__nfet_01v8 L=8 W=0.84 nf=1
* Timer cap: 100pF
XCtimer timer_node vss sky130_fd_pr__cap_mim_m3_1 W=224 L=224

* Source follower: shifts timer voltage down to 0.1-0.5V range
XMsf vdd timer_node sf_timer vss sky130_fd_pr__nfet_01v8 L=8 W=0.42 nf=1
XMsf_bias sf_timer vbias_delay vss vss sky130_fd_pr__nfet_01v8 L=8 W=0.42 nf=1

* === COMPARATORS ===
* Same topology as validated rr_timing diff pairs.
* NFET diff pair (L=4 W=2) + PMOS current mirror loads (L=4 W=2)
* Output goes HIGH when sf_timer drops below threshold.

* S14 comparator moved to fast timer — see below

* Two-stage comparator for S69 (69ms) — diff pair + inverter for rail-to-rail
* Inputs swapped so inverter output goes HIGH when sf < threshold
XMc2_1 cn2 sf_timer ct2 vss sky130_fd_pr__nfet_01v8 L=4 W=2 nf=1
XMc2_2 stg1_s69 vth_69 ct2 vss sky130_fd_pr__nfet_01v8 L=4 W=2 nf=1
XMc2_3 cn2 cn2 vdd vdd sky130_fd_pr__pfet_01v8 L=4 W=2 nf=1
XMc2_4 stg1_s69 cn2 vdd vdd sky130_fd_pr__pfet_01v8 L=4 W=2 nf=1
XMc2_5 ct2 vbias_delay vss vss sky130_fd_pr__nfet_01v8 L=8 W=0.42 nf=1
XMc2_6 trig_s69 stg1_s69 vdd vdd sky130_fd_pr__pfet_01v8 L=0.5 W=8 nf=1
XMc2_7 trig_s69 stg1_s69 vss vss sky130_fd_pr__nfet_01v8 L=0.5 W=4 nf=1

* Two-stage comparator for width (28ms)
XMc3_1 cn3 sf_timer ct3 vss sky130_fd_pr__nfet_01v8 L=4 W=2 nf=1
XMc3_2 stg1_wid vth_83 ct3 vss sky130_fd_pr__nfet_01v8 L=4 W=2 nf=1
XMc3_3 cn3 cn3 vdd vdd sky130_fd_pr__pfet_01v8 L=4 W=2 nf=1
XMc3_4 stg1_wid cn3 vdd vdd sky130_fd_pr__pfet_01v8 L=4 W=2 nf=1
XMc3_5 ct3 vbias_delay vss vss sky130_fd_pr__nfet_01v8 L=8 W=0.42 nf=1
XMc3_6 trig_wid stg1_wid vdd vdd sky130_fd_pr__pfet_01v8 L=0.5 W=8 nf=1
XMc3_7 trig_wid stg1_wid vss vss sky130_fd_pr__nfet_01v8 L=0.5 W=4 nf=1

* Two-stage comparator for bi_copy (300ms)
XMc4_1 cn4 sf_timer ct4 vss sky130_fd_pr__nfet_01v8 L=4 W=2 nf=1
XMc4_2 stg1_bi vth_300 ct4 vss sky130_fd_pr__nfet_01v8 L=4 W=2 nf=1
XMc4_3 cn4 cn4 vdd vdd sky130_fd_pr__pfet_01v8 L=4 W=2 nf=1
XMc4_4 stg1_bi cn4 vdd vdd sky130_fd_pr__pfet_01v8 L=4 W=2 nf=1
XMc4_5 ct4 vbias_delay vss vss sky130_fd_pr__nfet_01v8 L=8 W=0.42 nf=1
XMc4_6 trig_bi_copy stg1_bi vdd vdd sky130_fd_pr__pfet_01v8 L=0.5 W=8 nf=1
XMc4_7 trig_bi_copy stg1_bi vss vss sky130_fd_pr__nfet_01v8 L=0.5 W=4 nf=1

* === FAST DELAY FOR RR COPY (10ms) ===
* Separate small cap with faster discharge
XMch2 timer2 rpeak_bar vdd vdd sky130_fd_pr__pfet_01v8 L=0.5 W=2 nf=1
XMdis2 timer2 vbias_delay vss vss sky130_fd_pr__nfet_01v8 L=8 W=0.84 nf=1
XCt2 timer2 vss sky130_fd_pr__cap_mim_m3_1 W=45 L=45

* Source follower for fast timer
XMsf2 vdd timer2 sf_timer2 vss sky130_fd_pr__nfet_01v8 L=8 W=0.42 nf=1
XMsf2_bias sf_timer2 vbias_delay vss vss sky130_fd_pr__nfet_01v8 L=8 W=0.42 nf=1

* Two-stage comparator for rr_copy (10ms) on fast timer
* Inputs: sf_timer2 on mirror-diode side, vth_10 on output side
* First stage goes LOW when sf_timer2 < vth_10, inverter makes trig_rr_copy HIGH
XMc5_1 cn5 sf_timer2 ct5 vss sky130_fd_pr__nfet_01v8 L=4 W=2 nf=1
XMc5_2 stg1_rr vth_10 ct5 vss sky130_fd_pr__nfet_01v8 L=4 W=2 nf=1
XMc5_3 cn5 cn5 vdd vdd sky130_fd_pr__pfet_01v8 L=4 W=2 nf=1
XMc5_4 stg1_rr cn5 vdd vdd sky130_fd_pr__pfet_01v8 L=4 W=2 nf=1
XMc5_5 ct5 vbias_delay vss vss sky130_fd_pr__nfet_01v8 L=8 W=0.42 nf=1
XMc5_6 trig_rr_copy stg1_rr vdd vdd sky130_fd_pr__pfet_01v8 L=0.5 W=8 nf=1
XMc5_7 trig_rr_copy stg1_rr vss vss sky130_fd_pr__nfet_01v8 L=0.5 W=4 nf=1

* Two-stage comparator for S14 (14ms) on fast timer
* Inputs: sf_timer2 on mirror-diode side, vth_14_fast on output side
* First stage goes LOW when sf_timer2 < vth_14_fast, inverter makes trig_s14 HIGH
XMc6_1 cn6 sf_timer2 ct6 vss sky130_fd_pr__nfet_01v8 L=4 W=2 nf=1
XMc6_2 stg1_s14 vth_14_fast ct6 vss sky130_fd_pr__nfet_01v8 L=4 W=2 nf=1
XMc6_3 cn6 cn6 vdd vdd sky130_fd_pr__pfet_01v8 L=4 W=2 nf=1
XMc6_4 stg1_s14 cn6 vdd vdd sky130_fd_pr__pfet_01v8 L=4 W=2 nf=1
XMc6_5 ct6 vbias_delay vss vss sky130_fd_pr__nfet_01v8 L=8 W=0.42 nf=1
XMc6_6 trig_s14 stg1_s14 vdd vdd sky130_fd_pr__pfet_01v8 L=0.5 W=8 nf=1
XMc6_7 trig_s14 stg1_s14 vss vss sky130_fd_pr__nfet_01v8 L=0.5 W=4 nf=1

* Two-stage comparator for delayed rpeak (~7ms) on fast timer
* Fires ~6.6ms after rpeak_pulse so S&H captures near true R-peak
* instead of on the QRS upslope where inter-beat variation is minimal.
XMc7_1 cn7 sf_timer2 ct7 vss sky130_fd_pr__nfet_01v8 L=4 W=2 nf=1
XMc7_2 stg1_rpk vth_rpk_del ct7 vss sky130_fd_pr__nfet_01v8 L=4 W=2 nf=1
XMc7_3 cn7 cn7 vdd vdd sky130_fd_pr__pfet_01v8 L=4 W=2 nf=1
XMc7_4 stg1_rpk cn7 vdd vdd sky130_fd_pr__pfet_01v8 L=4 W=2 nf=1
XMc7_5 ct7 vbias_delay vss vss sky130_fd_pr__nfet_01v8 L=8 W=0.42 nf=1
XMc7_6 trig_rpk_delayed stg1_rpk vdd vdd sky130_fd_pr__pfet_01v8 L=0.5 W=8 nf=1
XMc7_7 trig_rpk_delayed stg1_rpk vss vss sky130_fd_pr__nfet_01v8 L=0.5 W=4 nf=1

.ends delay_timer
