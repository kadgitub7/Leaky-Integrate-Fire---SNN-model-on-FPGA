.title config_C_hold_copy
.lib "C:/Users/kadhi/OneDrive/Desktop/amux/verilogLearning/Leaky-Integrate-Fire---SNN-model-on-FPGA/experiments/frontend_optimization/ngspice_frontend/sky130_minimal.lib.spice" tt
.option scale=1.0u method=gear reltol=0.01 gmin=1e-15
.temp 27
Vdd vdd 0 0.9
Vss vss 0 0
Vecg0 ecg_l0 0 PWL(0.0000000 0.300000 0.5608889 0.300000 0.5638889 0.282026 0.5666667 0.281731 0.5694444 0.282320 0.5722222 0.282026 0.5750000 0.282910 0.5777778 0.282320 0.5805556 0.282320 0.5833333 0.282026 0.5861111 0.282026 0.5888889 0.282910 0.5916667 0.283499 0.5944444 0.282615 0.5972222 0.282026 0.6000000 0.281436 0.6027778 0.282026 0.6055556 0.282615 0.6083333 0.282910 0.6111111 0.283499 0.6138889 0.284088 0.6166667 0.283794 0.6194444 0.283794 0.6222222 0.284088 0.6250000 0.285267 0.6277778 0.285267 0.6305556 0.284972 0.6333333 0.286740 0.6361111 0.287035 0.6388889 0.287919 0.6416667 0.288214 0.6444444 0.287919 0.6472222 0.287330 0.6500000 0.286446 0.6527778 0.287035 0.6555556 0.286740 0.6583333 0.286740 0.6611111 0.286740 0.6638889 0.286446 0.6666667 0.286151 0.6694444 0.285856 0.6722222 0.286151 0.6750000 0.287035 0.6777778 0.287624 0.6805556 0.287919 0.6833333 0.285562 0.6861111 0.283204 0.6888889 0.283204 0.6916667 0.282320 0.6944444 0.281731 0.6972222 0.280552 0.7000000 0.280552 0.7027778 0.280847 0.7055556 0.281436 0.7083333 0.281142 0.7111111 0.281436 0.7138889 0.280847 0.7166667 0.279963 0.7194444 0.279669 0.7222222 0.279963 0.7250000 0.279963 0.7277778 0.279374 0.7305556 0.279669 0.7333333 0.279079 0.7361111 0.280552 0.7388889 0.280258 0.7416667 0.280552 0.7444444 0.281142 0.7472222 0.279669 0.7500000 0.279079 0.7527778 0.279963 0.7555556 0.280552 0.7583333 0.280847 0.7611111 0.280552 0.7638889 0.279374 0.7666667 0.278490 0.7694444 0.278785 0.7722222 0.277606 0.7750000 0.274954 0.7777778 0.273775 0.7805556 0.272007 0.7833333 0.269945 0.7861111 0.268471 0.7888889 0.270239 0.7916667 0.275543 0.7944444 0.282320 0.7972222 0.290571 0.8000000 0.299116 0.8027778 0.313849 0.8055556 0.328877 0.8083333 0.342431 0.8111111 0.351565 0.8138889 0.355396 0.8166667 0.353333 0.8194444 0.344494 0.8222222 0.328877 0.8250000 0.309724 0.8277778 0.293517 0.8305556 0.284088 0.8333333 0.277017 0.8361111 0.273481 0.8388889 0.272007 0.8416667 0.273186 0.8444444 0.274954 0.8472222 0.277017 0.8500000 0.277017 0.8527778 0.277311 0.8555556 0.277017 0.8583333 0.277606 0.8611111 0.277606 0.8638889 0.277606 0.8666667 0.276722 0.8694444 0.277311 0.8722222 0.277311 0.8750000 0.277311 0.8777778 0.277901 0.8805556 0.276722 0.8833333 0.275838 0.8861111 0.275838 0.8888889 0.276427 0.8916667 0.276722 0.8944444 0.277017 0.8972222 0.276133 0.9000000 0.276722 0.9027778 0.277311 0.9055556 0.277901 0.9083333 0.277017 0.9111111 0.277017 0.9138889 0.276133 0.9166667 0.275838 0.9194444 0.275838 0.9222222 0.277017 0.9250000 0.277017 0.9277778 0.276722 0.9305556 0.276133 0.9333333 0.275543 0.9361111 0.276427 0.9388889 0.275838 0.9416667 0.276133 0.9444444 0.275838 0.9472222 0.275543 0.9500000 0.275838 0.9527778 0.276427 0.9555556 0.276427 0.9583333 0.276722 0.9611111 0.277017 0.9638889 0.276133 0.9666667 0.275838 0.9694444 0.277017 0.9722222 0.277017 0.9750000 0.277311 0.9777778 0.277311 0.9805556 0.275838 0.9833333 0.276133 0.9861111 0.276722 0.9888889 0.277017 0.9916667 0.277901 0.9944444 0.277017 0.9972222 0.276722 1.0000000 0.275838 1.0027778 0.276427 1.0055556 0.277017 1.0083333 0.277017 1.0111111 0.277311 1.0138889 0.276133 1.0166667 0.275543 1.0194444 0.275543 1.0222222 0.276427 1.0250000 0.276722 1.0277778 0.276133 1.0305556 0.275543 1.0333333 0.275249 1.0361111 0.275249 1.0388889 0.275838 1.0416667 0.275543 1.0444444 0.274954 1.0472222 0.275249 1.0500000 0.274365 1.0527778 0.274659 1.0555556 0.274659 1.0583333 0.275249 1.0611111 0.274659 1.0638889 0.273481 1.0666667 0.273186 1.0694444 0.273481 1.0722222 0.274365 1.0750000 0.273775 1.0777778 0.273481 1.0805556 0.273186 1.0833333 0.272302 1.0861111 0.272891 1.0888889 0.273186 1.0916667 0.273481 1.0944444 0.273186 1.0972222 0.272302 1.1000000 0.272007 1.1027778 0.272891 1.1055556 0.273481 1.1083333 0.273775 1.1111111 0.274070 1.1168889 0.300000 1.3720000 0.300000 1.3750000 0.280552 1.3777778 0.279669 1.3805556 0.279669 1.3833333 0.279079 1.3861111 0.279374 1.3888889 0.279963 1.3916667 0.280552 1.3944444 0.279963 1.3972222 0.279963 1.4000000 0.279963 1.4027778 0.280552 1.4055556 0.280258 1.4083333 0.280552 1.4111111 0.280258 1.4138889 0.279669 1.4166667 0.279669 1.4194444 0.279963 1.4222222 0.280552 1.4250000 0.281436 1.4277778 0.282615 1.4305556 0.282320 1.4333333 0.282615 1.4361111 0.283204 1.4388889 0.283794 1.4416667 0.284383 1.4444444 0.284383 1.4472222 0.284383 1.4500000 0.284972 1.4527778 0.285267 1.4555556 0.285856 1.4583333 0.286740 1.4611111 0.287330 1.4638889 0.285856 1.4666667 0.285562 1.4694444 0.285856 1.4722222 0.285562 1.4750000 0.286151 1.4777778 0.285562 1.4805556 0.285267 1.4833333 0.283794 1.4861111 0.283794 1.4888889 0.284383 1.4916667 0.285267 1.4944444 0.286740 1.4972222 0.287035 1.5000000 0.286446 1.5027778 0.284383 1.5055556 0.284088 1.5083333 0.283499 1.5111111 0.283204 1.5138889 0.282026 1.5166667 0.281142 1.5194444 0.279963 1.5222222 0.280552 1.5250000 0.280258 1.5277778 0.280258 1.5305556 0.279079 1.5333333 0.278195 1.5361111 0.278785 1.5388889 0.279669 1.5416667 0.279374 1.5444444 0.279079 1.5472222 0.278490 1.5500000 0.277901 1.5527778 0.277606 1.5555556 0.278195 1.5583333 0.278490 1.5611111 0.278490 1.5638889 0.277606 1.5666667 0.277311 1.5694444 0.277606 1.5722222 0.277901 1.5750000 0.279079 1.5777778 0.278195 1.5805556 0.277017 1.5833333 0.276133 1.5861111 0.275838 1.5888889 0.274365 1.5916667 0.272597 1.5944444 0.271123 1.5972222 0.269355 1.6000000 0.267293 1.6027778 0.266409 1.6055556 0.269061 1.6083333 0.276133 1.6111111 0.285267 1.6138889 0.294696 1.6166667 0.307072 1.6194444 0.324162 1.6222222 0.340663 1.6250000 0.352155 1.6277778 0.356575 1.6305556 0.350092 1.6333333 0.330645 1.6361111 0.302947 1.6388889 0.281142 1.6416667 0.270534 1.6444444 0.270239 1.6472222 0.273775 1.6500000 0.275543 1.6527778 0.276722 1.6555556 0.277017 1.6583333 0.276722 1.6611111 0.277017 1.6638889 0.276722 1.6666667 0.276133 1.6694444 0.276722 1.6722222 0.276133 1.6750000 0.277017 1.6777778 0.276722 1.6805556 0.276722 1.6833333 0.275838 1.6861111 0.276133 1.6888889 0.276427 1.6916667 0.276427 1.6944444 0.275543 1.6972222 0.276133 1.7000000 0.275249 1.7027778 0.275543 1.7055556 0.276133 1.7083333 0.276133 1.7111111 0.275249 1.7138889 0.275249 1.7166667 0.274365 1.7194444 0.275249 1.7222222 0.275838 1.7250000 0.275838 1.7277778 0.276133 1.7305556 0.274954 1.7333333 0.274659 1.7361111 0.275249 1.7388889 0.275543 1.7416667 0.275838 1.7444444 0.275838 1.7472222 0.274954 1.7500000 0.275249 1.7527778 0.276427 1.7555556 0.276722 1.7583333 0.276427 1.7611111 0.276427 1.7638889 0.276722 1.7666667 0.275543 1.7694444 0.276133 1.7722222 0.277017 1.7750000 0.276427 1.7777778 0.276427 1.7805556 0.275543 1.7833333 0.274954 1.7861111 0.274954 1.7888889 0.275543 1.7916667 0.275543 1.7944444 0.275838 1.7972222 0.274954 1.8000000 0.274954 1.8027778 0.275249 1.8055556 0.275543 1.8083333 0.276427 1.8111111 0.276427 1.8138889 0.275838 1.8166667 0.274954 1.8194444 0.275838 1.8222222 0.276133 1.8250000 0.276722 1.8277778 0.276427 1.8305556 0.276427 1.8333333 0.276133 1.8361111 0.277311 1.8388889 0.276427 1.8416667 0.277017 1.8444444 0.277017 1.8472222 0.276427 1.8500000 0.275543 1.8527778 0.276133 1.8555556 0.276133 1.8583333 0.275838 1.8611111 0.275543 1.8638889 0.275249 1.8666667 0.275249 1.8694444 0.274954 1.8722222 0.275543 1.8750000 0.275543 1.8777778 0.275838 1.8805556 0.274365 1.8833333 0.274659 1.8861111 0.274365 1.8888889 0.275249 1.8916667 0.275249 1.8944444 0.275249 1.8972222 0.275249 1.9000000 0.274954 1.9027778 0.274954 1.9055556 0.275543 1.9083333 0.276722 1.9111111 0.276722 1.9138889 0.277017 1.9166667 0.277901 1.9194444 0.278785 1.9222222 0.279963 1.9280000 0.300000 2.1608889 0.300000 2.1638889 0.277901 2.1666667 0.277311 2.1694444 0.279079 2.1722222 0.278785 2.1750000 0.279079 2.1777778 0.278785 2.1805556 0.278785 2.1833333 0.278195 2.1861111 0.278785 2.1888889 0.279669 2.1916667 0.279079 2.1944444 0.279669 2.1972222 0.279669 2.2000000 0.279669 2.2027778 0.279963 2.2055556 0.281731 2.2083333 0.282026 2.2111111 0.282026 2.2138889 0.281731 2.2166667 0.282026 2.2194444 0.282910 2.2222222 0.283204 2.2250000 0.283794 2.2277778 0.283499 2.2305556 0.283499 2.2333333 0.283794 2.2361111 0.284383 2.2388889 0.284972 2.2416667 0.285562 2.2444444 0.284678 2.2472222 0.284383 2.2500000 0.283794 2.2527778 0.283499 2.2555556 0.284383 2.2583333 0.284088 2.2611111 0.283794 2.2638889 0.283499 2.2666667 0.283794 2.2694444 0.283499 2.2722222 0.283794 2.2750000 0.284383 2.2777778 0.284972 2.2805556 0.285856 2.2833333 0.284678 2.2861111 0.283499 2.2888889 0.281731 2.2916667 0.281731 2.2944444 0.279669 2.2972222 0.278785 2.3000000 0.277606 2.3027778 0.277311 2.3055556 0.277606 2.3083333 0.278195 2.3111111 0.277901 2.3138889 0.277311 2.3166667 0.277017 2.3194444 0.276722 2.3222222 0.277311 2.3250000 0.277311 2.3277778 0.277311 2.3305556 0.276722 2.3333333 0.276133 2.3361111 0.276427 2.3388889 0.277901 2.3416667 0.277901 2.3444444 0.277017 2.3472222 0.276722 2.3500000 0.275543 2.3527778 0.276133 2.3555556 0.276427 2.3583333 0.277017 2.3611111 0.276133 2.3638889 0.274954 2.3666667 0.272891 2.3694444 0.272007 2.3722222 0.270239 2.3750000 0.269945 2.3777778 0.269061 2.3805556 0.268177 2.3833333 0.264641 2.3861111 0.261989 2.3888889 0.262873 2.3916667 0.266114 2.3944444 0.270829 2.3972222 0.277311 2.4000000 0.284088 2.4027778 0.293223 2.4055556 0.305304 2.4083333 0.321805 2.4111111 0.337422 2.4138889 0.347735 2.4166667 0.350681 2.4194444 0.345378 2.4222222 0.327993 2.4250000 0.303831 2.4277778 0.282026 2.4305556 0.270534 2.4333333 0.269355 2.4361111 0.272007 2.4388889 0.275838 2.4416667 0.277017 2.4444444 0.277017 2.4472222 0.276427 2.4500000 0.275838 2.4527778 0.276133 2.4555556 0.277311 2.4583333 0.277017 2.4611111 0.276722 2.4638889 0.276133 2.4666667 0.275838 2.4694444 0.276133 2.4722222 0.276427 2.4750000 0.277017 2.4777778 0.276722 2.4805556 0.275838 2.4833333 0.275543 2.4861111 0.275838 2.4888889 0.276722 2.4916667 0.276133 2.4944444 0.275838 2.4972222 0.276133 2.5000000 0.276133 2.5027778 0.275838 2.5055556 0.277017 2.5083333 0.277311 2.5111111 0.277017 2.5138889 0.276722 2.5166667 0.276427 2.5194444 0.276427 2.5222222 0.276427 2.5250000 0.276722 2.5277778 0.276722 2.5305556 0.276133 2.5333333 0.276133 2.5361111 0.276427 2.5388889 0.276722 2.5416667 0.277311 2.5444444 0.277901 2.5472222 0.277311 2.5500000 0.276722 2.5527778 0.277017 2.5555556 0.277311 2.5583333 0.277901 2.5611111 0.277311 2.5638889 0.276722 2.5666667 0.276722 2.5694444 0.277311 2.5722222 0.277901 2.5750000 0.277901 2.5777778 0.277311 2.5805556 0.276722 2.5833333 0.277017 2.5861111 0.277017 2.5888889 0.278490 2.5916667 0.277901 2.5944444 0.277311 2.5972222 0.276722 2.6000000 0.277606 2.6027778 0.277311 2.6055556 0.277901 2.6083333 0.277606 2.6111111 0.277017 2.6138889 0.277606 2.6166667 0.277901 2.6194444 0.277901 2.6222222 0.277901 2.6250000 0.277901 2.6277778 0.277606 2.6305556 0.277017 2.6333333 0.277017 2.6361111 0.278490 2.6388889 0.278195 2.6416667 0.277901 2.6444444 0.277311 2.6472222 0.277017 2.6500000 0.277017 2.6527778 0.277901 2.6555556 0.278490 2.6583333 0.277311 2.6611111 0.277606 2.6638889 0.277017 2.6666667 0.277901 2.6694444 0.277901 2.6722222 0.278490 2.6750000 0.278195 2.6777778 0.277311 2.6805556 0.276722 2.6833333 0.277311 2.6861111 0.277311 2.6888889 0.278195 2.6916667 0.278490 2.6944444 0.278195 2.6972222 0.277901 2.7000000 0.279374 2.7027778 0.280258 2.7055556 0.281142 2.7083333 0.281436 2.7111111 0.281142 2.7168889 0.300000 2.9525556 0.300000 2.9555556 0.279669 2.9583333 0.279669 2.9611111 0.279374 2.9638889 0.279079 2.9666667 0.279669 2.9694444 0.280552 2.9722222 0.280552 2.9750000 0.280258 2.9777778 0.280258 2.9805556 0.279963 2.9833333 0.280552 2.9861111 0.281142 2.9888889 0.282910 2.9916667 0.282910 2.9944444 0.282320 2.9972222 0.282026 3.0000000 0.283204 3.0027778 0.283499 3.0055556 0.283794 3.0083333 0.283499 3.0111111 0.283794 3.0138889 0.284088 3.0166667 0.284383 3.0194444 0.285267 3.0222222 0.286446 3.0250000 0.285562 3.0277778 0.285856 3.0305556 0.284972 3.0333333 0.284972 3.0361111 0.285562 3.0388889 0.286151 3.0416667 0.284972 3.0444444 0.284383 3.0472222 0.284678 3.0500000 0.284972 3.0527778 0.284088 3.0555556 0.284383 3.0583333 0.283499 3.0611111 0.284972 3.0638889 0.285267 3.0666667 0.285562 3.0694444 0.284383 3.0722222 0.283499 3.0750000 0.282320 3.0777778 0.281436 3.0805556 0.280847 3.0833333 0.280258 3.0861111 0.279669 3.0888889 0.280552 3.0916667 0.280258 3.0944444 0.279669 3.0972222 0.278785 3.1000000 0.279374 3.1027778 0.279963 3.1055556 0.280258 3.1083333 0.279669 3.1111111 0.278785 3.1138889 0.278490 3.1166667 0.277901 3.1194444 0.278195 3.1222222 0.278490 3.1250000 0.278490 3.1277778 0.277606 3.1305556 0.277901 3.1333333 0.277901 3.1361111 0.278490 3.1388889 0.278195 3.1416667 0.278785 3.1444444 0.278195 3.1472222 0.277606 3.1500000 0.278490 3.1527778 0.278785 3.1555556 0.279374 3.1583333 0.279079 3.1611111 0.278195 3.1638889 0.277311 3.1666667 0.276722 3.1694444 0.274659 3.1722222 0.273775 3.1750000 0.271418 3.1777778 0.269650 3.1805556 0.266703 3.1833333 0.267293 3.1861111 0.272007 3.1888889 0.279079 3.1916667 0.287035 3.1944444 0.296759 3.1972222 0.310902 3.2000000 0.327993 3.2027778 0.341547 3.2055556 0.348324 3.2083333 0.345967 3.2111111 0.331529 3.2138889 0.308545 3.2166667 0.288214 3.2194444 0.275249 3.2222222 0.270534 3.2250000 0.271713 3.2277778 0.273481 3.2305556 0.275838 3.2333333 0.276427 3.2361111 0.277017 3.2388889 0.277017 3.2416667 0.276427 3.2444444 0.276133 3.2472222 0.274954 3.2500000 0.274954 3.2527778 0.276133 3.2555556 0.276722 3.2583333 0.276133 3.2611111 0.276133 3.2638889 0.275543 3.2666667 0.276133 3.2694444 0.277311 3.2722222 0.277017 3.2750000 0.276722 3.2777778 0.276722 3.2805556 0.276722 3.2833333 0.276722 3.2861111 0.277311 3.2888889 0.277017 3.2916667 0.277017 3.2944444 0.276427 3.2972222 0.274954 3.3000000 0.275838 3.3027778 0.276427 3.3055556 0.276722 3.3083333 0.276427 3.3111111 0.276133 3.3138889 0.274954 3.3166667 0.275543 3.3194444 0.276133 3.3222222 0.276133 3.3250000 0.276133 3.3277778 0.275838 3.3305556 0.275543 3.3333333 0.276133 3.3361111 0.275249 3.3388889 0.276133 3.3416667 0.275838 3.3444444 0.275838 3.3472222 0.275249 3.3500000 0.275543 3.3527778 0.276133 3.3555556 0.276722 3.3583333 0.276722 3.3611111 0.276722 3.3638889 0.276427 3.3666667 0.276722 3.3694444 0.276722 3.3722222 0.276133 3.3750000 0.276133 3.3777778 0.275249 3.3805556 0.274365 3.3833333 0.275543 3.3861111 0.276133 3.3888889 0.276722 3.3916667 0.277017 3.3944444 0.275543 3.3972222 0.276133 3.4000000 0.276133 3.4027778 0.276427 3.4055556 0.276722 3.4083333 0.276722 3.4111111 0.276133 3.4138889 0.275249 3.4166667 0.275543 3.4194444 0.276427 3.4222222 0.276722 3.4250000 0.276427 3.4277778 0.276133 3.4305556 0.274954 3.4333333 0.274954 3.4361111 0.274954 3.4388889 0.275249 3.4416667 0.274954 3.4444444 0.273481 3.4472222 0.273775 3.4500000 0.273481 3.4527778 0.274365 3.4555556 0.273775 3.4583333 0.272302 3.4611111 0.273186 3.4638889 0.272891 3.4666667 0.274070 3.4694444 0.274365 3.4722222 0.274954 3.4750000 0.274659 3.4777778 0.273775 3.4805556 0.273481 3.4833333 0.273775 3.4861111 0.274659 3.4888889 0.275249 3.4916667 0.275838 3.4944444 0.274954 3.4972222 0.275249 3.5000000 0.276133 3.5027778 0.277606 3.5085556 0.300000 3.7414444 0.300000 3.7444444 0.279963 3.7472222 0.279963 3.7500000 0.279963 3.7527778 0.280847 3.7555556 0.280847 3.7583333 0.280847 3.7611111 0.279669 3.7638889 0.279374 3.7666667 0.279963 3.7694444 0.280552 3.7722222 0.281142 3.7750000 0.281731 3.7777778 0.282026 3.7805556 0.282026 3.7833333 0.283794 3.7861111 0.284088 3.7888889 0.284972 3.7916667 0.284678 3.7944444 0.284383 3.7972222 0.284678 3.8000000 0.285267 3.8027778 0.286151 3.8055556 0.286151 3.8083333 0.287035 3.8111111 0.286151 3.8138889 0.286151 3.8166667 0.287035 3.8194444 0.286446 3.8222222 0.286740 3.8250000 0.286151 3.8277778 0.285562 3.8305556 0.284972 3.8333333 0.285856 3.8361111 0.286446 3.8388889 0.286446 3.8416667 0.285267 3.8444444 0.284972 3.8472222 0.285267 3.8500000 0.286446 3.8527778 0.287919 3.8555556 0.288508 3.8583333 0.287624 3.8611111 0.286446 3.8638889 0.284088 3.8666667 0.284088 3.8694444 0.283204 3.8722222 0.283204 3.8750000 0.281731 3.8777778 0.280552 3.8805556 0.279963 3.8833333 0.279963 3.8861111 0.279669 3.8888889 0.279374 3.8916667 0.279374 3.8944444 0.279963 3.8972222 0.279079 3.9000000 0.279669 3.9027778 0.279963 3.9055556 0.279963 3.9083333 0.279669 3.9111111 0.279079 3.9138889 0.278195 3.9166667 0.279079 3.9194444 0.278195 3.9222222 0.279669 3.9250000 0.279963 3.9277778 0.278785 3.9305556 0.277606 3.9333333 0.278785 3.9361111 0.279669 3.9388889 0.279374 3.9416667 0.279374 3.9444444 0.279079 3.9472222 0.277606 3.9500000 0.277017 3.9527778 0.276722 3.9555556 0.274954 3.9583333 0.273186 3.9611111 0.272007 3.9638889 0.269945 3.9666667 0.267882 3.9694444 0.268177 3.9722222 0.270829 3.9750000 0.276133 3.9777778 0.282615 3.9805556 0.290571 3.9833333 0.302357 3.9861111 0.318564 3.9888889 0.335064 3.9916667 0.347145 3.9944444 0.352155 3.9972222 0.346851 4.0000000 0.330645 4.0027778 0.307661 4.0055556 0.287330 4.0083333 0.274954 4.0111111 0.270534 4.0138889 0.271123 4.0166667 0.273481 4.0194444 0.276427 4.0222222 0.277017 4.0250000 0.276722 4.0277778 0.276722 4.0305556 0.276427 4.0333333 0.277017 4.0361111 0.277606 4.0388889 0.277311 4.0416667 0.277311 4.0444444 0.276427 4.0472222 0.275838 4.0500000 0.275838 4.0527778 0.277017 4.0555556 0.277017 4.0583333 0.276133 4.0611111 0.276133 4.0638889 0.275543 4.0666667 0.275838 4.0694444 0.276722 4.0722222 0.276722 4.0750000 0.276427 4.0777778 0.275543 4.0805556 0.275543 4.0833333 0.275543 4.0861111 0.276427 4.0888889 0.277017 4.0916667 0.277017 4.0944444 0.275838 4.0972222 0.275543 4.1000000 0.276133 4.1027778 0.276722 4.1055556 0.276722 4.1083333 0.276722 4.1111111 0.276133 4.1138889 0.275838 4.1166667 0.275838 4.1194444 0.276427 4.1222222 0.277017 4.1250000 0.276722 4.1277778 0.275838 4.1305556 0.274954 4.1333333 0.275543 4.1361111 0.276133 4.1388889 0.275838 4.1416667 0.276133 4.1444444 0.275543 4.1472222 0.274954 4.1500000 0.274954 4.1527778 0.275838 4.1555556 0.276722 4.1583333 0.277017 4.1611111 0.276427 4.1638889 0.275838 4.1666667 0.275838 4.1694444 0.276427 4.1722222 0.277017 4.1750000 0.275838 4.1777778 0.275249 4.1805556 0.275249 4.1833333 0.275543 4.1861111 0.275543 4.1888889 0.276133 4.1916667 0.275249 4.1944444 0.275543 4.1972222 0.274954 4.2000000 0.275838 4.2027778 0.276427 4.2055556 0.276133 4.2083333 0.276427 4.2111111 0.276427 4.2138889 0.275838 4.2166667 0.276427 4.2194444 0.276722 4.2222222 0.276722 4.2250000 0.276133 4.2277778 0.275838 4.2305556 0.274954 4.2333333 0.274954 4.2361111 0.275838 4.2388889 0.275838 4.2416667 0.275249 4.2444444 0.274659 4.2472222 0.273775 4.2500000 0.274070 4.2527778 0.274365 4.2555556 0.274659 4.2583333 0.274659 4.2611111 0.273481 4.2638889 0.273775 4.2666667 0.273775 4.2694444 0.274365 4.2722222 0.274365 4.2750000 0.273775 4.2777778 0.274070 4.2805556 0.273481 4.2833333 0.274659 4.2861111 0.274659 4.2888889 0.275543 4.2916667 0.276427 4.2974444 0.300000 4.5581111 0.300000 4.5611111 0.280552 4.5638889 0.280552 4.5666667 0.280847 4.5694444 0.281436 4.5722222 0.281436 4.5750000 0.281436 4.5777778 0.280552 4.5805556 0.280552 4.5833333 0.281142 4.5861111 0.281436 4.5888889 0.282026 4.5916667 0.282026 4.5944444 0.282615 4.5972222 0.281436 4.6000000 0.282320 4.6027778 0.283794 4.6055556 0.284972 4.6083333 0.284972 4.6111111 0.284678 4.6138889 0.284383 4.6166667 0.284972 4.6194444 0.286151 4.6222222 0.286446 4.6250000 0.286740 4.6277778 0.287035 4.6305556 0.287035 4.6333333 0.287330 4.6361111 0.288214 4.6388889 0.287919 4.6416667 0.287919 4.6444444 0.286740 4.6472222 0.286151 4.6500000 0.285856 4.6527778 0.286446 4.6555556 0.287330 4.6583333 0.285856 4.6611111 0.285856 4.6638889 0.285267 4.6666667 0.286151 4.6694444 0.287624 4.6722222 0.288214 4.6750000 0.287035 4.6777778 0.284972 4.6805556 0.283794 4.6833333 0.283204 4.6861111 0.282320 4.6888889 0.282026 4.6916667 0.281142 4.6944444 0.280552 4.6972222 0.280847 4.7000000 0.281142 4.7027778 0.280552 4.7055556 0.280552 4.7083333 0.280258 4.7111111 0.279963 4.7138889 0.279669 4.7166667 0.279963 4.7194444 0.280258 4.7222222 0.281142 4.7250000 0.280847 4.7277778 0.280258 4.7305556 0.279669 4.7333333 0.279669 4.7361111 0.279669 4.7388889 0.280258 4.7416667 0.279963 4.7444444 0.279669 4.7472222 0.279079 4.7500000 0.279963 4.7527778 0.279963 4.7555556 0.279963 4.7583333 0.279963 4.7611111 0.279669 4.7638889 0.279079 4.7666667 0.278490 4.7694444 0.278195 4.7722222 0.276133 4.7750000 0.273775 4.7777778 0.271713 4.7805556 0.270829 4.7833333 0.269355 4.7861111 0.268471 4.7888889 0.270239 4.7916667 0.275543 4.7944444 0.283499 4.7972222 0.292044 4.8000000 0.303831 4.8027778 0.317680 4.8055556 0.334180 4.8083333 0.347735 4.8111111 0.355691 4.8138889 0.354217 4.8166667 0.345672 4.8194444 0.326225 4.8222222 0.301179 4.8250000 0.282615 4.8277778 0.273775 4.8305556 0.272302 4.8333333 0.274954 4.8361111 0.277606 4.8388889 0.278785 4.8416667 0.278785 4.8444444 0.278195 4.8472222 0.277606 4.8500000 0.277606 4.8527778 0.277901 4.8555556 0.278195 4.8583333 0.278490 4.8611111 0.278195 4.8638889 0.277311 4.8666667 0.277311 4.8694444 0.277901 4.8722222 0.278195 4.8750000 0.278195 4.8777778 0.277311 4.8805556 0.276722 4.8833333 0.277311 4.8861111 0.277311 4.8888889 0.277017 4.8916667 0.277311 4.8944444 0.276722 4.8972222 0.275838 4.9000000 0.276427 4.9027778 0.276722 4.9055556 0.277606 4.9083333 0.276722 4.9111111 0.276722 4.9138889 0.276427 4.9166667 0.276427 4.9194444 0.276722 4.9222222 0.277017 4.9250000 0.277017 4.9277778 0.276722 4.9305556 0.276133 4.9333333 0.277017 4.9361111 0.277311 4.9388889 0.277901 4.9416667 0.277901 4.9444444 0.277606 4.9472222 0.277017 4.9500000 0.277311 4.9527778 0.278195 4.9555556 0.278195 4.9583333 0.278195 4.9611111 0.277901 4.9638889 0.277311 4.9666667 0.278195 4.9694444 0.277017 4.9722222 0.277901 4.9750000 0.278195 4.9777778 0.277606 4.9805556 0.277017 4.9833333 0.277017 4.9861111 0.277311 4.9888889 0.277901 4.9916667 0.277901 4.9944444 0.277311 4.9972222 0.276722 5.0000000 0.277017 5.0027778 0.277311 5.0055556 0.277901 5.0083333 0.277606 5.0111111 0.277311 5.0138889 0.277017 5.0166667 0.277606 5.0194444 0.277606 5.0222222 0.278195 5.0250000 0.278195 5.0277778 0.278490 5.0305556 0.277017 5.0333333 0.278490 5.0361111 0.278490 5.0388889 0.278785 5.0416667 0.277901 5.0444444 0.277606 5.0472222 0.276427 5.0500000 0.277017 5.0527778 0.277901 5.0555556 0.277901 5.0583333 0.278195 5.0611111 0.277311 5.0638889 0.277017 5.0666667 0.277017 5.0694444 0.277017 5.0722222 0.277017 5.0750000 0.277901 5.0777778 0.277311 5.0805556 0.276722 5.0833333 0.277606 5.0861111 0.278195 5.0888889 0.277901 5.0916667 0.277901 5.0944444 0.277017 5.0972222 0.276133 5.1000000 0.277901 5.1027778 0.278195 5.1055556 0.278785 5.1083333 0.277901 5.1141111 0.300000 5.2108889 0.300000 5.2138889 0.282615 5.2166667 0.283204 5.2194444 0.283499 5.2222222 0.283794 5.2250000 0.283499 5.2277778 0.282910 5.2305556 0.281731 5.2333333 0.282026 5.2361111 0.283204 5.2388889 0.284088 5.2416667 0.284088 5.2444444 0.283794 5.2472222 0.283204 5.2500000 0.283204 5.2527778 0.284088 5.2555556 0.284383 5.2583333 0.284383 5.2611111 0.284383 5.2638889 0.283499 5.2666667 0.284383 5.2694444 0.285562 5.2722222 0.286151 5.2750000 0.286151 5.2777778 0.285267 5.2805556 0.285267 5.2833333 0.285562 5.2861111 0.287330 5.2888889 0.287035 5.2916667 0.285562 5.2944444 0.284972 5.2972222 0.286446 5.3000000 0.287919 5.3027778 0.287624 5.3055556 0.287035 5.3083333 0.286446 5.3111111 0.285856 5.3138889 0.285856 5.3166667 0.285562 5.3194444 0.285267 5.3222222 0.284088 5.3250000 0.283204 5.3277778 0.281436 5.3305556 0.281142 5.3333333 0.281142 5.3361111 0.281731 5.3388889 0.280552 5.3416667 0.279963 5.3444444 0.279669 5.3472222 0.278785 5.3500000 0.278490 5.3527778 0.278785 5.3555556 0.279374 5.3583333 0.279079 5.3611111 0.277901 5.3638889 0.277311 5.3666667 0.277901 5.3694444 0.278195 5.3722222 0.278490 5.3750000 0.278490 5.3777778 0.278195 5.3805556 0.277606 5.3833333 0.278785 5.3861111 0.279374 5.3888889 0.279079 5.3916667 0.279079 5.3944444 0.279374 5.3972222 0.278490 5.4000000 0.279374 5.4027778 0.279374 5.4055556 0.279963 5.4083333 0.279079 5.4111111 0.279374 5.4138889 0.277901 5.4166667 0.278490 5.4194444 0.277901 5.4222222 0.276427 5.4250000 0.274659 5.4277778 0.272007 5.4305556 0.269355 5.4333333 0.269355 5.4361111 0.267587 5.4388889 0.266409 5.4416667 0.268177 5.4444444 0.273775 5.4472222 0.282026 5.4500000 0.291750 5.4527778 0.301473 5.4555556 0.315322 5.4583333 0.330055 5.4611111 0.343315 5.4638889 0.349797 5.4666667 0.351565 5.4694444 0.343315 5.4722222 0.323573 5.4750000 0.298527 5.4777778 0.280258 5.4805556 0.271713 5.4833333 0.272302 5.4861111 0.275543 5.4888889 0.277901 5.4916667 0.278490 5.4944444 0.277311 5.4972222 0.276427 5.5000000 0.277606 5.5027778 0.277017 5.5055556 0.277901 5.5083333 0.277311 5.5111111 0.276722 5.5138889 0.276133 5.5166667 0.277017 5.5194444 0.277606 5.5222222 0.277311 5.5250000 0.277311 5.5277778 0.276722 5.5305556 0.276427 5.5333333 0.276133 5.5361111 0.276427 5.5388889 0.277017 5.5416667 0.277017 5.5444444 0.276722 5.5472222 0.276427 5.5500000 0.277017 5.5527778 0.277311 5.5555556 0.277017 5.5583333 0.277311 5.5611111 0.275838 5.5638889 0.275249 5.5666667 0.276133 5.5694444 0.275838 5.5722222 0.277017 5.5750000 0.277017 5.5777778 0.277017 5.5805556 0.276427 5.5833333 0.276427 5.5861111 0.277017 5.5888889 0.277901 5.5916667 0.277606 5.5944444 0.276722 5.5972222 0.276427 5.6000000 0.277017 5.6027778 0.276427 5.6055556 0.277017 5.6083333 0.276722 5.6111111 0.275838 5.6138889 0.275543 5.6166667 0.276133 5.6194444 0.277311 5.6222222 0.277311 5.6250000 0.277606 5.6277778 0.276427 5.6305556 0.276427 5.6333333 0.276722 5.6361111 0.277017 5.6388889 0.277606 5.6416667 0.277901 5.6444444 0.276722 5.6472222 0.276722 5.6500000 0.277311 5.6527778 0.277606 5.6555556 0.277901 5.6583333 0.277311 5.6611111 0.277017 5.6638889 0.276427 5.6666667 0.276427 5.6694444 0.277311 5.6722222 0.277606 5.6750000 0.276722 5.6777778 0.277017 5.6805556 0.276427 5.6833333 0.276722 5.6861111 0.277311 5.6888889 0.277606 5.6916667 0.277311 5.6944444 0.276722 5.6972222 0.276133 5.7000000 0.276427 5.7027778 0.277017 5.7055556 0.277606 5.7083333 0.277606 5.7111111 0.277311 5.7138889 0.276133 5.7166667 0.276722 5.7194444 0.276427 5.7222222 0.277017 5.7250000 0.276427 5.7277778 0.276133 5.7305556 0.274954 5.7333333 0.275249 5.7361111 0.276133 5.7388889 0.276427 5.7416667 0.276133 5.7444444 0.276133 5.7472222 0.275543 5.7500000 0.276427 5.7527778 0.277017 5.7555556 0.277606 5.7583333 0.277311 5.7611111 0.276722 5.7668889 0.300000 6.2053333 0.300000 6.2083333 0.279669 6.2111111 0.279079 6.2138889 0.278785 6.2166667 0.278785 6.2194444 0.278490 6.2222222 0.279669 6.2250000 0.279079 6.2277778 0.279374 6.2305556 0.278785 6.2333333 0.279079 6.2361111 0.278785 6.2388889 0.279669 6.2416667 0.280258 6.2444444 0.280552 6.2472222 0.280552 6.2500000 0.281731 6.2527778 0.282026 6.2555556 0.282320 6.2583333 0.282026 6.2611111 0.282615 6.2638889 0.282026 6.2666667 0.283204 6.2694444 0.283794 6.2722222 0.284383 6.2750000 0.284972 6.2777778 0.284972 6.2805556 0.284678 6.2833333 0.284383 6.2861111 0.284972 6.2888889 0.284972 6.2916667 0.284678 6.2944444 0.283499 6.2972222 0.282910 6.3000000 0.283499 6.3027778 0.284088 6.3055556 0.284972 6.3083333 0.283794 6.3111111 0.282910 6.3138889 0.281142 6.3166667 0.282320 6.3194444 0.282615 6.3222222 0.284088 6.3250000 0.284383 6.3277778 0.284088 6.3305556 0.283204 6.3333333 0.282320 6.3361111 0.281731 6.3388889 0.281436 6.3416667 0.281142 6.3444444 0.279374 6.3472222 0.278195 6.3500000 0.278490 6.3527778 0.278490 6.3555556 0.278490 6.3583333 0.278195 6.3611111 0.278195 6.3638889 0.278195 6.3666667 0.277606 6.3694444 0.278785 6.3722222 0.277901 6.3750000 0.277901 6.3777778 0.276427 6.3805556 0.275249 6.3833333 0.276133 6.3861111 0.276427 6.3888889 0.277311 6.3916667 0.277606 6.3944444 0.276427 6.3972222 0.275543 6.4000000 0.276133 6.4027778 0.276722 6.4055556 0.276722 6.4083333 0.276722 6.4111111 0.275838 6.4138889 0.274659 6.4166667 0.274070 6.4194444 0.273186 6.4222222 0.271123 6.4250000 0.271418 6.4277778 0.269355 6.4305556 0.266409 6.4333333 0.266114 6.4361111 0.269061 6.4388889 0.275249 6.4416667 0.282026 6.4444444 0.288803 6.4472222 0.298821 6.4500000 0.312965 6.4527778 0.328582 6.4555556 0.342136 6.4583333 0.349797 6.4611111 0.352155 6.4638889 0.346556 6.4666667 0.333002 6.4694444 0.313260 6.4722222 0.295875 6.4750000 0.283204 6.4777778 0.274954 6.4805556 0.270534 6.4833333 0.267587 6.4861111 0.268471 6.4888889 0.270534 6.4916667 0.272597 6.4944444 0.273481 6.4972222 0.273481 6.5000000 0.274365 6.5027778 0.275249 6.5055556 0.275838 6.5083333 0.275838 6.5111111 0.275543 6.5138889 0.275249 6.5166667 0.274954 6.5194444 0.275249 6.5222222 0.274659 6.5250000 0.274659 6.5277778 0.274070 6.5305556 0.273481 6.5333333 0.273481 6.5361111 0.274659 6.5388889 0.274659 6.5416667 0.274659 6.5444444 0.273775 6.5472222 0.273775 6.5500000 0.274070 6.5527778 0.274954 6.5555556 0.274659 6.5583333 0.274659 6.5611111 0.274954 6.5638889 0.273775 6.5666667 0.273775 6.5694444 0.274659 6.5722222 0.274365 6.5750000 0.274365 6.5777778 0.273775 6.5805556 0.273775 6.5833333 0.274365 6.5861111 0.274659 6.5888889 0.274954 6.5916667 0.274659 6.5944444 0.274659 6.5972222 0.274070 6.6000000 0.275249 6.6027778 0.274659 6.6055556 0.274954 6.6083333 0.274659 6.6111111 0.274070 6.6138889 0.274070 6.6166667 0.274659 6.6194444 0.274659 6.6222222 0.275543 6.6250000 0.274954 6.6277778 0.274659 6.6305556 0.273186 6.6333333 0.273775 6.6361111 0.273775 6.6388889 0.274659 6.6416667 0.274659 6.6444444 0.274070 6.6472222 0.274070 6.6500000 0.274365 6.6527778 0.274659 6.6555556 0.275543 6.6583333 0.275543 6.6611111 0.274954 6.6638889 0.274954 6.6666667 0.275249 6.6694444 0.276133 6.6722222 0.276133 6.6750000 0.275543 6.6777778 0.275543 6.6805556 0.274954 6.6833333 0.274659 6.6861111 0.276133 6.6888889 0.276133 6.6916667 0.276133 6.6944444 0.276133 6.6972222 0.274659 6.7000000 0.275543 6.7027778 0.275838 6.7055556 0.275543 6.7083333 0.274659 6.7111111 0.273775 6.7138889 0.272597 6.7166667 0.272891 6.7194444 0.273481 6.7222222 0.273186 6.7250000 0.272891 6.7277778 0.272597 6.7305556 0.271418 6.7333333 0.270829 6.7361111 0.272007 6.7388889 0.271123 6.7416667 0.270534 6.7444444 0.270829 6.7472222 0.269650 6.7500000 0.270534 6.7527778 0.271418 6.7555556 0.271123 6.7613333 0.300000 7.0497778 0.300000 7.0527778 0.279079 7.0555556 0.279963 7.0583333 0.279669 7.0611111 0.279079 7.0638889 0.279079 7.0666667 0.279079 7.0694444 0.279963 7.0722222 0.279963 7.0750000 0.279669 7.0777778 0.278490 7.0805556 0.278195 7.0833333 0.279374 7.0861111 0.280552 7.0888889 0.281142 7.0916667 0.281436 7.0944444 0.282615 7.0972222 0.282026 7.1000000 0.282615 7.1027778 0.282320 7.1055556 0.283204 7.1083333 0.283794 7.1111111 0.284678 7.1138889 0.283794 7.1166667 0.284383 7.1194444 0.284678 7.1222222 0.285267 7.1250000 0.285562 7.1277778 0.284972 7.1305556 0.284383 7.1333333 0.284678 7.1361111 0.284678 7.1388889 0.285267 7.1416667 0.284678 7.1444444 0.283499 7.1472222 0.283499 7.1500000 0.283794 7.1527778 0.283204 7.1555556 0.283499 7.1583333 0.284972 7.1611111 0.285562 7.1638889 0.285562 7.1666667 0.284678 7.1694444 0.283204 7.1722222 0.282910 7.1750000 0.282320 7.1777778 0.281142 7.1805556 0.280258 7.1833333 0.279079 7.1861111 0.279374 7.1888889 0.279079 7.1916667 0.279079 7.1944444 0.277901 7.1972222 0.277311 7.2000000 0.277606 7.2027778 0.278785 7.2055556 0.279374 7.2083333 0.278785 7.2111111 0.278490 7.2138889 0.278195 7.2166667 0.278195 7.2194444 0.278490 7.2222222 0.278785 7.2250000 0.278490 7.2277778 0.278195 7.2305556 0.277311 7.2333333 0.277311 7.2361111 0.278490 7.2388889 0.278785 7.2416667 0.277606 7.2444444 0.277311 7.2472222 0.276722 7.2500000 0.276722 7.2527778 0.277311 7.2555556 0.277606 7.2583333 0.276722 7.2611111 0.274954 7.2638889 0.272597 7.2666667 0.270534 7.2694444 0.269650 7.2722222 0.268766 7.2750000 0.266998 7.2777778 0.265525 7.2805556 0.268766 7.2833333 0.275838 7.2861111 0.284972 7.2888889 0.293812 7.2916667 0.306188 7.2944444 0.320921 7.2972222 0.335359 7.3000000 0.347735 7.3027778 0.352449 7.3055556 0.348913 7.3083333 0.334180 7.3111111 0.310902 7.3138889 0.287919 7.3166667 0.273481 7.3194444 0.269061 7.3222222 0.270829 7.3250000 0.272597 7.3277778 0.274365 7.3305556 0.275543 7.3333333 0.275543 7.3361111 0.275543 7.3388889 0.276427 7.3416667 0.276722 7.3444444 0.276133 7.3472222 0.274954 7.3500000 0.274365 7.3527778 0.275543 7.3555556 0.275543 7.3583333 0.275543 7.3611111 0.275543 7.3638889 0.274659 7.3666667 0.275249 7.3694444 0.275838 7.3722222 0.276133 7.3750000 0.275249 7.3777778 0.275838 7.3805556 0.275249 7.3833333 0.276427 7.3861111 0.276722 7.3888889 0.277311 7.3916667 0.276427 7.3944444 0.276427 7.3972222 0.276427 7.4000000 0.276427 7.4027778 0.276722 7.4055556 0.276427 7.4083333 0.276427 7.4111111 0.276427 7.4138889 0.275838 7.4166667 0.276722 7.4194444 0.275838 7.4222222 0.276427 7.4250000 0.276722 7.4277778 0.276133 7.4305556 0.275838 7.4333333 0.275543 7.4361111 0.276133 7.4388889 0.276427 7.4416667 0.276722 7.4444444 0.276133 7.4472222 0.275543 7.4500000 0.276133 7.4527778 0.275543 7.4555556 0.275838 7.4583333 0.276133 7.4611111 0.276133 7.4638889 0.275838 7.4666667 0.276133 7.4694444 0.276427 7.4722222 0.276722 7.4750000 0.276133 7.4777778 0.276133 7.4805556 0.276427 7.4833333 0.276722 7.4861111 0.277017 7.4888889 0.276722 7.4916667 0.277017 7.4944444 0.276722 7.4972222 0.275249 7.5000000 0.275543 7.5027778 0.276133 7.5055556 0.276427 7.5083333 0.276427 7.5111111 0.275543 7.5138889 0.275249 7.5166667 0.275838 7.5194444 0.276722 7.5222222 0.276427 7.5250000 0.276133 7.5277778 0.275543 7.5305556 0.274365 7.5333333 0.275543 7.5361111 0.275543 7.5388889 0.276427 7.5416667 0.276133 7.5444444 0.275249 7.5472222 0.274659 7.5500000 0.274954 7.5527778 0.275838 7.5555556 0.275838 7.5583333 0.276133 7.5611111 0.275543 7.5638889 0.274954 7.5666667 0.274954 7.5694444 0.275249 7.5722222 0.275838 7.5750000 0.275838 7.5777778 0.275249 7.5805556 0.274659 7.5833333 0.274954 7.5861111 0.275249 7.5888889 0.276133 7.5916667 0.275543 7.5944444 0.275838 7.5972222 0.275838 7.6000000 0.277311 7.6057778 0.300000 7.8608889 0.300000 7.8638889 0.280258 7.8666667 0.281142 7.8694444 0.280847 7.8722222 0.281436 7.8750000 0.281142 7.8777778 0.281142 7.8805556 0.279669 7.8833333 0.280258 7.8861111 0.281142 7.8888889 0.281731 7.8916667 0.281142 7.8944444 0.281142 7.8972222 0.279963 7.9000000 0.280552 7.9027778 0.281142 7.9055556 0.281731 7.9083333 0.281731 7.9111111 0.281731 7.9138889 0.282615 7.9166667 0.283499 7.9194444 0.284972 7.9222222 0.285267 7.9250000 0.285267 7.9277778 0.284972 7.9305556 0.284678 7.9333333 0.285856 7.9361111 0.287035 7.9388889 0.286446 7.9416667 0.286446 7.9444444 0.287330 7.9472222 0.287035 7.9500000 0.286740 7.9527778 0.286446 7.9555556 0.286446 7.9583333 0.286151 7.9611111 0.285562 7.9638889 0.284972 7.9666667 0.285856 7.9694444 0.286151 7.9722222 0.285562 7.9750000 0.286151 7.9777778 0.286446 7.9805556 0.287035 7.9833333 0.288508 7.9861111 0.287035 7.9888889 0.285562 7.9916667 0.284678 7.9944444 0.284088 7.9972222 0.282910 8.0000000 0.282320 8.0027778 0.282026 8.0055556 0.282026 8.0083333 0.281142 8.0111111 0.280552 8.0138889 0.279374 8.0166667 0.279374 8.0194444 0.280258 8.0222222 0.280258 8.0250000 0.280258 8.0277778 0.279963 8.0305556 0.279374 8.0333333 0.279374 8.0361111 0.279669 8.0388889 0.280258 8.0416667 0.279669 8.0444444 0.279079 8.0472222 0.278195 8.0500000 0.279374 8.0527778 0.279669 8.0555556 0.280258 8.0583333 0.280258 8.0611111 0.280258 8.0638889 0.279079 8.0666667 0.279079 8.0694444 0.279669 8.0722222 0.279079 8.0750000 0.276722 8.0777778 0.273481 8.0805556 0.271713 8.0833333 0.270239 8.0861111 0.269061 8.0888889 0.267882 8.0916667 0.270534 8.0944444 0.276722 8.0972222 0.284972 8.1000000 0.295875 8.1027778 0.308545 8.1055556 0.325046 8.1083333 0.340368 8.1111111 0.351565 8.1138889 0.354512 8.1166667 0.346851 8.1194444 0.327698 8.1222222 0.301179 8.1250000 0.280847 8.1277778 0.272302 8.1305556 0.271418 8.1333333 0.275838 8.1361111 0.278490 8.1388889 0.279079 8.1416667 0.278490 8.1444444 0.277606 8.1472222 0.277311 8.1500000 0.277606 8.1527778 0.278195 8.1555556 0.278195 8.1583333 0.277901 8.1611111 0.277311 8.1638889 0.276722 8.1666667 0.277311 8.1694444 0.277606 8.1722222 0.277311 8.1750000 0.277901 8.1777778 0.277017 8.1805556 0.276133 8.1833333 0.276133 8.1861111 0.277017 8.1888889 0.277311 8.1916667 0.277311 8.1944444 0.277017 8.1972222 0.275838 8.2000000 0.276427 8.2027778 0.277017 8.2055556 0.277311 8.2083333 0.277311 8.2111111 0.276722 8.2138889 0.277017 8.2166667 0.276722 8.2194444 0.277606 8.2222222 0.277901 8.2250000 0.277606 8.2277778 0.277311 8.2305556 0.276427 8.2333333 0.277311 8.2361111 0.277606 8.2388889 0.277901 8.2416667 0.277606 8.2444444 0.276722 8.2472222 0.276722 8.2500000 0.277311 8.2527778 0.277901 8.2555556 0.278195 8.2583333 0.278490 8.2611111 0.277311 8.2638889 0.276722 8.2666667 0.277311 8.2694444 0.277311 8.2722222 0.278195 8.2750000 0.277901 8.2777778 0.278195 8.2805556 0.277901 8.2833333 0.277901 8.2861111 0.278195 8.2888889 0.279079 8.2916667 0.278490 8.2944444 0.277606 8.2972222 0.277901 8.3000000 0.278195 8.3027778 0.277606 8.3055556 0.278490 8.3083333 0.278195 8.3111111 0.277901 8.3138889 0.277017 8.3166667 0.277606 8.3194444 0.277901 8.3222222 0.277606 8.3250000 0.278195 8.3277778 0.277901 8.3305556 0.277606 8.3333333 0.277311 8.3361111 0.277311 8.3388889 0.278195 8.3416667 0.277901 8.3444444 0.277901 8.3472222 0.277606 8.3500000 0.277606 8.3527778 0.277606 8.3555556 0.277606 8.3583333 0.277901 8.3611111 0.277017 8.3638889 0.276722 8.3666667 0.277311 8.3694444 0.277311 8.3722222 0.277901 8.3750000 0.277901 8.3777778 0.277311 8.3805556 0.277311 8.3833333 0.277017 8.3861111 0.278195 8.3888889 0.278490 8.3916667 0.278490 8.3944444 0.277901 8.3972222 0.277311 8.4000000 0.279374 8.4027778 0.279669 8.4055556 0.280847 8.4083333 0.280847 8.4111111 0.280552 8.4168889 0.300000 8.6497778 0.300000 8.6527778 0.282026 8.6555556 0.282910 8.6583333 0.283204 8.6611111 0.282910 8.6638889 0.282026 8.6666667 0.281731 8.6694444 0.282320 8.6722222 0.282320 8.6750000 0.281731 8.6777778 0.281436 8.6805556 0.281436 8.6833333 0.281731 8.6861111 0.282615 8.6888889 0.282320 8.6916667 0.282615 8.6944444 0.281436 8.6972222 0.281731 8.7000000 0.282910 8.7027778 0.284383 8.7055556 0.285856 8.7083333 0.284972 8.7111111 0.285856 8.7138889 0.285267 8.7166667 0.286740 8.7194444 0.286740 8.7222222 0.287330 8.7250000 0.287624 8.7277778 0.288214 8.7305556 0.288508 8.7333333 0.288508 8.7361111 0.289392 8.7388889 0.289687 8.7416667 0.289392 8.7444444 0.287919 8.7472222 0.287330 8.7500000 0.287624 8.7527778 0.287624 8.7555556 0.287624 8.7583333 0.287624 8.7611111 0.287330 8.7638889 0.286740 8.7666667 0.287624 8.7694444 0.289392 8.7722222 0.289982 8.7750000 0.289098 8.7777778 0.285856 8.7805556 0.284972 8.7833333 0.284972 8.7861111 0.284088 8.7888889 0.283794 8.7916667 0.283204 8.7944444 0.282320 8.7972222 0.282320 8.8000000 0.281436 8.8027778 0.282026 8.8055556 0.282320 8.8083333 0.282615 8.8111111 0.282320 8.8138889 0.281436 8.8166667 0.281731 8.8194444 0.281731 8.8222222 0.282320 8.8250000 0.282320 8.8277778 0.282026 8.8305556 0.281436 8.8333333 0.280847 8.8361111 0.281142 8.8388889 0.281142 8.8416667 0.281142 8.8444444 0.280847 8.8472222 0.279963 8.8500000 0.280258 8.8527778 0.280847 8.8555556 0.281436 8.8583333 0.281142 8.8611111 0.279669 8.8638889 0.278195 8.8666667 0.276722 8.8694444 0.274954 8.8722222 0.273775 8.8750000 0.272597 8.8777778 0.269945 8.8805556 0.268766 8.8833333 0.271418 8.8861111 0.278195 8.8888889 0.286151 8.8916667 0.294696 8.8944444 0.306188 8.8972222 0.322099 8.9000000 0.338600 8.9027778 0.348324 8.9055556 0.350976 8.9083333 0.343315 8.9111111 0.326519 8.9138889 0.303536 8.9166667 0.284088 8.9194444 0.274659 8.9222222 0.272891 8.9250000 0.275543 8.9277778 0.277311 8.9305556 0.278490 8.9333333 0.279079 8.9361111 0.279079 8.9388889 0.279669 8.9416667 0.279374 8.9444444 0.279374 8.9472222 0.278785 8.9500000 0.279669 8.9527778 0.279963 8.9555556 0.279963 8.9583333 0.280258 8.9611111 0.280258 8.9638889 0.279079 8.9666667 0.279669 8.9694444 0.279963 8.9722222 0.280258 8.9750000 0.279963 8.9777778 0.279374 8.9805556 0.278490 8.9833333 0.278785 8.9861111 0.278490 8.9888889 0.279374 8.9916667 0.279669 8.9944444 0.278490 8.9972222 0.278785 9.0000000 0.279374 9.0027778 0.279079 9.0055556 0.279374 9.0083333 0.279079 9.0111111 0.279374 9.0138889 0.278785 9.0166667 0.280258 9.0194444 0.280258 9.0222222 0.280552 9.0250000 0.279963 9.0277778 0.279374 9.0305556 0.279374 9.0333333 0.279669 9.0361111 0.280258 9.0388889 0.279669 9.0416667 0.279079 9.0444444 0.279079 9.0472222 0.278195 9.0500000 0.279079 9.0527778 0.279374 9.0555556 0.279669 9.0583333 0.278490 9.0611111 0.278490 9.0638889 0.278195 9.0666667 0.278490 9.0694444 0.279079 9.0722222 0.279669 9.0750000 0.279669 9.0777778 0.279669 9.0805556 0.279963 9.0833333 0.280258 9.0861111 0.280847 9.0888889 0.280258 9.0916667 0.279669 9.0944444 0.279374 9.0972222 0.279374 9.1000000 0.279079 9.1027778 0.279079 9.1055556 0.278785 9.1083333 0.279374 9.1111111 0.278785 9.1138889 0.278490 9.1166667 0.279669 9.1194444 0.279669 9.1222222 0.280552 9.1250000 0.279374 9.1277778 0.279669 9.1305556 0.279079 9.1333333 0.279374 9.1361111 0.279963 9.1388889 0.280258 9.1416667 0.279374 9.1444444 0.278490 9.1472222 0.277606 9.1500000 0.277311 9.1527778 0.279079 9.1555556 0.278785 9.1583333 0.279079 9.1611111 0.278195 9.1638889 0.277311 9.1666667 0.278195 9.1694444 0.278195 9.1722222 0.279374 9.1750000 0.279669 9.1777778 0.278490 9.1805556 0.278490 9.1833333 0.278785 9.1861111 0.279669 9.1888889 0.280552 9.1916667 0.280552 9.1944444 0.280552 9.1972222 0.280258 9.2000000 0.281436 9.2057778 0.300000 9.4220000 0.300000 9.4250000 0.282026 9.4277778 0.281731 9.4305556 0.281142 9.4333333 0.281731 9.4361111 0.282320 9.4388889 0.282615 9.4416667 0.282320 9.4444444 0.281436 9.4472222 0.280847 9.4500000 0.280847 9.4527778 0.282026 9.4555556 0.281731 9.4583333 0.282910 9.4611111 0.281436 9.4638889 0.280847 9.4666667 0.281142 9.4694444 0.282910 9.4722222 0.283499 9.4750000 0.284678 9.4777778 0.284678 9.4805556 0.284383 9.4833333 0.284678 9.4861111 0.285267 9.4888889 0.286446 9.4916667 0.287035 9.4944444 0.287035 9.4972222 0.286151 9.5000000 0.287035 9.5027778 0.287919 9.5055556 0.287919 9.5083333 0.287624 9.5111111 0.287624 9.5138889 0.286446 9.5166667 0.285856 9.5194444 0.286446 9.5222222 0.286740 9.5250000 0.286151 9.5277778 0.285267 9.5305556 0.284383 9.5333333 0.284678 9.5361111 0.285562 9.5388889 0.287330 9.5416667 0.287330 9.5444444 0.285562 9.5472222 0.283499 9.5500000 0.283794 9.5527778 0.283794 9.5555556 0.282615 9.5583333 0.281731 9.5611111 0.280847 9.5638889 0.279963 9.5666667 0.279963 9.5694444 0.280847 9.5722222 0.281436 9.5750000 0.281731 9.5777778 0.281436 9.5805556 0.280552 9.5833333 0.280552 9.5861111 0.280847 9.5888889 0.280847 9.5916667 0.280258 9.5944444 0.279669 9.5972222 0.279374 9.6000000 0.279374 9.6027778 0.279374 9.6055556 0.279669 9.6083333 0.279374 9.6111111 0.278490 9.6138889 0.278785 9.6166667 0.279374 9.6194444 0.279079 9.6222222 0.279669 9.6250000 0.279669 9.6277778 0.279374 9.6305556 0.278490 9.6333333 0.277606 9.6361111 0.276133 9.6388889 0.274954 9.6416667 0.274070 9.6444444 0.272302 9.6472222 0.269355 9.6500000 0.268177 9.6527778 0.271123 9.6555556 0.277017 9.6583333 0.284678 9.6611111 0.293223 9.6638889 0.305009 9.6666667 0.321215 9.6694444 0.336243 9.6722222 0.345967 9.6750000 0.349208 9.6777778 0.342431 9.6805556 0.324162 9.6833333 0.301768 9.6861111 0.284972 9.6888889 0.275543 9.6916667 0.272302 9.6944444 0.272597 9.6972222 0.274365 9.7000000 0.276722 9.7027778 0.277901 9.7055556 0.278195 9.7083333 0.277901 9.7111111 0.277901 9.7138889 0.277017 9.7166667 0.276427 9.7194444 0.277606 9.7222222 0.277311 9.7250000 0.277311 9.7277778 0.277311 9.7305556 0.277311 9.7333333 0.278195 9.7361111 0.278195 9.7388889 0.278785 9.7416667 0.277606 9.7444444 0.277606 9.7472222 0.277311 9.7500000 0.278195 9.7527778 0.278195 9.7555556 0.278490 9.7583333 0.277901 9.7611111 0.277311 9.7638889 0.277017 9.7666667 0.277017 9.7694444 0.277311 9.7722222 0.277311 9.7750000 0.276722 9.7777778 0.277017 9.7805556 0.276427 9.7833333 0.276133 9.7861111 0.277017 9.7888889 0.276722 9.7916667 0.277017 9.7944444 0.276133 9.7972222 0.276133 9.8000000 0.276427 9.8027778 0.277901 9.8055556 0.277606 9.8083333 0.277017 9.8111111 0.276722 9.8138889 0.276722 9.8166667 0.277017 9.8194444 0.277017 9.8222222 0.277311 9.8250000 0.276133 9.8277778 0.276427 9.8305556 0.276133 9.8333333 0.276722 9.8361111 0.277017 9.8388889 0.276722 9.8416667 0.277017 9.8444444 0.276427 9.8472222 0.276133 9.8500000 0.276133 9.8527778 0.277017 9.8555556 0.277017 9.8583333 0.276722 9.8611111 0.276427 9.8638889 0.276427 9.8666667 0.276722 9.8694444 0.277606 9.8722222 0.278195 9.8750000 0.277606 9.8777778 0.277311 9.8805556 0.276722 9.8833333 0.277017 9.8861111 0.277606 9.8888889 0.277606 9.8916667 0.277311 9.8944444 0.277017 9.8972222 0.277017 9.9000000 0.276427 9.9027778 0.276427 9.9055556 0.276133 9.9083333 0.275543 9.9111111 0.275249 9.9138889 0.274659 9.9166667 0.274659 9.9194444 0.274954 9.9222222 0.275249 9.9250000 0.274659 9.9277778 0.273775 9.9305556 0.272597 9.9333333 0.273186 9.9361111 0.274070 9.9388889 0.274954 9.9416667 0.274365 9.9444444 0.273481 9.9472222 0.274070 9.9500000 0.273775 9.9527778 0.274954 9.9555556 0.274954 9.9583333 0.274954 9.9611111 0.274659 9.9638889 0.274659 9.9666667 0.275543 9.9694444 0.275543 9.9722222 0.277311 9.9780000 0.300000 10.2608889 0.300000 10.2638889 0.281142 10.2666667 0.281436 10.2694444 0.281731 10.2722222 0.282615 10.2750000 0.282615 10.2777778 0.282026 10.2805556 0.281731 10.2833333 0.282320 10.2861111 0.283499 10.2888889 0.283794 10.2916667 0.284383 10.2944444 0.283794 10.2972222 0.283794 10.3000000 0.284678 10.3027778 0.285856 10.3055556 0.285856 10.3083333 0.286151 10.3111111 0.285856 10.3138889 0.286151 10.3166667 0.286740 10.3194444 0.287330 10.3222222 0.287919 10.3250000 0.287919 10.3277778 0.287624 10.3305556 0.287330 10.3333333 0.287035 10.3361111 0.287035 10.3388889 0.287330 10.3416667 0.287035 10.3444444 0.287035 10.3472222 0.286446 10.3500000 0.286446 10.3527778 0.285856 10.3555556 0.287624 10.3583333 0.287035 10.3611111 0.286446 10.3638889 0.284972 10.3666667 0.286151 10.3694444 0.287624 10.3722222 0.288803 10.3750000 0.287919 10.3777778 0.286740 10.3805556 0.284678 10.3833333 0.283794 10.3861111 0.283499 10.3888889 0.283204 10.3916667 0.282026 10.3944444 0.281142 10.3972222 0.281436 10.4000000 0.280258 10.4027778 0.280847 10.4055556 0.280258 10.4083333 0.281142 10.4111111 0.280847 10.4138889 0.281142 10.4166667 0.280847 10.4194444 0.280847 10.4222222 0.281731 10.4250000 0.282026 10.4277778 0.281142 10.4305556 0.281142 10.4333333 0.280552 10.4361111 0.281142 10.4388889 0.281142 10.4416667 0.280552 10.4444444 0.280552 10.4472222 0.278785 10.4500000 0.279079 10.4527778 0.280552 10.4555556 0.280847 10.4583333 0.280847 10.4611111 0.280258 10.4638889 0.279374 10.4666667 0.279963 10.4694444 0.279669 10.4722222 0.279079 10.4750000 0.277311 10.4777778 0.274954 10.4805556 0.273481 10.4833333 0.272302 10.4861111 0.271418 10.4888889 0.269945 10.4916667 0.269650 10.4944444 0.273186 10.4972222 0.280847 10.5000000 0.290276 10.5027778 0.300589 10.5055556 0.314733 10.5083333 0.330350 10.5111111 0.343610 10.5138889 0.352155 10.5166667 0.355101 10.5194444 0.349208 10.5222222 0.330939 10.5250000 0.307072 10.5277778 0.286446 10.5305556 0.274954 10.5333333 0.273186 10.5361111 0.275249 10.5388889 0.277606 10.5416667 0.278785 10.5444444 0.278490 10.5472222 0.277901 10.5500000 0.277606 10.5527778 0.279079 10.5555556 0.279079 10.5583333 0.278195 10.5611111 0.277901 10.5638889 0.277311 10.5666667 0.277606 10.5694444 0.278490 10.5722222 0.278195 10.5750000 0.278195 10.5777778 0.278490 10.5805556 0.277606 10.5833333 0.278195 10.5861111 0.277901 10.5888889 0.278490 10.5916667 0.278195 10.5944444 0.277606 10.5972222 0.277901 10.6000000 0.278490 10.6027778 0.278785 10.6055556 0.278785 10.6083333 0.279079 10.6111111 0.279079 10.6138889 0.278195 10.6166667 0.278490 10.6194444 0.279079 10.6222222 0.279374 10.6250000 0.279374 10.6277778 0.279374 10.6305556 0.278785 10.6333333 0.278785 10.6361111 0.278785 10.6388889 0.279374 10.6416667 0.279079 10.6444444 0.278490 10.6472222 0.278195 10.6500000 0.278785 10.6527778 0.279374 10.6555556 0.279079 10.6583333 0.279374 10.6611111 0.279079 10.6638889 0.278195 10.6666667 0.277901 10.6694444 0.278785 10.6722222 0.279374 10.6750000 0.279669 10.6777778 0.279374 10.6805556 0.278195 10.6833333 0.278195 10.6861111 0.279079 10.6888889 0.279374 10.6916667 0.279669 10.6944444 0.278785 10.6972222 0.278195 10.7000000 0.278490 10.7027778 0.278785 10.7055556 0.279374 10.7083333 0.279079 10.7111111 0.278490 10.7138889 0.278490 10.7166667 0.278195 10.7194444 0.278490 10.7222222 0.279374 10.7250000 0.279374 10.7277778 0.278785 10.7305556 0.278785 10.7333333 0.279079 10.7361111 0.279669 10.7388889 0.279374 10.7416667 0.279669 10.7444444 0.279079 10.7472222 0.278195 10.7500000 0.278490 10.7527778 0.279079 10.7555556 0.278785 10.7583333 0.278490 10.7611111 0.278490 10.7638889 0.277606 10.7666667 0.277311 10.7694444 0.277901 10.7722222 0.278195 10.7750000 0.277901 10.7777778 0.277311 10.7805556 0.276722 10.7833333 0.277901 10.7861111 0.277311 10.7888889 0.277606 10.7916667 0.278195 10.7944444 0.277311 10.7972222 0.277311 10.8000000 0.277606 10.8027778 0.278195 10.8055556 0.278785 10.8083333 0.279374 10.8111111 0.280258 10.8168889 0.300000 11.1164444 0.300000 11.1194444 0.282615 11.1222222 0.283204 11.1250000 0.282615 11.1277778 0.282615 11.1305556 0.281731 11.1333333 0.282320 11.1361111 0.283204 11.1388889 0.283499 11.1416667 0.283794 11.1444444 0.283499 11.1472222 0.284383 11.1500000 0.285562 11.1527778 0.286446 11.1555556 0.285856 11.1583333 0.285856 11.1611111 0.285856 11.1638889 0.285562 11.1666667 0.287035 11.1694444 0.287035 11.1722222 0.287330 11.1750000 0.288214 11.1777778 0.288214 11.1805556 0.287624 11.1833333 0.287919 11.1861111 0.288508 11.1888889 0.287919 11.1916667 0.287624 11.1944444 0.287330 11.1972222 0.286740 11.2000000 0.286740 11.2027778 0.288214 11.2055556 0.288214 11.2083333 0.287624 11.2111111 0.286740 11.2138889 0.287035 11.2166667 0.288508 11.2194444 0.289392 11.2222222 0.289687 11.2250000 0.287919 11.2277778 0.285562 11.2305556 0.284383 11.2333333 0.283794 11.2361111 0.283499 11.2388889 0.283204 11.2416667 0.282320 11.2444444 0.281731 11.2472222 0.280847 11.2500000 0.281142 11.2527778 0.280847 11.2555556 0.281731 11.2583333 0.280847 11.2611111 0.280552 11.2638889 0.279963 11.2666667 0.280258 11.2694444 0.280552 11.2722222 0.280847 11.2750000 0.281142 11.2777778 0.279963 11.2805556 0.279669 11.2833333 0.279963 11.2861111 0.280552 11.2888889 0.280258 11.2916667 0.280552 11.2944444 0.279963 11.2972222 0.279963 11.3000000 0.280258 11.3027778 0.280258 11.3055556 0.280552 11.3083333 0.280258 11.3111111 0.279669 11.3138889 0.277901 11.3166667 0.276722 11.3194444 0.274659 11.3222222 0.274070 11.3250000 0.273481 11.3277778 0.273481 11.3305556 0.272007 11.3333333 0.271713 11.3361111 0.269945 11.3388889 0.267587 11.3416667 0.266114 11.3444444 0.267882 11.3472222 0.271123 11.3500000 0.277901 11.3527778 0.285267 11.3555556 0.292928 11.3583333 0.303536 11.3611111 0.316796 11.3638889 0.330939 11.3666667 0.343610 11.3694444 0.350681 11.3722222 0.352449 11.3750000 0.343020 11.3777778 0.325046 11.3805556 0.300884 11.3833333 0.283204 11.3861111 0.274365 11.3888889 0.273481 11.3916667 0.274365 11.3944444 0.277311 11.3972222 0.277606 11.4000000 0.278195 11.4027778 0.278195 11.4055556 0.278195 11.4083333 0.278785 11.4111111 0.278785 11.4138889 0.278195 11.4166667 0.277311 11.4194444 0.278490 11.4222222 0.278785 11.4250000 0.278490 11.4277778 0.278490 11.4305556 0.277901 11.4333333 0.277311 11.4361111 0.278785 11.4388889 0.278490 11.4416667 0.279079 11.4444444 0.277901 11.4472222 0.277606 11.4500000 0.277901 11.4527778 0.279079 11.4555556 0.279079 11.4583333 0.278785 11.4611111 0.278490 11.4638889 0.277606 11.4666667 0.278195 11.4694444 0.279079 11.4722222 0.279374 11.4750000 0.279079 11.4777778 0.278490 11.4805556 0.277606 11.4833333 0.278490 11.4861111 0.279079 11.4888889 0.279079 11.4916667 0.278490 11.4944444 0.277311 11.4972222 0.277017 11.5000000 0.277901 11.5027778 0.279079 11.5055556 0.278490 11.5083333 0.278785 11.5111111 0.279079 11.5138889 0.278490 11.5166667 0.278490 11.5194444 0.279079 11.5222222 0.279669 11.5250000 0.279669 11.5277778 0.278490 11.5305556 0.278785 11.5333333 0.277901 11.5361111 0.279079 11.5388889 0.278785 11.5416667 0.278490 11.5444444 0.278490 11.5472222 0.278195 11.5500000 0.278785 11.5527778 0.279079 11.5555556 0.278785 11.5583333 0.278490 11.5611111 0.277311 11.5638889 0.277606 11.5666667 0.278490 11.5694444 0.279079 11.5722222 0.280258 11.5750000 0.278785 11.5777778 0.278785 11.5805556 0.277311 11.5833333 0.277606 11.5861111 0.277901 11.5888889 0.278785 11.5916667 0.278785 11.5944444 0.278490 11.5972222 0.277901 11.6000000 0.278490 11.6027778 0.279079 11.6055556 0.278785 11.6083333 0.279374 11.6111111 0.278785 11.6138889 0.278195 11.6166667 0.278195 11.6194444 0.278490 11.6222222 0.278195 11.6250000 0.277606 11.6277778 0.277017 11.6305556 0.277311 11.6333333 0.277606 11.6361111 0.278195 11.6388889 0.278195 11.6416667 0.278490 11.6444444 0.278490 11.6472222 0.277017 11.6500000 0.277901 11.6527778 0.278195 11.6555556 0.279079 11.6583333 0.278490 11.6611111 0.278785 11.6638889 0.278195 11.6666667 0.279374 11.6724444 0.300000 11.9386667 0.300000 11.9416667 0.281436 11.9444444 0.280258 11.9472222 0.280258 11.9500000 0.280552 11.9527778 0.281731 11.9555556 0.281731 11.9583333 0.281436 11.9611111 0.280552 11.9638889 0.281142 11.9666667 0.281436 11.9694444 0.282320 11.9722222 0.283204 11.9750000 0.283499 11.9777778 0.284383 11.9805556 0.284678 11.9833333 0.284383 11.9861111 0.284678 11.9888889 0.284972 11.9916667 0.284678 11.9944444 0.285267 11.9972222 0.284972 12.0000000 0.285856 12.0027778 0.286446 12.0055556 0.287919 12.0083333 0.287624 12.0111111 0.286740 12.0138889 0.286151 12.0166667 0.286740 12.0194444 0.286740 12.0222222 0.286446 12.0250000 0.286740 12.0277778 0.285856 12.0305556 0.285856 12.0333333 0.286446 12.0361111 0.286151 12.0388889 0.285267 12.0416667 0.285267 12.0444444 0.284972 12.0472222 0.286151 12.0500000 0.287035 12.0527778 0.287919 12.0555556 0.287330 12.0583333 0.285856 12.0611111 0.284383 12.0638889 0.283499 12.0666667 0.283499 12.0694444 0.284088 12.0722222 0.284088 12.0750000 0.282910 12.0777778 0.281142 12.0805556 0.280258 12.0833333 0.279963 12.0861111 0.280552 12.0888889 0.280552 12.0916667 0.280258 12.0944444 0.279374 12.0972222 0.278785 12.1000000 0.279374 12.1027778 0.279374 12.1055556 0.279669 12.1083333 0.279374 12.1111111 0.279079 12.1138889 0.278490 12.1166667 0.278785 12.1194444 0.279079 12.1222222 0.279374 12.1250000 0.279963 12.1277778 0.278785 12.1305556 0.278195 12.1333333 0.278195 12.1361111 0.279079 12.1388889 0.279669 12.1416667 0.279374 12.1444444 0.278195 12.1472222 0.277311 12.1500000 0.275838 12.1527778 0.274070 12.1555556 0.272891 12.1583333 0.271123 12.1611111 0.268177 12.1638889 0.266703 12.1666667 0.267587 12.1694444 0.271418 12.1722222 0.278490 12.1750000 0.284972 12.1777778 0.292634 12.1805556 0.305304 12.1833333 0.321215 12.1861111 0.335359 12.1888889 0.344199 12.1916667 0.346851 12.1944444 0.341252 12.1972222 0.325930 12.2000000 0.305599 12.2027778 0.289098 12.2055556 0.278195 12.2083333 0.272302 12.2111111 0.271123 12.2138889 0.272302 12.2166667 0.274070 12.2194444 0.274954 12.2222222 0.275838 12.2250000 0.275838 12.2277778 0.275838 12.2305556 0.275249 12.2333333 0.276427 12.2361111 0.276722 12.2388889 0.276133 12.2416667 0.275838 12.2444444 0.276133 12.2472222 0.275249 12.2500000 0.276722 12.2527778 0.276722 12.2555556 0.277017 12.2583333 0.276722 12.2611111 0.276722 12.2638889 0.275838 12.2666667 0.276427 12.2694444 0.276427 12.2722222 0.275838 12.2750000 0.276427 12.2777778 0.276133 12.2805556 0.275838 12.2833333 0.275838 12.2861111 0.276427 12.2888889 0.277017 12.2916667 0.277017 12.2944444 0.276427 12.2972222 0.276427 12.3000000 0.276722 12.3027778 0.277017 12.3055556 0.277311 12.3083333 0.277017 12.3111111 0.275838 12.3138889 0.275838 12.3166667 0.275838 12.3194444 0.275543 12.3222222 0.275838 12.3250000 0.276133 12.3277778 0.275249 12.3305556 0.275249 12.3333333 0.275249 12.3361111 0.275543 12.3388889 0.275838 12.3416667 0.275543 12.3444444 0.274954 12.3472222 0.274954 12.3500000 0.275249 12.3527778 0.274954 12.3555556 0.275249 12.3583333 0.275838 12.3611111 0.275838 12.3638889 0.275543 12.3666667 0.275838 12.3694444 0.275838 12.3722222 0.276427 12.3750000 0.276133 12.3777778 0.276133 12.3805556 0.274954 12.3833333 0.275249 12.3861111 0.275838 12.3888889 0.276427 12.3916667 0.276133 12.3944444 0.275543 12.3972222 0.275249 12.4000000 0.275838 12.4027778 0.275838 12.4055556 0.276427 12.4083333 0.275838 12.4111111 0.275543 12.4138889 0.275249 12.4166667 0.275838 12.4194444 0.276427 12.4222222 0.277017 12.4250000 0.276427 12.4277778 0.275543 12.4305556 0.275249 12.4333333 0.275543 12.4361111 0.275543 12.4388889 0.276427 12.4416667 0.275543 12.4444444 0.274659 12.4472222 0.273481 12.4500000 0.274070 12.4527778 0.274070 12.4555556 0.274365 12.4583333 0.274365 12.4611111 0.274070 12.4638889 0.273481 12.4666667 0.274365 12.4694444 0.274070 12.4722222 0.274659 12.4750000 0.274070 12.4777778 0.273775 12.4805556 0.273775 12.4833333 0.274070 12.4861111 0.274365 12.4888889 0.275249 12.4946667 0.300000 12.7664444 0.300000 12.7694444 0.279374 12.7722222 0.280258 12.7750000 0.279669 12.7777778 0.279374 12.7805556 0.279374 12.7833333 0.279079 12.7861111 0.279963 12.7888889 0.280258 12.7916667 0.280552 12.7944444 0.279963 12.7972222 0.279079 12.8000000 0.279079 12.8027778 0.280552 12.8055556 0.281436 12.8083333 0.281436 12.8111111 0.281436 12.8138889 0.281142 12.8166667 0.282320 12.8194444 0.282320 12.8222222 0.283499 12.8250000 0.284383 12.8277778 0.283499 12.8305556 0.283204 12.8333333 0.284383 12.8361111 0.286151 12.8388889 0.286446 12.8416667 0.286446 12.8444444 0.285562 12.8472222 0.284972 12.8500000 0.285267 12.8527778 0.285562 12.8555556 0.285267 12.8583333 0.284972 12.8611111 0.284383 12.8638889 0.284088 12.8666667 0.282910 12.8694444 0.283499 12.8722222 0.283794 12.8750000 0.284678 12.8777778 0.284972 12.8805556 0.284678 12.8833333 0.283794 12.8861111 0.282615 12.8888889 0.282320 12.8916667 0.282026 12.8944444 0.280258 12.8972222 0.279079 12.9000000 0.279374 12.9027778 0.279374 12.9055556 0.279374 12.9083333 0.279079 12.9111111 0.278195 12.9138889 0.278195 12.9166667 0.278785 12.9194444 0.278490 12.9222222 0.279079 12.9250000 0.278490 12.9277778 0.277901 12.9305556 0.277311 12.9333333 0.277606 12.9361111 0.277901 12.9388889 0.279079 12.9416667 0.278195 12.9444444 0.277311 12.9472222 0.277017 12.9500000 0.277017 12.9527778 0.278195 12.9555556 0.278785 12.9583333 0.278195 12.9611111 0.277606 12.9638889 0.277311 12.9666667 0.277606 12.9694444 0.277901 12.9722222 0.278195 12.9750000 0.277606 12.9777778 0.276133 12.9805556 0.273775 12.9833333 0.272597 12.9861111 0.271713 12.9888889 0.271418 12.9916667 0.269061 12.9944444 0.267293 12.9972222 0.268471 13.0000000 0.273481 13.0027778 0.280847 13.0055556 0.289098 13.0083333 0.298527 13.0111111 0.310902 13.0138889 0.325341 13.0166667 0.338895 13.0194444 0.348029 13.0222222 0.350092 13.0250000 0.344199 13.0277778 0.328582 13.0305556 0.306483 13.0333333 0.287624 13.0361111 0.277017 13.0388889 0.272891 13.0416667 0.271418 13.0444444 0.272302 13.0472222 0.273481 13.0500000 0.274954 13.0527778 0.275543 13.0555556 0.276133 13.0583333 0.275543 13.0611111 0.275543 13.0638889 0.275249 13.0666667 0.276427 13.0694444 0.276722 13.0722222 0.277311 13.0750000 0.276722 13.0777778 0.276427 13.0805556 0.275249 13.0833333 0.275838 13.0861111 0.276427 13.0888889 0.276427 13.0916667 0.276133 13.0944444 0.276133 13.0972222 0.274365 13.1000000 0.275249 13.1027778 0.275838 13.1055556 0.276133 13.1083333 0.275543 13.1111111 0.274659 13.1138889 0.274070 13.1166667 0.274365 13.1194444 0.275543 13.1222222 0.275249 13.1250000 0.274659 13.1277778 0.275543 13.1305556 0.274659 13.1333333 0.274954 13.1361111 0.275249 13.1388889 0.275249 13.1416667 0.275543 13.1444444 0.274954 13.1472222 0.274954 13.1500000 0.275249 13.1527778 0.275838 13.1555556 0.275838 13.1583333 0.275838 13.1611111 0.275249 13.1638889 0.274659 13.1666667 0.275249 13.1694444 0.275543 13.1722222 0.276722 13.1750000 0.276133 13.1777778 0.275543 13.1805556 0.274659 13.1833333 0.275249 13.1861111 0.275249 13.1888889 0.275543 13.1916667 0.275249 13.1944444 0.274954 13.1972222 0.274070 13.2000000 0.274659 13.2027778 0.274954 13.2055556 0.275543 13.2083333 0.275249 13.2111111 0.274954 13.2138889 0.274070 13.2166667 0.274659 13.2194444 0.274659 13.2222222 0.274954 13.2250000 0.275249 13.2277778 0.275543 13.2305556 0.274954 13.2333333 0.274659 13.2361111 0.274954 13.2388889 0.275543 13.2416667 0.276133 13.2444444 0.276133 13.2472222 0.274954 13.2500000 0.275543 13.2527778 0.275249 13.2555556 0.275249 13.2583333 0.275249 13.2611111 0.274365 13.2638889 0.274365 13.2666667 0.274070 13.2694444 0.275249 13.2722222 0.274659 13.2750000 0.273481 13.2777778 0.273186 13.2805556 0.272597 13.2833333 0.272597 13.2861111 0.272597 13.2888889 0.272597 13.2916667 0.272597 13.2944444 0.272302 13.2972222 0.271123 13.3000000 0.271418 13.3027778 0.272891 13.3055556 0.273186 13.3083333 0.272891 13.3111111 0.273186 13.3138889 0.273186 13.3166667 0.274070 13.3224444 0.300000 13.5886667 0.300000 13.5916667 0.280258 13.5944444 0.279079 13.5972222 0.279669 13.6000000 0.279963 13.6027778 0.280552 13.6055556 0.279963 13.6083333 0.279669 13.6111111 0.279374 13.6138889 0.279079 13.6166667 0.279374 13.6194444 0.280258 13.6222222 0.280552 13.6250000 0.280552 13.6277778 0.280552 13.6305556 0.280552 13.6333333 0.282026 13.6361111 0.283204 13.6388889 0.283794 13.6416667 0.283499 13.6444444 0.283204 13.6472222 0.282910 13.6500000 0.283794 13.6527778 0.284678 13.6555556 0.285562 13.6583333 0.285856 13.6611111 0.285856 13.6638889 0.285856 13.6666667 0.286151 13.6694444 0.286740 13.6722222 0.287035 13.6750000 0.286446 13.6777778 0.285856 13.6805556 0.284972 13.6833333 0.284972 13.6861111 0.285856 13.6888889 0.285856 13.6916667 0.285267 13.6944444 0.284088 13.6972222 0.284088 13.7000000 0.285856 13.7027778 0.286446 13.7055556 0.286740 13.7083333 0.284383 13.7111111 0.282615 13.7138889 0.282026 13.7166667 0.280847 13.7194444 0.281436 13.7222222 0.280847 13.7250000 0.280552 13.7277778 0.279669 13.7305556 0.278785 13.7333333 0.278490 13.7361111 0.279079 13.7388889 0.279669 13.7416667 0.279963 13.7444444 0.280258 13.7472222 0.278785 13.7500000 0.279079 13.7527778 0.279669 13.7555556 0.280258 13.7583333 0.279079 13.7611111 0.279374 13.7638889 0.277901 13.7666667 0.277901 13.7694444 0.278490 13.7722222 0.278490 13.7750000 0.279374 13.7777778 0.278195 13.7805556 0.277606 13.7833333 0.278490 13.7861111 0.278195 13.7888889 0.279079 13.7916667 0.278195 13.7944444 0.277606 13.7972222 0.277311 13.8000000 0.277311 13.8027778 0.276427 13.8055556 0.274659 13.8083333 0.272597 13.8111111 0.271418 13.8138889 0.269355 13.8166667 0.267293 13.8194444 0.269061 13.8222222 0.274365 13.8250000 0.282026 13.8277778 0.290866 13.8305556 0.300589 13.8333333 0.315322 13.8361111 0.331529 13.8388889 0.344788 13.8416667 0.352449 13.8444444 0.353333 13.8472222 0.341547 13.8500000 0.321215 13.8527778 0.298232 13.8555556 0.281142 13.8583333 0.273186 13.8611111 0.272007 13.8638889 0.274070 13.8666667 0.276722 13.8694444 0.277606 13.8722222 0.277606 13.8750000 0.277311 13.8777778 0.276722 13.8805556 0.276427 13.8833333 0.276133 13.8861111 0.276722 13.8888889 0.275838 13.8916667 0.277017 13.8944444 0.276722 13.8972222 0.276133 13.9000000 0.276133 13.9027778 0.276722 13.9055556 0.277311 13.9083333 0.277311 13.9111111 0.276133 13.9138889 0.276133 13.9166667 0.276427 13.9194444 0.277311 13.9222222 0.277606 13.9250000 0.277311 13.9277778 0.276133 13.9305556 0.275838 13.9333333 0.276427 13.9361111 0.276722 13.9388889 0.277311 13.9416667 0.276722 13.9444444 0.275838 13.9472222 0.276133 13.9500000 0.276133 13.9527778 0.276722 13.9555556 0.277017 13.9583333 0.276722 13.9611111 0.276722 13.9638889 0.276133 13.9666667 0.275838 13.9694444 0.276427 13.9722222 0.277311 13.9750000 0.276722 13.9777778 0.276427 13.9805556 0.276722 13.9833333 0.277311 13.9861111 0.277311 13.9888889 0.277901 13.9916667 0.277901 13.9944444 0.277606 13.9972222 0.276722 14.0000000 0.277311 14.0027778 0.277017 14.0055556 0.277311 14.0083333 0.277606 14.0111111 0.277017 14.0138889 0.276427 14.0166667 0.276427 14.0194444 0.277017 14.0222222 0.278490 14.0250000 0.277901 14.0277778 0.277311 14.0305556 0.276427 14.0333333 0.276427 14.0361111 0.277017 14.0388889 0.277606 14.0416667 0.277901 14.0444444 0.277311 14.0472222 0.276722 14.0500000 0.277606 14.0527778 0.278195 14.0555556 0.278490 14.0583333 0.278490 14.0611111 0.277901 14.0638889 0.277311 14.0666667 0.277901 14.0694444 0.277901 14.0722222 0.278490 14.0750000 0.278195 14.0777778 0.277901 14.0805556 0.276427 14.0833333 0.276722 14.0861111 0.276133 14.0888889 0.278195 14.0916667 0.277311 14.0944444 0.276427 14.0972222 0.275838 14.1000000 0.276427 14.1027778 0.276722 14.1055556 0.277901 14.1083333 0.277606 14.1111111 0.277311 14.1138889 0.276133 14.1166667 0.277311 14.1194444 0.277901 14.1222222 0.278195 14.1250000 0.278490 14.1277778 0.278490 14.1305556 0.279374 14.1333333 0.279079 14.1361111 0.281142 14.1388889 0.281731 14.1446667 0.300000 14.3831111 0.300000 14.3861111 0.281142 14.3888889 0.281731 14.3916667 0.282026 14.3944444 0.281436 14.3972222 0.280552 14.4000000 0.281142 14.4027778 0.281731 14.4055556 0.282026 14.4083333 0.282320 14.4111111 0.282615 14.4138889 0.281142 14.4166667 0.281731 14.4194444 0.282320 14.4222222 0.283794 14.4250000 0.284088 14.4277778 0.284678 14.4305556 0.285267 14.4333333 0.286151 14.4361111 0.286446 14.4388889 0.286740 14.4416667 0.286446 14.4444444 0.286446 14.4472222 0.285856 14.4500000 0.286446 14.4527778 0.286740 14.4555556 0.287919 14.4583333 0.287919 14.4611111 0.288214 14.4638889 0.287624 14.4666667 0.288508 14.4694444 0.288214 14.4722222 0.288803 14.4750000 0.288214 14.4777778 0.287624 14.4805556 0.286740 14.4833333 0.286740 14.4861111 0.287035 14.4888889 0.287035 14.4916667 0.287035 14.4944444 0.286446 14.4972222 0.285267 14.5000000 0.285562 14.5027778 0.286446 14.5055556 0.287919 14.5083333 0.289098 14.5111111 0.288508 14.5138889 0.286740 14.5166667 0.285267 14.5194444 0.284972 14.5222222 0.284383 14.5250000 0.283794 14.5277778 0.282026 14.5305556 0.281142 14.5333333 0.280847 14.5361111 0.280847 14.5388889 0.280552 14.5416667 0.280552 14.5444444 0.280847 14.5472222 0.280258 14.5500000 0.279963 14.5527778 0.280258 14.5555556 0.281142 14.5583333 0.280258 14.5611111 0.279669 14.5638889 0.279079 14.5666667 0.279374 14.5694444 0.279079 14.5722222 0.279374 14.5750000 0.279669 14.5777778 0.279963 14.5805556 0.279079 14.5833333 0.279374 14.5861111 0.279963 14.5888889 0.279963 14.5916667 0.279963 14.5944444 0.279079 14.5972222 0.276427 14.6000000 0.274365 14.6027778 0.273186 14.6055556 0.272302 14.6083333 0.270534 14.6111111 0.268177 14.6138889 0.267882 14.6166667 0.272597 14.6194444 0.279079 14.6222222 0.287624 14.6250000 0.297937 14.6277778 0.310902 14.6305556 0.325635 14.6333333 0.339779 14.6361111 0.348324 14.6388889 0.348619 14.6416667 0.337716 14.6444444 0.318858 14.6472222 0.295875 14.6500000 0.279963 14.6527778 0.273775 14.6555556 0.273775 14.6583333 0.275838 14.6611111 0.277606 14.6638889 0.277901 14.6666667 0.277901 14.6694444 0.278195 14.6722222 0.278490 14.6750000 0.278785 14.6777778 0.278195 14.6805556 0.277901 14.6833333 0.278195 14.6861111 0.278785 14.6888889 0.279374 14.6916667 0.279079 14.6944444 0.278490 14.6972222 0.277606 14.7000000 0.277606 14.7027778 0.278195 14.7055556 0.278490 14.7083333 0.278490 14.7111111 0.277606 14.7138889 0.277311 14.7166667 0.277017 14.7194444 0.277606 14.7222222 0.277901 14.7250000 0.277901 14.7277778 0.277606 14.7305556 0.277017 14.7333333 0.277606 14.7361111 0.277901 14.7388889 0.278195 14.7416667 0.278490 14.7444444 0.277901 14.7472222 0.277311 14.7500000 0.278490 14.7527778 0.278785 14.7555556 0.279374 14.7583333 0.279079 14.7611111 0.279079 14.7638889 0.278195 14.7666667 0.278490 14.7694444 0.279374 14.7722222 0.278785 14.7750000 0.278490 14.7777778 0.278490 14.7805556 0.277901 14.7833333 0.277901 14.7861111 0.279079 14.7888889 0.279079 14.7916667 0.278195 14.7944444 0.277901 14.7972222 0.277606 14.8000000 0.277311 14.8027778 0.278195 14.8055556 0.278195 14.8083333 0.278785 14.8111111 0.278195 14.8138889 0.277901 14.8166667 0.278490 14.8194444 0.279079 14.8222222 0.279669 14.8250000 0.278785 14.8277778 0.279079 14.8305556 0.278490 14.8333333 0.278785 14.8361111 0.279669 14.8388889 0.280258 14.8416667 0.280258 14.8444444 0.279079 14.8472222 0.279079 14.8500000 0.279374 14.8527778 0.279963 14.8555556 0.279374 14.8583333 0.279374 14.8611111 0.279079 14.8638889 0.278490 14.8666667 0.278785 14.8694444 0.278490 14.8722222 0.278490 14.8750000 0.278490 14.8777778 0.278195 14.8805556 0.277901 14.8833333 0.277606 14.8861111 0.278490 14.8888889 0.279374 14.8916667 0.278785 14.8944444 0.278490 14.8972222 0.277606 14.9000000 0.277901 14.9027778 0.278195 14.9055556 0.278785 14.9083333 0.278490 14.9111111 0.277901 14.9138889 0.277606 14.9166667 0.277901 14.9194444 0.278785 14.9222222 0.279079 14.9250000 0.279079 14.9277778 0.279079 14.9305556 0.279374 14.9333333 0.279374 14.9391111 0.300000 15.1803333 0.300000 15.1833333 0.280258 15.1861111 0.280847 15.1888889 0.280847 15.1916667 0.281142 15.1944444 0.280847 15.1972222 0.280258 15.2000000 0.281142 15.2027778 0.281142 15.2055556 0.281731 15.2083333 0.281731 15.2111111 0.281142 15.2138889 0.280552 15.2166667 0.279963 15.2194444 0.280847 15.2222222 0.282026 15.2250000 0.282026 15.2277778 0.282910 15.2305556 0.282910 15.2333333 0.284088 15.2361111 0.284383 15.2388889 0.284383 15.2416667 0.284678 15.2444444 0.284678 15.2472222 0.284088 15.2500000 0.283794 15.2527778 0.284678 15.2555556 0.285562 15.2583333 0.286151 15.2611111 0.286446 15.2638889 0.285562 15.2666667 0.285856 15.2694444 0.286446 15.2722222 0.285856 15.2750000 0.286740 15.2777778 0.285856 15.2805556 0.285562 15.2833333 0.285856 15.2861111 0.287035 15.2888889 0.287035 15.2916667 0.286446 15.2944444 0.285562 15.2972222 0.284972 15.3000000 0.285856 15.3027778 0.287330 15.3055556 0.286740 15.3083333 0.284972 15.3111111 0.283204 15.3138889 0.281731 15.3166667 0.281731 15.3194444 0.280552 15.3222222 0.280258 15.3250000 0.279374 15.3277778 0.279374 15.3305556 0.278785 15.3333333 0.279079 15.3361111 0.279963 15.3388889 0.279963 15.3416667 0.280258 15.3444444 0.279374 15.3472222 0.278785 15.3500000 0.278785 15.3527778 0.279669 15.3555556 0.279669 15.3583333 0.279374 15.3611111 0.279374 15.3638889 0.278785 15.3666667 0.279374 15.3694444 0.279374 15.3722222 0.279669 15.3750000 0.279079 15.3777778 0.279079 15.3805556 0.278195 15.3833333 0.277901 15.3861111 0.277017 15.3888889 0.274954 15.3916667 0.273186 15.3944444 0.272007 15.3972222 0.270534 15.4000000 0.268177 15.4027778 0.266409 15.4055556 0.269945 15.4083333 0.275543 15.4111111 0.280258 15.4138889 0.284678 15.4166667 0.291160 15.4194444 0.299705 15.4222222 0.312081 15.4250000 0.327698 15.4277778 0.340074 15.4305556 0.348619 15.4333333 0.354512 15.4361111 0.357164 15.4388889 0.352155 15.4416667 0.340663 15.4444444 0.324457 15.4472222 0.306188 15.4500000 0.291160 15.4527778 0.279669 15.4555556 0.274365 15.4583333 0.272597 15.4611111 0.273186 15.4638889 0.274954 15.4666667 0.275543 15.4694444 0.276722 15.4722222 0.277901 15.4750000 0.278195 15.4777778 0.276722 15.4805556 0.276427 15.4833333 0.276427 15.4861111 0.275838 15.4888889 0.276427 15.4916667 0.276133 15.4944444 0.276427 15.4972222 0.276133 15.5000000 0.276722 15.5027778 0.277017 15.5055556 0.277606 15.5083333 0.277311 15.5111111 0.276133 15.5138889 0.275249 15.5166667 0.276133 15.5194444 0.276427 15.5222222 0.277017 15.5250000 0.277606 15.5277778 0.276722 15.5305556 0.276722 15.5333333 0.276427 15.5361111 0.277017 15.5388889 0.275838 15.5416667 0.276133 15.5444444 0.275838 15.5472222 0.275838 15.5500000 0.276722 15.5527778 0.277311 15.5555556 0.276722 15.5583333 0.276133 15.5611111 0.275249 15.5638889 0.274365 15.5666667 0.275543 15.5694444 0.276133 15.5722222 0.275838 15.5750000 0.276427 15.5777778 0.275838 15.5805556 0.275543 15.5833333 0.275838 15.5861111 0.276427 15.5888889 0.276133 15.5916667 0.277017 15.5944444 0.277017 15.5972222 0.276427 15.6000000 0.277017 15.6027778 0.277017 15.6055556 0.277017 15.6083333 0.276722 15.6111111 0.275249 15.6138889 0.275249 15.6166667 0.275543 15.6194444 0.275838 15.6222222 0.276722 15.6250000 0.276722 15.6277778 0.276427 15.6305556 0.275543 15.6333333 0.275543 15.6361111 0.276427 15.6388889 0.276427 15.6416667 0.277311 15.6444444 0.277017 15.6472222 0.275838 15.6500000 0.276722 15.6527778 0.277017 15.6555556 0.277606 15.6583333 0.277901 15.6611111 0.277017 15.6638889 0.276133 15.6666667 0.275249 15.6694444 0.275543 15.6722222 0.275543 15.6750000 0.275543 15.6777778 0.274365 15.6805556 0.272597 15.6833333 0.273186 15.6861111 0.272597 15.6888889 0.272891 15.6916667 0.273775 15.6944444 0.273186 15.6972222 0.272597 15.7000000 0.272007 15.7027778 0.273186 15.7055556 0.272891 15.7083333 0.273481 15.7111111 0.273186 15.7138889 0.272302 15.7166667 0.273186 15.7194444 0.274070 15.7222222 0.275249 15.7250000 0.275543 15.7277778 0.275249 15.7305556 0.275838 15.7363333 0.300000 15.9720000 0.300000 15.9750000 0.279374 15.9777778 0.278490 15.9805556 0.279079 15.9833333 0.279374 15.9861111 0.279963 15.9888889 0.279963 15.9916667 0.279079 15.9944444 0.279079 15.9972222 0.279374 16.0000000 0.279374 16.0027778 0.280258 16.0055556 0.279963 16.0083333 0.279963 16.0111111 0.280552 16.0138889 0.279374 16.0166667 0.281436 16.0194444 0.282320 16.0222222 0.282910 16.0250000 0.283794 16.0277778 0.283499 16.0305556 0.283204 16.0333333 0.283794 16.0361111 0.284088 16.0388889 0.284972 16.0416667 0.285856 16.0444444 0.285267 16.0472222 0.284972 16.0500000 0.285856 16.0527778 0.286740 16.0555556 0.286740 16.0583333 0.285856 16.0611111 0.284972 16.0638889 0.284678 16.0666667 0.283794 16.0694444 0.284678 16.0722222 0.285562 16.0750000 0.284972 16.0777778 0.284383 16.0805556 0.283499 16.0833333 0.284088 16.0861111 0.285267 16.0888889 0.286151 16.0916667 0.286446 16.0944444 0.285562 16.0972222 0.284088 16.1000000 0.283499 16.1027778 0.283499 16.1055556 0.282910 16.1083333 0.281436 16.1111111 0.280258 16.1138889 0.279079 16.1166667 0.279079 16.1194444 0.279079 16.1222222 0.278785 16.1250000 0.278785 16.1277778 0.277901 16.1305556 0.277606 16.1333333 0.278785 16.1361111 0.279079 16.1388889 0.279374 16.1416667 0.279669 16.1444444 0.278195 16.1472222 0.278195 16.1500000 0.279079 16.1527778 0.279079 16.1555556 0.279374 16.1583333 0.279669 16.1611111 0.279079 16.1638889 0.279079 16.1666667 0.278785 16.1694444 0.279079 16.1722222 0.279079 16.1750000 0.279079 16.1777778 0.278785 16.1805556 0.277901 16.1833333 0.278195 16.1861111 0.277017 16.1888889 0.274954 16.1916667 0.272597 16.1944444 0.271123 16.1972222 0.269061 16.2000000 0.266998 16.2027778 0.266998 16.2055556 0.270829 16.2083333 0.278785 16.2111111 0.287035 16.2138889 0.297348 16.2166667 0.311197 16.2194444 0.327993 16.2222222 0.342726 16.2250000 0.352744 16.2277778 0.352744 16.2305556 0.341842 16.2333333 0.320626 16.2361111 0.296759 16.2388889 0.279374 16.2416667 0.271713 16.2444444 0.271123 16.2472222 0.272597 16.2500000 0.275543 16.2527778 0.276133 16.2555556 0.276722 16.2583333 0.276133 16.2611111 0.275249 16.2638889 0.276722 16.2666667 0.275543 16.2694444 0.276427 16.2722222 0.277017 16.2750000 0.277311 16.2777778 0.276722 16.2805556 0.276133 16.2833333 0.276722 16.2861111 0.276427 16.2888889 0.277017 16.2916667 0.277017 16.2944444 0.276427 16.2972222 0.275543 16.3000000 0.276133 16.3027778 0.277017 16.3055556 0.277606 16.3083333 0.277606 16.3111111 0.276133 16.3138889 0.277017 16.3166667 0.276427 16.3194444 0.277017 16.3222222 0.277606 16.3250000 0.277606 16.3277778 0.276133 16.3305556 0.276427 16.3333333 0.275838 16.3361111 0.276427 16.3388889 0.276722 16.3416667 0.276427 16.3444444 0.276427 16.3472222 0.276133 16.3500000 0.277017 16.3527778 0.277606 16.3555556 0.277311 16.3583333 0.277311 16.3611111 0.277017 16.3638889 0.276133 16.3666667 0.276427 16.3694444 0.276427 16.3722222 0.277017 16.3750000 0.277017 16.3777778 0.275838 16.3805556 0.275838 16.3833333 0.276133 16.3861111 0.276427 16.3888889 0.275838 16.3916667 0.276133 16.3944444 0.275838 16.3972222 0.275543 16.4000000 0.275838 16.4027778 0.276133 16.4055556 0.276722 16.4083333 0.276133 16.4111111 0.276427 16.4138889 0.276427 16.4166667 0.276722 16.4194444 0.276133 16.4222222 0.277606 16.4250000 0.277311 16.4277778 0.277017 16.4305556 0.275838 16.4333333 0.276722 16.4361111 0.277017 16.4388889 0.277606 16.4416667 0.277311 16.4444444 0.276133 16.4472222 0.276133 16.4500000 0.276133 16.4527778 0.276427 16.4555556 0.275838 16.4583333 0.275838 16.4611111 0.275543 16.4638889 0.274365 16.4666667 0.274659 16.4694444 0.275543 16.4722222 0.275249 16.4750000 0.275249 16.4777778 0.274070 16.4805556 0.274070 16.4833333 0.274365 16.4861111 0.274365 16.4888889 0.274365 16.4916667 0.274659 16.4944444 0.273775 16.4972222 0.273775 16.5000000 0.275249 16.5027778 0.274954 16.5055556 0.275838 16.5083333 0.276133 16.5111111 0.276427 16.5138889 0.275838 16.5166667 0.277606 16.5194444 0.278195 16.5222222 0.279374 16.5280000 0.300000 16.7942222 0.300000 16.7972222 0.280847 16.8000000 0.281436 16.8027778 0.282320 16.8055556 0.282615 16.8083333 0.281731 16.8111111 0.281436 16.8138889 0.281142 16.8166667 0.281436 16.8194444 0.281731 16.8222222 0.282615 16.8250000 0.283204 16.8277778 0.284088 16.8305556 0.285267 16.8333333 0.285562 16.8361111 0.286446 16.8388889 0.287035 16.8416667 0.286740 16.8444444 0.286151 16.8472222 0.286446 16.8500000 0.287035 16.8527778 0.287919 16.8555556 0.288803 16.8583333 0.288803 16.8611111 0.288803 16.8638889 0.287919 16.8666667 0.287919 16.8694444 0.287919 16.8722222 0.287624 16.8750000 0.287330 16.8777778 0.286740 16.8805556 0.286446 16.8833333 0.286740 16.8861111 0.287035 16.8888889 0.287035 16.8916667 0.285856 16.8944444 0.285856 16.8972222 0.286446 16.9000000 0.287919 16.9027778 0.288508 16.9055556 0.288508 16.9083333 0.287035 16.9111111 0.285562 16.9138889 0.283794 16.9166667 0.284678 16.9194444 0.283794 16.9222222 0.283204 16.9250000 0.282320 16.9277778 0.282320 16.9305556 0.281731 16.9333333 0.281731 16.9361111 0.281142 16.9388889 0.281142 16.9416667 0.280847 16.9444444 0.280258 16.9472222 0.279669 16.9500000 0.280258 16.9527778 0.280258 16.9555556 0.280552 16.9583333 0.280258 16.9611111 0.279669 16.9638889 0.278785 16.9666667 0.279669 16.9694444 0.280258 16.9722222 0.279669 16.9750000 0.279669 16.9777778 0.279079 16.9805556 0.278785 16.9833333 0.279079 16.9861111 0.279963 16.9888889 0.279963 16.9916667 0.279374 16.9944444 0.279374 16.9972222 0.279079 17.0000000 0.279079 17.0027778 0.279079 17.0055556 0.278195 17.0083333 0.274954 17.0111111 0.272597 17.0138889 0.271713 17.0166667 0.270534 17.0194444 0.268766 17.0222222 0.268471 17.0250000 0.271418 17.0277778 0.276722 17.0305556 0.284972 17.0333333 0.294401 17.0361111 0.305599 17.0388889 0.320626 17.0416667 0.337127 17.0444444 0.349797 17.0472222 0.356280 17.0500000 0.357459 17.0527778 0.348619 17.0555556 0.328287 17.0583333 0.303241 17.0611111 0.284088 17.0638889 0.273186 17.0666667 0.271418 17.0694444 0.274070 17.0722222 0.276133 17.0750000 0.277901 17.0777778 0.277901 17.0805556 0.277017 17.0833333 0.277606 17.0861111 0.278785 17.0888889 0.279079 17.0916667 0.279669 17.0944444 0.278490 17.0972222 0.277901 17.1000000 0.278195 17.1027778 0.278195 17.1055556 0.279079 17.1083333 0.278195 17.1111111 0.277901 17.1138889 0.277606 17.1166667 0.277311 17.1194444 0.277606 17.1222222 0.277606 17.1250000 0.277606 17.1277778 0.277311 17.1305556 0.276722 17.1333333 0.276722 17.1361111 0.277017 17.1388889 0.277311 17.1416667 0.277606 17.1444444 0.277606 17.1472222 0.276722 17.1500000 0.277017 17.1527778 0.277606 17.1555556 0.278195 17.1583333 0.277901 17.1611111 0.277311 17.1638889 0.277606 17.1666667 0.277901 17.1694444 0.278490 17.1722222 0.278785 17.1750000 0.278490 17.1777778 0.278490 17.1805556 0.277311 17.1833333 0.278195 17.1861111 0.278490 17.1888889 0.279079 17.1916667 0.277311 17.1944444 0.276722 17.1972222 0.276722 17.2000000 0.277311 17.2027778 0.278195 17.2055556 0.277606 17.2083333 0.278195 17.2111111 0.277901 17.2138889 0.277017 17.2166667 0.277311 17.2194444 0.277606 17.2222222 0.278195 17.2250000 0.278195 17.2277778 0.277311 17.2305556 0.277311 17.2333333 0.277606 17.2361111 0.277311 17.2388889 0.278195 17.2416667 0.277901 17.2444444 0.277901 17.2472222 0.277606 17.2500000 0.277606 17.2527778 0.279079 17.2555556 0.278785 17.2583333 0.278490 17.2611111 0.278195 17.2638889 0.277606 17.2666667 0.278195 17.2694444 0.277901 17.2722222 0.278785 17.2750000 0.278195 17.2777778 0.277606 17.2805556 0.277311 17.2833333 0.277901 17.2861111 0.277901 17.2888889 0.278195 17.2916667 0.278195 17.2944444 0.277311 17.2972222 0.276427 17.3000000 0.276722 17.3027778 0.277311 17.3055556 0.276722 17.3083333 0.277606 17.3111111 0.276427 17.3138889 0.276427 17.3166667 0.276427 17.3194444 0.277017 17.3222222 0.277017 17.3250000 0.277311 17.3277778 0.276427 17.3305556 0.276427 17.3333333 0.277311 17.3361111 0.277606 17.3388889 0.277606 17.3416667 0.277311 17.3444444 0.277311 17.3502222 0.300000 17.6636667 0.300000 17.6666667 0.281142 17.6694444 0.282026 17.6722222 0.281731 17.6750000 0.282026 17.6777778 0.282615 17.6805556 0.281142 17.6833333 0.282026 17.6861111 0.282910 17.6888889 0.283204 17.6916667 0.283204 17.6944444 0.283204 17.6972222 0.283204 17.7000000 0.284383 17.7027778 0.285267 17.7055556 0.285267 17.7083333 0.285267 17.7111111 0.285267 17.7138889 0.285267 17.7166667 0.285267 17.7194444 0.286446 17.7222222 0.287330 17.7250000 0.286740 17.7277778 0.286740 17.7305556 0.286446 17.7333333 0.286446 17.7361111 0.286740 17.7388889 0.287330 17.7416667 0.287330 17.7444444 0.286446 17.7472222 0.285267 17.7500000 0.285856 17.7527778 0.286446 17.7555556 0.286446 17.7583333 0.285856 17.7611111 0.285267 17.7638889 0.284972 17.7666667 0.287035 17.7694444 0.288214 17.7722222 0.288214 17.7750000 0.286740 17.7777778 0.284383 17.7805556 0.282910 17.7833333 0.282910 17.7861111 0.282320 17.7888889 0.281731 17.7916667 0.280847 17.7944444 0.280258 17.7972222 0.279963 17.8000000 0.279374 17.8027778 0.279963 17.8055556 0.279963 17.8083333 0.279669 17.8111111 0.280552 17.8138889 0.279374 17.8166667 0.279669 17.8194444 0.279669 17.8222222 0.279963 17.8250000 0.279374 17.8277778 0.279079 17.8305556 0.279079 17.8333333 0.279079 17.8361111 0.279669 17.8388889 0.279963 17.8416667 0.279963 17.8444444 0.279079 17.8472222 0.278785 17.8500000 0.278785 17.8527778 0.279079 17.8555556 0.279669 17.8583333 0.279669 17.8611111 0.278785 17.8638889 0.278195 17.8666667 0.277901 17.8694444 0.278195 17.8722222 0.277606 17.8750000 0.275249 17.8777778 0.272597 17.8805556 0.271418 17.8833333 0.269650 17.8861111 0.267882 17.8888889 0.266114 17.8916667 0.267882 17.8944444 0.273481 17.8972222 0.280847 17.9000000 0.288508 17.9027778 0.297348 17.9055556 0.309724 17.9083333 0.325046 17.9111111 0.338600 17.9138889 0.347735 17.9166667 0.351565 17.9194444 0.348029 17.9222222 0.334770 17.9250000 0.312965 17.9277778 0.291160 17.9305556 0.277606 17.9333333 0.272302 17.9361111 0.272597 17.9388889 0.274954 17.9416667 0.277311 17.9444444 0.277901 17.9472222 0.276722 17.9500000 0.277311 17.9527778 0.277901 17.9555556 0.279079 17.9583333 0.278195 17.9611111 0.278785 17.9638889 0.278490 17.9666667 0.278195 17.9694444 0.278195 17.9722222 0.278785 17.9750000 0.278490 17.9777778 0.277901 17.9805556 0.277606 17.9833333 0.278195 17.9861111 0.278195 17.9888889 0.278195 17.9916667 0.277606 17.9944444 0.277311 17.9972222 0.276722 18.0000000 0.277017 18.0027778 0.277606 18.0055556 0.277901 18.0083333 0.277901 18.0111111 0.276722 18.0138889 0.276427 18.0166667 0.276722 18.0194444 0.278195 18.0222222 0.278195 18.0250000 0.278195 18.0277778 0.278490 18.0305556 0.277017 18.0333333 0.277311 18.0361111 0.277901 18.0388889 0.278785 18.0416667 0.277606 18.0444444 0.277017 18.0472222 0.277017 18.0500000 0.277311 18.0527778 0.277901 18.0555556 0.277901 18.0583333 0.277901 18.0611111 0.277606 18.0638889 0.277017 18.0666667 0.277606 18.0694444 0.278490 18.0722222 0.277606 18.0750000 0.277606 18.0777778 0.277311 18.0805556 0.277017 18.0833333 0.277017 18.0861111 0.277606 18.0888889 0.277606 18.0916667 0.277311 18.0944444 0.276722 18.0972222 0.276427 18.1000000 0.277311 18.1027778 0.277606 18.1055556 0.278785 18.1083333 0.278195 18.1111111 0.277901 18.1138889 0.278195 18.1166667 0.277311 18.1194444 0.278195 18.1222222 0.278490 18.1250000 0.278785 18.1277778 0.278490 18.1305556 0.277901 18.1333333 0.277606 18.1361111 0.278490 18.1388889 0.278195 18.1416667 0.278785 18.1444444 0.278195 18.1472222 0.276722 18.1500000 0.277311 18.1527778 0.277311 18.1555556 0.277017 18.1583333 0.277017 18.1611111 0.277017 18.1638889 0.275838 18.1666667 0.277017 18.1694444 0.277606 18.1722222 0.277017 18.1750000 0.277606 18.1777778 0.276722 18.1805556 0.276133 18.1833333 0.276133 18.1861111 0.276722 18.1888889 0.277017 18.1916667 0.277017 18.1944444 0.275838 18.1972222 0.275543 18.2000000 0.277017 18.2027778 0.277606 18.2055556 0.277017 18.2083333 0.277311 18.2111111 0.277017 18.2138889 0.277017 18.2196667 0.300000 18.4858889 0.300000 18.4888889 0.281436 18.4916667 0.281142 18.4944444 0.280847 18.4972222 0.280552 18.5000000 0.280552 18.5027778 0.281436 18.5055556 0.281731 18.5083333 0.282026 18.5111111 0.281731 18.5138889 0.281731 18.5166667 0.282320 18.5194444 0.283204 18.5222222 0.283794 18.5250000 0.284088 18.5277778 0.284088 18.5305556 0.283499 18.5333333 0.284383 18.5361111 0.284972 18.5388889 0.285267 18.5416667 0.285562 18.5444444 0.285267 18.5472222 0.285562 18.5500000 0.286740 18.5527778 0.287330 18.5555556 0.287035 18.5583333 0.287035 18.5611111 0.286446 18.5638889 0.286151 18.5666667 0.285856 18.5694444 0.285856 18.5722222 0.286446 18.5750000 0.286740 18.5777778 0.285856 18.5805556 0.284088 18.5833333 0.285267 18.5861111 0.284972 18.5888889 0.286151 18.5916667 0.286740 18.5944444 0.287330 18.5972222 0.285856 18.6000000 0.284678 18.6027778 0.283794 18.6055556 0.283204 18.6083333 0.281436 18.6111111 0.281142 18.6138889 0.279669 18.6166667 0.279374 18.6194444 0.279374 18.6222222 0.278785 18.6250000 0.278490 18.6277778 0.279079 18.6305556 0.278785 18.6333333 0.278785 18.6361111 0.278785 18.6388889 0.279374 18.6416667 0.279669 18.6444444 0.279079 18.6472222 0.277901 18.6500000 0.278490 18.6527778 0.279374 18.6555556 0.279669 18.6583333 0.279963 18.6611111 0.280258 18.6638889 0.279079 18.6666667 0.278490 18.6694444 0.279374 18.6722222 0.279669 18.6750000 0.279669 18.6777778 0.279079 18.6805556 0.278195 18.6833333 0.278195 18.6861111 0.278490 18.6888889 0.278785 18.6916667 0.277311 18.6944444 0.275543 18.6972222 0.273186 18.7000000 0.272597 18.7027778 0.272891 18.7055556 0.272007 18.7083333 0.270829 18.7111111 0.267293 18.7138889 0.265525 18.7166667 0.267587 18.7194444 0.272891 18.7222222 0.279669 18.7250000 0.287919 18.7277778 0.297643 18.7305556 0.311197 18.7333333 0.326814 18.7361111 0.340074 18.7388889 0.349503 18.7416667 0.351860 18.7444444 0.342726 18.7472222 0.323573 18.7500000 0.300000 18.7527778 0.283499 18.7555556 0.274365 18.7583333 0.269945 18.7611111 0.271418 18.7638889 0.272891 18.7666667 0.274659 18.7694444 0.276133 18.7722222 0.275838 18.7750000 0.275838 18.7777778 0.275543 18.7805556 0.276133 18.7833333 0.275543 18.7861111 0.276722 18.7888889 0.277017 18.7916667 0.276722 18.7944444 0.276133 18.7972222 0.275838 18.8000000 0.275838 18.8027778 0.276722 18.8055556 0.277017 18.8083333 0.276427 18.8111111 0.276427 18.8138889 0.276722 18.8166667 0.276427 18.8194444 0.277311 18.8222222 0.277311 18.8250000 0.276722 18.8277778 0.275838 18.8305556 0.275249 18.8333333 0.275838 18.8361111 0.276427 18.8388889 0.277017 18.8416667 0.275838 18.8444444 0.275543 18.8472222 0.274954 18.8500000 0.274954 18.8527778 0.276133 18.8555556 0.276427 18.8583333 0.274954 18.8611111 0.275543 18.8638889 0.275543 18.8666667 0.275838 18.8694444 0.276133 18.8722222 0.276427 18.8750000 0.275838 18.8777778 0.276133 18.8805556 0.275543 18.8833333 0.275838 18.8861111 0.276427 18.8888889 0.276722 18.8916667 0.276427 18.8944444 0.276133 18.8972222 0.276133 18.9000000 0.275543 18.9027778 0.276133 18.9055556 0.276427 18.9083333 0.276133 18.9111111 0.275838 18.9138889 0.275249 18.9166667 0.275543 18.9194444 0.276427 18.9222222 0.276722 18.9250000 0.276427 18.9277778 0.275543 18.9305556 0.275249 18.9333333 0.275838 18.9361111 0.276427 18.9388889 0.276722 18.9416667 0.276427 18.9444444 0.275543 18.9472222 0.275838 18.9500000 0.275543 18.9527778 0.275543 18.9555556 0.276133 18.9583333 0.275838 18.9611111 0.275249 18.9638889 0.274070 18.9666667 0.274659 18.9694444 0.274659 18.9722222 0.274954 18.9750000 0.274365 18.9777778 0.274365 18.9805556 0.274070 18.9833333 0.273481 18.9861111 0.273481 18.9888889 0.273481 18.9916667 0.272597 18.9944444 0.272302 18.9972222 0.271418 19.0000000 0.272597 19.0027778 0.273186 19.0055556 0.273481 19.0083333 0.273481 19.0111111 0.272302 19.0138889 0.271418 19.0166667 0.272891 19.0194444 0.273775 19.0222222 0.274365 19.0250000 0.274954 19.0277778 0.274659 19.0305556 0.274659 19.0333333 0.275543 19.0361111 0.277311 19.0418889 0.300000 19.2720000 0.300000 19.2750000 0.279963 19.2777778 0.279669 19.2805556 0.278785 19.2833333 0.279374 19.2861111 0.279669 19.2888889 0.280258 19.2916667 0.279669 19.2944444 0.279669 19.2972222 0.279079 19.3000000 0.279669 19.3027778 0.280258 19.3055556 0.280847 19.3083333 0.281142 19.3111111 0.282026 19.3138889 0.282026 19.3166667 0.282320 19.3194444 0.283204 19.3222222 0.283499 19.3250000 0.284383 19.3277778 0.283794 19.3305556 0.284088 19.3333333 0.285562 19.3361111 0.285856 19.3388889 0.286446 19.3416667 0.286151 19.3444444 0.286446 19.3472222 0.285562 19.3500000 0.285562 19.3527778 0.285856 19.3555556 0.285267 19.3583333 0.284972 19.3611111 0.284972 19.3638889 0.284088 19.3666667 0.284383 19.3694444 0.284383 19.3722222 0.284383 19.3750000 0.284972 19.3777778 0.285267 19.3805556 0.286151 19.3833333 0.286446 19.3861111 0.285267 19.3888889 0.284678 19.3916667 0.283499 19.3944444 0.282026 19.3972222 0.279963 19.4000000 0.280552 19.4027778 0.280258 19.4055556 0.280552 19.4083333 0.279669 19.4111111 0.279374 19.4138889 0.278785 19.4166667 0.278785 19.4194444 0.278785 19.4222222 0.278490 19.4250000 0.278490 19.4277778 0.279079 19.4305556 0.278490 19.4333333 0.278785 19.4361111 0.278785 19.4388889 0.278785 19.4416667 0.279079 19.4444444 0.277901 19.4472222 0.277901 19.4500000 0.278490 19.4527778 0.278785 19.4555556 0.278195 19.4583333 0.278785 19.4611111 0.277606 19.4638889 0.277017 19.4666667 0.277311 19.4694444 0.277311 19.4722222 0.278490 19.4750000 0.277901 19.4777778 0.277901 19.4805556 0.276427 19.4833333 0.276722 19.4861111 0.274659 19.4888889 0.272891 19.4916667 0.271713 19.4944444 0.269945 19.4972222 0.266409 19.5000000 0.265525 19.5027778 0.269650 19.5055556 0.277311 19.5083333 0.285856 19.5111111 0.294991 19.5138889 0.307366 19.5166667 0.323867 19.5194444 0.339779 19.5222222 0.350976 19.5250000 0.355101 19.5277778 0.349503 19.5305556 0.332707 19.5333333 0.308250 19.5361111 0.288214 19.5388889 0.276133 19.5416667 0.271418 19.5444444 0.271418 19.5472222 0.273481 19.5500000 0.277311 19.5527778 0.277311 19.5555556 0.277311 19.5583333 0.277017 19.5611111 0.277311 19.5638889 0.276722 19.5666667 0.277017 19.5694444 0.277311 19.5722222 0.277311 19.5750000 0.277017 19.5777778 0.276722 19.5805556 0.277017 19.5833333 0.277017 19.5861111 0.276722 19.5888889 0.277606 19.5916667 0.277311 19.5944444 0.277017 19.5972222 0.276133 19.6000000 0.276427 19.6027778 0.276722 19.6055556 0.277017 19.6083333 0.277017 19.6111111 0.277017 19.6138889 0.276133 19.6166667 0.277901 19.6194444 0.277017 19.6222222 0.277606 19.6250000 0.277017 19.6277778 0.277311 19.6305556 0.277017 19.6333333 0.277311 19.6361111 0.278195 19.6388889 0.278490 19.6416667 0.278490 19.6444444 0.277606 19.6472222 0.277017 19.6500000 0.277017 19.6527778 0.277311 19.6555556 0.277901 19.6583333 0.277606 19.6611111 0.277017 19.6638889 0.277017 19.6666667 0.276722 19.6694444 0.277901 19.6722222 0.277311 19.6750000 0.277311 19.6777778 0.276427 19.6805556 0.277017 19.6833333 0.277311 19.6861111 0.277311 19.6888889 0.277901 19.6916667 0.277606 19.6944444 0.276722 19.6972222 0.276133 19.7000000 0.277311 19.7027778 0.277606 19.7055556 0.277901 19.7083333 0.277606 19.7111111 0.277606 19.7138889 0.277017 19.7166667 0.277017 19.7194444 0.277606 19.7222222 0.279079 19.7250000 0.279079 19.7277778 0.278195 19.7305556 0.277311 19.7333333 0.277901 19.7361111 0.277311 19.7388889 0.277901 19.7416667 0.277017 19.7444444 0.277017 19.7472222 0.276427 19.7500000 0.276427 19.7527778 0.277311 19.7555556 0.277017 19.7583333 0.277017 19.7611111 0.276133 19.7638889 0.275543 19.7666667 0.276133 19.7694444 0.276133 19.7722222 0.276133 19.7750000 0.275838 19.7777778 0.274954 19.7805556 0.274659 19.7833333 0.275249 19.7861111 0.276133 19.7888889 0.275838 19.7916667 0.275838 19.7944444 0.275838 19.7972222 0.275838 19.8000000 0.276427 19.8027778 0.277311 19.8055556 0.278195 19.8083333 0.277901 19.8111111 0.278785 19.8138889 0.278490 19.8166667 0.279079 19.8194444 0.280258 19.8222222 0.281436 19.8280000 0.300000 20.0636667 0.300000 20.0666667 0.281436 20.0694444 0.281436 20.0722222 0.282320 20.0750000 0.282320 20.0777778 0.281731 20.0805556 0.281142 20.0833333 0.281436 20.0861111 0.282026 20.0888889 0.282320 20.0916667 0.282320 20.0944444 0.282320 20.0972222 0.282320 20.1000000 0.283204 20.1027778 0.284678 20.1055556 0.285562 20.1083333 0.285856 20.1111111 0.285562 20.1138889 0.285267 20.1166667 0.285856 20.1194444 0.285562 20.1222222 0.286446 20.1250000 0.287035 20.1277778 0.286446 20.1305556 0.286151 20.1333333 0.286446 20.1361111 0.287919 20.1388889 0.288214 20.1416667 0.288508 20.1444444 0.287624 20.1472222 0.287330 20.1500000 0.287919 20.1527778 0.287919 20.1555556 0.287919 20.1583333 0.287624 20.1611111 0.286740 20.1638889 0.286446 20.1666667 0.286740 20.1694444 0.287035 20.1722222 0.287035 20.1750000 0.287330 20.1777778 0.288214 20.1805556 0.288803 20.1833333 0.288803 20.1861111 0.287919 20.1888889 0.286740 20.1916667 0.285267 20.1944444 0.284088 20.1972222 0.282320 20.2000000 0.282026 20.2027778 0.281142 20.2055556 0.281142 20.2083333 0.280847 20.2111111 0.280258 20.2138889 0.279963 20.2166667 0.280258 20.2194444 0.279669 20.2222222 0.280552 20.2250000 0.280552 20.2277778 0.279669 20.2305556 0.279669 20.2333333 0.279374 20.2361111 0.280258 20.2388889 0.280258 20.2416667 0.280258 20.2444444 0.279963 20.2472222 0.279669 20.2500000 0.279963 20.2527778 0.281142 20.2555556 0.280847 20.2583333 0.280847 20.2611111 0.280258 20.2638889 0.279669 20.2666667 0.279374 20.2694444 0.276722 20.2722222 0.274659 20.2750000 0.272891 20.2777778 0.270239 20.2805556 0.267882 20.2833333 0.266114 20.2861111 0.266998 20.2888889 0.273186 20.2916667 0.280552 20.2944444 0.286151 20.2972222 0.292339 20.3000000 0.300000 20.3027778 0.309429 20.3055556 0.320626 20.3083333 0.332118 20.3111111 0.341252 20.3138889 0.348029 20.3166667 0.354807 20.3194444 0.360994 20.3222222 0.361878 20.3250000 0.354217 20.3277778 0.333591 20.3305556 0.306777 20.3333333 0.285562 20.3361111 0.275249 20.3388889 0.274954 20.3416667 0.277017 20.3444444 0.279079 20.3472222 0.278785 20.3500000 0.278490 20.3527778 0.279079 20.3555556 0.279374 20.3583333 0.278785 20.3611111 0.278490 20.3638889 0.277017 20.3666667 0.277311 20.3694444 0.277901 20.3722222 0.278195 20.3750000 0.278195 20.3777778 0.277606 20.3805556 0.276722 20.3833333 0.277311 20.3861111 0.277901 20.3888889 0.278490 20.3916667 0.278195 20.3944444 0.277311 20.3972222 0.276427 20.4000000 0.277311 20.4027778 0.277311 20.4055556 0.278195 20.4083333 0.277901 20.4111111 0.277311 20.4138889 0.276722 20.4166667 0.277017 20.4194444 0.278195 20.4222222 0.278785 20.4250000 0.278785 20.4277778 0.278490 20.4305556 0.278195 20.4333333 0.278195 20.4361111 0.278490 20.4388889 0.279079 20.4416667 0.278785 20.4444444 0.278195 20.4472222 0.277606 20.4500000 0.277606 20.4527778 0.278490 20.4555556 0.278195 20.4583333 0.278490 20.4611111 0.277606 20.4638889 0.277017 20.4666667 0.277606 20.4694444 0.277606 20.4722222 0.278490 20.4750000 0.278490 20.4777778 0.277901 20.4805556 0.277311 20.4833333 0.277311 20.4861111 0.277901 20.4888889 0.278785 20.4916667 0.279079 20.4944444 0.278195 20.4972222 0.277901 20.5000000 0.278195 20.5027778 0.278195 20.5055556 0.279079 20.5083333 0.278490 20.5111111 0.278785 20.5138889 0.277311 20.5166667 0.277311 20.5194444 0.277606 20.5222222 0.278785 20.5250000 0.278490 20.5277778 0.277901 20.5305556 0.277606 20.5333333 0.278195 20.5361111 0.278195 20.5388889 0.278195 20.5416667 0.278785 20.5444444 0.277311 20.5472222 0.276722 20.5500000 0.277606 20.5527778 0.277901 20.5555556 0.278490 20.5583333 0.277901 20.5611111 0.277311 20.5638889 0.277017 20.5666667 0.277901 20.5694444 0.278195 20.5722222 0.278195 20.5750000 0.278195 20.5777778 0.278195 20.5805556 0.277311 20.5833333 0.277606 20.5861111 0.277311 20.5888889 0.278195 20.5916667 0.278195 20.5944444 0.278195 20.5972222 0.277606 20.6000000 0.278195 20.6027778 0.279669 20.6055556 0.279963 20.6083333 0.280847 20.6111111 0.280258 20.6138889 0.280847 20.6196667 0.300000 20.8386667 0.300000 20.8416667 0.281436 20.8444444 0.281142 20.8472222 0.281731 20.8500000 0.281731 20.8527778 0.281731 20.8555556 0.282026 20.8583333 0.282320 20.8611111 0.281731 20.8638889 0.281731 20.8666667 0.282320 20.8694444 0.283204 20.8722222 0.282910 20.8750000 0.283794 20.8777778 0.283794 20.8805556 0.283794 20.8833333 0.284088 20.8861111 0.284972 20.8888889 0.285856 20.8916667 0.285562 20.8944444 0.285856 20.8972222 0.285562 20.9000000 0.285562 20.9027778 0.287035 20.9055556 0.287919 20.9083333 0.288803 20.9111111 0.288508 20.9138889 0.288803 20.9166667 0.288214 20.9194444 0.288508 20.9222222 0.288214 20.9250000 0.287624 20.9277778 0.287330 20.9305556 0.287035 20.9333333 0.287624 20.9361111 0.287624 20.9388889 0.288214 20.9416667 0.287624 20.9444444 0.287035 20.9472222 0.287330 20.9500000 0.287035 20.9527778 0.286151 20.9555556 0.286740 20.9583333 0.286740 20.9611111 0.287035 20.9638889 0.288214 20.9666667 0.287919 20.9694444 0.286446 20.9722222 0.285267 20.9750000 0.284678 20.9777778 0.283204 20.9805556 0.282320 20.9833333 0.281436 20.9861111 0.280552 20.9888889 0.280847 20.9916667 0.280258 20.9944444 0.279963 20.9972222 0.279669 21.0000000 0.280552 21.0027778 0.281142 21.0055556 0.281142 21.0083333 0.280847 21.0111111 0.280258 21.0138889 0.280258 21.0166667 0.280258 21.0194444 0.280552 21.0222222 0.280552 21.0250000 0.280258 21.0277778 0.279374 21.0305556 0.279079 21.0333333 0.279374 21.0361111 0.279669 21.0388889 0.279963 21.0416667 0.279374 21.0444444 0.278785 21.0472222 0.277017 21.0500000 0.276427 21.0527778 0.274365 21.0555556 0.272597 21.0583333 0.271713 21.0611111 0.269650 21.0638889 0.266409 21.0666667 0.265820 21.0694444 0.269355 21.0722222 0.276427 21.0750000 0.285267 21.0777778 0.294401 21.0805556 0.305893 21.0833333 0.323278 21.0861111 0.338895 21.0888889 0.348913 21.0916667 0.351860 21.0944444 0.344788 21.0972222 0.327109 21.1000000 0.304125 21.1027778 0.285856 21.1055556 0.274954 21.1083333 0.271418 21.1111111 0.271713 21.1138889 0.274659 21.1166667 0.276427 21.1194444 0.276722 21.1222222 0.276427 21.1250000 0.276427 21.1277778 0.276722 21.1305556 0.277017 21.1333333 0.277901 21.1361111 0.278490 21.1388889 0.278195 21.1416667 0.277311 21.1444444 0.276722 21.1472222 0.276133 21.1500000 0.277017 21.1527778 0.277017 21.1555556 0.277311 21.1583333 0.277606 21.1611111 0.276722 21.1638889 0.276427 21.1666667 0.277606 21.1694444 0.277606 21.1722222 0.277901 21.1750000 0.277311 21.1777778 0.276722 21.1805556 0.276133 21.1833333 0.276427 21.1861111 0.276722 21.1888889 0.276722 21.1916667 0.277606 21.1944444 0.276722 21.1972222 0.277017 21.2000000 0.276722 21.2027778 0.276427 21.2055556 0.277017 21.2083333 0.277311 21.2111111 0.277017 21.2138889 0.276427 21.2166667 0.277017 21.2194444 0.277606 21.2222222 0.277606 21.2250000 0.277311 21.2277778 0.277606 21.2305556 0.277311 21.2333333 0.278195 21.2361111 0.277901 21.2388889 0.278195 21.2416667 0.278195 21.2444444 0.277901 21.2472222 0.277311 21.2500000 0.277311 21.2527778 0.277901 21.2555556 0.277311 21.2583333 0.277606 21.2611111 0.276427 21.2638889 0.276133 21.2666667 0.276427 21.2694444 0.277311 21.2722222 0.277606 21.2750000 0.277901 21.2777778 0.276722 21.2805556 0.276133 21.2833333 0.276133 21.2861111 0.276722 21.2888889 0.277017 21.2916667 0.277606 21.2944444 0.277311 21.2972222 0.276722 21.3000000 0.277901 21.3027778 0.277901 21.3055556 0.277606 21.3083333 0.277311 21.3111111 0.277901 21.3138889 0.277311 21.3166667 0.277311 21.3194444 0.277901 21.3222222 0.277606 21.3250000 0.276427 21.3277778 0.276133 21.3305556 0.275543 21.3333333 0.275838 21.3361111 0.275543 21.3388889 0.276427 21.3416667 0.275838 21.3444444 0.275838 21.3472222 0.275543 21.3500000 0.275543 21.3527778 0.275543 21.3555556 0.275543 21.3583333 0.275543 21.3611111 0.274954 21.3638889 0.273775 21.3666667 0.274659 21.3694444 0.275249 21.3722222 0.275543 21.3750000 0.276427 21.3777778 0.275838 21.3805556 0.276133 21.3833333 0.277311 21.3861111 0.277901 21.3888889 0.279374 21.3946667 0.300000 21.6247778 0.300000 21.6277778 0.280552 21.6305556 0.280258 21.6333333 0.279963 21.6361111 0.281142 21.6388889 0.280847 21.6416667 0.280552 21.6444444 0.279374 21.6472222 0.279374 21.6500000 0.280258 21.6527778 0.281142 21.6555556 0.281731 21.6583333 0.282026 21.6611111 0.282615 21.6638889 0.282615 21.6666667 0.283794 21.6694444 0.284088 21.6722222 0.284972 21.6750000 0.284383 21.6777778 0.285267 21.6805556 0.285267 21.6833333 0.285267 21.6861111 0.286740 21.6888889 0.287035 21.6916667 0.287035 21.6944444 0.286446 21.6972222 0.285267 21.7000000 0.285267 21.7027778 0.285267 21.7055556 0.286151 21.7083333 0.286446 21.7111111 0.285562 21.7138889 0.285856 21.7166667 0.286151 21.7194444 0.286151 21.7222222 0.286446 21.7250000 0.284972 21.7277778 0.284678 21.7305556 0.283794 21.7333333 0.284383 21.7361111 0.284972 21.7388889 0.286446 21.7416667 0.286740 21.7444444 0.285856 21.7472222 0.284088 21.7500000 0.283204 21.7527778 0.282615 21.7555556 0.282026 21.7583333 0.281142 21.7611111 0.279079 21.7638889 0.278490 21.7666667 0.278785 21.7694444 0.278490 21.7722222 0.279079 21.7750000 0.279079 21.7777778 0.278785 21.7805556 0.278490 21.7833333 0.278490 21.7861111 0.279079 21.7888889 0.279669 21.7916667 0.279079 21.7944444 0.278195 21.7972222 0.277311 21.8000000 0.278195 21.8027778 0.279374 21.8055556 0.279374 21.8083333 0.279669 21.8111111 0.278785 21.8138889 0.278195 21.8166667 0.278195 21.8194444 0.278785 21.8222222 0.279669 21.8250000 0.278785 21.8277778 0.278490 21.8305556 0.277311 21.8333333 0.277017 21.8361111 0.276133 21.8388889 0.274659 21.8416667 0.273481 21.8444444 0.272302 21.8472222 0.269650 21.8500000 0.267587 21.8527778 0.266703 21.8555556 0.270239 21.8583333 0.275249 21.8611111 0.282615 21.8638889 0.292339 21.8666667 0.304715 21.8694444 0.321215 21.8722222 0.336538 21.8750000 0.349208 21.8777778 0.354217 21.8805556 0.348913 21.8833333 0.332118 21.8861111 0.309429 21.8888889 0.289392 21.8916667 0.276722 21.8944444 0.271123 21.8972222 0.269650 21.9000000 0.272302 21.9027778 0.274954 21.9055556 0.275838 21.9083333 0.275838 21.9111111 0.275543 21.9138889 0.275838 21.9166667 0.276133 21.9194444 0.276722 21.9222222 0.276722 21.9250000 0.276722 21.9277778 0.276133 21.9305556 0.275838 21.9333333 0.276427 21.9361111 0.276133 21.9388889 0.276722 21.9416667 0.276427 21.9444444 0.275838 21.9472222 0.275249 21.9500000 0.275543 21.9527778 0.275543 21.9555556 0.276133 21.9583333 0.275838 21.9611111 0.274659 21.9638889 0.273775 21.9666667 0.273775 21.9694444 0.274954 21.9722222 0.275543 21.9750000 0.275249 21.9777778 0.275249 21.9805556 0.274954 21.9833333 0.275249 21.9861111 0.274954 21.9888889 0.275838 21.9916667 0.275543 21.9944444 0.274365 21.9972222 0.274070 22.0000000 0.274365 22.0027778 0.275543 22.0055556 0.275543 22.0083333 0.275838 22.0111111 0.275838 22.0138889 0.275249 22.0166667 0.274659 22.0194444 0.274365 22.0222222 0.274954 22.0250000 0.275249 22.0277778 0.275249 22.0305556 0.274954 22.0333333 0.274954 22.0361111 0.274954 22.0388889 0.275249 22.0416667 0.274954 22.0444444 0.274954 22.0472222 0.274954 22.0500000 0.275249 22.0527778 0.275543 22.0555556 0.275543 22.0583333 0.275543 22.0611111 0.275249 22.0638889 0.274659 22.0666667 0.274954 22.0694444 0.275249 22.0722222 0.275543 22.0750000 0.275249 22.0777778 0.275249 22.0805556 0.274659 22.0833333 0.275249 22.0861111 0.275249 22.0888889 0.275838 22.0916667 0.276133 22.0944444 0.274954 22.0972222 0.274365 22.1000000 0.274070 22.1027778 0.275249 22.1055556 0.275543 22.1083333 0.274659 22.1111111 0.274070 22.1138889 0.273481 22.1166667 0.273481 22.1194444 0.273775 22.1222222 0.273775 22.1250000 0.273775 22.1277778 0.272597 22.1305556 0.272007 22.1333333 0.271123 22.1361111 0.271713 22.1388889 0.272007 22.1416667 0.271713 22.1444444 0.271418 22.1472222 0.271123 22.1500000 0.271418 22.1527778 0.272007 22.1555556 0.273186 22.1583333 0.272597 22.1611111 0.272891 22.1638889 0.272302 22.1666667 0.273186 22.1694444 0.273481 22.1722222 0.274365 22.1750000 0.274659 22.1807778 0.300000 22.4358889 0.300000 22.4388889 0.278490 22.4416667 0.278490 22.4444444 0.277606 22.4472222 0.277606 22.4500000 0.278195 22.4527778 0.278785 22.4555556 0.278785 22.4583333 0.279374 22.4611111 0.278785 22.4638889 0.278490 22.4666667 0.279374 22.4694444 0.279669 22.4722222 0.280258 22.4750000 0.280847 22.4777778 0.281142 22.4805556 0.280552 22.4833333 0.281142 22.4861111 0.282320 22.4888889 0.282320 22.4916667 0.282615 22.4944444 0.282026 22.4972222 0.282615 22.5000000 0.283204 22.5027778 0.284088 22.5055556 0.284088 22.5083333 0.284972 22.5111111 0.284383 22.5138889 0.284088 22.5166667 0.283794 22.5194444 0.284383 22.5222222 0.283794 22.5250000 0.284088 22.5277778 0.283204 22.5305556 0.282615 22.5333333 0.282615 22.5361111 0.283204 22.5388889 0.283794 22.5416667 0.283499 22.5444444 0.282320 22.5472222 0.282910 22.5500000 0.283204 22.5527778 0.284972 22.5555556 0.285856 22.5583333 0.284088 22.5611111 0.282320 22.5638889 0.279963 22.5666667 0.279963 22.5694444 0.279374 22.5722222 0.278785 22.5750000 0.277606 22.5777778 0.277017 22.5805556 0.276133 22.5833333 0.276427 22.5861111 0.277311 22.5888889 0.277311 22.5916667 0.277311 22.5944444 0.276133 22.5972222 0.275838 22.6000000 0.276133 22.6027778 0.277017 22.6055556 0.276427 22.6083333 0.276722 22.6111111 0.275543 22.6138889 0.275543 22.6166667 0.276133 22.6194444 0.276722 22.6222222 0.277017 22.6250000 0.277017 22.6277778 0.276133 22.6305556 0.275543 22.6333333 0.275543 22.6361111 0.276427 22.6388889 0.276133 22.6416667 0.274659 22.6444444 0.271713 22.6472222 0.269061 22.6500000 0.267587 22.6527778 0.266409 22.6555556 0.264936 22.6583333 0.261989 22.6611111 0.262284 22.6638889 0.266409 22.6666667 0.274070 22.6694444 0.280258 22.6722222 0.285267 22.6750000 0.291160 22.6777778 0.299116 22.6805556 0.309429 22.6833333 0.324162 22.6861111 0.339190 22.6888889 0.350387 22.6916667 0.356280 22.6944444 0.353628 22.6972222 0.338011 22.7000000 0.312670 22.7027778 0.288508 22.7055556 0.273775 22.7083333 0.268177 22.7111111 0.269945 22.7138889 0.271418 22.7166667 0.274365 22.7194444 0.273775 22.7222222 0.274070 22.7250000 0.274070 22.7277778 0.274070 22.7305556 0.273481 22.7333333 0.273186 22.7361111 0.273186 22.7388889 0.273481 22.7416667 0.273186 22.7444444 0.272891 22.7472222 0.272302 22.7500000 0.272597 22.7527778 0.273481 22.7555556 0.274070 22.7583333 0.273481 22.7611111 0.273775 22.7638889 0.272891 22.7666667 0.272891 22.7694444 0.274070 22.7722222 0.273775 22.7750000 0.273775 22.7777778 0.273481 22.7805556 0.273186 22.7833333 0.273481 22.7861111 0.273186 22.7888889 0.274365 22.7916667 0.273186 22.7944444 0.273481 22.7972222 0.273186 22.8000000 0.273186 22.8027778 0.273775 22.8055556 0.274070 22.8083333 0.274365 22.8111111 0.274365 22.8138889 0.273481 22.8166667 0.273775 22.8194444 0.274659 22.8222222 0.274070 22.8250000 0.273481 22.8277778 0.273481 22.8305556 0.273186 22.8333333 0.272891 22.8361111 0.274070 22.8388889 0.274365 22.8416667 0.273775 22.8444444 0.273186 22.8472222 0.272891 22.8500000 0.273186 22.8527778 0.274070 22.8555556 0.273775 22.8583333 0.274070 22.8611111 0.273481 22.8638889 0.272597 22.8666667 0.273481 22.8694444 0.273186 22.8722222 0.274070 22.8750000 0.274070 22.8777778 0.273481 22.8805556 0.272007 22.8833333 0.273186 22.8861111 0.273481 22.8888889 0.273481 22.8916667 0.274070 22.8944444 0.274070 22.8972222 0.273186 22.9000000 0.274070 22.9027778 0.274070 22.9055556 0.274365 22.9083333 0.274070 22.9111111 0.273775 22.9138889 0.273186 22.9166667 0.273481 22.9194444 0.274070 22.9222222 0.274365 22.9250000 0.273481 22.9277778 0.273775 22.9305556 0.273186 22.9333333 0.273481 22.9361111 0.273775 22.9388889 0.273775 22.9416667 0.273186 22.9444444 0.272302 22.9472222 0.272302 22.9500000 0.271713 22.9527778 0.272597 22.9555556 0.273186 22.9583333 0.273186 22.9611111 0.272597 22.9638889 0.272302 22.9666667 0.272302 22.9694444 0.273186 22.9722222 0.273186 22.9750000 0.272891 22.9777778 0.273481 22.9805556 0.273186 22.9833333 0.273775 22.9861111 0.274365 22.9918889 0.300000 23.2525556 0.300000 23.2555556 0.276133 23.2583333 0.276722 23.2611111 0.276133 23.2638889 0.275838 23.2666667 0.275838 23.2694444 0.276427 23.2722222 0.276722 23.2750000 0.276722 23.2777778 0.276722 23.2805556 0.276133 23.2833333 0.277017 23.2861111 0.278195 23.2888889 0.278490 23.2916667 0.279079 23.2944444 0.279079 23.2972222 0.279079 23.3000000 0.279374 23.3027778 0.279963 23.3055556 0.280552 23.3083333 0.280847 23.3111111 0.279963 23.3138889 0.279669 23.3166667 0.279669 23.3194444 0.280847 23.3222222 0.282320 23.3250000 0.282026 23.3277778 0.282026 23.3305556 0.281142 23.3333333 0.282320 23.3361111 0.281436 23.3388889 0.282615 23.3416667 0.282026 23.3444444 0.281142 23.3472222 0.280552 23.3500000 0.281142 23.3527778 0.282320 23.3555556 0.282615 23.3583333 0.281731 23.3611111 0.280847 23.3638889 0.281142 23.3666667 0.282320 23.3694444 0.283499 23.3722222 0.282615 23.3750000 0.280552 23.3777778 0.278490 23.3805556 0.277311 23.3833333 0.277017 23.3861111 0.276722 23.3888889 0.276722 23.3916667 0.275838 23.3944444 0.275249 23.3972222 0.274070 23.4000000 0.274659 23.4027778 0.275249 23.4055556 0.275543 23.4083333 0.275838 23.4111111 0.274659 23.4138889 0.274365 23.4166667 0.274659 23.4194444 0.274659 23.4222222 0.275249 23.4250000 0.275249 23.4277778 0.274070 23.4305556 0.273775 23.4333333 0.274659 23.4361111 0.274659 23.4388889 0.274954 23.4416667 0.274659 23.4444444 0.274659 23.4472222 0.273775 23.4500000 0.274070 23.4527778 0.273186 23.4555556 0.274659 23.4583333 0.274070 23.4611111 0.273186 23.4638889 0.271713 23.4666667 0.269945 23.4694444 0.267882 23.4722222 0.266703 23.4750000 0.265820 23.4777778 0.262578 23.4805556 0.260810 23.4833333 0.262873 23.4861111 0.269945 23.4888889 0.279079 23.4916667 0.288214 23.4944444 0.298527 23.4972222 0.314144 23.5000000 0.331823 23.5027778 0.344494 23.5055556 0.349797 23.5083333 0.346851 23.5111111 0.332413 23.5138889 0.307072 23.5166667 0.283204 23.5194444 0.269355 23.5222222 0.265525 23.5250000 0.266998 23.5277778 0.269355 23.5305556 0.270534 23.5333333 0.272302 23.5361111 0.272007 23.5388889 0.272302 23.5416667 0.272891 23.5444444 0.271713 23.5472222 0.271418 23.5500000 0.271418 23.5527778 0.272302 23.5555556 0.272597 23.5583333 0.272007 23.5611111 0.271713 23.5638889 0.271123 23.5666667 0.271418 23.5694444 0.272007 23.5722222 0.272302 23.5750000 0.272007 23.5777778 0.271123 23.5805556 0.270829 23.5833333 0.270829 23.5861111 0.270829 23.5888889 0.271713 23.5916667 0.271123 23.5944444 0.271418 23.5972222 0.270829 23.6000000 0.271123 23.6027778 0.271418 23.6055556 0.271713 23.6083333 0.272007 23.6111111 0.271418 23.6138889 0.271123 23.6166667 0.271418 23.6194444 0.271713 23.6222222 0.272007 23.6250000 0.271418 23.6277778 0.271418 23.6305556 0.269945 23.6333333 0.270829 23.6361111 0.271123 23.6388889 0.271418 23.6416667 0.272007 23.6444444 0.272007 23.6472222 0.270829 23.6500000 0.272007 23.6527778 0.272007 23.6555556 0.272007 23.6583333 0.272302 23.6611111 0.270829 23.6638889 0.270829 23.6666667 0.270829 23.6694444 0.271123 23.6722222 0.272302 23.6750000 0.271418 23.6777778 0.270829 23.6805556 0.270239 23.6833333 0.270829 23.6861111 0.271123 23.6888889 0.271123 23.6916667 0.271713 23.6944444 0.271123 23.6972222 0.270534 23.7000000 0.270829 23.7027778 0.271123 23.7055556 0.272007 23.7083333 0.271713 23.7111111 0.271123 23.7138889 0.270534 23.7166667 0.271713 23.7194444 0.271418 23.7222222 0.272007 23.7250000 0.271713 23.7277778 0.271713 23.7305556 0.271713 23.7333333 0.272302 23.7361111 0.272597 23.7388889 0.272891 23.7416667 0.272007 23.7444444 0.272007 23.7472222 0.271713 23.7500000 0.271123 23.7527778 0.271713 23.7555556 0.272302 23.7583333 0.271713 23.7611111 0.270829 23.7638889 0.270239 23.7666667 0.270239 23.7694444 0.271418 23.7722222 0.271418 23.7750000 0.271418 23.7777778 0.270829 23.7805556 0.270239 23.7833333 0.270239 23.7861111 0.271123 23.7888889 0.271418 23.7916667 0.270534 23.7944444 0.271123 23.7972222 0.270534 23.8000000 0.271713 23.8027778 0.272302 23.8085556 0.300000 24.0803333 0.300000 24.0833333 0.274954 24.0861111 0.275249 24.0888889 0.274954 24.0916667 0.275249 24.0944444 0.274954 24.0972222 0.274070 24.1000000 0.274070 24.1027778 0.274954 24.1055556 0.275249 24.1083333 0.275249 24.1111111 0.275543 24.1138889 0.274954 24.1166667 0.276427 24.1194444 0.277606 24.1222222 0.278490 24.1250000 0.278195 24.1277778 0.278195 24.1305556 0.278490 24.1333333 0.279079 24.1361111 0.279669 24.1388889 0.280552 24.1416667 0.281142 24.1444444 0.281142 24.1472222 0.280552 24.1500000 0.280847 24.1527778 0.281436 24.1555556 0.281436 24.1583333 0.281436 24.1611111 0.280847 24.1638889 0.279963 24.1666667 0.279669 24.1694444 0.280258 24.1722222 0.280847 24.1750000 0.280258 24.1777778 0.279079 24.1805556 0.277606 24.1833333 0.278785 24.1861111 0.279669 24.1888889 0.282026 24.1916667 0.282615 24.1944444 0.281436 24.1972222 0.280258 24.2000000 0.278490 24.2027778 0.278195 24.2055556 0.277901 24.2083333 0.277311 24.2111111 0.276133 24.2138889 0.274659 24.2166667 0.274659 24.2194444 0.274659 24.2222222 0.274659 24.2250000 0.274365 24.2277778 0.273481 24.2305556 0.272891 24.2333333 0.272891 24.2361111 0.272891 24.2388889 0.273186 24.2416667 0.273481 24.2444444 0.273481 24.2472222 0.272597 24.2500000 0.272302 24.2527778 0.272302 24.2555556 0.272891 24.2583333 0.272007 24.2611111 0.271713 24.2638889 0.271123 24.2666667 0.271713 24.2694444 0.272597 24.2722222 0.272597 24.2750000 0.271713 24.2777778 0.271418 24.2805556 0.270829 24.2833333 0.270829 24.2861111 0.271123 24.2888889 0.271123 24.2916667 0.269061 24.2944444 0.267293 24.2972222 0.264641 24.3000000 0.264052 24.3027778 0.263462 24.3055556 0.261400 24.3083333 0.259926 24.3111111 0.261400 24.3138889 0.266114 24.3166667 0.273775 24.3194444 0.281731 24.3222222 0.292339 24.3250000 0.307366 24.3277778 0.323278 24.3305556 0.335359 24.3333333 0.342726 24.3361111 0.342136 24.3388889 0.331234 24.3416667 0.310902 24.3444444 0.288508 24.3472222 0.273186 24.3500000 0.265230 24.3527778 0.263757 24.3555556 0.265525 24.3583333 0.267882 24.3611111 0.268471 24.3638889 0.268471 24.3666667 0.268471 24.3694444 0.269061 24.3722222 0.270239 24.3750000 0.269650 24.3777778 0.270239 24.3805556 0.269650 24.3833333 0.269650 24.3861111 0.271123 24.3888889 0.270829 24.3916667 0.270534 24.3944444 0.271123 24.3972222 0.269355 24.4000000 0.269945 24.4027778 0.269355 24.4055556 0.270239 24.4083333 0.270239 24.4111111 0.270239 24.4138889 0.269650 24.4166667 0.269650 24.4194444 0.270534 24.4222222 0.269945 24.4250000 0.269650 24.4277778 0.269061 24.4305556 0.268766 24.4333333 0.269061 24.4361111 0.268471 24.4388889 0.269355 24.4416667 0.269061 24.4444444 0.269355 24.4472222 0.268766 24.4500000 0.269355 24.4527778 0.269355 24.4555556 0.269945 24.4583333 0.269650 24.4611111 0.269945 24.4638889 0.268766 24.4666667 0.268766 24.4694444 0.269355 24.4722222 0.269945 24.4750000 0.270239 24.4777778 0.269061 24.4805556 0.268766 24.4833333 0.269061 24.4861111 0.269945 24.4888889 0.270829 24.4916667 0.270534 24.4944444 0.269945 24.4972222 0.269355 24.5000000 0.269355 24.5027778 0.269650 24.5055556 0.270239 24.5083333 0.270534 24.5111111 0.269945 24.5138889 0.269355 24.5166667 0.270239 24.5194444 0.269650 24.5222222 0.269945 24.5250000 0.269355 24.5277778 0.270239 24.5305556 0.270239 24.5333333 0.269650 24.5361111 0.269061 24.5388889 0.270534 24.5416667 0.270829 24.5444444 0.270829 24.5472222 0.270239 24.5500000 0.270829 24.5527778 0.271123 24.5555556 0.272007 24.5583333 0.271123 24.5611111 0.270829 24.5638889 0.269945 24.5666667 0.270239 24.5694444 0.270534 24.5722222 0.270534 24.5750000 0.270534 24.5777778 0.270239 24.5805556 0.269650 24.5833333 0.270239 24.5861111 0.270239 24.5888889 0.269650 24.5916667 0.269945 24.5944444 0.269061 24.5972222 0.268471 24.6000000 0.268471 24.6027778 0.268177 24.6055556 0.269355 24.6083333 0.268177 24.6111111 0.268177 24.6138889 0.266998 24.6166667 0.267587 24.6194444 0.268177 24.6222222 0.267882 24.6250000 0.268177 24.6277778 0.267882 24.6305556 0.267587 24.6363333 0.300000 24.8333333 0.300000)
Vecg1 ecg_l1 0 PWL(0.0000000 0.300000 0.5608889 0.300000 0.5638889 0.287330 0.5666667 0.286740 0.5694444 0.287330 0.5722222 0.287330 0.5750000 0.287330 0.5777778 0.286740 0.5805556 0.286740 0.5833333 0.286740 0.5861111 0.287919 0.5888889 0.288508 0.5916667 0.287624 0.5944444 0.287624 0.5972222 0.287330 0.6000000 0.286151 0.6027778 0.286446 0.6055556 0.287035 0.6083333 0.287035 0.6111111 0.286446 0.6138889 0.286740 0.6166667 0.286446 0.6194444 0.287330 0.6222222 0.288508 0.6250000 0.288508 0.6277778 0.288803 0.6305556 0.288214 0.6333333 0.288508 0.6361111 0.289392 0.6388889 0.289982 0.6416667 0.289392 0.6444444 0.289687 0.6472222 0.288508 0.6500000 0.288508 0.6527778 0.289982 0.6555556 0.289687 0.6583333 0.289687 0.6611111 0.289392 0.6638889 0.289098 0.6666667 0.289098 0.6694444 0.289687 0.6722222 0.289687 0.6750000 0.289687 0.6777778 0.288803 0.6805556 0.287919 0.6833333 0.288214 0.6861111 0.287919 0.6888889 0.287919 0.6916667 0.287330 0.6944444 0.287330 0.6972222 0.286740 0.7000000 0.287330 0.7027778 0.287624 0.7055556 0.288214 0.7083333 0.287330 0.7111111 0.286740 0.7138889 0.285562 0.7166667 0.285562 0.7194444 0.285267 0.7222222 0.286740 0.7250000 0.286446 0.7277778 0.286151 0.7305556 0.285856 0.7333333 0.286151 0.7361111 0.286151 0.7388889 0.287035 0.7416667 0.286446 0.7444444 0.285856 0.7472222 0.285856 0.7500000 0.285562 0.7527778 0.286740 0.7555556 0.286740 0.7583333 0.286151 0.7611111 0.285267 0.7638889 0.284088 0.7666667 0.283499 0.7694444 0.282910 0.7722222 0.282320 0.7750000 0.280552 0.7777778 0.278785 0.7805556 0.279079 0.7833333 0.282026 0.7861111 0.287919 0.7888889 0.295285 0.7916667 0.300884 0.7944444 0.303831 0.7972222 0.306777 0.8000000 0.311197 0.8027778 0.317680 0.8055556 0.324162 0.8083333 0.329171 0.8111111 0.328582 0.8138889 0.321215 0.8166667 0.306188 0.8194444 0.290276 0.8222222 0.279374 0.8250000 0.273481 0.8277778 0.272302 0.8305556 0.273481 0.8333333 0.276722 0.8361111 0.279669 0.8388889 0.281731 0.8416667 0.282615 0.8444444 0.283204 0.8472222 0.282615 0.8500000 0.282615 0.8527778 0.283499 0.8555556 0.283204 0.8583333 0.283204 0.8611111 0.283204 0.8638889 0.282910 0.8666667 0.283794 0.8694444 0.283794 0.8722222 0.283794 0.8750000 0.284088 0.8777778 0.283204 0.8805556 0.282615 0.8833333 0.282910 0.8861111 0.283794 0.8888889 0.284383 0.8916667 0.284383 0.8944444 0.283794 0.8972222 0.282615 0.9000000 0.282910 0.9027778 0.283204 0.9055556 0.284088 0.9083333 0.284383 0.9111111 0.283794 0.9138889 0.283499 0.9166667 0.283499 0.9194444 0.284088 0.9222222 0.284383 0.9250000 0.284088 0.9277778 0.284088 0.9305556 0.283499 0.9333333 0.284088 0.9361111 0.284383 0.9388889 0.284383 0.9416667 0.284383 0.9444444 0.284088 0.9472222 0.283204 0.9500000 0.283204 0.9527778 0.284383 0.9555556 0.284383 0.9583333 0.284972 0.9611111 0.283794 0.9638889 0.283794 0.9666667 0.283499 0.9694444 0.284088 0.9722222 0.284383 0.9750000 0.283794 0.9777778 0.283204 0.9805556 0.283499 0.9833333 0.283499 0.9861111 0.283794 0.9888889 0.283794 0.9916667 0.283794 0.9944444 0.283204 0.9972222 0.282615 1.0000000 0.282615 1.0027778 0.283794 1.0055556 0.283794 1.0083333 0.283204 1.0111111 0.282910 1.0138889 0.281436 1.0166667 0.281436 1.0194444 0.282026 1.0222222 0.282910 1.0250000 0.281731 1.0277778 0.281142 1.0305556 0.281142 1.0333333 0.280258 1.0361111 0.280552 1.0388889 0.280847 1.0416667 0.279669 1.0444444 0.279374 1.0472222 0.278490 1.0500000 0.278195 1.0527778 0.279079 1.0555556 0.278785 1.0583333 0.278195 1.0611111 0.277017 1.0638889 0.276722 1.0666667 0.276427 1.0694444 0.277017 1.0722222 0.277311 1.0750000 0.277017 1.0777778 0.276427 1.0805556 0.275838 1.0833333 0.275249 1.0861111 0.276133 1.0888889 0.275838 1.0916667 0.275838 1.0944444 0.276427 1.0972222 0.276133 1.1000000 0.277017 1.1027778 0.277311 1.1055556 0.278490 1.1083333 0.279079 1.1111111 0.279669 1.1168889 0.300000 1.3720000 0.300000 1.3750000 0.288214 1.3777778 0.286446 1.3805556 0.287035 1.3833333 0.287330 1.3861111 0.287919 1.3888889 0.288214 1.3916667 0.287919 1.3944444 0.287035 1.3972222 0.287035 1.4000000 0.286740 1.4027778 0.287919 1.4055556 0.288214 1.4083333 0.288214 1.4111111 0.287624 1.4138889 0.286446 1.4166667 0.287330 1.4194444 0.288214 1.4222222 0.288214 1.4250000 0.287919 1.4277778 0.287624 1.4305556 0.287330 1.4333333 0.287035 1.4361111 0.287919 1.4388889 0.288214 1.4416667 0.288508 1.4444444 0.287919 1.4472222 0.287919 1.4500000 0.287919 1.4527778 0.289392 1.4555556 0.289982 1.4583333 0.288803 1.4611111 0.288803 1.4638889 0.288214 1.4666667 0.289098 1.4694444 0.290276 1.4722222 0.291455 1.4750000 0.291455 1.4777778 0.289982 1.4805556 0.289687 1.4833333 0.289982 1.4861111 0.290276 1.4888889 0.291160 1.4916667 0.290571 1.4944444 0.289687 1.4972222 0.288803 1.5000000 0.288803 1.5027778 0.289098 1.5055556 0.289098 1.5083333 0.289687 1.5111111 0.288508 1.5138889 0.287330 1.5166667 0.287919 1.5194444 0.288214 1.5222222 0.288508 1.5250000 0.287919 1.5277778 0.287624 1.5305556 0.287035 1.5333333 0.287330 1.5361111 0.287624 1.5388889 0.287919 1.5416667 0.288214 1.5444444 0.287624 1.5472222 0.287035 1.5500000 0.287035 1.5527778 0.287035 1.5555556 0.288214 1.5583333 0.287919 1.5611111 0.287330 1.5638889 0.286740 1.5666667 0.287035 1.5694444 0.287330 1.5722222 0.287919 1.5750000 0.287035 1.5777778 0.286740 1.5805556 0.285856 1.5833333 0.284678 1.5861111 0.283499 1.5888889 0.282320 1.5916667 0.279669 1.5944444 0.277901 1.5972222 0.279669 1.6000000 0.284678 1.6027778 0.292634 1.6055556 0.301473 1.6083333 0.308545 1.6111111 0.315322 1.6138889 0.322099 1.6166667 0.329761 1.6194444 0.337422 1.6222222 0.341547 1.6250000 0.335948 1.6277778 0.318858 1.6305556 0.297348 1.6333333 0.285267 1.6361111 0.284088 1.6388889 0.285856 1.6416667 0.285856 1.6444444 0.285267 1.6472222 0.284972 1.6500000 0.285562 1.6527778 0.285562 1.6555556 0.285562 1.6583333 0.284972 1.6611111 0.284678 1.6638889 0.284678 1.6666667 0.284088 1.6694444 0.285562 1.6722222 0.285562 1.6750000 0.285267 1.6777778 0.284383 1.6805556 0.284088 1.6833333 0.284088 1.6861111 0.284383 1.6888889 0.284678 1.6916667 0.284678 1.6944444 0.284088 1.6972222 0.283499 1.7000000 0.283499 1.7027778 0.284088 1.7055556 0.284972 1.7083333 0.284383 1.7111111 0.283499 1.7138889 0.282910 1.7166667 0.283794 1.7194444 0.284383 1.7222222 0.284972 1.7250000 0.284678 1.7277778 0.284678 1.7305556 0.283499 1.7333333 0.283499 1.7361111 0.284383 1.7388889 0.284678 1.7416667 0.284972 1.7444444 0.284678 1.7472222 0.283794 1.7500000 0.284088 1.7527778 0.283794 1.7555556 0.284383 1.7583333 0.284383 1.7611111 0.284088 1.7638889 0.283499 1.7666667 0.283204 1.7694444 0.283499 1.7722222 0.284972 1.7750000 0.284088 1.7777778 0.283499 1.7805556 0.282910 1.7833333 0.282910 1.7861111 0.284088 1.7888889 0.284088 1.7916667 0.283204 1.7944444 0.282320 1.7972222 0.282320 1.8000000 0.282320 1.8027778 0.282615 1.8055556 0.283794 1.8083333 0.282615 1.8111111 0.282320 1.8138889 0.281731 1.8166667 0.281731 1.8194444 0.281436 1.8222222 0.281731 1.8250000 0.281731 1.8277778 0.280258 1.8305556 0.279669 1.8333333 0.279079 1.8361111 0.279374 1.8388889 0.279669 1.8416667 0.278785 1.8444444 0.278195 1.8472222 0.277901 1.8500000 0.277311 1.8527778 0.278195 1.8555556 0.278195 1.8583333 0.277311 1.8611111 0.276427 1.8638889 0.275543 1.8666667 0.276133 1.8694444 0.275838 1.8722222 0.277017 1.8750000 0.276133 1.8777778 0.275838 1.8805556 0.274954 1.8833333 0.275249 1.8861111 0.275838 1.8888889 0.276133 1.8916667 0.276427 1.8944444 0.276427 1.8972222 0.276133 1.9000000 0.277311 1.9027778 0.278490 1.9055556 0.279669 1.9083333 0.280258 1.9111111 0.280847 1.9138889 0.281731 1.9166667 0.282615 1.9194444 0.283794 1.9222222 0.284972 1.9280000 0.300000 2.1608889 0.300000 2.1638889 0.286151 2.1666667 0.286446 2.1694444 0.286740 2.1722222 0.286740 2.1750000 0.286740 2.1777778 0.286740 2.1805556 0.286446 2.1833333 0.286446 2.1861111 0.287330 2.1888889 0.287624 2.1916667 0.286740 2.1944444 0.285856 2.1972222 0.286151 2.2000000 0.285856 2.2027778 0.286740 2.2055556 0.287330 2.2083333 0.287035 2.2111111 0.287035 2.2138889 0.286446 2.2166667 0.286446 2.2194444 0.287919 2.2222222 0.288214 2.2250000 0.287919 2.2277778 0.288508 2.2305556 0.287624 2.2333333 0.287919 2.2361111 0.288803 2.2388889 0.289098 2.2416667 0.288214 2.2444444 0.288508 2.2472222 0.288214 2.2500000 0.288803 2.2527778 0.289982 2.2555556 0.291750 2.2583333 0.290276 2.2611111 0.290276 2.2638889 0.289098 2.2666667 0.289392 2.2694444 0.289982 2.2722222 0.291160 2.2750000 0.290276 2.2777778 0.289392 2.2805556 0.288214 2.2833333 0.287624 2.2861111 0.287624 2.2888889 0.289098 2.2916667 0.288803 2.2944444 0.288214 2.2972222 0.287330 2.3000000 0.287035 2.3027778 0.287624 2.3055556 0.288508 2.3083333 0.287919 2.3111111 0.287035 2.3138889 0.286740 2.3166667 0.286446 2.3194444 0.287035 2.3222222 0.287624 2.3250000 0.287624 2.3277778 0.286446 2.3305556 0.286151 2.3333333 0.286446 2.3361111 0.286740 2.3388889 0.287330 2.3416667 0.287035 2.3444444 0.287035 2.3472222 0.286446 2.3500000 0.285856 2.3527778 0.287035 2.3555556 0.286740 2.3583333 0.286151 2.3611111 0.285267 2.3638889 0.283499 2.3666667 0.282026 2.3694444 0.280847 2.3722222 0.279669 2.3750000 0.277901 2.3777778 0.275543 2.3805556 0.274954 2.3833333 0.277311 2.3861111 0.282615 2.3888889 0.289392 2.3916667 0.296169 2.3944444 0.302063 2.3972222 0.307661 2.4000000 0.314144 2.4027778 0.321805 2.4055556 0.329171 2.4083333 0.335948 2.4111111 0.338600 2.4138889 0.332118 2.4166667 0.313554 2.4194444 0.293812 2.4222222 0.283499 2.4250000 0.283204 2.4277778 0.284972 2.4305556 0.284972 2.4333333 0.284678 2.4361111 0.286446 2.4388889 0.287035 2.4416667 0.285562 2.4444444 0.284972 2.4472222 0.284678 2.4500000 0.285267 2.4527778 0.286151 2.4555556 0.285562 2.4583333 0.285562 2.4611111 0.284678 2.4638889 0.284383 2.4666667 0.284383 2.4694444 0.284678 2.4722222 0.285856 2.4750000 0.285562 2.4777778 0.284678 2.4805556 0.284088 2.4833333 0.284088 2.4861111 0.284972 2.4888889 0.284972 2.4916667 0.285267 2.4944444 0.284383 2.4972222 0.284088 2.5000000 0.284088 2.5027778 0.284383 2.5055556 0.285267 2.5083333 0.285562 2.5111111 0.284383 2.5138889 0.284088 2.5166667 0.284678 2.5194444 0.284972 2.5222222 0.285562 2.5250000 0.285267 2.5277778 0.284678 2.5305556 0.284088 2.5333333 0.284678 2.5361111 0.284972 2.5388889 0.285267 2.5416667 0.284972 2.5444444 0.284972 2.5472222 0.283794 2.5500000 0.284088 2.5527778 0.284383 2.5555556 0.284678 2.5583333 0.284678 2.5611111 0.283794 2.5638889 0.284088 2.5666667 0.284678 2.5694444 0.285562 2.5722222 0.284972 2.5750000 0.284383 2.5777778 0.284383 2.5805556 0.284088 2.5833333 0.284383 2.5861111 0.284678 2.5888889 0.284088 2.5916667 0.284383 2.5944444 0.284088 2.5972222 0.283499 2.6000000 0.283204 2.6027778 0.283499 2.6055556 0.283204 2.6083333 0.282910 2.6111111 0.281731 2.6138889 0.282026 2.6166667 0.282320 2.6194444 0.282320 2.6222222 0.281731 2.6250000 0.280847 2.6277778 0.279963 2.6305556 0.279963 2.6333333 0.280847 2.6361111 0.281142 2.6388889 0.279079 2.6416667 0.278785 2.6444444 0.277606 2.6472222 0.277311 2.6500000 0.277901 2.6527778 0.278490 2.6555556 0.277901 2.6583333 0.277311 2.6611111 0.277017 2.6638889 0.276722 2.6666667 0.277311 2.6694444 0.277901 2.6722222 0.277901 2.6750000 0.277901 2.6777778 0.277606 2.6805556 0.278490 2.6833333 0.279669 2.6861111 0.280258 2.6888889 0.281436 2.6916667 0.281731 2.6944444 0.282026 2.6972222 0.282910 2.7000000 0.284088 2.7027778 0.284972 2.7055556 0.285267 2.7083333 0.285562 2.7111111 0.286151 2.7168889 0.300000 2.9525556 0.300000 2.9555556 0.286446 2.9583333 0.286151 2.9611111 0.285562 2.9638889 0.285267 2.9666667 0.285562 2.9694444 0.286446 2.9722222 0.286446 2.9750000 0.286151 2.9777778 0.285267 2.9805556 0.285267 2.9833333 0.285856 2.9861111 0.286740 2.9888889 0.286446 2.9916667 0.286151 2.9944444 0.285856 2.9972222 0.285562 3.0000000 0.285856 3.0027778 0.286740 3.0055556 0.286740 3.0083333 0.286446 3.0111111 0.286446 3.0138889 0.286740 3.0166667 0.287919 3.0194444 0.287624 3.0222222 0.287035 3.0250000 0.287919 3.0277778 0.287035 3.0305556 0.287035 3.0333333 0.287624 3.0361111 0.288803 3.0388889 0.289392 3.0416667 0.289392 3.0444444 0.289098 3.0472222 0.288803 3.0500000 0.288803 3.0527778 0.289098 3.0555556 0.287919 3.0583333 0.288214 3.0611111 0.287035 3.0638889 0.287035 3.0666667 0.287035 3.0694444 0.287624 3.0722222 0.286740 3.0750000 0.287035 3.0777778 0.285856 3.0805556 0.285562 3.0833333 0.286151 3.0861111 0.286446 3.0888889 0.285562 3.0916667 0.285562 3.0944444 0.285267 3.0972222 0.284972 3.1000000 0.286446 3.1027778 0.286740 3.1055556 0.286446 3.1083333 0.285562 3.1111111 0.284972 3.1138889 0.284383 3.1166667 0.284972 3.1194444 0.285562 3.1222222 0.284678 3.1250000 0.285267 3.1277778 0.284678 3.1305556 0.284088 3.1333333 0.285856 3.1361111 0.285562 3.1388889 0.285267 3.1416667 0.285267 3.1444444 0.285267 3.1472222 0.284383 3.1500000 0.284972 3.1527778 0.285562 3.1555556 0.284972 3.1583333 0.284383 3.1611111 0.283499 3.1638889 0.282026 3.1666667 0.281142 3.1694444 0.279374 3.1722222 0.277606 3.1750000 0.277017 3.1777778 0.279669 3.1805556 0.285856 3.1833333 0.293517 3.1861111 0.298821 3.1888889 0.302357 3.1916667 0.306483 3.1944444 0.312965 3.1972222 0.320626 3.2000000 0.325930 3.2027778 0.323278 3.2055556 0.309134 3.2083333 0.289982 3.2111111 0.277606 3.2138889 0.275838 3.2166667 0.279079 3.2194444 0.281142 3.2222222 0.282026 3.2250000 0.282320 3.2277778 0.282615 3.2305556 0.282615 3.2333333 0.283204 3.2361111 0.282320 3.2388889 0.281731 3.2416667 0.282026 3.2444444 0.282026 3.2472222 0.282615 3.2500000 0.284088 3.2527778 0.284088 3.2555556 0.283204 3.2583333 0.282026 3.2611111 0.281731 3.2638889 0.282320 3.2666667 0.282910 3.2694444 0.283794 3.2722222 0.283204 3.2750000 0.283204 3.2777778 0.282026 3.2805556 0.282910 3.2833333 0.282910 3.2861111 0.283204 3.2888889 0.283204 3.2916667 0.282910 3.2944444 0.282320 3.2972222 0.282615 3.3000000 0.283204 3.3027778 0.283794 3.3055556 0.282910 3.3083333 0.282615 3.3111111 0.283794 3.3138889 0.283204 3.3166667 0.283204 3.3194444 0.284678 3.3222222 0.284088 3.3250000 0.284383 3.3277778 0.283204 3.3305556 0.282910 3.3333333 0.282615 3.3361111 0.283499 3.3388889 0.282910 3.3416667 0.282615 3.3444444 0.282320 3.3472222 0.281731 3.3500000 0.282026 3.3527778 0.282615 3.3555556 0.282320 3.3583333 0.283499 3.3611111 0.282910 3.3638889 0.282026 3.3666667 0.282910 3.3694444 0.283204 3.3722222 0.282026 3.3750000 0.281731 3.3777778 0.281436 3.3805556 0.282026 3.3833333 0.282615 3.3861111 0.282910 3.3888889 0.282615 3.3916667 0.282320 3.3944444 0.282026 3.3972222 0.280847 3.4000000 0.281731 3.4027778 0.282320 3.4055556 0.281731 3.4083333 0.280258 3.4111111 0.279963 3.4138889 0.279374 3.4166667 0.279079 3.4194444 0.279963 3.4222222 0.279374 3.4250000 0.278490 3.4277778 0.277606 3.4305556 0.276427 3.4333333 0.277311 3.4361111 0.277606 3.4388889 0.277017 3.4416667 0.276427 3.4444444 0.276133 3.4472222 0.276133 3.4500000 0.276133 3.4527778 0.275543 3.4555556 0.275543 3.4583333 0.275249 3.4611111 0.275543 3.4638889 0.274954 3.4666667 0.275838 3.4694444 0.276722 3.4722222 0.277311 3.4750000 0.276133 3.4777778 0.276722 3.4805556 0.276722 3.4833333 0.277901 3.4861111 0.278195 3.4888889 0.277901 3.4916667 0.277901 3.4944444 0.278195 3.4972222 0.278785 3.5000000 0.279669 3.5027778 0.281142 3.5085556 0.300000 3.7414444 0.300000 3.7444444 0.284088 3.7472222 0.284383 3.7500000 0.284972 3.7527778 0.285562 3.7555556 0.284972 3.7583333 0.283794 3.7611111 0.283794 3.7638889 0.283794 3.7666667 0.284972 3.7694444 0.284972 3.7722222 0.284678 3.7750000 0.284383 3.7777778 0.283204 3.7805556 0.283499 3.7833333 0.284383 3.7861111 0.284678 3.7888889 0.284972 3.7916667 0.285267 3.7944444 0.284972 3.7972222 0.285267 3.8000000 0.285856 3.8027778 0.286446 3.8055556 0.286151 3.8083333 0.286740 3.8111111 0.286151 3.8138889 0.285856 3.8166667 0.286740 3.8194444 0.287330 3.8222222 0.286151 3.8250000 0.286446 3.8277778 0.286740 3.8305556 0.287330 3.8333333 0.287919 3.8361111 0.288214 3.8388889 0.287624 3.8416667 0.286740 3.8444444 0.286446 3.8472222 0.286740 3.8500000 0.287330 3.8527778 0.287624 3.8555556 0.286151 3.8583333 0.285856 3.8611111 0.284972 3.8638889 0.285562 3.8666667 0.286151 3.8694444 0.286446 3.8722222 0.286151 3.8750000 0.285562 3.8777778 0.284088 3.8805556 0.284678 3.8833333 0.285267 3.8861111 0.285856 3.8888889 0.285856 3.8916667 0.284972 3.8944444 0.284678 3.8972222 0.284383 3.9000000 0.284972 3.9027778 0.285562 3.9055556 0.285562 3.9083333 0.284678 3.9111111 0.284972 3.9138889 0.284678 3.9166667 0.284972 3.9194444 0.285856 3.9222222 0.285856 3.9250000 0.284678 3.9277778 0.284678 3.9305556 0.285267 3.9333333 0.285856 3.9361111 0.286151 3.9388889 0.285856 3.9416667 0.284972 3.9444444 0.284088 3.9472222 0.283204 3.9500000 0.282910 3.9527778 0.281731 3.9555556 0.280552 3.9583333 0.278490 3.9611111 0.278195 3.9638889 0.279374 3.9666667 0.284678 3.9694444 0.292044 3.9722222 0.298821 3.9750000 0.302063 3.9777778 0.305599 3.9805556 0.310902 3.9833333 0.318564 3.9861111 0.326519 3.9888889 0.330350 3.9916667 0.326519 3.9944444 0.310313 3.9972222 0.289392 4.0000000 0.277311 4.0027778 0.276722 4.0055556 0.279669 4.0083333 0.281731 4.0111111 0.282910 4.0138889 0.283794 4.0166667 0.284383 4.0194444 0.286151 4.0222222 0.285267 4.0250000 0.284383 4.0277778 0.284972 4.0305556 0.285562 4.0333333 0.285856 4.0361111 0.285856 4.0388889 0.285267 4.0416667 0.284678 4.0444444 0.284383 4.0472222 0.283794 4.0500000 0.284972 4.0527778 0.285856 4.0555556 0.285562 4.0583333 0.284678 4.0611111 0.284678 4.0638889 0.284383 4.0666667 0.285267 4.0694444 0.285267 4.0722222 0.285562 4.0750000 0.285267 4.0777778 0.284383 4.0805556 0.284972 4.0833333 0.285267 4.0861111 0.285562 4.0888889 0.285562 4.0916667 0.284972 4.0944444 0.284678 4.0972222 0.285267 4.1000000 0.285856 4.1027778 0.287330 4.1055556 0.286446 4.1083333 0.285267 4.1111111 0.285267 4.1138889 0.284972 4.1166667 0.285856 4.1194444 0.287035 4.1222222 0.286151 4.1250000 0.286151 4.1277778 0.285856 4.1305556 0.284972 4.1333333 0.285562 4.1361111 0.286740 4.1388889 0.286446 4.1416667 0.286151 4.1444444 0.285856 4.1472222 0.285856 4.1500000 0.285856 4.1527778 0.286446 4.1555556 0.285562 4.1583333 0.284972 4.1611111 0.285267 4.1638889 0.285267 4.1666667 0.286151 4.1694444 0.285856 4.1722222 0.286151 4.1750000 0.284972 4.1777778 0.284972 4.1805556 0.284972 4.1833333 0.285267 4.1861111 0.286151 4.1888889 0.284678 4.1916667 0.284972 4.1944444 0.284088 4.1972222 0.283204 4.2000000 0.283204 4.2027778 0.283499 4.2055556 0.283204 4.2083333 0.283204 4.2111111 0.282026 4.2138889 0.282615 4.2166667 0.283204 4.2194444 0.282910 4.2222222 0.282026 4.2250000 0.281142 4.2277778 0.280258 4.2305556 0.279963 4.2333333 0.281436 4.2361111 0.281436 4.2388889 0.280552 4.2416667 0.279669 4.2444444 0.279374 4.2472222 0.279079 4.2500000 0.278490 4.2527778 0.279079 4.2555556 0.278490 4.2583333 0.278195 4.2611111 0.277901 4.2638889 0.277901 4.2666667 0.278195 4.2694444 0.279079 4.2722222 0.278785 4.2750000 0.279963 4.2777778 0.279963 4.2805556 0.280552 4.2833333 0.281436 4.2861111 0.282910 4.2888889 0.283794 4.2916667 0.284383 4.2974444 0.300000 4.5581111 0.300000 4.5611111 0.290276 4.5638889 0.290571 4.5666667 0.290571 4.5694444 0.291455 4.5722222 0.291160 4.5750000 0.291160 4.5777778 0.290571 4.5805556 0.290571 4.5833333 0.291160 4.5861111 0.291160 4.5888889 0.291160 4.5916667 0.290866 4.5944444 0.290571 4.5972222 0.290571 4.6000000 0.291160 4.6027778 0.292339 4.6055556 0.291160 4.6083333 0.290866 4.6111111 0.290571 4.6138889 0.291160 4.6166667 0.292634 4.6194444 0.292928 4.6222222 0.293223 4.6250000 0.292634 4.6277778 0.292044 4.6305556 0.291750 4.6333333 0.292339 4.6361111 0.293812 4.6388889 0.293812 4.6416667 0.294107 4.6444444 0.293812 4.6472222 0.294696 4.6500000 0.295285 4.6527778 0.295580 4.6555556 0.294696 4.6583333 0.294696 4.6611111 0.294107 4.6638889 0.294107 4.6666667 0.294401 4.6694444 0.294696 4.6722222 0.293517 4.6750000 0.292634 4.6777778 0.292339 4.6805556 0.292928 4.6833333 0.292928 4.6861111 0.293517 4.6888889 0.293517 4.6916667 0.292928 4.6944444 0.292339 4.6972222 0.291750 4.7000000 0.291455 4.7027778 0.292634 4.7055556 0.292339 4.7083333 0.291160 4.7111111 0.291455 4.7138889 0.291750 4.7166667 0.291750 4.7194444 0.292928 4.7222222 0.292044 4.7250000 0.291455 4.7277778 0.290571 4.7305556 0.291160 4.7333333 0.292044 4.7361111 0.292634 4.7388889 0.292044 4.7416667 0.291455 4.7444444 0.291160 4.7472222 0.290571 4.7500000 0.291455 4.7527778 0.292044 4.7555556 0.292044 4.7583333 0.292634 4.7611111 0.290571 4.7638889 0.289687 4.7666667 0.288508 4.7694444 0.287624 4.7722222 0.286446 4.7750000 0.284088 4.7777778 0.282910 4.7805556 0.283499 4.7833333 0.288508 4.7861111 0.297053 4.7888889 0.305009 4.7916667 0.311492 4.7944444 0.317974 4.7972222 0.324751 4.8000000 0.333297 4.8027778 0.341547 4.8055556 0.347145 4.8083333 0.346851 4.8111111 0.335064 4.8138889 0.313849 4.8166667 0.295580 4.8194444 0.288803 4.8222222 0.289098 4.8250000 0.290866 4.8277778 0.289982 4.8305556 0.290276 4.8333333 0.290866 4.8361111 0.291455 4.8388889 0.290866 4.8416667 0.288803 4.8444444 0.288214 4.8472222 0.288508 4.8500000 0.289687 4.8527778 0.289687 4.8555556 0.289392 4.8583333 0.289098 4.8611111 0.288214 4.8638889 0.288508 4.8666667 0.288214 4.8694444 0.288508 4.8722222 0.288803 4.8750000 0.288508 4.8777778 0.288214 4.8805556 0.288214 4.8833333 0.288803 4.8861111 0.289392 4.8888889 0.289098 4.8916667 0.288508 4.8944444 0.287624 4.8972222 0.287624 4.9000000 0.289687 4.9027778 0.288803 4.9055556 0.289098 4.9083333 0.289098 4.9111111 0.288508 4.9138889 0.288214 4.9166667 0.288508 4.9194444 0.289392 4.9222222 0.288803 4.9250000 0.288508 4.9277778 0.288803 4.9305556 0.288508 4.9333333 0.289687 4.9361111 0.289687 4.9388889 0.289098 4.9416667 0.288803 4.9444444 0.288508 4.9472222 0.288803 4.9500000 0.289098 4.9527778 0.289982 4.9555556 0.289982 4.9583333 0.288803 4.9611111 0.288214 4.9638889 0.288214 4.9666667 0.289392 4.9694444 0.289687 4.9722222 0.288508 4.9750000 0.289687 4.9777778 0.288803 4.9805556 0.288803 4.9833333 0.288803 4.9861111 0.289392 4.9888889 0.288803 4.9916667 0.287624 4.9944444 0.287919 4.9972222 0.288214 5.0000000 0.287624 5.0027778 0.288508 5.0055556 0.287919 5.0083333 0.287330 5.0111111 0.286446 5.0138889 0.287330 5.0166667 0.286740 5.0194444 0.287919 5.0222222 0.287330 5.0250000 0.286151 5.0277778 0.285562 5.0305556 0.285562 5.0333333 0.285856 5.0361111 0.285562 5.0388889 0.286151 5.0416667 0.284678 5.0444444 0.284383 5.0472222 0.284088 5.0500000 0.284383 5.0527778 0.284383 5.0555556 0.284088 5.0583333 0.283204 5.0611111 0.282320 5.0638889 0.282615 5.0666667 0.282615 5.0694444 0.282615 5.0722222 0.282026 5.0750000 0.281731 5.0777778 0.281142 5.0805556 0.280847 5.0833333 0.281142 5.0861111 0.281731 5.0888889 0.281142 5.0916667 0.281142 5.0944444 0.280847 5.0972222 0.281731 5.1000000 0.283499 5.1027778 0.283499 5.1055556 0.283499 5.1083333 0.284383 5.1141111 0.300000 5.2108889 0.300000 5.2138889 0.292928 5.2166667 0.293223 5.2194444 0.293812 5.2222222 0.293517 5.2250000 0.292634 5.2277778 0.293223 5.2305556 0.292339 5.2333333 0.293223 5.2361111 0.294401 5.2388889 0.294107 5.2416667 0.293517 5.2444444 0.293223 5.2472222 0.293223 5.2500000 0.293812 5.2527778 0.294107 5.2555556 0.293517 5.2583333 0.294107 5.2611111 0.294107 5.2638889 0.293812 5.2666667 0.294401 5.2694444 0.294401 5.2722222 0.294401 5.2750000 0.293517 5.2777778 0.293223 5.2805556 0.293517 5.2833333 0.293812 5.2861111 0.293812 5.2888889 0.293223 5.2916667 0.293223 5.2944444 0.292044 5.2972222 0.292634 5.3000000 0.292044 5.3027778 0.292634 5.3055556 0.292339 5.3083333 0.291160 5.3111111 0.290866 5.3138889 0.290276 5.3166667 0.290276 5.3194444 0.289982 5.3222222 0.289687 5.3250000 0.289982 5.3277778 0.289687 5.3305556 0.289982 5.3333333 0.290276 5.3361111 0.290571 5.3388889 0.290571 5.3416667 0.289982 5.3444444 0.289392 5.3472222 0.289982 5.3500000 0.290866 5.3527778 0.290866 5.3555556 0.290571 5.3583333 0.290571 5.3611111 0.289687 5.3638889 0.289982 5.3666667 0.290866 5.3694444 0.291160 5.3722222 0.290571 5.3750000 0.290866 5.3777778 0.290276 5.3805556 0.290571 5.3833333 0.291160 5.3861111 0.291160 5.3888889 0.291455 5.3916667 0.290866 5.3944444 0.290276 5.3972222 0.290866 5.4000000 0.292044 5.4027778 0.292339 5.4055556 0.291455 5.4083333 0.290866 5.4111111 0.290571 5.4138889 0.290571 5.4166667 0.289687 5.4194444 0.288803 5.4222222 0.286151 5.4250000 0.285267 5.4277778 0.282615 5.4305556 0.281436 5.4333333 0.282615 5.4361111 0.288803 5.4388889 0.294991 5.4416667 0.303536 5.4444444 0.310313 5.4472222 0.315617 5.4500000 0.322394 5.4527778 0.328582 5.4555556 0.334770 5.4583333 0.339190 5.4611111 0.339190 5.4638889 0.329466 5.4666667 0.312081 5.4694444 0.295580 5.4722222 0.287330 5.4750000 0.287919 5.4777778 0.289392 5.4805556 0.289687 5.4833333 0.290276 5.4861111 0.291455 5.4888889 0.291455 5.4916667 0.290571 5.4944444 0.290276 5.4972222 0.289982 5.5000000 0.290866 5.5027778 0.290866 5.5055556 0.290866 5.5083333 0.289982 5.5111111 0.289687 5.5138889 0.289982 5.5166667 0.290866 5.5194444 0.290866 5.5222222 0.290571 5.5250000 0.290276 5.5277778 0.289392 5.5305556 0.289687 5.5333333 0.289982 5.5361111 0.290571 5.5388889 0.290571 5.5416667 0.289982 5.5444444 0.289392 5.5472222 0.289392 5.5500000 0.289982 5.5527778 0.290276 5.5555556 0.290276 5.5583333 0.289687 5.5611111 0.289392 5.5638889 0.289098 5.5666667 0.289982 5.5694444 0.290571 5.5722222 0.290276 5.5750000 0.289687 5.5777778 0.289687 5.5805556 0.289687 5.5833333 0.289392 5.5861111 0.289982 5.5888889 0.290571 5.5916667 0.289982 5.5944444 0.289392 5.5972222 0.289098 5.6000000 0.289982 5.6027778 0.290571 5.6055556 0.289392 5.6083333 0.289392 5.6111111 0.289098 5.6138889 0.289098 5.6166667 0.290276 5.6194444 0.290866 5.6222222 0.289982 5.6250000 0.289687 5.6277778 0.288508 5.6305556 0.288508 5.6333333 0.288803 5.6361111 0.289687 5.6388889 0.289687 5.6416667 0.288803 5.6444444 0.288803 5.6472222 0.288803 5.6500000 0.289098 5.6527778 0.288803 5.6555556 0.287330 5.6583333 0.287035 5.6611111 0.287330 5.6638889 0.286740 5.6666667 0.287330 5.6694444 0.288214 5.6722222 0.286446 5.6750000 0.286740 5.6777778 0.285562 5.6805556 0.285856 5.6833333 0.285562 5.6861111 0.287035 5.6888889 0.285562 5.6916667 0.284678 5.6944444 0.283499 5.6972222 0.283499 5.7000000 0.283204 5.7027778 0.284088 5.7055556 0.283204 5.7083333 0.282615 5.7111111 0.282026 5.7138889 0.282026 5.7166667 0.281436 5.7194444 0.282026 5.7222222 0.281731 5.7250000 0.280552 5.7277778 0.280847 5.7305556 0.280552 5.7333333 0.281436 5.7361111 0.281731 5.7388889 0.281436 5.7416667 0.281731 5.7444444 0.281142 5.7472222 0.282026 5.7500000 0.282910 5.7527778 0.283794 5.7555556 0.284088 5.7583333 0.284383 5.7611111 0.284383 5.7668889 0.300000 6.2053333 0.300000 6.2083333 0.287035 6.2111111 0.286740 6.2138889 0.286740 6.2166667 0.287919 6.2194444 0.288214 6.2222222 0.287919 6.2250000 0.287919 6.2277778 0.287624 6.2305556 0.287624 6.2333333 0.288508 6.2361111 0.288508 6.2388889 0.288508 6.2416667 0.288214 6.2444444 0.286740 6.2472222 0.286740 6.2500000 0.287919 6.2527778 0.288803 6.2555556 0.288508 6.2583333 0.288803 6.2611111 0.288214 6.2638889 0.289098 6.2666667 0.289392 6.2694444 0.290276 6.2722222 0.289982 6.2750000 0.289392 6.2777778 0.289687 6.2805556 0.289982 6.2833333 0.290276 6.2861111 0.291160 6.2888889 0.290866 6.2916667 0.290276 6.2944444 0.289982 6.2972222 0.290276 6.3000000 0.290276 6.3027778 0.290866 6.3055556 0.289982 6.3083333 0.289392 6.3111111 0.289982 6.3138889 0.290276 6.3166667 0.290571 6.3194444 0.290571 6.3222222 0.289392 6.3250000 0.288803 6.3277778 0.287919 6.3305556 0.288803 6.3333333 0.288803 6.3361111 0.289982 6.3388889 0.289098 6.3416667 0.288803 6.3444444 0.288508 6.3472222 0.286740 6.3500000 0.287330 6.3527778 0.288214 6.3555556 0.287919 6.3583333 0.287919 6.3611111 0.287919 6.3638889 0.287035 6.3666667 0.287624 6.3694444 0.287624 6.3722222 0.287624 6.3750000 0.287330 6.3777778 0.286740 6.3805556 0.286151 6.3833333 0.286446 6.3861111 0.287919 6.3888889 0.287330 6.3916667 0.286740 6.3944444 0.286740 6.3972222 0.287035 6.4000000 0.287035 6.4027778 0.287330 6.4055556 0.286740 6.4083333 0.286740 6.4111111 0.284972 6.4138889 0.283794 6.4166667 0.282910 6.4194444 0.282910 6.4222222 0.281436 6.4250000 0.280552 6.4277778 0.282026 6.4305556 0.285562 6.4333333 0.293223 6.4361111 0.298527 6.4388889 0.301768 6.4416667 0.304715 6.4444444 0.309134 6.4472222 0.315617 6.4500000 0.322689 6.4527778 0.329466 6.4555556 0.332118 6.4583333 0.326519 6.4611111 0.312670 6.4638889 0.294696 6.4666667 0.280847 6.4694444 0.277017 6.4722222 0.277311 6.4750000 0.278490 6.4777778 0.280258 6.4805556 0.282615 6.4833333 0.283204 6.4861111 0.284088 6.4888889 0.284383 6.4916667 0.284088 6.4944444 0.283794 6.4972222 0.283204 6.5000000 0.284383 6.5027778 0.285267 6.5055556 0.284678 6.5083333 0.284678 6.5111111 0.284383 6.5138889 0.284088 6.5166667 0.284383 6.5194444 0.285562 6.5222222 0.284678 6.5250000 0.284972 6.5277778 0.283499 6.5305556 0.284678 6.5333333 0.285267 6.5361111 0.285267 6.5388889 0.284972 6.5416667 0.284972 6.5444444 0.284678 6.5472222 0.284678 6.5500000 0.284972 6.5527778 0.286740 6.5555556 0.285856 6.5583333 0.285562 6.5611111 0.284383 6.5638889 0.283794 6.5666667 0.285267 6.5694444 0.285562 6.5722222 0.286446 6.5750000 0.285856 6.5777778 0.284972 6.5805556 0.285267 6.5833333 0.285267 6.5861111 0.285562 6.5888889 0.286151 6.5916667 0.285856 6.5944444 0.285267 6.5972222 0.285267 6.6000000 0.285562 6.6027778 0.287035 6.6055556 0.285562 6.6083333 0.285562 6.6111111 0.285856 6.6138889 0.284972 6.6166667 0.285562 6.6194444 0.286740 6.6222222 0.285856 6.6250000 0.285267 6.6277778 0.284678 6.6305556 0.284383 6.6333333 0.284972 6.6361111 0.285856 6.6388889 0.285267 6.6416667 0.285267 6.6444444 0.284383 6.6472222 0.284678 6.6500000 0.284678 6.6527778 0.284383 6.6555556 0.283794 6.6583333 0.284088 6.6611111 0.284088 6.6638889 0.284088 6.6666667 0.284088 6.6694444 0.285562 6.6722222 0.284383 6.6750000 0.284383 6.6777778 0.284088 6.6805556 0.283204 6.6833333 0.284678 6.6861111 0.285562 6.6888889 0.284972 6.6916667 0.284383 6.6944444 0.283204 6.6972222 0.282615 6.7000000 0.282320 6.7027778 0.282615 6.7055556 0.283204 6.7083333 0.281142 6.7111111 0.280847 6.7138889 0.280258 6.7166667 0.280258 6.7194444 0.280552 6.7222222 0.279374 6.7250000 0.279669 6.7277778 0.278490 6.7305556 0.277606 6.7333333 0.277901 6.7361111 0.277901 6.7388889 0.277311 6.7416667 0.277311 6.7444444 0.276427 6.7472222 0.276427 6.7500000 0.276722 6.7527778 0.277017 6.7555556 0.277017 6.7613333 0.300000 7.0497778 0.300000 7.0527778 0.289098 7.0555556 0.288508 7.0583333 0.288214 7.0611111 0.288214 7.0638889 0.287919 7.0666667 0.288508 7.0694444 0.289098 7.0722222 0.288803 7.0750000 0.288508 7.0777778 0.288214 7.0805556 0.288214 7.0833333 0.288214 7.0861111 0.288803 7.0888889 0.288214 7.0916667 0.288803 7.0944444 0.288214 7.0972222 0.288508 7.1000000 0.289392 7.1027778 0.290571 7.1055556 0.289392 7.1083333 0.289392 7.1111111 0.289098 7.1138889 0.289392 7.1166667 0.290571 7.1194444 0.291455 7.1222222 0.290866 7.1250000 0.289982 7.1277778 0.289982 7.1305556 0.290866 7.1333333 0.291455 7.1361111 0.292339 7.1388889 0.292044 7.1416667 0.291750 7.1444444 0.292044 7.1472222 0.291750 7.1500000 0.291750 7.1527778 0.292634 7.1555556 0.292339 7.1583333 0.291160 7.1611111 0.290276 7.1638889 0.290276 7.1666667 0.290276 7.1694444 0.290866 7.1722222 0.291160 7.1750000 0.290276 7.1777778 0.289392 7.1805556 0.288508 7.1833333 0.289687 7.1861111 0.289982 7.1888889 0.289687 7.1916667 0.289098 7.1944444 0.288508 7.1972222 0.288803 7.2000000 0.289687 7.2027778 0.289098 7.2055556 0.288803 7.2083333 0.287919 7.2111111 0.287330 7.2138889 0.287330 7.2166667 0.288508 7.2194444 0.289392 7.2222222 0.288803 7.2250000 0.288214 7.2277778 0.288214 7.2305556 0.287330 7.2333333 0.288214 7.2361111 0.289392 7.2388889 0.288508 7.2416667 0.288214 7.2444444 0.287919 7.2472222 0.287624 7.2500000 0.288214 7.2527778 0.287919 7.2555556 0.286151 7.2583333 0.284678 7.2611111 0.283204 7.2638889 0.282320 7.2666667 0.280847 7.2694444 0.281142 7.2722222 0.282910 7.2750000 0.288803 7.2777778 0.296759 7.2805556 0.302947 7.2833333 0.308840 7.2861111 0.314438 7.2888889 0.320331 7.2916667 0.326225 7.2944444 0.331234 7.2972222 0.335064 7.3000000 0.330645 7.3027778 0.316206 7.3055556 0.294991 7.3083333 0.282320 7.3111111 0.280258 7.3138889 0.283204 7.3166667 0.285267 7.3194444 0.285562 7.3222222 0.286151 7.3250000 0.287330 7.3277778 0.286446 7.3305556 0.286446 7.3333333 0.285856 7.3361111 0.286151 7.3388889 0.286151 7.3416667 0.285562 7.3444444 0.284972 7.3472222 0.285267 7.3500000 0.285856 7.3527778 0.286740 7.3555556 0.286446 7.3583333 0.285267 7.3611111 0.285856 7.3638889 0.284972 7.3666667 0.286446 7.3694444 0.286740 7.3722222 0.286740 7.3750000 0.286740 7.3777778 0.286446 7.3805556 0.285856 7.3833333 0.286740 7.3861111 0.287330 7.3888889 0.287330 7.3916667 0.286740 7.3944444 0.286151 7.3972222 0.285856 7.4000000 0.286740 7.4027778 0.287919 7.4055556 0.287624 7.4083333 0.286740 7.4111111 0.286446 7.4138889 0.286151 7.4166667 0.286740 7.4194444 0.287330 7.4222222 0.287035 7.4250000 0.286446 7.4277778 0.286151 7.4305556 0.286446 7.4333333 0.287330 7.4361111 0.287330 7.4388889 0.287330 7.4416667 0.286740 7.4444444 0.286151 7.4472222 0.286151 7.4500000 0.286446 7.4527778 0.287330 7.4555556 0.286740 7.4583333 0.286740 7.4611111 0.286151 7.4638889 0.285562 7.4666667 0.285856 7.4694444 0.286740 7.4722222 0.287624 7.4750000 0.286446 7.4777778 0.286446 7.4805556 0.285562 7.4833333 0.287035 7.4861111 0.286740 7.4888889 0.286151 7.4916667 0.285562 7.4944444 0.285267 7.4972222 0.285267 7.5000000 0.285856 7.5027778 0.285856 7.5055556 0.285562 7.5083333 0.285267 7.5111111 0.284088 7.5138889 0.284088 7.5166667 0.284383 7.5194444 0.284678 7.5222222 0.283499 7.5250000 0.282615 7.5277778 0.282615 7.5305556 0.281436 7.5333333 0.281731 7.5361111 0.282026 7.5388889 0.281731 7.5416667 0.280847 7.5444444 0.280552 7.5472222 0.279374 7.5500000 0.279963 7.5527778 0.280258 7.5555556 0.279374 7.5583333 0.279374 7.5611111 0.278195 7.5638889 0.278490 7.5666667 0.279079 7.5694444 0.280258 7.5722222 0.279079 7.5750000 0.278490 7.5777778 0.278195 7.5805556 0.278785 7.5833333 0.280258 7.5861111 0.281436 7.5888889 0.281436 7.5916667 0.282026 7.5944444 0.283204 7.5972222 0.283204 7.6000000 0.284088 7.6057778 0.300000 7.8608889 0.300000 7.8638889 0.287919 7.8666667 0.289098 7.8694444 0.290571 7.8722222 0.289982 7.8750000 0.288803 7.8777778 0.288803 7.8805556 0.288803 7.8833333 0.289392 7.8861111 0.289982 7.8888889 0.290571 7.8916667 0.289982 7.8944444 0.289098 7.8972222 0.288508 7.9000000 0.289392 7.9027778 0.289687 7.9055556 0.289982 7.9083333 0.289982 7.9111111 0.288508 7.9138889 0.288214 7.9166667 0.289392 7.9194444 0.289982 7.9222222 0.289687 7.9250000 0.289392 7.9277778 0.289392 7.9305556 0.289982 7.9333333 0.290866 7.9361111 0.292044 7.9388889 0.291455 7.9416667 0.290571 7.9444444 0.290571 7.9472222 0.290571 7.9500000 0.291750 7.9527778 0.292928 7.9555556 0.292928 7.9583333 0.292339 7.9611111 0.292339 7.9638889 0.292634 7.9666667 0.292634 7.9694444 0.293223 7.9722222 0.293517 7.9750000 0.292339 7.9777778 0.291455 7.9805556 0.290866 7.9833333 0.291750 7.9861111 0.291750 7.9888889 0.291455 7.9916667 0.291160 7.9944444 0.290571 7.9972222 0.290276 8.0000000 0.290571 8.0027778 0.291160 8.0055556 0.290276 8.0083333 0.289098 8.0111111 0.289392 8.0138889 0.289098 8.0166667 0.289982 8.0194444 0.290866 8.0222222 0.289687 8.0250000 0.288803 8.0277778 0.288508 8.0305556 0.288508 8.0333333 0.289392 8.0361111 0.289687 8.0388889 0.289392 8.0416667 0.289392 8.0444444 0.288803 8.0472222 0.289982 8.0500000 0.289392 8.0527778 0.289687 8.0555556 0.289392 8.0583333 0.289098 8.0611111 0.288214 8.0638889 0.288508 8.0666667 0.288214 8.0694444 0.286740 8.0722222 0.284972 8.0750000 0.282615 8.0777778 0.280552 8.0805556 0.279963 8.0833333 0.282026 8.0861111 0.288508 8.0888889 0.296169 8.0916667 0.304125 8.0944444 0.310608 8.0972222 0.316796 8.1000000 0.324457 8.1027778 0.332707 8.1055556 0.339484 8.1083333 0.341252 8.1111111 0.332707 8.1138889 0.312376 8.1166667 0.292634 8.1194444 0.284383 8.1222222 0.285856 8.1250000 0.287330 8.1277778 0.287330 8.1305556 0.286446 8.1333333 0.287035 8.1361111 0.287624 8.1388889 0.286151 8.1416667 0.286151 8.1444444 0.286151 8.1472222 0.286446 8.1500000 0.286740 8.1527778 0.287624 8.1555556 0.287330 8.1583333 0.286740 8.1611111 0.285856 8.1638889 0.285267 8.1666667 0.286446 8.1694444 0.286446 8.1722222 0.286740 8.1750000 0.286446 8.1777778 0.285856 8.1805556 0.286151 8.1833333 0.286446 8.1861111 0.286740 8.1888889 0.286446 8.1916667 0.285562 8.1944444 0.286151 8.1972222 0.286151 8.2000000 0.287035 8.2027778 0.287035 8.2055556 0.286740 8.2083333 0.286446 8.2111111 0.285562 8.2138889 0.286740 8.2166667 0.287035 8.2194444 0.287624 8.2222222 0.287624 8.2250000 0.287035 8.2277778 0.285856 8.2305556 0.286151 8.2333333 0.286740 8.2361111 0.287624 8.2388889 0.288214 8.2416667 0.286740 8.2444444 0.286740 8.2472222 0.286740 8.2500000 0.286740 8.2527778 0.287330 8.2555556 0.287330 8.2583333 0.286151 8.2611111 0.285856 8.2638889 0.285856 8.2666667 0.286151 8.2694444 0.287035 8.2722222 0.286740 8.2750000 0.286151 8.2777778 0.285562 8.2805556 0.285562 8.2833333 0.286446 8.2861111 0.286740 8.2888889 0.287035 8.2916667 0.285562 8.2944444 0.285267 8.2972222 0.284972 8.3000000 0.284972 8.3027778 0.285856 8.3055556 0.285267 8.3083333 0.284678 8.3111111 0.283794 8.3138889 0.283204 8.3166667 0.283794 8.3194444 0.283499 8.3222222 0.282910 8.3250000 0.282320 8.3277778 0.282026 8.3305556 0.281436 8.3333333 0.281731 8.3361111 0.281436 8.3388889 0.280847 8.3416667 0.280258 8.3444444 0.279374 8.3472222 0.279669 8.3500000 0.279963 8.3527778 0.280258 8.3555556 0.279374 8.3583333 0.278785 8.3611111 0.278195 8.3638889 0.278490 8.3666667 0.278785 8.3694444 0.279669 8.3722222 0.279963 8.3750000 0.279374 8.3777778 0.279079 8.3805556 0.279669 8.3833333 0.280847 8.3861111 0.282026 8.3888889 0.282320 8.3916667 0.283204 8.3944444 0.283204 8.3972222 0.283499 8.4000000 0.284383 8.4027778 0.286446 8.4055556 0.286151 8.4083333 0.285856 8.4111111 0.285562 8.4168889 0.300000 8.6497778 0.300000 8.6527778 0.291160 8.6555556 0.290571 8.6583333 0.290276 8.6611111 0.289392 8.6638889 0.289392 8.6666667 0.290276 8.6694444 0.291160 8.6722222 0.290866 8.6750000 0.290866 8.6777778 0.289982 8.6805556 0.289687 8.6833333 0.290276 8.6861111 0.290866 8.6888889 0.291160 8.6916667 0.290866 8.6944444 0.290276 8.6972222 0.290276 8.7000000 0.290571 8.7027778 0.290571 8.7055556 0.290276 8.7083333 0.289982 8.7111111 0.289687 8.7138889 0.290571 8.7166667 0.292044 8.7194444 0.291750 8.7222222 0.291455 8.7250000 0.291750 8.7277778 0.291455 8.7305556 0.292044 8.7333333 0.292634 8.7361111 0.293223 8.7388889 0.293223 8.7416667 0.292634 8.7444444 0.292339 8.7472222 0.293812 8.7500000 0.294401 8.7527778 0.294401 8.7555556 0.294401 8.7583333 0.294401 8.7611111 0.294401 8.7638889 0.293223 8.7666667 0.292928 8.7694444 0.292928 8.7722222 0.292339 8.7750000 0.292044 8.7777778 0.292634 8.7805556 0.291750 8.7833333 0.292044 8.7861111 0.292928 8.7888889 0.291160 8.7916667 0.291160 8.7944444 0.290866 8.7972222 0.290571 8.8000000 0.291455 8.8027778 0.291750 8.8055556 0.291455 8.8083333 0.291455 8.8111111 0.290571 8.8138889 0.290276 8.8166667 0.290866 8.8194444 0.291455 8.8222222 0.290866 8.8250000 0.290866 8.8277778 0.289982 8.8305556 0.290276 8.8333333 0.290571 8.8361111 0.290866 8.8388889 0.290571 8.8416667 0.289982 8.8444444 0.289982 8.8472222 0.290276 8.8500000 0.290276 8.8527778 0.291455 8.8555556 0.289982 8.8583333 0.288803 8.8611111 0.286740 8.8638889 0.285267 8.8666667 0.284088 8.8694444 0.283499 8.8722222 0.282026 8.8750000 0.282910 8.8777778 0.288214 8.8805556 0.295580 8.8833333 0.302357 8.8861111 0.307956 8.8888889 0.312670 8.8916667 0.318858 8.8944444 0.325635 8.8972222 0.331823 8.9000000 0.334180 8.9027778 0.327403 8.9055556 0.308545 8.9083333 0.290866 8.9111111 0.283204 8.9138889 0.285267 8.9166667 0.288214 8.9194444 0.289392 8.9222222 0.288803 8.9250000 0.288803 8.9277778 0.289098 8.9305556 0.288508 8.9333333 0.289098 8.9361111 0.289687 8.9388889 0.288803 8.9416667 0.288508 8.9444444 0.287919 8.9472222 0.287919 8.9500000 0.289098 8.9527778 0.290276 8.9555556 0.289098 8.9583333 0.288803 8.9611111 0.287624 8.9638889 0.287624 8.9666667 0.288214 8.9694444 0.288803 8.9722222 0.289098 8.9750000 0.288508 8.9777778 0.287624 8.9805556 0.287624 8.9833333 0.288803 8.9861111 0.289392 8.9888889 0.288803 8.9916667 0.288508 8.9944444 0.287330 8.9972222 0.287330 9.0000000 0.288508 9.0027778 0.289098 9.0055556 0.289392 9.0083333 0.289098 9.0111111 0.288214 9.0138889 0.287919 9.0166667 0.288803 9.0194444 0.289392 9.0222222 0.289098 9.0250000 0.288508 9.0277778 0.288508 9.0305556 0.288508 9.0333333 0.288803 9.0361111 0.289098 9.0388889 0.288508 9.0416667 0.288508 9.0444444 0.287919 9.0472222 0.288214 9.0500000 0.288803 9.0527778 0.289098 9.0555556 0.288508 9.0583333 0.287624 9.0611111 0.287330 9.0638889 0.287330 9.0666667 0.287919 9.0694444 0.288803 9.0722222 0.288803 9.0750000 0.287919 9.0777778 0.287035 9.0805556 0.287330 9.0833333 0.287919 9.0861111 0.287624 9.0888889 0.287035 9.0916667 0.286446 9.0944444 0.285856 9.0972222 0.284972 9.1000000 0.285856 9.1027778 0.286740 9.1055556 0.286446 9.1083333 0.285267 9.1111111 0.285267 9.1138889 0.284678 9.1166667 0.284678 9.1194444 0.284972 9.1222222 0.284678 9.1250000 0.283204 9.1277778 0.282615 9.1305556 0.282320 9.1333333 0.283204 9.1361111 0.283499 9.1388889 0.282910 9.1416667 0.282026 9.1444444 0.281436 9.1472222 0.281142 9.1500000 0.281731 9.1527778 0.282026 9.1555556 0.281731 9.1583333 0.281142 9.1611111 0.280847 9.1638889 0.280258 9.1666667 0.281142 9.1694444 0.282320 9.1722222 0.282320 9.1750000 0.282320 9.1777778 0.283204 9.1805556 0.283499 9.1833333 0.284678 9.1861111 0.285856 9.1888889 0.286151 9.1916667 0.286740 9.1944444 0.286446 9.1972222 0.286740 9.2000000 0.288803 9.2057778 0.300000 9.4220000 0.300000 9.4250000 0.287919 9.4277778 0.287624 9.4305556 0.287330 9.4333333 0.287035 9.4361111 0.287919 9.4388889 0.287035 9.4416667 0.286446 9.4444444 0.286740 9.4472222 0.286740 9.4500000 0.288508 9.4527778 0.288508 9.4555556 0.287035 9.4583333 0.286446 9.4611111 0.285267 9.4638889 0.285856 9.4666667 0.286740 9.4694444 0.287624 9.4722222 0.287624 9.4750000 0.286446 9.4777778 0.286151 9.4805556 0.285856 9.4833333 0.287624 9.4861111 0.288508 9.4888889 0.288508 9.4916667 0.288803 9.4944444 0.288214 9.4972222 0.288508 9.5000000 0.289392 9.5027778 0.289392 9.5055556 0.288803 9.5083333 0.288803 9.5111111 0.289392 9.5138889 0.289098 9.5166667 0.290276 9.5194444 0.290276 9.5222222 0.289687 9.5250000 0.289098 9.5277778 0.288214 9.5305556 0.288508 9.5333333 0.289098 9.5361111 0.289392 9.5388889 0.288508 9.5416667 0.288508 9.5444444 0.287330 9.5472222 0.288214 9.5500000 0.287624 9.5527778 0.288508 9.5555556 0.286740 9.5583333 0.286151 9.5611111 0.285562 9.5638889 0.285562 9.5666667 0.287035 9.5694444 0.286446 9.5722222 0.287035 9.5750000 0.286740 9.5777778 0.285856 9.5805556 0.286740 9.5833333 0.287624 9.5861111 0.287035 9.5888889 0.286446 9.5916667 0.286446 9.5944444 0.285856 9.5972222 0.285562 9.6000000 0.285562 9.6027778 0.285856 9.6055556 0.286151 9.6083333 0.285856 9.6111111 0.284972 9.6138889 0.284972 9.6166667 0.285267 9.6194444 0.286446 9.6222222 0.285856 9.6250000 0.285267 9.6277778 0.284383 9.6305556 0.282910 9.6333333 0.281731 9.6361111 0.282026 9.6388889 0.280258 9.6416667 0.279079 9.6444444 0.280258 9.6472222 0.284088 9.6500000 0.290571 9.6527778 0.297053 9.6555556 0.300589 9.6583333 0.303831 9.6611111 0.307956 9.6638889 0.314144 9.6666667 0.320921 9.6694444 0.323278 9.6722222 0.315028 9.6750000 0.299116 9.6777778 0.282615 9.6805556 0.276133 9.6833333 0.277017 9.6861111 0.279963 9.6888889 0.282026 9.6916667 0.281731 9.6944444 0.282615 9.6972222 0.282615 9.7000000 0.283499 9.7027778 0.284088 9.7055556 0.284383 9.7083333 0.283204 9.7111111 0.282910 9.7138889 0.282910 9.7166667 0.282910 9.7194444 0.283204 9.7222222 0.282910 9.7250000 0.282910 9.7277778 0.283204 9.7305556 0.283204 9.7333333 0.283204 9.7361111 0.284383 9.7388889 0.284383 9.7416667 0.283794 9.7444444 0.283204 9.7472222 0.283499 9.7500000 0.284088 9.7527778 0.284088 9.7555556 0.283794 9.7583333 0.284088 9.7611111 0.283204 9.7638889 0.282320 9.7666667 0.283499 9.7694444 0.283794 9.7722222 0.283204 9.7750000 0.283204 9.7777778 0.282615 9.7805556 0.282910 9.7833333 0.283204 9.7861111 0.283794 9.7888889 0.284383 9.7916667 0.283204 9.7944444 0.282320 9.7972222 0.282026 9.8000000 0.283204 9.8027778 0.284088 9.8055556 0.283499 9.8083333 0.283794 9.8111111 0.282910 9.8138889 0.283499 9.8166667 0.282910 9.8194444 0.283499 9.8222222 0.283499 9.8250000 0.283204 9.8277778 0.283204 9.8305556 0.283204 9.8333333 0.282615 9.8361111 0.283794 9.8388889 0.283499 9.8416667 0.282910 9.8444444 0.282615 9.8472222 0.282615 9.8500000 0.283204 9.8527778 0.283794 9.8555556 0.282615 9.8583333 0.282026 9.8611111 0.282026 9.8638889 0.281142 9.8666667 0.282026 9.8694444 0.282615 9.8722222 0.282320 9.8750000 0.282320 9.8777778 0.281142 9.8805556 0.281142 9.8833333 0.281731 9.8861111 0.282026 9.8888889 0.281436 9.8916667 0.280552 9.8944444 0.279669 9.8972222 0.279079 9.9000000 0.279963 9.9027778 0.280258 9.9055556 0.279374 9.9083333 0.278195 9.9111111 0.277606 9.9138889 0.277606 9.9166667 0.277901 9.9194444 0.277311 9.9222222 0.276133 9.9250000 0.276133 9.9277778 0.275249 9.9305556 0.274659 9.9333333 0.275543 9.9361111 0.275838 9.9388889 0.275543 9.9416667 0.274954 9.9444444 0.274954 9.9472222 0.274954 9.9500000 0.276133 9.9527778 0.277311 9.9555556 0.277017 9.9583333 0.277311 9.9611111 0.277311 9.9638889 0.277606 9.9666667 0.279374 9.9694444 0.281142 9.9722222 0.281436 9.9780000 0.300000 10.2608889 0.300000 10.2638889 0.285856 10.2666667 0.286740 10.2694444 0.287919 10.2722222 0.287330 10.2750000 0.287330 10.2777778 0.287035 10.2805556 0.286446 10.2833333 0.286740 10.2861111 0.287330 10.2888889 0.286740 10.2916667 0.287035 10.2944444 0.287035 10.2972222 0.286740 10.3000000 0.288508 10.3027778 0.288508 10.3055556 0.287919 10.3083333 0.288214 10.3111111 0.288214 10.3138889 0.288508 10.3166667 0.288803 10.3194444 0.289982 10.3222222 0.289982 10.3250000 0.289392 10.3277778 0.289392 10.3305556 0.289098 10.3333333 0.289982 10.3361111 0.290276 10.3388889 0.289392 10.3416667 0.289687 10.3444444 0.289098 10.3472222 0.289687 10.3500000 0.289982 10.3527778 0.291160 10.3555556 0.291160 10.3583333 0.290866 10.3611111 0.289392 10.3638889 0.289392 10.3666667 0.289982 10.3694444 0.289687 10.3722222 0.289392 10.3750000 0.288803 10.3777778 0.288508 10.3805556 0.288214 10.3833333 0.288803 10.3861111 0.289098 10.3888889 0.288214 10.3916667 0.288508 10.3944444 0.287330 10.3972222 0.287624 10.4000000 0.288214 10.4027778 0.288508 10.4055556 0.287919 10.4083333 0.287035 10.4111111 0.287330 10.4138889 0.286740 10.4166667 0.286740 10.4194444 0.287624 10.4222222 0.287919 10.4250000 0.287624 10.4277778 0.286740 10.4305556 0.286446 10.4333333 0.287330 10.4361111 0.288214 10.4388889 0.287330 10.4416667 0.287035 10.4444444 0.286740 10.4472222 0.287624 10.4500000 0.287624 10.4527778 0.288214 10.4555556 0.287624 10.4583333 0.287330 10.4611111 0.286740 10.4638889 0.286151 10.4666667 0.285856 10.4694444 0.284972 10.4722222 0.282910 10.4750000 0.281731 10.4777778 0.280258 10.4805556 0.278785 10.4833333 0.279374 10.4861111 0.283204 10.4888889 0.289687 10.4916667 0.297053 10.4944444 0.304420 10.4972222 0.311197 10.5000000 0.318564 10.5027778 0.325341 10.5055556 0.332118 10.5083333 0.338600 10.5111111 0.338600 10.5138889 0.329761 10.5166667 0.312376 10.5194444 0.294696 10.5222222 0.283794 10.5250000 0.282910 10.5277778 0.284383 10.5305556 0.285267 10.5333333 0.284972 10.5361111 0.286446 10.5388889 0.286446 10.5416667 0.285267 10.5444444 0.284972 10.5472222 0.284972 10.5500000 0.285267 10.5527778 0.286151 10.5555556 0.285267 10.5583333 0.285267 10.5611111 0.284383 10.5638889 0.284972 10.5666667 0.285267 10.5694444 0.285856 10.5722222 0.285562 10.5750000 0.284972 10.5777778 0.284972 10.5805556 0.284383 10.5833333 0.285856 10.5861111 0.285856 10.5888889 0.284972 10.5916667 0.284972 10.5944444 0.284383 10.5972222 0.284678 10.6000000 0.285267 10.6027778 0.284972 10.6055556 0.284972 10.6083333 0.284972 10.6111111 0.284972 10.6138889 0.285267 10.6166667 0.285562 10.6194444 0.286740 10.6222222 0.286446 10.6250000 0.285562 10.6277778 0.284972 10.6305556 0.284678 10.6333333 0.285562 10.6361111 0.285562 10.6388889 0.285562 10.6416667 0.285856 10.6444444 0.285267 10.6472222 0.285562 10.6500000 0.285562 10.6527778 0.285856 10.6555556 0.285856 10.6583333 0.285267 10.6611111 0.284383 10.6638889 0.284972 10.6666667 0.285856 10.6694444 0.285856 10.6722222 0.285856 10.6750000 0.284972 10.6777778 0.284678 10.6805556 0.284678 10.6833333 0.284972 10.6861111 0.284972 10.6888889 0.285267 10.6916667 0.284678 10.6944444 0.283794 10.6972222 0.283499 10.7000000 0.283499 10.7027778 0.284088 10.7055556 0.284383 10.7083333 0.283204 10.7111111 0.282910 10.7138889 0.283499 10.7166667 0.283499 10.7194444 0.283794 10.7222222 0.282615 10.7250000 0.282026 10.7277778 0.281731 10.7305556 0.281731 10.7333333 0.281142 10.7361111 0.282026 10.7388889 0.281142 10.7416667 0.279669 10.7444444 0.279374 10.7472222 0.279079 10.7500000 0.279079 10.7527778 0.279374 10.7555556 0.279374 10.7583333 0.278785 10.7611111 0.277606 10.7638889 0.277311 10.7666667 0.277606 10.7694444 0.277606 10.7722222 0.277901 10.7750000 0.277311 10.7777778 0.276722 10.7805556 0.277606 10.7833333 0.277017 10.7861111 0.277606 10.7888889 0.277311 10.7916667 0.277606 10.7944444 0.277901 10.7972222 0.278195 10.8000000 0.280258 10.8027778 0.281436 10.8055556 0.281731 10.8083333 0.282320 10.8111111 0.281731 10.8168889 0.300000 11.1164444 0.300000 11.1194444 0.287624 11.1222222 0.287919 11.1250000 0.287624 11.1277778 0.286446 11.1305556 0.286740 11.1333333 0.287330 11.1361111 0.287624 11.1388889 0.287624 11.1416667 0.286740 11.1444444 0.286740 11.1472222 0.286740 11.1500000 0.287919 11.1527778 0.288214 11.1555556 0.287624 11.1583333 0.287035 11.1611111 0.287624 11.1638889 0.287330 11.1666667 0.288803 11.1694444 0.288803 11.1722222 0.289098 11.1750000 0.289098 11.1777778 0.289098 11.1805556 0.288214 11.1833333 0.289098 11.1861111 0.289982 11.1888889 0.289982 11.1916667 0.290866 11.1944444 0.290571 11.1972222 0.290571 11.2000000 0.289687 11.2027778 0.290276 11.2055556 0.290571 11.2083333 0.290571 11.2111111 0.290276 11.2138889 0.289982 11.2166667 0.290276 11.2194444 0.290571 11.2222222 0.289687 11.2250000 0.288508 11.2277778 0.288214 11.2305556 0.287919 11.2333333 0.288508 11.2361111 0.288508 11.2388889 0.287919 11.2416667 0.288214 11.2444444 0.287035 11.2472222 0.286740 11.2500000 0.287035 11.2527778 0.287624 11.2555556 0.287330 11.2583333 0.287035 11.2611111 0.286446 11.2638889 0.285856 11.2666667 0.287330 11.2694444 0.287330 11.2722222 0.286740 11.2750000 0.286151 11.2777778 0.285856 11.2805556 0.285267 11.2833333 0.286446 11.2861111 0.287919 11.2888889 0.286740 11.2916667 0.286446 11.2944444 0.285856 11.2972222 0.285267 11.3000000 0.286446 11.3027778 0.287330 11.3055556 0.286446 11.3083333 0.284972 11.3111111 0.283499 11.3138889 0.282026 11.3166667 0.281436 11.3194444 0.280847 11.3222222 0.280552 11.3250000 0.279374 11.3277778 0.277901 11.3305556 0.275543 11.3333333 0.275543 11.3361111 0.277901 11.3388889 0.281142 11.3416667 0.286151 11.3444444 0.292634 11.3472222 0.300000 11.3500000 0.306777 11.3527778 0.312081 11.3555556 0.318564 11.3583333 0.324751 11.3611111 0.330939 11.3638889 0.335948 11.3666667 0.336243 11.3694444 0.327698 11.3722222 0.307956 11.3750000 0.290276 11.3777778 0.280847 11.3805556 0.282026 11.3833333 0.284088 11.3861111 0.284678 11.3888889 0.284678 11.3916667 0.285267 11.3944444 0.284088 11.3972222 0.283794 11.4000000 0.284678 11.4027778 0.284678 11.4055556 0.283794 11.4083333 0.284088 11.4111111 0.284088 11.4138889 0.284088 11.4166667 0.284383 11.4194444 0.284678 11.4222222 0.284088 11.4250000 0.284088 11.4277778 0.283499 11.4305556 0.283204 11.4333333 0.284383 11.4361111 0.284972 11.4388889 0.284678 11.4416667 0.284088 11.4444444 0.283794 11.4472222 0.283204 11.4500000 0.284088 11.4527778 0.284383 11.4555556 0.284383 11.4583333 0.284678 11.4611111 0.283794 11.4638889 0.284088 11.4666667 0.284383 11.4694444 0.284972 11.4722222 0.284678 11.4750000 0.284972 11.4777778 0.283794 11.4805556 0.284383 11.4833333 0.284678 11.4861111 0.284972 11.4888889 0.284972 11.4916667 0.284678 11.4944444 0.284383 11.4972222 0.283499 11.5000000 0.284678 11.5027778 0.285856 11.5055556 0.285267 11.5083333 0.284383 11.5111111 0.284088 11.5138889 0.283499 11.5166667 0.284383 11.5194444 0.285267 11.5222222 0.284972 11.5250000 0.284678 11.5277778 0.284088 11.5305556 0.283499 11.5333333 0.283794 11.5361111 0.284678 11.5388889 0.284088 11.5416667 0.283204 11.5444444 0.283499 11.5472222 0.283499 11.5500000 0.283794 11.5527778 0.283499 11.5555556 0.283794 11.5583333 0.284088 11.5611111 0.282615 11.5638889 0.282026 11.5666667 0.282615 11.5694444 0.283499 11.5722222 0.282320 11.5750000 0.281731 11.5777778 0.281731 11.5805556 0.281436 11.5833333 0.281436 11.5861111 0.281731 11.5888889 0.281436 11.5916667 0.280552 11.5944444 0.279374 11.5972222 0.279374 11.6000000 0.279079 11.6027778 0.280258 11.6055556 0.279669 11.6083333 0.279079 11.6111111 0.278195 11.6138889 0.277901 11.6166667 0.277311 11.6194444 0.277606 11.6222222 0.277017 11.6250000 0.277017 11.6277778 0.276133 11.6305556 0.275838 11.6333333 0.276722 11.6361111 0.276722 11.6388889 0.276722 11.6416667 0.276427 11.6444444 0.275838 11.6472222 0.276133 11.6500000 0.277311 11.6527778 0.277901 11.6555556 0.278490 11.6583333 0.278490 11.6611111 0.278490 11.6638889 0.279079 11.6666667 0.280847 11.6724444 0.300000 11.9386667 0.300000 11.9416667 0.285562 11.9444444 0.285856 11.9472222 0.285856 11.9500000 0.285562 11.9527778 0.286151 11.9555556 0.286151 11.9583333 0.285562 11.9611111 0.284088 11.9638889 0.284678 11.9666667 0.285267 11.9694444 0.285267 11.9722222 0.284972 11.9750000 0.285267 11.9777778 0.284088 11.9805556 0.284088 11.9833333 0.285267 11.9861111 0.286446 11.9888889 0.286151 11.9916667 0.285856 11.9944444 0.286151 11.9972222 0.286151 12.0000000 0.286446 12.0027778 0.286740 12.0055556 0.287330 12.0083333 0.286151 12.0111111 0.286740 12.0138889 0.287035 12.0166667 0.287919 12.0194444 0.287919 12.0222222 0.287919 12.0250000 0.287919 12.0277778 0.287624 12.0305556 0.286740 12.0333333 0.287624 12.0361111 0.288508 12.0388889 0.288214 12.0416667 0.287330 12.0444444 0.286151 12.0472222 0.286446 12.0500000 0.286740 12.0527778 0.286740 12.0555556 0.285562 12.0583333 0.285267 12.0611111 0.284678 12.0638889 0.284383 12.0666667 0.286446 12.0694444 0.286151 12.0722222 0.285856 12.0750000 0.285267 12.0777778 0.283499 12.0805556 0.284088 12.0833333 0.284383 12.0861111 0.284972 12.0888889 0.284383 12.0916667 0.283794 12.0944444 0.283499 12.0972222 0.282910 12.1000000 0.283794 12.1027778 0.284383 12.1055556 0.284088 12.1083333 0.284088 12.1111111 0.283499 12.1138889 0.283499 12.1166667 0.284088 12.1194444 0.284383 12.1222222 0.283499 12.1250000 0.283204 12.1277778 0.282615 12.1305556 0.282615 12.1333333 0.283499 12.1361111 0.284383 12.1388889 0.283499 12.1416667 0.282320 12.1444444 0.280847 12.1472222 0.279079 12.1500000 0.278785 12.1527778 0.279079 12.1555556 0.277311 12.1583333 0.276427 12.1611111 0.279079 12.1638889 0.284088 12.1666667 0.289982 12.1694444 0.295580 12.1722222 0.299411 12.1750000 0.302947 12.1777778 0.307956 12.1805556 0.315028 12.1833333 0.321215 12.1861111 0.322983 12.1888889 0.316206 12.1916667 0.302357 12.1944444 0.286740 12.1972222 0.276427 12.2000000 0.275838 12.2027778 0.278785 12.2055556 0.279669 12.2083333 0.279963 12.2111111 0.279669 12.2138889 0.279669 12.2166667 0.280552 12.2194444 0.282026 12.2222222 0.281436 12.2250000 0.281436 12.2277778 0.280847 12.2305556 0.280258 12.2333333 0.280552 12.2361111 0.281731 12.2388889 0.281436 12.2416667 0.281142 12.2444444 0.281142 12.2472222 0.281142 12.2500000 0.281142 12.2527778 0.281731 12.2555556 0.280847 12.2583333 0.280552 12.2611111 0.279669 12.2638889 0.279963 12.2666667 0.281142 12.2694444 0.281731 12.2722222 0.281731 12.2750000 0.281142 12.2777778 0.280847 12.2805556 0.280847 12.2833333 0.281436 12.2861111 0.281731 12.2888889 0.281731 12.2916667 0.281436 12.2944444 0.280552 12.2972222 0.281142 12.3000000 0.281436 12.3027778 0.282910 12.3055556 0.282026 12.3083333 0.282026 12.3111111 0.281142 12.3138889 0.281142 12.3166667 0.280847 12.3194444 0.281142 12.3222222 0.281436 12.3250000 0.281142 12.3277778 0.280847 12.3305556 0.280552 12.3333333 0.281436 12.3361111 0.281731 12.3388889 0.281436 12.3416667 0.280552 12.3444444 0.279963 12.3472222 0.280258 12.3500000 0.281436 12.3527778 0.282026 12.3555556 0.281142 12.3583333 0.280847 12.3611111 0.281142 12.3638889 0.280847 12.3666667 0.280552 12.3694444 0.281142 12.3722222 0.281731 12.3750000 0.280847 12.3777778 0.280847 12.3805556 0.280552 12.3833333 0.280847 12.3861111 0.280552 12.3888889 0.280552 12.3916667 0.280258 12.3944444 0.280258 12.3972222 0.279669 12.4000000 0.280258 12.4027778 0.279963 12.4055556 0.279669 12.4083333 0.279374 12.4111111 0.278785 12.4138889 0.277606 12.4166667 0.278490 12.4194444 0.278785 12.4222222 0.278195 12.4250000 0.277606 12.4277778 0.276133 12.4305556 0.274954 12.4333333 0.275249 12.4361111 0.276133 12.4388889 0.275838 12.4416667 0.274954 12.4444444 0.274070 12.4472222 0.273775 12.4500000 0.274070 12.4527778 0.274659 12.4555556 0.274659 12.4583333 0.274070 12.4611111 0.273481 12.4638889 0.272597 12.4666667 0.274070 12.4694444 0.274365 12.4722222 0.273775 12.4750000 0.272597 12.4777778 0.273481 12.4805556 0.273775 12.4833333 0.275249 12.4861111 0.276427 12.4888889 0.277311 12.4946667 0.300000 12.7664444 0.300000 12.7694444 0.281142 12.7722222 0.280847 12.7750000 0.279669 12.7777778 0.279374 12.7805556 0.279374 12.7833333 0.279669 12.7861111 0.280552 12.7888889 0.281436 12.7916667 0.280552 12.7944444 0.279963 12.7972222 0.279669 12.8000000 0.279963 12.8027778 0.281142 12.8055556 0.280552 12.8083333 0.279963 12.8111111 0.279374 12.8138889 0.280258 12.8166667 0.280847 12.8194444 0.281731 12.8222222 0.282026 12.8250000 0.281142 12.8277778 0.281436 12.8305556 0.281142 12.8333333 0.281731 12.8361111 0.282910 12.8388889 0.282615 12.8416667 0.282026 12.8444444 0.282026 12.8472222 0.281731 12.8500000 0.282615 12.8527778 0.283499 12.8555556 0.283499 12.8583333 0.283204 12.8611111 0.282910 12.8638889 0.282615 12.8666667 0.282910 12.8694444 0.283204 12.8722222 0.282615 12.8750000 0.282320 12.8777778 0.281436 12.8805556 0.281436 12.8833333 0.282026 12.8861111 0.282615 12.8888889 0.282026 12.8916667 0.281731 12.8944444 0.279669 12.8972222 0.280258 12.9000000 0.279963 12.9027778 0.280258 12.9055556 0.280552 12.9083333 0.280552 12.9111111 0.279669 12.9138889 0.279669 12.9166667 0.279963 12.9194444 0.280258 12.9222222 0.280552 12.9250000 0.280258 12.9277778 0.280258 12.9305556 0.280552 12.9333333 0.280847 12.9361111 0.281731 12.9388889 0.280847 12.9416667 0.280847 12.9444444 0.280552 12.9472222 0.280258 12.9500000 0.280258 12.9527778 0.281436 12.9555556 0.281142 12.9583333 0.280552 12.9611111 0.280847 12.9638889 0.280258 12.9666667 0.280847 12.9694444 0.280552 12.9722222 0.279374 12.9750000 0.277901 12.9777778 0.276722 12.9805556 0.274954 12.9833333 0.274954 12.9861111 0.274659 12.9888889 0.274954 12.9916667 0.278490 12.9944444 0.284088 12.9972222 0.290276 13.0000000 0.296169 13.0027778 0.300884 13.0055556 0.304715 13.0083333 0.310608 13.0111111 0.317385 13.0138889 0.322983 13.0166667 0.323867 13.0194444 0.318564 13.0222222 0.301473 13.0250000 0.284678 13.0277778 0.274070 13.0305556 0.272597 13.0333333 0.275543 13.0361111 0.277901 13.0388889 0.278785 13.0416667 0.279374 13.0444444 0.279374 13.0472222 0.279374 13.0500000 0.280258 13.0527778 0.280847 13.0555556 0.280847 13.0583333 0.279963 13.0611111 0.280552 13.0638889 0.280258 13.0666667 0.280847 13.0694444 0.280847 13.0722222 0.280258 13.0750000 0.280847 13.0777778 0.279374 13.0805556 0.279963 13.0833333 0.279963 13.0861111 0.281731 13.0888889 0.281142 13.0916667 0.280847 13.0944444 0.279669 13.0972222 0.279963 13.1000000 0.280552 13.1027778 0.281436 13.1055556 0.281731 13.1083333 0.281142 13.1111111 0.280258 13.1138889 0.280258 13.1166667 0.280847 13.1194444 0.281436 13.1222222 0.280847 13.1250000 0.280552 13.1277778 0.280847 13.1305556 0.280552 13.1333333 0.281436 13.1361111 0.281142 13.1388889 0.281731 13.1416667 0.281142 13.1444444 0.280258 13.1472222 0.280552 13.1500000 0.281436 13.1527778 0.281436 13.1555556 0.281436 13.1583333 0.281142 13.1611111 0.280552 13.1638889 0.280552 13.1666667 0.281436 13.1694444 0.281731 13.1722222 0.282026 13.1750000 0.281142 13.1777778 0.280258 13.1805556 0.280258 13.1833333 0.279669 13.1861111 0.280847 13.1888889 0.280552 13.1916667 0.280552 13.1944444 0.280258 13.1972222 0.280258 13.2000000 0.280552 13.2027778 0.280847 13.2055556 0.280552 13.2083333 0.280258 13.2111111 0.279079 13.2138889 0.279079 13.2166667 0.279374 13.2194444 0.280552 13.2222222 0.279963 13.2250000 0.278785 13.2277778 0.278490 13.2305556 0.278490 13.2333333 0.278195 13.2361111 0.279374 13.2388889 0.279079 13.2416667 0.278195 13.2444444 0.277606 13.2472222 0.277017 13.2500000 0.277311 13.2527778 0.277606 13.2555556 0.277017 13.2583333 0.276722 13.2611111 0.275249 13.2638889 0.274659 13.2666667 0.275249 13.2694444 0.275838 13.2722222 0.274954 13.2750000 0.274659 13.2777778 0.273481 13.2805556 0.272891 13.2833333 0.273775 13.2861111 0.273186 13.2888889 0.273481 13.2916667 0.273481 13.2944444 0.272302 13.2972222 0.272597 13.3000000 0.272891 13.3027778 0.274070 13.3055556 0.273775 13.3083333 0.274365 13.3111111 0.275249 13.3138889 0.276427 13.3166667 0.277606 13.3224444 0.300000 13.5886667 0.300000 13.5916667 0.284088 13.5944444 0.284088 13.5972222 0.283794 13.6000000 0.284383 13.6027778 0.285267 13.6055556 0.285267 13.6083333 0.284678 13.6111111 0.284383 13.6138889 0.283794 13.6166667 0.284383 13.6194444 0.284972 13.6222222 0.285267 13.6250000 0.284383 13.6277778 0.284678 13.6305556 0.284383 13.6333333 0.285267 13.6361111 0.286151 13.6388889 0.284678 13.6416667 0.284678 13.6444444 0.285267 13.6472222 0.285267 13.6500000 0.285856 13.6527778 0.287035 13.6555556 0.287330 13.6583333 0.286446 13.6611111 0.285856 13.6638889 0.286740 13.6666667 0.287035 13.6694444 0.288508 13.6722222 0.288214 13.6750000 0.287624 13.6777778 0.288214 13.6805556 0.287330 13.6833333 0.288803 13.6861111 0.288508 13.6888889 0.288508 13.6916667 0.288803 13.6944444 0.287624 13.6972222 0.287624 13.7000000 0.288214 13.7027778 0.287624 13.7055556 0.286740 13.7083333 0.287035 13.7111111 0.286446 13.7138889 0.286151 13.7166667 0.286740 13.7194444 0.287035 13.7222222 0.286151 13.7250000 0.285856 13.7277778 0.286446 13.7305556 0.285267 13.7333333 0.284972 13.7361111 0.285562 13.7388889 0.285856 13.7416667 0.285562 13.7444444 0.285267 13.7472222 0.284972 13.7500000 0.285856 13.7527778 0.286151 13.7555556 0.285856 13.7583333 0.285562 13.7611111 0.284972 13.7638889 0.284678 13.7666667 0.284972 13.7694444 0.286446 13.7722222 0.285856 13.7750000 0.285562 13.7777778 0.284972 13.7805556 0.284383 13.7833333 0.284383 13.7861111 0.285267 13.7888889 0.285562 13.7916667 0.285267 13.7944444 0.284088 13.7972222 0.282320 13.8000000 0.281142 13.8027778 0.280552 13.8055556 0.279079 13.8083333 0.277311 13.8111111 0.278195 13.8138889 0.281142 13.8166667 0.288803 13.8194444 0.297053 13.8222222 0.304420 13.8250000 0.311197 13.8277778 0.317974 13.8305556 0.325635 13.8333333 0.333591 13.8361111 0.338895 13.8388889 0.338011 13.8416667 0.326814 13.8444444 0.307072 13.8472222 0.289687 13.8500000 0.282615 13.8527778 0.284678 13.8555556 0.284972 13.8583333 0.283794 13.8611111 0.283499 13.8638889 0.283499 13.8666667 0.283794 13.8694444 0.283499 13.8722222 0.283499 13.8750000 0.283204 13.8777778 0.282615 13.8805556 0.282320 13.8833333 0.282910 13.8861111 0.283204 13.8888889 0.282615 13.8916667 0.282320 13.8944444 0.281731 13.8972222 0.282615 13.9000000 0.282026 13.9027778 0.282910 13.9055556 0.283204 13.9083333 0.282320 13.9111111 0.282026 13.9138889 0.282320 13.9166667 0.282910 13.9194444 0.283204 13.9222222 0.282910 13.9250000 0.282910 13.9277778 0.282615 13.9305556 0.282910 13.9333333 0.282910 13.9361111 0.283204 13.9388889 0.283204 13.9416667 0.282910 13.9444444 0.281731 13.9472222 0.282026 13.9500000 0.283204 13.9527778 0.283499 13.9555556 0.283499 13.9583333 0.283204 13.9611111 0.282615 13.9638889 0.282026 13.9666667 0.282910 13.9694444 0.284088 13.9722222 0.283499 13.9750000 0.283499 13.9777778 0.282615 13.9805556 0.282026 13.9833333 0.282615 13.9861111 0.283499 13.9888889 0.283499 13.9916667 0.283204 13.9944444 0.282615 13.9972222 0.282615 14.0000000 0.282615 14.0027778 0.282910 14.0055556 0.282615 14.0083333 0.282320 14.0111111 0.281731 14.0138889 0.282320 14.0166667 0.282320 14.0194444 0.282615 14.0222222 0.282026 14.0250000 0.281436 14.0277778 0.280552 14.0305556 0.280847 14.0333333 0.280847 14.0361111 0.281436 14.0388889 0.280847 14.0416667 0.280552 14.0444444 0.279669 14.0472222 0.279374 14.0500000 0.279669 14.0527778 0.280258 14.0555556 0.279079 14.0583333 0.277606 14.0611111 0.277901 14.0638889 0.277311 14.0666667 0.277901 14.0694444 0.278195 14.0722222 0.277606 14.0750000 0.276722 14.0777778 0.275838 14.0805556 0.275838 14.0833333 0.276133 14.0861111 0.276427 14.0888889 0.276133 14.0916667 0.275249 14.0944444 0.274659 14.0972222 0.274659 14.1000000 0.275249 14.1027778 0.275838 14.1055556 0.276133 14.1083333 0.276133 14.1111111 0.275838 14.1138889 0.276133 14.1166667 0.277311 14.1194444 0.278195 14.1222222 0.279079 14.1250000 0.279669 14.1277778 0.280258 14.1305556 0.281142 14.1333333 0.282320 14.1361111 0.283499 14.1388889 0.284088 14.1446667 0.300000 14.3831111 0.300000 14.3861111 0.286446 14.3888889 0.286151 14.3916667 0.285562 14.3944444 0.285856 14.3972222 0.286446 14.4000000 0.286740 14.4027778 0.286151 14.4055556 0.286446 14.4083333 0.286446 14.4111111 0.285856 14.4138889 0.285562 14.4166667 0.286446 14.4194444 0.286740 14.4222222 0.286740 14.4250000 0.286446 14.4277778 0.285562 14.4305556 0.285856 14.4333333 0.286446 14.4361111 0.287330 14.4388889 0.287624 14.4416667 0.286740 14.4444444 0.286740 14.4472222 0.286446 14.4500000 0.287330 14.4527778 0.288214 14.4555556 0.287919 14.4583333 0.287624 14.4611111 0.287624 14.4638889 0.288214 14.4666667 0.288803 14.4694444 0.289392 14.4722222 0.289098 14.4750000 0.288508 14.4777778 0.288214 14.4805556 0.288508 14.4833333 0.289098 14.4861111 0.290866 14.4888889 0.290276 14.4916667 0.289982 14.4944444 0.289392 14.4972222 0.289687 14.5000000 0.289392 14.5027778 0.290571 14.5055556 0.289098 14.5083333 0.288803 14.5111111 0.287919 14.5138889 0.287919 14.5166667 0.288508 14.5194444 0.288803 14.5222222 0.288214 14.5250000 0.287919 14.5277778 0.286740 14.5305556 0.286446 14.5333333 0.286740 14.5361111 0.288214 14.5388889 0.287330 14.5416667 0.286740 14.5444444 0.286446 14.5472222 0.285562 14.5500000 0.286151 14.5527778 0.287330 14.5555556 0.286740 14.5583333 0.286151 14.5611111 0.286446 14.5638889 0.286151 14.5666667 0.287035 14.5694444 0.287035 14.5722222 0.286740 14.5750000 0.286740 14.5777778 0.286740 14.5805556 0.286446 14.5833333 0.286740 14.5861111 0.286740 14.5888889 0.285562 14.5916667 0.283499 14.5944444 0.282026 14.5972222 0.280258 14.6000000 0.279374 14.6027778 0.278785 14.6055556 0.278785 14.6083333 0.281436 14.6111111 0.287035 14.6138889 0.294401 14.6166667 0.301473 14.6194444 0.308250 14.6222222 0.314438 14.6250000 0.321510 14.6277778 0.327403 14.6305556 0.333297 14.6333333 0.334180 14.6361111 0.324457 14.6388889 0.304420 14.6416667 0.287624 14.6444444 0.280552 14.6472222 0.282320 14.6500000 0.284088 14.6527778 0.284678 14.6555556 0.284678 14.6583333 0.284972 14.6611111 0.284383 14.6638889 0.284383 14.6666667 0.284972 14.6694444 0.285267 14.6722222 0.284678 14.6750000 0.284383 14.6777778 0.284678 14.6805556 0.283794 14.6833333 0.284972 14.6861111 0.284972 14.6888889 0.284678 14.6916667 0.283794 14.6944444 0.283794 14.6972222 0.283794 14.7000000 0.284678 14.7027778 0.284678 14.7055556 0.284972 14.7083333 0.283794 14.7111111 0.283204 14.7138889 0.283499 14.7166667 0.284383 14.7194444 0.285267 14.7222222 0.285267 14.7250000 0.284678 14.7277778 0.283794 14.7305556 0.283204 14.7333333 0.283794 14.7361111 0.285267 14.7388889 0.284972 14.7416667 0.284972 14.7444444 0.284088 14.7472222 0.284088 14.7500000 0.284972 14.7527778 0.285267 14.7555556 0.285267 14.7583333 0.284972 14.7611111 0.284972 14.7638889 0.285267 14.7666667 0.284972 14.7694444 0.286151 14.7722222 0.285856 14.7750000 0.284972 14.7777778 0.284972 14.7805556 0.284383 14.7833333 0.284678 14.7861111 0.285267 14.7888889 0.285267 14.7916667 0.284678 14.7944444 0.283794 14.7972222 0.283499 14.8000000 0.283794 14.8027778 0.284972 14.8055556 0.284383 14.8083333 0.283204 14.8111111 0.283499 14.8138889 0.282615 14.8166667 0.282615 14.8194444 0.283794 14.8222222 0.283204 14.8250000 0.282615 14.8277778 0.282026 14.8305556 0.282026 14.8333333 0.282026 14.8361111 0.282026 14.8388889 0.281731 14.8416667 0.281436 14.8444444 0.280552 14.8472222 0.280552 14.8500000 0.281436 14.8527778 0.281436 14.8555556 0.281142 14.8583333 0.279963 14.8611111 0.278490 14.8638889 0.278785 14.8666667 0.278785 14.8694444 0.279669 14.8722222 0.278490 14.8750000 0.278490 14.8777778 0.277311 14.8805556 0.277311 14.8833333 0.277017 14.8861111 0.277901 14.8888889 0.278490 14.8916667 0.277311 14.8944444 0.276427 14.8972222 0.276722 14.9000000 0.277017 14.9027778 0.277606 14.9055556 0.277311 14.9083333 0.276427 14.9111111 0.276133 14.9138889 0.276427 14.9166667 0.276722 14.9194444 0.278195 14.9222222 0.278195 14.9250000 0.278490 14.9277778 0.278195 14.9305556 0.279374 14.9333333 0.280258 14.9391111 0.300000 15.1803333 0.300000 15.1833333 0.283204 15.1861111 0.283204 15.1888889 0.283204 15.1916667 0.282910 15.1944444 0.282320 15.1972222 0.282615 15.2000000 0.282615 15.2027778 0.283794 15.2055556 0.283499 15.2083333 0.283499 15.2111111 0.282320 15.2138889 0.282320 15.2166667 0.283204 15.2194444 0.283794 15.2222222 0.284088 15.2250000 0.282615 15.2277778 0.282615 15.2305556 0.282026 15.2333333 0.282910 15.2361111 0.284088 15.2388889 0.283499 15.2416667 0.282910 15.2444444 0.282910 15.2472222 0.283794 15.2500000 0.284972 15.2527778 0.285267 15.2555556 0.284678 15.2583333 0.284088 15.2611111 0.283499 15.2638889 0.284088 15.2666667 0.284383 15.2694444 0.285562 15.2722222 0.285562 15.2750000 0.284972 15.2777778 0.285267 15.2805556 0.285856 15.2833333 0.286151 15.2861111 0.286446 15.2888889 0.286446 15.2916667 0.285267 15.2944444 0.284383 15.2972222 0.283794 15.3000000 0.283794 15.3027778 0.284678 15.3055556 0.284972 15.3083333 0.284383 15.3111111 0.282910 15.3138889 0.282615 15.3166667 0.282615 15.3194444 0.283499 15.3222222 0.284088 15.3250000 0.282910 15.3277778 0.282320 15.3305556 0.282615 15.3333333 0.282320 15.3361111 0.282320 15.3388889 0.282320 15.3416667 0.282026 15.3444444 0.282615 15.3472222 0.282615 15.3500000 0.282615 15.3527778 0.282320 15.3555556 0.282320 15.3583333 0.282320 15.3611111 0.282320 15.3638889 0.281436 15.3666667 0.282026 15.3694444 0.283499 15.3722222 0.282910 15.3750000 0.282615 15.3777778 0.280847 15.3805556 0.279963 15.3833333 0.278785 15.3861111 0.278490 15.3888889 0.277606 15.3916667 0.275543 15.3944444 0.273481 15.3972222 0.275249 15.4000000 0.279669 15.4027778 0.285562 15.4055556 0.290571 15.4083333 0.294696 15.4111111 0.296464 15.4138889 0.299705 15.4166667 0.302947 15.4194444 0.309724 15.4222222 0.315617 15.4250000 0.322394 15.4277778 0.327109 15.4305556 0.329171 15.4333333 0.328582 15.4361111 0.319742 15.4388889 0.302652 15.4416667 0.285562 15.4444444 0.274659 15.4472222 0.271713 15.4500000 0.274659 15.4527778 0.276427 15.4555556 0.277606 15.4583333 0.278490 15.4611111 0.279079 15.4638889 0.278490 15.4666667 0.279669 15.4694444 0.279669 15.4722222 0.279963 15.4750000 0.279669 15.4777778 0.278490 15.4805556 0.278785 15.4833333 0.278785 15.4861111 0.279963 15.4888889 0.279374 15.4916667 0.279669 15.4944444 0.278490 15.4972222 0.278785 15.5000000 0.278785 15.5027778 0.279669 15.5055556 0.279669 15.5083333 0.278785 15.5111111 0.278785 15.5138889 0.278195 15.5166667 0.279079 15.5194444 0.279669 15.5222222 0.279669 15.5250000 0.279079 15.5277778 0.278785 15.5305556 0.278785 15.5333333 0.279079 15.5361111 0.279374 15.5388889 0.279963 15.5416667 0.279669 15.5444444 0.278785 15.5472222 0.279669 15.5500000 0.279079 15.5527778 0.280258 15.5555556 0.279374 15.5583333 0.278490 15.5611111 0.278785 15.5638889 0.278195 15.5666667 0.278785 15.5694444 0.279669 15.5722222 0.279963 15.5750000 0.279079 15.5777778 0.277901 15.5805556 0.277606 15.5833333 0.278490 15.5861111 0.278785 15.5888889 0.279079 15.5916667 0.279079 15.5944444 0.279374 15.5972222 0.278490 15.6000000 0.279079 15.6027778 0.278785 15.6055556 0.278490 15.6083333 0.277311 15.6111111 0.277017 15.6138889 0.277606 15.6166667 0.278195 15.6194444 0.278490 15.6222222 0.277311 15.6250000 0.277311 15.6277778 0.275249 15.6305556 0.276133 15.6333333 0.277017 15.6361111 0.277017 15.6388889 0.277311 15.6416667 0.276722 15.6444444 0.276133 15.6472222 0.276427 15.6500000 0.276722 15.6527778 0.276722 15.6555556 0.276133 15.6583333 0.274954 15.6611111 0.274070 15.6638889 0.273186 15.6666667 0.273186 15.6694444 0.273775 15.6722222 0.272597 15.6750000 0.272597 15.6777778 0.271713 15.6805556 0.271418 15.6833333 0.271418 15.6861111 0.271418 15.6888889 0.271123 15.6916667 0.270534 15.6944444 0.269945 15.6972222 0.269061 15.7000000 0.269945 15.7027778 0.270829 15.7055556 0.270534 15.7083333 0.269650 15.7111111 0.269945 15.7138889 0.271123 15.7166667 0.272007 15.7194444 0.273481 15.7222222 0.273481 15.7250000 0.273481 15.7277778 0.274070 15.7305556 0.274659 15.7363333 0.300000 15.9720000 0.300000 15.9750000 0.279963 15.9777778 0.279374 15.9805556 0.278785 15.9833333 0.279963 15.9861111 0.279963 15.9888889 0.280258 15.9916667 0.279963 15.9944444 0.279374 15.9972222 0.279374 16.0000000 0.279963 16.0027778 0.280552 16.0055556 0.280552 16.0083333 0.279963 16.0111111 0.279669 16.0138889 0.279669 16.0166667 0.279669 16.0194444 0.280258 16.0222222 0.281142 16.0250000 0.280258 16.0277778 0.279963 16.0305556 0.279669 16.0333333 0.280847 16.0361111 0.282320 16.0388889 0.281436 16.0416667 0.281436 16.0444444 0.282026 16.0472222 0.282320 16.0500000 0.283499 16.0527778 0.284088 16.0555556 0.282910 16.0583333 0.282910 16.0611111 0.282615 16.0638889 0.282910 16.0666667 0.283794 16.0694444 0.284972 16.0722222 0.284383 16.0750000 0.283794 16.0777778 0.283499 16.0805556 0.283204 16.0833333 0.283499 16.0861111 0.284088 16.0888889 0.283204 16.0916667 0.282026 16.0944444 0.282026 16.0972222 0.282026 16.1000000 0.282615 16.1027778 0.282615 16.1055556 0.282615 16.1083333 0.281436 16.1111111 0.280847 16.1138889 0.280847 16.1166667 0.281731 16.1194444 0.282026 16.1222222 0.282320 16.1250000 0.281731 16.1277778 0.280847 16.1305556 0.280847 16.1333333 0.280847 16.1361111 0.282026 16.1388889 0.282026 16.1416667 0.280847 16.1444444 0.281142 16.1472222 0.280847 16.1500000 0.281731 16.1527778 0.281731 16.1555556 0.281436 16.1583333 0.281142 16.1611111 0.280847 16.1638889 0.281142 16.1666667 0.281436 16.1694444 0.282026 16.1722222 0.282320 16.1750000 0.280847 16.1777778 0.280258 16.1805556 0.279374 16.1833333 0.279079 16.1861111 0.277606 16.1888889 0.275543 16.1916667 0.274659 16.1944444 0.273186 16.1972222 0.275838 16.2000000 0.282026 16.2027778 0.290571 16.2055556 0.297348 16.2083333 0.302063 16.2111111 0.307072 16.2138889 0.314438 16.2166667 0.322689 16.2194444 0.329171 16.2222222 0.327993 16.2250000 0.317385 16.2277778 0.297643 16.2305556 0.279374 16.2333333 0.274070 16.2361111 0.275543 16.2388889 0.277606 16.2416667 0.278785 16.2444444 0.278490 16.2472222 0.279079 16.2500000 0.279963 16.2527778 0.279963 16.2555556 0.280258 16.2583333 0.279374 16.2611111 0.278195 16.2638889 0.278785 16.2666667 0.279079 16.2694444 0.279079 16.2722222 0.279374 16.2750000 0.279374 16.2777778 0.279079 16.2805556 0.279374 16.2833333 0.279374 16.2861111 0.279963 16.2888889 0.279669 16.2916667 0.279669 16.2944444 0.279374 16.2972222 0.279669 16.3000000 0.280258 16.3027778 0.280258 16.3055556 0.280552 16.3083333 0.279669 16.3111111 0.279669 16.3138889 0.279963 16.3166667 0.280258 16.3194444 0.281142 16.3222222 0.280258 16.3250000 0.280552 16.3277778 0.279963 16.3305556 0.279963 16.3333333 0.280258 16.3361111 0.280847 16.3388889 0.280847 16.3416667 0.279963 16.3444444 0.279669 16.3472222 0.279669 16.3500000 0.281142 16.3527778 0.281142 16.3555556 0.280552 16.3583333 0.279669 16.3611111 0.280258 16.3638889 0.279963 16.3666667 0.280552 16.3694444 0.280847 16.3722222 0.280552 16.3750000 0.279963 16.3777778 0.279669 16.3805556 0.279374 16.3833333 0.280258 16.3861111 0.280847 16.3888889 0.279963 16.3916667 0.280258 16.3944444 0.279079 16.3972222 0.278785 16.4000000 0.279079 16.4027778 0.279374 16.4055556 0.279669 16.4083333 0.279079 16.4111111 0.277901 16.4138889 0.278490 16.4166667 0.277901 16.4194444 0.277901 16.4222222 0.278490 16.4250000 0.277901 16.4277778 0.277311 16.4305556 0.277017 16.4333333 0.277606 16.4361111 0.278195 16.4388889 0.277606 16.4416667 0.277017 16.4444444 0.276133 16.4472222 0.274954 16.4500000 0.275249 16.4527778 0.274954 16.4555556 0.274954 16.4583333 0.274365 16.4611111 0.273775 16.4638889 0.273481 16.4666667 0.272891 16.4694444 0.273186 16.4722222 0.272302 16.4750000 0.272007 16.4777778 0.271123 16.4805556 0.271123 16.4833333 0.272007 16.4861111 0.272597 16.4888889 0.272302 16.4916667 0.271713 16.4944444 0.271418 16.4972222 0.272302 16.5000000 0.272597 16.5027778 0.274659 16.5055556 0.274659 16.5083333 0.275249 16.5111111 0.275249 16.5138889 0.277017 16.5166667 0.277901 16.5194444 0.278490 16.5222222 0.279374 16.5280000 0.300000 16.7942222 0.300000 16.7972222 0.283204 16.8000000 0.283499 16.8027778 0.284088 16.8055556 0.285267 16.8083333 0.284088 16.8111111 0.284383 16.8138889 0.283499 16.8166667 0.283794 16.8194444 0.284383 16.8222222 0.284088 16.8250000 0.283499 16.8277778 0.283499 16.8305556 0.283499 16.8333333 0.284972 16.8361111 0.284678 16.8388889 0.285267 16.8416667 0.284972 16.8444444 0.284678 16.8472222 0.284972 16.8500000 0.286151 16.8527778 0.287330 16.8555556 0.286740 16.8583333 0.286151 16.8611111 0.286151 16.8638889 0.285856 16.8666667 0.286446 16.8694444 0.287624 16.8722222 0.287919 16.8750000 0.287919 16.8777778 0.288214 16.8805556 0.288214 16.8833333 0.288214 16.8861111 0.288803 16.8888889 0.288803 16.8916667 0.287919 16.8944444 0.287624 16.8972222 0.287919 16.9000000 0.287919 16.9027778 0.288214 16.9055556 0.287624 16.9083333 0.286740 16.9111111 0.286151 16.9138889 0.286151 16.9166667 0.286446 16.9194444 0.287330 16.9222222 0.286740 16.9250000 0.286151 16.9277778 0.286151 16.9305556 0.285562 16.9333333 0.285856 16.9361111 0.286446 16.9388889 0.285856 16.9416667 0.285562 16.9444444 0.284972 16.9472222 0.284678 16.9500000 0.284972 16.9527778 0.286446 16.9555556 0.285562 16.9583333 0.284972 16.9611111 0.284972 16.9638889 0.284972 16.9666667 0.285562 16.9694444 0.286151 16.9722222 0.285562 16.9750000 0.285267 16.9777778 0.284678 16.9805556 0.284678 16.9833333 0.285267 16.9861111 0.285856 16.9888889 0.285267 16.9916667 0.284383 16.9944444 0.283794 16.9972222 0.283794 17.0000000 0.282615 17.0027778 0.281731 17.0055556 0.279963 17.0083333 0.277901 17.0111111 0.275838 17.0138889 0.275249 17.0166667 0.278490 17.0194444 0.286151 17.0222222 0.293223 17.0250000 0.300884 17.0277778 0.306777 17.0305556 0.313849 17.0333333 0.321805 17.0361111 0.329466 17.0388889 0.336243 17.0416667 0.341547 17.0444444 0.341842 17.0472222 0.330055 17.0500000 0.309429 17.0527778 0.292634 17.0555556 0.283204 17.0583333 0.282615 17.0611111 0.282615 17.0638889 0.282026 17.0666667 0.282910 17.0694444 0.283499 17.0722222 0.283794 17.0750000 0.284088 17.0777778 0.282910 17.0805556 0.282910 17.0833333 0.282910 17.0861111 0.283499 17.0888889 0.283204 17.0916667 0.282615 17.0944444 0.282615 17.0972222 0.282026 17.1000000 0.282320 17.1027778 0.282320 17.1055556 0.282910 17.1083333 0.282615 17.1111111 0.282026 17.1138889 0.281731 17.1166667 0.282320 17.1194444 0.282910 17.1222222 0.282910 17.1250000 0.282615 17.1277778 0.281731 17.1305556 0.282320 17.1333333 0.282615 17.1361111 0.283499 17.1388889 0.283204 17.1416667 0.282615 17.1444444 0.282026 17.1472222 0.281731 17.1500000 0.282910 17.1527778 0.283204 17.1555556 0.282910 17.1583333 0.282910 17.1611111 0.282615 17.1638889 0.282320 17.1666667 0.282910 17.1694444 0.283499 17.1722222 0.283204 17.1750000 0.282910 17.1777778 0.282320 17.1805556 0.282026 17.1833333 0.282615 17.1861111 0.283499 17.1888889 0.282320 17.1916667 0.282615 17.1944444 0.282026 17.1972222 0.282026 17.2000000 0.282910 17.2027778 0.283794 17.2055556 0.282910 17.2083333 0.282320 17.2111111 0.282026 17.2138889 0.281731 17.2166667 0.282615 17.2194444 0.282615 17.2222222 0.282320 17.2250000 0.282026 17.2277778 0.281436 17.2305556 0.281436 17.2333333 0.281142 17.2361111 0.281436 17.2388889 0.280552 17.2416667 0.281142 17.2444444 0.280258 17.2472222 0.279963 17.2500000 0.280552 17.2527778 0.281731 17.2555556 0.280847 17.2583333 0.280552 17.2611111 0.279669 17.2638889 0.279374 17.2666667 0.279079 17.2694444 0.279669 17.2722222 0.279079 17.2750000 0.278785 17.2777778 0.277901 17.2805556 0.277017 17.2833333 0.278195 17.2861111 0.277606 17.2888889 0.277017 17.2916667 0.276427 17.2944444 0.275838 17.2972222 0.275838 17.3000000 0.276133 17.3027778 0.276133 17.3055556 0.274659 17.3083333 0.274070 17.3111111 0.273775 17.3138889 0.272597 17.3166667 0.273186 17.3194444 0.273775 17.3222222 0.273186 17.3250000 0.273186 17.3277778 0.272597 17.3305556 0.272302 17.3333333 0.272891 17.3361111 0.273481 17.3388889 0.274070 17.3416667 0.273775 17.3444444 0.274070 17.3502222 0.300000 17.6636667 0.300000 17.6666667 0.284972 17.6694444 0.285856 17.6722222 0.285562 17.6750000 0.284972 17.6777778 0.285562 17.6805556 0.284383 17.6833333 0.285562 17.6861111 0.285856 17.6888889 0.285562 17.6916667 0.285267 17.6944444 0.284383 17.6972222 0.284383 17.7000000 0.285856 17.7027778 0.286740 17.7055556 0.286151 17.7083333 0.285267 17.7111111 0.285562 17.7138889 0.285267 17.7166667 0.286151 17.7194444 0.287035 17.7222222 0.287330 17.7250000 0.287624 17.7277778 0.287624 17.7305556 0.286740 17.7333333 0.287919 17.7361111 0.288214 17.7388889 0.288508 17.7416667 0.287919 17.7444444 0.288214 17.7472222 0.288508 17.7500000 0.289687 17.7527778 0.289687 17.7555556 0.289098 17.7583333 0.289098 17.7611111 0.288803 17.7638889 0.287919 17.7666667 0.288803 17.7694444 0.288508 17.7722222 0.287624 17.7750000 0.287624 17.7777778 0.287035 17.7805556 0.286740 17.7833333 0.287330 17.7861111 0.287330 17.7888889 0.286740 17.7916667 0.287035 17.7944444 0.286151 17.7972222 0.286151 17.8000000 0.286446 17.8027778 0.287035 17.8055556 0.287035 17.8083333 0.285856 17.8111111 0.285856 17.8138889 0.285562 17.8166667 0.286446 17.8194444 0.286446 17.8222222 0.286446 17.8250000 0.285562 17.8277778 0.284972 17.8305556 0.285267 17.8333333 0.285267 17.8361111 0.285856 17.8388889 0.285562 17.8416667 0.285267 17.8444444 0.285562 17.8472222 0.285267 17.8500000 0.286151 17.8527778 0.287035 17.8555556 0.286446 17.8583333 0.285562 17.8611111 0.284088 17.8638889 0.283794 17.8666667 0.283499 17.8694444 0.283204 17.8722222 0.281142 17.8750000 0.279669 17.8777778 0.277017 17.8805556 0.276722 17.8833333 0.277901 17.8861111 0.282910 17.8888889 0.289982 17.8916667 0.297053 17.8944444 0.302357 17.8972222 0.307366 17.9000000 0.314438 17.9027778 0.321510 17.9055556 0.327109 17.9083333 0.333002 17.9111111 0.335359 17.9138889 0.330350 17.9166667 0.316206 17.9194444 0.298232 17.9222222 0.284678 17.9250000 0.279963 17.9277778 0.282026 17.9305556 0.283794 17.9333333 0.283204 17.9361111 0.284383 17.9388889 0.285267 17.9416667 0.284678 17.9444444 0.284088 17.9472222 0.284088 17.9500000 0.284088 17.9527778 0.284383 17.9555556 0.284088 17.9583333 0.284088 17.9611111 0.283499 17.9638889 0.282910 17.9666667 0.283794 17.9694444 0.284383 17.9722222 0.284088 17.9750000 0.283794 17.9777778 0.283499 17.9805556 0.283499 17.9833333 0.284088 17.9861111 0.284088 17.9888889 0.284088 17.9916667 0.284678 17.9944444 0.283499 17.9972222 0.282910 18.0000000 0.284088 18.0027778 0.284972 18.0055556 0.284383 18.0083333 0.284088 18.0111111 0.283204 18.0138889 0.283204 18.0166667 0.285267 18.0194444 0.285267 18.0222222 0.284088 18.0250000 0.284383 18.0277778 0.283794 18.0305556 0.284088 18.0333333 0.284383 18.0361111 0.284972 18.0388889 0.284972 18.0416667 0.284383 18.0444444 0.283794 18.0472222 0.283794 18.0500000 0.284383 18.0527778 0.285267 18.0555556 0.284678 18.0583333 0.284088 18.0611111 0.283499 18.0638889 0.283499 18.0666667 0.283794 18.0694444 0.284678 18.0722222 0.284383 18.0750000 0.283499 18.0777778 0.283204 18.0805556 0.283204 18.0833333 0.284383 18.0861111 0.284383 18.0888889 0.283794 18.0916667 0.282615 18.0944444 0.282320 18.0972222 0.282320 18.1000000 0.283204 18.1027778 0.283794 18.1055556 0.282615 18.1083333 0.281731 18.1111111 0.282026 18.1138889 0.281142 18.1166667 0.282026 18.1194444 0.282026 18.1222222 0.281731 18.1250000 0.281436 18.1277778 0.280258 18.1305556 0.280258 18.1333333 0.280258 18.1361111 0.280847 18.1388889 0.280258 18.1416667 0.279374 18.1444444 0.278195 18.1472222 0.277606 18.1500000 0.278195 18.1527778 0.278785 18.1555556 0.277606 18.1583333 0.277311 18.1611111 0.276427 18.1638889 0.275838 18.1666667 0.276133 18.1694444 0.276722 18.1722222 0.276427 18.1750000 0.275249 18.1777778 0.274659 18.1805556 0.274659 18.1833333 0.274659 18.1861111 0.276133 18.1888889 0.275543 18.1916667 0.275249 18.1944444 0.274954 18.1972222 0.275543 18.2000000 0.275838 18.2027778 0.277606 18.2055556 0.277606 18.2083333 0.277901 18.2111111 0.277606 18.2138889 0.278195 18.2196667 0.300000 18.4858889 0.300000 18.4888889 0.283204 18.4916667 0.282910 18.4944444 0.282026 18.4972222 0.282615 18.5000000 0.283204 18.5027778 0.283499 18.5055556 0.283204 18.5083333 0.281731 18.5111111 0.281436 18.5138889 0.281731 18.5166667 0.282320 18.5194444 0.282615 18.5222222 0.282615 18.5250000 0.282615 18.5277778 0.282320 18.5305556 0.281731 18.5333333 0.282910 18.5361111 0.283499 18.5388889 0.284088 18.5416667 0.284088 18.5444444 0.284088 18.5472222 0.284383 18.5500000 0.285267 18.5527778 0.285267 18.5555556 0.284972 18.5583333 0.284383 18.5611111 0.284678 18.5638889 0.285562 18.5666667 0.286151 18.5694444 0.286740 18.5722222 0.285267 18.5750000 0.285267 18.5777778 0.284383 18.5805556 0.284383 18.5833333 0.285562 18.5861111 0.285856 18.5888889 0.285856 18.5916667 0.285267 18.5944444 0.283794 18.5972222 0.283204 18.6000000 0.283499 18.6027778 0.284383 18.6055556 0.284088 18.6083333 0.283794 18.6111111 0.282910 18.6138889 0.282320 18.6166667 0.283204 18.6194444 0.283204 18.6222222 0.282615 18.6250000 0.282615 18.6277778 0.282320 18.6305556 0.282026 18.6333333 0.283204 18.6361111 0.284383 18.6388889 0.282615 18.6416667 0.281731 18.6444444 0.281142 18.6472222 0.280847 18.6500000 0.281436 18.6527778 0.282320 18.6555556 0.282910 18.6583333 0.282320 18.6611111 0.281436 18.6638889 0.282320 18.6666667 0.282026 18.6694444 0.282910 18.6722222 0.283204 18.6750000 0.282320 18.6777778 0.282320 18.6805556 0.282615 18.6833333 0.283499 18.6861111 0.282615 18.6888889 0.281142 18.6916667 0.278785 18.6944444 0.276722 18.6972222 0.277311 18.7000000 0.276722 18.7027778 0.275249 18.7055556 0.273775 18.7083333 0.274954 18.7111111 0.278195 18.7138889 0.284678 18.7166667 0.291750 18.7194444 0.295875 18.7222222 0.299411 18.7250000 0.303831 18.7277778 0.308840 18.7305556 0.316796 18.7333333 0.323867 18.7361111 0.325046 18.7388889 0.315028 18.7416667 0.296169 18.7444444 0.279374 18.7472222 0.272302 18.7500000 0.274070 18.7527778 0.277017 18.7555556 0.278785 18.7583333 0.279374 18.7611111 0.279374 18.7638889 0.278785 18.7666667 0.279374 18.7694444 0.279963 18.7722222 0.280258 18.7750000 0.280258 18.7777778 0.280258 18.7805556 0.280258 18.7833333 0.281731 18.7861111 0.280552 18.7888889 0.279963 18.7916667 0.279669 18.7944444 0.279079 18.7972222 0.280258 18.8000000 0.280552 18.8027778 0.281436 18.8055556 0.280258 18.8083333 0.280258 18.8111111 0.280258 18.8138889 0.279963 18.8166667 0.281436 18.8194444 0.282026 18.8222222 0.282026 18.8250000 0.281731 18.8277778 0.281436 18.8305556 0.281142 18.8333333 0.281142 18.8361111 0.282026 18.8388889 0.280847 18.8416667 0.280552 18.8444444 0.280552 18.8472222 0.280847 18.8500000 0.280847 18.8527778 0.281142 18.8555556 0.280258 18.8583333 0.280552 18.8611111 0.279669 18.8638889 0.280552 18.8666667 0.280552 18.8694444 0.281142 18.8722222 0.280552 18.8750000 0.280258 18.8777778 0.280258 18.8805556 0.280552 18.8833333 0.281436 18.8861111 0.281436 18.8888889 0.281142 18.8916667 0.281142 18.8944444 0.280258 18.8972222 0.279669 18.9000000 0.279963 18.9027778 0.279963 18.9055556 0.280552 18.9083333 0.280258 18.9111111 0.279374 18.9138889 0.279079 18.9166667 0.280258 18.9194444 0.280847 18.9222222 0.279374 18.9250000 0.279079 18.9277778 0.278785 18.9305556 0.278490 18.9333333 0.279079 18.9361111 0.279079 18.9388889 0.279079 18.9416667 0.278195 18.9444444 0.278195 18.9472222 0.277901 18.9500000 0.277311 18.9527778 0.278195 18.9555556 0.276722 18.9583333 0.276427 18.9611111 0.276133 18.9638889 0.275838 18.9666667 0.274659 18.9694444 0.275249 18.9722222 0.274070 18.9750000 0.273481 18.9777778 0.273481 18.9805556 0.272891 18.9833333 0.272891 18.9861111 0.272597 18.9888889 0.272007 18.9916667 0.272007 18.9944444 0.271123 18.9972222 0.270534 19.0000000 0.272007 19.0027778 0.272302 19.0055556 0.272302 19.0083333 0.272891 19.0111111 0.272302 19.0138889 0.272302 19.0166667 0.273481 19.0194444 0.274954 19.0222222 0.275543 19.0250000 0.277311 19.0277778 0.276722 19.0305556 0.277901 19.0333333 0.278785 19.0361111 0.279079 19.0418889 0.300000 19.2720000 0.300000 19.2750000 0.284383 19.2777778 0.283499 19.2805556 0.283499 19.2833333 0.283499 19.2861111 0.284088 19.2888889 0.284972 19.2916667 0.284383 19.2944444 0.283499 19.2972222 0.283499 19.3000000 0.284088 19.3027778 0.284383 19.3055556 0.284383 19.3083333 0.283794 19.3111111 0.283794 19.3138889 0.284383 19.3166667 0.285267 19.3194444 0.286446 19.3222222 0.285562 19.3250000 0.285267 19.3277778 0.284972 19.3305556 0.285267 19.3333333 0.286446 19.3361111 0.287624 19.3388889 0.287919 19.3416667 0.287330 19.3444444 0.286446 19.3472222 0.287035 19.3500000 0.287035 19.3527778 0.288508 19.3555556 0.288803 19.3583333 0.288214 19.3611111 0.288214 19.3638889 0.288508 19.3666667 0.288214 19.3694444 0.289392 19.3722222 0.287624 19.3750000 0.287919 19.3777778 0.287624 19.3805556 0.287035 19.3833333 0.287624 19.3861111 0.287330 19.3888889 0.286740 19.3916667 0.287035 19.3944444 0.286740 19.3972222 0.285856 19.4000000 0.286740 19.4027778 0.287035 19.4055556 0.286740 19.4083333 0.286740 19.4111111 0.285562 19.4138889 0.285562 19.4166667 0.286151 19.4194444 0.286151 19.4222222 0.285562 19.4250000 0.285267 19.4277778 0.285267 19.4305556 0.285562 19.4333333 0.286151 19.4361111 0.286446 19.4388889 0.286446 19.4416667 0.285856 19.4444444 0.285267 19.4472222 0.285562 19.4500000 0.285562 19.4527778 0.286446 19.4555556 0.285856 19.4583333 0.285562 19.4611111 0.285562 19.4638889 0.284972 19.4666667 0.286151 19.4694444 0.286446 19.4722222 0.285856 19.4750000 0.285267 19.4777778 0.284088 19.4805556 0.282910 19.4833333 0.281731 19.4861111 0.280847 19.4888889 0.278490 19.4916667 0.277606 19.4944444 0.278785 19.4972222 0.284678 19.5000000 0.293223 19.5027778 0.300589 19.5055556 0.305893 19.5083333 0.311492 19.5111111 0.317090 19.5138889 0.324751 19.5166667 0.332118 19.5194444 0.336243 19.5222222 0.329761 19.5250000 0.312965 19.5277778 0.292339 19.5305556 0.279374 19.5333333 0.278490 19.5361111 0.282026 19.5388889 0.283204 19.5416667 0.283499 19.5444444 0.283794 19.5472222 0.284383 19.5500000 0.284383 19.5527778 0.284972 19.5555556 0.284678 19.5583333 0.284088 19.5611111 0.284088 19.5638889 0.283794 19.5666667 0.284678 19.5694444 0.285562 19.5722222 0.285267 19.5750000 0.284383 19.5777778 0.283794 19.5805556 0.283794 19.5833333 0.284678 19.5861111 0.285267 19.5888889 0.285562 19.5916667 0.285267 19.5944444 0.284383 19.5972222 0.284678 19.6000000 0.284678 19.6027778 0.285267 19.6055556 0.284972 19.6083333 0.284678 19.6111111 0.284972 19.6138889 0.284972 19.6166667 0.285562 19.6194444 0.285856 19.6222222 0.285562 19.6250000 0.284972 19.6277778 0.284383 19.6305556 0.284972 19.6333333 0.285856 19.6361111 0.286446 19.6388889 0.286446 19.6416667 0.286446 19.6444444 0.285267 19.6472222 0.285267 19.6500000 0.286151 19.6527778 0.285562 19.6555556 0.286151 19.6583333 0.286151 19.6611111 0.284383 19.6638889 0.285562 19.6666667 0.285856 19.6694444 0.286740 19.6722222 0.285562 19.6750000 0.286151 19.6777778 0.285267 19.6805556 0.284678 19.6833333 0.285267 19.6861111 0.286446 19.6888889 0.285856 19.6916667 0.285856 19.6944444 0.285267 19.6972222 0.284678 19.7000000 0.284972 19.7027778 0.285267 19.7055556 0.284383 19.7083333 0.284678 19.7111111 0.283499 19.7138889 0.283499 19.7166667 0.284088 19.7194444 0.284088 19.7222222 0.283794 19.7250000 0.283204 19.7277778 0.282026 19.7305556 0.282320 19.7333333 0.282026 19.7361111 0.282910 19.7388889 0.282026 19.7416667 0.281142 19.7444444 0.279963 19.7472222 0.279374 19.7500000 0.280258 19.7527778 0.280552 19.7555556 0.279669 19.7583333 0.278490 19.7611111 0.277606 19.7638889 0.277311 19.7666667 0.277311 19.7694444 0.278195 19.7722222 0.277311 19.7750000 0.276427 19.7777778 0.276427 19.7805556 0.275249 19.7833333 0.276427 19.7861111 0.277017 19.7888889 0.276722 19.7916667 0.277017 19.7944444 0.276722 19.7972222 0.277901 19.8000000 0.279079 19.8027778 0.280552 19.8055556 0.280847 19.8083333 0.281142 19.8111111 0.282026 19.8138889 0.283499 19.8166667 0.284383 19.8194444 0.285562 19.8222222 0.286151 19.8280000 0.300000 20.0636667 0.300000 20.0666667 0.288214 20.0694444 0.288803 20.0722222 0.288214 20.0750000 0.287624 20.0777778 0.287624 20.0805556 0.287919 20.0833333 0.288508 20.0861111 0.289687 20.0888889 0.289098 20.0916667 0.287624 20.0944444 0.287624 20.0972222 0.287330 20.1000000 0.287624 20.1027778 0.288508 20.1055556 0.288214 20.1083333 0.287919 20.1111111 0.287624 20.1138889 0.287919 20.1166667 0.288508 20.1194444 0.289392 20.1222222 0.289392 20.1250000 0.289098 20.1277778 0.288508 20.1305556 0.288508 20.1333333 0.290276 20.1361111 0.290866 20.1388889 0.291750 20.1416667 0.289982 20.1444444 0.289687 20.1472222 0.290276 20.1500000 0.290276 20.1527778 0.291160 20.1555556 0.291750 20.1583333 0.292339 20.1611111 0.291750 20.1638889 0.290866 20.1666667 0.291455 20.1694444 0.292044 20.1722222 0.291455 20.1750000 0.291750 20.1777778 0.290571 20.1805556 0.290571 20.1833333 0.289687 20.1861111 0.290571 20.1888889 0.290276 20.1916667 0.289687 20.1944444 0.289098 20.1972222 0.288508 20.2000000 0.289687 20.2027778 0.289392 20.2055556 0.289098 20.2083333 0.288214 20.2111111 0.287624 20.2138889 0.287919 20.2166667 0.287624 20.2194444 0.289392 20.2222222 0.288803 20.2250000 0.287919 20.2277778 0.287330 20.2305556 0.287624 20.2333333 0.287330 20.2361111 0.288803 20.2388889 0.289098 20.2416667 0.288214 20.2444444 0.287919 20.2472222 0.287624 20.2500000 0.288214 20.2527778 0.288214 20.2555556 0.288214 20.2583333 0.286740 20.2611111 0.286446 20.2638889 0.284972 20.2666667 0.283794 20.2694444 0.282320 20.2722222 0.279963 20.2750000 0.278195 20.2777778 0.277901 20.2805556 0.282320 20.2833333 0.290571 20.2861111 0.298821 20.2888889 0.305009 20.2916667 0.309429 20.2944444 0.311786 20.2972222 0.315322 20.3000000 0.320037 20.3027778 0.325635 20.3055556 0.329466 20.3083333 0.333591 20.3111111 0.338600 20.3138889 0.344494 20.3166667 0.346556 20.3194444 0.338011 20.3222222 0.318858 20.3250000 0.296169 20.3277778 0.284972 20.3305556 0.284678 20.3333333 0.286446 20.3361111 0.287035 20.3388889 0.286446 20.3416667 0.286740 20.3444444 0.285856 20.3472222 0.284972 20.3500000 0.285267 20.3527778 0.285562 20.3555556 0.285562 20.3583333 0.284088 20.3611111 0.284678 20.3638889 0.284088 20.3666667 0.285267 20.3694444 0.285267 20.3722222 0.284972 20.3750000 0.284678 20.3777778 0.284088 20.3805556 0.284088 20.3833333 0.285267 20.3861111 0.284678 20.3888889 0.284972 20.3916667 0.284972 20.3944444 0.283794 20.3972222 0.283794 20.4000000 0.283794 20.4027778 0.285562 20.4055556 0.285562 20.4083333 0.285267 20.4111111 0.284383 20.4138889 0.284088 20.4166667 0.284678 20.4194444 0.284972 20.4222222 0.284678 20.4250000 0.284088 20.4277778 0.284088 20.4305556 0.284383 20.4333333 0.284972 20.4361111 0.284678 20.4388889 0.285267 20.4416667 0.285267 20.4444444 0.284088 20.4472222 0.283794 20.4500000 0.284678 20.4527778 0.284972 20.4555556 0.284088 20.4583333 0.284972 20.4611111 0.284088 20.4638889 0.284088 20.4666667 0.283794 20.4694444 0.284383 20.4722222 0.284678 20.4750000 0.283499 20.4777778 0.284088 20.4805556 0.283794 20.4833333 0.284088 20.4861111 0.284088 20.4888889 0.283499 20.4916667 0.282615 20.4944444 0.282320 20.4972222 0.282320 20.5000000 0.282615 20.5027778 0.282615 20.5055556 0.282910 20.5083333 0.281436 20.5111111 0.280258 20.5138889 0.280847 20.5166667 0.280847 20.5194444 0.281731 20.5222222 0.281142 20.5250000 0.279669 20.5277778 0.278785 20.5305556 0.278490 20.5333333 0.278490 20.5361111 0.279374 20.5388889 0.278195 20.5416667 0.277901 20.5444444 0.277017 20.5472222 0.276133 20.5500000 0.276133 20.5527778 0.276427 20.5555556 0.275543 20.5583333 0.275249 20.5611111 0.274954 20.5638889 0.274659 20.5666667 0.274954 20.5694444 0.275543 20.5722222 0.274954 20.5750000 0.274659 20.5777778 0.274954 20.5805556 0.274659 20.5833333 0.276722 20.5861111 0.277606 20.5888889 0.277901 20.5916667 0.278195 20.5944444 0.277901 20.5972222 0.279374 20.6000000 0.280847 20.6027778 0.282320 20.6055556 0.282615 20.6083333 0.283499 20.6111111 0.283499 20.6138889 0.283794 20.6196667 0.300000 20.8386667 0.300000 20.8416667 0.287330 20.8444444 0.286740 20.8472222 0.286740 20.8500000 0.287624 20.8527778 0.287624 20.8555556 0.287330 20.8583333 0.287035 20.8611111 0.287035 20.8638889 0.286740 20.8666667 0.287330 20.8694444 0.288214 20.8722222 0.287035 20.8750000 0.286446 20.8777778 0.286446 20.8805556 0.286740 20.8833333 0.287624 20.8861111 0.287919 20.8888889 0.287624 20.8916667 0.287919 20.8944444 0.287330 20.8972222 0.287624 20.9000000 0.288508 20.9027778 0.289687 20.9055556 0.290276 20.9083333 0.288803 20.9111111 0.288803 20.9138889 0.289098 20.9166667 0.289392 20.9194444 0.289392 20.9222222 0.289687 20.9250000 0.289098 20.9277778 0.288803 20.9305556 0.288508 20.9333333 0.289687 20.9361111 0.290866 20.9388889 0.291160 20.9416667 0.290866 20.9444444 0.289982 20.9472222 0.289687 20.9500000 0.290276 20.9527778 0.290866 20.9555556 0.290571 20.9583333 0.289982 20.9611111 0.289392 20.9638889 0.288803 20.9666667 0.289098 20.9694444 0.289982 20.9722222 0.288803 20.9750000 0.287919 20.9777778 0.287624 20.9805556 0.287035 20.9833333 0.287330 20.9861111 0.287624 20.9888889 0.287330 20.9916667 0.286740 20.9944444 0.286151 20.9972222 0.286740 21.0000000 0.286740 21.0027778 0.287330 21.0055556 0.287624 21.0083333 0.287035 21.0111111 0.286740 21.0138889 0.286740 21.0166667 0.286151 21.0194444 0.286740 21.0222222 0.286151 21.0250000 0.286740 21.0277778 0.286151 21.0305556 0.285856 21.0333333 0.286151 21.0361111 0.286740 21.0388889 0.285856 21.0416667 0.284678 21.0444444 0.283204 21.0472222 0.281731 21.0500000 0.280847 21.0527778 0.279079 21.0555556 0.277017 21.0583333 0.276133 21.0611111 0.278785 21.0638889 0.284383 21.0666667 0.291750 21.0694444 0.298821 21.0722222 0.303241 21.0750000 0.307661 21.0777778 0.314438 21.0805556 0.321510 21.0833333 0.327993 21.0861111 0.331234 21.0888889 0.323867 21.0916667 0.306188 21.0944444 0.287624 21.0972222 0.279079 21.1000000 0.279079 21.1027778 0.282910 21.1055556 0.283204 21.1083333 0.283499 21.1111111 0.283499 21.1138889 0.282910 21.1166667 0.282910 21.1194444 0.283794 21.1222222 0.283794 21.1250000 0.283499 21.1277778 0.282910 21.1305556 0.283204 21.1333333 0.282910 21.1361111 0.282910 21.1388889 0.283204 21.1416667 0.282910 21.1444444 0.282026 21.1472222 0.282026 21.1500000 0.282320 21.1527778 0.283499 21.1555556 0.282320 21.1583333 0.282615 21.1611111 0.282615 21.1638889 0.283204 21.1666667 0.283794 21.1694444 0.284383 21.1722222 0.283499 21.1750000 0.282320 21.1777778 0.282320 21.1805556 0.282320 21.1833333 0.282615 21.1861111 0.284088 21.1888889 0.283204 21.1916667 0.283204 21.1944444 0.282910 21.1972222 0.282615 21.2000000 0.282910 21.2027778 0.283204 21.2055556 0.283794 21.2083333 0.282615 21.2111111 0.282910 21.2138889 0.282320 21.2166667 0.282615 21.2194444 0.282615 21.2222222 0.283204 21.2250000 0.282910 21.2277778 0.283204 21.2305556 0.282615 21.2333333 0.283204 21.2361111 0.283794 21.2388889 0.282910 21.2416667 0.283499 21.2444444 0.282910 21.2472222 0.282026 21.2500000 0.282910 21.2527778 0.283794 21.2555556 0.282910 21.2583333 0.282910 21.2611111 0.282615 21.2638889 0.282026 21.2666667 0.282615 21.2694444 0.282615 21.2722222 0.282320 21.2750000 0.281142 21.2777778 0.280847 21.2805556 0.281142 21.2833333 0.281731 21.2861111 0.282320 21.2888889 0.281142 21.2916667 0.280258 21.2944444 0.279374 21.2972222 0.279374 21.3000000 0.280847 21.3027778 0.280552 21.3055556 0.279963 21.3083333 0.279669 21.3111111 0.278785 21.3138889 0.277606 21.3166667 0.277606 21.3194444 0.278195 21.3222222 0.277901 21.3250000 0.277606 21.3277778 0.276427 21.3305556 0.276133 21.3333333 0.276427 21.3361111 0.276427 21.3388889 0.275543 21.3416667 0.274954 21.3444444 0.274659 21.3472222 0.273775 21.3500000 0.274365 21.3527778 0.275249 21.3555556 0.274070 21.3583333 0.274070 21.3611111 0.273186 21.3638889 0.272597 21.3666667 0.274659 21.3694444 0.276133 21.3722222 0.276133 21.3750000 0.276722 21.3777778 0.275838 21.3805556 0.276722 21.3833333 0.279079 21.3861111 0.280552 21.3888889 0.281142 21.3946667 0.300000 21.6247778 0.300000 21.6277778 0.282320 21.6305556 0.281731 21.6333333 0.282320 21.6361111 0.283204 21.6388889 0.283204 21.6416667 0.282910 21.6444444 0.282615 21.6472222 0.282320 21.6500000 0.282910 21.6527778 0.283204 21.6555556 0.283204 21.6583333 0.282910 21.6611111 0.282615 21.6638889 0.282615 21.6666667 0.282910 21.6694444 0.283499 21.6722222 0.282910 21.6750000 0.284088 21.6777778 0.282910 21.6805556 0.283794 21.6833333 0.284678 21.6861111 0.284972 21.6888889 0.284678 21.6916667 0.283499 21.6944444 0.283499 21.6972222 0.283204 21.7000000 0.284088 21.7027778 0.285856 21.7055556 0.286446 21.7083333 0.286151 21.7111111 0.285562 21.7138889 0.285856 21.7166667 0.286446 21.7194444 0.286446 21.7222222 0.286446 21.7250000 0.285856 21.7277778 0.284383 21.7305556 0.284678 21.7333333 0.285562 21.7361111 0.285267 21.7388889 0.284383 21.7416667 0.282615 21.7444444 0.282910 21.7472222 0.282615 21.7500000 0.283499 21.7527778 0.283204 21.7555556 0.283499 21.7583333 0.282910 21.7611111 0.281142 21.7638889 0.281731 21.7666667 0.282026 21.7694444 0.282615 21.7722222 0.282615 21.7750000 0.282615 21.7777778 0.282615 21.7805556 0.282320 21.7833333 0.282320 21.7861111 0.282910 21.7888889 0.282026 21.7916667 0.282026 21.7944444 0.281142 21.7972222 0.282026 21.8000000 0.282615 21.8027778 0.282910 21.8055556 0.283204 21.8083333 0.282910 21.8111111 0.282026 21.8138889 0.282026 21.8166667 0.282320 21.8194444 0.282910 21.8222222 0.281436 21.8250000 0.281436 21.8277778 0.280552 21.8305556 0.279669 21.8333333 0.279079 21.8361111 0.277901 21.8388889 0.276427 21.8416667 0.274659 21.8444444 0.274070 21.8472222 0.276133 21.8500000 0.281142 21.8527778 0.287330 21.8555556 0.293223 21.8583333 0.296759 21.8611111 0.300000 21.8638889 0.305009 21.8666667 0.313260 21.8694444 0.320921 21.8722222 0.325341 21.8750000 0.320921 21.8777778 0.303536 21.8805556 0.283794 21.8833333 0.272597 21.8861111 0.272597 21.8888889 0.274659 21.8916667 0.277311 21.8944444 0.277901 21.8972222 0.278785 21.9000000 0.279374 21.9027778 0.279079 21.9055556 0.279374 21.9083333 0.279079 21.9111111 0.279374 21.9138889 0.279079 21.9166667 0.279669 21.9194444 0.280552 21.9222222 0.280552 21.9250000 0.279669 21.9277778 0.279669 21.9305556 0.279374 21.9333333 0.280258 21.9361111 0.281436 21.9388889 0.280847 21.9416667 0.280847 21.9444444 0.280258 21.9472222 0.279669 21.9500000 0.281142 21.9527778 0.280847 21.9555556 0.280552 21.9583333 0.281142 21.9611111 0.279669 21.9638889 0.279963 21.9666667 0.280552 21.9694444 0.281436 21.9722222 0.280847 21.9750000 0.280258 21.9777778 0.279963 21.9805556 0.279963 21.9833333 0.281436 21.9861111 0.281731 21.9888889 0.280847 21.9916667 0.279963 21.9944444 0.279963 21.9972222 0.279963 22.0000000 0.280552 22.0027778 0.281142 22.0055556 0.281436 22.0083333 0.281731 22.0111111 0.280847 22.0138889 0.280552 22.0166667 0.281436 22.0194444 0.281731 22.0222222 0.281731 22.0250000 0.279963 22.0277778 0.279669 22.0305556 0.279669 22.0333333 0.280258 22.0361111 0.281142 22.0388889 0.281142 22.0416667 0.281731 22.0444444 0.280847 22.0472222 0.280552 22.0500000 0.280552 22.0527778 0.280847 22.0555556 0.280552 22.0583333 0.279963 22.0611111 0.280258 22.0638889 0.279963 22.0666667 0.280258 22.0694444 0.281142 22.0722222 0.280847 22.0750000 0.279963 22.0777778 0.279079 22.0805556 0.278785 22.0833333 0.279374 22.0861111 0.279669 22.0888889 0.279079 22.0916667 0.278195 22.0944444 0.278490 22.0972222 0.277017 22.1000000 0.277901 22.1027778 0.278195 22.1055556 0.277901 22.1083333 0.277017 22.1111111 0.275543 22.1138889 0.275543 22.1166667 0.275838 22.1194444 0.275838 22.1222222 0.274954 22.1250000 0.274070 22.1277778 0.273481 22.1305556 0.273186 22.1333333 0.274070 22.1361111 0.273775 22.1388889 0.273481 22.1416667 0.272597 22.1444444 0.272007 22.1472222 0.272302 22.1500000 0.272891 22.1527778 0.274070 22.1555556 0.273775 22.1583333 0.274070 22.1611111 0.273775 22.1638889 0.274659 22.1666667 0.276427 22.1694444 0.277017 22.1722222 0.278195 22.1750000 0.278490 22.1807778 0.300000 22.4358889 0.300000 22.4388889 0.286446 22.4416667 0.286151 22.4444444 0.285562 22.4472222 0.285562 22.4500000 0.286151 22.4527778 0.287330 22.4555556 0.287035 22.4583333 0.285856 22.4611111 0.285856 22.4638889 0.286151 22.4666667 0.285856 22.4694444 0.286151 22.4722222 0.286446 22.4750000 0.286446 22.4777778 0.285856 22.4805556 0.285562 22.4833333 0.285856 22.4861111 0.287035 22.4888889 0.286740 22.4916667 0.286446 22.4944444 0.286151 22.4972222 0.287035 22.5000000 0.287919 22.5027778 0.288803 22.5055556 0.288508 22.5083333 0.289098 22.5111111 0.288214 22.5138889 0.288508 22.5166667 0.287919 22.5194444 0.288803 22.5222222 0.288214 22.5250000 0.288803 22.5277778 0.289098 22.5305556 0.289392 22.5333333 0.290571 22.5361111 0.290276 22.5388889 0.290276 22.5416667 0.289982 22.5444444 0.289392 22.5472222 0.289687 22.5500000 0.289982 22.5527778 0.289982 22.5555556 0.289687 22.5583333 0.288803 22.5611111 0.287624 22.5638889 0.287624 22.5666667 0.288214 22.5694444 0.288214 22.5722222 0.288214 22.5750000 0.287330 22.5777778 0.287035 22.5805556 0.286740 22.5833333 0.287035 22.5861111 0.287919 22.5888889 0.287035 22.5916667 0.287035 22.5944444 0.286446 22.5972222 0.286740 22.6000000 0.287330 22.6027778 0.287624 22.6055556 0.286740 22.6083333 0.286446 22.6111111 0.285562 22.6138889 0.286740 22.6166667 0.287330 22.6194444 0.287624 22.6222222 0.287330 22.6250000 0.287624 22.6277778 0.286740 22.6305556 0.286446 22.6333333 0.286151 22.6361111 0.286151 22.6388889 0.284383 22.6416667 0.282615 22.6444444 0.280258 22.6472222 0.277311 22.6500000 0.277311 22.6527778 0.278195 22.6555556 0.281142 22.6583333 0.287330 22.6611111 0.294107 22.6638889 0.300000 22.6666667 0.305304 22.6694444 0.310018 22.6722222 0.313849 22.6750000 0.317974 22.6777778 0.324751 22.6805556 0.331234 22.6833333 0.339190 22.6861111 0.344199 22.6888889 0.341252 22.6916667 0.325930 22.6944444 0.304125 22.6972222 0.287035 22.7000000 0.283204 22.7027778 0.284972 22.7055556 0.286151 22.7083333 0.285562 22.7111111 0.284972 22.7138889 0.284972 22.7166667 0.285562 22.7194444 0.285562 22.7222222 0.285267 22.7250000 0.284678 22.7277778 0.284383 22.7305556 0.284088 22.7333333 0.284678 22.7361111 0.285267 22.7388889 0.285267 22.7416667 0.284678 22.7444444 0.284383 22.7472222 0.284088 22.7500000 0.284088 22.7527778 0.285267 22.7555556 0.284678 22.7583333 0.284678 22.7611111 0.284678 22.7638889 0.284383 22.7666667 0.284972 22.7694444 0.284678 22.7722222 0.285267 22.7750000 0.284678 22.7777778 0.284383 22.7805556 0.284383 22.7833333 0.284678 22.7861111 0.284383 22.7888889 0.284972 22.7916667 0.284678 22.7944444 0.283794 22.7972222 0.284383 22.8000000 0.284972 22.8027778 0.285856 22.8055556 0.285562 22.8083333 0.285562 22.8111111 0.284678 22.8138889 0.284678 22.8166667 0.284383 22.8194444 0.285267 22.8222222 0.285267 22.8250000 0.284088 22.8277778 0.284383 22.8305556 0.284678 22.8333333 0.284972 22.8361111 0.285267 22.8388889 0.284678 22.8416667 0.284383 22.8444444 0.283794 22.8472222 0.283794 22.8500000 0.284383 22.8527778 0.284678 22.8555556 0.284972 22.8583333 0.283794 22.8611111 0.283794 22.8638889 0.283794 22.8666667 0.284088 22.8694444 0.283794 22.8722222 0.284088 22.8750000 0.283794 22.8777778 0.282320 22.8805556 0.282615 22.8833333 0.282910 22.8861111 0.283204 22.8888889 0.282910 22.8916667 0.282320 22.8944444 0.280552 22.8972222 0.280847 22.9000000 0.281731 22.9027778 0.282026 22.9055556 0.280847 22.9083333 0.280258 22.9111111 0.278785 22.9138889 0.279079 22.9166667 0.279374 22.9194444 0.279374 22.9222222 0.278785 22.9250000 0.278785 22.9277778 0.277311 22.9305556 0.276722 22.9333333 0.277017 22.9361111 0.277017 22.9388889 0.276427 22.9416667 0.276427 22.9444444 0.274954 22.9472222 0.275838 22.9500000 0.275249 22.9527778 0.276133 22.9555556 0.276133 22.9583333 0.275838 22.9611111 0.275249 22.9638889 0.275838 22.9666667 0.276133 22.9694444 0.277606 22.9722222 0.277606 22.9750000 0.277901 22.9777778 0.277606 22.9805556 0.278785 22.9833333 0.279669 22.9861111 0.280552 22.9918889 0.300000 23.2525556 0.300000 23.2555556 0.287624 23.2583333 0.287330 23.2611111 0.287035 23.2638889 0.286740 23.2666667 0.286740 23.2694444 0.287624 23.2722222 0.287330 23.2750000 0.286740 23.2777778 0.286740 23.2805556 0.287035 23.2833333 0.287330 23.2861111 0.287919 23.2888889 0.287330 23.2916667 0.287035 23.2944444 0.285856 23.2972222 0.286151 23.3000000 0.286446 23.3027778 0.287624 23.3055556 0.287624 23.3083333 0.287624 23.3111111 0.287330 23.3138889 0.287624 23.3166667 0.288803 23.3194444 0.288508 23.3222222 0.289098 23.3250000 0.289098 23.3277778 0.288803 23.3305556 0.288803 23.3333333 0.289392 23.3361111 0.289687 23.3388889 0.289687 23.3416667 0.289687 23.3444444 0.289687 23.3472222 0.290571 23.3500000 0.290866 23.3527778 0.291160 23.3555556 0.291455 23.3583333 0.290276 23.3611111 0.290571 23.3638889 0.289098 23.3666667 0.289392 23.3694444 0.289982 23.3722222 0.289687 23.3750000 0.289687 23.3777778 0.288803 23.3805556 0.289098 23.3833333 0.288214 23.3861111 0.288803 23.3888889 0.288508 23.3916667 0.288803 23.3944444 0.287330 23.3972222 0.287035 23.4000000 0.287919 23.4027778 0.287919 23.4055556 0.287624 23.4083333 0.287330 23.4111111 0.287330 23.4138889 0.287035 23.4166667 0.287035 23.4194444 0.287330 23.4222222 0.287624 23.4250000 0.287330 23.4277778 0.286446 23.4305556 0.287330 23.4333333 0.287919 23.4361111 0.287919 23.4388889 0.288214 23.4416667 0.287035 23.4444444 0.286446 23.4472222 0.286446 23.4500000 0.287330 23.4527778 0.287330 23.4555556 0.287035 23.4583333 0.285267 23.4611111 0.283499 23.4638889 0.282026 23.4666667 0.280847 23.4694444 0.279963 23.4722222 0.278195 23.4750000 0.278785 23.4777778 0.283794 23.4805556 0.290866 23.4833333 0.300000 23.4861111 0.306777 23.4888889 0.312965 23.4916667 0.320037 23.4944444 0.326814 23.4972222 0.334180 23.5000000 0.339779 23.5027778 0.337422 23.5055556 0.322394 23.5083333 0.300295 23.5111111 0.284972 23.5138889 0.282026 23.5166667 0.284678 23.5194444 0.284972 23.5222222 0.285267 23.5250000 0.284678 23.5277778 0.284972 23.5305556 0.284678 23.5333333 0.284678 23.5361111 0.285267 23.5388889 0.285562 23.5416667 0.284383 23.5444444 0.283794 23.5472222 0.283204 23.5500000 0.284678 23.5527778 0.285562 23.5555556 0.284972 23.5583333 0.284972 23.5611111 0.284678 23.5638889 0.283794 23.5666667 0.284678 23.5694444 0.285267 23.5722222 0.284678 23.5750000 0.284972 23.5777778 0.284383 23.5805556 0.284383 23.5833333 0.284383 23.5861111 0.284972 23.5888889 0.285267 23.5916667 0.284678 23.5944444 0.283499 23.5972222 0.284383 23.6000000 0.284972 23.6027778 0.285856 23.6055556 0.285267 23.6083333 0.284678 23.6111111 0.284383 23.6138889 0.284383 23.6166667 0.284383 23.6194444 0.284972 23.6222222 0.284678 23.6250000 0.285267 23.6277778 0.284088 23.6305556 0.284678 23.6333333 0.284972 23.6361111 0.285562 23.6388889 0.285562 23.6416667 0.285267 23.6444444 0.284088 23.6472222 0.284678 23.6500000 0.285267 23.6527778 0.286151 23.6555556 0.284972 23.6583333 0.285267 23.6611111 0.283794 23.6638889 0.284088 23.6666667 0.284383 23.6694444 0.284972 23.6722222 0.284972 23.6750000 0.284383 23.6777778 0.284088 23.6805556 0.283204 23.6833333 0.283204 23.6861111 0.284678 23.6888889 0.283794 23.6916667 0.283204 23.6944444 0.282910 23.6972222 0.283204 23.7000000 0.283499 23.7027778 0.284088 23.7055556 0.283204 23.7083333 0.282910 23.7111111 0.282320 23.7138889 0.281142 23.7166667 0.281436 23.7194444 0.281731 23.7222222 0.281436 23.7250000 0.280847 23.7277778 0.280552 23.7305556 0.279669 23.7333333 0.279669 23.7361111 0.279963 23.7388889 0.279669 23.7416667 0.278785 23.7444444 0.278490 23.7472222 0.278195 23.7500000 0.277901 23.7527778 0.278195 23.7555556 0.277901 23.7583333 0.276722 23.7611111 0.276133 23.7638889 0.276427 23.7666667 0.276427 23.7694444 0.276722 23.7722222 0.276133 23.7750000 0.276133 23.7777778 0.275543 23.7805556 0.275249 23.7833333 0.276427 23.7861111 0.278195 23.7888889 0.277901 23.7916667 0.278195 23.7944444 0.278490 23.7972222 0.280258 23.8000000 0.280847 23.8027778 0.281731 23.8085556 0.300000 24.0803333 0.300000 24.0833333 0.286151 24.0861111 0.287624 24.0888889 0.287035 24.0916667 0.286446 24.0944444 0.286446 24.0972222 0.286151 24.1000000 0.286446 24.1027778 0.287035 24.1055556 0.286446 24.1083333 0.286446 24.1111111 0.285267 24.1138889 0.285562 24.1166667 0.285856 24.1194444 0.286740 24.1222222 0.287035 24.1250000 0.287035 24.1277778 0.287330 24.1305556 0.286740 24.1333333 0.287919 24.1361111 0.288214 24.1388889 0.288214 24.1416667 0.287624 24.1444444 0.287624 24.1472222 0.287624 24.1500000 0.288803 24.1527778 0.289687 24.1555556 0.289687 24.1583333 0.288508 24.1611111 0.288803 24.1638889 0.288803 24.1666667 0.289982 24.1694444 0.289982 24.1722222 0.290571 24.1750000 0.289982 24.1777778 0.289098 24.1805556 0.289098 24.1833333 0.289392 24.1861111 0.289392 24.1888889 0.289687 24.1916667 0.289098 24.1944444 0.287624 24.1972222 0.287330 24.2000000 0.287624 24.2027778 0.288214 24.2055556 0.288214 24.2083333 0.287919 24.2111111 0.287330 24.2138889 0.286151 24.2166667 0.286446 24.2194444 0.286740 24.2222222 0.286151 24.2250000 0.285856 24.2277778 0.285267 24.2305556 0.284972 24.2333333 0.285267 24.2361111 0.285562 24.2388889 0.285562 24.2416667 0.285267 24.2444444 0.284678 24.2472222 0.284088 24.2500000 0.284678 24.2527778 0.285856 24.2555556 0.285562 24.2583333 0.284972 24.2611111 0.284678 24.2638889 0.284678 24.2666667 0.284678 24.2694444 0.285267 24.2722222 0.285562 24.2750000 0.284972 24.2777778 0.284088 24.2805556 0.284383 24.2833333 0.283204 24.2861111 0.282910 24.2888889 0.281436 24.2916667 0.279669 24.2944444 0.278195 24.2972222 0.276133 24.3000000 0.275543 24.3027778 0.277311 24.3055556 0.281731 24.3083333 0.287035 24.3111111 0.293517 24.3138889 0.297937 24.3166667 0.302652 24.3194444 0.308545 24.3222222 0.314144 24.3250000 0.321805 24.3277778 0.325930 24.3305556 0.323867 24.3333333 0.312670 24.3361111 0.295285 24.3388889 0.280552 24.3416667 0.275838 24.3444444 0.277017 24.3472222 0.279963 24.3500000 0.281436 24.3527778 0.282026 24.3555556 0.281436 24.3583333 0.281731 24.3611111 0.281436 24.3638889 0.281142 24.3666667 0.281436 24.3694444 0.282320 24.3722222 0.282320 24.3750000 0.281142 24.3777778 0.281142 24.3805556 0.281436 24.3833333 0.281731 24.3861111 0.282910 24.3888889 0.282615 24.3916667 0.282910 24.3944444 0.281436 24.3972222 0.282026 24.4000000 0.281731 24.4027778 0.282320 24.4055556 0.282615 24.4083333 0.281731 24.4111111 0.281142 24.4138889 0.281142 24.4166667 0.281436 24.4194444 0.282320 24.4222222 0.282320 24.4250000 0.281731 24.4277778 0.280847 24.4305556 0.281436 24.4333333 0.281142 24.4361111 0.282615 24.4388889 0.281731 24.4416667 0.282910 24.4444444 0.282026 24.4472222 0.281731 24.4500000 0.282026 24.4527778 0.283204 24.4555556 0.282026 24.4583333 0.282026 24.4611111 0.280847 24.4638889 0.281436 24.4666667 0.282320 24.4694444 0.282910 24.4722222 0.282320 24.4750000 0.281436 24.4777778 0.280847 24.4805556 0.280258 24.4833333 0.281142 24.4861111 0.282615 24.4888889 0.281731 24.4916667 0.281731 24.4944444 0.282026 24.4972222 0.281142 24.5000000 0.281142 24.5027778 0.281731 24.5055556 0.281731 24.5083333 0.282026 24.5111111 0.281142 24.5138889 0.281142 24.5166667 0.281142 24.5194444 0.281731 24.5222222 0.281436 24.5250000 0.281142 24.5277778 0.280552 24.5305556 0.280847 24.5333333 0.281436 24.5361111 0.281436 24.5388889 0.280847 24.5416667 0.280847 24.5444444 0.280847 24.5472222 0.279963 24.5500000 0.279963 24.5527778 0.279669 24.5555556 0.279669 24.5583333 0.279079 24.5611111 0.278195 24.5638889 0.278490 24.5666667 0.277901 24.5694444 0.278490 24.5722222 0.278490 24.5750000 0.277606 24.5777778 0.276722 24.5805556 0.276133 24.5833333 0.275543 24.5861111 0.277017 24.5888889 0.276427 24.5916667 0.275838 24.5944444 0.274070 24.5972222 0.274070 24.6000000 0.273775 24.6027778 0.274365 24.6055556 0.273775 24.6083333 0.274070 24.6111111 0.273481 24.6138889 0.273481 24.6166667 0.274070 24.6194444 0.274659 24.6222222 0.274070 24.6250000 0.273775 24.6277778 0.273186 24.6305556 0.273481 24.6363333 0.300000 24.8333333 0.300000)
.include "C:/Users/kadhi/OneDrive/Desktop/amux/verilogLearning/Leaky-Integrate-Fire---SNN-model-on-FPGA/experiments/frontend_optimization/complete_frontend/inverter.spice"
.include "C:/Users/kadhi/OneDrive/Desktop/amux/verilogLearning/Leaky-Integrate-Fire---SNN-model-on-FPGA/experiments/frontend_optimization/complete_frontend/bias_gen.spice"
.include "C:/Users/kadhi/OneDrive/Desktop/amux/verilogLearning/Leaky-Integrate-Fire---SNN-model-on-FPGA/experiments/frontend_optimization/complete_frontend/edge_buffer.spice"
.include "C:/Users/kadhi/OneDrive/Desktop/amux/verilogLearning/Leaky-Integrate-Fire---SNN-model-on-FPGA/experiments/frontend_optimization/complete_frontend/pulse_gen.spice"
.include "C:/Users/kadhi/OneDrive/Desktop/amux/verilogLearning/Leaky-Integrate-Fire---SNN-model-on-FPGA/experiments/frontend_optimization/complete_frontend/long_pulse_gen.spice"
.include "C:/Users/kadhi/OneDrive/Desktop/amux/verilogLearning/Leaky-Integrate-Fire---SNN-model-on-FPGA/experiments/frontend_optimization/complete_frontend/beat_instability.spice"
.include "C:/Users/kadhi/OneDrive/Desktop/amux/verilogLearning/Leaky-Integrate-Fire---SNN-model-on-FPGA/experiments/frontend_optimization/complete_frontend/pwave_diff.spice"
.include "C:/Users/kadhi/OneDrive/Desktop/amux/verilogLearning/Leaky-Integrate-Fire---SNN-model-on-FPGA/experiments/frontend_optimization/complete_frontend/qrs_width.spice"
.include "C:/Users/kadhi/OneDrive/Desktop/amux/verilogLearning/Leaky-Integrate-Fire---SNN-model-on-FPGA/experiments/frontend_optimization/complete_frontend/qrs_slope.spice"
.include "C:/Users/kadhi/OneDrive/Desktop/amux/verilogLearning/Leaky-Integrate-Fire---SNN-model-on-FPGA/experiments/frontend_optimization/complete_frontend/qrs_symmetry.spice"
Xbias vbias vref vdd vss bias_gen
.ic V(xbias.iref)=0.3
.include "C:/Users/kadhi/OneDrive/Desktop/amux/verilogLearning/Leaky-Integrate-Fire---SNN-model-on-FPGA/experiments/frontend_optimization/complete_frontend/rr_timing_v6.spice"
.include "C:/Users/kadhi/OneDrive/Desktop/amux/verilogLearning/Leaky-Integrate-Fire---SNN-model-on-FPGA/experiments/frontend_optimization/complete_frontend/rpeak_detector.spice"
.include "C:/Users/kadhi/OneDrive/Desktop/amux/verilogLearning/Leaky-Integrate-Fire---SNN-model-on-FPGA/experiments/frontend_optimization/complete_frontend/delay_timer.spice"

* Analog rpeak detector
Vrpk_thresh rpeak_threshold 0 0.3281
Xrpeak ecg_l0 rpeak_threshold rpeak_raw vdd vss vbias rpeak_detector
Xpg_rpk rpeak_raw rpeak_pulse vdd vss vbias pulse_gen

* Analog delay timer
Xdelay rpeak_pulse dt_s14_lev dt_s69_lev dt_wid_lev dt_bi_lev dt_rr_copy_lev dt_sf_out vdd vss vbias 0.231510 0.457657 0.471270 0.377285 0.303178 delay_timer
Xeb_wid dt_wid_lev wid_sharp vdd vss edge_buffer
Xpg_wid wid_sharp trig_wid vdd vss vbias pulse_gen
Xeb_s69 dt_s69_lev s69_sharp vdd vss edge_buffer
Xpg_s69 s69_sharp trig_s69 vdd vss vbias pulse_gen
Xeb_bi dt_bi_lev bi_sharp vdd vss edge_buffer
Xpg_bi bi_sharp trig_bi_raw vdd vss vbias long_pulse_gen
Xeb_rrc dt_rr_copy_lev rrc_sharp vdd vss edge_buffer
Xpg_rrc rrc_sharp trig_rr_copy vdd vss vbias long_pulse_gen
Xeb_s14 dt_s14_lev s14_sharp vdd vss edge_buffer
Xpg_s14 s14_sharp trig_s14 vdd vss vbias pulse_gen

* Capture at R+5ms (ideal — in ASIC: fast-timer comparator)
Vcap_post trig_cap_post 0 PWL(0.0000000 0.000000 0.8184889 0.000000 0.8188889 0.900000 0.8208889 0.900000 0.8212889 0.000000 1.6296000 0.000000 1.6300000 0.900000 1.6320000 0.900000 1.6324000 0.000000 2.4184889 0.000000 2.4188889 0.900000 2.4208889 0.900000 2.4212889 0.000000 3.2101556 0.000000 3.2105556 0.900000 3.2125556 0.900000 3.2129556 0.000000 3.9990444 0.000000 3.9994444 0.900000 4.0014444 0.900000 4.0018444 0.000000 4.8157111 0.000000 4.8161111 0.900000 4.8181111 0.900000 4.8185111 0.000000 5.4684889 0.000000 5.4688889 0.900000 5.4708889 0.900000 5.4712889 0.000000 6.4629333 0.000000 6.4633333 0.900000 6.4653333 0.900000 6.4657333 0.000000 7.3073778 0.000000 7.3077778 0.900000 7.3097778 0.900000 7.3101778 0.000000 8.1184889 0.000000 8.1188889 0.900000 8.1208889 0.900000 8.1212889 0.000000 8.9073778 0.000000 8.9077778 0.900000 8.9097778 0.900000 8.9101778 0.000000 9.6796000 0.000000 9.6800000 0.900000 9.6820000 0.900000 9.6824000 0.000000 10.5184889 0.000000 10.5188889 0.900000 10.5208889 0.900000 10.5212889 0.000000 11.3740444 0.000000 11.3744444 0.900000 11.3764444 0.900000 11.3768444 0.000000 12.1962667 0.000000 12.1966667 0.900000 12.1986667 0.900000 12.1990667 0.000000 13.0240444 0.000000 13.0244444 0.900000 13.0264444 0.900000 13.0268444 0.000000 13.8462667 0.000000 13.8466667 0.900000 13.8486667 0.900000 13.8490667 0.000000 14.6407111 0.000000 14.6411111 0.900000 14.6431111 0.900000 14.6435111 0.000000 15.4379333 0.000000 15.4383333 0.900000 15.4403333 0.900000 15.4407333 0.000000 16.2296000 0.000000 16.2300000 0.900000 16.2320000 0.900000 16.2324000 0.000000 17.0518222 0.000000 17.0522222 0.900000 17.0542222 0.900000 17.0546222 0.000000 17.9212667 0.000000 17.9216667 0.900000 17.9236667 0.900000 17.9240667 0.000000 18.7434889 0.000000 18.7438889 0.900000 18.7458889 0.900000 18.7462889 0.000000 19.5296000 0.000000 19.5300000 0.900000 19.5320000 0.900000 19.5324000 0.000000 20.3212667 0.000000 20.3216667 0.900000 20.3236667 0.900000 20.3240667 0.000000 21.0962667 0.000000 21.0966667 0.900000 21.0986667 0.900000 21.0990667 0.000000 21.8823778 0.000000 21.8827778 0.900000 21.8847778 0.900000 21.8851778 0.000000 22.6934889 0.000000 22.6938889 0.900000 22.6958889 0.900000 22.6962889 0.000000 23.5101556 0.000000 23.5105556 0.900000 23.5125556 0.900000 23.5129556 0.000000 24.3379333 0.000000 24.3383333 0.900000 24.3403333 0.900000 24.3407333 0.000000 24.8333333 0.000000)
* Pwave still ideal
Vpwb trig_pw_base 0 PWL(0.0000000 0.000000 0.6079333 0.000000 0.6083333 0.900000 0.6088333 0.900000 0.6092333 0.000000 1.4190444 0.000000 1.4194444 0.900000 1.4199444 0.900000 1.4203444 0.000000 2.2079333 0.000000 2.2083333 0.900000 2.2088333 0.900000 2.2092333 0.000000 2.9996000 0.000000 3.0000000 0.900000 3.0005000 0.900000 3.0009000 0.000000 3.7884889 0.000000 3.7888889 0.900000 3.7893889 0.900000 3.7897889 0.000000 4.6051556 0.000000 4.6055556 0.900000 4.6060556 0.900000 4.6064556 0.000000 5.2579333 0.000000 5.2583333 0.900000 5.2588333 0.900000 5.2592333 0.000000 6.2523778 0.000000 6.2527778 0.900000 6.2532778 0.900000 6.2536778 0.000000 7.0968222 0.000000 7.0972222 0.900000 7.0977222 0.900000 7.0981222 0.000000 7.9079333 0.000000 7.9083333 0.900000 7.9088333 0.900000 7.9092333 0.000000 8.6968222 0.000000 8.6972222 0.900000 8.6977222 0.900000 8.6981222 0.000000 9.4690444 0.000000 9.4694444 0.900000 9.4699444 0.900000 9.4703444 0.000000 10.3079333 0.000000 10.3083333 0.900000 10.3088333 0.900000 10.3092333 0.000000 11.1634889 0.000000 11.1638889 0.900000 11.1643889 0.900000 11.1647889 0.000000 11.9857111 0.000000 11.9861111 0.900000 11.9866111 0.900000 11.9870111 0.000000 12.8134889 0.000000 12.8138889 0.900000 12.8143889 0.900000 12.8147889 0.000000 13.6357111 0.000000 13.6361111 0.900000 13.6366111 0.900000 13.6370111 0.000000 14.4301556 0.000000 14.4305556 0.900000 14.4310556 0.900000 14.4314556 0.000000 15.2273778 0.000000 15.2277778 0.900000 15.2282778 0.900000 15.2286778 0.000000 16.0190444 0.000000 16.0194444 0.900000 16.0199444 0.900000 16.0203444 0.000000 16.8412667 0.000000 16.8416667 0.900000 16.8421667 0.900000 16.8425667 0.000000 17.7107111 0.000000 17.7111111 0.900000 17.7116111 0.900000 17.7120111 0.000000 18.5329333 0.000000 18.5333333 0.900000 18.5338333 0.900000 18.5342333 0.000000 19.3190444 0.000000 19.3194444 0.900000 19.3199444 0.900000 19.3203444 0.000000 20.1107111 0.000000 20.1111111 0.900000 20.1116111 0.900000 20.1120111 0.000000 20.8857111 0.000000 20.8861111 0.900000 20.8866111 0.900000 20.8870111 0.000000 21.6718222 0.000000 21.6722222 0.900000 21.6727222 0.900000 21.6731222 0.000000 22.4829333 0.000000 22.4833333 0.900000 22.4838333 0.900000 22.4842333 0.000000 23.2996000 0.000000 23.3000000 0.900000 23.3005000 0.900000 23.3009000 0.000000 24.1273778 0.000000 24.1277778 0.900000 24.1282778 0.900000 24.1286778 0.000000 24.8333333 0.000000)
Vpwp trig_pw_peak 0 PWL(0.0000000 0.000000 0.6829333 0.000000 0.6833333 0.900000 0.6838333 0.900000 0.6842333 0.000000 1.4940444 0.000000 1.4944444 0.900000 1.4949444 0.900000 1.4953444 0.000000 2.2829333 0.000000 2.2833333 0.900000 2.2838333 0.900000 2.2842333 0.000000 3.0746000 0.000000 3.0750000 0.900000 3.0755000 0.900000 3.0759000 0.000000 3.8634889 0.000000 3.8638889 0.900000 3.8643889 0.900000 3.8647889 0.000000 4.6801556 0.000000 4.6805556 0.900000 4.6810556 0.900000 4.6814556 0.000000 5.3329333 0.000000 5.3333333 0.900000 5.3338333 0.900000 5.3342333 0.000000 6.3273778 0.000000 6.3277778 0.900000 6.3282778 0.900000 6.3286778 0.000000 7.1718222 0.000000 7.1722222 0.900000 7.1727222 0.900000 7.1731222 0.000000 7.9829333 0.000000 7.9833333 0.900000 7.9838333 0.900000 7.9842333 0.000000 8.7718222 0.000000 8.7722222 0.900000 8.7727222 0.900000 8.7731222 0.000000 9.5440444 0.000000 9.5444444 0.900000 9.5449444 0.900000 9.5453444 0.000000 10.3829333 0.000000 10.3833333 0.900000 10.3838333 0.900000 10.3842333 0.000000 11.2384889 0.000000 11.2388889 0.900000 11.2393889 0.900000 11.2397889 0.000000 12.0607111 0.000000 12.0611111 0.900000 12.0616111 0.900000 12.0620111 0.000000 12.8884889 0.000000 12.8888889 0.900000 12.8893889 0.900000 12.8897889 0.000000 13.7107111 0.000000 13.7111111 0.900000 13.7116111 0.900000 13.7120111 0.000000 14.5051556 0.000000 14.5055556 0.900000 14.5060556 0.900000 14.5064556 0.000000 15.3023778 0.000000 15.3027778 0.900000 15.3032778 0.900000 15.3036778 0.000000 16.0940444 0.000000 16.0944444 0.900000 16.0949444 0.900000 16.0953444 0.000000 16.9162667 0.000000 16.9166667 0.900000 16.9171667 0.900000 16.9175667 0.000000 17.7857111 0.000000 17.7861111 0.900000 17.7866111 0.900000 17.7870111 0.000000 18.6079333 0.000000 18.6083333 0.900000 18.6088333 0.900000 18.6092333 0.000000 19.3940444 0.000000 19.3944444 0.900000 19.3949444 0.900000 19.3953444 0.000000 20.1857111 0.000000 20.1861111 0.900000 20.1866111 0.900000 20.1870111 0.000000 20.9607111 0.000000 20.9611111 0.900000 20.9616111 0.900000 20.9620111 0.000000 21.7468222 0.000000 21.7472222 0.900000 21.7477222 0.900000 21.7481222 0.000000 22.5579333 0.000000 22.5583333 0.900000 22.5588333 0.900000 22.5592333 0.000000 23.3746000 0.000000 23.3750000 0.900000 23.3755000 0.900000 23.3759000 0.000000 24.2023778 0.000000 24.2027778 0.900000 24.2032778 0.900000 24.2036778 0.000000 24.8333333 0.000000)

* rr_timing_v6: hold latches at rpeak, capture copies hold at R+5ms, EWMA at R+10ms
Xrr ecg_l0 trig_cap_post rpeak_pulse trig_rr_copy f1_rr_ratio f2_rr_asym rr_timer rr_ewma vdd vss vbias rr_timing_v6
Xbi0 ecg_l0 rpeak_pulse trig_bi_raw f3_bi_l0 vdd vss vbias beat_instability
Xbi1 ecg_l1 rpeak_pulse trig_bi_raw f4_bi_l1 vdd vss vbias beat_instability
Xpw ecg_l0 trig_pw_base trig_pw_peak f5_pwave vdd vss vbias pwave_diff
Xwid ecg_l0 trig_wid f6_width vdd vss qrs_width
Xslp ecg_l0 trig_s14 trig_s69 f7_slope vdd vss vbias qrs_slope
Xsym ecg_l0 rpeak_pulse f8_symmetry vdd vss qrs_symmetry

.ic V(xrr.ewma_node)=0.390944
.ic V(xrr.esamp_node)=0.390944
.ic V(xrr.prev_node)=0.390944
.ic V(xrr.hold_node)=0.390944
.ic V(xbi0.prev_node)=0.30
.ic V(xbi0.esamp_node)=0.30
.ic V(xbi1.prev_node)=0.30
.ic V(xbi1.esamp_node)=0.30

.tran 0.5m 24.8333
.meas tran f1_5 FIND V(f1_rr_ratio) AT=4.8011111
.meas tran f2_5 FIND V(f2_rr_asym) AT=5.3988889
.meas tran f3_5 FIND V(f3_bi_l0) AT=4.9111111
.meas tran f4_5 FIND V(f4_bi_l1) AT=4.9111111
.meas tran f5_5 FIND V(f5_pwave) AT=4.9111111
.meas tran f6_5 FIND V(f6_width) AT=4.9111111
.meas tran f7_5 FIND V(f7_slope) AT=4.9111111
.meas tran f8_5 FIND V(f8_symmetry) AT=4.9111111
.meas tran f1_6 FIND V(f1_rr_ratio) AT=5.4538889
.meas tran f2_6 FIND V(f2_rr_asym) AT=6.3933333
.meas tran f3_6 FIND V(f3_bi_l0) AT=5.5638889
.meas tran f4_6 FIND V(f4_bi_l1) AT=5.5638889
.meas tran f5_6 FIND V(f5_pwave) AT=5.5638889
.meas tran f6_6 FIND V(f6_width) AT=5.5638889
.meas tran f7_6 FIND V(f7_slope) AT=5.5638889
.meas tran f8_6 FIND V(f8_symmetry) AT=5.5638889
.meas tran f1_7 FIND V(f1_rr_ratio) AT=6.4483333
.meas tran f2_7 FIND V(f2_rr_asym) AT=7.2377778
.meas tran f3_7 FIND V(f3_bi_l0) AT=6.5583333
.meas tran f4_7 FIND V(f4_bi_l1) AT=6.5583333
.meas tran f5_7 FIND V(f5_pwave) AT=6.5583333
.meas tran f6_7 FIND V(f6_width) AT=6.5583333
.meas tran f7_7 FIND V(f7_slope) AT=6.5583333
.meas tran f8_7 FIND V(f8_symmetry) AT=6.5583333
.meas tran f1_8 FIND V(f1_rr_ratio) AT=7.2927778
.meas tran f2_8 FIND V(f2_rr_asym) AT=8.0488889
.meas tran f3_8 FIND V(f3_bi_l0) AT=7.4027778
.meas tran f4_8 FIND V(f4_bi_l1) AT=7.4027778
.meas tran f5_8 FIND V(f5_pwave) AT=7.4027778
.meas tran f6_8 FIND V(f6_width) AT=7.4027778
.meas tran f7_8 FIND V(f7_slope) AT=7.4027778
.meas tran f8_8 FIND V(f8_symmetry) AT=7.4027778
.meas tran f1_9 FIND V(f1_rr_ratio) AT=8.1038889
.meas tran f2_9 FIND V(f2_rr_asym) AT=8.8377778
.meas tran f3_9 FIND V(f3_bi_l0) AT=8.2138889
.meas tran f4_9 FIND V(f4_bi_l1) AT=8.2138889
.meas tran f5_9 FIND V(f5_pwave) AT=8.2138889
.meas tran f6_9 FIND V(f6_width) AT=8.2138889
.meas tran f7_9 FIND V(f7_slope) AT=8.2138889
.meas tran f8_9 FIND V(f8_symmetry) AT=8.2138889
.meas tran f1_10 FIND V(f1_rr_ratio) AT=8.8927778
.meas tran f2_10 FIND V(f2_rr_asym) AT=9.6100000
.meas tran f3_10 FIND V(f3_bi_l0) AT=9.0027778
.meas tran f4_10 FIND V(f4_bi_l1) AT=9.0027778
.meas tran f5_10 FIND V(f5_pwave) AT=9.0027778
.meas tran f6_10 FIND V(f6_width) AT=9.0027778
.meas tran f7_10 FIND V(f7_slope) AT=9.0027778
.meas tran f8_10 FIND V(f8_symmetry) AT=9.0027778
.meas tran f1_11 FIND V(f1_rr_ratio) AT=9.6650000
.meas tran f2_11 FIND V(f2_rr_asym) AT=10.4488889
.meas tran f3_11 FIND V(f3_bi_l0) AT=9.7750000
.meas tran f4_11 FIND V(f4_bi_l1) AT=9.7750000
.meas tran f5_11 FIND V(f5_pwave) AT=9.7750000
.meas tran f6_11 FIND V(f6_width) AT=9.7750000
.meas tran f7_11 FIND V(f7_slope) AT=9.7750000
.meas tran f8_11 FIND V(f8_symmetry) AT=9.7750000
.meas tran f1_12 FIND V(f1_rr_ratio) AT=10.5038889
.meas tran f2_12 FIND V(f2_rr_asym) AT=11.3044444
.meas tran f3_12 FIND V(f3_bi_l0) AT=10.6138889
.meas tran f4_12 FIND V(f4_bi_l1) AT=10.6138889
.meas tran f5_12 FIND V(f5_pwave) AT=10.6138889
.meas tran f6_12 FIND V(f6_width) AT=10.6138889
.meas tran f7_12 FIND V(f7_slope) AT=10.6138889
.meas tran f8_12 FIND V(f8_symmetry) AT=10.6138889
.meas tran f1_13 FIND V(f1_rr_ratio) AT=11.3594444
.meas tran f2_13 FIND V(f2_rr_asym) AT=12.1266667
.meas tran f3_13 FIND V(f3_bi_l0) AT=11.4694444
.meas tran f4_13 FIND V(f4_bi_l1) AT=11.4694444
.meas tran f5_13 FIND V(f5_pwave) AT=11.4694444
.meas tran f6_13 FIND V(f6_width) AT=11.4694444
.meas tran f7_13 FIND V(f7_slope) AT=11.4694444
.meas tran f8_13 FIND V(f8_symmetry) AT=11.4694444
.meas tran f1_14 FIND V(f1_rr_ratio) AT=12.1816667
.meas tran f2_14 FIND V(f2_rr_asym) AT=12.9544444
.meas tran f3_14 FIND V(f3_bi_l0) AT=12.2916667
.meas tran f4_14 FIND V(f4_bi_l1) AT=12.2916667
.meas tran f5_14 FIND V(f5_pwave) AT=12.2916667
.meas tran f6_14 FIND V(f6_width) AT=12.2916667
.meas tran f7_14 FIND V(f7_slope) AT=12.2916667
.meas tran f8_14 FIND V(f8_symmetry) AT=12.2916667
.meas tran f1_15 FIND V(f1_rr_ratio) AT=13.0094444
.meas tran f2_15 FIND V(f2_rr_asym) AT=13.7766667
.meas tran f3_15 FIND V(f3_bi_l0) AT=13.1194444
.meas tran f4_15 FIND V(f4_bi_l1) AT=13.1194444
.meas tran f5_15 FIND V(f5_pwave) AT=13.1194444
.meas tran f6_15 FIND V(f6_width) AT=13.1194444
.meas tran f7_15 FIND V(f7_slope) AT=13.1194444
.meas tran f8_15 FIND V(f8_symmetry) AT=13.1194444
.meas tran f1_16 FIND V(f1_rr_ratio) AT=13.8316667
.meas tran f2_16 FIND V(f2_rr_asym) AT=14.5711111
.meas tran f3_16 FIND V(f3_bi_l0) AT=13.9416667
.meas tran f4_16 FIND V(f4_bi_l1) AT=13.9416667
.meas tran f5_16 FIND V(f5_pwave) AT=13.9416667
.meas tran f6_16 FIND V(f6_width) AT=13.9416667
.meas tran f7_16 FIND V(f7_slope) AT=13.9416667
.meas tran f8_16 FIND V(f8_symmetry) AT=13.9416667
.meas tran f1_17 FIND V(f1_rr_ratio) AT=14.6261111
.meas tran f2_17 FIND V(f2_rr_asym) AT=15.3683333
.meas tran f3_17 FIND V(f3_bi_l0) AT=14.7361111
.meas tran f4_17 FIND V(f4_bi_l1) AT=14.7361111
.meas tran f5_17 FIND V(f5_pwave) AT=14.7361111
.meas tran f6_17 FIND V(f6_width) AT=14.7361111
.meas tran f7_17 FIND V(f7_slope) AT=14.7361111
.meas tran f8_17 FIND V(f8_symmetry) AT=14.7361111
.meas tran f1_18 FIND V(f1_rr_ratio) AT=15.4233333
.meas tran f2_18 FIND V(f2_rr_asym) AT=16.1600000
.meas tran f3_18 FIND V(f3_bi_l0) AT=15.5333333
.meas tran f4_18 FIND V(f4_bi_l1) AT=15.5333333
.meas tran f5_18 FIND V(f5_pwave) AT=15.5333333
.meas tran f6_18 FIND V(f6_width) AT=15.5333333
.meas tran f7_18 FIND V(f7_slope) AT=15.5333333
.meas tran f8_18 FIND V(f8_symmetry) AT=15.5333333
.meas tran f1_19 FIND V(f1_rr_ratio) AT=16.2150000
.meas tran f2_19 FIND V(f2_rr_asym) AT=16.9822222
.meas tran f3_19 FIND V(f3_bi_l0) AT=16.3250000
.meas tran f4_19 FIND V(f4_bi_l1) AT=16.3250000
.meas tran f5_19 FIND V(f5_pwave) AT=16.3250000
.meas tran f6_19 FIND V(f6_width) AT=16.3250000
.meas tran f7_19 FIND V(f7_slope) AT=16.3250000
.meas tran f8_19 FIND V(f8_symmetry) AT=16.3250000
.meas tran f1_20 FIND V(f1_rr_ratio) AT=17.0372222
.meas tran f2_20 FIND V(f2_rr_asym) AT=17.8516667
.meas tran f3_20 FIND V(f3_bi_l0) AT=17.1472222
.meas tran f4_20 FIND V(f4_bi_l1) AT=17.1472222
.meas tran f5_20 FIND V(f5_pwave) AT=17.1472222
.meas tran f6_20 FIND V(f6_width) AT=17.1472222
.meas tran f7_20 FIND V(f7_slope) AT=17.1472222
.meas tran f8_20 FIND V(f8_symmetry) AT=17.1472222
.meas tran f1_21 FIND V(f1_rr_ratio) AT=17.9066667
.meas tran f2_21 FIND V(f2_rr_asym) AT=18.6738889
.meas tran f3_21 FIND V(f3_bi_l0) AT=18.0166667
.meas tran f4_21 FIND V(f4_bi_l1) AT=18.0166667
.meas tran f5_21 FIND V(f5_pwave) AT=18.0166667
.meas tran f6_21 FIND V(f6_width) AT=18.0166667
.meas tran f7_21 FIND V(f7_slope) AT=18.0166667
.meas tran f8_21 FIND V(f8_symmetry) AT=18.0166667
.meas tran f1_22 FIND V(f1_rr_ratio) AT=18.7288889
.meas tran f2_22 FIND V(f2_rr_asym) AT=19.4600000
.meas tran f3_22 FIND V(f3_bi_l0) AT=18.8388889
.meas tran f4_22 FIND V(f4_bi_l1) AT=18.8388889
.meas tran f5_22 FIND V(f5_pwave) AT=18.8388889
.meas tran f6_22 FIND V(f6_width) AT=18.8388889
.meas tran f7_22 FIND V(f7_slope) AT=18.8388889
.meas tran f8_22 FIND V(f8_symmetry) AT=18.8388889
.meas tran f1_23 FIND V(f1_rr_ratio) AT=19.5150000
.meas tran f2_23 FIND V(f2_rr_asym) AT=20.2516667
.meas tran f3_23 FIND V(f3_bi_l0) AT=19.6250000
.meas tran f4_23 FIND V(f4_bi_l1) AT=19.6250000
.meas tran f5_23 FIND V(f5_pwave) AT=19.6250000
.meas tran f6_23 FIND V(f6_width) AT=19.6250000
.meas tran f7_23 FIND V(f7_slope) AT=19.6250000
.meas tran f8_23 FIND V(f8_symmetry) AT=19.6250000
.meas tran f1_24 FIND V(f1_rr_ratio) AT=20.3066667
.meas tran f2_24 FIND V(f2_rr_asym) AT=21.0266667
.meas tran f3_24 FIND V(f3_bi_l0) AT=20.4166667
.meas tran f4_24 FIND V(f4_bi_l1) AT=20.4166667
.meas tran f5_24 FIND V(f5_pwave) AT=20.4166667
.meas tran f6_24 FIND V(f6_width) AT=20.4166667
.meas tran f7_24 FIND V(f7_slope) AT=20.4166667
.meas tran f8_24 FIND V(f8_symmetry) AT=20.4166667
.meas tran f1_25 FIND V(f1_rr_ratio) AT=21.0816667
.meas tran f2_25 FIND V(f2_rr_asym) AT=21.8127778
.meas tran f3_25 FIND V(f3_bi_l0) AT=21.1916667
.meas tran f4_25 FIND V(f4_bi_l1) AT=21.1916667
.meas tran f5_25 FIND V(f5_pwave) AT=21.1916667
.meas tran f6_25 FIND V(f6_width) AT=21.1916667
.meas tran f7_25 FIND V(f7_slope) AT=21.1916667
.meas tran f8_25 FIND V(f8_symmetry) AT=21.1916667
.meas tran f1_26 FIND V(f1_rr_ratio) AT=21.8677778
.meas tran f2_26 FIND V(f2_rr_asym) AT=22.6238889
.meas tran f3_26 FIND V(f3_bi_l0) AT=21.9777778
.meas tran f4_26 FIND V(f4_bi_l1) AT=21.9777778
.meas tran f5_26 FIND V(f5_pwave) AT=21.9777778
.meas tran f6_26 FIND V(f6_width) AT=21.9777778
.meas tran f7_26 FIND V(f7_slope) AT=21.9777778
.meas tran f8_26 FIND V(f8_symmetry) AT=21.9777778
.meas tran f1_27 FIND V(f1_rr_ratio) AT=22.6788889
.meas tran f2_27 FIND V(f2_rr_asym) AT=23.4405556
.meas tran f3_27 FIND V(f3_bi_l0) AT=22.7888889
.meas tran f4_27 FIND V(f4_bi_l1) AT=22.7888889
.meas tran f5_27 FIND V(f5_pwave) AT=22.7888889
.meas tran f6_27 FIND V(f6_width) AT=22.7888889
.meas tran f7_27 FIND V(f7_slope) AT=22.7888889
.meas tran f8_27 FIND V(f8_symmetry) AT=22.7888889
.meas tran f1_28 FIND V(f1_rr_ratio) AT=23.4955556
.meas tran f2_28 FIND V(f2_rr_asym) AT=24.2683333
.meas tran f3_28 FIND V(f3_bi_l0) AT=23.6055556
.meas tran f4_28 FIND V(f4_bi_l1) AT=23.6055556
.meas tran f5_28 FIND V(f5_pwave) AT=23.6055556
.meas tran f6_28 FIND V(f6_width) AT=23.6055556
.meas tran f7_28 FIND V(f7_slope) AT=23.6055556
.meas tran f8_28 FIND V(f8_symmetry) AT=23.6055556
.meas tran f1_29 FIND V(f1_rr_ratio) AT=24.3233333
.meas tran f3_29 FIND V(f3_bi_l0) AT=24.4333333
.meas tran f4_29 FIND V(f4_bi_l1) AT=24.4333333
.meas tran f5_29 FIND V(f5_pwave) AT=24.4333333
.meas tran f6_29 FIND V(f6_width) AT=24.4333333
.meas tran f7_29 FIND V(f7_slope) AT=24.4333333
.meas tran f8_29 FIND V(f8_symmetry) AT=24.4333333

.end
