* ============================================================
* FEATURES 3 & 4: Beat-to-beat Amplitude Instability — v11 (hybrid loads)
*
* Captures ECG at R-peak, compares with previous via charge-share.
* Hybrid mirror+diode loads for ~3-5x gain.
* v9 diode-only had F3 rho=0.895 on rec 231 (below 0.90 threshold)
* and F3 span=221mV (below 225mV threshold).
* v11 uses F5-proven mirror+diode topology.
*
* Triggers: capture_trig (at R-peak), copy_trig (R+300ms)
* One instance per lead (L0 and L1).
*
* Pin: ecg_in capture_trig copy_trig instab_out vdd vss vbias
* ============================================================

.subckt beat_instability ecg_in capture_trig copy_trig instab_out vdd vss vbias

* === CURRENT PEAK CAPTURE ===
XMcurr ecg_in capture_trig curr_node vss sky130_fd_pr__nfet_01v8 L=0.5 W=2 nf=1
XCcurr curr_node vss sky130_fd_pr__cap_mim_m3_1 W=50 L=50

* === EWMA SAMPLE (for prev update) ===
XMesamp ecg_in capture_trig esamp_node vss sky130_fd_pr__nfet_01v8 L=0.5 W=2 nf=1
XCesamp esamp_node vss sky130_fd_pr__cap_mim_m3_1 W=150 L=150

* === PREV UPDATE at copy_trig ===
XMcopy esamp_node copy_trig prev_node vss sky130_fd_pr__nfet_01v8 L=0.5 W=2 nf=1
XCprev prev_node vss sky130_fd_pr__cap_mim_m3_1 W=50 L=50

* === DIFF PAIR: instability output (hybrid mirror+diode loads) ===
XMi_tail tail_i vbias vss vss sky130_fd_pr__nfet_01v8 L=8 W=0.42 nf=1
XMi1 net_i1 curr_node tail_i vss sky130_fd_pr__nfet_01v8 L=1 W=8 nf=1
XMi2 instab_out prev_node tail_i vss sky130_fd_pr__nfet_01v8 L=1 W=8 nf=1
* Reference side: diode
XMi3 net_i1 net_i1 vdd vdd sky130_fd_pr__pfet_01v8 L=4 W=4 nf=1
* Output side: mirror + parallel diode (gain ~3-5x, prevents bistability)
XMi4_mir instab_out net_i1 vdd vdd sky130_fd_pr__pfet_01v8 L=4 W=4 nf=1
XMi4_dg instab_out instab_out vdd vdd sky130_fd_pr__pfet_01v8 L=4 W=2 nf=1

.ends beat_instability
