.title delay_timer
.lib "C:/Users/kadhi/OneDrive/Desktop/amux/verilogLearning/Leaky-Integrate-Fire---SNN-model-on-FPGA/experiments/frontend_optimization/ngspice_frontend/sky130_minimal.lib.spice" tt
.option scale=1.0u method=gear reltol=0.01 gmin=1e-15
.temp 27
Vdd vdd 0 0.9
Vss vss 0 0
Vbias vbias 0 0.300

.include "C:/Users/kadhi/OneDrive/Desktop/amux/verilogLearning/Leaky-Integrate-Fire---SNN-model-on-FPGA/experiments/frontend_optimization/complete_frontend/inverter.spice"
.include "C:/Users/kadhi/OneDrive/Desktop/amux/verilogLearning/Leaky-Integrate-Fire---SNN-model-on-FPGA/experiments/frontend_optimization/complete_frontend/delay_timer.spice"

* rpeak pulse at t=10ms (0.5ms wide)
Vrpk rpeak_pulse 0 PWL(0 0 9.5e-3 0 10.0e-3 0.9 10.5e-3 0.9 11.0e-3 0)

* Threshold voltage sources
Vth14 vth_14_node 0 0.230855
Vth69 vth_69_node 0 0.449968
Vth28 vth_28_node 0 0.471410
Vth300 vth_300_node 0 0.332438
Vth10 vth_10_node 0 0.300430

Xdt rpeak_pulse trig_s14 trig_s69 trig_wid trig_bi_copy trig_rr_copy sf_out vdd vss vbias vth_14_node vth_69_node vth_28_node vth_300_node vth_10_node delay_timer

.tran 0.5m 500m

* Measure when each trigger fires (crosses 0.45V going HIGH)
.meas tran dt_s14 WHEN V(trig_s14)=0.45 RISE=1 TD=10e-3
.meas tran dt_s69 WHEN V(trig_s69)=0.45 RISE=1 TD=10e-3
.meas tran dt_wid WHEN V(trig_wid)=0.45 RISE=1 TD=10e-3
.meas tran dt_bi  WHEN V(trig_bi_copy)=0.45 RISE=1 TD=10e-3
.meas tran dt_rr  WHEN V(trig_rr_copy)=0.45 RISE=1 TD=10e-3

* Also measure SF voltage at key times
.meas tran sf_at_0 FIND V(sf_out) AT=10.5e-3
.meas tran sf_at_14 FIND V(sf_out) AT=24.0e-3
.meas tran sf_at_69 FIND V(sf_out) AT=79.0e-3
.meas tran sf_at_300 FIND V(sf_out) AT=310.0e-3

.end
