Integration test v2 - trigger chain + features
.lib "C:\Users\kadhi\OneDrive\Desktop\amux\verilogLearning\Leaky-Integrate-Fire---SNN-model-on-FPGA\experiments\frontend_optimization\ngspice_frontend\sky130_minimal.lib.spice" tt
.option scale=1.0u method=gear gmin=1e-15
.temp 27

.include "bias_gen.spice"
.include "rpeak_detector.spice"
.include "inverter.spice"
.include "delay_timer.spice"
.include "rr_timing.spice"
.include "pwave_predictor.spice"
.include "beat_instability.spice"
.include "pwave_diff.spice"
.include "qrs_width.spice"
.include "qrs_slope.spice"
.include "qrs_symmetry.spice"

Vdd vdd 0 0.9
Vss vss 0 0

* Bias generator
Xbias vbias vref vdd vss bias_gen
.ic v(xbias.vbias) = 0.3
.ic v(xbias.vref) = 0.3

* Amplified ECG (bypassing IA - IA validated independently)
Vecg_l0 ecg_amp_l0 0 PWL(
+ 0.000000 0.250130
+ 0.002778 0.208366
+ 0.005556 0.359796
+ 0.008333 0.250130
+ 0.011111 0.199585
+ 0.013889 0.359791
+ 0.016667 0.250130
+ 0.019444 0.203325
+ 0.022222 0.359761
+ 0.025000 0.256395
+ 0.027778 0.208390
+ 0.030556 0.359810
+ 0.033333 0.248877
+ 0.036111 0.205850
+ 0.038889 0.359801
+ 0.041667 0.255142
+ 0.044444 0.205860
+ 0.047222 0.359786
+ 0.050000 0.250130
+ 0.052778 0.205865
+ 0.055556 0.359786
+ 0.058333 0.246371
+ 0.061111 0.199580
+ 0.063889 0.359786
+ 0.066667 0.248877
+ 0.069444 0.203334
+ 0.072222 0.359776
+ 0.075000 0.247624
+ 0.077778 0.207103
+ 0.080556 0.359791
+ 0.083333 0.246371
+ 0.086111 0.205835
+ 0.088889 0.359801
+ 0.091667 0.246371
+ 0.094444 0.210862
+ 0.097222 0.359801
+ 0.100000 0.247624
+ 0.102778 0.205855
+ 0.105556 0.359801
+ 0.108333 0.242612
+ 0.111111 0.205826
+ 0.113889 0.359791
+ 0.116667 0.250130
+ 0.119444 0.202081
+ 0.122222 0.359776
+ 0.125000 0.243865
+ 0.127778 0.207088
+ 0.130556 0.359791
+ 0.133333 0.241359
+ 0.136111 0.203290
+ 0.138889 0.359786
+ 0.141667 0.242612
+ 0.144444 0.205826
+ 0.147222 0.359791
+ 0.150000 0.243865
+ 0.152778 0.209589
+ 0.155556 0.359805
+ 0.158333 0.238853
+ 0.161111 0.205806
+ 0.163889 0.359786
+ 0.166667 0.243865
+ 0.169444 0.208332
+ 0.172222 0.359791
+ 0.175000 0.246371
+ 0.177778 0.209594
+ 0.180556 0.359815
+ 0.183333 0.238853
+ 0.186111 0.218336
+ 0.188889 0.359845
+ 0.191667 0.246371
+ 0.194444 0.222129
+ 0.197222 0.359845
+ 0.200000 0.250130
+ 0.202778 0.229671
+ 0.205556 0.359894
+ 0.208333 0.251383
+ 0.211111 0.229667
+ 0.213889 0.359894
+ 0.216667 0.256395
+ 0.219444 0.225913
+ 0.222222 0.359859
+ 0.225000 0.253889
+ 0.227778 0.232187
+ 0.230556 0.359874
+ 0.233333 0.252636
+ 0.236111 0.220901
+ 0.238889 0.359854
+ 0.241667 0.250130
+ 0.244444 0.228394
+ 0.247222 0.359864
+ 0.250000 0.247624
+ 0.252778 0.217137
+ 0.255556 0.359830
+ 0.258333 0.246371
+ 0.261111 0.204553
+ 0.263889 0.359786
+ 0.266667 0.243865
+ 0.269444 0.203320
+ 0.272222 0.359781
+ 0.275000 0.242612
+ 0.277778 0.202062
+ 0.280556 0.359776
+ 0.283333 0.238853
+ 0.286111 0.194519
+ 0.288889 0.359752
+ 0.291667 0.241359
+ 0.294444 0.195782
+ 0.297222 0.359737
+ 0.300000 0.240106
+ 0.302778 0.197045
+ 0.305556 0.359757
+ 0.308333 0.231336
+ 0.311111 0.185709
+ 0.313889 0.359698
+ 0.316667 0.216300
+ 0.319444 0.165608
+ 0.322222 0.359585
+ 0.325000 0.266419
+ 0.327778 0.190966
+ 0.330556 0.379892
+ 0.333333 0.334158
+ 0.336111 0.350379
+ 0.338889 0.380666
+ 0.341667 0.431896
+ 0.344444 0.196443
+ 0.347222 0.360916
+ 0.350000 0.213799
+ 0.352778 0.278318
+ 0.355556 0.359864
+ 0.358333 0.211288
+ 0.361111 0.158124
+ 0.363889 0.359619
+ 0.366667 0.228830
+ 0.369444 0.183208
+ 0.372222 0.359703
+ 0.375000 0.228830
+ 0.377778 0.193252
+ 0.380556 0.359742
+ 0.383333 0.228830
+ 0.386111 0.189473
+ 0.388889 0.359732
+ 0.391667 0.230083
+ 0.394444 0.185729
+ 0.397222 0.359703
+ 0.400000 0.232589
+ 0.402778 0.188240
+ 0.405556 0.359722
+ 0.408333 0.230083
+ 0.411111 0.185724
+ 0.413889 0.359727
+ 0.416667 0.235095
+ 0.419444 0.189498
+ 0.422222 0.359708
+ 0.425000 0.232589
+ 0.427778 0.186992
+ 0.430556 0.359717
+ 0.433333 0.231336
+ 0.436111 0.186987
+ 0.438889 0.359722
+ 0.441667 0.236348
+ 0.444444 0.188250
+ 0.447222 0.359712
+ 0.450000 0.233842
+ 0.452778 0.189522
+ 0.455556 0.359722
+ 0.458333 0.235095
+ 0.461111 0.188235
+ 0.463889 0.359722
+ 0.466667 0.235095
+ 0.469444 0.188240
+ 0.472222 0.359698
+ 0.475000 0.231336
+ 0.477778 0.188250
+ 0.480556 0.359722
+ 0.483333 0.228830
+ 0.486111 0.186977
+ 0.488889 0.359722
+ 0.491667 0.226324
+ 0.494444 0.189473
+ 0.497222 0.359727
+ 0.500000 0.227577
+ 0.502778 0.194510
+ 0.505556 0.359737
+ 0.508333 0.227577
+ 0.511111 0.188206
+ 0.513889 0.359747
+ 0.516667 0.231336
+ 0.519444 0.194490
+ 0.522222 0.359722
+ 0.525000 0.220059
+ 0.527778 0.191955
+ 0.530556 0.359722
+ 0.533333 0.213794
+ 0.536111 0.180639
+ 0.538889 0.359703
+ 0.541667 0.207529
+ 0.544444 0.179376
+ 0.547222 0.359668
+ 0.550000 0.201264
+ 0.552778 0.173082
+ 0.555556 0.359654
+ 0.558333 0.194999
+ 0.561111 0.170551
+ 0.563889 0.359668
+ 0.566667 0.197505
+ 0.569444 0.170551
+ 0.572222 0.359654
+ 0.575000 0.200011
+ 0.577778 0.180619
+ 0.580556 0.359693
+ 0.583333 0.208782
+ 0.586111 0.185651
+ 0.588889 0.359722
+ 0.591667 0.225071
+ 0.594444 0.193232
+ 0.597222 0.359752
+ 0.600000 0.236348
+ 0.602778 0.207074
+ 0.605556 0.359801
+ 0.608333 0.240106
+ 0.611111 0.210828
+ 0.613889 0.359820
+ 0.616667 0.250130
+ 0.619444 0.215869
+ 0.622222 0.359835
+ 0.625000 0.247624
+ 0.627778 0.219643
+ 0.630556 0.359845
+ 0.633333 0.248877
+ 0.636111 0.218375
+ 0.638889 0.359835
+ 0.641667 0.247624
+ 0.644444 0.214621
+ 0.647222 0.359825
+ 0.650000 0.252636
+ 0.652778 0.218390
+ 0.655556 0.359835
+ 0.658333 0.246371
+ 0.661111 0.214611
+ 0.663889 0.359825
+ 0.666667 0.250130
+ 0.669444 0.213363
+ 0.672222 0.359815
+ 0.675000 0.246371
+ 0.677778 0.215869
+ 0.680556 0.359830
+ 0.683333 0.243865
+ 0.686111 0.214597
+ 0.688889 0.359825
+ 0.691667 0.246371
+ 0.694444 0.214597
+ 0.697222 0.359801
+ 0.700000 0.242612
+ 0.702778 0.212095
+ 0.705556 0.359805
+ 0.708333 0.242612
+ 0.711111 0.207059
+ 0.713889 0.359805
+ 0.716667 0.245118
+ 0.719444 0.209585
+ 0.722222 0.359796
+ 0.725000 0.246371
+ 0.727778 0.213363
+ 0.730556 0.359815
+ 0.733333 0.240106
+ 0.736111 0.208322
+ 0.738889 0.359810
+ 0.741667 0.241359
+ 0.744444 0.205821
+ 0.747222 0.359796
+ 0.750000 0.241359
+ 0.752778 0.209589
+ 0.755556 0.359801
+ 0.758333 0.241359
+ 0.761111 0.203310
+ 0.763889 0.359805
+ 0.766667 0.245118
+ 0.769444 0.207074
+ 0.772222 0.359786
+ 0.775000 0.246371
+ 0.777778 0.209589
+ 0.780556 0.359801
+ 0.783333 0.240106
+ 0.786111 0.208322
+ 0.788889 0.359796
+ 0.791667 0.246371
+ 0.794444 0.207084
+ 0.797222 0.359796
+ 0.800000 0.246371
+ 0.802778 0.210857
+ 0.805556 0.359805
+ 0.808333 0.245118
+ 0.811111 0.208336
+ 0.813889 0.359820
+ 0.816667 0.245118
+ 0.819444 0.222129
+ 0.822222 0.359845
+ 0.825000 0.250130
+ 0.827778 0.224664
+ 0.830556 0.359874
+ 0.833333 0.248877
+ 0.836111 0.229657
+ 0.838889 0.359889
+ 0.841667 0.256395
+ 0.844444 0.232173
+ 0.847222 0.359884
+ 0.850000 0.258901
+ 0.852778 0.233465
+ 0.855556 0.359889
+ 0.858333 0.261407
+ 0.861111 0.227190
+ 0.863889 0.359864
+ 0.866667 0.262660
+ 0.869444 0.234698
+ 0.872222 0.359903
+ 0.875000 0.253889
+ 0.877778 0.223416
+ 0.880556 0.359849
+ 0.883333 0.250130
+ 0.886111 0.207088
+ 0.888889 0.359801
+ 0.891667 0.251383
+ 0.894444 0.202086
+ 0.897222 0.359766
+ 0.900000 0.251383
+ 0.902778 0.208351
+ 0.905556 0.359791
+ 0.908333 0.241359
+ 0.911111 0.203310
+ 0.913889 0.359786
+ 0.916667 0.247624
+ 0.919444 0.203325
+ 0.922222 0.359766
+ 0.925000 0.245118
+ 0.927778 0.205850
+ 0.930556 0.359771
+ 0.933333 0.243865
+ 0.936111 0.197050
+ 0.938889 0.359766
+ 0.941667 0.236348
+ 0.944444 0.189483
+ 0.947222 0.359688
+ 0.950000 0.213794
+ 0.952778 0.163112
+ 0.955556 0.359595
+ 0.958333 0.281455
+ 0.961111 0.192292
+ 0.963889 0.379941
+ 0.966667 0.381772
+ 0.969444 0.384385
+ 0.972222 0.380778
+ 0.975000 0.425631
+ 0.977778 0.182489
+ 0.980556 0.360711
+ 0.983333 0.211293
+ 0.986111 0.183194
+ 0.988889 0.359629
+ 0.991667 0.236348
+ 0.994444 0.187021
+ 0.997222 0.359737
+ 1.000000 0.235095
+ 1.002778 0.195772
+ 1.005556 0.359757
+ 1.008333 0.231336
+ 1.011111 0.186987
+ 1.013889 0.359737
+ 1.016667 0.237600
+ 1.019444 0.191999
+ 1.022222 0.359722
+ 1.025000 0.237600
+ 1.027778 0.194529
+ 1.030556 0.359732
+ 1.033333 0.237600
+ 1.036111 0.195768
+ 1.038889 0.359757
+ 1.041667 0.241359
+ 1.044444 0.195782
+ 1.047222 0.359752
+ 1.050000 0.238853
+ 1.052778 0.195802
+ 1.055556 0.359752
+ 1.058333 0.237600
+ 1.061111 0.197025
+ 1.063889 0.359742
+ 1.066667 0.240106
+ 1.069444 0.194524
+ 1.072222 0.359742
+ 1.075000 0.241359
+ 1.077778 0.195792
+ 1.080556 0.359757
+ 1.083333 0.236348
+ 1.086111 0.194519
+ 1.088889 0.359737
+ 1.091667 0.238853
+ 1.094444 0.194529
+ 1.097222 0.359742
+ 1.100000 0.235095
+ 1.102778 0.197035
+ 1.105556 0.359747
+ 1.108333 0.237600
+ 1.111111 0.197016
+ 1.113889 0.359761
+ 1.116667 0.236348
+ 1.119444 0.197016
+ 1.122222 0.359732
+ 1.125000 0.235095
+ 1.127778 0.195768
+ 1.130556 0.359752
+ 1.133333 0.227577
+ 1.136111 0.193232
+ 1.138889 0.359757
+ 1.141667 0.225071
+ 1.144444 0.191955
+ 1.147222 0.359717
+ 1.150000 0.217553
+ 1.152778 0.195704
+ 1.155556 0.359747
+ 1.158333 0.212541
+ 1.161111 0.189395
+ 1.163889 0.359742
+ 1.166667 0.207529
+ 1.169444 0.191901
+ 1.172222 0.359727
+ 1.175000 0.206276
+ 1.177778 0.193169
+ 1.180556 0.359742
+ 1.183333 0.202517
+ 1.186111 0.189385
+ 1.188889 0.359732
+ 1.191667 0.216300
+ 1.194444 0.193198
+ 1.197222 0.359742
+ 1.200000 0.227577
+ 1.202778 0.205791
+ 1.205556 0.359801
+ 1.208333 0.240106
+ 1.211111 0.212095
+ 1.213889 0.359830
+ 1.216667 0.250130
+ 1.219444 0.217122
+ 1.222222 0.359830
+ 1.225000 0.250130
+ 1.227778 0.222144
+ 1.230556 0.359859
+ 1.233333 0.251383
+ 1.236111 0.224655
+ 1.238889 0.359864
+ 1.241667 0.255142
+ 1.244444 0.225917
+ 1.247222 0.359854
+ 1.250000 0.255142
+ 1.252778 0.227185
+ 1.255556 0.359864
+ 1.258333 0.253889
+ 1.261111 0.222144
+ 1.263889 0.359864
+ 1.266667 0.256395
+ 1.269444 0.220905
+ 1.272222 0.359840
+ 1.275000 0.252636
+ 1.277778 0.223411
+ 1.280556 0.359864
+ 1.283333 0.251383
+ 1.286111 0.220886
+ 1.288889 0.359854
+ 1.291667 0.252636
+ 1.294444 0.219628
+ 1.297222 0.359830
+ 1.300000 0.251383
+ 1.302778 0.220896
+ 1.305556 0.359840
+ 1.308333 0.245118
+ 1.311111 0.213353
+ 1.313889 0.359840
+ 1.316667 0.250130
+ 1.319444 0.214616
+ 1.322222 0.359805
+ 1.325000 0.247624
+ 1.327778 0.215869
+ 1.330556 0.359815
+ 1.333333 0.243865
+ 1.336111 0.210828
+ 1.338889 0.359830
+ 1.341667 0.248877
+ 1.344444 0.210842
+ 1.347222 0.359810
+ 1.350000 0.243865
+ 1.352778 0.213358
+ 1.355556 0.359810
+ 1.358333 0.243865
+ 1.361111 0.209589
+ 1.363889 0.359815
+ 1.366667 0.248877
+ 1.369444 0.210857
+ 1.372222 0.359805
+ 1.375000 0.250130
+ 1.377778 0.214621
+ 1.380556 0.359825
+ 1.383333 0.245118
+ 1.386111 0.210847
+ 1.388889 0.359830
+ 1.391667 0.248877
+ 1.394444 0.212105
+ 1.397222 0.359815
+ 1.400000 0.248877
+ 1.402778 0.217147
+ 1.405556 0.359830
+ 1.408333 0.247624
+ 1.411111 0.212105
+ 1.413889 0.359830
+ 1.416667 0.255142
+ 1.419444 0.215884
+ 1.422222 0.359810
+ 1.425000 0.250130
+ 1.427778 0.218385
+ 1.430556 0.359840
+ 1.433333 0.246371
+ 1.436111 0.225878
+ 1.438889 0.359894
+ 1.441667 0.251383
+ 1.444444 0.232163
+ 1.447222 0.359889
+ 1.450000 0.256395
+ 1.452778 0.238472
+ 1.455556 0.359918
+ 1.458333 0.255142
+ 1.461111 0.239700
+ 1.463889 0.359918
+ 1.466667 0.265166
+ 1.469444 0.234718
+ 1.472222 0.359894
+ 1.475000 0.263913
+ 1.477778 0.234732
+ 1.480556 0.359913
+ 1.483333 0.258901
+ 1.486111 0.247223
+ 1.488889 0.359928
+ 1.491667 0.258901
+ 1.494444 0.228433
+ 1.497222 0.359859
+ 1.500000 0.255142
+ 1.502778 0.219662
+ 1.505556 0.359830
+ 1.508333 0.250130
+ 1.511111 0.208351
+ 1.513889 0.359815
+ 1.516667 0.251383
+ 1.519444 0.210852
+ 1.522222 0.359801
+ 1.525000 0.250130
+ 1.527778 0.212120
+ 1.530556 0.359805
+ 1.533333 0.247624
+ 1.536111 0.208366
+ 1.538889 0.359805
+ 1.541667 0.250130
+ 1.544444 0.212110
+ 1.547222 0.359796
+ 1.550000 0.245118
+ 1.552778 0.207059
+ 1.555556 0.359757
+ 1.558333 0.212541
+ 1.561111 0.169357
+ 1.563889 0.359629
+ 1.566667 0.278949
+ 1.569444 0.196071
+ 1.572222 0.379941
+ 1.575000 0.399314
+ 1.577778 0.402035
+ 1.580556 0.380861
+ 1.583333 0.434402
+ 1.586111 0.173654
+ 1.588889 0.360603
+ 1.591667 0.235099
+ 1.594444 0.178250
+ 1.597222 0.359668
+ 1.600000 0.240106
+ 1.602778 0.207074
+ 1.605556 0.359786
+ 1.608333 0.236348
+ 1.611111 0.200789
+ 1.613889 0.359781
+ 1.616667 0.241359
+ 1.619444 0.199541
+ 1.622222 0.359757
+ 1.625000 0.237600
+ 1.627778 0.199536
+ 1.630556 0.359776
+ 1.633333 0.235095
+ 1.636111 0.194519
+ 1.638889 0.359761
+ 1.641667 0.237600
+ 1.644444 0.198269
+ 1.647222 0.359742
+ 1.650000 0.240106
+ 1.652778 0.199546
+ 1.655556 0.359766
+ 1.658333 0.233842
+ 1.661111 0.197035
+ 1.663889 0.359771
+ 1.666667 0.242612
+ 1.669444 0.199546
+ 1.672222 0.359752
+ 1.675000 0.238853
+ 1.677778 0.202062
+ 1.680556 0.359771
+ 1.683333 0.238853
+ 1.686111 0.199541
+ 1.688889 0.359776
+ 1.691667 0.241359
+ 1.694444 0.199531
+ 1.697222 0.359757
+ 1.700000 0.236348
+ 1.702778 0.203305
+ 1.705556 0.359776
+ 1.708333 0.233842
+ 1.711111 0.202028
+ 1.713889 0.359781
+ 1.716667 0.240106
+ 1.719444 0.200775
+ 1.722222 0.359776
+ 1.725000 0.231336
+ 1.727778 0.204538
+ 1.730556 0.359781
+ 1.733333 0.226324
+ 1.736111 0.200735
+ 1.738889 0.359776
+ 1.741667 0.222565
+ 1.744444 0.201974
+ 1.747222 0.359771
+ 1.750000 0.217553
+ 1.752778 0.203212
+ 1.755556 0.359776
+ 1.758333 0.207529
+ 1.761111 0.200677
+ 1.763889 0.359771
+ 1.766667 0.207529
+ 1.769444 0.198156
+ 1.772222 0.359757
+ 1.775000 0.205023
+ 1.777778 0.201930
+ 1.780556 0.359776
+ 1.783333 0.206276
+ 1.786111 0.198171
+ 1.788889 0.359781
+ 1.791667 0.220059
+ 1.794444 0.201988
+ 1.797222 0.359766
+ 1.800000 0.228830
+ 1.802778 0.214572
+ 1.805556 0.359825
+ 1.808333 0.233842
+ 1.811111 0.214577
+ 1.813889 0.359835
+ 1.816667 0.250130
+ 1.819444 0.220886
+ 1.822222 0.359849
+ 1.825000 0.253889
+ 1.827778 0.229696
+ 1.830556 0.359889
+ 1.833333 0.255142
+ 1.836111 0.229681
+ 1.838889 0.359894
+ 1.841667 0.257648
+ 1.844444 0.225913
+ 1.847222 0.359864
+ 1.850000 0.258901
+ 1.852778 0.228438
+ 1.855556 0.359879
+ 1.858333 0.252636
+ 1.861111 0.225908
+ 1.863889 0.359874
+ 1.866667 0.258901
+ 1.869444 0.227175
+ 1.872222 0.359859
+ 1.875000 0.253889
+ 1.877778 0.227180
+ 1.880556 0.359879
+ 1.883333 0.252636
+ 1.886111 0.225903
+ 1.888889 0.359879
+ 1.891667 0.253889
+ 1.894444 0.224650
+ 1.897222 0.359849
+ 1.900000 0.253889
+ 1.902778 0.222158
+ 1.905556 0.359849
+ 1.908333 0.246371
+ 1.911111 0.222134
+ 1.913889 0.359859
+ 1.916667 0.251383
+ 1.919444 0.218390
+ 1.922222 0.359830
+ 1.925000 0.248877
+ 1.927778 0.220886
+ 1.930556 0.359845
+ 1.933333 0.247624
+ 1.936111 0.215869
+ 1.938889 0.359845
+ 1.941667 0.248877
+ 1.944444 0.217122
+ 1.947222 0.359825
+ 1.950000 0.246371
+ 1.952778 0.220901
+ 1.955556 0.359845
+ 1.958333 0.247624
+ 1.961111 0.217112
+ 1.963889 0.359835
+ 1.966667 0.251383
+ 1.969444 0.214636
+ 1.972222 0.359830
+ 1.975000 0.250130
+ 1.977778 0.219657
+ 1.980556 0.359830
+ 1.983333 0.250130
+ 1.986111 0.218375
+ 1.988889 0.359845
+ 1.991667 0.255142
+ 1.994444 0.223407
+ 1.997222 0.359845
+ 2.000000 0.253889
+ 2.002778 0.220915
+ 2.005556 0.359840
+ 2.008333 0.252636
+ 2.011111 0.218385
+ 2.013889 0.359854
+ 2.016667 0.257648
+ 2.019444 0.217151
+ 2.022222 0.359840
+ 2.025000 0.255142
+ 2.027778 0.235941
+ 2.030556 0.359894
+ 2.033333 0.251383
+ 2.036111 0.239700
+ 2.038889 0.359923
+ 2.041667 0.258901
+ 2.044444 0.245985
+ 2.047222 0.359952
+ 2.050000 0.263913
+ 2.052778 0.252274
+ 2.055556 0.359967
+ 2.058333 0.262660
+ 2.061111 0.243513
+ 2.063889 0.359938
+ 2.066667 0.271431
+ 2.069444 0.242270
+ 2.072222 0.359923
+ 2.075000 0.265166
+ 2.077778 0.253522
+ 2.080556 0.359962
+ 2.083333 0.263913
+ 2.086111 0.232202
+ 2.088889 0.359879
+ 2.091667 0.257648
+ 2.094444 0.220915
+ 2.097222 0.359849
+ 2.100000 0.258901
+ 2.102778 0.220925
+ 2.105556 0.359854
+ 2.108333 0.255142
+ 2.111111 0.218395
+ 2.113889 0.359840
+ 2.116667 0.256395
+ 2.119444 0.219657
+ 2.122222 0.359835
+ 2.125000 0.255142
+ 2.127778 0.215898
+ 2.130556 0.359830
+ 2.133333 0.252636
+ 2.136111 0.212130
+ 2.138889 0.359825
+ 2.141667 0.252636
+ 2.144444 0.209599
+ 2.147222 0.359781
+ 2.150000 0.227577
+ 2.152778 0.184452
+ 2.155556 0.359688
+ 2.158333 0.245118
+ 2.161111 0.174628
+ 2.163889 0.379829
+ 2.166667 0.349194
+ 2.169444 0.321614
+ 2.172222 0.380558
+ 2.175000 0.440667
+ 2.177778 0.191446
+ 2.180556 0.360863
+ 2.183333 0.223823
+ 2.186111 0.228335
+ 2.188889 0.359722
+ 2.191667 0.247624
+ 2.194444 0.199575
+ 2.197222 0.359786
+ 2.200000 0.248877
+ 2.202778 0.209614
+ 2.205556 0.359801
+ 2.208333 0.243865
+ 2.211111 0.209585
+ 2.213889 0.359810
+ 2.216667 0.248877
+ 2.219444 0.212105
+ 2.222222 0.359796
+ 2.225000 0.245118
+ 2.227778 0.212105
+ 2.230556 0.359810
+ 2.233333 0.242612
+ 2.236111 0.205821
+ 2.238889 0.359786
+ 2.241667 0.247624
+ 2.244444 0.204582
+ 2.247222 0.359791
+ 2.250000 0.246371
+ 2.252778 0.208351
+ 2.255556 0.359796
+ 2.258333 0.245118
+ 2.261111 0.212091
+ 2.263889 0.359815
+ 2.266667 0.248877
+ 2.269444 0.208341
+ 2.272222 0.359801
+ 2.275000 0.247624
+ 2.277778 0.209604
+ 2.280556 0.359796
+ 2.283333 0.243865
+ 2.286111 0.207084
+ 2.288889 0.359801
+ 2.291667 0.246371
+ 2.294444 0.204568
+ 2.297222 0.359781
+ 2.300000 0.243865
+ 2.302778 0.209599
+ 2.305556 0.359805
+ 2.308333 0.240106
+ 2.311111 0.212081
+ 2.313889 0.359825
+ 2.316667 0.240106
+ 2.319444 0.208307
+ 2.322222 0.359801
+ 2.325000 0.235095
+ 2.327778 0.205806
+ 2.330556 0.359801
+ 2.333333 0.232589
+ 2.336111 0.209531
+ 2.338889 0.359805
+ 2.341667 0.230083
+ 2.344444 0.209506
+ 2.347222 0.359796
+ 2.350000 0.223818
+ 2.352778 0.212017
+ 2.355556 0.359801
+ 2.358333 0.216300
+ 2.361111 0.199448
+ 2.363889 0.359796
+ 2.366667 0.217553
+ 2.369444 0.203207
+ 2.372222 0.359766
+ 2.375000 0.215047
+ 2.377778 0.208239
+ 2.380556 0.359805
+ 2.383333 0.223818
+ 2.386111 0.205752
+ 2.388889 0.359805
+ 2.391667 0.236348
+ 2.394444 0.213324
+ 2.397222 0.359815
+ 2.400000 0.247624
+ 2.402778 0.224645
+ 2.405556 0.359859
+ 2.408333 0.246371
+ 2.411111 0.225898
+ 2.413889 0.359874
+ 2.416667 0.252636
+ 2.419444 0.228414
+ 2.422222 0.359884
+ 2.425000 0.252636
+ 2.427778 0.234693
+ 2.430556 0.359903
+ 2.433333 0.250130
+ 2.436111 0.230915
+ 2.438889 0.359894
+ 2.441667 0.252636
+ 2.444444 0.232168
+ 2.447222 0.359874
+ 2.450000 0.251383
+ 2.452778 0.228418
+ 2.455556 0.359874
+ 2.458333 0.248877
+ 2.461111 0.225893
+ 2.463889 0.359874
+ 2.466667 0.248877
+ 2.469444 0.225893
+ 2.472222 0.359859
+ 2.475000 0.246371
+ 2.477778 0.227161
+ 2.480556 0.359859
+ 2.483333 0.247624
+ 2.486111 0.225878
+ 2.488889 0.359864
+ 2.491667 0.245118
+ 2.494444 0.222114
+ 2.497222 0.359845
+ 2.500000 0.243865
+ 2.502778 0.219608
+ 2.505556 0.359835
+ 2.508333 0.238853
+ 2.511111 0.218346
+ 2.513889 0.359849
+ 2.516667 0.243865
+ 2.519444 0.215840
+ 2.522222 0.359825
+ 2.525000 0.242612
+ 2.527778 0.218360
+ 2.530556 0.359840
+ 2.533333 0.240106
+ 2.536111 0.217083
+ 2.538889 0.359845
+ 2.541667 0.246371
+ 2.544444 0.215840
+ 2.547222 0.359825
+ 2.550000 0.240106
+ 2.552778 0.219608
+ 2.555556 0.359845
+ 2.558333 0.235095
+ 2.561111 0.220832
+ 2.563889 0.359840
+ 2.566667 0.243865
+ 2.569444 0.218355
+ 2.572222 0.359830
+ 2.575000 0.240106
+ 2.577778 0.222114
+ 2.580556 0.359849
+ 2.583333 0.238853
+ 2.586111 0.214577
+ 2.588889 0.359845
+ 2.591667 0.240106
+ 2.594444 0.217078
+ 2.597222 0.359825
+ 2.600000 0.238853
+ 2.602778 0.225868
+ 2.605556 0.359889
+ 2.608333 0.236348
+ 2.611111 0.230851
+ 2.613889 0.359898
+ 2.616667 0.246371
+ 2.619444 0.240924
+ 2.622222 0.359913
+ 2.625000 0.250130
+ 2.627778 0.244693
+ 2.630556 0.359938
+ 2.633333 0.250130
+ 2.636111 0.235917
+ 2.638889 0.359918
+ 2.641667 0.251383
+ 2.644444 0.233411
+ 2.647222 0.359884
+ 2.650000 0.248877
+ 2.652778 0.242187
+ 2.655556 0.359933
+ 2.658333 0.241359
+ 2.661111 0.227131
+ 2.663889 0.359874
+ 2.666667 0.238853
+ 2.669444 0.214567
+ 2.672222 0.359810
+ 2.675000 0.240106
+ 2.677778 0.217078
+ 2.680556 0.359840
+ 2.683333 0.235095
+ 2.686111 0.213324
+ 2.688889 0.359825
+ 2.691667 0.237600
+ 2.694444 0.209560
+ 2.697222 0.359801
+ 2.700000 0.233842
+ 2.702778 0.209550
+ 2.705556 0.359801
+ 2.708333 0.231336
+ 2.711111 0.208283
+ 2.713889 0.359796
+ 2.716667 0.235095
+ 2.719444 0.208288
+ 2.722222 0.359786
+ 2.725000 0.217553
+ 2.727778 0.189439
+ 2.730556 0.359712
+ 2.733333 0.211288
+ 2.736111 0.160655
+ 2.738889 0.359664
+ 2.741667 0.297822
+ 2.744444 0.266233
+ 2.747222 0.380274
+ 2.750000 0.384283
+ 2.752778 0.170076
+ 2.755556 0.360961
+ 2.758333 0.221317
+ 2.761111 0.303362
+ 2.763889 0.359894
+ 2.766667 0.218806
+ 2.769444 0.179410
+ 2.772222 0.359717
+ 2.775000 0.225071
+ 2.777778 0.203256
+ 2.780556 0.359776
+ 2.783333 0.222565
+ 2.786111 0.195719
+ 2.788889 0.359771
+ 2.791667 0.222565
+ 2.794444 0.199478
+ 2.797222 0.359766
+ 2.800000 0.223818
+ 2.802778 0.205767
+ 2.805556 0.359771
+ 2.808333 0.223818
+ 2.811111 0.203246
+ 2.813889 0.359781
+ 2.816667 0.226324
+ 2.819444 0.199497
+ 2.822222 0.359761
+ 2.825000 0.225071
+ 2.827778 0.199492
+ 2.830556 0.359757
+ 2.833333 0.221312
+ 2.836111 0.194466
+ 2.838889 0.359761
+ 2.841667 0.228830
+ 2.844444 0.194470
+ 2.847222 0.359747
+ 2.850000 0.223818
+ 2.852778 0.200750
+ 2.855556 0.359761
+ 2.858333 0.222565
+ 2.861111 0.198234
+ 2.863889 0.359761
+ 2.866667 0.225071
+ 2.869444 0.195723
+ 2.872222 0.359747
+ 2.875000 0.221312
+ 2.877778 0.196986
+ 2.880556 0.359761
+ 2.883333 0.221312
+ 2.886111 0.194461
+ 2.888889 0.359761
+ 2.891667 0.221312
+ 2.894444 0.195704
+ 2.897222 0.359752
+ 2.900000 0.218806
+ 2.902778 0.203232
+ 2.905556 0.359771
+ 2.908333 0.215047
+ 2.911111 0.198195
+ 2.913889 0.359771
+ 2.916667 0.216300
+ 2.919444 0.198185
+ 2.922222 0.359761
+ 2.925000 0.210035
+ 2.927778 0.194422
+ 2.930556 0.359737
+ 2.933333 0.200011
+ 2.936111 0.188113
+ 2.938889 0.359727
+ 2.941667 0.193746
+ 2.944444 0.184329
+ 2.947222 0.359688
+ 2.950000 0.191240
+ 2.952778 0.189336
+ 2.955556 0.359717
+ 2.958333 0.188734
+ 2.961111 0.184310
+ 2.963889 0.359727
+ 2.966667 0.197505
+ 2.969444 0.188108
+ 2.972222 0.359722
+ 2.975000 0.207529
+ 2.977778 0.199448
+ 2.980556 0.359776
+ 2.983333 0.218806
+ 2.986111 0.205728
+ 2.988889 0.359801
+ 2.991667 0.236348
+ 2.994444 0.214567
+ 2.997222 0.359830
+ 3.000000 0.236348
+ 3.002778 0.222105
+ 3.005556 0.359849
+ 3.008333 0.238853
+ 3.011111 0.223353
+ 3.013889 0.359859
+ 3.016667 0.241359
+ 3.019444 0.224611
+ 3.022222 0.359859
+ 3.025000 0.241359
+ 3.027778 0.228394
+ 3.030556 0.359879
+ 3.033333 0.243865
+ 3.036111 0.224620
+ 3.038889 0.359874
+ 3.041667 0.243865
+ 3.044444 0.223367
+ 3.047222 0.359845
+ 3.050000 0.242612
+ 3.052778 0.225878
+ 3.055556 0.359859
+ 3.058333 0.240106
+ 3.061111 0.218351
+ 3.063889 0.359854
+ 3.066667 0.246371
+ 3.069444 0.219599
+ 3.072222 0.359845
+ 3.075000 0.242612
+ 3.077778 0.222110
+ 3.080556 0.359845
+ 3.083333 0.238853
+ 3.086111 0.218331
+ 3.088889 0.359840
+ 3.091667 0.241359
+ 3.094444 0.219594
+ 3.097222 0.359840
+ 3.100000 0.243865
+ 3.102778 0.222119
+ 3.105556 0.359849
+ 3.108333 0.235095
+ 3.111111 0.215825
+ 3.113889 0.359830
+ 3.116667 0.238853
+ 3.119444 0.214582
+ 3.122222 0.359815
+ 3.125000 0.238853
+ 3.127778 0.215845
+ 3.130556 0.359840
+ 3.133333 0.238853
+ 3.136111 0.214572
+ 3.138889 0.359840
+ 3.141667 0.240106
+ 3.144444 0.215840
+ 3.147222 0.359820
+ 3.150000 0.241359
+ 3.152778 0.218351
+ 3.155556 0.359845
+ 3.158333 0.238853
+ 3.161111 0.213314
+ 3.163889 0.359820
+ 3.166667 0.238853
+ 3.169444 0.214582
+ 3.172222 0.359815
+ 3.175000 0.240106
+ 3.177778 0.218351
+ 3.180556 0.359835
+ 3.183333 0.240106
+ 3.186111 0.217083
+ 3.188889 0.359840
+ 3.191667 0.241359
+ 3.194444 0.217083
+ 3.197222 0.359830
+ 3.200000 0.238853
+ 3.202778 0.222114
+ 3.205556 0.359854
+ 3.208333 0.240106
+ 3.211111 0.220837
+ 3.213889 0.359869
+ 3.216667 0.238853
+ 3.219444 0.227112
+ 3.222222 0.359874
+ 3.225000 0.246371
+ 3.227778 0.235907
+ 3.230556 0.359913
+ 3.233333 0.245118
+ 3.236111 0.239666
+ 3.238889 0.359933
+ 3.241667 0.252636
+ 3.244444 0.243440
+ 3.247222 0.359933
+ 3.250000 0.252636
+ 3.252778 0.242201
+ 3.255556 0.359928
+ 3.258333 0.248877
+ 3.261111 0.238433
+ 3.263889 0.359908
+ 3.266667 0.257648
+ 3.269444 0.238452
+ 3.272222 0.359894
+ 3.275000 0.252636
+ 3.277778 0.248456
+ 3.280556 0.359942
+ 3.283333 0.246371
+ 3.286111 0.227131
+ 3.288889 0.359869
+ 3.291667 0.245118
+ 3.294444 0.215859
+ 3.297222 0.359835
+ 3.300000 0.245118
+ 3.302778 0.212100
+ 3.305556 0.359830
+ 3.308333 0.241359
+ 3.311111 0.214577
+ 3.313889 0.359825
+ 3.316667 0.243865
+ 3.319444 0.215845
+ 3.322222 0.359830
+ 3.325000 0.241359
+ 3.327778 0.215854
+ 3.330556 0.359820
+ 3.333333 0.238853
+ 3.336111 0.207074
+ 3.338889 0.359820
+ 3.341667 0.242612
+ 3.344444 0.212081
+ 3.347222 0.359801
+ 3.350000 0.235095
+ 3.352778 0.207030
+ 3.355556 0.359766
+ 3.358333 0.211288
+ 3.361111 0.178108
+ 3.363889 0.359668
+ 3.366667 0.251383
+ 3.369444 0.182171
+ 3.372222 0.379873
+ 3.375000 0.374254
+ 3.377778 0.358058
+ 3.380556 0.380695
+ 3.383333 0.459462
+ 3.386111 0.209027
+ 3.388889 0.360961
+ 3.391667 0.226329
+ 3.394444 0.238320
+ 3.397222 0.359727
+ 3.400000 0.231336
+ 3.402778 0.200789
+ 3.405556 0.359791
+ 3.408333 0.231336
+ 3.411111 0.200765
+ 3.413889 0.359796
+ 3.416667 0.232589
+ 3.419444 0.202023
+ 3.422222 0.359766
+ 3.425000 0.232589
+ 3.427778 0.203285
+ 3.430556 0.359781
+ 3.433333 0.231336
+ 3.436111 0.203261
+ 3.438889 0.359776
+ 3.441667 0.231336
+ 3.444444 0.200765
+ 3.447222 0.359776
+ 3.450000 0.232589
+ 3.452778 0.205777
+ 3.455556 0.359796
+ 3.458333 0.231336
+ 3.461111 0.204529
+ 3.463889 0.359796
+ 3.466667 0.237600
+ 3.469444 0.208292
+ 3.472222 0.359791
+ 3.475000 0.233842
+ 3.477778 0.208292
+ 3.480556 0.359796
+ 3.483333 0.232589
+ 3.486111 0.205786
+ 3.488889 0.359801
+ 3.491667 0.235095
+ 3.494444 0.207035
+ 3.497222 0.359781
+ 3.500000 0.235095
+ 3.502778 0.208297
+ 3.505556 0.359805
+ 3.508333 0.230083
+ 3.511111 0.203266
+ 3.513889 0.359796
+ 3.516667 0.232589
+ 3.519444 0.205772
+ 3.522222 0.359781
+ 3.525000 0.225071
+ 3.527778 0.208268
+ 3.530556 0.359796
+ 3.533333 0.222565
+ 3.536111 0.203246
+ 3.538889 0.359786
+ 3.541667 0.221312
+ 3.544444 0.205728
+ 3.547222 0.359791
+ 3.550000 0.215047
+ 3.552778 0.208234
+ 3.555556 0.359805
+ 3.558333 0.207529
+ 3.561111 0.204426
+ 3.563889 0.359796
+ 3.566667 0.207529
+ 3.569444 0.204421
+ 3.572222 0.359771
+ 3.575000 0.200011
+ 3.577778 0.203148
+ 3.580556 0.359776
+ 3.583333 0.196252
+ 3.586111 0.201895
+ 3.588889 0.359766
+ 3.591667 0.198758
+ 3.594444 0.199389
+ 3.597222 0.359766
+ 3.600000 0.211288
+ 3.602778 0.205718
+ 3.605556 0.359801
+ 3.608333 0.217553
+ 3.611111 0.217024
+ 3.613889 0.359854
+ 3.616667 0.238853
+ 3.619444 0.224606
+ 3.622222 0.359859
+ 3.625000 0.243865
+ 3.627778 0.230895
+ 3.630556 0.359894
+ 3.633333 0.247624
+ 3.636111 0.230910
+ 3.638889 0.359898
+ 3.641667 0.255142
+ 3.644444 0.230915
+ 3.647222 0.359884
+ 3.650000 0.252636
+ 3.652778 0.234688
+ 3.655556 0.359908
+ 3.658333 0.250130
+ 3.661111 0.233421
+ 3.663889 0.359898
+ 3.666667 0.252636
+ 3.669444 0.232163
+ 3.672222 0.359884
+ 3.675000 0.252636
+ 3.677778 0.233440
+ 3.680556 0.359903
+ 3.683333 0.251383
+ 3.686111 0.229657
+ 3.688889 0.359879
+ 3.691667 0.253889
+ 3.694444 0.227156
+ 3.697222 0.359864
+ 3.700000 0.247624
+ 3.702778 0.228409
+ 3.705556 0.359879
+ 3.708333 0.246371
+ 3.711111 0.224630
+ 3.713889 0.359869
+ 3.716667 0.247624
+ 3.719444 0.224620
+ 3.722222 0.359849
+ 3.725000 0.242612
+ 3.727778 0.228394
+ 3.730556 0.359869
+ 3.733333 0.243865
+ 3.736111 0.223348
+ 3.738889 0.359854
+ 3.741667 0.243865
+ 3.744444 0.219608
+ 3.747222 0.359835
+ 3.750000 0.245118
+ 3.752778 0.223372
+ 3.755556 0.359854
+ 3.758333 0.237600
+ 3.761111 0.217093
+ 3.763889 0.359840
+ 3.766667 0.243865
+ 3.769444 0.217088
+ 3.772222 0.359830
+ 3.775000 0.240106
+ 3.777778 0.223362
+ 3.780556 0.359849
+ 3.783333 0.237600
+ 3.786111 0.218341
+ 3.788889 0.359849
+ 3.791667 0.242612
+ 3.794444 0.218326
+ 3.797222 0.359825
+ 3.800000 0.240106
+ 3.802778 0.219613
+ 3.805556 0.359845
+ 3.808333 0.236348
+ 3.811111 0.215825
+ 3.813889 0.359840
+ 3.816667 0.241359
+ 3.819444 0.217088
+ 3.822222 0.359830
+ 3.825000 0.242612
+ 3.827778 0.223372
+ 3.830556 0.359854
+ 3.833333 0.238853
+ 3.836111 0.222095
+ 3.838889 0.359854
+ 3.841667 0.243865
+ 3.844444 0.222110
+ 3.847222 0.359840
+ 3.850000 0.241359
+ 3.852778 0.225868
+ 3.855556 0.359874
+ 3.858333 0.238853
+ 3.861111 0.234625
+ 3.863889 0.359918
+ 3.866667 0.242612
+ 3.869444 0.235883
+ 3.872222 0.359903
+ 3.875000 0.247624
+ 3.877778 0.242177
+ 3.880556 0.359947
+ 3.883333 0.248877
+ 3.886111 0.244673
+ 3.888889 0.359952
+ 3.891667 0.252636
+ 3.894444 0.242211
+ 3.897222 0.359923
+ 3.900000 0.251383
+ 3.902778 0.245960
+ 3.905556 0.359938
+ 3.908333 0.253889
+ 3.911111 0.247208
+ 3.913889 0.359967
+ 3.916667 0.251383
+ 3.919444 0.234654
+ 3.922222 0.359884
+ 3.925000 0.246371
+ 3.927778 0.224630
+ 3.930556 0.359849
+ 3.933333 0.240106
+ 3.936111 0.215830
+ 3.938889 0.359825
+ 3.941667 0.241359
+ 3.944444 0.213329
+ 3.947222 0.359810
+ 3.950000 0.241359
+ 3.952778 0.214587
+ 3.955556 0.359830
+ 3.958333 0.235095
+ 3.961111 0.210794
+ 3.963889 0.359820
+ 3.966667 0.238853
+ 3.969444 0.210813
+ 3.972222 0.359810
+ 3.975000 0.237600
+ 3.977778 0.213334
+ 3.980556 0.359815
+ 3.983333 0.225071
+ 3.986111 0.196957
+ 3.988889 0.359722
+ 3.991667 0.212541
+ 3.994444 0.183130
+ 3.997222 0.359678
+ 4.000000 0.191240
+ 4.002778 0.158046
+ 4.005556 0.359580
+ 4.008333 0.263913
+ 4.011111 0.201014
+ 4.013889 0.379946
+ 4.016667 0.374254
+ 4.019444 0.366819
+ 4.022222 0.380705
+ 4.025000 0.449438
+ 4.027778 0.197716
+ 4.030556 0.360858
+ 4.033333 0.213799
+ 4.036111 0.224522
+ 4.038889 0.359717
+ 4.041667 0.230083
+ 4.044444 0.199517
+ 4.047222 0.359771
+ 4.050000 0.230083
+ 4.052778 0.203266
+ 4.055556 0.359791
+ 4.058333 0.227577
+ 4.061111 0.199497
+ 4.063889 0.359786
+ 4.066667 0.227577
+ 4.069444 0.204509
+ 4.072222 0.359776
+ 4.075000 0.228830
+ 4.077778 0.204524
+ 4.080556 0.359796
+ 4.083333 0.226324
+ 4.086111 0.201988
+ 4.088889 0.359796
+ 4.091667 0.228830
+ 4.094444 0.204519
+ 4.097222 0.359771
+ 4.100000 0.228830
+ 4.102778 0.208283
+ 4.105556 0.359796
+ 4.108333 0.226324
+ 4.111111 0.204514
+ 4.113889 0.359796
+ 4.116667 0.231336
+ 4.119444 0.199507
+ 4.122222 0.359761
+ 4.125000 0.230083
+ 4.127778 0.204538
+ 4.130556 0.359791
+ 4.133333 0.227577
+ 4.136111 0.204499
+ 4.138889 0.359796
+ 4.141667 0.231336
+ 4.144444 0.204519
+ 4.147222 0.359791
+ 4.150000 0.226324
+ 4.152778 0.205772
+ 4.155556 0.359786
+ 4.158333 0.225071
+ 4.161111 0.205752
+ 4.163889 0.359796
+ 4.166667 0.226324
+ 4.169444 0.199497
+ 4.172222 0.359771
+ 4.175000 0.221312
+ 4.177778 0.212017
+ 4.180556 0.359791
+ 4.183333 0.217553
+ 4.186111 0.200706
+ 4.188889 0.359776
+ 4.191667 0.216300
+ 4.194444 0.204450
+ 4.197222 0.359776
+ 4.200000 0.206276
+ 4.202778 0.205698
+ 4.205556 0.359801
+ 4.208333 0.202517
+ 4.211111 0.203153
+ 4.213889 0.359786
+ 4.216667 0.197505
+ 4.219444 0.198127
+ 4.222222 0.359766
+ 4.225000 0.196252
+ 4.227778 0.203134
+ 4.230556 0.359786
+ 4.233333 0.192493
+ 4.236111 0.201871
+ 4.238889 0.359781
+ 4.241667 0.203770
+ 4.244444 0.205669
+ 4.247222 0.359781
+ 4.250000 0.213794
+ 4.252778 0.214508
+ 4.255556 0.359830
+ 4.258333 0.225071
+ 4.261111 0.218287
+ 4.263889 0.359854
+ 4.266667 0.241359
+ 4.269444 0.223362
+ 4.272222 0.359874
+ 4.275000 0.242612
+ 4.277778 0.230895
+ 4.280556 0.359889
+ 4.283333 0.246371
+ 4.286111 0.224615
+ 4.288889 0.359889
+ 4.291667 0.247624
+ 4.294444 0.228389
+ 4.297222 0.359869
+ 4.300000 0.247624
+ 4.302778 0.232173
+ 4.305556 0.359903
+ 4.308333 0.246371
+ 4.311111 0.232133
+ 4.313889 0.359894
+ 4.316667 0.248877
+ 4.319444 0.225888
+ 4.322222 0.359854
+ 4.325000 0.242612
+ 4.327778 0.225878
+ 4.330556 0.359869
+ 4.333333 0.241359
+ 4.336111 0.224601
+ 4.338889 0.359869
+ 4.341667 0.243865
+ 4.344444 0.220847
+ 4.347222 0.359840
+ 4.350000 0.240106
+ 4.352778 0.225868
+ 4.355556 0.359849
+ 4.358333 0.240106
+ 4.361111 0.220832
+ 4.363889 0.359854
+ 4.366667 0.238853
+ 4.369444 0.222090
+ 4.372222 0.359825
+ 4.375000 0.238853
+ 4.377778 0.219594
+ 4.380556 0.359849
+ 4.383333 0.230083
+ 4.386111 0.215796
+ 4.388889 0.359830
+ 4.391667 0.235095
+ 4.394444 0.214557
+ 4.397222 0.359815
+ 4.400000 0.235095
+ 4.402778 0.218326
+ 4.405556 0.359835
+ 4.408333 0.231336
+ 4.411111 0.215801
+ 4.413889 0.359840
+ 4.416667 0.232589
+ 4.419444 0.215796
+ 4.422222 0.359815
+ 4.425000 0.233842
+ 4.427778 0.217078
+ 4.430556 0.359840
+ 4.433333 0.235095
+ 4.436111 0.215805
+ 4.438889 0.359830
+ 4.441667 0.230083
+ 4.444444 0.213295
+ 4.447222 0.359805
+ 4.450000 0.231336
+ 4.452778 0.215801
+ 4.455556 0.359835
+ 4.458333 0.235095
+ 4.461111 0.213309
+ 4.463889 0.359840
+ 4.466667 0.236348
+ 4.469444 0.213304
+ 4.472222 0.359830
+ 4.475000 0.232589
+ 4.477778 0.224576
+ 4.480556 0.359869
+ 4.483333 0.227577
+ 4.486111 0.229569
+ 4.488889 0.359889
+ 4.491667 0.236348
+ 4.494444 0.233357
+ 4.497222 0.359894
+ 4.500000 0.237600
+ 4.502778 0.244649
+ 4.505556 0.359938
+ 4.508333 0.238853
+ 4.511111 0.239641
+ 4.513889 0.359923
+ 4.516667 0.243865
+ 4.519444 0.235897
+ 4.522222 0.359908
+ 4.525000 0.242612
+ 4.527778 0.233401
+ 4.530556 0.359898
+ 4.533333 0.236348
+ 4.536111 0.240885
+ 4.538889 0.359942
+ 4.541667 0.233842
+ 4.544444 0.229588
+ 4.547222 0.359869
+ 4.550000 0.237600
+ 4.552778 0.228350
+ 4.555556 0.359859
+ 4.558333 0.225071
+ 4.561111 0.210774
+ 4.563889 0.359820
+ 4.566667 0.228830
+ 4.569444 0.208263
+ 4.572222 0.359791
+ 4.575000 0.226324
+ 4.577778 0.209526
+ 4.580556 0.359801
+ 4.583333 0.225071
+ 4.586111 0.205752
+ 4.588889 0.359796
+ 4.591667 0.225071
+ 4.594444 0.205747
+ 4.597222 0.359781
+ 4.600000 0.225071
+ 4.602778 0.209526
+ 4.605556 0.359801
+ 4.608333 0.213794
+ 4.611111 0.193149
+ 4.613889 0.359712
+ 4.616667 0.198758
+ 4.619444 0.160527
+ 4.622222 0.359590
+ 4.625000 0.252636
+ 4.627778 0.204700
+ 4.630556 0.379941
+ 4.633333 0.329147
+ 4.636111 0.385452
+ 4.638889 0.380778
+ 4.641667 0.364235
+ 4.644444 0.149681
+ 4.647222 0.360574
+ 4.650000 0.192498
+ 4.652778 0.203168
+ 4.655556 0.359683
+ 4.658333 0.208782
+ 4.661111 0.185641
+ 4.663889 0.359727
+ 4.666667 0.216300
+ 4.669444 0.193188
+ 4.672222 0.359732
+ 4.675000 0.212541
+ 4.677778 0.194446
+ 4.680556 0.359742
+ 4.683333 0.215047
+ 4.686111 0.196942
+ 4.688889 0.359757
+ 4.691667 0.213794
+ 4.694444 0.196932
+ 4.697222 0.359742
+ 4.700000 0.215047
+ 4.702778 0.193193
+ 4.705556 0.359752
+ 4.708333 0.213794
+ 4.711111 0.193178
+ 4.713889 0.359752
+ 4.716667 0.217553
+ 4.719444 0.195694
+ 4.722222 0.359752
+ 4.725000 0.216300
+ 4.727778 0.199478
+ 4.730556 0.359761
+ 4.733333 0.215047
+ 4.736111 0.193183
+ 4.738889 0.359737
+ 4.741667 0.216300
+ 4.744444 0.190677
+ 4.747222 0.359732
+ 4.750000 0.216300
+ 4.752778 0.193193
+ 4.755556 0.359737
+ 4.758333 0.210035
+ 4.761111 0.190663
+ 4.763889 0.359727
+ 4.766667 0.215047
+ 4.769444 0.193178
+ 4.772222 0.359737
+ 4.775000 0.212541
+ 4.777778 0.195689
+ 4.780556 0.359747
+ 4.783333 0.213794
+ 4.786111 0.190667
+ 4.788889 0.359742
+ 4.791667 0.212541
+ 4.794444 0.191916
+ 4.797222 0.359732
+ 4.800000 0.211288
+ 4.802778 0.195670
+ 4.805556 0.359742
+ 4.808333 0.205023
+ 4.811111 0.193125
+ 4.813889 0.359752
+ 4.816667 0.202517
+ 4.819444 0.191872
+ 4.822222 0.359732
+ 4.825000 0.189987
+ 4.827778 0.195606
+ 4.830556 0.359737
+ 4.833333 0.184975
+ 4.836111 0.185543
+ 4.838889 0.359712
+ 4.841667 0.187481
+ 4.844444 0.185548
+ 4.847222 0.359703
+ 4.850000 0.184975
+ 4.852778 0.188059
+ 4.855556 0.359712
+ 4.858333 0.182469
+ 4.861111 0.185543
+ 4.863889 0.359717
+ 4.866667 0.198758
+ 4.869444 0.193125
+ 4.872222 0.359747
+ 4.875000 0.203770
+ 4.877778 0.203183
+ 4.880556 0.359781
+ 4.883333 0.213794
+ 4.886111 0.206981
+ 4.888889 0.359825
+ 4.891667 0.222565
+ 4.894444 0.215752
+ 4.897222 0.359825
+ 4.900000 0.222565
+ 4.902778 0.220788
+ 4.905556 0.359845
+ 4.908333 0.222565
+ 4.911111 0.213265
+ 4.913889 0.359840
+ 4.916667 0.222565
+ 4.919444 0.219520
+ 4.922222 0.359840
+ 4.925000 0.225071
+ 4.927778 0.220798
+ 4.930556 0.359849
+ 4.933333 0.220059
+ 4.936111 0.215766
+ 4.938889 0.359835
+ 4.941667 0.223818
+ 4.944444 0.213251
+ 4.947222 0.359815
+ 4.950000 0.221312
+ 4.952778 0.217014
+ 4.955556 0.359835
+ 4.958333 0.218806
+ 4.961111 0.211988
+ 4.963889 0.359830
+ 4.966667 0.221312
+ 4.969444 0.215757
+ 4.972222 0.359830
+ 4.975000 0.215047
+ 4.977778 0.215757
+ 4.980556 0.359825
+ 4.983333 0.213794
+ 4.986111 0.209457
+ 4.988889 0.359801
+ 4.991667 0.215047
+ 4.994444 0.205708
+ 4.997222 0.359791
+ 5.000000 0.213794
+ 5.002778 0.210730
+ 5.005556 0.359796
+ 5.008333 0.211288
+ 5.011111 0.206946
+ 5.013889 0.359810
+ 5.016667 0.212541
+ 5.019444 0.208195
+ 5.022222 0.359796
+ 5.025000 0.212541
+ 5.027778 0.209467
+ 5.030556 0.359805
+ 5.033333 0.207529
+ 5.036111 0.204426
+ 5.038889 0.359786
+ 5.041667 0.213794
+ 5.044444 0.205703
+ 5.047222 0.359781
+ 5.050000 0.210035
+ 5.052778 0.211978
+ 5.055556 0.359801
+ 5.058333 0.212541
+ 5.061111 0.210696
+ 5.063889 0.359810
+ 5.066667 0.210035
+ 5.069444 0.209452
+ 5.072222 0.359801
+ 5.075000 0.213794
+ 5.077778 0.211978
+ 5.080556 0.359805
+ 5.083333 0.207529
+ 5.086111 0.206937
+ 5.088889 0.359810
+ 5.091667 0.216300
+ 5.094444 0.210715
+ 5.097222 0.359796
+ 5.100000 0.210035
+ 5.102778 0.216990
+ 5.105556 0.359835
+ 5.108333 0.207529
+ 5.111111 0.220734
+ 5.113889 0.359849
+ 5.116667 0.218806
+ 5.119444 0.225761
+ 5.122222 0.359864
+ 5.125000 0.217553
+ 5.127778 0.238320
+ 5.130556 0.359918
+ 5.133333 0.218806
+ 5.136111 0.233288
+ 5.138889 0.359903
+ 5.141667 0.225071
+ 5.144444 0.229554
+ 5.147222 0.359879
+ 5.150000 0.222565
+ 5.152778 0.227048
+ 5.155556 0.359889
+ 5.158333 0.216300
+ 5.161111 0.227019
+ 5.163889 0.359854
+ 5.166667 0.218806
+ 5.169444 0.211988
+ 5.172222 0.359796
+ 5.175000 0.210035
+ 5.177778 0.208204
+ 5.180556 0.359796
+ 5.183333 0.208782
+ 5.186111 0.205689
+ 5.188889 0.359786
+ 5.191667 0.212541
+ 5.194444 0.201939
+ 5.197222 0.359766
+ 5.200000 0.213794
+ 5.202778 0.206976
+ 5.205556 0.359781
+ 5.208333 0.212541
+ 5.211111 0.198180
+ 5.213889 0.359781
+ 5.216667 0.215047
+ 5.219444 0.200691
+ 5.222222 0.359766
+ 5.225000 0.213794
+ 5.227778 0.203197
+ 5.230556 0.359771
+ 5.233333 0.196252
+ 5.236111 0.179298
+ 5.238889 0.359673
+ 5.241667 0.188734
+ 5.244444 0.156803
+ 5.247222 0.359619
+ 5.250000 0.278949
+ 5.252778 0.248642
+ 5.255556 0.380166
+ 5.258333 0.369247
+ 5.261111 0.140000
+ 5.263889 0.380989
+ 5.266667 0.301586
+ 5.269444 0.417526
+ 5.272222 0.360251
+ 5.275000 0.191240
+ 5.277778 0.180600
+ 5.280556 0.359668
+ 5.283333 0.207529
+ 5.286111 0.189395
+ 5.288889 0.359737
+ 5.291667 0.213794
+ 5.294444 0.191911
+ 5.297222 0.359732
+ 5.300000 0.213794
+ 5.302778 0.199443
+ 5.305556 0.359757
+ 5.308333 0.207529
+ 5.311111 0.193164
+ 5.313889 0.359752
+ 5.316667 0.215047
+ 5.319444 0.194431
+ 5.322222 0.359717
+ 5.325000 0.212541
+ 5.327778 0.194441
+ 5.330556 0.359737
+ 5.333333 0.211288
+ 5.336111 0.186904
+ 5.338889 0.359737
+ 5.341667 0.213794
+ 5.344444 0.191920
+ 5.347222 0.359722
+ 5.350000 0.216300
+ 5.352778 0.190677
+ 5.355556 0.359737
+ 5.358333 0.211288
+ 5.361111 0.190667
+ 5.363889 0.359742
+ 5.366667 0.216300
+ 5.369444 0.190677
+ 5.372222 0.359722
+ 5.375000 0.216300
+ 5.377778 0.196952
+ 5.380556 0.359747
+ 5.383333 0.211288
+ 5.386111 0.190663
+ 5.388889 0.359732
+ 5.391667 0.212541
+ 5.394444 0.189414
+ 5.397222 0.359712
+ 5.400000 0.212541
+ 5.402778 0.191925
+ 5.405556 0.359732
+ 5.408333 0.206276
+ 5.411111 0.188137
+ 5.413889 0.359722
+ 5.416667 0.210035
+ 5.419444 0.191891
+ 5.422222 0.359727
+ 5.425000 0.202517
+ 5.427778 0.191901
+ 5.430556 0.359747
+ 5.433333 0.200011
+ 5.436111 0.191862
+ 5.438889 0.359732
+ 5.441667 0.197505
+ 5.444444 0.186845
+ 5.447222 0.359717
+ 5.450000 0.189987
+ 5.452778 0.188083
+ 5.455556 0.359703
+ 5.458333 0.182469
+ 5.461111 0.179263
+ 5.463889 0.359688
+ 5.466667 0.182469
+ 5.469444 0.178020
+ 5.472222 0.359664
+ 5.475000 0.179963
+ 5.477778 0.181789
+ 5.480556 0.359693
+ 5.483333 0.189987
+ 5.486111 0.185587
+ 5.488889 0.359727
+ 5.491667 0.203770
+ 5.494444 0.194402
+ 5.497222 0.359752
+ 5.500000 0.215047
+ 5.502778 0.204480
+ 5.505556 0.359791
+ 5.508333 0.221312
+ 5.511111 0.207000
+ 5.513889 0.359810
+ 5.516667 0.231336
+ 5.519444 0.213299
+ 5.522222 0.359810
+ 5.525000 0.233842
+ 5.527778 0.219569
+ 5.530556 0.359835
+ 5.533333 0.235095
+ 5.536111 0.215805
+ 5.538889 0.359835
+ 5.541667 0.236348
+ 5.544444 0.217068
+ 5.547222 0.359820
+ 5.550000 0.235095
+ 5.552778 0.218331
+ 5.555556 0.359830
+ 5.558333 0.228830
+ 5.561111 0.213285
+ )
Vecg_l1 ecg_amp_l1 0 PWL(
+ 0.000000 0.359924
+ 0.002778 0.252535
+ 0.005556 0.205658
+ 0.008333 0.359890
+ 0.011111 0.252535
+ 0.013889 0.205648
+ 0.016667 0.359909
+ 0.019444 0.246256
+ 0.022222 0.201866
+ 0.025000 0.359909
+ 0.027778 0.253790
+ 0.030556 0.209415
+ 0.033333 0.359919
+ 0.036111 0.252535
+ 0.038889 0.208179
+ 0.041667 0.359944
+ 0.044444 0.250023
+ 0.047222 0.204383
+ 0.050000 0.359919
+ 0.052778 0.252535
+ 0.055556 0.201876
+ 0.058333 0.359895
+ 0.061111 0.248768
+ 0.063889 0.203132
+ 0.066667 0.359904
+ 0.069444 0.250023
+ 0.072222 0.204383
+ 0.075000 0.359924
+ 0.077778 0.247512
+ 0.080556 0.204383
+ 0.083333 0.359909
+ 0.086111 0.248768
+ 0.088889 0.210676
+ 0.091667 0.359934
+ 0.094444 0.250023
+ 0.097222 0.209410
+ 0.100000 0.359929
+ 0.102778 0.247512
+ 0.105556 0.205638
+ 0.108333 0.359909
+ 0.111111 0.248768
+ 0.113889 0.206904
+ 0.116667 0.359919
+ 0.119444 0.241234
+ 0.122222 0.203097
+ 0.125000 0.359929
+ 0.127778 0.247512
+ 0.130556 0.204378
+ 0.133333 0.359904
+ 0.136111 0.242489
+ 0.138889 0.205628
+ 0.141667 0.359924
+ 0.144444 0.241234
+ 0.147222 0.208125
+ 0.150000 0.359939
+ 0.152778 0.247512
+ 0.155556 0.206865
+ 0.158333 0.359919
+ 0.161111 0.243745
+ 0.163889 0.209395
+ 0.166667 0.359924
+ 0.169444 0.242489
+ 0.172222 0.206874
+ 0.175000 0.359919
+ 0.177778 0.246256
+ 0.180556 0.213162
+ 0.183333 0.359948
+ 0.186111 0.243745
+ 0.188889 0.220706
+ 0.191667 0.359973
+ 0.194444 0.245001
+ 0.197222 0.224478
+ 0.200000 0.360002
+ 0.202778 0.252535
+ 0.205556 0.232017
+ 0.208333 0.360017
+ 0.211111 0.253790
+ 0.213889 0.232047
+ 0.216667 0.360017
+ 0.219444 0.252535
+ 0.222222 0.225754
+ 0.225000 0.360007
+ 0.227778 0.252535
+ 0.230556 0.223227
+ 0.233333 0.359958
+ 0.236111 0.255046
+ 0.238889 0.228270
+ 0.241667 0.360012
+ 0.244444 0.243745
+ 0.247222 0.220706
+ 0.250000 0.359968
+ 0.252778 0.248768
+ 0.255556 0.208150
+ 0.258333 0.359909
+ 0.261111 0.241234
+ 0.263889 0.204373
+ 0.266667 0.359909
+ 0.269444 0.243745
+ 0.272222 0.200586
+ 0.275000 0.359919
+ 0.277778 0.242489
+ 0.280556 0.195568
+ 0.283333 0.359860
+ 0.286111 0.237467
+ 0.288889 0.199345
+ 0.291667 0.359899
+ 0.294444 0.238722
+ 0.297222 0.194308
+ 0.300000 0.359885
+ 0.302778 0.238722
+ 0.305556 0.193047
+ 0.308333 0.359850
+ 0.311111 0.222399
+ 0.313889 0.172893
+ 0.316667 0.359796
+ 0.319444 0.218632
+ 0.322222 0.151590
+ 0.325000 0.359757
+ 0.327778 0.302840
+ 0.330556 0.247340
+ 0.333333 0.380343
+ 0.336111 0.391998
+ 0.338889 0.153577
+ 0.341667 0.381192
+ 0.344444 0.349305
+ 0.347222 0.436780
+ 0.350000 0.360493
+ 0.352778 0.198541
+ 0.355556 0.189143
+ 0.358333 0.359782
+ 0.361111 0.223654
+ 0.363889 0.170401
+ 0.366667 0.359816
+ 0.369444 0.226166
+ 0.372222 0.186710
+ 0.375000 0.359860
+ 0.377778 0.229933
+ 0.380556 0.191757
+ 0.383333 0.359860
+ 0.386111 0.228677
+ 0.388889 0.188005
+ 0.391667 0.359850
+ 0.394444 0.224910
+ 0.397222 0.182968
+ 0.400000 0.359850
+ 0.402778 0.231188
+ 0.405556 0.184228
+ 0.408333 0.359836
+ 0.411111 0.231188
+ 0.413889 0.188025
+ 0.416667 0.359850
+ 0.419444 0.228677
+ 0.422222 0.184208
+ 0.425000 0.359850
+ 0.427778 0.237467
+ 0.430556 0.184243
+ 0.433333 0.359836
+ 0.436111 0.232444
+ 0.438889 0.189261
+ 0.441667 0.359850
+ 0.444444 0.232444
+ 0.447222 0.190511
+ 0.450000 0.359850
+ 0.452778 0.233700
+ 0.455556 0.185494
+ 0.458333 0.359841
+ 0.461111 0.233700
+ 0.463889 0.191792
+ 0.466667 0.359855
+ 0.469444 0.229933
+ 0.472222 0.184218
+ 0.475000 0.359836
+ 0.477778 0.232444
+ 0.480556 0.185489
+ 0.483333 0.359841
+ 0.486111 0.229933
+ 0.488889 0.191752
+ 0.491667 0.359865
+ 0.494444 0.227421
+ 0.497222 0.190492
+ 0.500000 0.359875
+ 0.502778 0.228677
+ 0.505556 0.191752
+ 0.508333 0.359855
+ 0.511111 0.229933
+ 0.513889 0.194283
+ 0.516667 0.359875
+ 0.519444 0.223654
+ 0.522222 0.191723
+ 0.525000 0.359870
+ 0.527778 0.223654
+ 0.530556 0.184164
+ 0.533333 0.359816
+ 0.536111 0.211097
+ 0.538889 0.181643
+ 0.541667 0.359821
+ 0.544444 0.203563
+ 0.547222 0.171549
+ 0.550000 0.359806
+ 0.552778 0.198541
+ 0.555556 0.171544
+ 0.558333 0.359767
+ 0.561111 0.196029
+ 0.563889 0.172795
+ 0.566667 0.359796
+ 0.569444 0.193518
+ 0.572222 0.172775
+ 0.575000 0.359801
+ 0.577778 0.207330
+ 0.580556 0.177866
+ 0.583333 0.359816
+ 0.586111 0.217376
+ 0.588889 0.189221
+ 0.591667 0.359870
+ 0.594444 0.231188
+ 0.597222 0.198050
+ 0.600000 0.359899
+ 0.602778 0.241234
+ 0.605556 0.206865
+ 0.608333 0.359929
+ 0.611111 0.247512
+ 0.613889 0.214438
+ 0.616667 0.359973
+ 0.619444 0.246256
+ 0.622222 0.219446
+ 0.625000 0.359978
+ 0.627778 0.252535
+ 0.630556 0.218200
+ 0.633333 0.359948
+ 0.636111 0.250023
+ 0.638889 0.216959
+ 0.641667 0.359958
+ 0.644444 0.246256
+ 0.647222 0.214428
+ 0.650000 0.359968
+ 0.652778 0.251279
+ 0.655556 0.214428
+ 0.658333 0.359948
+ 0.661111 0.248768
+ 0.663889 0.216944
+ 0.666667 0.359958
+ 0.669444 0.247512
+ 0.672222 0.213158
+ 0.675000 0.359963
+ 0.677778 0.248768
+ 0.680556 0.211922
+ 0.683333 0.359944
+ 0.686111 0.250023
+ 0.688889 0.215679
+ 0.691667 0.359958
+ 0.694444 0.242489
+ 0.697222 0.209371
+ 0.700000 0.359934
+ 0.702778 0.245001
+ 0.705556 0.206879
+ 0.708333 0.359924
+ 0.711111 0.242489
+ 0.713889 0.211907
+ 0.716667 0.359944
+ 0.719444 0.242489
+ 0.722222 0.210651
+ 0.725000 0.359944
+ 0.727778 0.243745
+ 0.730556 0.209386
+ 0.733333 0.359929
+ 0.736111 0.243745
+ 0.738889 0.211907
+ 0.741667 0.359948
+ 0.744444 0.238722
+ 0.747222 0.209376
+ 0.750000 0.359944
+ 0.752778 0.242489
+ 0.755556 0.205624
+ 0.758333 0.359899
+ 0.761111 0.241234
+ 0.763889 0.209395
+ 0.766667 0.359929
+ 0.769444 0.239978
+ 0.772222 0.205619
+ 0.775000 0.359934
+ 0.777778 0.247512
+ 0.780556 0.205619
+ 0.783333 0.359919
+ 0.786111 0.245001
+ 0.788889 0.210666
+ 0.791667 0.359934
+ 0.794444 0.245001
+ 0.797222 0.206879
+ 0.800000 0.359939
+ 0.802778 0.247512
+ 0.805556 0.204378
+ 0.808333 0.359909
+ 0.811111 0.245001
+ 0.813889 0.215684
+ 0.816667 0.359963
+ 0.819444 0.245001
+ 0.822222 0.221957
+ 0.825000 0.359978
+ 0.827778 0.250023
+ 0.830556 0.230761
+ 0.833333 0.360002
+ 0.836111 0.255046
+ 0.838889 0.233307
+ 0.841667 0.360032
+ 0.844444 0.252535
+ 0.847222 0.230786
+ 0.850000 0.360017
+ 0.852778 0.261324
+ 0.855556 0.225778
+ 0.858333 0.359998
+ 0.861111 0.260069
+ 0.863889 0.225793
+ 0.866667 0.360022
+ 0.869444 0.253790
+ 0.872222 0.230776
+ 0.875000 0.359993
+ 0.877778 0.257557
+ 0.880556 0.215708
+ 0.883333 0.359944
+ 0.886111 0.251279
+ 0.888889 0.206914
+ 0.891667 0.359924
+ 0.894444 0.246256
+ 0.897222 0.200616
+ 0.900000 0.359919
+ 0.902778 0.247512
+ 0.905556 0.204368
+ 0.908333 0.359909
+ 0.911111 0.246256
+ 0.913889 0.205648
+ 0.916667 0.359914
+ 0.919444 0.245001
+ 0.922222 0.199335
+ 0.925000 0.359914
+ 0.927778 0.246256
+ 0.930556 0.199350
+ 0.933333 0.359885
+ 0.936111 0.245001
+ 0.938889 0.200601
+ 0.941667 0.359885
+ 0.944444 0.223654
+ 0.947222 0.170372
+ 0.950000 0.359767
+ 0.952778 0.222399
+ 0.955556 0.149133
+ 0.958333 0.379843
+ 0.961111 0.332976
+ 0.963889 0.268849
+ 0.966667 0.380466
+ 0.969444 0.428412
+ 0.972222 0.177528
+ 0.975000 0.381236
+ 0.977778 0.273886
+ 0.980556 0.342399
+ 0.983333 0.360071
+ 0.986111 0.232444
+ 0.988889 0.171681
+ 0.991667 0.359816
+ 0.994444 0.237467
+ 0.997222 0.191787
+ 1.000000 0.359865
+ 1.002778 0.236211
+ 1.005556 0.194283
+ 1.008333 0.359855
+ 1.011111 0.234955
+ 1.013889 0.191792
+ 1.016667 0.359865
+ 1.019444 0.234955
+ 1.022222 0.190506
+ 1.025000 0.359870
+ 1.027778 0.238722
+ 1.030556 0.193047
+ 1.033333 0.359860
+ 1.036111 0.238722
+ 1.038889 0.199335
+ 1.041667 0.359880
+ 1.044444 0.236211
+ 1.047222 0.195544
+ 1.050000 0.359885
+ 1.052778 0.242489
+ 1.055556 0.195559
+ 1.058333 0.359870
+ 1.061111 0.238722
+ 1.063889 0.195568
+ 1.066667 0.359885
+ 1.069444 0.236211
+ 1.072222 0.191787
+ 1.075000 0.359875
+ 1.077778 0.241234
+ 1.080556 0.194303
+ 1.083333 0.359865
+ 1.086111 0.237467
+ 1.088889 0.193057
+ 1.091667 0.359875
+ 1.094444 0.236211
+ 1.097222 0.194283
+ 1.100000 0.359880
+ 1.102778 0.242489
+ 1.105556 0.194298
+ 1.108333 0.359880
+ 1.111111 0.239978
+ 1.113889 0.196814
+ 1.116667 0.359890
+ 1.119444 0.232444
+ 1.122222 0.191767
+ 1.125000 0.359875
+ 1.127778 0.233700
+ 1.130556 0.191767
+ 1.133333 0.359860
+ 1.136111 0.228677
+ 1.138889 0.195524
+ 1.141667 0.359875
+ 1.144444 0.221143
+ 1.147222 0.191703
+ 1.150000 0.359865
+ 1.152778 0.217376
+ 1.155556 0.190438
+ 1.158333 0.359850
+ 1.161111 0.209842
+ 1.163889 0.192939
+ 1.166667 0.359875
+ 1.169444 0.202308
+ 1.172222 0.189143
+ 1.175000 0.359860
+ 1.177778 0.206075
+ 1.180556 0.190399
+ 1.183333 0.359850
+ 1.186111 0.211097
+ 1.188889 0.194215
+ 1.191667 0.359865
+ 1.194444 0.223654
+ 1.197222 0.199267
+ 1.200000 0.359909
+ 1.202778 0.237467
+ 1.205556 0.208120
+ 1.208333 0.359929
+ 1.211111 0.250023
+ 1.213889 0.219465
+ 1.216667 0.359963
+ 1.219444 0.247512
+ 1.222222 0.219456
+ 1.225000 0.359973
+ 1.227778 0.252535
+ 1.230556 0.221987
+ 1.233333 0.359983
+ 1.236111 0.253790
+ 1.238889 0.228275
+ 1.241667 0.359998
+ 1.244444 0.253790
+ 1.247222 0.225754
+ 1.250000 0.359993
+ 1.252778 0.257557
+ 1.255556 0.221991
+ 1.258333 0.359973
+ 1.261111 0.257557
+ 1.263889 0.224522
+ 1.266667 0.359988
+ 1.269444 0.251279
+ 1.272222 0.221977
+ 1.275000 0.359978
+ 1.277778 0.256302
+ 1.280556 0.219475
+ 1.283333 0.359968
+ 1.286111 0.252535
+ 1.288889 0.219475
+ 1.291667 0.359978
+ 1.294444 0.248768
+ 1.297222 0.215693
+ 1.300000 0.359968
+ 1.302778 0.250023
+ 1.305556 0.215689
+ 1.308333 0.359939
+ 1.311111 0.248768
+ 1.313889 0.216954
+ 1.316667 0.359953
+ 1.319444 0.243745
+ 1.322222 0.213153
+ 1.325000 0.359958
+ 1.327778 0.247512
+ 1.330556 0.211907
+ 1.333333 0.359924
+ 1.336111 0.245001
+ 1.338889 0.216949
+ 1.341667 0.359948
+ 1.344444 0.243745
+ 1.347222 0.208140
+ 1.350000 0.359948
+ 1.352778 0.247512
+ 1.355556 0.208159
+ 1.358333 0.359924
+ 1.361111 0.246256
+ 1.363889 0.211926
+ 1.366667 0.359939
+ 1.369444 0.245001
+ 1.372222 0.211907
+ 1.375000 0.359944
+ 1.377778 0.248768
+ 1.380556 0.211922
+ 1.383333 0.359939
+ 1.386111 0.251279
+ 1.388889 0.216954
+ 1.391667 0.359958
+ 1.394444 0.246256
+ 1.397222 0.215669
+ 1.400000 0.359953
+ 1.402778 0.252535
+ 1.405556 0.215684
+ 1.408333 0.359934
+ 1.411111 0.250023
+ 1.413889 0.218215
+ 1.416667 0.359958
+ 1.419444 0.248768
+ 1.422222 0.213167
+ 1.425000 0.359958
+ 1.427778 0.252535
+ 1.430556 0.218215
+ 1.433333 0.359983
+ 1.436111 0.250023
+ 1.438889 0.233283
+ 1.441667 0.360027
+ 1.444444 0.250023
+ 1.447222 0.235794
+ 1.450000 0.360056
+ 1.452778 0.258813
+ 1.455556 0.242082
+ 1.458333 0.360056
+ 1.461111 0.260069
+ 1.463889 0.238354
+ 1.466667 0.360042
+ 1.469444 0.262580
+ 1.472222 0.235838
+ 1.475000 0.360042
+ 1.477778 0.267603
+ 1.480556 0.238345
+ 1.483333 0.360056
+ 1.486111 0.260069
+ 1.488889 0.234568
+ 1.491667 0.360017
+ 1.494444 0.255046
+ 1.497222 0.220731
+ 1.500000 0.359973
+ 1.502778 0.253790
+ 1.505556 0.213177
+ 1.508333 0.359929
+ 1.511111 0.252535
+ 1.513889 0.211951
+ 1.516667 0.359944
+ 1.519444 0.246256
+ 1.522222 0.208145
+ 1.525000 0.359934
+ 1.527778 0.250023
+ 1.530556 0.206904
+ 1.533333 0.359909
+ 1.536111 0.250023
+ 1.538889 0.211931
+ 1.541667 0.359944
+ 1.544444 0.245001
+ 1.547222 0.206889
+ 1.550000 0.359934
+ 1.552778 0.231188
+ 1.555556 0.182933
+ 1.558333 0.359801
+ 1.561111 0.218632
+ 1.563889 0.159174
+ 1.566667 0.379872
+ 1.569444 0.340510
+ 1.572222 0.277677
+ 1.575000 0.380505
+ 1.577778 0.142119
+ 1.580556 0.193955
+ 1.583333 0.381270
+ 1.586111 0.263841
+ 1.588889 0.300996
+ 1.591667 0.359953
+ 1.594444 0.241234
+ 1.597222 0.193042
+ 1.600000 0.359914
+ 1.602778 0.236211
+ 1.605556 0.200571
+ 1.608333 0.359895
+ 1.611111 0.238722
+ 1.613889 0.203107
+ 1.616667 0.359904
+ 1.619444 0.234955
+ 1.622222 0.199301
+ 1.625000 0.359899
+ 1.627778 0.238722
+ 1.630556 0.198065
+ 1.633333 0.359875
+ 1.636111 0.237467
+ 1.638889 0.199326
+ 1.641667 0.359895
+ 1.644444 0.236211
+ 1.647222 0.195549
+ 1.650000 0.359890
+ 1.652778 0.238722
+ 1.655556 0.196809
+ 1.658333 0.359890
+ 1.661111 0.239978
+ 1.663889 0.201852
+ 1.666667 0.359899
+ 1.669444 0.234955
+ 1.672222 0.199316
+ 1.675000 0.359899
+ 1.677778 0.245001
+ 1.680556 0.196814
+ 1.683333 0.359885
+ 1.686111 0.238722
+ 1.688889 0.203102
+ 1.691667 0.359914
+ 1.694444 0.234955
+ 1.697222 0.199311
+ 1.700000 0.359895
+ 1.702778 0.238722
+ 1.705556 0.203083
+ 1.708333 0.359904
+ 1.711111 0.237467
+ 1.713889 0.206860
+ 1.716667 0.359914
+ 1.719444 0.232444
+ 1.722222 0.203063
+ 1.725000 0.359899
+ 1.727778 0.232444
+ 1.730556 0.201803
+ 1.733333 0.359890
+ 1.736111 0.226166
+ 1.738889 0.200527
+ 1.741667 0.359909
+ 1.744444 0.218632
+ 1.747222 0.199237
+ 1.750000 0.359895
+ 1.752778 0.213609
+ 1.755556 0.201729
+ 1.758333 0.359899
+ 1.761111 0.209842
+ 1.763889 0.200473
+ 1.766667 0.359904
+ 1.769444 0.202308
+ 1.772222 0.199188
+ 1.775000 0.359895
+ 1.777778 0.209842
+ 1.780556 0.199203
+ 1.783333 0.359895
+ 1.786111 0.213609
+ 1.788889 0.204270
+ 1.791667 0.359914
+ 1.794444 0.223654
+ 1.797222 0.208061
+ 1.800000 0.359934
+ 1.802778 0.236211
+ 1.805556 0.213123
+ 1.808333 0.359953
+ 1.811111 0.241234
+ 1.813889 0.216934
+ 1.816667 0.359963
+ 1.819444 0.247512
+ 1.822222 0.224483
+ 1.825000 0.360007
+ 1.827778 0.256302
+ 1.830556 0.227009
+ 1.833333 0.359993
+ 1.836111 0.258813
+ 1.838889 0.233317
+ 1.841667 0.360007
+ 1.844444 0.252535
+ 1.847222 0.224513
+ 1.850000 0.359998
+ 1.852778 0.258813
+ 1.855556 0.228270
+ 1.858333 0.359993
+ 1.861111 0.256302
+ 1.863889 0.228294
+ 1.866667 0.360012
+ 1.869444 0.253790
+ 1.872222 0.224483
+ 1.875000 0.359993
+ 1.877778 0.255046
+ 1.880556 0.225768
+ 1.883333 0.359983
+ 1.886111 0.253790
+ 1.888889 0.228275
+ 1.891667 0.360002
+ 1.894444 0.250023
+ 1.897222 0.221977
+ 1.900000 0.359988
+ 1.902778 0.253790
+ 1.905556 0.223223
+ 1.908333 0.359973
+ 1.911111 0.248768
+ 1.913889 0.221982
+ 1.916667 0.359988
+ 1.919444 0.248768
+ 1.922222 0.216949
+ 1.925000 0.359963
+ 1.927778 0.251279
+ 1.930556 0.216944
+ 1.933333 0.359948
+ 1.936111 0.252535
+ 1.938889 0.216969
+ 1.941667 0.359973
+ 1.944444 0.247512
+ 1.947222 0.218185
+ 1.950000 0.359983
+ 1.952778 0.251279
+ 1.955556 0.218205
+ 1.958333 0.359953
+ 1.961111 0.247512
+ 1.963889 0.219480
+ 1.966667 0.359973
+ 1.969444 0.248768
+ 1.972222 0.215693
+ 1.975000 0.359968
+ 1.977778 0.252535
+ 1.980556 0.215693
+ 1.983333 0.359958
+ 1.986111 0.253790
+ 1.988889 0.223257
+ 1.991667 0.359993
+ 1.994444 0.250023
+ 1.997222 0.218205
+ 2.000000 0.359978
+ 2.002778 0.256302
+ 2.005556 0.216974
+ 2.008333 0.359963
+ 2.011111 0.253790
+ 2.013889 0.220741
+ 2.016667 0.359983
+ 2.019444 0.253790
+ 2.022222 0.223242
+ 2.025000 0.360012
+ 2.027778 0.253790
+ 2.030556 0.235794
+ 2.033333 0.360027
+ 2.036111 0.261324
+ 2.038889 0.242102
+ 2.041667 0.360066
+ 2.044444 0.258813
+ 2.047222 0.247129
+ 2.050000 0.360096
+ 2.052778 0.266347
+ 2.055556 0.244628
+ 2.058333 0.360061
+ 2.061111 0.271370
+ 2.063889 0.243402
+ 2.066667 0.360066
+ 2.069444 0.271370
+ 2.072222 0.243382
+ 2.075000 0.360096
+ 2.077778 0.262580
+ 2.080556 0.235828
+ 2.083333 0.360022
+ 2.086111 0.261324
+ 2.088889 0.227053
+ 2.091667 0.359993
+ 2.094444 0.256302
+ 2.097222 0.216969
+ 2.100000 0.359973
+ 2.102778 0.258813
+ 2.105556 0.220750
+ 2.108333 0.359963
+ 2.111111 0.256302
+ 2.113889 0.220750
+ 2.116667 0.359978
+ 2.119444 0.252535
+ 2.122222 0.214452
+ 2.125000 0.359958
+ 2.127778 0.255046
+ 2.130556 0.214448
+ 2.133333 0.359939
+ 2.136111 0.253790
+ 2.138889 0.216983
+ 2.141667 0.359958
+ 2.144444 0.238722
+ 2.147222 0.196790
+ 2.150000 0.359855
+ 2.152778 0.218632
+ 2.155556 0.167870
+ 2.158333 0.359752
+ 2.161111 0.305351
+ 2.163889 0.236093
+ 2.166667 0.380275
+ 2.169444 0.404554
+ 2.172222 0.460000
+ 2.175000 0.381167
+ 2.177778 0.331725
+ 2.180556 0.409091
+ 2.183333 0.360331
+ 2.186111 0.245001
+ 2.188889 0.180535
+ 2.191667 0.359865
+ 2.194444 0.248768
+ 2.197222 0.206889
+ 2.200000 0.359924
+ 2.202778 0.247512
+ 2.205556 0.208145
+ 2.208333 0.359919
+ 2.211111 0.248768
+ 2.213889 0.210685
+ 2.216667 0.359944
+ 2.219444 0.242489
+ 2.222222 0.209386
+ 2.225000 0.359939
+ 2.227778 0.248768
+ 2.230556 0.208145
+ 2.233333 0.359914
+ 2.236111 0.247512
+ 2.238889 0.208159
+ 2.241667 0.359934
+ 2.244444 0.241234
+ 2.247222 0.208125
+ 2.250000 0.359924
+ 2.252778 0.250023
+ 2.255556 0.208155
+ 2.258333 0.359919
+ 2.261111 0.247512
+ 2.263889 0.213182
+ 2.266667 0.359939
+ 2.269444 0.246256
+ 2.272222 0.209400
+ 2.275000 0.359944
+ 2.277778 0.246256
+ 2.280556 0.206889
+ 2.283333 0.359909
+ 2.286111 0.247512
+ 2.288889 0.209410
+ 2.291667 0.359914
+ 2.294444 0.241234
+ 2.297222 0.204358
+ 2.300000 0.359924
+ 2.302778 0.247512
+ 2.305556 0.209391
+ 2.308333 0.359939
+ 2.311111 0.243745
+ 2.313889 0.211897
+ 2.316667 0.359934
+ 2.319444 0.234955
+ 2.322222 0.206830
+ 2.325000 0.359924
+ 2.327778 0.237467
+ 2.330556 0.205579
+ 2.333333 0.359914
+ 2.336111 0.229933
+ 2.338889 0.213109
+ 2.341667 0.359929
+ 2.344444 0.221143
+ 2.347222 0.208042
+ 2.350000 0.359939
+ 2.352778 0.222399
+ 2.355556 0.204270
+ 2.358333 0.359899
+ 2.361111 0.217376
+ 2.363889 0.205525
+ 2.366667 0.359924
+ 2.369444 0.213609
+ 2.372222 0.202985
+ 2.375000 0.359909
+ 2.377778 0.219887
+ 2.380556 0.204275
+ 2.383333 0.359914
+ 2.386111 0.229933
+ 2.388889 0.213123
+ 2.391667 0.359948
+ 2.394444 0.237467
+ 2.397222 0.216905
+ 2.400000 0.359968
+ 2.402778 0.248768
+ 2.405556 0.223227
+ 2.408333 0.359978
+ 2.411111 0.252535
+ 2.413889 0.230781
+ 2.416667 0.360017
+ 2.419444 0.250023
+ 2.422222 0.232017
+ 2.425000 0.360027
+ 2.427778 0.256302
+ 2.430556 0.232037
+ 2.433333 0.360012
+ 2.436111 0.253790
+ 2.438889 0.235804
+ 2.441667 0.360027
+ 2.444444 0.247512
+ 2.447222 0.226985
+ 2.450000 0.360012
+ 2.452778 0.251279
+ 2.455556 0.225739
+ 2.458333 0.359988
+ 2.461111 0.248768
+ 2.463889 0.228265
+ 2.466667 0.360007
+ 2.469444 0.243745
+ 2.472222 0.225709
+ 2.475000 0.359993
+ 2.477778 0.250023
+ 2.480556 0.225734
+ 2.483333 0.359988
+ 2.486111 0.245001
+ 2.488889 0.226980
+ 2.491667 0.359998
+ 2.494444 0.242489
+ 2.497222 0.220682
+ 2.500000 0.359978
+ 2.502778 0.239978
+ 2.505556 0.215659
+ 2.508333 0.359968
+ 2.511111 0.242489
+ 2.513889 0.218195
+ 2.516667 0.359968
+ 2.519444 0.239978
+ 2.522222 0.218161
+ 2.525000 0.359958
+ 2.527778 0.243745
+ 2.530556 0.216915
+ 2.533333 0.359953
+ 2.536111 0.241234
+ 2.538889 0.216925
+ 2.541667 0.359968
+ 2.544444 0.237467
+ 2.547222 0.214384
+ 2.550000 0.359958
+ 2.552778 0.239978
+ 2.555556 0.220667
+ 2.558333 0.359963
+ 2.561111 0.241234
+ 2.563889 0.216920
+ 2.566667 0.359973
+ 2.569444 0.242489
+ 2.572222 0.218170
+ 2.575000 0.359978
+ 2.577778 0.239978
+ 2.580556 0.216900
+ 2.583333 0.359953
+ 2.586111 0.246256
+ 2.588889 0.218190
+ 2.591667 0.359988
+ 2.594444 0.232444
+ 2.597222 0.215635
+ 2.600000 0.359988
+ 2.602778 0.242489
+ 2.605556 0.230712
+ 2.608333 0.360012
+ 2.611111 0.242489
+ 2.613889 0.238281
+ 2.616667 0.360056
+ 2.619444 0.245001
+ 2.622222 0.240792
+ 2.625000 0.360071
+ 2.627778 0.247512
+ 2.630556 0.243308
+ 2.633333 0.360047
+ 2.636111 0.253790
+ 2.638889 0.239566
+ 2.641667 0.360042
+ 2.644444 0.245001
+ 2.647222 0.230747
+ 2.650000 0.360032
+ 2.652778 0.246256
+ 2.655556 0.234514
+ 2.658333 0.359998
+ 2.661111 0.242489
+ 2.663889 0.221957
+ 2.666667 0.359968
+ 2.669444 0.233700
+ 2.672222 0.210607
+ 2.675000 0.359953
+ 2.677778 0.239978
+ 2.680556 0.216905
+ 2.683333 0.359948
+ 2.686111 0.242489
+ 2.688889 0.214399
+ 2.691667 0.359944
+ 2.694444 0.234955
+ 2.697222 0.208096
+ 2.700000 0.359929
+ 2.702778 0.236211
+ 2.705556 0.204334
+ 2.708333 0.359919
+ 2.711111 0.232444
+ 2.713889 0.209366
+ 2.716667 0.359934
+ 2.719444 0.228677
+ 2.722222 0.200517
+ 2.725000 0.359875
+ 2.727778 0.211097
+ 2.730556 0.177852
+ 2.733333 0.359762
+ 2.736111 0.255046
+ 2.738889 0.198242
+ 2.741667 0.380108
+ 2.744444 0.329209
+ 2.747222 0.385621
+ 2.750000 0.380966
+ 2.752778 0.359350
+ 2.755556 0.155583
+ 2.758333 0.360674
+ 2.761111 0.197290
+ 2.763889 0.191679
+ 2.766667 0.359811
+ 2.769444 0.221143
+ 2.772222 0.196746
+ 2.775000 0.359904
+ 2.777778 0.228677
+ 2.780556 0.201778
+ 2.783333 0.359890
+ 2.786111 0.222399
+ 2.788889 0.199267
+ 2.791667 0.359895
+ 2.794444 0.223654
+ 2.797222 0.203034
+ 2.800000 0.359909
+ 2.802778 0.228677
+ 2.805556 0.200532
+ 2.808333 0.359895
+ 2.811111 0.227421
+ 2.813889 0.204304
+ 2.816667 0.359904
+ 2.819444 0.223654
+ 2.822222 0.197996
+ 2.825000 0.359895
+ 2.827778 0.223654
+ 2.830556 0.198011
+ 2.833333 0.359880
+ 2.836111 0.223654
+ 2.838889 0.196765
+ 2.841667 0.359890
+ 2.844444 0.219887
+ 2.847222 0.195480
+ 2.850000 0.359904
+ 2.852778 0.224910
+ 2.855556 0.196765
+ 2.858333 0.359885
+ 2.861111 0.222399
+ 2.863889 0.199272
+ 2.866667 0.359875
+ 2.869444 0.223654
+ 2.872222 0.196755
+ 2.875000 0.359890
+ 2.877778 0.224910
+ 2.880556 0.195495
+ 2.883333 0.359875
+ 2.886111 0.223654
+ 2.888889 0.198021
+ 2.891667 0.359885
+ 2.894444 0.218632
+ 2.897222 0.196721
+ 2.900000 0.359899
+ 2.902778 0.219887
+ 2.905556 0.199252
+ 2.908333 0.359885
+ 2.911111 0.217376
+ 2.913889 0.200503
+ 2.916667 0.359895
+ 2.919444 0.208586
+ 2.922222 0.195431
+ 2.925000 0.359880
+ 2.927778 0.207330
+ 2.930556 0.190394
+ 2.933333 0.359850
+ 2.936111 0.201052
+ 2.938889 0.190379
+ 2.941667 0.359850
+ 2.944444 0.189751
+ 2.947222 0.181545
+ 2.950000 0.359841
+ 2.952778 0.191007
+ 2.955556 0.182806
+ 2.958333 0.359841
+ 2.961111 0.193518
+ 2.963889 0.189123
+ 2.966667 0.359855
+ 2.969444 0.198541
+ 2.972222 0.191639
+ 2.975000 0.359865
+ 2.977778 0.216120
+ 2.980556 0.199237
+ 2.983333 0.359909
+ 2.986111 0.227421
+ 2.988889 0.211858
+ 2.991667 0.359944
+ 2.994444 0.233700
+ 2.997222 0.214379
+ 3.000000 0.359973
+ 3.002778 0.239978
+ 3.005556 0.223188
+ 3.008333 0.359983
+ 3.011111 0.241234
+ 3.013889 0.224459
+ 3.016667 0.359993
+ 3.019444 0.238722
+ 3.022222 0.223183
+ 3.025000 0.359993
+ 3.027778 0.246256
+ 3.030556 0.225709
+ 3.033333 0.359988
+ 3.036111 0.245001
+ 3.038889 0.226970
+ 3.041667 0.360002
+ 3.044444 0.241234
+ 3.047222 0.219431
+ 3.050000 0.359978
+ 3.052778 0.245001
+ 3.055556 0.219436
+ 3.058333 0.359963
+ 3.061111 0.245001
+ 3.063889 0.223208
+ 3.066667 0.359978
+ 3.069444 0.241234
+ 3.072222 0.218166
+ 3.075000 0.359978
+ 3.077778 0.242489
+ 3.080556 0.219426
+ 3.083333 0.359963
+ 3.086111 0.241234
+ 3.088889 0.221937
+ 3.091667 0.359978
+ 3.094444 0.237467
+ 3.097222 0.219421
+ 3.100000 0.359973
+ 3.102778 0.239978
+ 3.105556 0.216905
+ 3.108333 0.359953
+ 3.111111 0.237467
+ 3.113889 0.216915
+ 3.116667 0.359968
+ 3.119444 0.236211
+ 3.122222 0.213138
+ 3.125000 0.359958
+ 3.127778 0.238722
+ 3.130556 0.213138
+ 3.133333 0.359948
+ 3.136111 0.239978
+ 3.138889 0.219431
+ 3.141667 0.359973
+ 3.144444 0.237467
+ 3.147222 0.214384
+ 3.150000 0.359978
+ 3.152778 0.241234
+ 3.155556 0.216905
+ 3.158333 0.359948
+ 3.161111 0.237467
+ 3.163889 0.215659
+ 3.166667 0.359953
+ 3.169444 0.237467
+ 3.172222 0.214394
+ 3.175000 0.359963
+ 3.177778 0.241234
+ 3.180556 0.215654
+ 3.183333 0.359953
+ 3.186111 0.242489
+ 3.188889 0.219436
+ 3.191667 0.359968
+ 3.194444 0.237467
+ 3.197222 0.216890
+ 3.200000 0.359968
+ 3.202778 0.241234
+ 3.205556 0.219426
+ 3.208333 0.359968
+ 3.211111 0.238722
+ 3.213889 0.226960
+ 3.216667 0.360012
+ 3.219444 0.239978
+ 3.222222 0.230717
+ 3.225000 0.360037
+ 3.227778 0.243745
+ 3.230556 0.235765
+ 3.233333 0.360042
+ 3.236111 0.247512
+ 3.238889 0.244584
+ 3.241667 0.360071
+ 3.244444 0.250023
+ 3.247222 0.240802
+ 3.250000 0.360056
+ 3.252778 0.250023
+ 3.255556 0.240812
+ 3.258333 0.360047
+ 3.261111 0.252535
+ 3.263889 0.243348
+ 3.266667 0.360056
+ 3.269444 0.250023
+ 3.272222 0.237040
+ 3.275000 0.360066
+ 3.277778 0.250023
+ 3.280556 0.239541
+ 3.283333 0.360017
+ 3.286111 0.247512
+ 3.288889 0.224478
+ 3.291667 0.359973
+ 3.294444 0.241234
+ 3.297222 0.211897
+ 3.300000 0.359953
+ 3.302778 0.243745
+ 3.305556 0.214399
+ 3.308333 0.359958
+ 3.311111 0.238722
+ 3.313889 0.218175
+ 3.316667 0.359973
+ 3.319444 0.238722
+ 3.322222 0.213133
+ 3.325000 0.359958
+ 3.327778 0.241234
+ 3.330556 0.213143
+ 3.333333 0.359919
+ 3.336111 0.242489
+ 3.338889 0.214418
+ 3.341667 0.359953
+ 3.344444 0.238722
+ 3.347222 0.210617
+ 3.350000 0.359934
+ 3.352778 0.222399
+ 3.355556 0.189197
+ 3.358333 0.359831
+ 3.361111 0.207330
+ 3.363889 0.167875
+ 3.366667 0.359767
+ 3.369444 0.314141
+ 3.372222 0.253727
+ 3.375000 0.380373
+ 3.377778 0.432179
+ 3.380556 0.160007
+ 3.383333 0.381231
+ 3.386111 0.348049
+ 3.388889 0.427990
+ 3.391667 0.360390
+ 3.394444 0.228677
+ 3.397222 0.181722
+ 3.400000 0.359860
+ 3.402778 0.237467
+ 3.405556 0.204324
+ 3.408333 0.359904
+ 3.411111 0.232444
+ 3.413889 0.206850
+ 3.416667 0.359909
+ 3.419444 0.228677
+ 3.422222 0.200552
+ 3.425000 0.359914
+ 3.427778 0.233700
+ 3.430556 0.204319
+ 3.433333 0.359899
+ 3.436111 0.234955
+ 3.438889 0.204334
+ 3.441667 0.359909
+ 3.444444 0.228677
+ 3.447222 0.204314
+ 3.450000 0.359919
+ 3.452778 0.231188
+ 3.455556 0.206830
+ 3.458333 0.359909
+ 3.461111 0.233700
+ 3.463889 0.208115
+ 3.466667 0.359929
+ 3.469444 0.231188
+ 3.472222 0.205570
+ 3.475000 0.359919
+ 3.477778 0.233700
+ 3.480556 0.204334
+ 3.483333 0.359909
+ 3.486111 0.233700
+ 3.488889 0.206845
+ 3.491667 0.359929
+ 3.494444 0.228677
+ 3.497222 0.201807
+ 3.500000 0.359919
+ 3.502778 0.234955
+ 3.505556 0.208086
+ 3.508333 0.359909
+ 3.511111 0.231188
+ 3.513889 0.208086
+ 3.516667 0.359934
+ 3.519444 0.226166
+ 3.522222 0.204294
+ 3.525000 0.359919
+ 3.527778 0.228677
+ 3.530556 0.204289
+ 3.533333 0.359914
+ 3.536111 0.224910
+ 3.538889 0.208066
+ 3.541667 0.359929
+ 3.544444 0.217376
+ 3.547222 0.206776
+ 3.550000 0.359934
+ 3.552778 0.214865
+ 3.555556 0.206742
+ 3.558333 0.359909
+ 3.561111 0.206075
+ 3.563889 0.205481
+ 3.566667 0.359914
+ 3.569444 0.199796
+ 3.572222 0.199169
+ 3.575000 0.359904
+ 3.577778 0.201052
+ 3.580556 0.199169
+ 3.583333 0.359885
+ 3.586111 0.197285
+ 3.588889 0.200429
+ 3.591667 0.359909
+ 3.594444 0.201052
+ 3.597222 0.200439
+ 3.600000 0.359909
+ 3.602778 0.217376
+ 3.605556 0.211809
+ 3.608333 0.359948
+ 3.611111 0.229933
+ 3.613889 0.223183
+ 3.616667 0.359988
+ 3.619444 0.237467
+ 3.622222 0.225704
+ 3.625000 0.359998
+ 3.627778 0.248768
+ 3.630556 0.228235
+ 3.633333 0.360002
+ 3.636111 0.252535
+ 3.638889 0.234558
+ 3.641667 0.360027
+ 3.644444 0.248768
+ 3.647222 0.234533
+ 3.650000 0.360042
+ 3.652778 0.253790
+ 3.655556 0.233288
+ 3.658333 0.360012
+ 3.661111 0.252535
+ 3.663889 0.233288
+ 3.666667 0.360027
+ 3.669444 0.248768
+ 3.672222 0.230752
+ 3.675000 0.360037
+ 3.677778 0.255046
+ 3.680556 0.233288
+ 3.683333 0.360007
+ 3.686111 0.252535
+ 3.688889 0.229521
+ 3.691667 0.360012
+ 3.694444 0.248768
+ 3.697222 0.226985
+ 3.700000 0.360012
+ 3.702778 0.247512
+ 3.705556 0.225739
+ 3.708333 0.359993
+ 3.711111 0.250023
+ 3.713889 0.224483
+ 3.716667 0.359998
+ 3.719444 0.241234
+ 3.722222 0.223193
+ 3.725000 0.359993
+ 3.727778 0.248768
+ 3.730556 0.221952
+ 3.733333 0.359988
+ 3.736111 0.243745
+ 3.738889 0.223208
+ 3.741667 0.359993
+ 3.744444 0.241234
+ 3.747222 0.218170
+ 3.750000 0.359968
+ 3.752778 0.242489
+ 3.755556 0.218175
+ 3.758333 0.359958
+ 3.761111 0.239978
+ 3.763889 0.220692
+ 3.766667 0.359978
+ 3.769444 0.236211
+ 3.772222 0.216905
+ 3.775000 0.359958
+ 3.777778 0.241234
+ 3.780556 0.220677
+ 3.783333 0.359963
+ 3.786111 0.239978
+ 3.788889 0.220682
+ 3.791667 0.359988
+ 3.794444 0.238722
+ 3.797222 0.216910
+ 3.800000 0.359973
+ 3.802778 0.239978
+ 3.805556 0.216915
+ 3.808333 0.359953
+ 3.811111 0.238722
+ 3.813889 0.220687
+ 3.816667 0.359983
+ 3.819444 0.238722
+ 3.822222 0.219426
+ 3.825000 0.359978
+ 3.827778 0.242489
+ 3.830556 0.221933
+ 3.833333 0.359968
+ 3.836111 0.238722
+ 3.838889 0.224454
+ 3.841667 0.359983
+ 3.844444 0.237467
+ 3.847222 0.220672
+ 3.850000 0.359993
+ 3.852778 0.242489
+ 3.855556 0.225695
+ 3.858333 0.360012
+ 3.861111 0.243745
+ 3.863889 0.235765
+ 3.866667 0.360037
+ 3.869444 0.242489
+ 3.872222 0.240773
+ 3.875000 0.360056
+ 3.877778 0.248768
+ 3.880556 0.245825
+ 3.883333 0.360066
+ 3.886111 0.248768
+ 3.888889 0.244584
+ 3.891667 0.360066
+ 3.894444 0.255046
+ 3.897222 0.239571
+ 3.900000 0.360076
+ 3.902778 0.255046
+ 3.905556 0.239571
+ 3.908333 0.360056
+ 3.911111 0.253790
+ 3.913889 0.252128
+ 3.916667 0.360071
+ 3.919444 0.245001
+ 3.922222 0.226970
+ 3.925000 0.359998
+ 3.927778 0.243745
+ 3.930556 0.218185
+ 3.933333 0.359953
+ 3.936111 0.239978
+ 3.938889 0.218175
+ 3.941667 0.359953
+ 3.944444 0.237467
+ 3.947222 0.211868
+ 3.950000 0.359948
+ 3.952778 0.238722
+ 3.955556 0.210617
+ 3.958333 0.359934
+ 3.961111 0.237467
+ 3.963889 0.211902
+ 3.966667 0.359948
+ 3.969444 0.234955
+ 3.972222 0.211858
+ 3.975000 0.359944
+ 3.977778 0.237467
+ 3.980556 0.209342
+ 3.983333 0.359904
+ 3.986111 0.216120
+ 3.988889 0.185415
+ 3.991667 0.359831
+ 3.994444 0.201052
+ 3.997222 0.175281
+ 4.000000 0.359772
+ 4.002778 0.214865
+ 4.005556 0.159134
+ 4.008333 0.379882
+ 4.011111 0.324186
+ 4.013889 0.265042
+ 4.016667 0.380422
+ 4.019444 0.427156
+ 4.022222 0.159963
+ 4.025000 0.381207
+ 4.027778 0.329214
+ 4.030556 0.402803
+ 4.033333 0.360287
+ 4.036111 0.227421
+ 4.038889 0.182968
+ 4.041667 0.359845
+ 4.044444 0.227421
+ 4.047222 0.203044
+ 4.050000 0.359909
+ 4.052778 0.226166
+ 4.055556 0.205560
+ 4.058333 0.359909
+ 4.061111 0.228677
+ 4.063889 0.205570
+ 4.066667 0.359914
+ 4.069444 0.224910
+ 4.072222 0.199267
+ 4.075000 0.359919
+ 4.077778 0.229933
+ 4.080556 0.201793
+ 4.083333 0.359899
+ 4.086111 0.227421
+ 4.088889 0.206820
+ 4.091667 0.359919
+ 4.094444 0.226166
+ 4.097222 0.203048
+ 4.100000 0.359924
+ 4.102778 0.229933
+ 4.105556 0.204319
+ 4.108333 0.359899
+ 4.111111 0.229933
+ 4.113889 0.206830
+ 4.116667 0.359914
+ 4.119444 0.228677
+ 4.122222 0.201783
+ 4.125000 0.359924
+ 4.127778 0.232444
+ 4.130556 0.206820
+ 4.133333 0.359914
+ 4.136111 0.228677
+ 4.138889 0.209346
+ 4.141667 0.359934
+ 4.144444 0.227421
+ 4.147222 0.201783
+ 4.150000 0.359924
+ 4.152778 0.227421
+ 4.155556 0.204289
+ 4.158333 0.359909
+ 4.161111 0.226166
+ 4.163889 0.205550
+ 4.166667 0.359914
+ 4.169444 0.221143
+ 4.172222 0.204270
+ 4.175000 0.359924
+ 4.177778 0.219887
+ 4.180556 0.205521
+ 4.183333 0.359895
+ 4.186111 0.216120
+ 4.188889 0.205521
+ 4.191667 0.359919
+ 4.194444 0.207330
+ 4.197222 0.204226
+ 4.200000 0.359924
+ 4.202778 0.208586
+ 4.205556 0.205476
+ 4.208333 0.359909
+ 4.211111 0.198541
+ 4.213889 0.202941
+ 4.216667 0.359899
+ 4.219444 0.193518
+ 4.222222 0.200400
+ 4.225000 0.359909
+ 4.227778 0.196029
+ 4.230556 0.204177
+ 4.233333 0.359890
+ 4.236111 0.198541
+ 4.238889 0.206712
+ 4.241667 0.359914
+ 4.244444 0.203563
+ 4.247222 0.207988
+ 4.250000 0.359939
+ 4.252778 0.221143
+ 4.255556 0.216866
+ 4.258333 0.359953
+ 4.261111 0.233700
+ 4.263889 0.224434
+ 4.266667 0.359988
+ 4.269444 0.238722
+ 4.272222 0.228216
+ 4.275000 0.360012
+ 4.277778 0.247512
+ 4.280556 0.226960
+ 4.283333 0.360002
+ 4.286111 0.250023
+ 4.288889 0.230761
+ 4.291667 0.360012
+ 4.294444 0.245001
+ 4.297222 0.226975
+ 4.300000 0.360022
+ 4.302778 0.250023
+ 4.305556 0.232002
+ 4.308333 0.360017
+ 4.311111 0.245001
+ 4.313889 0.230747
+ 4.316667 0.360012
+ 4.319444 0.241234
+ 4.322222 0.223198
+ 4.325000 0.360002
+ 4.327778 0.243745
+ 4.330556 0.225704
+ 4.333333 0.359993
+ 4.336111 0.241234
+ 4.338889 0.228235
+ 4.341667 0.359993
+ 4.344444 0.234955
+ 4.347222 0.220657
+ 4.350000 0.359988
+ 4.352778 0.241234
+ 4.355556 0.223193
+ 4.358333 0.359968
+ 4.361111 0.238722
+ 4.363889 0.223188
+ 4.366667 0.359993
+ 4.369444 0.236211
+ 4.372222 0.216885
+ 4.375000 0.359968
+ 4.377778 0.237467
+ 4.380556 0.216885
+ 4.383333 0.359948
+ 4.386111 0.232444
+ 4.388889 0.216900
+ 4.391667 0.359958
+ 4.394444 0.232444
+ 4.397222 0.213113
+ 4.400000 0.359953
+ 4.402778 0.233700
+ 4.405556 0.216890
+ 4.408333 0.359944
+ 4.411111 0.232444
+ 4.413889 0.216880
+ 4.416667 0.359968
+ 4.419444 0.229933
+ 4.422222 0.214369
+ 4.425000 0.359953
+ 4.427778 0.236211
+ 4.430556 0.215635
+ 4.433333 0.359948
+ 4.436111 0.234955
+ 4.438889 0.218146
+ 4.441667 0.359948
+ 4.444444 0.227421
+ 4.447222 0.210582
+ 4.450000 0.359948
+ 4.452778 0.234955
+ 4.455556 0.211863
+ 4.458333 0.359944
+ 4.461111 0.233700
+ 4.463889 0.218151
+ 4.466667 0.359963
+ 4.469444 0.227421
+ 4.472222 0.216871
+ 4.475000 0.359978
+ 4.477778 0.231188
+ 4.480556 0.229437
+ 4.483333 0.360017
+ 4.486111 0.232444
+ 4.488889 0.231968
+ 4.491667 0.360017
+ 4.494444 0.236211
+ 4.497222 0.235730
+ 4.500000 0.360047
+ 4.502778 0.241234
+ 4.505556 0.239497
+ 4.508333 0.360042
+ 4.511111 0.243745
+ 4.513889 0.238271
+ 4.516667 0.360052
+ 4.519444 0.242489
+ 4.522222 0.238251
+ 4.525000 0.360042
+ 4.527778 0.245001
+ 4.530556 0.231983
+ 4.533333 0.360042
+ 4.536111 0.238722
+ 4.538889 0.242018
+ 4.541667 0.360037
+ 4.544444 0.229933
+ 4.547222 0.225655
+ 4.550000 0.360007
+ 4.552778 0.234955
+ 4.555556 0.215625
+ 4.558333 0.359944
+ 4.561111 0.228677
+ 4.563889 0.213109
+ 4.566667 0.359944
+ 4.569444 0.224910
+ 4.572222 0.208052
+ 4.575000 0.359929
+ 4.577778 0.227421
+ 4.580556 0.206815
+ 4.583333 0.359914
+ 4.586111 0.227421
+ 4.588889 0.208076
+ 4.591667 0.359939
+ 4.594444 0.221143
+ 4.597222 0.203024
+ 4.600000 0.359924
+ 4.602778 0.224910
+ 4.605556 0.203019
+ 4.608333 0.359895
+ 4.611111 0.204819
+ 4.613889 0.180363
+ 4.616667 0.359792
+ 4.619444 0.206075
+ 4.622222 0.157844
+ 4.625000 0.359796
+ 4.627778 0.292716
+ 4.630556 0.263635
+ 4.633333 0.380451
+ 4.636111 0.385719
+ 4.638889 0.162259
+ 4.641667 0.381143
+ 4.644444 0.238727
+ 4.647222 0.319698
+ 4.650000 0.360091
+ 4.652778 0.208586
+ 4.655556 0.172844
+ 4.658333 0.359811
+ 4.661111 0.212353
+ 4.663889 0.192969
+ 4.666667 0.359870
+ 4.669444 0.213609
+ 4.672222 0.195451
+ 4.675000 0.359885
+ 4.677778 0.216120
+ 4.680556 0.194210
+ 4.683333 0.359860
+ 4.686111 0.214865
+ 4.688889 0.197987
+ 4.691667 0.359885
+ 4.694444 0.208586
+ 4.697222 0.195446
+ 4.700000 0.359880
+ 4.702778 0.217376
+ 4.705556 0.194210
+ 4.708333 0.359870
+ 4.711111 0.216120
+ 4.713889 0.197987
+ 4.716667 0.359890
+ 4.719444 0.212353
+ 4.722222 0.196721
+ 4.725000 0.359890
+ 4.727778 0.218632
+ 4.730556 0.192969
+ 4.733333 0.359870
+ 4.736111 0.213609
+ 4.738889 0.192954
+ 4.741667 0.359875
+ 4.744444 0.213609
+ 4.747222 0.190433
+ 4.750000 0.359865
+ 4.752778 0.216120
+ 4.755556 0.189177
+ 4.758333 0.359855
+ 4.761111 0.216120
+ 4.763889 0.190457
+ 4.766667 0.359870
+ 4.769444 0.214865
+ 4.772222 0.192949
+ 4.775000 0.359870
+ 4.777778 0.217376
+ 4.780556 0.194205
+ 4.783333 0.359855
+ 4.786111 0.213609
+ 4.788889 0.195456
+ 4.791667 0.359875
+ 4.794444 0.211097
+ 4.797222 0.192929
+ 4.800000 0.359870
+ 4.802778 0.208586
+ 4.805556 0.191669
+ 4.808333 0.359860
+ 4.811111 0.203563
+ 4.813889 0.197937
+ 4.816667 0.359880
+ 4.819444 0.193518
+ 4.822222 0.191595
+ 4.825000 0.359865
+ 4.827778 0.192262
+ 4.830556 0.187828
+ 4.833333 0.359831
+ 4.836111 0.184728
+ 4.838889 0.186568
+ 4.841667 0.359845
+ 4.844444 0.182217
+ 4.847222 0.186533
+ 4.850000 0.359841
+ 4.852778 0.183473
+ 4.855556 0.184022
+ 4.858333 0.359836
+ 4.861111 0.189751
+ 4.863889 0.190364
+ 4.866667 0.359865
+ 4.869444 0.199796
+ 4.872222 0.200434
+ 4.875000 0.359904
+ 4.877778 0.209842
+ 4.880556 0.202980
+ 4.883333 0.359919
+ 4.886111 0.224910
+ 4.888889 0.219367
+ 4.891667 0.359968
+ 4.894444 0.217376
+ 4.897222 0.214315
+ 4.900000 0.359963
+ 4.902778 0.224910
+ 4.905556 0.215605
+ 4.908333 0.359948
+ 4.911111 0.222399
+ 4.913889 0.218112
+ 4.916667 0.359968
+ 4.919444 0.222399
+ 4.922222 0.215576
+ 4.925000 0.359973
+ 4.927778 0.224910
+ 4.930556 0.219357
+ 4.933333 0.359958
+ 4.936111 0.223654
+ 4.938889 0.216856
+ 4.941667 0.359968
+ 4.944444 0.218632
+ 4.947222 0.211799
+ 4.950000 0.359958
+ 4.952778 0.222399
+ 4.955556 0.214325
+ 4.958333 0.359948
+ 4.961111 0.218632
+ 4.963889 0.220603
+ 4.966667 0.359978
+ 4.969444 0.219887
+ 4.972222 0.213055
+ 4.975000 0.359958
+ 4.977778 0.213609
+ 4.980556 0.210529
+ 4.983333 0.359924
+ 4.986111 0.212353
+ 4.988889 0.209288
+ 4.991667 0.359934
+ 4.994444 0.211097
+ 4.997222 0.209258
+ 5.000000 0.359939
+ 5.002778 0.212353
+ 5.005556 0.208012
+ 5.008333 0.359929
+ 5.011111 0.211097
+ 5.013889 0.211794
+ 5.016667 0.359939
+ 5.019444 0.209842
+ 5.022222 0.206747
+ 5.025000 0.359924
+ 5.027778 0.212353
+ 5.030556 0.208002
+ 5.033333 0.359919
+ 5.036111 0.211097
+ 5.038889 0.208022
+ 5.041667 0.359929
+ 5.044444 0.212353
+ 5.047222 0.205476
+ 5.050000 0.359929
+ 5.052778 0.211097
+ 5.055556 0.208007
+ 5.058333 0.359934
+ 5.061111 0.211097
+ 5.063889 0.210519
+ 5.066667 0.359939
+ 5.069444 0.207330
+ 5.072222 0.205486
+ 5.075000 0.359929
+ 5.077778 0.213609
+ 5.080556 0.207998
+ 5.083333 0.359929
+ 5.086111 0.208586
+ 5.088889 0.211779
+ 5.091667 0.359948
+ 5.094444 0.209842
+ 5.097222 0.206742
+ 5.100000 0.359948
+ 5.102778 0.212353
+ 5.105556 0.216792
+ 5.108333 0.359958
+ 5.111111 0.213609
+ 5.113889 0.225611
+ 5.116667 0.360012
+ 5.119444 0.216120
+ 5.122222 0.229368
+ 5.125000 0.360042
+ 5.127778 0.221143
+ 5.130556 0.234406
+ 5.133333 0.360022
+ 5.136111 0.221143
+ 5.138889 0.233175
+ 5.141667 0.360022
+ 5.144444 0.222399
+ 5.147222 0.223115
+ 5.150000 0.359998
+ 5.152778 0.221143
+ 5.155556 0.231899
+ 5.158333 0.360017
+ 5.161111 0.218632
+ 5.163889 0.220603
+ 5.166667 0.359973
+ 5.169444 0.208586
+ 5.172222 0.208007
+ 5.175000 0.359929
+ 5.177778 0.212353
+ 5.180556 0.202990
+ 5.183333 0.359909
+ 5.186111 0.209842
+ 5.188889 0.206752
+ 5.191667 0.359914
+ 5.194444 0.211097
+ 5.197222 0.200478
+ 5.200000 0.359904
+ 5.202778 0.213609
+ 5.205556 0.199227
+ 5.208333 0.359890
+ 5.211111 0.211097
+ 5.213889 0.205516
+ 5.216667 0.359909
+ 5.219444 0.213609
+ 5.222222 0.200473
+ 5.225000 0.359904
+ 5.227778 0.207330
+ 5.230556 0.194156
+ 5.233333 0.359836
+ 5.236111 0.188495
+ 5.238889 0.174011
+ 5.241667 0.359757
+ 5.244444 0.227421
+ 5.247222 0.183061
+ 5.250000 0.380044
+ 5.252778 0.315397
+ 5.255556 0.341614
+ 5.258333 0.380785
+ 5.261111 0.397020
+ 5.263889 0.187299
+ 5.266667 0.361008
+ 5.269444 0.184733
+ 5.272222 0.243039
+ 5.275000 0.359890
+ 5.277778 0.204819
+ 5.280556 0.177857
+ 5.283333 0.359831
+ 5.286111 0.211097
+ 5.288889 0.194205
+ 5.291667 0.359865
+ 5.294444 0.212353
+ 5.297222 0.195451
+ 5.300000 0.359885
+ 5.302778 0.211097
+ 5.305556 0.195460
+ 5.308333 0.359860
+ 5.311111 0.209842
+ 5.313889 0.195475
+ 5.316667 0.359875
+ 5.319444 0.208586
+ 5.322222 0.190423
+ 5.325000 0.359870
+ 5.327778 0.217376
+ 5.330556 0.187931
+ 5.333333 0.359841
+ 5.336111 0.213609
+ 5.338889 0.190448
+ 5.341667 0.359850
+ 5.344444 0.213609
+ 5.347222 0.189177
+ 5.350000 0.359860
+ 5.352778 0.217376
+ 5.355556 0.189187
+ 5.358333 0.359855
+ 5.361111 0.216120
+ 5.363889 0.192959
+ 5.366667 0.359870
+ 5.369444 0.212353
+ 5.372222 0.190433
+ 5.375000 0.359865
+ 5.377778 0.218632
+ 5.380556 0.191698
+ 5.383333 0.359850
+ 5.386111 0.208586
+ 5.388889 0.191693
+ 5.391667 0.359860
+ 5.394444 0.211097
+ 5.397222 0.187917
+ 5.400000 0.359855
+ 5.402778 0.212353
+ 5.405556 0.189172
+ 5.408333 0.359841
+ 5.411111 0.207330
+ 5.413889 0.189177
+ 5.416667 0.359860
+ 5.419444 0.203563
+ 5.422222 0.187887
+ 5.425000 0.359855
+ 5.427778 0.206075
+ 5.430556 0.194161
+ 5.433333 0.359855
+ 5.436111 0.198541
+ 5.438889 0.190384
+ 5.441667 0.359860
+ 5.444444 0.189751
+ 5.447222 0.185312
+ 5.450000 0.359860
+ 5.452778 0.188495
+ 5.455556 0.181545
+ 5.458333 0.359816
+ 5.461111 0.183473
+ 5.463889 0.179009
+ 5.466667 0.359816
+ 5.469444 0.177194
+ 5.472222 0.173977
+ 5.475000 0.359821
+ 5.477778 0.183473
+ 5.480556 0.181540
+ 5.483333 0.359826
+ 5.486111 0.199796
+ 5.488889 0.191654
+ 5.491667 0.359880
+ 5.494444 0.209842
+ 5.497222 0.199208
+ 5.500000 0.359914
+ 5.502778 0.222399
+ 5.505556 0.203039
+ 5.508333 0.359904
+ 5.511111 0.227421
+ 5.513889 0.213104
+ 5.516667 0.359948
+ 5.519444 0.232444
+ 5.522222 0.211853
+ 5.525000 0.359958
+ 5.527778 0.236211
+ 5.530556 0.215630
+ 5.533333 0.359958
+ 5.536111 0.234955
+ 5.538889 0.218156
+ 5.541667 0.359968
+ 5.544444 0.229933
+ 5.547222 0.215625
+ 5.550000 0.359958
+ 5.552778 0.236211
+ 5.555556 0.213128
+ 5.558333 0.359939
+ 5.561111 0.231188
+ )

* R-peak detector
Vthresh rpeak_threshold 0 0.33
Xrpeak ecg_amp_l0 rpeak_threshold rpeak_pulse vdd vss vbias rpeak_detector

* Delay timer
Vth14 vth_14 0 0.4757
Vth69 vth_69 0 0.4471
Vth83 vth_83 0 0.4684
Vth300 vth_300 0 0.3269
Vth10 vth_10 0 0.2282
Xdelay rpeak_pulse trig_s14 trig_s69 trig_wid trig_bi_copy trig_rr_copy vdd vss vbias vth_14 vth_69 vth_83 vth_300 vth_10 delay_timer
.ic v(xdelay.timer_node) = 0.9
.ic v(xdelay.timer2) = 0.9

* RR timing (F1, F2)
Xrr ecg_amp_l0 trig_rr_cap rpeak_pulse trig_rr_copy f1_rr_ratio f2_rr_asym rr_timer_node rr_ewma_node vdd vss vbias rr_timing
.ic v(xrr.net_timer) = 0.9
.ic v(xrr.ewma_node) = 0.15
.ic v(xrr.prev_node) = 0.15

* P-wave predictor
Vthpb vth_pw_base 0 0.157
Vthpp vth_pw_peak 0 0.118
Xpw rr_timer_node rr_ewma_node trig_pw_base trig_pw_peak trig_rr_cap vth_pw_base vth_pw_peak vdd vss vbias pwave_predictor

* F3: Beat instability L0
Xbi_l0 ecg_amp_l0 rpeak_pulse trig_bi_copy f3_bi_l0 vdd vss vbias beat_instability

* F4: Beat instability L1
Xbi_l1 ecg_amp_l1 rpeak_pulse trig_bi_copy f4_bi_l1 vdd vss vbias beat_instability

* F5: P-wave diff
Xpwave ecg_amp_l0 trig_pw_base trig_pw_peak f5_pwave vdd vss vbias pwave_diff

* F6: QRS width
Xwidth ecg_amp_l0 trig_wid f6_width vdd vss qrs_width

* F7: QRS slope
Xslope ecg_amp_l0 trig_s14 trig_s69 f7_slope vdd vss vbias qrs_slope

* F8: QRS symmetry
Xsym ecg_amp_l0 rpeak_pulse f8_symmetry vdd vss qrs_symmetry

.tran 0.5m 5.564 uic

.meas tran f1_rr_ratio_b1 FIND V(f1_rr_ratio) AT=0.842778
.meas tran f2_rr_asym_b1 FIND V(f2_rr_asym) AT=0.842778
.meas tran f3_bi_l0_b1 FIND V(f3_bi_l0) AT=0.842778
.meas tran f4_bi_l1_b1 FIND V(f4_bi_l1) AT=0.842778
.meas tran f5_pwave_b1 FIND V(f5_pwave) AT=0.842778
.meas tran f6_width_b1 FIND V(f6_width) AT=0.842778
.meas tran f7_slope_b1 FIND V(f7_slope) AT=0.842778
.meas tran f8_symmetry_b1 FIND V(f8_symmetry) AT=0.842778
.meas tran rpeak_b1 FIND V(rpeak_pulse) AT=0.852778
.meas tran ecg_b1 FIND V(ecg_amp_l0) AT=0.852778
.meas tran f1_rr_ratio_b2 FIND V(f1_rr_ratio) AT=1.837222
.meas tran f2_rr_asym_b2 FIND V(f2_rr_asym) AT=1.837222
.meas tran f3_bi_l0_b2 FIND V(f3_bi_l0) AT=1.837222
.meas tran f4_bi_l1_b2 FIND V(f4_bi_l1) AT=1.837222
.meas tran f5_pwave_b2 FIND V(f5_pwave) AT=1.837222
.meas tran f6_width_b2 FIND V(f6_width) AT=1.837222
.meas tran f7_slope_b2 FIND V(f7_slope) AT=1.837222
.meas tran f8_symmetry_b2 FIND V(f8_symmetry) AT=1.837222
.meas tran rpeak_b2 FIND V(rpeak_pulse) AT=1.847222
.meas tran ecg_b2 FIND V(ecg_amp_l0) AT=1.847222
.meas tran f1_rr_ratio_b3 FIND V(f1_rr_ratio) AT=2.681667
.meas tran f2_rr_asym_b3 FIND V(f2_rr_asym) AT=2.681667
.meas tran f3_bi_l0_b3 FIND V(f3_bi_l0) AT=2.681667
.meas tran f4_bi_l1_b3 FIND V(f4_bi_l1) AT=2.681667
.meas tran f5_pwave_b3 FIND V(f5_pwave) AT=2.681667
.meas tran f6_width_b3 FIND V(f6_width) AT=2.681667
.meas tran f7_slope_b3 FIND V(f7_slope) AT=2.681667
.meas tran f8_symmetry_b3 FIND V(f8_symmetry) AT=2.681667
.meas tran rpeak_b3 FIND V(rpeak_pulse) AT=2.691667
.meas tran ecg_b3 FIND V(ecg_amp_l0) AT=2.691667
.meas tran f1_rr_ratio_b4 FIND V(f1_rr_ratio) AT=3.492778
.meas tran f2_rr_asym_b4 FIND V(f2_rr_asym) AT=3.492778
.meas tran f3_bi_l0_b4 FIND V(f3_bi_l0) AT=3.492778
.meas tran f4_bi_l1_b4 FIND V(f4_bi_l1) AT=3.492778
.meas tran f5_pwave_b4 FIND V(f5_pwave) AT=3.492778
.meas tran f6_width_b4 FIND V(f6_width) AT=3.492778
.meas tran f7_slope_b4 FIND V(f7_slope) AT=3.492778
.meas tran f8_symmetry_b4 FIND V(f8_symmetry) AT=3.492778
.meas tran rpeak_b4 FIND V(rpeak_pulse) AT=3.502778
.meas tran ecg_b4 FIND V(ecg_amp_l0) AT=3.502778
.meas tran f1_rr_ratio_b5 FIND V(f1_rr_ratio) AT=4.281667
.meas tran f2_rr_asym_b5 FIND V(f2_rr_asym) AT=4.281667
.meas tran f3_bi_l0_b5 FIND V(f3_bi_l0) AT=4.281667
.meas tran f4_bi_l1_b5 FIND V(f4_bi_l1) AT=4.281667
.meas tran f5_pwave_b5 FIND V(f5_pwave) AT=4.281667
.meas tran f6_width_b5 FIND V(f6_width) AT=4.281667
.meas tran f7_slope_b5 FIND V(f7_slope) AT=4.281667
.meas tran f8_symmetry_b5 FIND V(f8_symmetry) AT=4.281667
.meas tran rpeak_b5 FIND V(rpeak_pulse) AT=4.291667
.meas tran ecg_b5 FIND V(ecg_amp_l0) AT=4.291667
.meas tran trig_s14_b2 FIND V(trig_s14) AT=1.861222
.meas tran trig_wid_b2 FIND V(trig_wid) AT=1.875222
.meas tran trig_s69_b2 FIND V(trig_s69) AT=1.916222
.meas tran rpeak_at_r2 FIND V(rpeak_pulse) AT=1.848222
.meas tran trig_s14_b3 FIND V(trig_s14) AT=2.705667
.meas tran trig_wid_b3 FIND V(trig_wid) AT=2.719667
.meas tran trig_s69_b3 FIND V(trig_s69) AT=2.760667
.meas tran rpeak_at_r3 FIND V(rpeak_pulse) AT=2.692667
.meas tran trig_s14_b4 FIND V(trig_s14) AT=3.516778
.meas tran trig_wid_b4 FIND V(trig_wid) AT=3.530778
.meas tran trig_s69_b4 FIND V(trig_s69) AT=3.571778
.meas tran rpeak_at_r4 FIND V(rpeak_pulse) AT=3.503778
.meas tran trig_s14_b5 FIND V(trig_s14) AT=4.305667
.meas tran trig_wid_b5 FIND V(trig_wid) AT=4.319667
.meas tran trig_s69_b5 FIND V(trig_s69) AT=4.360667
.meas tran rpeak_at_r5 FIND V(rpeak_pulse) AT=4.292667
.meas tran avg_idd AVG I(Vdd) FROM=0.5 TO=5.564

.control
run
set wr_singlescale
wrdata _integ_v2_data.txt v(f1_rr_ratio) v(f2_rr_asym) v(f3_bi_l0) v(f4_bi_l1) v(f5_pwave) v(f6_width) v(f7_slope) v(f8_symmetry) v(ecg_amp_l0) v(rpeak_pulse)
.endc
.end
