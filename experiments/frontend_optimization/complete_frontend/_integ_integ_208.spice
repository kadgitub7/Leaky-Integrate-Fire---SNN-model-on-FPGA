.title integ_208
.lib "C:/Users/kadhi/OneDrive/Desktop/amux/verilogLearning/Leaky-Integrate-Fire---SNN-model-on-FPGA/experiments/frontend_optimization/ngspice_frontend/sky130_minimal.lib.spice" tt
.option scale=1.0u method=gear reltol=0.01 gmin=1e-15
.temp 27
Vdd vdd 0 0.9
Vss vss 0 0

* ECG inputs
Vecg0 ecg_l0 0 PWL(0.0000000 0.300000 0.2470000 0.300000 0.2500000 0.292178 0.2527778 0.292178 0.2555556 0.292533 0.2583333 0.293244 0.2611111 0.294311 0.2638889 0.296444 0.2666667 0.296444 0.2694444 0.296444 0.2722222 0.296444 0.2750000 0.297156 0.2777778 0.298578 0.2805556 0.298933 0.2833333 0.298578 0.2861111 0.296800 0.2888889 0.296444 0.2916667 0.296444 0.2944444 0.297511 0.2972222 0.296800 0.3000000 0.295378 0.3027778 0.292533 0.3055556 0.291822 0.3083333 0.291467 0.3111111 0.292178 0.3138889 0.291822 0.3166667 0.289333 0.3194444 0.287200 0.3222222 0.286133 0.3250000 0.286133 0.3277778 0.286133 0.3305556 0.286133 0.3333333 0.284711 0.3361111 0.282578 0.3388889 0.282222 0.3416667 0.282578 0.3444444 0.283289 0.3472222 0.283289 0.3500000 0.283289 0.3527778 0.281511 0.3555556 0.280800 0.3583333 0.281867 0.3611111 0.282933 0.3638889 0.282578 0.3666667 0.281511 0.3694444 0.279733 0.3722222 0.279378 0.3750000 0.281156 0.3777778 0.282222 0.3805556 0.281867 0.3833333 0.281867 0.3861111 0.280800 0.3888889 0.280089 0.3916667 0.281511 0.3944444 0.282578 0.3972222 0.282578 0.4000000 0.282578 0.4027778 0.280800 0.4055556 0.281511 0.4083333 0.282933 0.4111111 0.283289 0.4138889 0.282933 0.4166667 0.282222 0.4194444 0.281867 0.4222222 0.282222 0.4250000 0.284000 0.4277778 0.286489 0.4305556 0.286489 0.4333333 0.286133 0.4361111 0.286133 0.4388889 0.288267 0.4416667 0.290756 0.4444444 0.295378 0.4472222 0.298578 0.4500000 0.299644 0.4527778 0.302844 0.4555556 0.308178 0.4583333 0.316000 0.4611111 0.323467 0.4638889 0.329511 0.4666667 0.333422 0.4694444 0.337689 0.4722222 0.344444 0.4750000 0.354756 0.4777778 0.363289 0.4805556 0.371111 0.4833333 0.376089 0.4861111 0.382133 0.4888889 0.389956 0.4916667 0.399556 0.4944444 0.409156 0.4972222 0.418044 0.5000000 0.421244 0.5027778 0.419111 0.5055556 0.413778 0.5083333 0.408444 0.5111111 0.404533 0.5138889 0.399911 0.5166667 0.393156 0.5194444 0.387111 0.5222222 0.384978 0.5250000 0.381778 0.5277778 0.377156 0.5305556 0.371822 0.5333333 0.366489 0.5361111 0.362222 0.5388889 0.362933 0.5416667 0.364000 0.5444444 0.362222 0.5472222 0.354044 0.5500000 0.343022 0.5527778 0.332356 0.5555556 0.319911 0.5583333 0.308889 0.5611111 0.295022 0.5638889 0.282578 0.5666667 0.271556 0.5694444 0.265156 0.5722222 0.263733 0.5750000 0.261244 0.5777778 0.257689 0.5805556 0.254844 0.5833333 0.253422 0.5861111 0.252000 0.5888889 0.251289 0.5916667 0.249867 0.5944444 0.248800 0.5972222 0.248800 0.6000000 0.247733 0.6027778 0.246667 0.6055556 0.245600 0.6083333 0.246667 0.6111111 0.245244 0.6138889 0.243467 0.6166667 0.243467 0.6194444 0.241689 0.6222222 0.241689 0.6250000 0.241333 0.6277778 0.239200 0.6305556 0.238844 0.6333333 0.237422 0.6361111 0.237067 0.6388889 0.235644 0.6416667 0.235644 0.6444444 0.235644 0.6472222 0.234222 0.6500000 0.233156 0.6527778 0.230667 0.6555556 0.230311 0.6583333 0.230311 0.6611111 0.231378 0.6638889 0.231378 0.6666667 0.229244 0.6694444 0.227822 0.6722222 0.227467 0.6750000 0.227111 0.6777778 0.226756 0.6805556 0.226400 0.6833333 0.226400 0.6861111 0.226044 0.6888889 0.226400 0.6916667 0.226044 0.6944444 0.229244 0.6972222 0.229600 0.7000000 0.228889 0.7027778 0.228178 0.7055556 0.229244 0.7083333 0.231378 0.7111111 0.235289 0.7138889 0.235644 0.7166667 0.235644 0.7194444 0.237067 0.7222222 0.239556 0.7250000 0.243822 0.7277778 0.247022 0.7305556 0.248800 0.7333333 0.249156 0.7361111 0.250578 0.7388889 0.252711 0.7416667 0.256978 0.7444444 0.259822 0.7472222 0.261600 0.7500000 0.262311 0.7527778 0.263378 0.7555556 0.266222 0.7583333 0.268356 0.7611111 0.270489 0.7638889 0.270844 0.7666667 0.270844 0.7694444 0.270844 0.7722222 0.271911 0.7750000 0.272978 0.7777778 0.274756 0.7805556 0.274756 0.7833333 0.272622 0.7861111 0.272267 0.7888889 0.272267 0.7916667 0.274400 0.7944444 0.275822 0.7972222 0.275111 0.8030000 0.300000 1.0081111 0.300000 1.0111111 0.281511 1.0138889 0.282222 1.0166667 0.279733 1.0194444 0.280089 1.0222222 0.280089 1.0250000 0.281156 1.0277778 0.282578 1.0305556 0.283289 1.0333333 0.281156 1.0361111 0.280089 1.0388889 0.280089 1.0416667 0.281867 1.0444444 0.283289 1.0472222 0.283644 1.0500000 0.282222 1.0527778 0.281511 1.0555556 0.281511 1.0583333 0.283289 1.0611111 0.283289 1.0638889 0.283644 1.0666667 0.282222 1.0694444 0.281867 1.0722222 0.281867 1.0750000 0.283289 1.0777778 0.284356 1.0805556 0.283289 1.0833333 0.282578 1.0861111 0.281511 1.0888889 0.281867 1.0916667 0.283644 1.0944444 0.285067 1.0972222 0.285067 1.1000000 0.283644 1.1027778 0.283644 1.1055556 0.285067 1.1083333 0.287200 1.1111111 0.289333 1.1138889 0.288622 1.1166667 0.287911 1.1194444 0.287556 1.1222222 0.290400 1.1250000 0.293600 1.1277778 0.295378 1.1305556 0.295378 1.1333333 0.293244 1.1361111 0.292533 1.1388889 0.293244 1.1416667 0.293600 1.1444444 0.295022 1.1472222 0.293956 1.1500000 0.291111 1.1527778 0.289689 1.1555556 0.289333 1.1583333 0.289689 1.1611111 0.288267 1.1638889 0.285422 1.1666667 0.282578 1.1694444 0.282222 1.1722222 0.283289 1.1750000 0.285067 1.1777778 0.284356 1.1805556 0.282933 1.1833333 0.281867 1.1861111 0.281156 1.1888889 0.281867 1.1916667 0.283289 1.1944444 0.282222 1.1972222 0.280800 1.2000000 0.279378 1.2027778 0.280089 1.2055556 0.282578 1.2083333 0.284356 1.2111111 0.283289 1.2138889 0.282578 1.2166667 0.281511 1.2194444 0.281511 1.2222222 0.282222 1.2250000 0.284000 1.2277778 0.284000 1.2305556 0.282222 1.2333333 0.280800 1.2361111 0.281511 1.2388889 0.285778 1.2416667 0.293956 1.2444444 0.304267 1.2472222 0.315289 1.2500000 0.329867 1.2527778 0.348356 1.2555556 0.369689 1.2583333 0.389956 1.2611111 0.404178 1.2638889 0.405600 1.2666667 0.389600 1.2694444 0.366489 1.2722222 0.341956 1.2750000 0.317067 1.2777778 0.297867 1.2805556 0.287200 1.2833333 0.281867 1.2861111 0.281867 1.2888889 0.280800 1.2916667 0.280800 1.2944444 0.280444 1.2972222 0.281156 1.3000000 0.280800 1.3027778 0.280444 1.3055556 0.279733 1.3083333 0.279022 1.3111111 0.278311 1.3138889 0.277956 1.3166667 0.277956 1.3194444 0.277956 1.3222222 0.277600 1.3250000 0.277600 1.3277778 0.277244 1.3305556 0.278311 1.3333333 0.279022 1.3361111 0.279378 1.3388889 0.278667 1.3416667 0.277244 1.3444444 0.279022 1.3472222 0.279022 1.3500000 0.279022 1.3527778 0.279022 1.3555556 0.279022 1.3583333 0.279733 1.3611111 0.280089 1.3638889 0.280089 1.3666667 0.281511 1.3694444 0.279378 1.3722222 0.280800 1.3750000 0.281156 1.3777778 0.282222 1.3805556 0.282578 1.3833333 0.282578 1.3861111 0.280800 1.3888889 0.281867 1.3916667 0.282578 1.3944444 0.284000 1.3972222 0.284711 1.4000000 0.284711 1.4027778 0.283644 1.4055556 0.284000 1.4083333 0.286133 1.4111111 0.286133 1.4138889 0.286844 1.4166667 0.286133 1.4194444 0.286844 1.4222222 0.287911 1.4250000 0.289333 1.4277778 0.290756 1.4305556 0.291467 1.4333333 0.291111 1.4361111 0.291467 1.4388889 0.292178 1.4416667 0.294311 1.4444444 0.295733 1.4472222 0.297511 1.4500000 0.297867 1.4527778 0.297867 1.4555556 0.298933 1.4583333 0.300356 1.4611111 0.302844 1.4638889 0.304267 1.4666667 0.304978 1.4694444 0.304267 1.4722222 0.304622 1.4750000 0.306400 1.4777778 0.308889 1.4805556 0.310667 1.4833333 0.308533 1.4861111 0.308889 1.4888889 0.308533 1.4916667 0.309956 1.4944444 0.312089 1.4972222 0.312444 1.5000000 0.311378 1.5027778 0.310311 1.5055556 0.308889 1.5083333 0.309956 1.5111111 0.310311 1.5138889 0.309956 1.5166667 0.307822 1.5194444 0.304978 1.5222222 0.302844 1.5250000 0.302133 1.5277778 0.302844 1.5305556 0.301422 1.5333333 0.298578 1.5361111 0.295733 1.5388889 0.295022 1.5416667 0.294311 1.5444444 0.294667 1.5472222 0.293956 1.5500000 0.291822 1.5527778 0.288622 1.5555556 0.287200 1.5583333 0.288267 1.5641111 0.300000 1.6025556 0.300000 1.6055556 0.281867 1.6083333 0.283644 1.6111111 0.284000 1.6138889 0.284000 1.6166667 0.284000 1.6194444 0.281867 1.6222222 0.282578 1.6250000 0.283644 1.6277778 0.285067 1.6305556 0.285778 1.6333333 0.284711 1.6361111 0.283289 1.6388889 0.283644 1.6416667 0.284356 1.6444444 0.285422 1.6472222 0.285778 1.6500000 0.283644 1.6527778 0.282578 1.6555556 0.283289 1.6583333 0.284711 1.6611111 0.285778 1.6638889 0.286133 1.6666667 0.284356 1.6694444 0.282222 1.6722222 0.281511 1.6750000 0.283644 1.6777778 0.284356 1.6805556 0.285067 1.6833333 0.284000 1.6861111 0.282578 1.6888889 0.284356 1.6916667 0.285778 1.6944444 0.287556 1.6972222 0.288622 1.7000000 0.287200 1.7027778 0.287200 1.7055556 0.288978 1.7083333 0.291822 1.7111111 0.294311 1.7138889 0.295733 1.7166667 0.295022 1.7194444 0.294311 1.7222222 0.293956 1.7250000 0.295378 1.7277778 0.296089 1.7305556 0.295733 1.7333333 0.293956 1.7361111 0.291822 1.7388889 0.291111 1.7416667 0.290400 1.7444444 0.290756 1.7472222 0.290044 1.7500000 0.287200 1.7527778 0.284356 1.7555556 0.282933 1.7583333 0.282578 1.7611111 0.282933 1.7638889 0.283289 1.7666667 0.281867 1.7694444 0.281511 1.7722222 0.283289 1.7750000 0.286133 1.7777778 0.289333 1.7805556 0.292889 1.7833333 0.295733 1.7861111 0.297511 1.7888889 0.302489 1.7916667 0.308178 1.7944444 0.314222 1.7972222 0.320622 1.8000000 0.324889 1.8027778 0.329511 1.8055556 0.334844 1.8083333 0.340533 1.8111111 0.344800 1.8138889 0.347644 1.8166667 0.349067 1.8194444 0.352978 1.8222222 0.359022 1.8250000 0.366844 1.8277778 0.372889 1.8305556 0.375378 1.8333333 0.377156 1.8361111 0.384622 1.8388889 0.397422 1.8416667 0.407378 1.8444444 0.414133 1.8472222 0.418044 1.8500000 0.420178 1.8527778 0.425511 1.8555556 0.431911 1.8583333 0.437600 1.8611111 0.438311 1.8638889 0.423378 1.8666667 0.394933 1.8694444 0.366133 1.8722222 0.343378 1.8750000 0.323467 1.8777778 0.307111 1.8805556 0.292889 1.8833333 0.281156 1.8861111 0.273333 1.8888889 0.270844 1.8916667 0.271200 1.8944444 0.270489 1.8972222 0.267289 1.9000000 0.264800 1.9027778 0.261244 1.9055556 0.261244 1.9083333 0.261244 1.9111111 0.261244 1.9138889 0.260178 1.9166667 0.258044 1.9194444 0.256267 1.9222222 0.256622 1.9250000 0.256622 1.9277778 0.256978 1.9305556 0.257333 1.9333333 0.255200 1.9361111 0.254133 1.9388889 0.255200 1.9416667 0.256267 1.9444444 0.256267 1.9472222 0.256267 1.9500000 0.253067 1.9527778 0.251289 1.9555556 0.252000 1.9583333 0.253067 1.9611111 0.253778 1.9638889 0.253422 1.9666667 0.250933 1.9694444 0.248800 1.9722222 0.248444 1.9750000 0.250222 1.9777778 0.250222 1.9805556 0.249156 1.9833333 0.247022 1.9861111 0.245956 1.9888889 0.245600 1.9916667 0.246311 1.9944444 0.246311 1.9972222 0.246311 2.0000000 0.243822 2.0027778 0.242756 2.0055556 0.243467 2.0083333 0.244178 2.0111111 0.245244 2.0138889 0.244533 2.0166667 0.243111 2.0194444 0.241333 2.0222222 0.240978 2.0250000 0.241689 2.0277778 0.243111 2.0305556 0.243822 2.0333333 0.242756 2.0358889 0.300000 2.0361111 0.240267 2.0388889 0.240978 2.0416667 0.242756 2.0444444 0.244178 2.0472222 0.245600 2.0500000 0.245600 2.0527778 0.244533 2.0555556 0.245956 2.0583333 0.249156 2.0611111 0.252356 2.0638889 0.252356 2.0666667 0.252000 2.0694444 0.252000 2.0722222 0.254844 2.0750000 0.258044 2.0777778 0.260533 2.0805556 0.261956 2.0833333 0.261244 2.0861111 0.263022 2.0888889 0.264800 2.0916667 0.268356 2.0944444 0.270489 2.0972222 0.271911 2.1000000 0.270489 2.1027778 0.270133 2.1055556 0.272978 2.1083333 0.274400 2.1111111 0.275111 2.1138889 0.275822 2.1166667 0.275111 2.1194444 0.274044 2.1222222 0.273689 2.1250000 0.275822 2.1277778 0.277956 2.1305556 0.276889 2.1333333 0.274756 2.1361111 0.273689 2.1388889 0.274756 2.1416667 0.275822 2.1444444 0.276533 2.1472222 0.276533 2.1500000 0.273689 2.1527778 0.272622 2.1555556 0.274400 2.1583333 0.275111 2.1585556 0.300000 2.1611111 0.275822 2.1638889 0.276889 2.1666667 0.274756 2.1694444 0.273333 2.1722222 0.275111 2.1750000 0.275467 2.1777778 0.276533 2.1805556 0.276889 2.1833333 0.274400 2.1861111 0.274044 2.1888889 0.275111 2.1916667 0.275822 2.1944444 0.277244 2.1972222 0.276533 2.2000000 0.275111 2.2027778 0.274756 2.2055556 0.274756 2.2083333 0.276178 2.2111111 0.276889 2.2138889 0.276533 2.2166667 0.275467 2.2194444 0.274756 2.2222222 0.274756 2.2250000 0.276889 2.2277778 0.278311 2.2305556 0.279733 2.2333333 0.279022 2.2361111 0.280444 2.2388889 0.282578 2.2416667 0.286489 2.2444444 0.289333 2.2472222 0.290400 2.2500000 0.292178 2.2527778 0.296089 2.2555556 0.303200 2.2583333 0.312089 2.2611111 0.319200 2.2638889 0.327733 2.2666667 0.334844 2.2694444 0.342311 2.2722222 0.350489 2.2750000 0.357244 2.2777778 0.364711 2.2805556 0.369333 2.2833333 0.373600 2.2861111 0.378578 2.2888889 0.384267 2.2916667 0.387467 2.2944444 0.387467 2.2972222 0.383556 2.3000000 0.378222 2.3027778 0.372889 2.3055556 0.370756 2.3083333 0.369689 2.3111111 0.368978 2.3138889 0.366133 2.3166667 0.362933 2.3194444 0.360800 2.3222222 0.361511 2.3250000 0.362578 2.3277778 0.362578 2.3305556 0.363644 2.3333333 0.362578 2.3361111 0.362933 2.3388889 0.360089 2.3416667 0.355822 2.3444444 0.346578 2.3472222 0.336978 2.3500000 0.321333 2.3527778 0.306756 2.3555556 0.294667 2.3583333 0.285422 2.3611111 0.278311 2.3638889 0.273333 2.3666667 0.269422 2.3694444 0.266222 2.3722222 0.265156 2.3750000 0.262311 2.3777778 0.259111 2.3805556 0.255911 2.3833333 0.252711 2.3861111 0.250933 2.3888889 0.249511 2.3916667 0.249156 2.3944444 0.248444 2.3972222 0.245600 2.4000000 0.242756 2.4027778 0.241689 2.4055556 0.242400 2.4083333 0.243111 2.4111111 0.242400 2.4138889 0.240978 2.4166667 0.239911 2.4194444 0.238489 2.4222222 0.237422 2.4250000 0.238133 2.4277778 0.237422 2.4305556 0.236356 2.4333333 0.234578 2.4361111 0.233156 2.4388889 0.232800 2.4416667 0.231733 2.4444444 0.231022 2.4472222 0.231022 2.4500000 0.228178 2.4527778 0.227822 2.4555556 0.227822 2.4583333 0.227822 2.4611111 0.227467 2.4638889 0.224622 2.4666667 0.223200 2.4694444 0.221422 2.4722222 0.222133 2.4750000 0.222489 2.4777778 0.221067 2.4805556 0.220356 2.4833333 0.218933 2.4861111 0.218933 2.4888889 0.218933 2.4916667 0.218933 2.4944444 0.220000 2.4972222 0.221067 2.5000000 0.221067 2.5027778 0.221422 2.5055556 0.221778 2.5083333 0.223200 2.5111111 0.225333 2.5138889 0.228178 2.5166667 0.229956 2.5194444 0.231022 2.5222222 0.231733 2.5250000 0.235644 2.5277778 0.238489 2.5305556 0.240978 2.5333333 0.242400 2.5361111 0.244889 2.5388889 0.247733 2.5416667 0.250933 2.5444444 0.253422 2.5472222 0.256267 2.5500000 0.257333 2.5527778 0.258756 2.5555556 0.259111 2.5583333 0.261600 2.5611111 0.263733 2.5638889 0.265511 2.5666667 0.265511 2.5694444 0.265156 2.5722222 0.265867 2.5750000 0.267644 2.5777778 0.267644 2.5805556 0.268356 2.5833333 0.268356 2.5861111 0.267644 2.5918889 0.300000 2.9470000 0.300000 2.9500000 0.278667 2.9527778 0.278311 2.9555556 0.279378 2.9583333 0.281156 2.9611111 0.279378 2.9638889 0.279733 2.9666667 0.279022 2.9694444 0.279022 2.9722222 0.280089 2.9750000 0.281511 2.9777778 0.281156 2.9805556 0.279378 2.9833333 0.277600 2.9861111 0.278311 2.9888889 0.279733 2.9916667 0.281511 2.9944444 0.279733 2.9972222 0.280089 3.0000000 0.278667 3.0027778 0.279022 3.0055556 0.280800 3.0083333 0.281511 3.0111111 0.281511 3.0138889 0.280089 3.0166667 0.279378 3.0194444 0.279378 3.0222222 0.279733 3.0250000 0.281867 3.0277778 0.282222 3.0305556 0.281867 3.0333333 0.281156 3.0361111 0.282578 3.0388889 0.284000 3.0416667 0.285778 3.0444444 0.286844 3.0472222 0.286489 3.0500000 0.286489 3.0527778 0.286844 3.0555556 0.288978 3.0583333 0.292178 3.0611111 0.292889 3.0638889 0.293244 3.0666667 0.292533 3.0694444 0.292889 3.0722222 0.293244 3.0750000 0.293956 3.0777778 0.294311 3.0805556 0.291467 3.0833333 0.289333 3.0861111 0.287911 3.0888889 0.289689 3.0916667 0.289333 3.0944444 0.288978 3.0972222 0.286489 3.1000000 0.285778 3.1027778 0.285422 3.1055556 0.283289 3.1083333 0.285067 3.1111111 0.285067 3.1138889 0.283644 3.1166667 0.282578 3.1194444 0.281156 3.1222222 0.282578 3.1250000 0.284000 3.1277778 0.284000 3.1305556 0.283644 3.1333333 0.281511 3.1361111 0.282578 3.1388889 0.283644 3.1416667 0.284356 3.1444444 0.284000 3.1472222 0.282933 3.1500000 0.282578 3.1527778 0.281867 3.1555556 0.283289 3.1583333 0.283644 3.1611111 0.284356 3.1638889 0.282933 3.1666667 0.282222 3.1694444 0.280800 3.1722222 0.280444 3.1750000 0.281867 3.1777778 0.285422 3.1805556 0.291822 3.1833333 0.301778 3.1861111 0.314933 3.1888889 0.334489 3.1916667 0.356533 3.1944444 0.376800 3.1972222 0.394578 3.2000000 0.408089 3.2027778 0.410933 3.2055556 0.396356 3.2083333 0.370756 3.2111111 0.340533 3.2138889 0.312444 3.2166667 0.293244 3.2194444 0.285778 3.2222222 0.284356 3.2250000 0.284000 3.2277778 0.284356 3.2305556 0.282222 3.2333333 0.281867 3.2361111 0.282222 3.2388889 0.284356 3.2416667 0.284000 3.2444444 0.282933 3.2472222 0.282222 3.2500000 0.281156 3.2527778 0.280444 3.2555556 0.282222 3.2583333 0.281511 3.2611111 0.279733 3.2638889 0.278667 3.2666667 0.279378 3.2694444 0.279378 3.2722222 0.281156 3.2750000 0.281511 3.2777778 0.281156 3.2805556 0.280444 3.2833333 0.280089 3.2861111 0.279733 3.2888889 0.281867 3.2916667 0.283289 3.2944444 0.281156 3.2972222 0.280800 3.3000000 0.280444 3.3027778 0.280800 3.3055556 0.282222 3.3083333 0.284000 3.3111111 0.284356 3.3138889 0.283289 3.3166667 0.282933 3.3194444 0.282933 3.3222222 0.283644 3.3250000 0.285067 3.3277778 0.285422 3.3305556 0.284356 3.3333333 0.285067 3.3361111 0.286133 3.3388889 0.286489 3.3416667 0.287556 3.3444444 0.288622 3.3472222 0.288622 3.3500000 0.288267 3.3527778 0.288978 3.3555556 0.290756 3.3583333 0.290400 3.3611111 0.291111 3.3638889 0.291822 3.3666667 0.292178 3.3694444 0.292178 3.3722222 0.294311 3.3750000 0.295378 3.3777778 0.296444 3.3805556 0.295733 3.3833333 0.296444 3.3861111 0.296800 3.3888889 0.299644 3.3916667 0.301067 3.3944444 0.301422 3.3972222 0.301778 3.4000000 0.301067 3.4027778 0.302489 3.4055556 0.304622 3.4083333 0.307467 3.4111111 0.308178 3.4138889 0.307467 3.4166667 0.306756 3.4194444 0.308889 3.4222222 0.309956 3.4250000 0.312089 3.4277778 0.311733 3.4305556 0.311022 3.4333333 0.310667 3.4361111 0.311022 3.4388889 0.312800 3.4416667 0.313867 3.4444444 0.315289 3.4472222 0.314222 3.4500000 0.314578 3.4527778 0.314578 3.4555556 0.314933 3.4583333 0.315289 3.4611111 0.315644 3.4638889 0.313156 3.4666667 0.312444 3.4694444 0.312089 3.4722222 0.312089 3.4750000 0.312800 3.4777778 0.311378 3.4805556 0.309244 3.4833333 0.307111 3.4861111 0.304978 3.4888889 0.303556 3.4916667 0.302489 3.4942222 0.300000 3.4944444 0.301778 3.4972222 0.300711 3.5000000 0.298933 3.5027778 0.297511 3.5030000 0.300000 3.5055556 0.296800 3.5083333 0.295733 3.5111111 0.295378 3.5138889 0.294311 3.5166667 0.293600 3.5194444 0.293600 3.5222222 0.293244 3.5250000 0.293956 3.5277778 0.293600 3.5305556 0.293244 3.5333333 0.292178 3.5361111 0.292178 3.5388889 0.292533 3.5416667 0.293600 3.5444444 0.293244 3.5472222 0.291467 3.5500000 0.291467 3.5527778 0.291111 3.5555556 0.292533 3.5583333 0.292889 3.5611111 0.292533 3.5638889 0.292533 3.5666667 0.292889 3.5694444 0.292178 3.5722222 0.292889 3.5750000 0.292889 3.5777778 0.292178 3.5805556 0.291822 3.5833333 0.291467 3.5861111 0.291467 3.5888889 0.292178 3.5916667 0.293600 3.5944444 0.292889 3.5972222 0.291822 3.6000000 0.291822 3.6027778 0.292533 3.6055556 0.293244 3.6083333 0.293600 3.6111111 0.293600 3.6138889 0.292889 3.6166667 0.292533 3.6194444 0.293600 3.6222222 0.292889 3.6250000 0.295022 3.6277778 0.294667 3.6305556 0.293600 3.6333333 0.293600 3.6361111 0.294311 3.6388889 0.296800 3.6416667 0.296444 3.6444444 0.297511 3.6472222 0.297867 3.6500000 0.297867 3.6527778 0.298222 3.6555556 0.301778 3.6583333 0.302489 3.6611111 0.304267 3.6638889 0.303556 3.6666667 0.303200 3.6694444 0.304622 3.6722222 0.305689 3.6750000 0.306400 3.6777778 0.307111 3.6805556 0.306756 3.6833333 0.307822 3.6861111 0.310667 3.6888889 0.313867 3.6916667 0.316000 3.6944444 0.319556 3.6972222 0.322400 3.7000000 0.325600 3.7027778 0.332000 3.7055556 0.339467 3.7083333 0.344444 3.7111111 0.348000 3.7138889 0.350489 3.7166667 0.355467 3.7194444 0.360444 3.7222222 0.366489 3.7250000 0.374311 3.7277778 0.380356 3.7305556 0.384978 3.7333333 0.388533 3.7361111 0.392800 3.7388889 0.400622 3.7416667 0.409156 3.7444444 0.416267 3.7472222 0.416978 3.7500000 0.414489 3.7527778 0.410933 3.7555556 0.408800 3.7583333 0.406667 3.7611111 0.403111 3.7638889 0.397422 3.7666667 0.392800 3.7694444 0.389244 3.7722222 0.387822 3.7750000 0.384267 3.7777778 0.381422 3.7805556 0.377156 3.7833333 0.373956 3.7861111 0.371822 3.7888889 0.371467 3.7916667 0.370756 3.7944444 0.368267 3.7972222 0.363289 3.8000000 0.355822 3.8027778 0.348356 3.8055556 0.339822 3.8083333 0.328089 3.8111111 0.313511 3.8138889 0.298222 3.8166667 0.286844 3.8194444 0.279378 3.8222222 0.274400 3.8250000 0.272978 3.8277778 0.269422 3.8305556 0.265867 3.8333333 0.264444 3.8361111 0.263733 3.8388889 0.263378 3.8416667 0.262311 3.8444444 0.260889 3.8472222 0.258756 3.8500000 0.258044 3.8527778 0.257689 3.8555556 0.258400 3.8583333 0.257689 3.8611111 0.256978 3.8638889 0.256267 3.8666667 0.255200 3.8694444 0.255200 3.8722222 0.255200 3.8750000 0.255200 3.8777778 0.254133 3.8805556 0.252000 3.8833333 0.250578 3.8861111 0.250222 3.8888889 0.250578 3.8916667 0.249511 3.8944444 0.247733 3.8972222 0.246667 3.9000000 0.245956 3.9027778 0.245244 3.9055556 0.245956 3.9083333 0.245600 3.9111111 0.245244 3.9138889 0.242756 3.9166667 0.241333 3.9194444 0.241333 3.9222222 0.242044 3.9250000 0.241689 3.9277778 0.240978 3.9305556 0.238489 3.9333333 0.238133 3.9361111 0.237067 3.9388889 0.237422 3.9416667 0.237422 3.9444444 0.237778 3.9472222 0.237067 3.9500000 0.236000 3.9527778 0.237067 3.9555556 0.236711 3.9583333 0.237067 3.9611111 0.236356 3.9638889 0.236711 3.9666667 0.236711 3.9694444 0.237422 3.9722222 0.239556 3.9750000 0.240622 3.9777778 0.242044 3.9805556 0.241333 3.9833333 0.242400 3.9861111 0.244178 3.9888889 0.247022 3.9916667 0.249867 3.9944444 0.250933 3.9972222 0.251644 4.0000000 0.252356 4.0027778 0.256267 4.0055556 0.259467 4.0083333 0.263022 4.0111111 0.265156 4.0138889 0.266578 4.0166667 0.268000 4.0194444 0.270844 4.0222222 0.272978 4.0250000 0.275467 4.0277778 0.277244 4.0305556 0.277244 4.0333333 0.278311 4.0361111 0.280089 4.0388889 0.282933 4.0416667 0.284000 4.0444444 0.284711 4.0502222 0.300000 4.0525556 0.300000 4.0555556 0.284356 4.0583333 0.285778 4.0611111 0.286489 4.0638889 0.284711 4.0666667 0.284000 4.0694444 0.284000 4.0722222 0.285778 4.0750000 0.285422 4.0777778 0.285778 4.0805556 0.284711 4.0833333 0.283289 4.0861111 0.284356 4.0888889 0.285778 4.0916667 0.286489 4.0944444 0.286133 4.0972222 0.284000 4.1000000 0.284356 4.1027778 0.284711 4.1055556 0.285067 4.1083333 0.285422 4.1111111 0.285422 4.1138889 0.284000 4.1166667 0.282933 4.1194444 0.284000 4.1222222 0.284711 4.1250000 0.285067 4.1277778 0.284711 4.1305556 0.283644 4.1333333 0.282222 4.1361111 0.282933 4.1388889 0.285422 4.1416667 0.285778 4.1444444 0.285778 4.1472222 0.285067 4.1500000 0.284356 4.1527778 0.284356 4.1555556 0.285778 4.1583333 0.285778 4.1611111 0.286133 4.1638889 0.285778 4.1666667 0.284711 4.1694444 0.284711 4.1722222 0.286844 4.1750000 0.286844 4.1777778 0.287200 4.1805556 0.286489 4.1833333 0.285778 4.1861111 0.286489 4.1888889 0.287911 4.1916667 0.288622 4.1944444 0.287911 4.1972222 0.287556 4.2000000 0.286844 4.2027778 0.287200 4.2055556 0.288622 4.2083333 0.289333 4.2111111 0.289689 4.2138889 0.288267 4.2166667 0.287911 4.2194444 0.288267 4.2222222 0.289333 4.2250000 0.290044 4.2277778 0.290044 4.2305556 0.290756 4.2333333 0.291111 4.2361111 0.292178 4.2388889 0.294667 4.2416667 0.297511 4.2444444 0.300356 4.2472222 0.302489 4.2500000 0.304978 4.2527778 0.309600 4.2555556 0.314578 4.2583333 0.318844 4.2611111 0.323467 4.2638889 0.327733 4.2666667 0.333067 4.2694444 0.338756 4.2722222 0.345867 4.2750000 0.353689 4.2777778 0.360089 4.2805556 0.364356 4.2833333 0.368978 4.2861111 0.374667 4.2888889 0.381422 4.2916667 0.389600 4.2944444 0.395289 4.2972222 0.399556 4.3000000 0.403467 4.3027778 0.409156 4.3055556 0.416978 4.3083333 0.420178 4.3111111 0.416978 4.3138889 0.412356 4.3166667 0.405956 4.3194444 0.402044 4.3222222 0.399200 4.3250000 0.396356 4.3277778 0.393867 4.3305556 0.390311 4.3333333 0.387111 4.3361111 0.383911 4.3388889 0.383556 4.3416667 0.382844 4.3444444 0.381422 4.3472222 0.379289 4.3500000 0.376800 4.3527778 0.377156 4.3555556 0.378578 4.3583333 0.378222 4.3611111 0.374311 4.3638889 0.365422 4.3666667 0.356178 4.3694444 0.344444 4.3722222 0.330578 4.3750000 0.316000 4.3777778 0.301067 4.3805556 0.290400 4.3833333 0.282222 4.3861111 0.275822 4.3888889 0.272978 4.3916667 0.271200 4.3944444 0.268711 4.3972222 0.265867 4.4000000 0.264089 4.4027778 0.263022 4.4055556 0.262667 4.4083333 0.262311 4.4111111 0.261244 4.4138889 0.259111 4.4166667 0.257333 4.4194444 0.256267 4.4222222 0.256978 4.4250000 0.257333 4.4277778 0.255911 4.4305556 0.253778 4.4333333 0.252356 4.4361111 0.252356 4.4388889 0.252356 4.4416667 0.252000 4.4444444 0.252356 4.4472222 0.249867 4.4500000 0.249511 4.4527778 0.248089 4.4555556 0.248089 4.4583333 0.248444 4.4611111 0.246667 4.4638889 0.244889 4.4666667 0.243822 4.4694444 0.242756 4.4722222 0.243822 4.4750000 0.243111 4.4777778 0.242756 4.4805556 0.241333 4.4833333 0.240622 4.4861111 0.239911 4.4888889 0.239556 4.4916667 0.239911 4.4944444 0.238489 4.4972222 0.237422 4.5000000 0.237067 4.5027778 0.236711 4.5055556 0.237422 4.5083333 0.236356 4.5111111 0.235644 4.5138889 0.234578 4.5166667 0.233511 4.5194444 0.234578 4.5222222 0.236000 4.5250000 0.236000 4.5277778 0.236711 4.5305556 0.235644 4.5333333 0.235644 4.5361111 0.236000 4.5388889 0.237778 4.5416667 0.239556 4.5444444 0.242044 4.5472222 0.242400 4.5500000 0.243822 4.5527778 0.245956 4.5555556 0.247378 4.5583333 0.251289 4.5611111 0.254133 4.5638889 0.255200 4.5666667 0.257333 4.5694444 0.260178 4.5722222 0.264089 4.5750000 0.266933 4.5777778 0.267289 4.5805556 0.270133 4.5833333 0.270489 4.5861111 0.274044 4.5888889 0.278311 4.5916667 0.279733 4.5944444 0.280444 4.5972222 0.280800 4.6000000 0.281867 4.6027778 0.282933 4.6085556 0.300000 4.8331111 0.300000 4.8361111 0.291822 4.8388889 0.293244 4.8416667 0.293956 4.8444444 0.293956 4.8472222 0.293244 4.8500000 0.291467 4.8527778 0.292178 4.8555556 0.292889 4.8583333 0.293956 4.8611111 0.294311 4.8638889 0.292533 4.8666667 0.292533 4.8694444 0.291822 4.8722222 0.293244 4.8750000 0.293956 4.8777778 0.293600 4.8805556 0.292178 4.8833333 0.291822 4.8861111 0.292533 4.8888889 0.293956 4.8916667 0.293956 4.8944444 0.293600 4.8972222 0.291822 4.9000000 0.291467 4.9027778 0.292533 4.9055556 0.293600 4.9083333 0.294667 4.9111111 0.294667 4.9138889 0.294667 4.9166667 0.294667 4.9194444 0.295378 4.9222222 0.297867 4.9250000 0.297867 4.9277778 0.298933 4.9305556 0.298578 4.9333333 0.298222 4.9361111 0.299644 4.9388889 0.302133 4.9416667 0.304622 4.9444444 0.305689 4.9472222 0.304622 4.9500000 0.303911 4.9527778 0.304622 4.9555556 0.305689 4.9583333 0.305689 4.9611111 0.303911 4.9638889 0.301778 4.9666667 0.300000 4.9694444 0.300000 4.9722222 0.300356 4.9750000 0.299644 4.9777778 0.298578 4.9805556 0.296089 4.9833333 0.295022 4.9861111 0.294667 4.9888889 0.295022 4.9916667 0.294667 4.9944444 0.293600 4.9972222 0.292178 5.0000000 0.291467 5.0027778 0.291467 5.0055556 0.291467 5.0083333 0.292178 5.0111111 0.291467 5.0138889 0.291111 5.0166667 0.291467 5.0194444 0.292178 5.0222222 0.292178 5.0250000 0.292533 5.0277778 0.291822 5.0305556 0.291467 5.0333333 0.291822 5.0361111 0.292889 5.0388889 0.293956 5.0416667 0.293956 5.0444444 0.292533 5.0472222 0.292533 5.0500000 0.292889 5.0527778 0.293600 5.0555556 0.292889 5.0583333 0.293244 5.0611111 0.295733 5.0638889 0.299644 5.0666667 0.307822 5.0694444 0.320267 5.0722222 0.334844 5.0750000 0.351556 5.0777778 0.368978 5.0805556 0.386044 5.0833333 0.401689 5.0861111 0.415911 5.0888889 0.421600 5.0916667 0.411644 5.0944444 0.387822 5.0972222 0.359733 5.1000000 0.335200 5.1027778 0.316356 5.1055556 0.306400 5.1083333 0.301067 5.1111111 0.296089 5.1138889 0.291467 5.1166667 0.288622 5.1194444 0.290044 5.1222222 0.292889 5.1250000 0.293600 5.1277778 0.292178 5.1305556 0.290400 5.1333333 0.289333 5.1361111 0.289689 5.1388889 0.290044 5.1416667 0.290400 5.1444444 0.288978 5.1472222 0.287200 5.1500000 0.288267 5.1527778 0.288622 5.1555556 0.288978 5.1583333 0.289689 5.1611111 0.288978 5.1638889 0.287200 5.1666667 0.287556 5.1694444 0.288978 5.1722222 0.289333 5.1750000 0.289689 5.1777778 0.289689 5.1805556 0.287911 5.1833333 0.288978 5.1861111 0.290044 5.1888889 0.290400 5.1916667 0.291822 5.1944444 0.291111 5.1972222 0.290400 5.2000000 0.290756 5.2027778 0.291111 5.2055556 0.292533 5.2083333 0.293600 5.2111111 0.293600 5.2138889 0.293600 5.2166667 0.293244 5.2194444 0.293600 5.2222222 0.295022 5.2250000 0.297867 5.2277778 0.296444 5.2305556 0.297156 5.2333333 0.296800 5.2361111 0.297867 5.2388889 0.300000 5.2416667 0.301422 5.2444444 0.301422 5.2472222 0.301067 5.2500000 0.300711 5.2527778 0.302489 5.2555556 0.305689 5.2583333 0.307822 5.2611111 0.308178 5.2638889 0.307467 5.2666667 0.306400 5.2694444 0.308178 5.2722222 0.311733 5.2750000 0.312800 5.2777778 0.314222 5.2805556 0.314578 5.2833333 0.313867 5.2861111 0.314578 5.2888889 0.317422 5.2916667 0.319200 5.2944444 0.320267 5.2972222 0.320622 5.3000000 0.320622 5.3027778 0.322044 5.3055556 0.323111 5.3083333 0.324178 5.3111111 0.323822 5.3138889 0.322400 5.3166667 0.323467 5.3194444 0.323111 5.3222222 0.324533 5.3250000 0.324533 5.3277778 0.322756 5.3305556 0.318844 5.3333333 0.317778 5.3361111 0.316711 5.3388889 0.316711 5.3416667 0.314933 5.3444444 0.312800 5.3472222 0.311022 5.3500000 0.308533 5.3527778 0.307822 5.3555556 0.307467 5.3583333 0.305689 5.3611111 0.302844 5.3638889 0.300356 5.3666667 0.299289 5.3694444 0.298933 5.3722222 0.299289 5.3750000 0.298578 5.3777778 0.297511 5.3805556 0.295733 5.3831111 0.300000 5.3833333 0.293600 5.3861111 0.294667 5.3888889 0.296089 5.3891111 0.300000 5.3916667 0.296800 5.3944444 0.295378 5.3972222 0.293956 5.4000000 0.293244 5.4027778 0.294311 5.4055556 0.295022 5.4083333 0.295022 5.4111111 0.295022 5.4138889 0.293600 5.4166667 0.293244 5.4194444 0.293244 5.4222222 0.293956 5.4250000 0.294667 5.4277778 0.294311 5.4305556 0.293600 5.4333333 0.293244 5.4361111 0.293600 5.4388889 0.293956 5.4416667 0.295022 5.4444444 0.293244 5.4472222 0.293244 5.4500000 0.293244 5.4527778 0.294667 5.4555556 0.295022 5.4583333 0.296089 5.4611111 0.295378 5.4638889 0.294667 5.4666667 0.294311 5.4694444 0.295378 5.4722222 0.296800 5.4750000 0.296444 5.4777778 0.295733 5.4805556 0.295022 5.4833333 0.295022 5.4861111 0.294667 5.4888889 0.295378 5.4916667 0.296089 5.4944444 0.295378 5.4972222 0.294667 5.5000000 0.295022 5.5027778 0.295378 5.5055556 0.296089 5.5083333 0.293600 5.5111111 0.295022 5.5138889 0.295733 5.5166667 0.296089 5.5194444 0.297867 5.5222222 0.299289 5.5250000 0.300356 5.5277778 0.300000 5.5305556 0.300000 5.5333333 0.301067 5.5361111 0.302133 5.5388889 0.304978 5.5416667 0.306400 5.5444444 0.306756 5.5472222 0.305689 5.5500000 0.305689 5.5527778 0.305333 5.5555556 0.305689 5.5583333 0.305333 5.5611111 0.304978 5.5638889 0.303556 5.5666667 0.303200 5.5694444 0.303556 5.5722222 0.304267 5.5750000 0.304978 5.5777778 0.305689 5.5805556 0.306400 5.5833333 0.307467 5.5861111 0.311022 5.5888889 0.314578 5.5916667 0.318489 5.5944444 0.322044 5.5972222 0.324889 5.6000000 0.329156 5.6027778 0.334844 5.6055556 0.341244 5.6083333 0.345867 5.6111111 0.350489 5.6138889 0.353689 5.6166667 0.357956 5.6194444 0.362578 5.6222222 0.368622 5.6250000 0.375022 5.6277778 0.380000 5.6305556 0.383556 5.6333333 0.388178 5.6361111 0.396000 5.6388889 0.404178 5.6416667 0.409867 5.6444444 0.411644 5.6472222 0.408800 5.6500000 0.405244 5.6527778 0.401689 5.6555556 0.398489 5.6583333 0.396000 5.6611111 0.394222 5.6638889 0.393511 5.6666667 0.394578 5.6694444 0.395289 5.6722222 0.397422 5.6750000 0.397422 5.6777778 0.397067 5.6805556 0.397422 5.6833333 0.397778 5.6861111 0.398489 5.6888889 0.398133 5.6916667 0.393511 5.6944444 0.385333 5.6972222 0.372533 5.7000000 0.356533 5.7027778 0.339822 5.7055556 0.322400 5.7083333 0.306400 5.7111111 0.293600 5.7138889 0.283289 5.7166667 0.276178 5.7194444 0.272978 5.7222222 0.271556 5.7250000 0.270489 5.7277778 0.267644 5.7305556 0.265511 5.7333333 0.263733 5.7361111 0.263022 5.7388889 0.263022 5.7416667 0.263022 5.7444444 0.261956 5.7472222 0.259467 5.7500000 0.258400 5.7527778 0.258756 5.7555556 0.259467 5.7583333 0.259822 5.7611111 0.257689 5.7638889 0.256622 5.7666667 0.255556 5.7694444 0.256267 5.7722222 0.255911 5.7750000 0.255200 5.7777778 0.253778 5.7805556 0.252000 5.7833333 0.251289 5.7861111 0.252356 5.7888889 0.252711 5.7916667 0.251644 5.7944444 0.248800 5.7972222 0.246667 5.8000000 0.246667 5.8027778 0.247022 5.8055556 0.247733 5.8083333 0.247378 5.8111111 0.245600 5.8138889 0.244533 5.8166667 0.243467 5.8194444 0.243111 5.8222222 0.244178 5.8250000 0.243467 5.8277778 0.242756 5.8305556 0.240267 5.8333333 0.238489 5.8361111 0.238844 5.8388889 0.240267 5.8416667 0.240978 5.8444444 0.239911 5.8472222 0.238489 5.8500000 0.237422 5.8527778 0.238844 5.8555556 0.239556 5.8583333 0.240622 5.8611111 0.240267 5.8638889 0.239200 5.8666667 0.239200 5.8694444 0.240267 5.8722222 0.241333 5.8750000 0.243467 5.8777778 0.243111 5.8805556 0.243467 5.8833333 0.244533 5.8861111 0.246311 5.8888889 0.248444 5.8916667 0.250222 5.8942222 0.300000 5.8944444 0.252000 5.8972222 0.253067 5.9000000 0.254489 5.9027778 0.257689 5.9055556 0.261956 5.9083333 0.264800 5.9111111 0.265511 5.9138889 0.266578 5.9166667 0.266933 5.9194444 0.271200 5.9222222 0.274400 5.9250000 0.277956 5.9277778 0.278667 5.9305556 0.278667 5.9333333 0.280444 5.9361111 0.282578 5.9388889 0.285422 5.9391111 0.300000 5.9416667 0.286133 5.9444444 0.285422 5.9472222 0.284711 5.9500000 0.284356 5.9527778 0.285067 5.9555556 0.286844 5.9583333 0.287556 5.9611111 0.286844 5.9638889 0.286489 5.9666667 0.285067 5.9694444 0.284711 5.9722222 0.286844 5.9750000 0.287200 5.9777778 0.287556 5.9805556 0.285422 5.9833333 0.285778 5.9861111 0.286133 5.9888889 0.287556 5.9916667 0.287556 5.9944444 0.287556 5.9972222 0.285778 6.0000000 0.285422 6.0027778 0.285778 6.0055556 0.286489 6.0083333 0.287556 6.0111111 0.286133 6.0138889 0.285422 6.0166667 0.285422 6.0194444 0.285778 6.0222222 0.287200 6.0250000 0.288267 6.0277778 0.288267 6.0305556 0.287200 6.0333333 0.286133 6.0361111 0.287200 6.0388889 0.287911 6.0416667 0.289689 6.0444444 0.288267 6.0472222 0.287911 6.0500000 0.286133 6.0527778 0.286489 6.0555556 0.288622 6.0583333 0.290044 6.0611111 0.289689 6.0638889 0.287556 6.0666667 0.287911 6.0694444 0.288978 6.0722222 0.290044 6.0750000 0.290756 6.0777778 0.290756 6.0805556 0.290044 6.0833333 0.291111 6.0861111 0.294311 6.0888889 0.295733 6.0916667 0.299289 6.0944444 0.300356 6.0972222 0.301422 6.1000000 0.303556 6.1027778 0.306756 6.1055556 0.311378 6.1083333 0.316000 6.1111111 0.320978 6.1138889 0.326311 6.1166667 0.331644 6.1194444 0.336978 6.1222222 0.344089 6.1250000 0.350133 6.1277778 0.354756 6.1305556 0.359378 6.1333333 0.366133 6.1361111 0.371822 6.1388889 0.377867 6.1416667 0.382133 6.1444444 0.385689 6.1472222 0.390311 6.1500000 0.396356 6.1527778 0.402756 6.1555556 0.405956 6.1583333 0.405956 6.1611111 0.400267 6.1638889 0.396000 6.1666667 0.391733 6.1694444 0.389600 6.1722222 0.387822 6.1750000 0.384978 6.1777778 0.382133 6.1805556 0.379289 6.1833333 0.376444 6.1861111 0.375378 6.1888889 0.376444 6.1916667 0.377156 6.1944444 0.378222 6.1972222 0.379289 6.2000000 0.381778 6.2027778 0.383200 6.2055556 0.379644 6.2083333 0.373956 6.2111111 0.365067 6.2138889 0.352978 6.2166667 0.339467 6.2194444 0.325244 6.2222222 0.312444 6.2250000 0.300356 6.2277778 0.292533 6.2305556 0.285067 6.2333333 0.281156 6.2361111 0.277956 6.2388889 0.276178 6.2416667 0.272622 6.2444444 0.269422 6.2472222 0.266933 6.2500000 0.265156 6.2527778 0.264444 6.2555556 0.264089 6.2583333 0.263022 6.2611111 0.261244 6.2638889 0.258756 6.2666667 0.258400 6.2694444 0.258044 6.2722222 0.257689 6.2750000 0.257333 6.2777778 0.255911 6.2805556 0.253422 6.2833333 0.254133 6.2861111 0.253778 6.2888889 0.254489 6.2916667 0.253778 6.2944444 0.252000 6.2972222 0.249867 6.3000000 0.248089 6.3027778 0.248089 6.3055556 0.248800 6.3083333 0.248444 6.3111111 0.246311 6.3138889 0.244533 6.3166667 0.243111 6.3194444 0.243467 6.3222222 0.244178 6.3250000 0.243822 6.3277778 0.241689 6.3305556 0.240622 6.3333333 0.239200 6.3361111 0.238844 6.3388889 0.239200 6.3416667 0.238489 6.3444444 0.236711 6.3472222 0.236356 6.3500000 0.236000 6.3527778 0.236711 6.3555556 0.238133 6.3583333 0.237778 6.3611111 0.237422 6.3638889 0.237422 6.3666667 0.237067 6.3694444 0.238133 6.3722222 0.240267 6.3750000 0.240978 6.3777778 0.241333 6.3805556 0.241333 6.3833333 0.243111 6.3861111 0.245600 6.3888889 0.247022 6.3916667 0.249867 6.3944444 0.250578 6.3972222 0.250933 6.4000000 0.254133 6.4027778 0.255911 6.4055556 0.258756 6.4083333 0.260889 6.4111111 0.261956 6.4138889 0.263378 6.4166667 0.266222 6.4194444 0.268711 6.4222222 0.271556 6.4250000 0.273333 6.4277778 0.274756 6.4305556 0.273689 6.4333333 0.275467 6.4361111 0.278311 6.4388889 0.280444 6.4416667 0.282222 6.4444444 0.281867 6.4502222 0.300000 6.7720000 0.300000 6.7750000 0.292889 6.7777778 0.291467 6.7805556 0.289689 6.7833333 0.290044 6.7861111 0.291467 6.7888889 0.293244 6.7916667 0.293600 6.7944444 0.291822 6.7972222 0.290400 6.8000000 0.290756 6.8027778 0.291467 6.8055556 0.291822 6.8083333 0.292533 6.8111111 0.291467 6.8138889 0.291111 6.8166667 0.291111 6.8194444 0.292178 6.8222222 0.293600 6.8250000 0.292178 6.8277778 0.291467 6.8305556 0.291467 6.8333333 0.292178 6.8361111 0.291467 6.8388889 0.292178 6.8416667 0.292178 6.8444444 0.291822 6.8472222 0.290400 6.8500000 0.291111 6.8527778 0.292178 6.8555556 0.293244 6.8583333 0.293956 6.8611111 0.293600 6.8638889 0.291467 6.8666667 0.293244 6.8694444 0.294667 6.8722222 0.295378 6.8750000 0.296444 6.8777778 0.295733 6.8805556 0.295733 6.8833333 0.296800 6.8861111 0.299289 6.8888889 0.301067 6.8916667 0.301778 6.8944444 0.301422 6.8972222 0.301778 6.9000000 0.303200 6.9027778 0.304267 6.9055556 0.305333 6.9083333 0.304978 6.9111111 0.304267 6.9138889 0.302133 6.9166667 0.300711 6.9194444 0.302489 6.9222222 0.301778 6.9250000 0.301067 6.9277778 0.298578 6.9305556 0.296444 6.9333333 0.295378 6.9361111 0.294667 6.9388889 0.295378 6.9416667 0.293600 6.9444444 0.291822 6.9472222 0.291467 6.9500000 0.290400 6.9527778 0.290756 6.9555556 0.291467 6.9583333 0.290756 6.9611111 0.290400 6.9638889 0.289333 6.9666667 0.290044 6.9694444 0.291467 6.9722222 0.292533 6.9750000 0.292178 6.9777778 0.291467 6.9805556 0.290756 6.9833333 0.290400 6.9861111 0.291822 6.9888889 0.292533 6.9916667 0.291467 6.9944444 0.289333 6.9972222 0.286844 7.0000000 0.287200 7.0027778 0.291467 7.0055556 0.300356 7.0083333 0.310311 7.0111111 0.322400 7.0138889 0.338756 7.0166667 0.358667 7.0194444 0.380000 7.0222222 0.398844 7.0250000 0.413422 7.0277778 0.415556 7.0305556 0.402756 7.0333333 0.376800 7.0361111 0.346578 7.0388889 0.316000 7.0416667 0.293956 7.0444444 0.286844 7.0472222 0.287200 7.0500000 0.288622 7.0527778 0.289689 7.0555556 0.289689 7.0583333 0.289689 7.0611111 0.290756 7.0638889 0.289333 7.0666667 0.287911 7.0694444 0.287556 7.0722222 0.287911 7.0750000 0.288622 7.0777778 0.288622 7.0805556 0.287200 7.0833333 0.286844 7.0861111 0.287200 7.0888889 0.288267 7.0916667 0.290044 7.0944444 0.288978 7.0972222 0.287911 7.1000000 0.287200 7.1027778 0.287911 7.1055556 0.288622 7.1083333 0.289333 7.1111111 0.288978 7.1138889 0.288267 7.1166667 0.287911 7.1194444 0.288267 7.1222222 0.289333 7.1250000 0.290044 7.1277778 0.289333 7.1305556 0.288267 7.1333333 0.288622 7.1361111 0.288978 7.1388889 0.290044 7.1416667 0.291822 7.1444444 0.291111 7.1472222 0.290756 7.1500000 0.290400 7.1527778 0.290756 7.1555556 0.293244 7.1583333 0.293244 7.1611111 0.292533 7.1638889 0.292889 7.1666667 0.293600 7.1694444 0.294667 7.1722222 0.296800 7.1750000 0.297511 7.1777778 0.296444 7.1805556 0.297156 7.1833333 0.297156 7.1861111 0.298578 7.1888889 0.300711 7.1916667 0.300711 7.1944444 0.301778 7.1972222 0.301422 7.2000000 0.303200 7.2027778 0.303911 7.2055556 0.306044 7.2083333 0.307111 7.2111111 0.307111 7.2138889 0.306756 7.2166667 0.307467 7.2194444 0.309956 7.2222222 0.311378 7.2250000 0.312089 7.2277778 0.312089 7.2305556 0.311378 7.2333333 0.311378 7.2361111 0.312089 7.2388889 0.315289 7.2416667 0.316711 7.2444444 0.316000 7.2472222 0.316356 7.2500000 0.316356 7.2527778 0.317422 7.2555556 0.318133 7.2583333 0.318844 7.2611111 0.318133 7.2638889 0.317778 7.2666667 0.316356 7.2694444 0.316000 7.2722222 0.315289 7.2750000 0.315289 7.2777778 0.313867 7.2805556 0.311022 7.2833333 0.308889 7.2861111 0.308533 7.2888889 0.307111 7.2916667 0.306756 7.2944444 0.305333 7.2970000 0.300000 7.2972222 0.303556 7.3000000 0.301422 7.3027778 0.300000 7.3055556 0.299289 7.3083333 0.298933 7.3111111 0.297867 7.3138889 0.294667 7.3166667 0.293244 7.3194444 0.292178 7.3222222 0.293600 7.3250000 0.293956 7.3277778 0.291822 7.3280000 0.300000 7.3305556 0.291467 7.3333333 0.291111 7.3361111 0.290044 7.3388889 0.291467 7.3416667 0.290400 7.3444444 0.289333 7.3472222 0.288978 7.3500000 0.288267 7.3527778 0.290044 7.3555556 0.290756 7.3583333 0.291467 7.3611111 0.291111 7.3638889 0.289689 7.3666667 0.288978 7.3694444 0.289689 7.3722222 0.291111 7.3750000 0.290756 7.3777778 0.291467 7.3805556 0.290756 7.3833333 0.290400 7.3861111 0.290400 7.3888889 0.291111 7.3916667 0.292178 7.3944444 0.290400 7.3972222 0.289689 7.4000000 0.289689 7.4027778 0.289333 7.4055556 0.291111 7.4083333 0.291467 7.4111111 0.291822 7.4138889 0.290756 7.4166667 0.289689 7.4194444 0.290044 7.4222222 0.291467 7.4250000 0.292178 7.4277778 0.292178 7.4305556 0.291111 7.4333333 0.292533 7.4361111 0.293600 7.4388889 0.295733 7.4416667 0.297156 7.4444444 0.297156 7.4472222 0.297156 7.4500000 0.297511 7.4527778 0.300000 7.4555556 0.302844 7.4583333 0.303911 7.4611111 0.302844 7.4638889 0.301422 7.4666667 0.300356 7.4694444 0.300711 7.4722222 0.301778 7.4750000 0.302489 7.4777778 0.302133 7.4805556 0.300000 7.4833333 0.300356 7.4861111 0.303200 7.4888889 0.305333 7.4916667 0.307822 7.4944444 0.307822 7.4972222 0.309244 7.5000000 0.311733 7.5027778 0.317067 7.5055556 0.323467 7.5083333 0.329156 7.5111111 0.332711 7.5138889 0.337333 7.5166667 0.341600 7.5194444 0.346933 7.5222222 0.354400 7.5250000 0.359378 7.5277778 0.364356 7.5305556 0.368622 7.5333333 0.373956 7.5361111 0.379289 7.5388889 0.384622 7.5416667 0.390311 7.5444444 0.396711 7.5472222 0.403111 7.5500000 0.407022 7.5527778 0.408089 7.5555556 0.406311 7.5583333 0.401689 7.5611111 0.395644 7.5638889 0.391378 7.5666667 0.388178 7.5694444 0.384622 7.5722222 0.381778 7.5750000 0.379644 7.5777778 0.375378 7.5805556 0.371111 7.5833333 0.370044 7.5861111 0.370756 7.5888889 0.370400 7.5916667 0.370400 7.5944444 0.368622 7.5972222 0.367200 7.6000000 0.364356 7.6027778 0.360444 7.6055556 0.352978 7.6083333 0.344089 7.6111111 0.331289 7.6138889 0.314222 7.6166667 0.299289 7.6194444 0.287200 7.6222222 0.277956 7.6250000 0.271911 7.6277778 0.267289 7.6305556 0.264089 7.6333333 0.262667 7.6361111 0.260533 7.6388889 0.261600 7.6416667 0.259467 7.6444444 0.257689 7.6472222 0.255200 7.6500000 0.254844 7.6527778 0.255200 7.6555556 0.255200 7.6583333 0.254844 7.6611111 0.253422 7.6638889 0.251644 7.6666667 0.250578 7.6694444 0.250578 7.6722222 0.250933 7.6750000 0.250578 7.6777778 0.248800 7.6805556 0.247378 7.6833333 0.245956 7.6861111 0.245244 7.6888889 0.245244 7.6916667 0.243822 7.6944444 0.243467 7.6972222 0.241689 7.7000000 0.241333 7.7027778 0.239911 7.7055556 0.240267 7.7083333 0.239911 7.7111111 0.239200 7.7138889 0.237067 7.7166667 0.236356 7.7194444 0.235644 7.7222222 0.236711 7.7250000 0.236000 7.7277778 0.234222 7.7305556 0.231733 7.7333333 0.231733 7.7361111 0.232800 7.7388889 0.231733 7.7416667 0.231378 7.7444444 0.231022 7.7472222 0.229600 7.7500000 0.229600 7.7527778 0.230311 7.7555556 0.231378 7.7583333 0.231733 7.7611111 0.231733 7.7638889 0.230667 7.7666667 0.231378 7.7694444 0.233511 7.7722222 0.235289 7.7750000 0.236356 7.7777778 0.236356 7.7805556 0.236356 7.7833333 0.238133 7.7861111 0.240267 7.7888889 0.244178 7.7916667 0.245956 7.7944444 0.247022 7.7972222 0.248800 7.8000000 0.250933 7.8027778 0.253778 7.8053333 0.300000 7.8055556 0.256978 7.8083333 0.258756 7.8111111 0.261600 7.8138889 0.261956 7.8166667 0.264089 7.8194444 0.267289 7.8222222 0.270133 7.8250000 0.271200 7.8277778 0.271556 7.8305556 0.272978 7.8333333 0.273333 7.8361111 0.276533 7.8388889 0.276889 7.8416667 0.278311 7.8444444 0.278311 7.8472222 0.276889 7.8500000 0.277244 7.8527778 0.278311 7.8530000 0.300000 7.8555556 0.279733 7.8583333 0.280089 7.8611111 0.278311 7.8638889 0.277600 7.8666667 0.276889 7.8694444 0.277600 7.8722222 0.279733 7.8750000 0.279733 7.8777778 0.279022 7.8805556 0.277600 7.8833333 0.277600 7.8861111 0.277600 7.8888889 0.279378 7.8916667 0.279378 7.8944444 0.279022 7.8972222 0.278311 7.9000000 0.277600 7.9027778 0.278311 7.9055556 0.278667 7.9083333 0.279022 7.9111111 0.278667 7.9138889 0.277956 7.9166667 0.277244 7.9194444 0.277956 7.9222222 0.279022 7.9250000 0.280089 7.9277778 0.280089 7.9305556 0.278667 7.9333333 0.278311 7.9361111 0.277956 7.9388889 0.280089 7.9416667 0.281156 7.9444444 0.281511 7.9472222 0.280800 7.9500000 0.280089 7.9527778 0.280800 7.9555556 0.282933 7.9583333 0.282933 7.9611111 0.282933 7.9638889 0.282933 7.9666667 0.282222 7.9694444 0.283289 7.9722222 0.284000 7.9750000 0.284711 7.9777778 0.284356 7.9805556 0.282578 7.9833333 0.282222 7.9861111 0.284000 7.9888889 0.285778 7.9916667 0.287556 7.9944444 0.287911 7.9972222 0.289333 8.0000000 0.291111 8.0027778 0.295022 8.0055556 0.298578 8.0083333 0.300711 8.0111111 0.303911 8.0138889 0.306756 8.0166667 0.309600 8.0194444 0.317422 8.0222222 0.325244 8.0250000 0.332000 8.0277778 0.336622 8.0305556 0.342311 8.0333333 0.347289 8.0361111 0.354400 8.0388889 0.361156 8.0416667 0.367556 8.0444444 0.375378 8.0472222 0.381422 8.0500000 0.387467 8.0527778 0.396356 8.0555556 0.405956 8.0583333 0.410933 8.0611111 0.413067 8.0638889 0.409156 8.0666667 0.403467 8.0694444 0.398844 8.0722222 0.394578 8.0750000 0.391022 8.0777778 0.388533 8.0805556 0.384978 8.0833333 0.382489 8.0861111 0.380000 8.0888889 0.377867 8.0916667 0.375022 8.0944444 0.373244 8.0972222 0.370044 8.1000000 0.369333 8.1027778 0.371111 8.1055556 0.372889 8.1083333 0.370044 8.1111111 0.364000 8.1138889 0.354756 8.1166667 0.344089 8.1194444 0.332356 8.1222222 0.318133 8.1250000 0.303556 8.1277778 0.290400 8.1305556 0.277244 8.1333333 0.270844 8.1361111 0.267289 8.1388889 0.266578 8.1416667 0.265156 8.1444444 0.262667 8.1472222 0.259822 8.1500000 0.257333 8.1527778 0.256267 8.1555556 0.256622 8.1583333 0.255556 8.1611111 0.253422 8.1638889 0.251289 8.1666667 0.250933 8.1694444 0.251289 8.1722222 0.251644 8.1750000 0.251289 8.1777778 0.248800 8.1805556 0.247022 8.1833333 0.246311 8.1861111 0.247022 8.1888889 0.247378 8.1916667 0.245956 8.1944444 0.244178 8.1972222 0.242044 8.2000000 0.240622 8.2027778 0.240267 8.2055556 0.240978 8.2083333 0.239911 8.2111111 0.237778 8.2138889 0.236000 8.2166667 0.234578 8.2194444 0.234933 8.2222222 0.234933 8.2250000 0.234222 8.2277778 0.232444 8.2305556 0.231022 8.2333333 0.229600 8.2361111 0.229600 8.2388889 0.229956 8.2416667 0.230667 8.2444444 0.229600 8.2472222 0.227467 8.2500000 0.227822 8.2527778 0.229956 8.2555556 0.232800 8.2583333 0.234222 8.2611111 0.233511 8.2638889 0.234222 8.2666667 0.235644 8.2694444 0.239911 8.2722222 0.242756 8.2750000 0.245956 8.2777778 0.248800 8.2805556 0.249156 8.2833333 0.252356 8.2861111 0.255911 8.2888889 0.259822 8.2916667 0.262667 8.2944444 0.264800 8.2972222 0.266578 8.3000000 0.268711 8.3027778 0.271911 8.3055556 0.275111 8.3083333 0.276178 8.3111111 0.277600 8.3138889 0.277956 8.3166667 0.279022 8.3194444 0.280444 8.3222222 0.281511 8.3250000 0.282578 8.3277778 0.281511 8.3305556 0.280800 8.3333333 0.279378 8.3361111 0.281511 8.3388889 0.283644 8.3416667 0.284000 8.3444444 0.282933 8.3472222 0.281867 8.3500000 0.281511 8.3527778 0.281867 8.3555556 0.283289 8.3613333 0.300000 8.5581111 0.300000 8.5611111 0.290400 8.5638889 0.288622 8.5666667 0.288978 8.5694444 0.289689 8.5722222 0.291111 8.5750000 0.291467 8.5777778 0.290756 8.5805556 0.289333 8.5833333 0.288978 8.5861111 0.291111 8.5888889 0.291111 8.5916667 0.289689 8.5944444 0.289689 8.5972222 0.289689 8.6000000 0.289689 8.6027778 0.290400 8.6055556 0.291111 8.6083333 0.290400 8.6111111 0.288978 8.6138889 0.290044 8.6166667 0.290044 8.6194444 0.291111 8.6222222 0.291467 8.6250000 0.291822 8.6277778 0.291111 8.6305556 0.289689 8.6333333 0.289689 8.6361111 0.290400 8.6388889 0.291822 8.6416667 0.292533 8.6444444 0.292178 8.6472222 0.292533 8.6500000 0.292889 8.6527778 0.294311 8.6555556 0.296444 8.6583333 0.296800 8.6611111 0.297511 8.6638889 0.298222 8.6666667 0.298933 8.6694444 0.301422 8.6722222 0.303556 8.6750000 0.303556 8.6777778 0.302489 8.6805556 0.302133 8.6833333 0.301778 8.6861111 0.302489 8.6888889 0.301778 8.6916667 0.300356 8.6944444 0.298578 8.6972222 0.296444 8.7000000 0.296444 8.7027778 0.296089 8.7055556 0.296089 8.7083333 0.295378 8.7111111 0.293600 8.7138889 0.291822 8.7166667 0.291111 8.7194444 0.291111 8.7222222 0.291111 8.7250000 0.291111 8.7277778 0.290044 8.7305556 0.288267 8.7333333 0.289689 8.7361111 0.289689 8.7388889 0.290400 8.7416667 0.290756 8.7444444 0.289689 8.7472222 0.288978 8.7500000 0.290044 8.7527778 0.291111 8.7555556 0.291822 8.7583333 0.291111 8.7611111 0.290044 8.7638889 0.289689 8.7666667 0.289689 8.7694444 0.291467 8.7722222 0.291822 8.7750000 0.291111 8.7777778 0.288978 8.7805556 0.288267 8.7833333 0.289333 8.7861111 0.295022 8.7888889 0.302844 8.7916667 0.312444 8.7944444 0.324178 8.7972222 0.337689 8.8000000 0.353333 8.8027778 0.370756 8.8055556 0.388889 8.8083333 0.404533 8.8111111 0.413778 8.8138889 0.409511 8.8166667 0.391022 8.8194444 0.366489 8.8222222 0.342311 8.8250000 0.320622 8.8277778 0.307111 8.8305556 0.300000 8.8333333 0.295022 8.8361111 0.291822 8.8388889 0.289689 8.8416667 0.288622 8.8444444 0.288267 8.8472222 0.290400 8.8500000 0.290756 8.8527778 0.290400 8.8555556 0.290400 8.8583333 0.289333 8.8611111 0.287556 8.8638889 0.286844 8.8666667 0.286844 8.8694444 0.287200 8.8722222 0.288267 8.8750000 0.287911 8.8777778 0.285422 8.8805556 0.285778 8.8833333 0.286133 8.8861111 0.287556 8.8888889 0.287200 8.8916667 0.288267 8.8944444 0.287200 8.8972222 0.286489 8.9000000 0.286133 8.9027778 0.287911 8.9055556 0.289333 8.9083333 0.288978 8.9111111 0.288267 8.9138889 0.287200 8.9166667 0.286844 8.9194444 0.288978 8.9222222 0.289333 8.9250000 0.290044 8.9277778 0.290044 8.9305556 0.288978 8.9333333 0.288978 8.9361111 0.291111 8.9388889 0.292889 8.9416667 0.293244 8.9444444 0.292533 8.9472222 0.291111 8.9500000 0.290044 8.9527778 0.292178 8.9555556 0.294667 8.9583333 0.294667 8.9611111 0.293600 8.9638889 0.292889 8.9666667 0.293956 8.9694444 0.295378 8.9722222 0.297867 8.9750000 0.299289 8.9777778 0.297156 8.9805556 0.297156 8.9833333 0.296089 8.9861111 0.298933 8.9888889 0.301778 8.9916667 0.303200 8.9944444 0.302489 8.9972222 0.301067 9.0000000 0.301778 9.0027778 0.303911 9.0055556 0.307822 9.0083333 0.308178 9.0111111 0.308533 9.0138889 0.307822 9.0166667 0.308889 9.0194444 0.311022 9.0222222 0.313511 9.0250000 0.314578 9.0277778 0.314933 9.0305556 0.314578 9.0333333 0.314933 9.0361111 0.316711 9.0388889 0.318133 9.0416667 0.319200 9.0444444 0.319200 9.0472222 0.318844 9.0500000 0.318489 9.0527778 0.319556 9.0555556 0.322044 9.0583333 0.322756 9.0611111 0.322400 9.0638889 0.320978 9.0666667 0.319556 9.0694444 0.319556 9.0722222 0.320622 9.0750000 0.320622 9.0777778 0.317067 9.0805556 0.314578 9.0833333 0.312089 9.0861111 0.312089 9.0888889 0.312444 9.0916667 0.311022 9.0944444 0.309956 9.0972222 0.305689 9.1000000 0.304267 9.1027778 0.303556 9.1055556 0.303911 9.1083333 0.301422 9.1141111 0.300000 9.1414444 0.300000 9.1444444 0.292533 9.1472222 0.291111 9.1500000 0.291111 9.1527778 0.291111 9.1555556 0.292178 9.1583333 0.292178 9.1611111 0.292533 9.1638889 0.291467 9.1666667 0.290400 9.1694444 0.290400 9.1722222 0.291467 9.1750000 0.291822 9.1777778 0.292889 9.1805556 0.291111 9.1833333 0.290756 9.1861111 0.291111 9.1888889 0.291467 9.1916667 0.292533 9.1944444 0.293244 9.1972222 0.291111 9.2000000 0.291822 9.2027778 0.292889 9.2055556 0.294311 9.2083333 0.294311 9.2111111 0.292533 9.2138889 0.291467 9.2166667 0.290756 9.2194444 0.290756 9.2222222 0.291822 9.2250000 0.292533 9.2277778 0.293244 9.2305556 0.292178 9.2333333 0.292889 9.2361111 0.292533 9.2388889 0.293244 9.2416667 0.292889 9.2444444 0.292178 9.2472222 0.292178 9.2500000 0.291467 9.2527778 0.292533 9.2555556 0.292178 9.2583333 0.292178 9.2611111 0.292178 9.2638889 0.291467 9.2666667 0.293600 9.2694444 0.295022 9.2722222 0.295733 9.2750000 0.296444 9.2777778 0.296444 9.2805556 0.296800 9.2833333 0.297156 9.2861111 0.298933 9.2888889 0.300356 9.2916667 0.301422 9.2944444 0.301778 9.2972222 0.301778 9.3000000 0.301778 9.3027778 0.303200 9.3055556 0.304622 9.3083333 0.303911 9.3111111 0.301422 9.3138889 0.300356 9.3166667 0.300711 9.3194444 0.302133 9.3222222 0.303200 9.3250000 0.303200 9.3277778 0.302489 9.3305556 0.301778 9.3333333 0.303556 9.3361111 0.304978 9.3388889 0.308889 9.3416667 0.311378 9.3444444 0.312089 9.3472222 0.314578 9.3500000 0.319200 9.3527778 0.324889 9.3555556 0.330933 9.3583333 0.336622 9.3611111 0.340533 9.3638889 0.343733 9.3666667 0.348356 9.3694444 0.353689 9.3722222 0.359022 9.3750000 0.364000 9.3777778 0.368622 9.3805556 0.373956 9.3833333 0.379289 9.3861111 0.384267 9.3888889 0.388533 9.3916667 0.395289 9.3944444 0.400978 9.3972222 0.406311 9.4000000 0.410222 9.4027778 0.410578 9.4055556 0.409867 9.4083333 0.407022 9.4111111 0.402756 9.4138889 0.398844 9.4166667 0.394578 9.4194444 0.392089 9.4222222 0.391378 9.4250000 0.388533 9.4277778 0.386756 9.4305556 0.383200 9.4333333 0.381067 9.4361111 0.381422 9.4388889 0.382489 9.4416667 0.382133 9.4444444 0.381067 9.4472222 0.380000 9.4500000 0.377511 9.4527778 0.373244 9.4555556 0.368267 9.4583333 0.361511 9.4611111 0.350844 9.4638889 0.336978 9.4666667 0.320978 9.4694444 0.306756 9.4722222 0.293600 9.4750000 0.284711 9.4777778 0.276889 9.4805556 0.271911 9.4833333 0.268356 9.4861111 0.267289 9.4888889 0.267644 9.4916667 0.266933 9.4944444 0.264800 9.4972222 0.261600 9.5000000 0.259111 9.5027778 0.258756 9.5055556 0.258756 9.5083333 0.259111 9.5111111 0.258756 9.5138889 0.256978 9.5166667 0.256622 9.5194444 0.255911 9.5222222 0.255911 9.5250000 0.255556 9.5277778 0.253778 9.5305556 0.252356 9.5333333 0.252356 9.5361111 0.253422 9.5388889 0.254844 9.5416667 0.252711 9.5444444 0.251289 9.5472222 0.250933 9.5500000 0.250222 9.5527778 0.250578 9.5555556 0.250933 9.5583333 0.250222 9.5611111 0.248444 9.5638889 0.247378 9.5666667 0.247022 9.5694444 0.246667 9.5722222 0.246667 9.5750000 0.245244 9.5777778 0.243111 9.5805556 0.241333 9.5833333 0.241333 9.5861111 0.242044 9.5888889 0.242400 9.5916667 0.242400 9.5944444 0.240978 9.5972222 0.238844 9.6000000 0.238489 9.6027778 0.238844 9.6055556 0.238844 9.6083333 0.239556 9.6111111 0.238489 9.6138889 0.236711 9.6166667 0.235289 9.6194444 0.237422 9.6222222 0.239200 9.6250000 0.240978 9.6277778 0.238844 9.6305556 0.238844 9.6333333 0.238133 9.6361111 0.239911 9.6388889 0.242044 9.6416667 0.242756 9.6444444 0.243467 9.6472222 0.242756 9.6500000 0.243467 9.6527778 0.244889 9.6555556 0.247733 9.6583333 0.249156 9.6611111 0.250578 9.6638889 0.251644 9.6666667 0.253067 9.6694444 0.254133 9.6722222 0.257333 9.6750000 0.259822 9.6777778 0.262311 9.6805556 0.264089 9.6831111 0.300000 9.6833333 0.264800 9.6861111 0.266933 9.6888889 0.269778 9.6916667 0.272622 9.6944444 0.275467 9.6972222 0.275467 9.6974444 0.300000 9.7000000 0.277600 9.7027778 0.279378 9.7055556 0.282222 9.7083333 0.283289 9.7111111 0.283289 9.7138889 0.282933 9.7166667 0.283289 9.7194444 0.284000 9.7222222 0.285778 9.7250000 0.286133 9.7277778 0.286133 9.7305556 0.285067 9.7333333 0.285422 9.7361111 0.285422 9.7388889 0.286133 9.7416667 0.287200 9.7444444 0.286133 9.7472222 0.285422 9.7500000 0.285067 9.7527778 0.285422 9.7555556 0.286489 9.7583333 0.287200 9.7611111 0.287556 9.7638889 0.286844 9.7666667 0.286489 9.7694444 0.287200 9.7722222 0.287556 9.7750000 0.287556 9.7777778 0.287556 9.7805556 0.287200 9.7833333 0.287911 9.7861111 0.288622 9.7888889 0.287556 9.7916667 0.287200 9.7944444 0.286489 9.7972222 0.286489 9.8000000 0.287556 9.8027778 0.287911 9.8055556 0.287911 9.8083333 0.288267 9.8111111 0.287200 9.8138889 0.286844 9.8166667 0.287200 9.8194444 0.287911 9.8222222 0.288267 9.8250000 0.287911 9.8277778 0.288267 9.8305556 0.286844 9.8333333 0.287556 9.8361111 0.287911 9.8388889 0.288267 9.8416667 0.287911 9.8444444 0.287556 9.8472222 0.287911 9.8500000 0.287556 9.8527778 0.288978 9.8555556 0.290400 9.8583333 0.291467 9.8611111 0.292889 9.8638889 0.292533 9.8666667 0.294311 9.8694444 0.297511 9.8722222 0.301067 9.8750000 0.304267 9.8777778 0.306044 9.8805556 0.308533 9.8833333 0.311733 9.8861111 0.316711 9.8888889 0.322756 9.8916667 0.327733 9.8944444 0.333778 9.8972222 0.338756 9.9000000 0.344089 9.9027778 0.350489 9.9055556 0.357244 9.9083333 0.362933 9.9111111 0.366844 9.9138889 0.372889 9.9166667 0.380356 9.9194444 0.387111 9.9222222 0.392800 9.9250000 0.398489 9.9277778 0.403467 9.9305556 0.410222 9.9333333 0.415911 9.9361111 0.418756 9.9388889 0.418044 9.9416667 0.415200 9.9444444 0.409511 9.9472222 0.405244 9.9500000 0.400978 9.9527778 0.396356 9.9555556 0.393511 9.9583333 0.387822 9.9611111 0.383200 9.9638889 0.378578 9.9666667 0.375022 9.9694444 0.373600 9.9722222 0.373600 9.9750000 0.372533 9.9777778 0.371111 9.9805556 0.370756 9.9833333 0.368622 9.9861111 0.362933 9.9888889 0.354044 9.9916667 0.342311 9.9944444 0.328444 9.9972222 0.313511 10.0000000 0.300711 10.0027778 0.291111 10.0055556 0.284000 10.0083333 0.278311 10.0111111 0.273689 10.0138889 0.270489 10.0166667 0.268356 10.0194444 0.267644 10.0222222 0.266222 10.0250000 0.265511 10.0277778 0.263733 10.0305556 0.263022 10.0333333 0.261956 10.0361111 0.261600 10.0388889 0.261244 10.0416667 0.260178 10.0444444 0.259467 10.0472222 0.257689 10.0500000 0.257333 10.0527778 0.257333 10.0555556 0.256978 10.0583333 0.256978 10.0611111 0.255200 10.0638889 0.254133 10.0666667 0.253778 10.0694444 0.254133 10.0722222 0.253778 10.0750000 0.252356 10.0777778 0.251644 10.0805556 0.249867 10.0833333 0.250933 10.0861111 0.250578 10.0888889 0.250222 10.0916667 0.249511 10.0944444 0.247733 10.0972222 0.245600 10.1000000 0.245244 10.1027778 0.244533 10.1055556 0.245244 10.1083333 0.244533 10.1111111 0.242756 10.1138889 0.241689 10.1166667 0.241333 10.1194444 0.241333 10.1222222 0.241333 10.1250000 0.241333 10.1277778 0.239556 10.1305556 0.238844 10.1333333 0.238844 10.1361111 0.238844 10.1388889 0.239556 10.1416667 0.239200 10.1444444 0.238133 10.1472222 0.238133 10.1500000 0.237778 10.1527778 0.239200 10.1555556 0.241333 10.1583333 0.241689 10.1611111 0.240978 10.1638889 0.241689 10.1666667 0.243467 10.1694444 0.245600 10.1722222 0.247378 10.1750000 0.247378 10.1777778 0.248089 10.1805556 0.250222 10.1833333 0.252000 10.1861111 0.254844 10.1888889 0.258756 10.1916667 0.260533 10.1944444 0.260889 10.1972222 0.263378 10.2000000 0.265867 10.2027778 0.269422 10.2055556 0.273333 10.2083333 0.274756 10.2111111 0.275111 10.2138889 0.276533 10.2166667 0.277956 10.2194444 0.279733 10.2222222 0.282933 10.2250000 0.283289 10.2277778 0.283289 10.2305556 0.282933 10.2333333 0.284000 10.2391111 0.300000 10.4608889 0.300000 10.4638889 0.291111 10.4666667 0.290756 10.4694444 0.291111 10.4722222 0.292889 10.4750000 0.293956 10.4777778 0.292533 10.4805556 0.292533 10.4833333 0.291111 10.4861111 0.291822 10.4888889 0.293600 10.4916667 0.294311 10.4944444 0.293600 10.4972222 0.292533 10.5000000 0.291822 10.5027778 0.292178 10.5055556 0.293600 10.5083333 0.293600 10.5111111 0.293244 10.5138889 0.292889 10.5166667 0.291111 10.5194444 0.292533 10.5222222 0.294667 10.5250000 0.295022 10.5277778 0.293956 10.5305556 0.293956 10.5333333 0.292533 10.5361111 0.293956 10.5388889 0.295022 10.5416667 0.295733 10.5444444 0.295378 10.5472222 0.296089 10.5500000 0.296089 10.5527778 0.297867 10.5555556 0.299289 10.5583333 0.300356 10.5611111 0.300000 10.5638889 0.301067 10.5666667 0.301778 10.5694444 0.302844 10.5722222 0.304978 10.5750000 0.306044 10.5777778 0.306400 10.5805556 0.306400 10.5833333 0.306044 10.5861111 0.305689 10.5888889 0.306044 10.5916667 0.306044 10.5944444 0.303911 10.5972222 0.303200 10.6000000 0.302489 10.6027778 0.301778 10.6055556 0.301422 10.6083333 0.299289 10.6111111 0.298222 10.6138889 0.296089 10.6166667 0.295733 10.6194444 0.296089 10.6222222 0.296444 10.6250000 0.295378 10.6277778 0.294311 10.6305556 0.292889 10.6333333 0.292178 10.6361111 0.292178 10.6388889 0.292533 10.6416667 0.293244 10.6444444 0.292889 10.6472222 0.291822 10.6500000 0.292178 10.6527778 0.291467 10.6555556 0.293600 10.6583333 0.293956 10.6611111 0.293244 10.6638889 0.292533 10.6666667 0.292889 10.6694444 0.292178 10.6722222 0.292533 10.6750000 0.293956 10.6777778 0.292889 10.6805556 0.291822 10.6833333 0.290044 10.6861111 0.290044 10.6888889 0.295022 10.6916667 0.303911 10.6944444 0.313511 10.6972222 0.324889 10.7000000 0.338044 10.7027778 0.356889 10.7055556 0.378578 10.7083333 0.398844 10.7111111 0.415556 10.7138889 0.422311 10.7166667 0.415200 10.7194444 0.394222 10.7222222 0.367911 10.7250000 0.341244 10.7277778 0.317422 10.7305556 0.300000 10.7333333 0.292533 10.7361111 0.290756 10.7388889 0.291467 10.7416667 0.292533 10.7444444 0.289689 10.7472222 0.290400 10.7500000 0.290400 10.7527778 0.292178 10.7555556 0.291822 10.7583333 0.291822 10.7611111 0.290756 10.7638889 0.290044 10.7666667 0.290044 10.7694444 0.290400 10.7722222 0.290044 10.7750000 0.289333 10.7777778 0.288978 10.7805556 0.288622 10.7833333 0.288978 10.7861111 0.289333 10.7888889 0.289689 10.7916667 0.290044 10.7944444 0.290400 10.7972222 0.289333 10.8000000 0.289689 10.8027778 0.289689 10.8055556 0.289333 10.8083333 0.290756 10.8111111 0.289689 10.8138889 0.288978 10.8166667 0.290400 10.8194444 0.290400 10.8222222 0.291467 10.8250000 0.292178 10.8277778 0.291467 10.8305556 0.290756 10.8333333 0.291467 10.8361111 0.292889 10.8388889 0.292178 10.8416667 0.293244 10.8444444 0.292533 10.8472222 0.293244 10.8500000 0.293956 10.8527778 0.295022 10.8555556 0.296089 10.8583333 0.297511 10.8611111 0.296444 10.8638889 0.296444 10.8666667 0.296444 10.8694444 0.297156 10.8722222 0.299289 10.8750000 0.299644 10.8777778 0.300711 10.8805556 0.301067 10.8833333 0.301067 10.8861111 0.302133 10.8888889 0.303200 10.8916667 0.303911 10.8944444 0.304622 10.8972222 0.305333 10.9000000 0.305689 10.9027778 0.306044 10.9055556 0.308533 10.9083333 0.309956 10.9111111 0.309956 10.9138889 0.311378 10.9166667 0.312089 10.9194444 0.313156 10.9222222 0.315644 10.9250000 0.315289 10.9277778 0.316356 10.9305556 0.317067 10.9333333 0.316356 10.9361111 0.317422 10.9388889 0.318844 10.9416667 0.318844 10.9444444 0.320267 10.9472222 0.319556 10.9500000 0.319911 10.9527778 0.319200 10.9555556 0.320978 10.9583333 0.320267 10.9611111 0.319200 10.9638889 0.318133 10.9666667 0.318133 10.9694444 0.319200 10.9722222 0.317778 10.9750000 0.315289 10.9777778 0.314933 10.9805556 0.312444 10.9833333 0.311733 10.9861111 0.309956 10.9888889 0.309956 10.9916667 0.307822 10.9944444 0.306044 10.9972222 0.304978 11.0000000 0.302489 11.0027778 0.302133 11.0055556 0.300356 11.0083333 0.300000 11.0111111 0.298578 11.0168889 0.300000 11.0470000 0.300000 11.0500000 0.290756 11.0527778 0.291822 11.0555556 0.292889 11.0583333 0.293956 11.0611111 0.293600 11.0638889 0.292533 11.0666667 0.292178 11.0694444 0.291822 11.0722222 0.293600 11.0750000 0.294311 11.0777778 0.293956 11.0805556 0.292533 11.0833333 0.291822 11.0861111 0.292889 11.0888889 0.294311 11.0916667 0.295378 11.0944444 0.293600 11.0972222 0.292889 11.1000000 0.291467 11.1027778 0.292178 11.1055556 0.293244 11.1083333 0.293600 11.1111111 0.294311 11.1138889 0.293244 11.1166667 0.291822 11.1194444 0.292533 11.1222222 0.295022 11.1250000 0.294311 11.1277778 0.294667 11.1305556 0.293244 11.1333333 0.291822 11.1361111 0.293244 11.1388889 0.294667 11.1416667 0.295733 11.1444444 0.295733 11.1472222 0.295733 11.1500000 0.295733 11.1527778 0.297867 11.1555556 0.298933 11.1583333 0.300000 11.1611111 0.300356 11.1638889 0.301422 11.1666667 0.301422 11.1694444 0.302844 11.1722222 0.305333 11.1750000 0.305333 11.1777778 0.304978 11.1805556 0.302489 11.1833333 0.301067 11.1861111 0.301778 11.1888889 0.302133 11.1916667 0.301422 11.1944444 0.300000 11.1972222 0.297156 11.2000000 0.293956 11.2027778 0.293244 11.2055556 0.293956 11.2083333 0.293956 11.2111111 0.292889 11.2138889 0.291822 11.2166667 0.292889 11.2194444 0.296444 11.2222222 0.300000 11.2250000 0.302133 11.2277778 0.304267 11.2305556 0.307111 11.2333333 0.312089 11.2361111 0.317422 11.2388889 0.323822 11.2416667 0.328800 11.2444444 0.333778 11.2472222 0.336622 11.2500000 0.342311 11.2527778 0.349067 11.2555556 0.353333 11.2583333 0.356889 11.2611111 0.360089 11.2638889 0.365422 11.2666667 0.372889 11.2694444 0.378933 11.2722222 0.383200 11.2750000 0.387467 11.2777778 0.391378 11.2805556 0.396711 11.2833333 0.405956 11.2861111 0.412711 11.2888889 0.417689 11.2916667 0.420533 11.2944444 0.423022 11.2972222 0.427644 11.3000000 0.435467 11.3027778 0.442222 11.3055556 0.445422 11.3083333 0.431911 11.3111111 0.404533 11.3138889 0.374311 11.3166667 0.349422 11.3194444 0.329867 11.3222222 0.311733 11.3250000 0.297867 11.3277778 0.287556 11.3305556 0.281156 11.3333333 0.277956 11.3361111 0.277244 11.3388889 0.275111 11.3416667 0.272267 11.3444444 0.270133 11.3472222 0.268356 11.3500000 0.266933 11.3527778 0.266933 11.3555556 0.265511 11.3583333 0.264089 11.3611111 0.263022 11.3638889 0.262667 11.3666667 0.262667 11.3694444 0.262667 11.3722222 0.263378 11.3750000 0.262311 11.3777778 0.261244 11.3805556 0.260533 11.3833333 0.261244 11.3861111 0.261600 11.3888889 0.261956 11.3916667 0.261244 11.3944444 0.259111 11.3972222 0.258400 11.4000000 0.258756 11.4027778 0.259467 11.4055556 0.259822 11.4083333 0.258044 11.4111111 0.257333 11.4138889 0.256978 11.4166667 0.255200 11.4194444 0.256622 11.4222222 0.255911 11.4250000 0.254844 11.4277778 0.254133 11.4305556 0.253422 11.4333333 0.252711 11.4361111 0.252711 11.4388889 0.252000 11.4416667 0.252000 11.4444444 0.249867 11.4472222 0.249511 11.4500000 0.250222 11.4527778 0.250222 11.4555556 0.249867 11.4583333 0.249156 11.4611111 0.248800 11.4638889 0.247733 11.4666667 0.248800 11.4694444 0.248800 11.4722222 0.249511 11.4750000 0.249511 11.4777778 0.249511 11.4805556 0.249511 11.4833333 0.249511 11.4861111 0.250222 11.4888889 0.250222 11.4916667 0.252000 11.4944444 0.252000 11.4972222 0.253778 11.5000000 0.254844 11.5027778 0.256622 11.5053333 0.300000 11.5055556 0.257689 11.5083333 0.258756 11.5111111 0.260533 11.5138889 0.261244 11.5166667 0.263733 11.5194444 0.265511 11.5222222 0.267644 11.5250000 0.269422 11.5277778 0.271200 11.5305556 0.272622 11.5333333 0.274756 11.5361111 0.275467 11.5388889 0.277600 11.5416667 0.278311 11.5444444 0.280089 11.5472222 0.280089 11.5500000 0.280800 11.5527778 0.282933 11.5555556 0.283644 11.5583333 0.284711 11.5611111 0.284000 11.5638889 0.285067 11.5666667 0.284711 11.5694444 0.285422 11.5722222 0.285778 11.5750000 0.284000 11.5777778 0.284711 11.5805556 0.282933 11.5833333 0.282933 11.5861111 0.285067 11.5888889 0.284356 11.5916667 0.284000 11.5944444 0.284000 11.5972222 0.282578 11.6000000 0.283289 11.6027778 0.284000 11.6030000 0.300000 11.6055556 0.284711 11.6083333 0.284711 11.6111111 0.284356 11.6138889 0.283289 11.6166667 0.284356 11.6194444 0.285778 11.6222222 0.286133 11.6250000 0.286133 11.6277778 0.285067 11.6305556 0.283644 11.6333333 0.283644 11.6361111 0.285422 11.6388889 0.285422 11.6416667 0.286133 11.6444444 0.285422 11.6472222 0.283644 11.6500000 0.284356 11.6527778 0.285067 11.6555556 0.285422 11.6583333 0.285067 11.6611111 0.283644 11.6638889 0.282933 11.6666667 0.283644 11.6694444 0.284711 11.6722222 0.286133 11.6750000 0.286489 11.6777778 0.285778 11.6805556 0.283644 11.6833333 0.283644 11.6861111 0.285422 11.6888889 0.287200 11.6916667 0.288622 11.6944444 0.288978 11.6972222 0.289333 11.7000000 0.290044 11.7027778 0.293244 11.7055556 0.295733 11.7083333 0.298578 11.7111111 0.300000 11.7138889 0.301422 11.7166667 0.305333 11.7194444 0.311378 11.7222222 0.317778 11.7250000 0.323822 11.7277778 0.328089 11.7305556 0.332356 11.7333333 0.336622 11.7361111 0.343733 11.7388889 0.351200 11.7416667 0.356533 11.7444444 0.360089 11.7472222 0.362933 11.7500000 0.367556 11.7527778 0.373244 11.7555556 0.377156 11.7583333 0.383911 11.7611111 0.389600 11.7638889 0.394222 11.7666667 0.396711 11.7694444 0.398489 11.7722222 0.398133 11.7750000 0.394933 11.7777778 0.390667 11.7805556 0.387111 11.7833333 0.385333 11.7861111 0.383200 11.7888889 0.384267 11.7916667 0.383200 11.7944444 0.380000 11.7972222 0.375733 11.8000000 0.373956 11.8027778 0.373244 11.8055556 0.372889 11.8083333 0.374311 11.8111111 0.375022 11.8138889 0.373244 11.8166667 0.368978 11.8194444 0.361867 11.8222222 0.351911 11.8250000 0.340533 11.8277778 0.325956 11.8305556 0.309244 11.8333333 0.294667 11.8361111 0.284000 11.8388889 0.276889 11.8416667 0.271911 11.8444444 0.268356 11.8472222 0.265511 11.8500000 0.264089 11.8527778 0.262667 11.8555556 0.262311 11.8583333 0.260178 11.8611111 0.257333 11.8638889 0.257333 11.8666667 0.255911 11.8694444 0.255556 11.8722222 0.254844 11.8750000 0.254489 11.8777778 0.253067 11.8805556 0.250578 11.8833333 0.250933 11.8861111 0.250933 11.8888889 0.251644 11.8916667 0.251289 11.8944444 0.249156 11.8972222 0.247022 11.9000000 0.246311 11.9027778 0.245956 11.9055556 0.246311 11.9083333 0.245600 11.9111111 0.244178 11.9138889 0.242044 11.9166667 0.241333 11.9194444 0.242044 11.9222222 0.240267 11.9250000 0.238844 11.9277778 0.237067 11.9305556 0.236000 11.9333333 0.236356 11.9361111 0.236000 11.9388889 0.236356 11.9416667 0.234933 11.9444444 0.233156 11.9472222 0.231022 11.9500000 0.228889 11.9527778 0.231378 11.9555556 0.231733 11.9583333 0.230311 11.9611111 0.229956 11.9638889 0.228889 11.9666667 0.228533 11.9694444 0.230311 11.9722222 0.232089 11.9750000 0.231378 11.9777778 0.230667 11.9805556 0.230667 11.9833333 0.231378 11.9861111 0.233511 11.9888889 0.235644 11.9916667 0.236711 11.9944444 0.238133 11.9972222 0.238844 12.0000000 0.239911 12.0027778 0.242400 12.0055556 0.245244 12.0083333 0.248089 12.0111111 0.249867 12.0138889 0.250578 12.0166667 0.253422 12.0194444 0.256622 12.0222222 0.260533 12.0250000 0.262667 12.0277778 0.263022 12.0305556 0.264089 12.0333333 0.266222 12.0361111 0.269422 12.0388889 0.271911 12.0416667 0.272622 12.0444444 0.274044 12.0472222 0.274400 12.0500000 0.275467 12.0527778 0.277956 12.0555556 0.279378 12.0613333 0.300000 12.3470000 0.300000 12.3500000 0.285778 12.3527778 0.286489 12.3555556 0.288267 12.3583333 0.287911 12.3611111 0.286133 12.3638889 0.286133 12.3666667 0.286133 12.3694444 0.286844 12.3722222 0.287911 12.3750000 0.287911 12.3777778 0.285422 12.3805556 0.286133 12.3833333 0.286844 12.3861111 0.287556 12.3888889 0.288622 12.3916667 0.287911 12.3944444 0.287200 12.3972222 0.285067 12.4000000 0.285778 12.4027778 0.287556 12.4055556 0.288978 12.4083333 0.288978 12.4111111 0.286844 12.4138889 0.285778 12.4166667 0.286133 12.4194444 0.287911 12.4222222 0.287911 12.4250000 0.288978 12.4277778 0.288267 12.4305556 0.287200 12.4333333 0.287556 12.4361111 0.289333 12.4388889 0.290400 12.4416667 0.290756 12.4444444 0.290756 12.4472222 0.290400 12.4500000 0.291467 12.4527778 0.292178 12.4555556 0.294311 12.4583333 0.293600 12.4611111 0.294667 12.4638889 0.296089 12.4666667 0.297511 12.4694444 0.299289 12.4722222 0.301067 12.4750000 0.301067 12.4777778 0.299644 12.4805556 0.297156 12.4833333 0.297156 12.4861111 0.297156 12.4888889 0.297867 12.4916667 0.297511 12.4944444 0.295022 12.4972222 0.291822 12.5000000 0.290756 12.5027778 0.289689 12.5055556 0.290044 12.5083333 0.288978 12.5111111 0.287200 12.5138889 0.285422 12.5166667 0.287200 12.5194444 0.287911 12.5222222 0.288622 12.5250000 0.287911 12.5277778 0.287911 12.5305556 0.286844 12.5333333 0.286489 12.5361111 0.287911 12.5388889 0.288267 12.5416667 0.289333 12.5444444 0.286844 12.5472222 0.287556 12.5500000 0.286133 12.5527778 0.287200 12.5555556 0.287911 12.5583333 0.287911 12.5611111 0.287911 12.5638889 0.286844 12.5666667 0.287556 12.5694444 0.287911 12.5722222 0.287556 12.5750000 0.287556 12.5777778 0.291822 12.5805556 0.299289 12.5833333 0.308889 12.5861111 0.322400 12.5888889 0.338756 12.5916667 0.356533 12.5944444 0.376800 12.5972222 0.396000 12.6000000 0.408800 12.6027778 0.406667 12.6055556 0.388178 12.6083333 0.361867 12.6111111 0.333778 12.6138889 0.307822 12.6166667 0.292178 12.6194444 0.287556 12.6222222 0.288267 12.6250000 0.286489 12.6277778 0.285422 12.6305556 0.284711 12.6333333 0.286133 12.6361111 0.286489 12.6388889 0.286489 12.6416667 0.285778 12.6444444 0.284711 12.6472222 0.282578 12.6500000 0.284000 12.6527778 0.284000 12.6555556 0.285422 12.6583333 0.284711 12.6611111 0.284000 12.6638889 0.282933 12.6666667 0.282222 12.6694444 0.284000 12.6722222 0.285422 12.6750000 0.285422 12.6777778 0.285422 12.6805556 0.284356 12.6833333 0.283289 12.6861111 0.283289 12.6888889 0.285778 12.6916667 0.286133 12.6944444 0.285778 12.6972222 0.285422 12.7000000 0.285422 12.7027778 0.286133 12.7055556 0.286844 12.7083333 0.287200 12.7111111 0.286133 12.7138889 0.285422 12.7166667 0.286133 12.7194444 0.287200 12.7222222 0.289689 12.7250000 0.289689 12.7277778 0.290044 12.7305556 0.288978 12.7333333 0.290756 12.7361111 0.292178 12.7388889 0.293244 12.7416667 0.293244 12.7444444 0.292533 12.7472222 0.292889 12.7500000 0.294311 12.7527778 0.295378 12.7555556 0.297867 12.7583333 0.297867 12.7611111 0.296089 12.7638889 0.297156 12.7666667 0.297867 12.7694444 0.300000 12.7722222 0.301067 12.7750000 0.302133 12.7777778 0.301778 12.7805556 0.302133 12.7833333 0.303556 12.7861111 0.305333 12.7888889 0.306400 12.7916667 0.307111 12.7944444 0.306400 12.7972222 0.306400 12.8000000 0.307822 12.8027778 0.309600 12.8055556 0.311378 12.8083333 0.312089 12.8111111 0.311733 12.8138889 0.311733 12.8166667 0.313156 12.8194444 0.313867 12.8222222 0.316000 12.8250000 0.316711 12.8277778 0.315289 12.8305556 0.313867 12.8333333 0.313867 12.8361111 0.314578 12.8388889 0.315289 12.8416667 0.312444 12.8444444 0.308889 12.8472222 0.308889 12.8500000 0.306044 12.8527778 0.306400 12.8555556 0.307822 12.8583333 0.306756 12.8611111 0.304622 12.8638889 0.302133 12.8666667 0.300356 12.8694444 0.300000 12.8722222 0.298578 12.8750000 0.298578 12.8777778 0.297156 12.8805556 0.294311 12.8833333 0.292533 12.8861111 0.292889 12.8888889 0.292533 12.8916667 0.293244 12.8944444 0.291467 12.8972222 0.288978 12.9030000 0.300000 12.9053333 0.300000 12.9083333 0.290400 12.9111111 0.289689 12.9138889 0.288622 12.9166667 0.288622 12.9194444 0.289689 12.9222222 0.291111 12.9250000 0.290756 12.9277778 0.290400 12.9305556 0.289689 12.9333333 0.290756 12.9361111 0.289333 12.9388889 0.291467 12.9416667 0.291822 12.9444444 0.290756 12.9472222 0.290044 12.9500000 0.289333 12.9527778 0.290400 12.9555556 0.292533 12.9583333 0.292178 12.9611111 0.290400 12.9638889 0.289333 12.9666667 0.289689 12.9694444 0.291111 12.9722222 0.291467 12.9750000 0.292178 12.9777778 0.291467 12.9805556 0.290044 12.9833333 0.288622 12.9861111 0.291467 12.9888889 0.293244 12.9916667 0.293244 12.9944444 0.292533 12.9972222 0.292178 13.0000000 0.292889 13.0027778 0.295022 13.0055556 0.296444 13.0083333 0.297156 13.0111111 0.295733 13.0138889 0.296800 13.0166667 0.298222 13.0194444 0.301067 13.0222222 0.303556 13.0250000 0.304622 13.0277778 0.302844 13.0305556 0.302133 13.0333333 0.301422 13.0361111 0.302133 13.0388889 0.302133 13.0416667 0.301778 13.0444444 0.299289 13.0472222 0.296800 13.0500000 0.297511 13.0527778 0.297156 13.0555556 0.297156 13.0583333 0.294667 13.0611111 0.292533 13.0638889 0.289333 13.0666667 0.291467 13.0694444 0.294311 13.0722222 0.299289 13.0750000 0.301067 13.0777778 0.302489 13.0805556 0.304622 13.0833333 0.308178 13.0861111 0.314222 13.0888889 0.320267 13.0916667 0.326667 13.0944444 0.331289 13.0972222 0.335911 13.1000000 0.340178 13.1027778 0.345867 13.1055556 0.352267 13.1083333 0.356889 13.1111111 0.360089 13.1138889 0.365067 13.1166667 0.372178 13.1194444 0.378933 13.1222222 0.383911 13.1250000 0.388533 13.1277778 0.394578 13.1305556 0.401689 13.1333333 0.409156 13.1361111 0.412000 13.1388889 0.411289 13.1416667 0.409511 13.1444444 0.410222 13.1472222 0.414133 13.1500000 0.418756 13.1527778 0.421244 13.1555556 0.425156 13.1583333 0.428000 13.1611111 0.429067 13.1638889 0.429067 13.1666667 0.425511 13.1694444 0.411644 13.1722222 0.388533 13.1750000 0.363644 13.1777778 0.341956 13.1805556 0.323467 13.1833333 0.307467 13.1861111 0.296800 13.1888889 0.289689 13.1916667 0.284711 13.1944444 0.278667 13.1972222 0.273333 13.2000000 0.270844 13.2027778 0.269778 13.2055556 0.268356 13.2083333 0.267289 13.2111111 0.265156 13.2138889 0.263022 13.2166667 0.263733 13.2194444 0.263022 13.2222222 0.264089 13.2250000 0.261956 13.2277778 0.259822 13.2305556 0.258400 13.2333333 0.259467 13.2361111 0.260533 13.2388889 0.261244 13.2416667 0.259822 13.2444444 0.258044 13.2472222 0.256622 13.2500000 0.256622 13.2527778 0.257689 13.2555556 0.258400 13.2583333 0.257689 13.2611111 0.255556 13.2638889 0.254489 13.2666667 0.254489 13.2694444 0.254133 13.2722222 0.254844 13.2750000 0.252711 13.2777778 0.251644 13.2805556 0.249156 13.2833333 0.249867 13.2861111 0.249867 13.2888889 0.251289 13.2916667 0.250222 13.2944444 0.248800 13.2972222 0.245956 13.3000000 0.245600 13.3027778 0.245244 13.3055556 0.246311 13.3083333 0.246311 13.3111111 0.244533 13.3138889 0.243467 13.3166667 0.243111 13.3194444 0.243111 13.3222222 0.243467 13.3250000 0.243467 13.3277778 0.242044 13.3305556 0.240622 13.3333333 0.241689 13.3361111 0.242400 13.3388889 0.243467 13.3416667 0.243822 13.3444444 0.243111 13.3472222 0.242400 13.3500000 0.243822 13.3527778 0.246667 13.3555556 0.248089 13.3583333 0.249511 13.3611111 0.248800 13.3638889 0.248800 13.3666667 0.251644 13.3694444 0.254489 13.3722222 0.258044 13.3750000 0.260533 13.3777778 0.260178 13.3805556 0.260889 13.3833333 0.263022 13.3861111 0.265511 13.3888889 0.269422 13.3916667 0.271556 13.3944444 0.272622 13.3972222 0.274044 13.3997778 0.300000 13.4000000 0.276533 13.4027778 0.278667 13.4055556 0.281156 13.4083333 0.282222 13.4111111 0.282222 13.4138889 0.282578 13.4166667 0.283289 13.4194444 0.285067 13.4222222 0.286844 13.4250000 0.286133 13.4277778 0.285067 13.4305556 0.284356 13.4333333 0.285067 13.4361111 0.285778 13.4388889 0.287556 13.4416667 0.286844 13.4444444 0.285422 13.4472222 0.285422 13.4500000 0.286489 13.4527778 0.287556 13.4555556 0.288622 13.4583333 0.288622 13.4611111 0.287556 13.4613333 0.300000 13.4638889 0.286489 13.4666667 0.287911 13.4694444 0.288622 13.4722222 0.289333 13.4750000 0.288622 13.4777778 0.287556 13.4805556 0.287556 13.4833333 0.288267 13.4861111 0.288622 13.4888889 0.288978 13.4916667 0.289333 13.4944444 0.288267 13.4972222 0.286844 13.5000000 0.288267 13.5027778 0.288622 13.5055556 0.289333 13.5083333 0.290400 13.5111111 0.288622 13.5138889 0.289689 13.5166667 0.290756 13.5194444 0.291111 13.5222222 0.291822 13.5250000 0.291822 13.5277778 0.290400 13.5305556 0.291111 13.5333333 0.290756 13.5361111 0.292178 13.5388889 0.292178 13.5416667 0.293244 13.5444444 0.292178 13.5472222 0.292178 13.5500000 0.292533 13.5527778 0.292889 13.5555556 0.293956 13.5583333 0.294667 13.5611111 0.293956 13.5638889 0.293244 13.5666667 0.294311 13.5694444 0.295378 13.5722222 0.295733 13.5750000 0.294667 13.5777778 0.296089 13.5805556 0.297867 13.5833333 0.299289 13.5861111 0.301422 13.5888889 0.303911 13.5916667 0.306756 13.5944444 0.309600 13.5972222 0.313156 13.6000000 0.317067 13.6027778 0.322400 13.6055556 0.326311 13.6083333 0.331289 13.6111111 0.336622 13.6138889 0.341244 13.6166667 0.346222 13.6194444 0.352267 13.6222222 0.358667 13.6250000 0.363289 13.6277778 0.366133 13.6305556 0.368978 13.6333333 0.373244 13.6361111 0.380000 13.6388889 0.388178 13.6416667 0.391733 13.6444444 0.396356 13.6472222 0.402400 13.6500000 0.408800 13.6527778 0.415200 13.6555556 0.416978 13.6583333 0.415200 13.6611111 0.409511 13.6638889 0.403111 13.6666667 0.398844 13.6694444 0.395644 13.6722222 0.393156 13.6750000 0.391733 13.6777778 0.390311 13.6805556 0.387111 13.6833333 0.384622 13.6861111 0.382489 13.6888889 0.382489 13.6916667 0.380000 13.6944444 0.377867 13.6972222 0.376800 13.7000000 0.377156 13.7027778 0.375733 13.7055556 0.373244 13.7083333 0.366133 13.7111111 0.356533 13.7138889 0.344800 13.7166667 0.334133 13.7194444 0.321689 13.7222222 0.308533 13.7250000 0.297511 13.7277778 0.287556 13.7305556 0.278311 13.7333333 0.275111 13.7361111 0.272267 13.7388889 0.272267 13.7416667 0.270133 13.7444444 0.268000 13.7472222 0.266222 13.7500000 0.264444 13.7527778 0.263022 13.7555556 0.263022 13.7583333 0.261956 13.7611111 0.260178 13.7638889 0.258044 13.7666667 0.257689 13.7694444 0.258400 13.7722222 0.258400 13.7750000 0.257333 13.7777778 0.255200 13.7805556 0.252711 13.7833333 0.251644 13.7861111 0.252711 13.7888889 0.252356 13.7916667 0.252711 13.7944444 0.250933 13.7972222 0.248089 13.8000000 0.248089 13.8027778 0.247378 13.8055556 0.247733 13.8083333 0.247378 13.8111111 0.245600 13.8138889 0.244533 13.8166667 0.242756 13.8194444 0.242400 13.8222222 0.242400 13.8250000 0.242400 13.8277778 0.240267 13.8305556 0.238133 13.8333333 0.238489 13.8361111 0.238489 13.8388889 0.238489 13.8416667 0.238844 13.8444444 0.237422 13.8472222 0.236356 13.8500000 0.236000 13.8527778 0.236000 13.8555556 0.237067 13.8583333 0.237067 13.8611111 0.236356 13.8638889 0.235644 13.8666667 0.235644 13.8694444 0.236000 13.8722222 0.237422 13.8750000 0.239556 13.8777778 0.240267 13.8805556 0.240267 13.8833333 0.241689 13.8861111 0.244178 13.8888889 0.245956 13.8916667 0.248800 13.8944444 0.249511 13.8972222 0.250933 13.9000000 0.254844 13.9027778 0.258044 13.9055556 0.260889 13.9083333 0.264444 13.9111111 0.265511 13.9138889 0.266933 13.9166667 0.268356 13.9194444 0.272978 13.9222222 0.276533 13.9250000 0.278311 13.9277778 0.280444 13.9305556 0.281156 13.9333333 0.283289 13.9361111 0.285067 13.9388889 0.288267 13.9416667 0.289333 13.9444444 0.289689 13.9472222 0.289333 13.9500000 0.290756 13.9557778 0.300000 14.0997778 0.300000 14.1027778 0.297156 14.1055556 0.298578 14.1083333 0.298578 14.1111111 0.297867 14.1138889 0.297156 14.1166667 0.296444 14.1194444 0.297867 14.1222222 0.298933 14.1250000 0.298933 14.1277778 0.296800 14.1305556 0.295733 14.1333333 0.296089 14.1361111 0.297511 14.1388889 0.297511 14.1416667 0.297867 14.1444444 0.296089 14.1472222 0.295022 14.1500000 0.295378 14.1527778 0.297156 14.1555556 0.298933 14.1583333 0.298578 14.1611111 0.297867 14.1638889 0.297156 14.1666667 0.296444 14.1694444 0.297511 14.1722222 0.299644 14.1750000 0.299289 14.1777778 0.298222 14.1805556 0.296800 14.1833333 0.297156 14.1861111 0.298578 14.1888889 0.300000 14.1916667 0.299644 14.1944444 0.298578 14.1972222 0.298222 14.2000000 0.298578 14.2027778 0.300356 14.2055556 0.301067 14.2083333 0.302489 14.2111111 0.301422 14.2138889 0.301778 14.2166667 0.303200 14.2194444 0.304622 14.2222222 0.306756 14.2250000 0.307467 14.2277778 0.307467 14.2305556 0.309956 14.2333333 0.311733 14.2361111 0.312444 14.2388889 0.312800 14.2416667 0.311733 14.2444444 0.308889 14.2472222 0.307822 14.2500000 0.307467 14.2527778 0.306400 14.2555556 0.305333 14.2583333 0.304267 14.2611111 0.301422 14.2638889 0.300000 14.2666667 0.299644 14.2694444 0.300000 14.2722222 0.300000 14.2750000 0.299644 14.2777778 0.298578 14.2805556 0.297867 14.2833333 0.297867 14.2861111 0.298578 14.2888889 0.301067 14.2916667 0.299644 14.2944444 0.299644 14.2972222 0.298578 14.3000000 0.298933 14.3027778 0.299644 14.3055556 0.301067 14.3083333 0.300356 14.3111111 0.299644 14.3138889 0.297867 14.3166667 0.298222 14.3194444 0.299289 14.3222222 0.298222 14.3250000 0.297511 14.3277778 0.296800 14.3305556 0.300711 14.3333333 0.309244 14.3361111 0.319556 14.3388889 0.333422 14.3416667 0.349067 14.3444444 0.365778 14.3472222 0.384622 14.3500000 0.403111 14.3527778 0.419467 14.3555556 0.426933 14.3583333 0.415200 14.3611111 0.387111 14.3638889 0.358311 14.3666667 0.333422 14.3694444 0.317422 14.3722222 0.310311 14.3750000 0.306400 14.3777778 0.301067 14.3805556 0.296089 14.3833333 0.294311 14.3861111 0.295733 14.3888889 0.298578 14.3916667 0.298578 14.3944444 0.296444 14.3972222 0.295378 14.4000000 0.293956 14.4027778 0.293956 14.4055556 0.293600 14.4083333 0.293600 14.4111111 0.292533 14.4138889 0.291111 14.4166667 0.291822 14.4194444 0.292889 14.4222222 0.293956 14.4250000 0.292889 14.4277778 0.292533 14.4305556 0.292889 14.4333333 0.292533 14.4361111 0.292178 14.4388889 0.294311 14.4416667 0.293956 14.4444444 0.293244 14.4472222 0.291822 14.4500000 0.292178 14.4527778 0.293244 14.4555556 0.294667 14.4583333 0.295733 14.4611111 0.294667 14.4638889 0.292889 14.4666667 0.294667 14.4694444 0.294311 14.4722222 0.295733 14.4750000 0.297156 14.4777778 0.295378 14.4805556 0.295733 14.4833333 0.296444 14.4861111 0.297156 14.4888889 0.298933 14.4916667 0.298933 14.4944444 0.297867 14.4972222 0.299289 14.5000000 0.300711 14.5027778 0.300711 14.5055556 0.304267 14.5083333 0.304267 14.5111111 0.303200 14.5138889 0.303556 14.5166667 0.304622 14.5194444 0.306756 14.5222222 0.309244 14.5250000 0.309244 14.5277778 0.309600 14.5305556 0.309956 14.5333333 0.312089 14.5361111 0.313511 14.5388889 0.315644 14.5416667 0.317778 14.5444444 0.316711 14.5472222 0.317422 14.5500000 0.318489 14.5527778 0.318844 14.5555556 0.320267 14.5583333 0.321333 14.5611111 0.321333 14.5638889 0.321333 14.5666667 0.323111 14.5694444 0.324178 14.5722222 0.325600 14.5750000 0.325244 14.5777778 0.324178 14.5805556 0.324178 14.5833333 0.324889 14.5861111 0.326311 14.5888889 0.325956 14.5916667 0.324533 14.5944444 0.321689 14.5972222 0.319911 14.6000000 0.319200 14.6027778 0.318489 14.6055556 0.317067 14.6083333 0.314933 14.6111111 0.312444 14.6138889 0.309600 14.6166667 0.308889 14.6194444 0.308178 14.6222222 0.307467 14.6250000 0.306400 14.6277778 0.303556 14.6305556 0.300711 14.6333333 0.300356 14.6361111 0.300000 14.6388889 0.299644 14.6416667 0.298933 14.6444444 0.297156 14.6472222 0.295733 14.6500000 0.295022 14.6557778 0.300000 14.7053333 0.300000 14.7083333 0.295378 14.7111111 0.294667 14.7138889 0.293600 14.7166667 0.293600 14.7194444 0.295378 14.7222222 0.294311 14.7250000 0.295022 14.7277778 0.293244 14.7305556 0.292533 14.7333333 0.292533 14.7361111 0.294667 14.7388889 0.295378 14.7416667 0.295378 14.7444444 0.294311 14.7472222 0.293244 14.7500000 0.294311 14.7527778 0.294667 14.7555556 0.295378 14.7583333 0.295022 14.7611111 0.293600 14.7638889 0.293956 14.7666667 0.293600 14.7694444 0.294667 14.7722222 0.293600 14.7750000 0.293244 14.7777778 0.292533 14.7805556 0.292533 14.7833333 0.292533 14.7861111 0.293244 14.7888889 0.294311 14.7916667 0.295022 14.7944444 0.295022 14.7972222 0.295733 14.8000000 0.296444 14.8027778 0.296800 14.8055556 0.298578 14.8083333 0.300356 14.8111111 0.300356 14.8138889 0.300356 14.8166667 0.301067 14.8194444 0.303556 14.8222222 0.304622 14.8250000 0.304622 14.8277778 0.303200 14.8305556 0.302133 14.8333333 0.302844 14.8361111 0.303200 14.8388889 0.302489 14.8416667 0.301422 14.8444444 0.298578 14.8472222 0.297156 14.8500000 0.295733 14.8527778 0.294667 14.8555556 0.294667 14.8583333 0.293600 14.8611111 0.292533 14.8638889 0.292533 14.8666667 0.293600 14.8694444 0.296800 14.8722222 0.299644 14.8750000 0.302489 14.8777778 0.304267 14.8805556 0.308533 14.8833333 0.313867 14.8861111 0.319911 14.8888889 0.326311 14.8916667 0.329867 14.8944444 0.332711 14.8972222 0.336978 14.9000000 0.341956 14.9027778 0.348000 14.9055556 0.353333 14.9083333 0.357244 14.9111111 0.360800 14.9138889 0.365422 14.9166667 0.372178 14.9194444 0.380711 14.9222222 0.386044 14.9250000 0.390667 14.9277778 0.396356 14.9305556 0.401689 14.9333333 0.409511 14.9361111 0.413067 14.9388889 0.417689 14.9416667 0.418400 14.9444444 0.420533 14.9472222 0.423022 14.9500000 0.427289 14.9527778 0.432978 14.9555556 0.437600 14.9583333 0.441867 14.9611111 0.446489 14.9638889 0.447911 14.9666667 0.440089 14.9694444 0.421244 14.9722222 0.395289 14.9750000 0.371111 14.9777778 0.349067 14.9805556 0.326667 14.9833333 0.310667 14.9861111 0.299289 14.9888889 0.291111 14.9916667 0.285778 14.9944444 0.280089 14.9972222 0.276889 15.0000000 0.275467 15.0027778 0.274756 15.0055556 0.274756 15.0083333 0.272978 15.0111111 0.270844 15.0138889 0.268711 15.0166667 0.268356 15.0194444 0.268000 15.0222222 0.267644 15.0250000 0.266933 15.0277778 0.264800 15.0305556 0.264089 15.0333333 0.264089 15.0361111 0.264800 15.0388889 0.265156 15.0416667 0.264800 15.0444444 0.262311 15.0472222 0.261244 15.0500000 0.259822 15.0527778 0.262311 15.0555556 0.262667 15.0583333 0.262311 15.0611111 0.260178 15.0638889 0.258756 15.0666667 0.258044 15.0694444 0.258400 15.0722222 0.259467 15.0750000 0.258044 15.0777778 0.255556 15.0805556 0.254133 15.0833333 0.254133 15.0861111 0.254844 15.0888889 0.255556 15.0916667 0.254844 15.0944444 0.253067 15.0972222 0.251644 15.1000000 0.250222 15.1027778 0.251644 15.1055556 0.252356 15.1083333 0.252711 15.1111111 0.250933 15.1138889 0.248444 15.1166667 0.248444 15.1194444 0.249511 15.1222222 0.250578 15.1250000 0.250933 15.1277778 0.250578 15.1305556 0.249156 15.1331111 0.300000 15.1333333 0.249511 15.1361111 0.250578 15.1388889 0.250933 15.1416667 0.250933 15.1444444 0.251289 15.1472222 0.250578 15.1500000 0.252000 15.1527778 0.253422 15.1555556 0.254844 15.1583333 0.255556 15.1611111 0.254844 15.1638889 0.255200 15.1666667 0.257333 15.1694444 0.259111 15.1722222 0.260889 15.1750000 0.262667 15.1777778 0.262667 15.1805556 0.262667 15.1833333 0.265511 15.1861111 0.268000 15.1888889 0.270844 15.1916667 0.272267 15.1944444 0.272267 15.1972222 0.272978 15.2000000 0.273689 15.2027778 0.276533 15.2055556 0.278667 15.2083333 0.280444 15.2111111 0.281156 15.2138889 0.281156 15.2166667 0.282222 15.2194444 0.282933 15.2222222 0.285422 15.2250000 0.287200 15.2277778 0.286844 15.2305556 0.285778 15.2333333 0.286133 15.2361111 0.286844 15.2388889 0.287911 15.2416667 0.287911 15.2444444 0.285778 15.2472222 0.286844 15.2500000 0.285778 15.2527778 0.287556 15.2555556 0.287911 15.2583333 0.288267 15.2611111 0.286844 15.2613333 0.300000 15.2638889 0.285067 15.2666667 0.286489 15.2694444 0.287911 15.2722222 0.288622 15.2750000 0.288622 15.2777778 0.287200 15.2805556 0.287200 15.2833333 0.287911 15.2861111 0.288622 15.2888889 0.288622 15.2916667 0.290044 15.2944444 0.288622 15.2972222 0.287911 15.3000000 0.287911 15.3027778 0.288622 15.3055556 0.289689 15.3083333 0.290400 15.3111111 0.288978 15.3138889 0.288978 15.3166667 0.290044 15.3194444 0.292178 15.3222222 0.294667 15.3250000 0.297156 15.3277778 0.297867 15.3305556 0.299644 15.3333333 0.301422 15.3361111 0.304267 15.3388889 0.311022 15.3416667 0.316711 15.3444444 0.320978 15.3472222 0.325600 15.3500000 0.331289 15.3527778 0.337333 15.3555556 0.343733 15.3583333 0.350133 15.3611111 0.355822 15.3638889 0.362933 15.3666667 0.367556 15.3694444 0.372889 15.3722222 0.379644 15.3750000 0.384267 15.3777778 0.388178 15.3805556 0.390667 15.3833333 0.398133 15.3861111 0.405956 15.3888889 0.409867 15.3916667 0.409156 15.3944444 0.404178 15.3972222 0.400267 15.4000000 0.396711 15.4027778 0.394578 15.4055556 0.392089 15.4083333 0.389244 15.4111111 0.387111 15.4138889 0.384622 15.4166667 0.381422 15.4194444 0.380356 15.4222222 0.379289 15.4250000 0.377511 15.4277778 0.375733 15.4305556 0.374667 15.4333333 0.374311 15.4361111 0.370044 15.4388889 0.363644 15.4416667 0.355822 15.4444444 0.344444 15.4472222 0.330933 15.4500000 0.317778 15.4527778 0.307822 15.4555556 0.299644 15.4583333 0.292889 15.4611111 0.287556 15.4638889 0.283289 15.4666667 0.280800 15.4694444 0.279733 15.4722222 0.278311 15.4750000 0.275467 15.4777778 0.272267 15.4805556 0.268000 15.4833333 0.265867 15.4861111 0.265511 15.4888889 0.264444 15.4916667 0.262667 15.4944444 0.261244 15.4972222 0.258044 15.5000000 0.257689 15.5027778 0.257689 15.5055556 0.257333 15.5083333 0.256978 15.5111111 0.255200 15.5138889 0.254489 15.5166667 0.253067 15.5194444 0.253422 15.5222222 0.254133 15.5250000 0.253422 15.5277778 0.251289 15.5305556 0.249156 15.5333333 0.248800 15.5361111 0.249511 15.5388889 0.249156 15.5416667 0.248444 15.5444444 0.247022 15.5472222 0.244889 15.5500000 0.244533 15.5527778 0.244178 15.5555556 0.245244 15.5583333 0.245244 15.5611111 0.244533 15.5638889 0.243467 15.5666667 0.242044 15.5694444 0.243111 15.5722222 0.243822 15.5750000 0.242400 15.5777778 0.240622 15.5805556 0.239911 15.5833333 0.239200 15.5861111 0.240622 15.5888889 0.241333 15.5916667 0.240978 15.5944444 0.240267 15.5972222 0.240267 15.6000000 0.240622 15.6027778 0.242400 15.6055556 0.244533 15.6083333 0.244533 15.6111111 0.244178 15.6138889 0.244178 15.6166667 0.245956 15.6194444 0.249156 15.6222222 0.251644 15.6250000 0.253067 15.6277778 0.253422 15.6305556 0.254844 15.6333333 0.256267 15.6361111 0.258044 15.6388889 0.260533 15.6416667 0.261956 15.6444444 0.262311 15.6472222 0.264444 15.6500000 0.267289 15.6527778 0.269778 15.6555556 0.272978 15.6583333 0.274756 15.6611111 0.275111 15.6638889 0.275822 15.6666667 0.277244 15.6694444 0.279022 15.6722222 0.281156 15.6750000 0.281511 15.6777778 0.281156 15.6805556 0.280444 15.6833333 0.280800 15.6891111 0.300000 16.0525556 0.300000 16.0555556 0.293956 16.0583333 0.294311 16.0611111 0.292889 16.0638889 0.291822 16.0666667 0.292178 16.0694444 0.293244 16.0722222 0.294667 16.0750000 0.292889 16.0777778 0.292178 16.0805556 0.290756 16.0833333 0.291822 16.0861111 0.293244 16.0888889 0.294311 16.0916667 0.293600 16.0944444 0.291822 16.0972222 0.291822 16.1000000 0.291111 16.1027778 0.292178 16.1055556 0.291111 16.1083333 0.291822 16.1111111 0.291822 16.1138889 0.291467 16.1166667 0.291111 16.1194444 0.292178 16.1222222 0.292889 16.1250000 0.292533 16.1277778 0.291822 16.1305556 0.291111 16.1333333 0.291467 16.1361111 0.292533 16.1388889 0.293956 16.1416667 0.294311 16.1444444 0.294667 16.1472222 0.293956 16.1500000 0.294311 16.1527778 0.295022 16.1555556 0.295733 16.1583333 0.297156 16.1611111 0.298222 16.1638889 0.297867 16.1666667 0.299289 16.1694444 0.301067 16.1722222 0.302489 16.1750000 0.302489 16.1777778 0.301067 16.1805556 0.300711 16.1833333 0.300711 16.1861111 0.301067 16.1888889 0.300711 16.1916667 0.300000 16.1944444 0.298933 16.1972222 0.296800 16.2000000 0.296444 16.2027778 0.296089 16.2055556 0.296089 16.2083333 0.294667 16.2111111 0.293600 16.2138889 0.292533 16.2166667 0.291467 16.2194444 0.292533 16.2222222 0.291822 16.2250000 0.291467 16.2277778 0.290044 16.2305556 0.290756 16.2333333 0.290044 16.2361111 0.291467 16.2388889 0.292533 16.2416667 0.292178 16.2444444 0.290756 16.2472222 0.290044 16.2500000 0.290400 16.2527778 0.291111 16.2555556 0.291822 16.2583333 0.290756 16.2611111 0.291467 16.2638889 0.290044 16.2666667 0.290400 16.2694444 0.291822 16.2722222 0.291111 16.2750000 0.290044 16.2777778 0.290044 16.2805556 0.293600 16.2833333 0.301778 16.2861111 0.311733 16.2888889 0.324889 16.2916667 0.340178 16.2944444 0.359733 16.2972222 0.378933 16.3000000 0.394933 16.3027778 0.409511 16.3055556 0.419111 16.3083333 0.415911 16.3111111 0.397778 16.3138889 0.375022 16.3166667 0.349778 16.3194444 0.324178 16.3222222 0.305333 16.3250000 0.293956 16.3277778 0.289333 16.3305556 0.289333 16.3333333 0.287911 16.3361111 0.287200 16.3388889 0.286844 16.3416667 0.287911 16.3444444 0.287200 16.3472222 0.287200 16.3500000 0.286133 16.3527778 0.286844 16.3555556 0.286489 16.3583333 0.285778 16.3611111 0.284356 16.3638889 0.281867 16.3666667 0.282222 16.3694444 0.282578 16.3722222 0.284000 16.3750000 0.283289 16.3777778 0.282933 16.3805556 0.281156 16.3833333 0.281511 16.3861111 0.282578 16.3888889 0.282933 16.3916667 0.284000 16.3944444 0.282933 16.3972222 0.283289 16.4000000 0.284000 16.4027778 0.284356 16.4055556 0.285067 16.4083333 0.284000 16.4111111 0.283644 16.4138889 0.282578 16.4166667 0.283644 16.4194444 0.282933 16.4222222 0.285067 16.4250000 0.284711 16.4277778 0.284356 16.4305556 0.283289 16.4333333 0.283644 16.4361111 0.285067 16.4388889 0.285778 16.4416667 0.286133 16.4444444 0.285778 16.4472222 0.284356 16.4500000 0.285422 16.4527778 0.287200 16.4555556 0.287911 16.4583333 0.287911 16.4611111 0.286844 16.4638889 0.286489 16.4666667 0.286844 16.4694444 0.288978 16.4722222 0.290044 16.4750000 0.290400 16.4777778 0.289689 16.4805556 0.290400 16.4833333 0.291467 16.4861111 0.293956 16.4888889 0.294311 16.4916667 0.294667 16.4944444 0.294311 16.4972222 0.294311 16.5000000 0.295378 16.5027778 0.297511 16.5055556 0.298222 16.5083333 0.299289 16.5111111 0.299289 16.5138889 0.299289 16.5166667 0.300000 16.5194444 0.301778 16.5222222 0.303200 16.5250000 0.303911 16.5277778 0.302489 16.5305556 0.303556 16.5333333 0.303200 16.5361111 0.305689 16.5388889 0.306756 16.5416667 0.306044 16.5444444 0.306400 16.5472222 0.305689 16.5500000 0.307111 16.5527778 0.307822 16.5555556 0.309600 16.5583333 0.309244 16.5611111 0.308533 16.5638889 0.308533 16.5666667 0.308533 16.5694444 0.309956 16.5722222 0.310667 16.5750000 0.309244 16.5777778 0.307467 16.5805556 0.306400 16.5833333 0.304978 16.5861111 0.304978 16.5888889 0.304267 16.5916667 0.303200 16.5944444 0.301422 16.5972222 0.298222 16.6000000 0.297511 16.6027778 0.297867 16.6085556 0.300000 16.6247778 0.300000 16.6277778 0.286844 16.6305556 0.285778 16.6333333 0.285422 16.6361111 0.286844 16.6388889 0.286844 16.6416667 0.286844 16.6444444 0.285422 16.6472222 0.284356 16.6500000 0.283644 16.6527778 0.283644 16.6555556 0.284000 16.6583333 0.284356 16.6611111 0.284356 16.6638889 0.283289 16.6666667 0.284000 16.6694444 0.285067 16.6722222 0.285422 16.6750000 0.284711 16.6777778 0.283289 16.6805556 0.282933 16.6833333 0.283289 16.6861111 0.284356 16.6888889 0.284711 16.6916667 0.285067 16.6944444 0.283644 16.6972222 0.283289 16.7000000 0.284000 16.7027778 0.284711 16.7055556 0.285422 16.7083333 0.284356 16.7111111 0.283289 16.7138889 0.282578 16.7166667 0.283644 16.7194444 0.285067 16.7222222 0.285067 16.7250000 0.285067 16.7277778 0.283644 16.7305556 0.282933 16.7333333 0.283644 16.7361111 0.285067 16.7388889 0.285422 16.7416667 0.284356 16.7444444 0.284000 16.7472222 0.283644 16.7500000 0.284356 16.7527778 0.284711 16.7555556 0.285778 16.7583333 0.285067 16.7611111 0.284000 16.7638889 0.283644 16.7666667 0.284356 16.7694444 0.285422 16.7722222 0.285067 16.7750000 0.285778 16.7777778 0.285778 16.7805556 0.286489 16.7833333 0.287556 16.7861111 0.288267 16.7888889 0.289333 16.7916667 0.289689 16.7944444 0.288978 16.7972222 0.291467 16.8000000 0.293956 16.8027778 0.296444 16.8055556 0.299289 16.8083333 0.298933 16.8111111 0.300356 16.8138889 0.302133 16.8166667 0.305689 16.8194444 0.308533 16.8222222 0.311733 16.8250000 0.313156 16.8277778 0.315289 16.8305556 0.318844 16.8333333 0.323822 16.8361111 0.330578 16.8388889 0.334844 16.8416667 0.338400 16.8444444 0.340889 16.8472222 0.344444 16.8500000 0.348000 16.8527778 0.354044 16.8555556 0.359378 16.8583333 0.364711 16.8611111 0.369333 16.8638889 0.373600 16.8666667 0.377156 16.8694444 0.382489 16.8722222 0.388533 16.8750000 0.393511 16.8777778 0.396000 16.8805556 0.396356 16.8833333 0.395644 16.8861111 0.393511 16.8888889 0.389244 16.8916667 0.384978 16.8944444 0.380000 16.8972222 0.375378 16.9000000 0.373244 16.9027778 0.371822 16.9055556 0.369689 16.9083333 0.366844 16.9111111 0.362222 16.9138889 0.359733 16.9166667 0.357600 16.9194444 0.356533 16.9222222 0.355467 16.9250000 0.351911 16.9277778 0.350489 16.9305556 0.349067 16.9333333 0.348711 16.9361111 0.345867 16.9388889 0.342667 16.9416667 0.335200 16.9444444 0.325600 16.9472222 0.312800 16.9500000 0.299644 16.9527778 0.288267 16.9555556 0.277600 16.9583333 0.269422 16.9611111 0.261956 16.9638889 0.257689 16.9666667 0.254844 16.9694444 0.254489 16.9722222 0.254133 16.9750000 0.253067 16.9777778 0.250222 16.9805556 0.247733 16.9833333 0.247022 16.9861111 0.247022 16.9888889 0.246667 16.9916667 0.245956 16.9944444 0.244178 16.9972222 0.242400 17.0000000 0.243111 17.0027778 0.243111 17.0055556 0.243111 17.0083333 0.241689 17.0111111 0.240978 17.0138889 0.239556 17.0166667 0.240267 17.0194444 0.240267 17.0222222 0.239556 17.0250000 0.239556 17.0277778 0.237778 17.0305556 0.235644 17.0333333 0.235644 17.0361111 0.236356 17.0388889 0.236000 17.0416667 0.234933 17.0444444 0.233511 17.0472222 0.232800 17.0500000 0.230667 17.0527778 0.231378 17.0555556 0.231733 17.0583333 0.230311 17.0611111 0.228889 17.0638889 0.228533 17.0666667 0.228178 17.0694444 0.228533 17.0722222 0.227822 17.0750000 0.227467 17.0777778 0.225333 17.0805556 0.224267 17.0833333 0.224267 17.0861111 0.224978 17.0888889 0.225333 17.0916667 0.223911 17.0944444 0.221778 17.0972222 0.222133 17.1000000 0.222489 17.1027778 0.223911 17.1055556 0.224267 17.1083333 0.224622 17.1111111 0.224622 17.1138889 0.224978 17.1166667 0.225333 17.1194444 0.226756 17.1222222 0.227822 17.1250000 0.228889 17.1277778 0.229956 17.1305556 0.232089 17.1333333 0.234578 17.1361111 0.237067 17.1388889 0.238489 17.1416667 0.239911 17.1444444 0.242044 17.1472222 0.243111 17.1500000 0.245244 17.1527778 0.248089 17.1555556 0.250578 17.1583333 0.252711 17.1611111 0.253778 17.1638889 0.255911 17.1666667 0.259111 17.1694444 0.261956 17.1722222 0.263378 17.1750000 0.263378 17.1775556 0.300000 17.1805556 0.263378 17.1807778 0.300000 17.1833333 0.264800 17.1861111 0.266578 17.1888889 0.267644 17.1916667 0.268000 17.1944444 0.267289 17.1972222 0.266222 17.2000000 0.266222 17.2027778 0.267289 17.2055556 0.267644 17.2083333 0.267644 17.2111111 0.266933 17.2138889 0.266933 17.2166667 0.266933 17.2194444 0.266578 17.2222222 0.267644 17.2250000 0.268356 17.2277778 0.268000 17.2305556 0.266933 17.2333333 0.266933 17.2361111 0.268356 17.2388889 0.267644 17.2416667 0.266222 17.2444444 0.264800 17.2472222 0.264089 17.2500000 0.264800 17.2527778 0.265867 17.2555556 0.265867 17.2583333 0.264089 17.2611111 0.262667 17.2638889 0.262311 17.2666667 0.262311 17.2694444 0.262667 17.2722222 0.263378 17.2750000 0.263378 17.2777778 0.264444 17.2805556 0.265156 17.2833333 0.267289 17.2861111 0.270133 17.2888889 0.272978 17.2916667 0.275111 17.2944444 0.275822 17.2972222 0.274400 17.3000000 0.274756 17.3027778 0.276533 17.3055556 0.277956 17.3083333 0.279022 17.3111111 0.279378 17.3138889 0.279733 17.3166667 0.281156 17.3194444 0.283289 17.3222222 0.282933 17.3250000 0.282222 17.3277778 0.280800 17.3305556 0.280444 17.3333333 0.281511 17.3361111 0.283644 17.3388889 0.285422 17.3416667 0.285422 17.3444444 0.285067 17.3472222 0.283644 17.3500000 0.282933 17.3527778 0.284000 17.3555556 0.285422 17.3583333 0.286844 17.3611111 0.287200 17.3638889 0.288978 17.3666667 0.289689 17.3694444 0.291111 17.3722222 0.291467 17.3750000 0.292889 17.3777778 0.293956 17.3805556 0.294311 17.3833333 0.297156 17.3861111 0.300711 17.3888889 0.304978 17.3916667 0.309244 17.3944444 0.313867 17.3972222 0.319911 17.4000000 0.325956 17.4027778 0.332356 17.4055556 0.339111 17.4083333 0.344444 17.4111111 0.349422 17.4138889 0.355111 17.4166667 0.362222 17.4194444 0.369333 17.4222222 0.377511 17.4250000 0.382489 17.4277778 0.388178 17.4305556 0.393511 17.4333333 0.398133 17.4361111 0.400622 17.4388889 0.399200 17.4416667 0.397778 17.4444444 0.392444 17.4472222 0.386756 17.4500000 0.382844 17.4527778 0.382133 17.4555556 0.382844 17.4583333 0.382489 17.4611111 0.379289 17.4638889 0.375733 17.4666667 0.373600 17.4694444 0.371467 17.4722222 0.368622 17.4750000 0.365778 17.4777778 0.364000 17.4805556 0.362578 17.4833333 0.364000 17.4861111 0.364000 17.4888889 0.360444 17.4916667 0.351911 17.4944444 0.338400 17.4972222 0.322400 17.5000000 0.306400 17.5027778 0.291111 17.5055556 0.278667 17.5083333 0.266933 17.5111111 0.256978 17.5138889 0.252000 17.5166667 0.249156 17.5194444 0.248800 17.5222222 0.248444 17.5250000 0.247378 17.5277778 0.244889 17.5305556 0.242400 17.5333333 0.240978 17.5361111 0.239911 17.5388889 0.239200 17.5416667 0.238133 17.5444444 0.234933 17.5472222 0.233156 17.5500000 0.235644 17.5527778 0.237067 17.5555556 0.236711 17.5583333 0.236000 17.5611111 0.234222 17.5638889 0.233511 17.5666667 0.233511 17.5694444 0.235289 17.5722222 0.234222 17.5750000 0.233867 17.5777778 0.232800 17.5805556 0.231022 17.5833333 0.231022 17.5861111 0.230667 17.5888889 0.229600 17.5916667 0.229956 17.5944444 0.228533 17.5972222 0.227111 17.6000000 0.226756 17.6027778 0.226044 17.6055556 0.225689 17.6083333 0.223556 17.6111111 0.221067 17.6138889 0.220711 17.6166667 0.221067 17.6194444 0.222133 17.6222222 0.222844 17.6250000 0.221778 17.6277778 0.219289 17.6305556 0.218222 17.6333333 0.219644 17.6361111 0.221067 17.6388889 0.220711 17.6416667 0.221422 17.6444444 0.220000 17.6472222 0.219644 17.6500000 0.221778 17.6527778 0.224267 17.6555556 0.225689 17.6583333 0.226756 17.6611111 0.227111 17.6638889 0.227822 17.6666667 0.228889 17.6694444 0.231378 17.6722222 0.233511 17.6750000 0.235644 17.6777778 0.238133 17.6805556 0.240267 17.6833333 0.243467 17.6861111 0.247733 17.6888889 0.250578 17.6916667 0.253067 17.6944444 0.254133 17.6972222 0.256622 17.7000000 0.259822 17.7027778 0.262667 17.7055556 0.265867 17.7083333 0.267644 17.7111111 0.268000 17.7138889 0.267644 17.7166667 0.269778 17.7194444 0.271200 17.7222222 0.272622 17.7250000 0.274044 17.7277778 0.274044 17.7335556 0.300000 17.9414444 0.300000 17.9444444 0.271556 17.9472222 0.272622 17.9500000 0.274756 17.9527778 0.275111 17.9555556 0.274044 17.9583333 0.273333 17.9611111 0.272267 17.9638889 0.271200 17.9666667 0.272622 17.9694444 0.273689 17.9722222 0.272622 17.9750000 0.273689 17.9777778 0.271556 17.9805556 0.270489 17.9833333 0.270489 17.9861111 0.271911 17.9888889 0.273689 17.9916667 0.274756 17.9944444 0.274400 17.9972222 0.273333 18.0000000 0.272267 18.0027778 0.272622 18.0055556 0.273333 18.0083333 0.273689 18.0111111 0.273333 18.0138889 0.272622 18.0166667 0.275111 18.0194444 0.277244 18.0222222 0.277956 18.0250000 0.276889 18.0277778 0.275822 18.0305556 0.276178 18.0333333 0.278667 18.0361111 0.281867 18.0388889 0.282933 18.0416667 0.283289 18.0444444 0.281867 18.0472222 0.282933 18.0500000 0.285067 18.0527778 0.287556 18.0555556 0.291111 18.0583333 0.292178 18.0611111 0.291111 18.0638889 0.290400 18.0666667 0.290756 18.0694444 0.291822 18.0722222 0.291822 18.0750000 0.291467 18.0777778 0.289333 18.0805556 0.288978 18.0833333 0.288622 18.0861111 0.287911 18.0888889 0.287911 18.0916667 0.286489 18.0944444 0.282222 18.0972222 0.279733 18.1000000 0.280444 18.1027778 0.280800 18.1055556 0.281511 18.1083333 0.280444 18.1111111 0.278311 18.1138889 0.277244 18.1166667 0.276533 18.1194444 0.278667 18.1222222 0.278311 18.1250000 0.278311 18.1277778 0.277600 18.1305556 0.276533 18.1333333 0.276889 18.1361111 0.278311 18.1388889 0.279022 18.1416667 0.279733 18.1444444 0.278667 18.1472222 0.277956 18.1500000 0.276533 18.1527778 0.277244 18.1555556 0.278667 18.1583333 0.278667 18.1611111 0.278311 18.1638889 0.277956 18.1666667 0.278311 18.1694444 0.281156 18.1722222 0.288267 18.1750000 0.296800 18.1777778 0.307111 18.1805556 0.319556 18.1833333 0.335200 18.1861111 0.356889 18.1888889 0.380000 18.1916667 0.399200 18.1944444 0.409511 18.1972222 0.402400 18.2000000 0.384622 18.2027778 0.361511 18.2055556 0.336978 18.2083333 0.311378 18.2111111 0.290756 18.2138889 0.280800 18.2166667 0.281156 18.2194444 0.284356 18.2222222 0.285422 18.2250000 0.285067 18.2277778 0.284000 18.2305556 0.286489 18.2333333 0.286844 18.2361111 0.286844 18.2388889 0.284356 18.2416667 0.282578 18.2444444 0.280800 18.2472222 0.278311 18.2500000 0.279022 18.2527778 0.279022 18.2555556 0.279022 18.2583333 0.280089 18.2611111 0.278667 18.2638889 0.276178 18.2666667 0.276889 18.2694444 0.280089 18.2722222 0.282933 18.2750000 0.284356 18.2777778 0.286489 18.2805556 0.286489 18.2833333 0.284356 18.2861111 0.282933 18.2888889 0.283289 18.2916667 0.283644 18.2944444 0.282222 18.2972222 0.279733 18.3000000 0.278311 18.3027778 0.281511 18.3055556 0.285422 18.3083333 0.282222 18.3111111 0.272978 18.3138889 0.267644 18.3166667 0.268356 18.3194444 0.274044 18.3222222 0.277244 18.3250000 0.277244 18.3277778 0.276178 18.3305556 0.276533 18.3333333 0.277956 18.3361111 0.278667 18.3388889 0.276533 18.3416667 0.274756 18.3444444 0.274044 18.3472222 0.276178 18.3500000 0.280444 18.3527778 0.282933 18.3555556 0.285778 18.3583333 0.286489 18.3611111 0.286489 18.3638889 0.286489 18.3666667 0.286844 18.3694444 0.289333 18.3722222 0.291467 18.3750000 0.292889 18.3777778 0.293244 18.3805556 0.292889 18.3833333 0.293600 18.3861111 0.294667 18.3888889 0.296089 18.3916667 0.297156 18.3944444 0.298933 18.3972222 0.300356 18.4000000 0.302489 18.4027778 0.302489 18.4055556 0.303556 18.4083333 0.302133 18.4111111 0.302844 18.4138889 0.304622 18.4166667 0.309600 18.4194444 0.313867 18.4222222 0.314933 18.4250000 0.311022 18.4277778 0.303911 18.4305556 0.300356 18.4333333 0.300711 18.4361111 0.302489 18.4388889 0.303556 18.4416667 0.302844 18.4444444 0.301422 18.4472222 0.300000 18.4500000 0.300356 18.4527778 0.299644 18.4555556 0.298933 18.4583333 0.296444 18.4611111 0.293600 18.4638889 0.292178 18.4666667 0.289689 18.4694444 0.289689 18.4722222 0.290400 18.4750000 0.290400 18.4777778 0.291467 18.4805556 0.293244 18.4833333 0.296089 18.4861111 0.297867 18.4886667 0.300000 18.4888889 0.294311 18.4916667 0.287911 18.4944444 0.281511 18.4972222 0.277244 18.4974444 0.300000 18.5000000 0.274400 18.5027778 0.270844 18.5055556 0.269422 18.5083333 0.270844 18.5111111 0.271556 18.5138889 0.272978 18.5166667 0.273689 18.5194444 0.275467 18.5222222 0.277600 18.5250000 0.278667 18.5277778 0.279022 18.5305556 0.280089 18.5333333 0.280089 18.5361111 0.280800 18.5388889 0.280800 18.5416667 0.279733 18.5444444 0.278311 18.5472222 0.276533 18.5500000 0.276533 18.5527778 0.277600 18.5555556 0.278667 18.5583333 0.278311 18.5611111 0.277600 18.5638889 0.277956 18.5666667 0.279022 18.5694444 0.279378 18.5722222 0.280444 18.5750000 0.281156 18.5777778 0.281156 18.5805556 0.282578 18.5833333 0.284711 18.5861111 0.286844 18.5888889 0.288267 18.5916667 0.288622 18.5944444 0.288267 18.5972222 0.287556 18.6000000 0.288978 18.6027778 0.289689 18.6055556 0.293244 18.6083333 0.293956 18.6111111 0.294311 18.6138889 0.291111 18.6166667 0.290756 18.6194444 0.294667 18.6222222 0.298222 18.6250000 0.298222 18.6277778 0.293244 18.6305556 0.287556 18.6333333 0.288622 18.6361111 0.290400 18.6388889 0.287200 18.6416667 0.280089 18.6444444 0.272267 18.6472222 0.270489 18.6500000 0.274044 18.6527778 0.276889 18.6555556 0.276533 18.6583333 0.274400 18.6611111 0.273333 18.6638889 0.273689 18.6666667 0.274400 18.6694444 0.275822 18.6722222 0.275822 18.6750000 0.275467 18.6777778 0.273333 18.6805556 0.271556 18.6833333 0.271200 18.6861111 0.272978 18.6888889 0.274044 18.6916667 0.273333 18.6944444 0.272622 18.6972222 0.273689 18.7000000 0.277600 18.7027778 0.279378 18.7055556 0.281511 18.7083333 0.285422 18.7111111 0.289689 18.7138889 0.294311 18.7166667 0.299644 18.7194444 0.309956 18.7222222 0.327022 18.7250000 0.343378 18.7277778 0.360800 18.7305556 0.381067 18.7333333 0.406311 18.7361111 0.430844 18.7388889 0.449689 18.7416667 0.460000 18.7444444 0.455733 18.7472222 0.435111 18.7500000 0.405600 18.7527778 0.372178 18.7555556 0.338044 18.7583333 0.311378 18.7611111 0.296800 18.7638889 0.289333 18.7666667 0.285422 18.7694444 0.281511 18.7722222 0.277600 18.7750000 0.274044 18.7777778 0.271911 18.7805556 0.271556 18.7833333 0.273333 18.7861111 0.276533 18.7888889 0.278311 18.7916667 0.281867 18.7944444 0.285422 18.7972222 0.288267 18.8000000 0.283289 18.8027778 0.269422 18.8055556 0.255911 18.8083333 0.250933 18.8111111 0.256267 18.8138889 0.261244 18.8166667 0.264089 18.8194444 0.263378 18.8222222 0.264444 18.8250000 0.265511 18.8277778 0.266222 18.8305556 0.263378 18.8333333 0.261956 18.8361111 0.262311 18.8388889 0.265511 18.8416667 0.266933 18.8444444 0.269067 18.8472222 0.269067 18.8500000 0.268356 18.8527778 0.265511 18.8555556 0.264089 18.8583333 0.263733 18.8611111 0.263378 18.8638889 0.262311 18.8666667 0.262311 18.8694444 0.261956 18.8722222 0.263022 18.8750000 0.265511 18.8777778 0.266933 18.8805556 0.268711 18.8833333 0.270489 18.8861111 0.270133 18.8888889 0.269422 18.8916667 0.269778 18.8944444 0.268711 18.8972222 0.268000 18.9000000 0.268711 18.9027778 0.271911 18.9055556 0.274400 18.9083333 0.273689 18.9111111 0.271200 18.9138889 0.267289 18.9166667 0.265867 18.9194444 0.266933 18.9222222 0.268000 18.9250000 0.270844 18.9277778 0.272978 18.9305556 0.275467 18.9333333 0.277244 18.9361111 0.278311 18.9388889 0.278311 18.9416667 0.277244 18.9444444 0.276889 18.9470000 0.300000 18.9472222 0.279022 18.9500000 0.280800 18.9527778 0.282222 18.9555556 0.283644 18.9583333 0.284711 18.9611111 0.286133 18.9638889 0.285778 18.9666667 0.284356 18.9694444 0.284711 18.9722222 0.286489 18.9750000 0.289689 18.9777778 0.291467 18.9805556 0.291467 18.9833333 0.292178 18.9861111 0.290400 18.9888889 0.289333 18.9916667 0.289333 18.9944444 0.289689 18.9972222 0.292889 19.0000000 0.296800 19.0027778 0.301422 19.0055556 0.301778 19.0083333 0.301422 19.0111111 0.300356 19.0138889 0.299644 19.0166667 0.295733 19.0194444 0.291467 19.0222222 0.291467 19.0250000 0.291822 19.0277778 0.290044 19.0305556 0.285067 19.0333333 0.279733 19.0361111 0.271200 19.0388889 0.263733 19.0416667 0.255200 19.0444444 0.253778 19.0446667 0.300000 19.0472222 0.261956 19.0500000 0.272978 19.0527778 0.277244 19.0555556 0.274044 19.0583333 0.271556 19.0611111 0.278667 19.0638889 0.291822 19.0666667 0.299289 19.0694444 0.293600 19.0722222 0.280089 19.0750000 0.270133 19.0777778 0.272978 19.0805556 0.282222 19.0833333 0.285778 19.0861111 0.279733 19.0888889 0.269422 19.0916667 0.265511 19.0944444 0.268356 19.0972222 0.274400 19.1000000 0.276889 19.1027778 0.277244 19.1055556 0.280800 19.1083333 0.284000 19.1111111 0.280800 19.1138889 0.275822 19.1166667 0.277600 19.1194444 0.284711 19.1222222 0.292889 19.1250000 0.295378 19.1277778 0.291467 19.1305556 0.283644 19.1333333 0.280444 19.1361111 0.288978 19.1388889 0.301067 19.1416667 0.305689 19.1444444 0.301067 19.1472222 0.297156 19.1500000 0.302489 19.1527778 0.315644 19.1555556 0.332356 19.1583333 0.346222 19.1611111 0.349778 19.1638889 0.347644 19.1666667 0.346578 19.1694444 0.350133 19.1722222 0.355822 19.1750000 0.362222 19.1777778 0.369689 19.1805556 0.384622 19.1833333 0.400267 19.1861111 0.412000 19.1888889 0.415200 19.1916667 0.416978 19.1944444 0.415556 19.1972222 0.417333 19.2000000 0.425511 19.2027778 0.440089 19.2055556 0.442933 19.2083333 0.429067 19.2111111 0.411644 19.2138889 0.406311 19.2166667 0.405600 19.2194444 0.406311 19.2222222 0.401333 19.2250000 0.398133 19.2277778 0.392800 19.2305556 0.385689 19.2333333 0.377156 19.2361111 0.370400 19.2388889 0.372889 19.2416667 0.376089 19.2444444 0.377156 19.2472222 0.375378 19.2500000 0.372889 19.2527778 0.368267 19.2555556 0.359022 19.2583333 0.343733 19.2611111 0.325600 19.2638889 0.310311 19.2666667 0.296800 19.2694444 0.288622 19.2722222 0.290044 19.2750000 0.295733 19.2777778 0.298222 19.2805556 0.298222 19.2833333 0.294311 19.2861111 0.285067 19.2888889 0.277244 19.2916667 0.277600 19.2944444 0.285067 19.2972222 0.291467 19.3000000 0.294311 19.3027778 0.287556 19.3055556 0.275822 19.3083333 0.267289 19.3111111 0.264444 19.3138889 0.267289 19.3166667 0.277600 19.3194444 0.286844 19.3222222 0.291111 19.3250000 0.292533 19.3277778 0.292533 19.3305556 0.286844 19.3333333 0.277244 19.3361111 0.268356 19.3388889 0.260889 19.3416667 0.259111 19.3444444 0.266222 19.3472222 0.276889 19.3500000 0.281156 19.3527778 0.282222 19.3555556 0.279022 19.3583333 0.272267 19.3611111 0.262667 19.3638889 0.257689 19.3666667 0.265867 19.3694444 0.275467 19.3722222 0.275111 19.3750000 0.267289 19.3777778 0.264444 19.3805556 0.259822 19.3833333 0.252356 19.3861111 0.247733 19.3888889 0.246311 19.3916667 0.246311 19.3944444 0.250933 19.3972222 0.259467 19.4000000 0.263022 19.4027778 0.264444 19.4055556 0.267289 19.4083333 0.273689 19.4111111 0.274756 19.4138889 0.271556 19.4166667 0.266578 19.4194444 0.260889 19.4222222 0.253422 19.4250000 0.252711 19.4277778 0.261956 19.4305556 0.273333 19.4333333 0.280089 19.4361111 0.282933 19.4388889 0.283644 19.4416667 0.286133 19.4444444 0.289333 19.4472222 0.293244 19.4500000 0.296800 19.4527778 0.298578 19.4555556 0.297867 19.4583333 0.296089 19.4611111 0.293956 19.4638889 0.293956 19.4666667 0.297511 19.4694444 0.301778 19.4722222 0.302489 19.4750000 0.301067 19.4777778 0.298222 19.4805556 0.297511 19.4833333 0.300000 19.4861111 0.302844 19.4888889 0.303911 19.4916667 0.304267 19.4944444 0.302489 19.4972222 0.300000 19.5030000 0.300000 19.5803333 0.300000 19.5833333 0.289689 19.5861111 0.292178 19.5888889 0.292533 19.5916667 0.291467 19.5944444 0.290044 19.5972222 0.288978 19.6000000 0.290044 19.6027778 0.290756 19.6055556 0.292178 19.6083333 0.292178 19.6111111 0.292178 19.6138889 0.291467 19.6166667 0.292533 19.6194444 0.293956 19.6222222 0.295733 19.6250000 0.296444 19.6277778 0.296089 19.6305556 0.295733 19.6333333 0.296089 19.6361111 0.296444 19.6388889 0.294667 19.6416667 0.293600 19.6444444 0.293956 19.6472222 0.294311 19.6500000 0.295378 19.6527778 0.295022 19.6555556 0.294311 19.6583333 0.294667 19.6611111 0.295022 19.6638889 0.294311 19.6666667 0.295022 19.6694444 0.296800 19.6722222 0.297511 19.6750000 0.297156 19.6777778 0.296800 19.6805556 0.297511 19.6833333 0.300356 19.6861111 0.302133 19.6888889 0.304622 19.6916667 0.305689 19.6944444 0.306756 19.6972222 0.309244 19.7000000 0.309956 19.7027778 0.309600 19.7055556 0.309600 19.7083333 0.308889 19.7111111 0.307111 19.7138889 0.306044 19.7166667 0.305689 19.7194444 0.306400 19.7222222 0.306756 19.7250000 0.306044 19.7277778 0.302844 19.7305556 0.299289 19.7333333 0.297511 19.7361111 0.298578 19.7388889 0.297156 19.7416667 0.296800 19.7444444 0.295378 19.7472222 0.293956 19.7500000 0.293956 19.7527778 0.293956 19.7555556 0.294311 19.7583333 0.295022 19.7611111 0.294311 19.7638889 0.293956 19.7666667 0.294311 19.7694444 0.297156 19.7722222 0.297156 19.7750000 0.297511 19.7777778 0.295378 19.7805556 0.293956 19.7833333 0.294667 19.7861111 0.295378 19.7888889 0.297156 19.7916667 0.298222 19.7944444 0.297867 19.7972222 0.297156 19.8000000 0.296800 19.8027778 0.297156 19.8055556 0.298222 19.8083333 0.297867 19.8111111 0.299644 19.8138889 0.303911 19.8166667 0.313156 19.8194444 0.325956 19.8222222 0.342311 19.8250000 0.363289 19.8277778 0.386044 19.8305556 0.407022 19.8333333 0.425511 19.8361111 0.431556 19.8388889 0.419467 19.8416667 0.390311 19.8444444 0.354400 19.8472222 0.322400 19.8500000 0.304978 19.8527778 0.300356 19.8555556 0.300711 19.8583333 0.300711 19.8611111 0.299644 19.8638889 0.298933 19.8666667 0.301067 19.8694444 0.302489 19.8722222 0.300711 19.8750000 0.298222 19.8777778 0.295022 19.8805556 0.294311 19.8833333 0.293600 19.8861111 0.293600 19.8888889 0.294311 19.8916667 0.294667 19.8944444 0.292889 19.8972222 0.292533 19.9000000 0.293600 19.9027778 0.295733 19.9055556 0.295022 19.9083333 0.294311 19.9111111 0.290400 19.9138889 0.290756 19.9166667 0.292178 19.9194444 0.293956 19.9222222 0.293244 19.9250000 0.291111 19.9277778 0.289333 19.9305556 0.288267 19.9333333 0.290400 19.9361111 0.291822 19.9388889 0.292533 19.9416667 0.292533 19.9444444 0.291822 19.9472222 0.291111 19.9500000 0.291111 19.9527778 0.292178 19.9555556 0.293600 19.9583333 0.293956 19.9611111 0.292533 19.9638889 0.292889 19.9666667 0.295378 19.9694444 0.297511 19.9722222 0.298578 19.9750000 0.297867 19.9777778 0.296089 19.9805556 0.296800 19.9833333 0.297156 19.9861111 0.300000 19.9888889 0.301778 19.9916667 0.302133 19.9944444 0.302133 19.9972222 0.302489 20.0000000 0.302133 20.0027778 0.302489 20.0055556 0.304978 20.0083333 0.305333 20.0111111 0.305333 20.0138889 0.308178 20.0166667 0.311378 20.0194444 0.315289 20.0222222 0.317067 20.0250000 0.317067 20.0277778 0.316711 20.0305556 0.317067 20.0333333 0.320267 20.0361111 0.322756 20.0388889 0.326667 20.0416667 0.327733 20.0444444 0.329156 20.0472222 0.329867 20.0500000 0.332000 20.0527778 0.332711 20.0555556 0.333422 20.0583333 0.332711 20.0611111 0.329511 20.0638889 0.327378 20.0666667 0.327378 20.0694444 0.324178 20.0722222 0.321689 20.0750000 0.318844 20.0777778 0.315289 20.0803333 0.300000 20.0805556 0.312800 20.0833333 0.309600 20.0861111 0.307822 20.0888889 0.307111 20.0916667 0.303200 20.0944444 0.300000 20.0972222 0.297867 20.1000000 0.296444 20.1027778 0.296444 20.1055556 0.295733 20.1083333 0.293956 20.1111111 0.293244 20.1138889 0.291111 20.1166667 0.291111 20.1194444 0.290400 20.1222222 0.289333 20.1250000 0.287556 20.1277778 0.286489 20.1305556 0.286133 20.1333333 0.287556 20.1361111 0.288267 20.1363333 0.300000 20.1388889 0.288978 20.1416667 0.287556 20.1444444 0.285778 20.1472222 0.284711 20.1500000 0.282933 20.1527778 0.284000 20.1555556 0.284356 20.1583333 0.284000 20.1611111 0.282578 20.1638889 0.281867 20.1666667 0.280444 20.1694444 0.281156 20.1722222 0.278667 20.1750000 0.277600 20.1777778 0.274400 20.1805556 0.272622 20.1833333 0.271556 20.1861111 0.271911 20.1888889 0.272267 20.1916667 0.272622 20.1944444 0.270133 20.1972222 0.265156 20.2000000 0.263022 20.2027778 0.261600 20.2055556 0.260889 20.2083333 0.263378 20.2111111 0.271556 20.2138889 0.281156 20.2166667 0.284356 20.2194444 0.285422 20.2222222 0.292178 20.2250000 0.297511 20.2277778 0.295733 20.2305556 0.292178 20.2333333 0.292889 20.2361111 0.296444 20.2388889 0.298933 20.2416667 0.300356 20.2444444 0.302489 20.2472222 0.303911 20.2500000 0.301778 20.2527778 0.298933 20.2555556 0.295022 20.2583333 0.291111 20.2611111 0.288978 20.2638889 0.289333 20.2666667 0.291467 20.2694444 0.295022 20.2722222 0.294667 20.2750000 0.295022 20.2777778 0.293244 20.2805556 0.292178 20.2833333 0.292178 20.2861111 0.294311 20.2888889 0.294311 20.2916667 0.293956 20.2944444 0.293600 20.2972222 0.293600 20.3000000 0.295022 20.3027778 0.297156 20.3055556 0.297511 20.3083333 0.297867 20.3111111 0.298933 20.3138889 0.303200 20.3166667 0.312089 20.3194444 0.326667 20.3222222 0.346578 20.3250000 0.366133 20.3277778 0.384267 20.3305556 0.402400 20.3333333 0.418044 20.3361111 0.424089 20.3388889 0.411644 20.3416667 0.384622 20.3444444 0.352978 20.3472222 0.326667 20.3500000 0.309244 20.3527778 0.301778 20.3555556 0.301067 20.3583333 0.302133 20.3611111 0.303556 20.3638889 0.303200 20.3666667 0.302844 20.3694444 0.305333 20.3722222 0.305333 20.3750000 0.306044 20.3777778 0.304622 20.3805556 0.302844 20.3833333 0.300711 20.3861111 0.299644 20.3888889 0.297511 20.3916667 0.296089 20.3944444 0.293244 20.3972222 0.291111 20.4000000 0.290756 20.4027778 0.292178 20.4055556 0.293244 20.4083333 0.292889 20.4111111 0.292178 20.4138889 0.291111 20.4166667 0.291467 20.4194444 0.292889 20.4222222 0.293600 20.4250000 0.294311 20.4277778 0.293956 20.4305556 0.295022 20.4333333 0.296800 20.4361111 0.301067 20.4388889 0.304978 20.4416667 0.306756 20.4444444 0.307822 20.4472222 0.306400 20.4500000 0.305333 20.4527778 0.304978 20.4555556 0.303200 20.4583333 0.300711 20.4611111 0.298933 20.4638889 0.300356 20.4666667 0.303556 20.4694444 0.303200 20.4722222 0.300356 20.4750000 0.297511 20.4777778 0.295733 20.4805556 0.297156 20.4833333 0.299289 20.4861111 0.300711 20.4888889 0.301067 20.4916667 0.299644 20.4944444 0.298578 20.4972222 0.297867 20.5000000 0.298933 20.5027778 0.301422 20.5055556 0.303200 20.5083333 0.302489 20.5111111 0.302844 20.5138889 0.304267 20.5166667 0.306756 20.5194444 0.308533 20.5222222 0.308889 20.5250000 0.309244 20.5277778 0.309244 20.5305556 0.310311 20.5333333 0.311022 20.5361111 0.312800 20.5388889 0.315644 20.5416667 0.316356 20.5444444 0.317778 20.5472222 0.319200 20.5500000 0.320978 20.5527778 0.327378 20.5555556 0.329511 20.5583333 0.329867 20.5611111 0.326311 20.5638889 0.323111 20.5666667 0.325244 20.5694444 0.328800 20.5722222 0.330933 20.5750000 0.331644 20.5777778 0.328089 20.5805556 0.324178 20.5833333 0.320978 20.5861111 0.318844 20.5888889 0.318133 20.5916667 0.317422 20.5944444 0.317067 20.5972222 0.318489 20.6000000 0.319911 20.6027778 0.319911 20.6055556 0.319200 20.6083333 0.316000 20.6111111 0.314222 20.6138889 0.312444 20.6166667 0.316000 20.6194444 0.317067 20.6222222 0.316000 20.6250000 0.312444 20.6277778 0.308533 20.6303333 0.300000 20.6305556 0.307467 20.6333333 0.309600 20.6361111 0.311378 20.6363333 0.300000 20.6388889 0.311022 20.6416667 0.308533 20.6444444 0.306400 20.6472222 0.306400 20.6500000 0.307467 20.6527778 0.308533 20.6555556 0.307822 20.6583333 0.307467 20.6611111 0.305333 20.6638889 0.305333 20.6666667 0.305689 20.6694444 0.306400 20.6722222 0.304622 20.6750000 0.303200 20.6777778 0.302844 20.6805556 0.300711 20.6833333 0.301067 20.6861111 0.302844 20.6888889 0.303556 20.6916667 0.301067 20.6944444 0.297867 20.6972222 0.296444 20.7000000 0.298222 20.7027778 0.299289 20.7055556 0.298222 20.7083333 0.297511 20.7111111 0.296800 20.7138889 0.296800 20.7166667 0.297156 20.7194444 0.300356 20.7222222 0.301422 20.7250000 0.300356 20.7277778 0.298933 20.7305556 0.297867 20.7333333 0.298933 20.7361111 0.301422 20.7388889 0.302489 20.7416667 0.303911 20.7444444 0.304978 20.7472222 0.307467 20.7500000 0.308533 20.7527778 0.310311 20.7555556 0.310667 20.7583333 0.312089 20.7611111 0.312089 20.7638889 0.311733 20.7666667 0.309244 20.7694444 0.306400 20.7722222 0.305689 20.7750000 0.304622 20.7777778 0.304622 20.7805556 0.302844 20.7833333 0.301778 20.7861111 0.301422 20.7888889 0.301067 20.7916667 0.300356 20.7944444 0.299644 20.7972222 0.297511 20.8000000 0.296089 20.8027778 0.297156 20.8055556 0.298933 20.8083333 0.300356 20.8111111 0.301778 20.8138889 0.303200 20.8166667 0.306400 20.8194444 0.309956 20.8222222 0.315644 20.8250000 0.318489 20.8277778 0.319556 20.8305556 0.322400 20.8333333 0.326667 20.8361111 0.334844 20.8388889 0.340178 20.8416667 0.342667 20.8444444 0.344089 20.8472222 0.347644 20.8500000 0.352978 20.8527778 0.360800 20.8555556 0.364000 20.8583333 0.366133 20.8611111 0.369689 20.8638889 0.376089 20.8666667 0.388889 20.8694444 0.405244 20.8722222 0.422311 20.8750000 0.432622 20.8777778 0.440444 20.8805556 0.441511 20.8833333 0.445778 20.8861111 0.449333 20.8888889 0.445778 20.8916667 0.429422 20.8944444 0.400267 20.8972222 0.368622 20.9000000 0.342667 20.9027778 0.323822 20.9055556 0.312800 20.9083333 0.305689 20.9111111 0.297867 20.9138889 0.290044 20.9166667 0.282578 20.9194444 0.278311 20.9222222 0.277956 20.9250000 0.277956 20.9277778 0.275111 20.9305556 0.272978 20.9333333 0.273333 20.9361111 0.273333 20.9388889 0.274756 20.9416667 0.272978 20.9444444 0.272978 20.9472222 0.269422 20.9500000 0.266222 20.9527778 0.265156 20.9555556 0.265156 20.9583333 0.265511 20.9611111 0.264089 20.9638889 0.263733 20.9666667 0.263022 20.9694444 0.263733 20.9722222 0.263022 20.9750000 0.261956 20.9777778 0.259822 20.9805556 0.259467 20.9833333 0.259822 20.9861111 0.259822 20.9888889 0.258044 20.9916667 0.255200 20.9944444 0.252356 20.9972222 0.251289 21.0000000 0.250578 21.0027778 0.251644 21.0055556 0.254844 21.0083333 0.253422 21.0111111 0.252356 21.0138889 0.251289 21.0166667 0.251644 21.0194444 0.250578 21.0222222 0.250222 21.0250000 0.251289 21.0277778 0.250933 21.0305556 0.249511 21.0333333 0.247022 21.0361111 0.245244 21.0388889 0.243111 21.0416667 0.242400 21.0444444 0.240978 21.0472222 0.240622 21.0500000 0.240978 21.0527778 0.244889 21.0555556 0.245244 21.0583333 0.244889 21.0611111 0.242756 21.0638889 0.243467 21.0666667 0.245956 21.0694444 0.248444 21.0722222 0.250578 21.0750000 0.251644 21.0777778 0.249156 21.0805556 0.247733 21.0833333 0.248444 21.0861111 0.248800 21.0888889 0.249867 21.0916667 0.251289 21.0944444 0.251289 21.0972222 0.252000 21.1000000 0.253778 21.1027778 0.255911 21.1055556 0.255556 21.1083333 0.255556 21.1111111 0.255556 21.1138889 0.255556 21.1166667 0.258044 21.1194444 0.261600 21.1222222 0.263733 21.1250000 0.264089 21.1277778 0.263733 21.1305556 0.264800 21.1333333 0.268000 21.1361111 0.269422 21.1388889 0.271556 21.1416667 0.273689 21.1444444 0.273333 21.1472222 0.273333 21.1500000 0.272978 21.1527778 0.275111 21.1555556 0.275111 21.1583333 0.272978 21.1611111 0.271911 21.1638889 0.271556 21.1666667 0.271911 21.1694444 0.273333 21.1722222 0.273689 21.1750000 0.272978 21.1777778 0.271911 21.1805556 0.270489 21.1863333 0.300000 21.1942222 0.300000 21.1972222 0.266933 21.2000000 0.266933 21.2027778 0.268356 21.2055556 0.266933 21.2083333 0.265511 21.2111111 0.264444 21.2138889 0.262667 21.2166667 0.264089 21.2194444 0.265156 21.2222222 0.264444 21.2250000 0.263378 21.2277778 0.262311 21.2305556 0.263022 21.2333333 0.263022 21.2361111 0.263378 21.2388889 0.264444 21.2416667 0.265156 21.2444444 0.263733 21.2472222 0.263378 21.2500000 0.264444 21.2527778 0.266578 21.2555556 0.268000 21.2583333 0.268356 21.2611111 0.267289 21.2638889 0.266933 21.2666667 0.269422 21.2694444 0.271556 21.2722222 0.272622 21.2750000 0.272978 21.2777778 0.273689 21.2805556 0.274400 21.2833333 0.275467 21.2861111 0.277244 21.2888889 0.279378 21.2916667 0.280089 21.2944444 0.281511 21.2972222 0.282578 21.3000000 0.283289 21.3027778 0.284356 21.3055556 0.284356 21.3083333 0.284356 21.3111111 0.284000 21.3138889 0.285067 21.3166667 0.285778 21.3194444 0.286489 21.3222222 0.286133 21.3250000 0.283644 21.3277778 0.281511 21.3305556 0.279733 21.3333333 0.277956 21.3361111 0.278311 21.3388889 0.276533 21.3416667 0.274044 21.3444444 0.271556 21.3472222 0.270133 21.3500000 0.270844 21.3527778 0.270489 21.3555556 0.269778 21.3583333 0.266933 21.3611111 0.264444 21.3638889 0.262667 21.3666667 0.262667 21.3694444 0.261956 21.3722222 0.260889 21.3750000 0.259467 21.3777778 0.258756 21.3805556 0.259111 21.3833333 0.259467 21.3861111 0.259822 21.3888889 0.260889 21.3916667 0.260889 21.3944444 0.259111 21.3972222 0.258400 21.4000000 0.257689 21.4027778 0.258044 21.4055556 0.258756 21.4083333 0.257689 21.4111111 0.255200 21.4138889 0.251289 21.4166667 0.250222 21.4194444 0.251289 21.4222222 0.256622 21.4250000 0.264089 21.4277778 0.275111 21.4305556 0.288267 21.4333333 0.305333 21.4361111 0.322400 21.4388889 0.337689 21.4416667 0.352267 21.4444444 0.364711 21.4472222 0.372533 21.4500000 0.368267 21.4527778 0.350489 21.4555556 0.324178 21.4583333 0.296800 21.4611111 0.275111 21.4638889 0.260889 21.4666667 0.257689 21.4694444 0.256267 21.4722222 0.254844 21.4750000 0.251644 21.4777778 0.248444 21.4805556 0.248800 21.4833333 0.251644 21.4861111 0.254844 21.4888889 0.255556 21.4916667 0.252711 21.4944444 0.250933 21.4972222 0.250222 21.5000000 0.249867 21.5027778 0.249156 21.5055556 0.248089 21.5083333 0.247733 21.5111111 0.245956 21.5138889 0.246667 21.5166667 0.248800 21.5194444 0.250933 21.5222222 0.251644 21.5250000 0.250933 21.5277778 0.250222 21.5305556 0.250222 21.5333333 0.253067 21.5361111 0.255200 21.5388889 0.255911 21.5416667 0.255556 21.5444444 0.254489 21.5472222 0.254133 21.5500000 0.255556 21.5527778 0.256622 21.5555556 0.258044 21.5583333 0.257333 21.5611111 0.257333 21.5638889 0.257333 21.5666667 0.258400 21.5694444 0.259111 21.5722222 0.259822 21.5750000 0.258756 21.5777778 0.259467 21.5805556 0.260178 21.5833333 0.261244 21.5861111 0.262311 21.5888889 0.263022 21.5916667 0.262311 21.5944444 0.260533 21.5972222 0.259822 21.6000000 0.261244 21.6027778 0.263022 21.6055556 0.264089 21.6083333 0.264089 21.6111111 0.264089 21.6138889 0.264089 21.6166667 0.265156 21.6194444 0.266933 21.6222222 0.266933 21.6250000 0.267289 21.6277778 0.266578 21.6305556 0.266222 21.6333333 0.268356 21.6361111 0.269067 21.6388889 0.269067 21.6416667 0.268000 21.6444444 0.266578 21.6472222 0.266578 21.6500000 0.266933 21.6527778 0.267644 21.6555556 0.269067 21.6583333 0.268000 21.6611111 0.266933 21.6638889 0.268000 21.6666667 0.270844 21.6694444 0.273689 21.6722222 0.275467 21.6750000 0.276533 21.6777778 0.274756 21.6805556 0.273333 21.6833333 0.274756 21.6861111 0.275467 21.6888889 0.277244 21.6916667 0.276178 21.6944444 0.275111 21.6972222 0.274400 21.7000000 0.275111 21.7027778 0.275822 21.7055556 0.275467 21.7083333 0.274756 21.7111111 0.272978 21.7138889 0.271911 21.7166667 0.270489 21.7194444 0.270489 21.7222222 0.270489 21.7250000 0.268000 21.7277778 0.266578 21.7305556 0.264089 21.7333333 0.263022 21.7361111 0.262667 21.7388889 0.262311 21.7416667 0.261956 21.7444444 0.259111 21.7502222 0.300000 21.9472222 0.300000)
Vecg1 ecg_l1 0 PWL(0.0000000 0.300000 0.2470000 0.300000 0.2500000 0.305333 0.2527778 0.304622 0.2555556 0.302489 0.2583333 0.302844 0.2611111 0.304267 0.2638889 0.303556 0.2666667 0.303911 0.2694444 0.302844 0.2722222 0.302133 0.2750000 0.301778 0.2777778 0.303200 0.2805556 0.304978 0.2833333 0.305689 0.2861111 0.304978 0.2888889 0.306044 0.2916667 0.306756 0.2944444 0.308533 0.2972222 0.310667 0.3000000 0.311733 0.3027778 0.312800 0.3055556 0.311378 0.3083333 0.313156 0.3111111 0.315289 0.3138889 0.317422 0.3166667 0.316356 0.3194444 0.317067 0.3222222 0.316711 0.3250000 0.317422 0.3277778 0.318489 0.3305556 0.319556 0.3333333 0.319911 0.3361111 0.319556 0.3388889 0.318133 0.3416667 0.318844 0.3444444 0.319911 0.3472222 0.320978 0.3500000 0.320622 0.3527778 0.319200 0.3555556 0.318489 0.3583333 0.319200 0.3611111 0.320622 0.3638889 0.320978 0.3666667 0.320267 0.3694444 0.319200 0.3722222 0.318844 0.3750000 0.319556 0.3777778 0.320978 0.3805556 0.321333 0.3833333 0.321333 0.3861111 0.319911 0.3888889 0.319200 0.3916667 0.319911 0.3944444 0.321689 0.3972222 0.321333 0.4000000 0.320622 0.4027778 0.319556 0.4055556 0.318844 0.4083333 0.318844 0.4111111 0.319911 0.4138889 0.321689 0.4166667 0.321689 0.4194444 0.320267 0.4222222 0.318489 0.4250000 0.319911 0.4277778 0.319911 0.4305556 0.319200 0.4333333 0.317778 0.4361111 0.316000 0.4388889 0.313867 0.4416667 0.312800 0.4444444 0.311733 0.4472222 0.308178 0.4500000 0.305689 0.4527778 0.301067 0.4555556 0.297156 0.4583333 0.292889 0.4611111 0.288622 0.4638889 0.282578 0.4666667 0.277244 0.4694444 0.270844 0.4722222 0.266933 0.4750000 0.260889 0.4777778 0.257333 0.4805556 0.253067 0.4833333 0.248444 0.4861111 0.244178 0.4888889 0.241333 0.4916667 0.239200 0.4944444 0.238133 0.4972222 0.237778 0.5000000 0.237067 0.5027778 0.238844 0.5055556 0.243111 0.5083333 0.248444 0.5111111 0.255556 0.5138889 0.261956 0.5166667 0.268000 0.5194444 0.275467 0.5222222 0.282222 0.5250000 0.288267 0.5277778 0.292889 0.5305556 0.295378 0.5333333 0.296089 0.5361111 0.296800 0.5388889 0.296089 0.5416667 0.297156 0.5444444 0.296800 0.5472222 0.295378 0.5500000 0.295733 0.5527778 0.296800 0.5555556 0.299644 0.5583333 0.304978 0.5611111 0.311733 0.5638889 0.318133 0.5666667 0.323822 0.5694444 0.325956 0.5722222 0.329156 0.5750000 0.329867 0.5777778 0.332711 0.5805556 0.333067 0.5833333 0.334133 0.5861111 0.334489 0.5888889 0.335200 0.5916667 0.335911 0.5944444 0.337333 0.5972222 0.337333 0.6000000 0.338044 0.6027778 0.338044 0.6055556 0.339111 0.6083333 0.338756 0.6111111 0.340533 0.6138889 0.342311 0.6166667 0.342667 0.6194444 0.342667 0.6222222 0.342667 0.6250000 0.343733 0.6277778 0.344800 0.6305556 0.346222 0.6333333 0.347289 0.6361111 0.346933 0.6388889 0.347289 0.6416667 0.348356 0.6444444 0.349422 0.6472222 0.351556 0.6500000 0.352267 0.6527778 0.352267 0.6555556 0.353333 0.6583333 0.353689 0.6611111 0.355822 0.6638889 0.356889 0.6666667 0.356533 0.6694444 0.356178 0.6722222 0.356178 0.6750000 0.357956 0.6777778 0.358667 0.6805556 0.358667 0.6833333 0.358667 0.6861111 0.357600 0.6888889 0.356178 0.6916667 0.356178 0.6944444 0.355467 0.6972222 0.355111 0.7000000 0.354756 0.7027778 0.351200 0.7055556 0.349778 0.7083333 0.348000 0.7111111 0.347644 0.7138889 0.345511 0.7166667 0.344089 0.7194444 0.341600 0.7222222 0.338044 0.7250000 0.336622 0.7277778 0.336622 0.7305556 0.334844 0.7333333 0.333778 0.7361111 0.330222 0.7388889 0.328800 0.7416667 0.328444 0.7444444 0.327378 0.7472222 0.328089 0.7500000 0.325956 0.7527778 0.323467 0.7555556 0.322756 0.7583333 0.322756 0.7611111 0.323467 0.7638889 0.322400 0.7666667 0.322044 0.7694444 0.320622 0.7722222 0.319556 0.7750000 0.320978 0.7777778 0.320622 0.7805556 0.320978 0.7833333 0.320978 0.7861111 0.320267 0.7888889 0.319556 0.7916667 0.319911 0.7944444 0.320978 0.7972222 0.322044 0.8030000 0.300000 1.0081111 0.300000 1.0111111 0.316711 1.0138889 0.317778 1.0166667 0.317067 1.0194444 0.315289 1.0222222 0.314578 1.0250000 0.315644 1.0277778 0.316356 1.0305556 0.317422 1.0333333 0.316711 1.0361111 0.315289 1.0388889 0.315289 1.0416667 0.315289 1.0444444 0.316356 1.0472222 0.317067 1.0500000 0.315644 1.0527778 0.315644 1.0555556 0.314578 1.0583333 0.314933 1.0611111 0.316000 1.0638889 0.315644 1.0666667 0.315644 1.0694444 0.314222 1.0722222 0.314222 1.0750000 0.315644 1.0777778 0.315644 1.0805556 0.316000 1.0833333 0.315289 1.0861111 0.314933 1.0888889 0.314222 1.0916667 0.315289 1.0944444 0.316000 1.0972222 0.316356 1.1000000 0.316356 1.1027778 0.316000 1.1055556 0.315644 1.1083333 0.317067 1.1111111 0.318133 1.1138889 0.318133 1.1166667 0.318133 1.1194444 0.317778 1.1222222 0.317067 1.1250000 0.317422 1.1277778 0.318133 1.1305556 0.317067 1.1333333 0.316356 1.1361111 0.313867 1.1388889 0.312444 1.1416667 0.313156 1.1444444 0.313511 1.1472222 0.312800 1.1500000 0.312089 1.1527778 0.312089 1.1555556 0.311733 1.1583333 0.312089 1.1611111 0.312800 1.1638889 0.313156 1.1666667 0.313511 1.1694444 0.313867 1.1722222 0.313511 1.1750000 0.313511 1.1777778 0.314933 1.1805556 0.315289 1.1833333 0.314578 1.1861111 0.313867 1.1888889 0.314222 1.1916667 0.313511 1.1944444 0.314222 1.1972222 0.315289 1.2000000 0.314222 1.2027778 0.313867 1.2055556 0.314222 1.2083333 0.314222 1.2111111 0.314933 1.2138889 0.314933 1.2166667 0.314578 1.2194444 0.313511 1.2222222 0.313156 1.2250000 0.313511 1.2277778 0.313511 1.2305556 0.312089 1.2333333 0.312800 1.2361111 0.312089 1.2388889 0.311733 1.2416667 0.309244 1.2444444 0.306044 1.2472222 0.301422 1.2500000 0.297156 1.2527778 0.296800 1.2555556 0.297511 1.2583333 0.296800 1.2611111 0.297156 1.2638889 0.300711 1.2666667 0.306044 1.2694444 0.309244 1.2722222 0.309600 1.2750000 0.310667 1.2777778 0.309244 1.2805556 0.307467 1.2833333 0.306400 1.2861111 0.306756 1.2888889 0.307822 1.2916667 0.311022 1.2944444 0.312800 1.2972222 0.314933 1.3000000 0.315289 1.3027778 0.314933 1.3055556 0.314933 1.3083333 0.315289 1.3111111 0.316711 1.3138889 0.316356 1.3166667 0.316356 1.3194444 0.316000 1.3222222 0.315644 1.3250000 0.315289 1.3277778 0.315644 1.3305556 0.316356 1.3333333 0.316356 1.3361111 0.316000 1.3388889 0.315289 1.3416667 0.315644 1.3444444 0.316000 1.3472222 0.316000 1.3500000 0.317067 1.3527778 0.315644 1.3555556 0.314933 1.3583333 0.315644 1.3611111 0.316356 1.3638889 0.317422 1.3666667 0.317067 1.3694444 0.316000 1.3722222 0.314578 1.3750000 0.314222 1.3777778 0.314933 1.3805556 0.315289 1.3833333 0.315289 1.3861111 0.313867 1.3888889 0.312800 1.3916667 0.311733 1.3944444 0.313156 1.3972222 0.313867 1.4000000 0.312800 1.4027778 0.311378 1.4055556 0.311022 1.4083333 0.311378 1.4111111 0.311378 1.4138889 0.312444 1.4166667 0.310667 1.4194444 0.309600 1.4222222 0.308533 1.4250000 0.308533 1.4277778 0.309244 1.4305556 0.308533 1.4333333 0.308178 1.4361111 0.306044 1.4388889 0.304622 1.4416667 0.303911 1.4444444 0.303911 1.4472222 0.303556 1.4500000 0.302844 1.4527778 0.300356 1.4555556 0.299289 1.4583333 0.298933 1.4611111 0.298933 1.4638889 0.298933 1.4666667 0.298578 1.4694444 0.296089 1.4722222 0.294667 1.4750000 0.295378 1.4777778 0.294667 1.4805556 0.295733 1.4833333 0.295733 1.4861111 0.293956 1.4888889 0.293600 1.4916667 0.293600 1.4944444 0.295733 1.4972222 0.296800 1.5000000 0.296444 1.5027778 0.296089 1.5055556 0.296444 1.5083333 0.298578 1.5111111 0.300000 1.5138889 0.302133 1.5166667 0.303200 1.5194444 0.303200 1.5222222 0.303911 1.5250000 0.306044 1.5277778 0.308889 1.5305556 0.310667 1.5333333 0.311022 1.5361111 0.311022 1.5388889 0.312089 1.5416667 0.313867 1.5444444 0.315289 1.5472222 0.317422 1.5500000 0.317067 1.5527778 0.317067 1.5555556 0.317067 1.5583333 0.318489 1.5641111 0.300000 1.6025556 0.300000 1.6055556 0.319911 1.6083333 0.320267 1.6111111 0.321689 1.6138889 0.322400 1.6166667 0.321689 1.6194444 0.320622 1.6222222 0.319556 1.6250000 0.320267 1.6277778 0.320267 1.6305556 0.320622 1.6333333 0.319911 1.6361111 0.319556 1.6388889 0.318489 1.6416667 0.318133 1.6444444 0.319556 1.6472222 0.320267 1.6500000 0.319200 1.6527778 0.317778 1.6555556 0.317067 1.6583333 0.317422 1.6611111 0.319556 1.6638889 0.319200 1.6666667 0.318844 1.6694444 0.317422 1.6722222 0.317778 1.6750000 0.318489 1.6777778 0.319556 1.6805556 0.319556 1.6833333 0.318844 1.6861111 0.318489 1.6888889 0.318844 1.6916667 0.319556 1.6944444 0.321333 1.6972222 0.321689 1.7000000 0.321333 1.7027778 0.320267 1.7055556 0.319556 1.7083333 0.319200 1.7111111 0.320622 1.7138889 0.320978 1.7166667 0.319200 1.7194444 0.316711 1.7222222 0.316000 1.7250000 0.315644 1.7277778 0.314933 1.7305556 0.315289 1.7333333 0.316000 1.7361111 0.313867 1.7388889 0.313511 1.7416667 0.314933 1.7444444 0.315289 1.7472222 0.316000 1.7500000 0.316000 1.7527778 0.314933 1.7555556 0.315644 1.7583333 0.317422 1.7611111 0.319911 1.7638889 0.321689 1.7666667 0.320267 1.7694444 0.319556 1.7722222 0.318489 1.7750000 0.316356 1.7777778 0.315289 1.7805556 0.312089 1.7833333 0.308889 1.7861111 0.304267 1.7888889 0.300000 1.7916667 0.295733 1.7944444 0.291467 1.7972222 0.284356 1.8000000 0.276178 1.8027778 0.268356 1.8055556 0.261600 1.8083333 0.257333 1.8111111 0.253778 1.8138889 0.249867 1.8166667 0.243822 1.8194444 0.238133 1.8222222 0.233156 1.8250000 0.230311 1.8277778 0.229244 1.8305556 0.228178 1.8333333 0.225689 1.8361111 0.221778 1.8388889 0.219644 1.8416667 0.217867 1.8444444 0.217156 1.8472222 0.216089 1.8500000 0.217511 1.8527778 0.220711 1.8555556 0.225333 1.8583333 0.234222 1.8611111 0.245600 1.8638889 0.258400 1.8666667 0.274400 1.8694444 0.287200 1.8722222 0.297511 1.8750000 0.306044 1.8777778 0.312089 1.8805556 0.314933 1.8833333 0.318133 1.8861111 0.320622 1.8888889 0.322044 1.8916667 0.324533 1.8944444 0.327378 1.8972222 0.328800 1.9000000 0.328800 1.9027778 0.329511 1.9055556 0.329867 1.9083333 0.330933 1.9111111 0.333067 1.9138889 0.333067 1.9166667 0.333067 1.9194444 0.333067 1.9222222 0.332711 1.9250000 0.333778 1.9277778 0.334844 1.9305556 0.335911 1.9333333 0.335200 1.9361111 0.335200 1.9388889 0.334844 1.9416667 0.336622 1.9444444 0.337333 1.9472222 0.338756 1.9500000 0.338400 1.9527778 0.338400 1.9555556 0.338044 1.9583333 0.340178 1.9611111 0.341956 1.9638889 0.342667 1.9666667 0.344089 1.9694444 0.343022 1.9722222 0.343733 1.9750000 0.345511 1.9777778 0.347289 1.9805556 0.348711 1.9833333 0.348711 1.9861111 0.348711 1.9888889 0.349422 1.9916667 0.350844 1.9944444 0.352978 1.9972222 0.354044 2.0000000 0.354044 2.0027778 0.354044 2.0055556 0.353689 2.0083333 0.355111 2.0111111 0.356889 2.0138889 0.357956 2.0166667 0.357956 2.0194444 0.357956 2.0222222 0.357244 2.0250000 0.359022 2.0277778 0.360089 2.0305556 0.360800 2.0333333 0.359733 2.0358889 0.300000 2.0361111 0.358311 2.0388889 0.357956 2.0416667 0.357244 2.0444444 0.357600 2.0472222 0.357244 2.0500000 0.355467 2.0527778 0.352978 2.0555556 0.352267 2.0583333 0.351200 2.0611111 0.350489 2.0638889 0.349067 2.0666667 0.346933 2.0694444 0.343378 2.0722222 0.340889 2.0750000 0.339822 2.0777778 0.339467 2.0805556 0.338756 2.0833333 0.335200 2.0861111 0.333422 2.0888889 0.331289 2.0916667 0.329156 2.0944444 0.329156 2.0972222 0.328444 2.1000000 0.326667 2.1027778 0.325600 2.1055556 0.324178 2.1083333 0.323467 2.1111111 0.324889 2.1138889 0.323111 2.1166667 0.322400 2.1194444 0.321689 2.1222222 0.320622 2.1250000 0.321333 2.1277778 0.322400 2.1305556 0.322400 2.1333333 0.321689 2.1361111 0.320267 2.1388889 0.320267 2.1416667 0.320978 2.1444444 0.321689 2.1472222 0.321333 2.1500000 0.321333 2.1527778 0.320267 2.1555556 0.319911 2.1583333 0.320267 2.1585556 0.300000 2.1611111 0.321689 2.1638889 0.321333 2.1666667 0.320267 2.1694444 0.318844 2.1722222 0.318133 2.1750000 0.320267 2.1777778 0.320622 2.1805556 0.320978 2.1833333 0.320978 2.1861111 0.319911 2.1888889 0.319556 2.1916667 0.320267 2.1944444 0.321333 2.1972222 0.320622 2.2000000 0.320267 2.2027778 0.318844 2.2055556 0.319556 2.2083333 0.319556 2.2111111 0.321333 2.2138889 0.321333 2.2166667 0.322044 2.2194444 0.320978 2.2222222 0.320267 2.2250000 0.320622 2.2277778 0.322400 2.2305556 0.320978 2.2333333 0.318844 2.2361111 0.317422 2.2388889 0.316000 2.2416667 0.314933 2.2444444 0.313156 2.2472222 0.311022 2.2500000 0.306400 2.2527778 0.301778 2.2555556 0.296089 2.2583333 0.289689 2.2611111 0.282578 2.2638889 0.276178 2.2666667 0.269778 2.2694444 0.261956 2.2722222 0.254844 2.2750000 0.247378 2.2777778 0.243111 2.2805556 0.240267 2.2833333 0.238489 2.2861111 0.237067 2.2888889 0.236000 2.2916667 0.237778 2.2944444 0.241689 2.2972222 0.246667 2.3000000 0.250933 2.3027778 0.255556 2.3055556 0.262667 2.3083333 0.271200 2.3111111 0.280800 2.3138889 0.286133 2.3166667 0.289689 2.3194444 0.291822 2.3222222 0.293956 2.3250000 0.298222 2.3277778 0.300356 2.3305556 0.301778 2.3333333 0.301778 2.3361111 0.301422 2.3388889 0.299644 2.3416667 0.300000 2.3444444 0.301778 2.3472222 0.304978 2.3500000 0.308533 2.3527778 0.313511 2.3555556 0.317067 2.3583333 0.321333 2.3611111 0.323467 2.3638889 0.325956 2.3666667 0.327022 2.3694444 0.327378 2.3722222 0.328444 2.3750000 0.329511 2.3777778 0.330222 2.3805556 0.331644 2.3833333 0.332000 2.3861111 0.333778 2.3888889 0.335200 2.3916667 0.334133 2.3944444 0.335911 2.3972222 0.336978 2.4000000 0.336978 2.4027778 0.336267 2.4055556 0.337333 2.4083333 0.338044 2.4111111 0.338756 2.4138889 0.339111 2.4166667 0.339111 2.4194444 0.338756 2.4222222 0.339467 2.4250000 0.339822 2.4277778 0.341244 2.4305556 0.342311 2.4333333 0.343378 2.4361111 0.343022 2.4388889 0.342667 2.4416667 0.343378 2.4444444 0.345156 2.4472222 0.345156 2.4500000 0.347289 2.4527778 0.345511 2.4555556 0.346222 2.4583333 0.347289 2.4611111 0.348356 2.4638889 0.349422 2.4666667 0.349778 2.4694444 0.348711 2.4722222 0.349067 2.4750000 0.349422 2.4777778 0.349422 2.4805556 0.349422 2.4833333 0.349422 2.4861111 0.347644 2.4888889 0.346222 2.4916667 0.345511 2.4944444 0.345511 2.4972222 0.344444 2.5000000 0.344089 2.5027778 0.342667 2.5055556 0.341956 2.5083333 0.340533 2.5111111 0.340178 2.5138889 0.339467 2.5166667 0.337333 2.5194444 0.334844 2.5222222 0.334489 2.5250000 0.333067 2.5277778 0.332711 2.5305556 0.330578 2.5333333 0.329156 2.5361111 0.327378 2.5388889 0.325600 2.5416667 0.325600 2.5444444 0.325600 2.5472222 0.324889 2.5500000 0.324178 2.5527778 0.322044 2.5555556 0.321333 2.5583333 0.320622 2.5611111 0.321333 2.5638889 0.321689 2.5666667 0.320267 2.5694444 0.319556 2.5722222 0.319200 2.5750000 0.319200 2.5777778 0.319911 2.5805556 0.320622 2.5833333 0.320622 2.5861111 0.319911 2.5918889 0.300000 2.9470000 0.300000 2.9500000 0.311378 2.9527778 0.311378 2.9555556 0.311022 2.9583333 0.312800 2.9611111 0.313511 2.9638889 0.311733 2.9666667 0.310667 2.9694444 0.310311 2.9722222 0.311733 2.9750000 0.312089 2.9777778 0.312800 2.9805556 0.312444 2.9833333 0.311378 2.9861111 0.311022 2.9888889 0.311733 2.9916667 0.311733 2.9944444 0.312444 2.9972222 0.312089 3.0000000 0.310667 3.0027778 0.310311 3.0055556 0.311378 3.0083333 0.312089 3.0111111 0.312089 3.0138889 0.312089 3.0166667 0.311022 3.0194444 0.309956 3.0222222 0.311378 3.0250000 0.313156 3.0277778 0.312800 3.0305556 0.312089 3.0333333 0.311378 3.0361111 0.311733 3.0388889 0.312089 3.0416667 0.313867 3.0444444 0.314222 3.0472222 0.313867 3.0500000 0.312444 3.0527778 0.312089 3.0555556 0.312089 3.0583333 0.311022 3.0611111 0.311022 3.0638889 0.308889 3.0666667 0.307111 3.0694444 0.306400 3.0722222 0.306756 3.0750000 0.307467 3.0777778 0.308533 3.0805556 0.307467 3.0833333 0.307467 3.0861111 0.306044 3.0888889 0.305689 3.0916667 0.307111 3.0944444 0.306756 3.0972222 0.306400 3.1000000 0.304622 3.1027778 0.305333 3.1055556 0.306400 3.1083333 0.308533 3.1111111 0.309600 3.1138889 0.309600 3.1166667 0.307467 3.1194444 0.307467 3.1222222 0.307111 3.1250000 0.308533 3.1277778 0.308889 3.1305556 0.308889 3.1333333 0.307467 3.1361111 0.306756 3.1388889 0.307467 3.1416667 0.308533 3.1444444 0.307822 3.1472222 0.307822 3.1500000 0.307467 3.1527778 0.307111 3.1555556 0.307467 3.1583333 0.307822 3.1611111 0.308533 3.1638889 0.307111 3.1666667 0.304978 3.1694444 0.304622 3.1722222 0.304622 3.1750000 0.305333 3.1777778 0.306044 3.1805556 0.303200 3.1833333 0.297867 3.1861111 0.292178 3.1888889 0.289689 3.1916667 0.290756 3.1944444 0.291467 3.1972222 0.291822 3.2000000 0.290756 3.2027778 0.293244 3.2055556 0.298222 3.2083333 0.302844 3.2111111 0.306756 3.2138889 0.306044 3.2166667 0.302844 3.2194444 0.300711 3.2222222 0.299289 3.2250000 0.300000 3.2277778 0.301778 3.2305556 0.304267 3.2333333 0.305689 3.2361111 0.306044 3.2388889 0.306756 3.2416667 0.307822 3.2444444 0.308889 3.2472222 0.307822 3.2500000 0.307822 3.2527778 0.307822 3.2555556 0.307467 3.2583333 0.308533 3.2611111 0.308533 3.2638889 0.308889 3.2666667 0.308178 3.2694444 0.307822 3.2722222 0.306756 3.2750000 0.307822 3.2777778 0.308178 3.2805556 0.307822 3.2833333 0.307111 3.2861111 0.305333 3.2888889 0.306756 3.2916667 0.308178 3.2944444 0.308178 3.2972222 0.307467 3.3000000 0.306044 3.3027778 0.305689 3.3055556 0.306400 3.3083333 0.306756 3.3111111 0.307467 3.3138889 0.307467 3.3166667 0.306400 3.3194444 0.304622 3.3222222 0.305333 3.3250000 0.306044 3.3277778 0.306044 3.3305556 0.304978 3.3333333 0.304267 3.3361111 0.303200 3.3388889 0.303556 3.3416667 0.304267 3.3444444 0.304267 3.3472222 0.303200 3.3500000 0.302489 3.3527778 0.300711 3.3555556 0.301422 3.3583333 0.302489 3.3611111 0.302489 3.3638889 0.301067 3.3666667 0.299644 3.3694444 0.298933 3.3722222 0.298222 3.3750000 0.297867 3.3777778 0.298578 3.3805556 0.297156 3.3833333 0.295378 3.3861111 0.294667 3.3888889 0.293956 3.3916667 0.294311 3.3944444 0.293600 3.3972222 0.292533 3.4000000 0.290400 3.4027778 0.289689 3.4055556 0.289689 3.4083333 0.289333 3.4111111 0.288978 3.4138889 0.288267 3.4166667 0.286489 3.4194444 0.287200 3.4222222 0.285778 3.4250000 0.286844 3.4277778 0.287200 3.4305556 0.286489 3.4333333 0.285422 3.4361111 0.284711 3.4388889 0.285067 3.4416667 0.285422 3.4444444 0.287200 3.4472222 0.286489 3.4500000 0.286844 3.4527778 0.286489 3.4555556 0.287556 3.4583333 0.288978 3.4611111 0.290400 3.4638889 0.290756 3.4666667 0.291111 3.4694444 0.291467 3.4722222 0.293600 3.4750000 0.295733 3.4777778 0.297156 3.4805556 0.298222 3.4833333 0.298222 3.4861111 0.298933 3.4888889 0.300711 3.4916667 0.301778 3.4942222 0.300000 3.4944444 0.302844 3.4972222 0.304267 3.5000000 0.303556 3.5027778 0.303556 3.5030000 0.300000 3.5055556 0.306044 3.5083333 0.306756 3.5111111 0.307111 3.5138889 0.307111 3.5166667 0.307111 3.5194444 0.306400 3.5222222 0.307111 3.5250000 0.308178 3.5277778 0.308533 3.5305556 0.308889 3.5333333 0.308178 3.5361111 0.308178 3.5388889 0.308533 3.5416667 0.309244 3.5444444 0.309244 3.5472222 0.309244 3.5500000 0.308889 3.5527778 0.308178 3.5555556 0.308178 3.5583333 0.308889 3.5611111 0.308889 3.5638889 0.308533 3.5666667 0.307822 3.5694444 0.306756 3.5722222 0.306756 3.5750000 0.307467 3.5777778 0.308178 3.5805556 0.307467 3.5833333 0.305689 3.5861111 0.305333 3.5888889 0.306044 3.5916667 0.307467 3.5944444 0.307111 3.5972222 0.307111 3.6000000 0.306044 3.6027778 0.304978 3.6055556 0.305333 3.6083333 0.306044 3.6111111 0.306756 3.6138889 0.306400 3.6166667 0.306400 3.6194444 0.305333 3.6222222 0.305689 3.6250000 0.306756 3.6277778 0.306756 3.6305556 0.307467 3.6333333 0.306400 3.6361111 0.306400 3.6388889 0.307467 3.6416667 0.309244 3.6444444 0.308533 3.6472222 0.308533 3.6500000 0.307467 3.6527778 0.307467 3.6555556 0.307822 3.6583333 0.309244 3.6611111 0.308889 3.6638889 0.309244 3.6666667 0.307111 3.6694444 0.306400 3.6722222 0.305689 3.6750000 0.305689 3.6777778 0.305333 3.6805556 0.303911 3.6833333 0.300711 3.6861111 0.298578 3.6888889 0.295733 3.6916667 0.293600 3.6944444 0.288622 3.6972222 0.282933 3.7000000 0.275467 3.7027778 0.268000 3.7055556 0.261600 3.7083333 0.257333 3.7111111 0.253422 3.7138889 0.249156 3.7166667 0.244889 3.7194444 0.240622 3.7222222 0.238489 3.7250000 0.236711 3.7277778 0.234578 3.7305556 0.232089 3.7333333 0.229956 3.7361111 0.226400 3.7388889 0.224267 3.7416667 0.224978 3.7444444 0.225689 3.7472222 0.228533 3.7500000 0.231022 3.7527778 0.235289 3.7555556 0.240978 3.7583333 0.246311 3.7611111 0.252711 3.7638889 0.259111 3.7666667 0.263733 3.7694444 0.269067 3.7722222 0.274756 3.7750000 0.279022 3.7777778 0.280800 3.7805556 0.281867 3.7833333 0.281511 3.7861111 0.281511 3.7888889 0.282222 3.7916667 0.283289 3.7944444 0.283644 3.7972222 0.283644 3.8000000 0.282933 3.8027778 0.283289 3.8055556 0.286489 3.8083333 0.290756 3.8111111 0.296444 3.8138889 0.302133 3.8166667 0.306756 3.8194444 0.310667 3.8222222 0.314222 3.8250000 0.317778 3.8277778 0.319200 3.8305556 0.319911 3.8333333 0.319556 3.8361111 0.320622 3.8388889 0.321333 3.8416667 0.322756 3.8444444 0.323822 3.8472222 0.324533 3.8500000 0.324533 3.8527778 0.324178 3.8555556 0.325956 3.8583333 0.327378 3.8611111 0.328089 3.8638889 0.327378 3.8666667 0.327733 3.8694444 0.328444 3.8722222 0.328800 3.8750000 0.331289 3.8777778 0.332356 3.8805556 0.333778 3.8833333 0.334133 3.8861111 0.334133 3.8888889 0.336622 3.8916667 0.337689 3.8944444 0.339822 3.8972222 0.339822 3.9000000 0.339467 3.9027778 0.340178 3.9055556 0.343022 3.9083333 0.344089 3.9111111 0.346578 3.9138889 0.346933 3.9166667 0.346222 3.9194444 0.346578 3.9222222 0.348000 3.9250000 0.349067 3.9277778 0.350844 3.9305556 0.350133 3.9333333 0.350489 3.9361111 0.350844 3.9388889 0.350844 3.9416667 0.351556 3.9444444 0.352267 3.9472222 0.351200 3.9500000 0.349778 3.9527778 0.350133 3.9555556 0.349422 3.9583333 0.350133 3.9611111 0.349778 3.9638889 0.347644 3.9666667 0.346222 3.9694444 0.344444 3.9722222 0.344800 3.9750000 0.343378 3.9777778 0.343378 3.9805556 0.341244 3.9833333 0.338756 3.9861111 0.335911 3.9888889 0.335200 3.9916667 0.333067 3.9944444 0.331289 3.9972222 0.329511 4.0000000 0.326667 4.0027778 0.323822 4.0055556 0.323111 4.0083333 0.322400 4.0111111 0.320267 4.0138889 0.318133 4.0166667 0.317067 4.0194444 0.314578 4.0222222 0.314222 4.0250000 0.314578 4.0277778 0.313867 4.0305556 0.313511 4.0333333 0.310311 4.0361111 0.309956 4.0388889 0.309600 4.0416667 0.309956 4.0444444 0.309956 4.0502222 0.300000 4.0525556 0.300000 4.0555556 0.307822 4.0583333 0.309244 4.0611111 0.308178 4.0638889 0.307467 4.0666667 0.307111 4.0694444 0.307111 4.0722222 0.307822 4.0750000 0.308178 4.0777778 0.309244 4.0805556 0.307822 4.0833333 0.307822 4.0861111 0.306756 4.0888889 0.307467 4.0916667 0.308533 4.0944444 0.308889 4.0972222 0.309244 4.1000000 0.307467 4.1027778 0.307822 4.1055556 0.307822 4.1083333 0.308889 4.1111111 0.308889 4.1138889 0.308178 4.1166667 0.308533 4.1194444 0.307822 4.1222222 0.308533 4.1250000 0.308889 4.1277778 0.309600 4.1305556 0.309244 4.1333333 0.308178 4.1361111 0.307822 4.1388889 0.308889 4.1416667 0.309956 4.1444444 0.309956 4.1472222 0.309244 4.1500000 0.308533 4.1527778 0.307467 4.1555556 0.308889 4.1583333 0.309600 4.1611111 0.309244 4.1638889 0.309244 4.1666667 0.308533 4.1694444 0.308178 4.1722222 0.308178 4.1750000 0.308889 4.1777778 0.308889 4.1805556 0.308533 4.1833333 0.307467 4.1861111 0.306400 4.1888889 0.307111 4.1916667 0.308889 4.1944444 0.308533 4.1972222 0.308178 4.2000000 0.307111 4.2027778 0.307111 4.2055556 0.307467 4.2083333 0.308533 4.2111111 0.308889 4.2138889 0.308889 4.2166667 0.307822 4.2194444 0.308178 4.2222222 0.309244 4.2250000 0.310667 4.2277778 0.309956 4.2305556 0.309244 4.2333333 0.308533 4.2361111 0.306756 4.2388889 0.306400 4.2416667 0.307111 4.2444444 0.304622 4.2472222 0.301778 4.2500000 0.298933 4.2527778 0.296800 4.2555556 0.295022 4.2583333 0.292889 4.2611111 0.290044 4.2638889 0.283289 4.2666667 0.274756 4.2694444 0.268711 4.2722222 0.263022 4.2750000 0.258400 4.2777778 0.253778 4.2805556 0.248444 4.2833333 0.243467 4.2861111 0.238489 4.2888889 0.233511 4.2916667 0.231733 4.2944444 0.229600 4.2972222 0.227822 4.3000000 0.224978 4.3027778 0.222489 4.3055556 0.222844 4.3083333 0.223911 4.3111111 0.226044 4.3138889 0.228889 4.3166667 0.232089 4.3194444 0.237067 4.3222222 0.242756 4.3250000 0.248800 4.3277778 0.254489 4.3305556 0.261956 4.3333333 0.268356 4.3361111 0.272267 4.3388889 0.277600 4.3416667 0.279733 4.3444444 0.281867 4.3472222 0.283289 4.3500000 0.283289 4.3527778 0.284711 4.3555556 0.287556 4.3583333 0.288978 4.3611111 0.289333 4.3638889 0.289333 4.3666667 0.289689 4.3694444 0.291467 4.3722222 0.296089 4.3750000 0.301778 4.3777778 0.306400 4.3805556 0.311378 4.3833333 0.314578 4.3861111 0.316000 4.3888889 0.318489 4.3916667 0.320978 4.3944444 0.322400 4.3972222 0.323111 4.4000000 0.322400 4.4027778 0.323467 4.4055556 0.324533 4.4083333 0.326311 4.4111111 0.327022 4.4138889 0.325956 4.4166667 0.326667 4.4194444 0.326667 4.4222222 0.328444 4.4250000 0.329867 4.4277778 0.330933 4.4305556 0.330933 4.4333333 0.331644 4.4361111 0.331289 4.4388889 0.333422 4.4416667 0.334489 4.4444444 0.335556 4.4472222 0.336267 4.4500000 0.335556 4.4527778 0.335911 4.4555556 0.337689 4.4583333 0.339467 4.4611111 0.340889 4.4638889 0.341600 4.4666667 0.342311 4.4694444 0.341600 4.4722222 0.343733 4.4750000 0.345511 4.4777778 0.346933 4.4805556 0.346578 4.4833333 0.346933 4.4861111 0.346933 4.4888889 0.348356 4.4916667 0.350133 4.4944444 0.351200 4.4972222 0.350844 4.5000000 0.350844 4.5027778 0.351200 4.5055556 0.351556 4.5083333 0.351556 4.5111111 0.351911 4.5138889 0.352267 4.5166667 0.349778 4.5194444 0.349067 4.5222222 0.349067 4.5250000 0.350133 4.5277778 0.349778 4.5305556 0.348356 4.5333333 0.346578 4.5361111 0.345511 4.5388889 0.344444 4.5416667 0.342667 4.5444444 0.342667 4.5472222 0.340178 4.5500000 0.337689 4.5527778 0.334844 4.5555556 0.332711 4.5583333 0.330933 4.5611111 0.329511 4.5638889 0.327022 4.5666667 0.324533 4.5694444 0.322756 4.5722222 0.321689 4.5750000 0.320622 4.5777778 0.319200 4.5805556 0.317422 4.5833333 0.315289 4.5861111 0.313867 4.5888889 0.312800 4.5916667 0.313156 4.5944444 0.313156 4.5972222 0.311378 4.6000000 0.309956 4.6027778 0.308889 4.6085556 0.300000 4.8331111 0.300000 4.8361111 0.303911 4.8388889 0.304978 4.8416667 0.304978 4.8444444 0.304978 4.8472222 0.304978 4.8500000 0.303200 4.8527778 0.303200 4.8555556 0.303200 4.8583333 0.304267 4.8611111 0.304622 4.8638889 0.304622 4.8666667 0.303911 4.8694444 0.303911 4.8722222 0.304267 4.8750000 0.304622 4.8777778 0.304267 4.8805556 0.304978 4.8833333 0.303556 4.8861111 0.303556 4.8888889 0.304267 4.8916667 0.304267 4.8944444 0.304622 4.8972222 0.304267 4.9000000 0.303556 4.9027778 0.302844 4.9055556 0.303200 4.9083333 0.304622 4.9111111 0.305333 4.9138889 0.304978 4.9166667 0.304267 4.9194444 0.304978 4.9222222 0.306756 4.9250000 0.307467 4.9277778 0.308533 4.9305556 0.307822 4.9333333 0.307822 4.9361111 0.306756 4.9388889 0.307111 4.9416667 0.306756 4.9444444 0.306756 4.9472222 0.304622 4.9500000 0.302489 4.9527778 0.300711 4.9555556 0.300000 4.9583333 0.301067 4.9611111 0.301778 4.9638889 0.301067 4.9666667 0.300000 4.9694444 0.299644 4.9722222 0.300000 4.9750000 0.301067 4.9777778 0.301067 4.9805556 0.299644 4.9833333 0.299289 4.9861111 0.299644 4.9888889 0.301067 4.9916667 0.302489 4.9944444 0.302489 4.9972222 0.301422 5.0000000 0.301067 5.0027778 0.300356 5.0055556 0.301778 5.0083333 0.302133 5.0111111 0.302489 5.0138889 0.301422 5.0166667 0.301067 5.0194444 0.300000 5.0222222 0.300711 5.0250000 0.302133 5.0277778 0.301778 5.0305556 0.301067 5.0333333 0.301067 5.0361111 0.299644 5.0388889 0.300356 5.0416667 0.301422 5.0444444 0.301067 5.0472222 0.301067 5.0500000 0.299644 5.0527778 0.297867 5.0555556 0.297867 5.0583333 0.298933 5.0611111 0.299289 5.0638889 0.299289 5.0666667 0.296800 5.0694444 0.291822 5.0722222 0.287556 5.0750000 0.285778 5.0777778 0.286133 5.0805556 0.285422 5.0833333 0.282578 5.0861111 0.280800 5.0888889 0.283289 5.0916667 0.289333 5.0944444 0.293600 5.0972222 0.295022 5.1000000 0.294667 5.1027778 0.295022 5.1055556 0.294311 5.1083333 0.293956 5.1111111 0.293956 5.1138889 0.296089 5.1166667 0.297511 5.1194444 0.299289 5.1222222 0.300000 5.1250000 0.302844 5.1277778 0.302844 5.1305556 0.302489 5.1333333 0.302133 5.1361111 0.302489 5.1388889 0.302489 5.1416667 0.303911 5.1444444 0.303556 5.1472222 0.302844 5.1500000 0.303556 5.1527778 0.302489 5.1555556 0.303911 5.1583333 0.304267 5.1611111 0.304978 5.1638889 0.304978 5.1666667 0.303556 5.1694444 0.303200 5.1722222 0.302489 5.1750000 0.304267 5.1777778 0.304267 5.1805556 0.303911 5.1833333 0.303911 5.1861111 0.302844 5.1888889 0.303556 5.1916667 0.303200 5.1944444 0.303911 5.1972222 0.303911 5.2000000 0.302489 5.2027778 0.301422 5.2055556 0.301778 5.2083333 0.302844 5.2111111 0.302133 5.2138889 0.302133 5.2166667 0.300711 5.2194444 0.300711 5.2222222 0.300356 5.2250000 0.300356 5.2277778 0.300711 5.2305556 0.299644 5.2333333 0.298933 5.2361111 0.298222 5.2388889 0.298222 5.2416667 0.298222 5.2444444 0.297511 5.2472222 0.296089 5.2500000 0.295378 5.2527778 0.293956 5.2555556 0.293956 5.2583333 0.293600 5.2611111 0.293600 5.2638889 0.291467 5.2666667 0.289333 5.2694444 0.288267 5.2722222 0.288622 5.2750000 0.288622 5.2777778 0.288267 5.2805556 0.286489 5.2833333 0.285067 5.2861111 0.283644 5.2888889 0.283644 5.2916667 0.284356 5.2944444 0.284356 5.2972222 0.282222 5.3000000 0.281867 5.3027778 0.281867 5.3055556 0.282222 5.3083333 0.282578 5.3111111 0.283289 5.3138889 0.283644 5.3166667 0.282222 5.3194444 0.282222 5.3222222 0.284356 5.3250000 0.286489 5.3277778 0.287911 5.3305556 0.288978 5.3333333 0.290044 5.3361111 0.291111 5.3388889 0.293244 5.3416667 0.295378 5.3444444 0.296800 5.3472222 0.297156 5.3500000 0.297867 5.3527778 0.299644 5.3555556 0.300711 5.3583333 0.302489 5.3611111 0.303556 5.3638889 0.303911 5.3666667 0.303556 5.3694444 0.304267 5.3722222 0.305333 5.3750000 0.306400 5.3777778 0.307467 5.3805556 0.306044 5.3831111 0.300000 5.3833333 0.305333 5.3861111 0.305689 5.3888889 0.306400 5.3891111 0.300000 5.3916667 0.307822 5.3944444 0.307467 5.3972222 0.306756 5.4000000 0.306044 5.4027778 0.306044 5.4055556 0.305689 5.4083333 0.307111 5.4111111 0.307822 5.4138889 0.307111 5.4166667 0.307111 5.4194444 0.307111 5.4222222 0.307467 5.4250000 0.308533 5.4277778 0.307822 5.4305556 0.307822 5.4333333 0.307111 5.4361111 0.306400 5.4388889 0.306756 5.4416667 0.307111 5.4444444 0.307111 5.4472222 0.306400 5.4500000 0.306400 5.4527778 0.305333 5.4555556 0.305689 5.4583333 0.305689 5.4611111 0.307822 5.4638889 0.306044 5.4666667 0.304622 5.4694444 0.304622 5.4722222 0.305333 5.4750000 0.306044 5.4777778 0.305689 5.4805556 0.305333 5.4833333 0.304267 5.4861111 0.304978 5.4888889 0.304978 5.4916667 0.306400 5.4944444 0.307467 5.4972222 0.306044 5.5000000 0.305689 5.5027778 0.304978 5.5055556 0.305689 5.5083333 0.306756 5.5111111 0.307111 5.5138889 0.307467 5.5166667 0.307111 5.5194444 0.307111 5.5222222 0.308178 5.5250000 0.308889 5.5277778 0.309600 5.5305556 0.308889 5.5333333 0.308178 5.5361111 0.307467 5.5388889 0.307822 5.5416667 0.308178 5.5444444 0.307467 5.5472222 0.306756 5.5500000 0.304622 5.5527778 0.302489 5.5555556 0.303556 5.5583333 0.305689 5.5611111 0.305689 5.5638889 0.305333 5.5666667 0.304267 5.5694444 0.303556 5.5722222 0.303200 5.5750000 0.302844 5.5777778 0.301422 5.5805556 0.298222 5.5833333 0.294667 5.5861111 0.292889 5.5888889 0.291111 5.5916667 0.289333 5.5944444 0.285067 5.5972222 0.279022 5.6000000 0.271911 5.6027778 0.263733 5.6055556 0.256622 5.6083333 0.250933 5.6111111 0.245600 5.6138889 0.241333 5.6166667 0.235644 5.6194444 0.230311 5.6222222 0.225689 5.6250000 0.221778 5.6277778 0.218933 5.6305556 0.217156 5.6333333 0.215022 5.6361111 0.210756 5.6388889 0.209333 5.6416667 0.209333 5.6444444 0.210756 5.6472222 0.212889 5.6500000 0.216444 5.6527778 0.221067 5.6555556 0.227111 5.6583333 0.234222 5.6611111 0.242044 5.6638889 0.248089 5.6666667 0.252711 5.6694444 0.255556 5.6722222 0.258400 5.6750000 0.260889 5.6777778 0.263733 5.6805556 0.266578 5.6833333 0.270489 5.6861111 0.274044 5.6888889 0.277956 5.6916667 0.280800 5.6944444 0.283289 5.6972222 0.285778 5.7000000 0.290044 5.7027778 0.296089 5.7055556 0.302844 5.7083333 0.308889 5.7111111 0.312089 5.7138889 0.314933 5.7166667 0.316356 5.7194444 0.317778 5.7222222 0.319200 5.7250000 0.321333 5.7277778 0.322400 5.7305556 0.322756 5.7333333 0.323467 5.7361111 0.322756 5.7388889 0.323822 5.7416667 0.325600 5.7444444 0.326311 5.7472222 0.326311 5.7500000 0.325244 5.7527778 0.325600 5.7555556 0.328089 5.7583333 0.328800 5.7611111 0.329511 5.7638889 0.329867 5.7666667 0.330933 5.7694444 0.330222 5.7722222 0.332711 5.7750000 0.333422 5.7777778 0.334133 5.7805556 0.334133 5.7833333 0.334489 5.7861111 0.335200 5.7888889 0.336622 5.7916667 0.338400 5.7944444 0.339467 5.7972222 0.338756 5.8000000 0.339467 5.8027778 0.340533 5.8055556 0.341600 5.8083333 0.343733 5.8111111 0.344800 5.8138889 0.345511 5.8166667 0.344800 5.8194444 0.345511 5.8222222 0.347289 5.8250000 0.348356 5.8277778 0.348711 5.8305556 0.348711 5.8333333 0.348711 5.8361111 0.348711 5.8388889 0.349422 5.8416667 0.350844 5.8444444 0.351200 5.8472222 0.350844 5.8500000 0.348711 5.8527778 0.348000 5.8555556 0.348356 5.8583333 0.348711 5.8611111 0.347644 5.8638889 0.346933 5.8666667 0.344444 5.8694444 0.343378 5.8722222 0.342311 5.8750000 0.342311 5.8777778 0.340889 5.8805556 0.338756 5.8833333 0.335911 5.8861111 0.333422 5.8888889 0.332711 5.8916667 0.331644 5.8942222 0.300000 5.8944444 0.329511 5.8972222 0.327378 5.9000000 0.323822 5.9027778 0.321333 5.9055556 0.320622 5.9083333 0.320622 5.9111111 0.318489 5.9138889 0.316711 5.9166667 0.314578 5.9194444 0.312089 5.9222222 0.312089 5.9250000 0.312089 5.9277778 0.311022 5.9305556 0.309600 5.9333333 0.308889 5.9361111 0.308178 5.9388889 0.308178 5.9391111 0.300000 5.9416667 0.308178 5.9444444 0.308533 5.9472222 0.308889 5.9500000 0.307111 5.9527778 0.306400 5.9555556 0.306756 5.9583333 0.308533 5.9611111 0.308178 5.9638889 0.307467 5.9666667 0.307111 5.9694444 0.306400 5.9722222 0.306400 5.9750000 0.307467 5.9777778 0.308178 5.9805556 0.307467 5.9833333 0.305689 5.9861111 0.305333 5.9888889 0.306044 5.9916667 0.307111 5.9944444 0.307822 5.9972222 0.307111 6.0000000 0.306044 6.0027778 0.306044 6.0055556 0.306756 6.0083333 0.307822 6.0111111 0.308533 6.0138889 0.307111 6.0166667 0.307467 6.0194444 0.306400 6.0222222 0.307467 6.0250000 0.308889 6.0277778 0.308178 6.0305556 0.308178 6.0333333 0.307467 6.0361111 0.305689 6.0388889 0.306756 6.0416667 0.307822 6.0444444 0.307467 6.0472222 0.307111 6.0500000 0.306400 6.0527778 0.304622 6.0555556 0.307111 6.0583333 0.307467 6.0611111 0.306756 6.0638889 0.306756 6.0666667 0.306400 6.0694444 0.306756 6.0722222 0.307822 6.0750000 0.308178 6.0777778 0.308178 6.0805556 0.308533 6.0833333 0.305689 6.0861111 0.303911 6.0888889 0.304267 6.0916667 0.303556 6.0944444 0.301778 6.0972222 0.299289 6.1000000 0.296444 6.1027778 0.292533 6.1055556 0.289689 6.1083333 0.285778 6.1111111 0.280800 6.1138889 0.273333 6.1166667 0.266933 6.1194444 0.259822 6.1222222 0.255556 6.1250000 0.251289 6.1277778 0.246311 6.1305556 0.240622 6.1333333 0.233867 6.1361111 0.229600 6.1388889 0.227467 6.1416667 0.226400 6.1444444 0.225333 6.1472222 0.224267 6.1500000 0.222133 6.1527778 0.222489 6.1555556 0.225689 6.1583333 0.230311 6.1611111 0.234933 6.1638889 0.239556 6.1666667 0.243111 6.1694444 0.249156 6.1722222 0.256622 6.1750000 0.266222 6.1777778 0.272622 6.1805556 0.278311 6.1833333 0.281867 6.1861111 0.285067 6.1888889 0.286489 6.1916667 0.288622 6.1944444 0.290044 6.1972222 0.290756 6.2000000 0.290044 6.2027778 0.288978 6.2055556 0.286844 6.2083333 0.287200 6.2111111 0.288622 6.2138889 0.289333 6.2166667 0.291822 6.2194444 0.294667 6.2222222 0.301422 6.2250000 0.306400 6.2277778 0.309244 6.2305556 0.310667 6.2333333 0.311733 6.2361111 0.312089 6.2388889 0.314222 6.2416667 0.316000 6.2444444 0.317422 6.2472222 0.318489 6.2500000 0.318844 6.2527778 0.319911 6.2555556 0.320267 6.2583333 0.322044 6.2611111 0.322400 6.2638889 0.322044 6.2666667 0.322044 6.2694444 0.322756 6.2722222 0.323467 6.2750000 0.324889 6.2777778 0.325956 6.2805556 0.326667 6.2833333 0.325244 6.2861111 0.325600 6.2888889 0.326667 6.2916667 0.328089 6.2944444 0.328444 6.2972222 0.329156 6.3000000 0.329156 6.3027778 0.329156 6.3055556 0.330578 6.3083333 0.332356 6.3111111 0.332711 6.3138889 0.332711 6.3166667 0.333067 6.3194444 0.334133 6.3222222 0.334844 6.3250000 0.336267 6.3277778 0.336978 6.3305556 0.336622 6.3333333 0.335911 6.3361111 0.335556 6.3388889 0.336622 6.3416667 0.337333 6.3444444 0.337689 6.3472222 0.337333 6.3500000 0.336622 6.3527778 0.335911 6.3555556 0.335911 6.3583333 0.337333 6.3611111 0.336267 6.3638889 0.335911 6.3666667 0.334844 6.3694444 0.333422 6.3722222 0.333067 6.3750000 0.333422 6.3777778 0.332000 6.3805556 0.329511 6.3833333 0.328444 6.3861111 0.326667 6.3888889 0.325244 6.3916667 0.325244 6.3944444 0.323467 6.3972222 0.322044 6.4000000 0.319911 6.4027778 0.318133 6.4055556 0.317067 6.4083333 0.316000 6.4111111 0.315289 6.4138889 0.313156 6.4166667 0.312089 6.4194444 0.309600 6.4222222 0.309600 6.4250000 0.309600 6.4277778 0.309244 6.4305556 0.308178 6.4333333 0.305689 6.4361111 0.304978 6.4388889 0.305689 6.4416667 0.305689 6.4444444 0.305333 6.4502222 0.300000 6.7720000 0.300000 6.7750000 0.299289 6.7777778 0.298933 6.7805556 0.299644 6.7833333 0.297867 6.7861111 0.297156 6.7888889 0.298578 6.7916667 0.298933 6.7944444 0.299644 6.7972222 0.298933 6.8000000 0.297511 6.8027778 0.297511 6.8055556 0.297867 6.8083333 0.298933 6.8111111 0.298578 6.8138889 0.298578 6.8166667 0.297156 6.8194444 0.297511 6.8222222 0.297511 6.8250000 0.298222 6.8277778 0.298578 6.8305556 0.298222 6.8333333 0.297511 6.8361111 0.297511 6.8388889 0.297156 6.8416667 0.299644 6.8444444 0.298933 6.8472222 0.298222 6.8500000 0.297511 6.8527778 0.297156 6.8555556 0.298222 6.8583333 0.299644 6.8611111 0.299289 6.8638889 0.299289 6.8666667 0.297867 6.8694444 0.298933 6.8722222 0.299644 6.8750000 0.301067 6.8777778 0.301067 6.8805556 0.300711 6.8833333 0.300711 6.8861111 0.301067 6.8888889 0.301778 6.8916667 0.302133 6.8944444 0.300356 6.8972222 0.299644 6.9000000 0.298578 6.9027778 0.296800 6.9055556 0.296444 6.9083333 0.296444 6.9111111 0.296089 6.9138889 0.295378 6.9166667 0.293956 6.9194444 0.295022 6.9222222 0.295378 6.9250000 0.295378 6.9277778 0.295733 6.9305556 0.295378 6.9333333 0.294667 6.9361111 0.295733 6.9388889 0.296089 6.9416667 0.297867 6.9444444 0.297511 6.9472222 0.296800 6.9500000 0.296089 6.9527778 0.295733 6.9555556 0.295733 6.9583333 0.297156 6.9611111 0.297156 6.9638889 0.296800 6.9666667 0.295733 6.9694444 0.295733 6.9722222 0.296089 6.9750000 0.297156 6.9777778 0.296089 6.9805556 0.296444 6.9833333 0.295378 6.9861111 0.295022 6.9888889 0.296089 6.9916667 0.295022 6.9944444 0.295022 6.9972222 0.293244 7.0000000 0.293956 7.0027778 0.293244 7.0055556 0.291111 7.0083333 0.287200 7.0111111 0.281867 7.0138889 0.279378 7.0166667 0.279733 7.0194444 0.279022 7.0222222 0.279378 7.0250000 0.281867 7.0277778 0.284356 7.0305556 0.288622 7.0333333 0.290756 7.0361111 0.293956 7.0388889 0.294311 7.0416667 0.292533 7.0444444 0.290400 7.0472222 0.287911 7.0500000 0.288267 7.0527778 0.289333 7.0555556 0.292533 7.0583333 0.295378 7.0611111 0.296444 7.0638889 0.297156 7.0666667 0.296089 7.0694444 0.296089 7.0722222 0.296800 7.0750000 0.298222 7.0777778 0.297867 7.0805556 0.297156 7.0833333 0.297156 7.0861111 0.297511 7.0888889 0.297156 7.0916667 0.297511 7.0944444 0.297511 7.0972222 0.297156 7.1000000 0.296800 7.1027778 0.295733 7.1055556 0.297156 7.1083333 0.297156 7.1111111 0.296800 7.1138889 0.296800 7.1166667 0.296089 7.1194444 0.295733 7.1222222 0.295733 7.1250000 0.297867 7.1277778 0.296800 7.1305556 0.296444 7.1333333 0.295022 7.1361111 0.295022 7.1388889 0.295378 7.1416667 0.295733 7.1444444 0.296444 7.1472222 0.295378 7.1500000 0.294667 7.1527778 0.293600 7.1555556 0.293244 7.1583333 0.295022 7.1611111 0.293956 7.1638889 0.292889 7.1666667 0.292178 7.1694444 0.291822 7.1722222 0.292178 7.1750000 0.291822 7.1777778 0.292533 7.1805556 0.291467 7.1833333 0.290400 7.1861111 0.288622 7.1888889 0.289333 7.1916667 0.288978 7.1944444 0.287911 7.1972222 0.287200 7.2000000 0.285422 7.2027778 0.284356 7.2055556 0.285422 7.2083333 0.284711 7.2111111 0.283644 7.2138889 0.282578 7.2166667 0.281511 7.2194444 0.280444 7.2222222 0.281156 7.2250000 0.280800 7.2277778 0.281156 7.2305556 0.279733 7.2333333 0.278667 7.2361111 0.277600 7.2388889 0.278311 7.2416667 0.279022 7.2444444 0.279378 7.2472222 0.279022 7.2500000 0.277956 7.2527778 0.278311 7.2555556 0.279022 7.2583333 0.280444 7.2611111 0.281156 7.2638889 0.280444 7.2666667 0.281511 7.2694444 0.282578 7.2722222 0.283644 7.2750000 0.286133 7.2777778 0.287911 7.2805556 0.288622 7.2833333 0.288978 7.2861111 0.290044 7.2888889 0.292178 7.2916667 0.293956 7.2944444 0.295378 7.2970000 0.300000 7.2972222 0.296089 7.3000000 0.295733 7.3027778 0.295378 7.3055556 0.297511 7.3083333 0.299644 7.3111111 0.300000 7.3138889 0.301422 7.3166667 0.300000 7.3194444 0.300356 7.3222222 0.300711 7.3250000 0.302489 7.3277778 0.302489 7.3280000 0.300000 7.3305556 0.302844 7.3333333 0.302489 7.3361111 0.301778 7.3388889 0.302844 7.3416667 0.303556 7.3444444 0.303911 7.3472222 0.303200 7.3500000 0.302489 7.3527778 0.301778 7.3555556 0.302844 7.3583333 0.303200 7.3611111 0.303911 7.3638889 0.303200 7.3666667 0.301778 7.3694444 0.302133 7.3722222 0.302489 7.3750000 0.303200 7.3777778 0.303556 7.3805556 0.302844 7.3833333 0.301778 7.3861111 0.300711 7.3888889 0.301778 7.3916667 0.302489 7.3944444 0.302133 7.3972222 0.302133 7.4000000 0.300000 7.4027778 0.300000 7.4055556 0.300000 7.4083333 0.302133 7.4111111 0.302133 7.4138889 0.300711 7.4166667 0.299644 7.4194444 0.300356 7.4222222 0.301422 7.4250000 0.302489 7.4277778 0.302489 7.4305556 0.301778 7.4333333 0.302489 7.4361111 0.301422 7.4388889 0.303200 7.4416667 0.303556 7.4444444 0.303556 7.4472222 0.303200 7.4500000 0.302844 7.4527778 0.302133 7.4555556 0.301422 7.4583333 0.303200 7.4611111 0.302844 7.4638889 0.302489 7.4666667 0.301422 7.4694444 0.300000 7.4722222 0.300000 7.4750000 0.300711 7.4777778 0.301422 7.4805556 0.301067 7.4833333 0.300000 7.4861111 0.296800 7.4888889 0.295022 7.4916667 0.294311 7.4944444 0.291822 7.4972222 0.288622 7.5000000 0.286133 7.5027778 0.281511 7.5055556 0.274044 7.5083333 0.267644 7.5111111 0.260533 7.5138889 0.253422 7.5166667 0.248444 7.5194444 0.242400 7.5222222 0.239911 7.5250000 0.238489 7.5277778 0.232444 7.5305556 0.228533 7.5333333 0.226400 7.5361111 0.223911 7.5388889 0.222489 7.5416667 0.220711 7.5444444 0.218222 7.5472222 0.216089 7.5500000 0.217511 7.5527778 0.220356 7.5555556 0.225333 7.5583333 0.231733 7.5611111 0.236000 7.5638889 0.240978 7.5666667 0.245956 7.5694444 0.253422 7.5722222 0.260533 7.5750000 0.267289 7.5777778 0.270844 7.5805556 0.272267 7.5833333 0.272267 7.5861111 0.274044 7.5888889 0.275822 7.5916667 0.278667 7.5944444 0.280089 7.5972222 0.280089 7.6000000 0.279378 7.6027778 0.280089 7.6055556 0.282222 7.6083333 0.286489 7.6111111 0.291467 7.6138889 0.296444 7.6166667 0.302489 7.6194444 0.307111 7.6222222 0.311733 7.6250000 0.315289 7.6277778 0.317067 7.6305556 0.317422 7.6333333 0.317422 7.6361111 0.318844 7.6388889 0.319911 7.6416667 0.321689 7.6444444 0.322400 7.6472222 0.322756 7.6500000 0.322400 7.6527778 0.323467 7.6555556 0.324889 7.6583333 0.325956 7.6611111 0.326311 7.6638889 0.326667 7.6666667 0.327378 7.6694444 0.327733 7.6722222 0.328800 7.6750000 0.330933 7.6777778 0.332000 7.6805556 0.333067 7.6833333 0.332356 7.6861111 0.333422 7.6888889 0.335200 7.6916667 0.337333 7.6944444 0.338756 7.6972222 0.339467 7.7000000 0.339822 7.7027778 0.340889 7.7055556 0.342667 7.7083333 0.344444 7.7111111 0.345156 7.7138889 0.346222 7.7166667 0.346222 7.7194444 0.345867 7.7222222 0.348356 7.7250000 0.349422 7.7277778 0.350844 7.7305556 0.350489 7.7333333 0.350133 7.7361111 0.349778 7.7388889 0.350844 7.7416667 0.352978 7.7444444 0.351556 7.7472222 0.352267 7.7500000 0.349778 7.7527778 0.349067 7.7555556 0.349067 7.7583333 0.349778 7.7611111 0.348356 7.7638889 0.346222 7.7666667 0.345511 7.7694444 0.343378 7.7722222 0.341956 7.7750000 0.341600 7.7777778 0.340178 7.7805556 0.336978 7.7833333 0.334489 7.7861111 0.332356 7.7888889 0.331289 7.7916667 0.329867 7.7944444 0.327733 7.7972222 0.324533 7.8000000 0.322044 7.8027778 0.319911 7.8053333 0.300000 7.8055556 0.318489 7.8083333 0.317422 7.8111111 0.316711 7.8138889 0.314578 7.8166667 0.312089 7.8194444 0.311022 7.8222222 0.310667 7.8250000 0.312089 7.8277778 0.310311 7.8305556 0.309600 7.8333333 0.307822 7.8361111 0.307467 7.8388889 0.307467 7.8416667 0.308889 7.8444444 0.308889 7.8472222 0.308178 7.8500000 0.306756 7.8527778 0.305689 7.8530000 0.300000 7.8555556 0.307111 7.8583333 0.307822 7.8611111 0.307467 7.8638889 0.307111 7.8666667 0.306400 7.8694444 0.306044 7.8722222 0.306756 7.8750000 0.307111 7.8777778 0.307822 7.8805556 0.307822 7.8833333 0.306044 7.8861111 0.306756 7.8888889 0.307111 7.8916667 0.307467 7.8944444 0.307822 7.8972222 0.308178 7.9000000 0.306756 7.9027778 0.306756 7.9055556 0.308178 7.9083333 0.308178 7.9111111 0.308533 7.9138889 0.308533 7.9166667 0.307467 7.9194444 0.306400 7.9222222 0.307111 7.9250000 0.308533 7.9277778 0.308533 7.9305556 0.307111 7.9333333 0.306756 7.9361111 0.306400 7.9388889 0.307467 7.9416667 0.308178 7.9444444 0.307111 7.9472222 0.306756 7.9500000 0.305333 7.9527778 0.306044 7.9555556 0.306400 7.9583333 0.306756 7.9611111 0.306756 7.9638889 0.306756 7.9666667 0.306044 7.9694444 0.305689 7.9722222 0.306400 7.9750000 0.307111 7.9777778 0.307467 7.9805556 0.307111 7.9833333 0.306756 7.9861111 0.307467 7.9888889 0.306756 7.9916667 0.307822 7.9944444 0.306400 7.9972222 0.305333 8.0000000 0.302489 8.0027778 0.300711 8.0055556 0.299289 8.0083333 0.298222 8.0111111 0.295022 8.0138889 0.289333 8.0166667 0.284000 8.0194444 0.277244 8.0222222 0.269067 8.0250000 0.263378 8.0277778 0.257689 8.0305556 0.252711 8.0333333 0.247733 8.0361111 0.244178 8.0388889 0.239911 8.0416667 0.236000 8.0444444 0.231022 8.0472222 0.228889 8.0500000 0.227467 8.0527778 0.224978 8.0555556 0.223911 8.0583333 0.225333 8.0611111 0.227111 8.0638889 0.228178 8.0666667 0.231378 8.0694444 0.235289 8.0722222 0.242400 8.0750000 0.250222 8.0777778 0.258400 8.0805556 0.265156 8.0833333 0.271200 8.0861111 0.274400 8.0888889 0.277244 8.0916667 0.280444 8.0944444 0.281156 8.0972222 0.284000 8.1000000 0.284711 8.1027778 0.286489 8.1055556 0.287911 8.1083333 0.288622 8.1111111 0.289333 8.1138889 0.288267 8.1166667 0.289689 8.1194444 0.293244 8.1222222 0.297867 8.1250000 0.303911 8.1277778 0.309600 8.1305556 0.313156 8.1333333 0.314222 8.1361111 0.316711 8.1388889 0.318844 8.1416667 0.319911 8.1444444 0.320978 8.1472222 0.321333 8.1500000 0.320978 8.1527778 0.321333 8.1555556 0.323467 8.1583333 0.323822 8.1611111 0.325956 8.1638889 0.326311 8.1666667 0.325600 8.1694444 0.325600 8.1722222 0.327378 8.1750000 0.328800 8.1777778 0.329511 8.1805556 0.329511 8.1833333 0.329511 8.1861111 0.331289 8.1888889 0.333067 8.1916667 0.334133 8.1944444 0.335200 8.1972222 0.335911 8.2000000 0.335911 8.2027778 0.335556 8.2055556 0.338044 8.2083333 0.340533 8.2111111 0.340889 8.2138889 0.341956 8.2166667 0.342311 8.2194444 0.342667 8.2222222 0.344444 8.2250000 0.346222 8.2277778 0.346578 8.2305556 0.347289 8.2333333 0.346222 8.2361111 0.346933 8.2388889 0.347644 8.2416667 0.348356 8.2444444 0.348356 8.2472222 0.347289 8.2500000 0.345511 8.2527778 0.344444 8.2555556 0.343378 8.2583333 0.343022 8.2611111 0.341956 8.2638889 0.339111 8.2666667 0.335911 8.2694444 0.333778 8.2722222 0.331644 8.2750000 0.329511 8.2777778 0.328444 8.2805556 0.325600 8.2833333 0.322756 8.2861111 0.320267 8.2888889 0.319556 8.2916667 0.317778 8.2944444 0.317067 8.2972222 0.314933 8.3000000 0.312444 8.3027778 0.311378 8.3055556 0.310667 8.3083333 0.310667 8.3111111 0.310311 8.3138889 0.309956 8.3166667 0.307822 8.3194444 0.307467 8.3222222 0.307467 8.3250000 0.308533 8.3277778 0.308533 8.3305556 0.308533 8.3333333 0.306044 8.3361111 0.306044 8.3388889 0.306756 8.3416667 0.308178 8.3444444 0.307467 8.3472222 0.306756 8.3500000 0.306400 8.3527778 0.307111 8.3555556 0.306756 8.3613333 0.300000 8.5581111 0.300000 8.5611111 0.304267 8.5638889 0.303556 8.5666667 0.302844 8.5694444 0.302489 8.5722222 0.302844 8.5750000 0.304267 8.5777778 0.303556 8.5805556 0.303200 8.5833333 0.301778 8.5861111 0.302844 8.5888889 0.303556 8.5916667 0.304622 8.5944444 0.304267 8.5972222 0.303911 8.6000000 0.302844 8.6027778 0.302489 8.6055556 0.303200 8.6083333 0.303911 8.6111111 0.304267 8.6138889 0.303200 8.6166667 0.302133 8.6194444 0.302489 8.6222222 0.302844 8.6250000 0.304267 8.6277778 0.303556 8.6305556 0.303200 8.6333333 0.302844 8.6361111 0.302844 8.6388889 0.303200 8.6416667 0.303556 8.6444444 0.303911 8.6472222 0.304622 8.6500000 0.304978 8.6527778 0.304978 8.6555556 0.305689 8.6583333 0.306400 8.6611111 0.307467 8.6638889 0.306400 8.6666667 0.305689 8.6694444 0.304622 8.6722222 0.303556 8.6750000 0.303911 8.6777778 0.302133 8.6805556 0.300356 8.6833333 0.299289 8.6861111 0.298222 8.6888889 0.299289 8.6916667 0.299289 8.6944444 0.299644 8.6972222 0.299644 8.7000000 0.298222 8.7027778 0.296800 8.7055556 0.297511 8.7083333 0.299289 8.7111111 0.300356 8.7138889 0.300356 8.7166667 0.299644 8.7194444 0.300711 8.7222222 0.299644 8.7250000 0.301422 8.7277778 0.301422 8.7305556 0.300000 8.7333333 0.299644 8.7361111 0.299644 8.7388889 0.299644 8.7416667 0.301067 8.7444444 0.300711 8.7472222 0.300356 8.7500000 0.299644 8.7527778 0.299289 8.7555556 0.299644 8.7583333 0.300000 8.7611111 0.300356 8.7638889 0.299289 8.7666667 0.298933 8.7694444 0.298578 8.7722222 0.299289 8.7750000 0.298222 8.7777778 0.298222 8.7805556 0.297511 8.7833333 0.296800 8.7861111 0.297156 8.7888889 0.296444 8.7916667 0.292533 8.7944444 0.286489 8.7972222 0.284000 8.8000000 0.282222 8.8027778 0.282578 8.8055556 0.281867 8.8083333 0.281156 8.8111111 0.282222 8.8138889 0.286489 8.8166667 0.290044 8.8194444 0.291111 8.8222222 0.292889 8.8250000 0.294311 8.8277778 0.294311 8.8305556 0.291822 8.8333333 0.290400 8.8361111 0.291467 8.8388889 0.293244 8.8416667 0.296444 8.8444444 0.298222 8.8472222 0.298578 8.8500000 0.298578 8.8527778 0.299289 8.8555556 0.300356 8.8583333 0.301422 8.8611111 0.300711 8.8638889 0.300356 8.8666667 0.300000 8.8694444 0.299644 8.8722222 0.301067 8.8750000 0.302133 8.8777778 0.301778 8.8805556 0.301422 8.8833333 0.300356 8.8861111 0.300711 8.8888889 0.301067 8.8916667 0.301422 8.8944444 0.301778 8.8972222 0.301422 8.9000000 0.300000 8.9027778 0.300000 8.9055556 0.300356 8.9083333 0.301778 8.9111111 0.301067 8.9138889 0.300356 8.9166667 0.299289 8.9194444 0.300711 8.9222222 0.300711 8.9250000 0.302133 8.9277778 0.300711 8.9305556 0.299644 8.9333333 0.298933 8.9361111 0.298933 8.9388889 0.298933 8.9416667 0.299644 8.9444444 0.300356 8.9472222 0.298933 8.9500000 0.297511 8.9527778 0.297156 8.9555556 0.297867 8.9583333 0.297867 8.9611111 0.297511 8.9638889 0.296444 8.9666667 0.295733 8.9694444 0.295378 8.9722222 0.296089 8.9750000 0.296089 8.9777778 0.295378 8.9805556 0.293956 8.9833333 0.292533 8.9861111 0.291467 8.9888889 0.292178 8.9916667 0.292533 8.9944444 0.292178 8.9972222 0.290400 9.0000000 0.288622 9.0027778 0.287911 9.0055556 0.287911 9.0083333 0.287556 9.0111111 0.286844 9.0138889 0.285067 9.0166667 0.283289 9.0194444 0.282933 9.0222222 0.282933 9.0250000 0.283644 9.0277778 0.282578 9.0305556 0.281156 9.0333333 0.279733 9.0361111 0.279378 9.0388889 0.279733 9.0416667 0.281156 9.0444444 0.280444 9.0472222 0.279733 9.0500000 0.277956 9.0527778 0.278667 9.0555556 0.279378 9.0583333 0.280444 9.0611111 0.281156 9.0638889 0.281511 9.0666667 0.280444 9.0694444 0.281156 9.0722222 0.283289 9.0750000 0.285778 9.0777778 0.286489 9.0805556 0.287200 9.0833333 0.287556 9.0861111 0.290044 9.0888889 0.292533 9.0916667 0.294311 9.0944444 0.296444 9.0972222 0.296444 9.1000000 0.297156 9.1027778 0.297511 9.1055556 0.298933 9.1083333 0.300356 9.1141111 0.300000 9.1414444 0.300000 9.1444444 0.304622 9.1472222 0.305333 9.1500000 0.304622 9.1527778 0.303200 9.1555556 0.304267 9.1583333 0.304978 9.1611111 0.305689 9.1638889 0.304978 9.1666667 0.304267 9.1694444 0.303911 9.1722222 0.303911 9.1750000 0.305689 9.1777778 0.304622 9.1805556 0.304622 9.1833333 0.303911 9.1861111 0.303556 9.1888889 0.303911 9.1916667 0.304622 9.1944444 0.305333 9.1972222 0.303556 9.2000000 0.303200 9.2027778 0.302489 9.2055556 0.303556 9.2083333 0.304267 9.2111111 0.303911 9.2138889 0.303911 9.2166667 0.302133 9.2194444 0.301778 9.2222222 0.301778 9.2250000 0.302133 9.2277778 0.302133 9.2305556 0.301778 9.2333333 0.300711 9.2361111 0.301422 9.2388889 0.302133 9.2416667 0.301778 9.2444444 0.302844 9.2472222 0.302489 9.2500000 0.301067 9.2527778 0.301067 9.2555556 0.302844 9.2583333 0.302489 9.2611111 0.302844 9.2638889 0.302844 9.2666667 0.302489 9.2694444 0.301778 9.2722222 0.303200 9.2750000 0.304622 9.2777778 0.305333 9.2805556 0.305333 9.2833333 0.304267 9.2861111 0.303911 9.2888889 0.305333 9.2916667 0.305333 9.2944444 0.304978 9.2972222 0.303911 9.3000000 0.302844 9.3027778 0.302489 9.3055556 0.302133 9.3083333 0.303200 9.3111111 0.302489 9.3138889 0.301778 9.3166667 0.301422 9.3194444 0.301067 9.3222222 0.301067 9.3250000 0.301422 9.3277778 0.301778 9.3305556 0.298222 9.3333333 0.295733 9.3361111 0.293956 9.3388889 0.292178 9.3416667 0.291111 9.3444444 0.287911 9.3472222 0.284000 9.3500000 0.279022 9.3527778 0.271200 9.3555556 0.263733 9.3583333 0.256978 9.3611111 0.251289 9.3638889 0.244889 9.3666667 0.240978 9.3694444 0.237067 9.3722222 0.234222 9.3750000 0.231378 9.3777778 0.226400 9.3805556 0.222844 9.3833333 0.220000 9.3861111 0.219289 9.3888889 0.218578 9.3916667 0.216800 9.3944444 0.215022 9.3972222 0.213600 9.4000000 0.213244 9.4027778 0.217156 9.4055556 0.220711 9.4083333 0.225689 9.4111111 0.229600 9.4138889 0.233156 9.4166667 0.238489 9.4194444 0.244889 9.4222222 0.252000 9.4250000 0.259822 9.4277778 0.263733 9.4305556 0.265867 9.4333333 0.267289 9.4361111 0.268000 9.4388889 0.271556 9.4416667 0.275467 9.4444444 0.277956 9.4472222 0.278667 9.4500000 0.278311 9.4527778 0.278667 9.4555556 0.280444 9.4583333 0.283289 9.4611111 0.286489 9.4638889 0.290044 9.4666667 0.295022 9.4694444 0.300711 9.4722222 0.305689 9.4750000 0.309244 9.4777778 0.313156 9.4805556 0.313867 9.4833333 0.314578 9.4861111 0.315644 9.4888889 0.317067 9.4916667 0.319200 9.4944444 0.320622 9.4972222 0.319556 9.5000000 0.320622 9.5027778 0.320267 9.5055556 0.321333 9.5083333 0.322400 9.5111111 0.323111 9.5138889 0.323111 9.5166667 0.323822 9.5194444 0.323822 9.5222222 0.324889 9.5250000 0.326667 9.5277778 0.326667 9.5305556 0.327378 9.5333333 0.327022 9.5361111 0.328800 9.5388889 0.328444 9.5416667 0.330578 9.5444444 0.330578 9.5472222 0.331289 9.5500000 0.331289 9.5527778 0.331289 9.5555556 0.333422 9.5583333 0.334844 9.5611111 0.335911 9.5638889 0.335911 9.5666667 0.336622 9.5694444 0.337333 9.5722222 0.339111 9.5750000 0.340178 9.5777778 0.341600 9.5805556 0.341600 9.5833333 0.341244 9.5861111 0.343378 9.5888889 0.344089 9.5916667 0.345867 9.5944444 0.345867 9.5972222 0.345156 9.6000000 0.345156 9.6027778 0.345511 9.6055556 0.346222 9.6083333 0.347644 9.6111111 0.347644 9.6138889 0.346933 9.6166667 0.345511 9.6194444 0.344800 9.6222222 0.345867 9.6250000 0.345867 9.6277778 0.345867 9.6305556 0.344089 9.6333333 0.342311 9.6361111 0.341244 9.6388889 0.340533 9.6416667 0.339822 9.6444444 0.339111 9.6472222 0.336622 9.6500000 0.334133 9.6527778 0.333067 9.6555556 0.331289 9.6583333 0.330933 9.6611111 0.329867 9.6638889 0.326667 9.6666667 0.324178 9.6694444 0.322044 9.6722222 0.321689 9.6750000 0.320978 9.6777778 0.318844 9.6805556 0.316356 9.6831111 0.300000 9.6833333 0.314222 9.6861111 0.312800 9.6888889 0.312444 9.6916667 0.312800 9.6944444 0.311022 9.6972222 0.309956 9.6974444 0.300000 9.7000000 0.307467 9.7027778 0.306400 9.7055556 0.305333 9.7083333 0.307111 9.7111111 0.306756 9.7138889 0.305689 9.7166667 0.304622 9.7194444 0.303556 9.7222222 0.304267 9.7250000 0.305333 9.7277778 0.304978 9.7305556 0.304622 9.7333333 0.303200 9.7361111 0.303911 9.7388889 0.304267 9.7416667 0.304622 9.7444444 0.304978 9.7472222 0.304622 9.7500000 0.303556 9.7527778 0.303556 9.7555556 0.304622 9.7583333 0.304267 9.7611111 0.306044 9.7638889 0.303911 9.7666667 0.303911 9.7694444 0.303200 9.7722222 0.303556 9.7750000 0.304978 9.7777778 0.304622 9.7805556 0.304267 9.7833333 0.303911 9.7861111 0.303556 9.7888889 0.304978 9.7916667 0.306044 9.7944444 0.306044 9.7972222 0.305333 9.8000000 0.304622 9.8027778 0.304622 9.8055556 0.306044 9.8083333 0.305333 9.8111111 0.306044 9.8138889 0.305333 9.8166667 0.304267 9.8194444 0.303556 9.8222222 0.304978 9.8250000 0.304622 9.8277778 0.305333 9.8305556 0.304267 9.8333333 0.303200 9.8361111 0.303200 9.8388889 0.302844 9.8416667 0.304622 9.8444444 0.306044 9.8472222 0.305689 9.8500000 0.304978 9.8527778 0.304978 9.8555556 0.304622 9.8583333 0.305333 9.8611111 0.305333 9.8638889 0.304267 9.8666667 0.301778 9.8694444 0.300000 9.8722222 0.298578 9.8750000 0.297156 9.8777778 0.295022 9.8805556 0.292178 9.8833333 0.288267 9.8861111 0.283644 9.8888889 0.278667 9.8916667 0.273333 9.8944444 0.267289 9.8972222 0.262311 9.9000000 0.258044 9.9027778 0.254489 9.9055556 0.251289 9.9083333 0.248800 9.9111111 0.245956 9.9138889 0.243111 9.9166667 0.238133 9.9194444 0.237067 9.9222222 0.236000 9.9250000 0.235289 9.9277778 0.234222 9.9305556 0.231733 9.9333333 0.230667 9.9361111 0.232089 9.9388889 0.236000 9.9416667 0.241333 9.9444444 0.245956 9.9472222 0.250578 9.9500000 0.253067 9.9527778 0.258756 9.9555556 0.266222 9.9583333 0.271911 9.9611111 0.277956 9.9638889 0.279733 9.9666667 0.281867 9.9694444 0.283289 9.9722222 0.284711 9.9750000 0.284711 9.9777778 0.284711 9.9805556 0.284000 9.9833333 0.281511 9.9861111 0.281156 9.9888889 0.281156 9.9916667 0.283644 9.9944444 0.287200 9.9972222 0.292533 10.0000000 0.297156 10.0027778 0.303200 10.0055556 0.307467 10.0083333 0.311022 10.0111111 0.313156 10.0138889 0.314222 10.0166667 0.314222 10.0194444 0.314933 10.0222222 0.316356 10.0250000 0.317422 10.0277778 0.318489 10.0305556 0.318844 10.0333333 0.318133 10.0361111 0.318844 10.0388889 0.319556 10.0416667 0.320978 10.0444444 0.321689 10.0472222 0.322400 10.0500000 0.322044 10.0527778 0.321333 10.0555556 0.323111 10.0583333 0.324178 10.0611111 0.324889 10.0638889 0.324533 10.0666667 0.324889 10.0694444 0.326311 10.0722222 0.327022 10.0750000 0.327733 10.0777778 0.328800 10.0805556 0.329511 10.0833333 0.329156 10.0861111 0.330578 10.0888889 0.332000 10.0916667 0.334133 10.0944444 0.334489 10.0972222 0.334489 10.1000000 0.334133 10.1027778 0.335556 10.1055556 0.335911 10.1083333 0.337689 10.1111111 0.339111 10.1138889 0.338756 10.1166667 0.337689 10.1194444 0.338044 10.1222222 0.338756 10.1250000 0.340533 10.1277778 0.340889 10.1305556 0.339822 10.1333333 0.339111 10.1361111 0.339111 10.1388889 0.339111 10.1416667 0.339822 10.1444444 0.339467 10.1472222 0.338044 10.1500000 0.336267 10.1527778 0.336622 10.1555556 0.336622 10.1583333 0.335911 10.1611111 0.334844 10.1638889 0.332711 10.1666667 0.330933 10.1694444 0.329867 10.1722222 0.328800 10.1750000 0.327378 10.1777778 0.325600 10.1805556 0.323111 10.1833333 0.320622 10.1861111 0.319200 10.1888889 0.318133 10.1916667 0.316711 10.1944444 0.314933 10.1972222 0.313867 10.2000000 0.310667 10.2027778 0.309600 10.2055556 0.309244 10.2083333 0.309600 10.2111111 0.308178 10.2138889 0.307111 10.2166667 0.305689 10.2194444 0.304622 10.2222222 0.304978 10.2250000 0.304978 10.2277778 0.304267 10.2305556 0.303911 10.2333333 0.302489 10.2391111 0.300000 10.4608889 0.300000 10.4638889 0.299289 10.4666667 0.298933 10.4694444 0.298933 10.4722222 0.299644 10.4750000 0.300356 10.4777778 0.300000 10.4805556 0.299289 10.4833333 0.298578 10.4861111 0.298578 10.4888889 0.298222 10.4916667 0.299644 10.4944444 0.300356 10.4972222 0.299289 10.5000000 0.298578 10.5027778 0.297511 10.5055556 0.298933 10.5083333 0.300356 10.5111111 0.299289 10.5138889 0.298933 10.5166667 0.297867 10.5194444 0.297867 10.5222222 0.298578 10.5250000 0.299289 10.5277778 0.299644 10.5305556 0.299289 10.5333333 0.297867 10.5361111 0.297511 10.5388889 0.298578 10.5416667 0.300711 10.5444444 0.300000 10.5472222 0.300000 10.5500000 0.300000 10.5527778 0.300356 10.5555556 0.301067 10.5583333 0.302133 10.5611111 0.302133 10.5638889 0.302489 10.5666667 0.301067 10.5694444 0.300356 10.5722222 0.300356 10.5750000 0.300711 10.5777778 0.301067 10.5805556 0.298578 10.5833333 0.296089 10.5861111 0.295733 10.5888889 0.295022 10.5916667 0.296089 10.5944444 0.296089 10.5972222 0.295733 10.6000000 0.295378 10.6027778 0.295022 10.6055556 0.294667 10.6083333 0.295733 10.6111111 0.296444 10.6138889 0.295733 10.6166667 0.296089 10.6194444 0.296800 10.6222222 0.296089 10.6250000 0.297511 10.6277778 0.297511 10.6305556 0.296800 10.6333333 0.296089 10.6361111 0.296800 10.6388889 0.296444 10.6416667 0.297511 10.6444444 0.297511 10.6472222 0.296444 10.6500000 0.296089 10.6527778 0.295733 10.6555556 0.296800 10.6583333 0.297156 10.6611111 0.297511 10.6638889 0.296444 10.6666667 0.296089 10.6694444 0.295733 10.6722222 0.296444 10.6750000 0.297156 10.6777778 0.295733 10.6805556 0.294311 10.6833333 0.294311 10.6861111 0.295378 10.6888889 0.296089 10.6916667 0.295022 10.6944444 0.291111 10.6972222 0.286489 10.7000000 0.280800 10.7027778 0.280444 10.7055556 0.281156 10.7083333 0.281511 10.7111111 0.281511 10.7138889 0.281511 10.7166667 0.283644 10.7194444 0.288622 10.7222222 0.292178 10.7250000 0.293956 10.7277778 0.293244 10.7305556 0.290756 10.7333333 0.288267 10.7361111 0.287556 10.7388889 0.288622 10.7416667 0.291111 10.7444444 0.292889 10.7472222 0.294311 10.7500000 0.295022 10.7527778 0.296089 10.7555556 0.297156 10.7583333 0.298222 10.7611111 0.298222 10.7638889 0.297156 10.7666667 0.297511 10.7694444 0.297867 10.7722222 0.297867 10.7750000 0.297867 10.7777778 0.297867 10.7805556 0.298222 10.7833333 0.296444 10.7861111 0.296800 10.7888889 0.297867 10.7916667 0.298933 10.7944444 0.298933 10.7972222 0.298222 10.8000000 0.296800 10.8027778 0.297511 10.8055556 0.298222 10.8083333 0.298933 10.8111111 0.298933 10.8138889 0.297867 10.8166667 0.297867 10.8194444 0.297511 10.8222222 0.297511 10.8250000 0.298933 10.8277778 0.298933 10.8305556 0.297867 10.8333333 0.297511 10.8361111 0.296444 10.8388889 0.296800 10.8416667 0.297511 10.8444444 0.296800 10.8472222 0.296089 10.8500000 0.295378 10.8527778 0.294311 10.8555556 0.294311 10.8583333 0.295022 10.8611111 0.294667 10.8638889 0.293956 10.8666667 0.292889 10.8694444 0.292533 10.8722222 0.293244 10.8750000 0.292889 10.8777778 0.292889 10.8805556 0.291467 10.8833333 0.290756 10.8861111 0.289689 10.8888889 0.289333 10.8916667 0.289689 10.8944444 0.288622 10.8972222 0.287911 10.9000000 0.285422 10.9027778 0.284000 10.9055556 0.284356 10.9083333 0.284356 10.9111111 0.284356 10.9138889 0.282222 10.9166667 0.280444 10.9194444 0.280089 10.9222222 0.280800 10.9250000 0.280089 10.9277778 0.280089 10.9305556 0.279378 10.9333333 0.279022 10.9361111 0.278311 10.9388889 0.277600 10.9416667 0.278667 10.9444444 0.279022 10.9472222 0.278667 10.9500000 0.278311 10.9527778 0.278667 10.9555556 0.279378 10.9583333 0.280089 10.9611111 0.280800 10.9638889 0.281511 10.9666667 0.281511 10.9694444 0.282933 10.9722222 0.284711 10.9750000 0.287556 10.9777778 0.287556 10.9805556 0.288622 10.9833333 0.288978 10.9861111 0.291822 10.9888889 0.292533 10.9916667 0.295022 10.9944444 0.297156 10.9972222 0.296800 11.0000000 0.297511 11.0027778 0.297867 11.0055556 0.299289 11.0083333 0.301778 11.0111111 0.301778 11.0168889 0.300000 11.0470000 0.300000 11.0500000 0.303200 11.0527778 0.303911 11.0555556 0.303911 11.0583333 0.304978 11.0611111 0.305333 11.0638889 0.304267 11.0666667 0.302844 11.0694444 0.303200 11.0722222 0.303200 11.0750000 0.304978 11.0777778 0.304622 11.0805556 0.303911 11.0833333 0.302489 11.0861111 0.302489 11.0888889 0.302844 11.0916667 0.304267 11.0944444 0.303911 11.0972222 0.303200 11.1000000 0.301778 11.1027778 0.301422 11.1055556 0.302489 11.1083333 0.303200 11.1111111 0.302844 11.1138889 0.302489 11.1166667 0.301422 11.1194444 0.301067 11.1222222 0.301422 11.1250000 0.302133 11.1277778 0.302844 11.1305556 0.302133 11.1333333 0.302133 11.1361111 0.302489 11.1388889 0.303200 11.1416667 0.304267 11.1444444 0.305333 11.1472222 0.304622 11.1500000 0.304267 11.1527778 0.304622 11.1555556 0.304978 11.1583333 0.306400 11.1611111 0.306400 11.1638889 0.304978 11.1666667 0.303200 11.1694444 0.302133 11.1722222 0.303200 11.1750000 0.303556 11.1777778 0.301422 11.1805556 0.300000 11.1833333 0.298933 11.1861111 0.298578 11.1888889 0.299644 11.1916667 0.301422 11.1944444 0.300711 11.1972222 0.300711 11.2000000 0.300711 11.2027778 0.300711 11.2055556 0.302489 11.2083333 0.303911 11.2111111 0.306044 11.2138889 0.303911 11.2166667 0.302133 11.2194444 0.301422 11.2222222 0.299289 11.2250000 0.296800 11.2277778 0.294311 11.2305556 0.290400 11.2333333 0.285778 11.2361111 0.281156 11.2388889 0.276178 11.2416667 0.269422 11.2444444 0.260533 11.2472222 0.253067 11.2500000 0.246667 11.2527778 0.242044 11.2555556 0.237422 11.2583333 0.234222 11.2611111 0.228178 11.2638889 0.223200 11.2666667 0.218222 11.2694444 0.217156 11.2722222 0.216089 11.2750000 0.213956 11.2777778 0.211111 11.2805556 0.208978 11.2833333 0.208978 11.2861111 0.209689 11.2888889 0.210044 11.2916667 0.210044 11.2944444 0.210756 11.2972222 0.212533 11.3000000 0.218578 11.3027778 0.227111 11.3055556 0.236356 11.3083333 0.246311 11.3111111 0.258400 11.3138889 0.270489 11.3166667 0.281867 11.3194444 0.290400 11.3222222 0.296800 11.3250000 0.302133 11.3277778 0.304978 11.3305556 0.306756 11.3333333 0.309244 11.3361111 0.311022 11.3388889 0.314933 11.3416667 0.316000 11.3444444 0.317067 11.3472222 0.317422 11.3500000 0.317778 11.3527778 0.318489 11.3555556 0.319911 11.3583333 0.321689 11.3611111 0.322044 11.3638889 0.320978 11.3666667 0.320978 11.3694444 0.320978 11.3722222 0.322756 11.3750000 0.323467 11.3777778 0.323467 11.3805556 0.324178 11.3833333 0.323467 11.3861111 0.324178 11.3888889 0.325244 11.3916667 0.325956 11.3944444 0.326667 11.3972222 0.327378 11.4000000 0.328089 11.4027778 0.328089 11.4055556 0.329867 11.4083333 0.330578 11.4111111 0.332000 11.4138889 0.332711 11.4166667 0.332356 11.4194444 0.333067 11.4222222 0.334844 11.4250000 0.335556 11.4277778 0.336267 11.4305556 0.337689 11.4333333 0.337333 11.4361111 0.338400 11.4388889 0.339822 11.4416667 0.340889 11.4444444 0.343022 11.4472222 0.342311 11.4500000 0.342311 11.4527778 0.343378 11.4555556 0.344444 11.4583333 0.345511 11.4611111 0.346578 11.4638889 0.346222 11.4666667 0.345867 11.4694444 0.345156 11.4722222 0.345511 11.4750000 0.346222 11.4777778 0.346222 11.4805556 0.345156 11.4833333 0.344089 11.4861111 0.343022 11.4888889 0.344089 11.4916667 0.343022 11.4944444 0.341600 11.4972222 0.339822 11.5000000 0.337333 11.5027778 0.336622 11.5053333 0.300000 11.5055556 0.335911 11.5083333 0.335200 11.5111111 0.333067 11.5138889 0.329867 11.5166667 0.327378 11.5194444 0.325600 11.5222222 0.324533 11.5250000 0.323467 11.5277778 0.322044 11.5305556 0.319911 11.5333333 0.318489 11.5361111 0.316000 11.5388889 0.315289 11.5416667 0.315289 11.5444444 0.313511 11.5472222 0.312444 11.5500000 0.311022 11.5527778 0.311022 11.5555556 0.310311 11.5583333 0.310667 11.5611111 0.309956 11.5638889 0.309600 11.5666667 0.308533 11.5694444 0.309600 11.5722222 0.309244 11.5750000 0.308889 11.5777778 0.308889 11.5805556 0.308178 11.5833333 0.307467 11.5861111 0.307822 11.5888889 0.307822 11.5916667 0.308533 11.5944444 0.308533 11.5972222 0.307467 11.6000000 0.306044 11.6027778 0.306756 11.6030000 0.300000 11.6055556 0.307467 11.6083333 0.307822 11.6111111 0.306756 11.6138889 0.306400 11.6166667 0.306044 11.6194444 0.306400 11.6222222 0.307111 11.6250000 0.307822 11.6277778 0.308178 11.6305556 0.306756 11.6333333 0.307111 11.6361111 0.306400 11.6388889 0.307111 11.6416667 0.308178 11.6444444 0.307111 11.6472222 0.306756 11.6500000 0.306756 11.6527778 0.306044 11.6555556 0.307111 11.6583333 0.307822 11.6611111 0.307111 11.6638889 0.307111 11.6666667 0.305333 11.6694444 0.306400 11.6722222 0.306044 11.6750000 0.308178 11.6777778 0.307111 11.6805556 0.307111 11.6833333 0.307467 11.6861111 0.307467 11.6888889 0.307822 11.6916667 0.307467 11.6944444 0.307111 11.6972222 0.304622 11.7000000 0.302489 11.7027778 0.302133 11.7055556 0.301422 11.7083333 0.301067 11.7111111 0.298578 11.7138889 0.295378 11.7166667 0.290400 11.7194444 0.285778 11.7222222 0.282222 11.7250000 0.276178 11.7277778 0.270489 11.7305556 0.263733 11.7333333 0.258756 11.7361111 0.253778 11.7388889 0.250222 11.7416667 0.246311 11.7444444 0.240267 11.7472222 0.234578 11.7500000 0.230311 11.7527778 0.227822 11.7555556 0.227822 11.7583333 0.227467 11.7611111 0.226044 11.7638889 0.226400 11.7666667 0.227467 11.7694444 0.229956 11.7722222 0.234578 11.7750000 0.239911 11.7777778 0.245244 11.7805556 0.248800 11.7833333 0.255200 11.7861111 0.262667 11.7888889 0.270489 11.7916667 0.276178 11.7944444 0.279378 11.7972222 0.281511 11.8000000 0.281511 11.8027778 0.281511 11.8055556 0.283289 11.8083333 0.285422 11.8111111 0.285422 11.8138889 0.285422 11.8166667 0.283289 11.8194444 0.283644 11.8222222 0.285067 11.8250000 0.288267 11.8277778 0.292889 11.8305556 0.297156 11.8333333 0.303556 11.8361111 0.309244 11.8388889 0.313511 11.8416667 0.315644 11.8444444 0.317067 11.8472222 0.317422 11.8500000 0.317778 11.8527778 0.318844 11.8555556 0.320978 11.8583333 0.321333 11.8611111 0.321689 11.8638889 0.322044 11.8666667 0.321689 11.8694444 0.322400 11.8722222 0.323822 11.8750000 0.324533 11.8777778 0.325244 11.8805556 0.325244 11.8833333 0.325244 11.8861111 0.324889 11.8888889 0.327378 11.8916667 0.327378 11.8944444 0.328444 11.8972222 0.328089 11.9000000 0.328089 11.9027778 0.329156 11.9055556 0.330578 11.9083333 0.331644 11.9111111 0.332000 11.9138889 0.332000 11.9166667 0.332356 11.9194444 0.333067 11.9222222 0.335556 11.9250000 0.336267 11.9277778 0.337333 11.9305556 0.336978 11.9333333 0.336978 11.9361111 0.336622 11.9388889 0.339467 11.9416667 0.339467 11.9444444 0.341600 11.9472222 0.339822 11.9500000 0.340178 11.9527778 0.340533 11.9555556 0.340533 11.9583333 0.341956 11.9611111 0.342311 11.9638889 0.340889 11.9666667 0.339822 11.9694444 0.340889 11.9722222 0.340178 11.9750000 0.340178 11.9777778 0.340178 11.9805556 0.337689 11.9833333 0.337333 11.9861111 0.335911 11.9888889 0.335556 11.9916667 0.334489 11.9944444 0.333067 11.9972222 0.331289 12.0000000 0.328089 12.0027778 0.327733 12.0055556 0.327022 12.0083333 0.325600 12.0111111 0.324178 12.0138889 0.320978 12.0166667 0.319200 12.0194444 0.317067 12.0222222 0.316711 12.0250000 0.316711 12.0277778 0.315289 12.0305556 0.314222 12.0333333 0.312089 12.0361111 0.310667 12.0388889 0.311022 12.0416667 0.311022 12.0444444 0.310311 12.0472222 0.309244 12.0500000 0.307467 12.0527778 0.308178 12.0555556 0.309244 12.0613333 0.300000 12.3470000 0.300000 12.3500000 0.301067 12.3527778 0.301422 12.3555556 0.302844 12.3583333 0.302489 12.3611111 0.302489 12.3638889 0.301067 12.3666667 0.301067 12.3694444 0.302133 12.3722222 0.301067 12.3750000 0.302133 12.3777778 0.302489 12.3805556 0.302133 12.3833333 0.301067 12.3861111 0.302133 12.3888889 0.302133 12.3916667 0.302489 12.3944444 0.302489 12.3972222 0.301778 12.4000000 0.301778 12.4027778 0.301778 12.4055556 0.302133 12.4083333 0.302133 12.4111111 0.302133 12.4138889 0.301422 12.4166667 0.300356 12.4194444 0.301067 12.4222222 0.302133 12.4250000 0.303556 12.4277778 0.302489 12.4305556 0.302133 12.4333333 0.301422 12.4361111 0.301067 12.4388889 0.302489 12.4416667 0.303556 12.4444444 0.303556 12.4472222 0.303556 12.4500000 0.302844 12.4527778 0.303200 12.4555556 0.304622 12.4583333 0.305689 12.4611111 0.305689 12.4638889 0.303200 12.4666667 0.301778 12.4694444 0.301778 12.4722222 0.301422 12.4750000 0.300000 12.4777778 0.300000 12.4805556 0.298222 12.4833333 0.296800 12.4861111 0.297511 12.4888889 0.297867 12.4916667 0.298933 12.4944444 0.299289 12.4972222 0.298933 12.5000000 0.297156 12.5027778 0.297867 12.5055556 0.298578 12.5083333 0.300356 12.5111111 0.300356 12.5138889 0.299289 12.5166667 0.298222 12.5194444 0.297867 12.5222222 0.299644 12.5250000 0.300000 12.5277778 0.300000 12.5305556 0.298933 12.5333333 0.297867 12.5361111 0.297867 12.5388889 0.298578 12.5416667 0.300000 12.5444444 0.298578 12.5472222 0.297867 12.5500000 0.297156 12.5527778 0.297867 12.5555556 0.298222 12.5583333 0.299289 12.5611111 0.298933 12.5638889 0.297867 12.5666667 0.296800 12.5694444 0.295378 12.5722222 0.295733 12.5750000 0.296800 12.5777778 0.296089 12.5805556 0.292533 12.5833333 0.288622 12.5861111 0.284356 12.5888889 0.283289 12.5916667 0.283289 12.5944444 0.283644 12.5972222 0.282933 12.6000000 0.284000 12.6027778 0.286489 12.6055556 0.292533 12.6083333 0.295022 12.6111111 0.296800 12.6138889 0.295378 12.6166667 0.292533 12.6194444 0.291467 12.6222222 0.292178 12.6250000 0.293956 12.6277778 0.296800 12.6305556 0.297156 12.6333333 0.297511 12.6361111 0.298222 12.6388889 0.299289 12.6416667 0.300000 12.6444444 0.300711 12.6472222 0.299644 12.6500000 0.298933 12.6527778 0.299289 12.6555556 0.299644 12.6583333 0.300711 12.6611111 0.300356 12.6638889 0.300000 12.6666667 0.298933 12.6694444 0.298933 12.6722222 0.299644 12.6750000 0.300356 12.6777778 0.300711 12.6805556 0.298578 12.6833333 0.297511 12.6861111 0.299289 12.6888889 0.299289 12.6916667 0.299289 12.6944444 0.300000 12.6972222 0.298578 12.7000000 0.298222 12.7027778 0.298578 12.7055556 0.299289 12.7083333 0.299289 12.7111111 0.300000 12.7138889 0.297867 12.7166667 0.297867 12.7194444 0.297511 12.7222222 0.297867 12.7250000 0.297511 12.7277778 0.297156 12.7305556 0.296089 12.7333333 0.296089 12.7361111 0.296089 12.7388889 0.296444 12.7416667 0.295378 12.7444444 0.294667 12.7472222 0.294667 12.7500000 0.292533 12.7527778 0.292889 12.7555556 0.292178 12.7583333 0.293600 12.7611111 0.292178 12.7638889 0.291111 12.7666667 0.289333 12.7694444 0.288267 12.7722222 0.288978 12.7750000 0.287911 12.7777778 0.288267 12.7805556 0.286489 12.7833333 0.284711 12.7861111 0.284711 12.7888889 0.285778 12.7916667 0.285422 12.7944444 0.285067 12.7972222 0.283644 12.8000000 0.282222 12.8027778 0.281511 12.8055556 0.282933 12.8083333 0.282933 12.8111111 0.282578 12.8138889 0.281511 12.8166667 0.280800 12.8194444 0.281156 12.8222222 0.281867 12.8250000 0.282933 12.8277778 0.284000 12.8305556 0.284000 12.8333333 0.284000 12.8361111 0.285067 12.8388889 0.286489 12.8416667 0.288267 12.8444444 0.288978 12.8472222 0.289689 12.8500000 0.290044 12.8527778 0.291111 12.8555556 0.293956 12.8583333 0.295733 12.8611111 0.296800 12.8638889 0.296800 12.8666667 0.297511 12.8694444 0.298222 12.8722222 0.300356 12.8750000 0.301422 12.8777778 0.302133 12.8805556 0.302133 12.8833333 0.302844 12.8861111 0.303200 12.8888889 0.303911 12.8916667 0.306044 12.8944444 0.305333 12.8972222 0.305333 12.9030000 0.300000 12.9053333 0.300000 12.9083333 0.306044 12.9111111 0.306400 12.9138889 0.306400 12.9166667 0.305689 12.9194444 0.306044 12.9222222 0.306044 12.9250000 0.306756 12.9277778 0.306756 12.9305556 0.306400 12.9333333 0.305333 12.9361111 0.305333 12.9388889 0.306400 12.9416667 0.306756 12.9444444 0.305689 12.9472222 0.305689 12.9500000 0.303911 12.9527778 0.304978 12.9555556 0.305333 12.9583333 0.305689 12.9611111 0.305689 12.9638889 0.304622 12.9666667 0.304267 12.9694444 0.304267 12.9722222 0.305333 12.9750000 0.305333 12.9777778 0.305333 12.9805556 0.304267 12.9833333 0.304267 12.9861111 0.304267 12.9888889 0.304978 12.9916667 0.306400 12.9944444 0.306044 12.9972222 0.305333 13.0000000 0.305333 13.0027778 0.305689 13.0055556 0.306756 13.0083333 0.307111 13.0111111 0.307467 13.0138889 0.306756 13.0166667 0.304978 13.0194444 0.305333 13.0222222 0.305333 13.0250000 0.304978 13.0277778 0.304267 13.0305556 0.302844 13.0333333 0.301778 13.0361111 0.302133 13.0388889 0.302489 13.0416667 0.303556 13.0444444 0.303911 13.0472222 0.304267 13.0500000 0.303200 13.0527778 0.303556 13.0555556 0.304267 13.0583333 0.305689 13.0611111 0.304978 13.0638889 0.304978 13.0666667 0.303200 13.0694444 0.302133 13.0722222 0.300711 13.0750000 0.299289 13.0777778 0.296089 13.0805556 0.292178 13.0833333 0.288267 13.0861111 0.283644 13.0888889 0.277956 13.0916667 0.272267 13.0944444 0.265867 13.0972222 0.260178 13.1000000 0.254489 13.1027778 0.251644 13.1055556 0.248444 13.1083333 0.247022 13.1111111 0.243822 13.1138889 0.239556 13.1166667 0.236711 13.1194444 0.233867 13.1222222 0.232800 13.1250000 0.232089 13.1277778 0.229244 13.1305556 0.227467 13.1333333 0.225689 13.1361111 0.227822 13.1388889 0.231733 13.1416667 0.236711 13.1444444 0.239911 13.1472222 0.240267 13.1500000 0.239911 13.1527778 0.242044 13.1555556 0.247022 13.1583333 0.251644 13.1611111 0.256267 13.1638889 0.259111 13.1666667 0.262667 13.1694444 0.268000 13.1722222 0.274044 13.1750000 0.281867 13.1777778 0.288267 13.1805556 0.293244 13.1833333 0.297156 13.1861111 0.300711 13.1888889 0.304978 13.1916667 0.309244 13.1944444 0.311733 13.1972222 0.313511 13.2000000 0.313867 13.2027778 0.315644 13.2055556 0.318133 13.2083333 0.319200 13.2111111 0.319911 13.2138889 0.319911 13.2166667 0.319911 13.2194444 0.320622 13.2222222 0.321689 13.2250000 0.323111 13.2277778 0.323111 13.2305556 0.323822 13.2333333 0.322400 13.2361111 0.323822 13.2388889 0.325244 13.2416667 0.326667 13.2444444 0.326667 13.2472222 0.325600 13.2500000 0.326311 13.2527778 0.327022 13.2555556 0.329156 13.2583333 0.330578 13.2611111 0.332356 13.2638889 0.330578 13.2666667 0.330578 13.2694444 0.332356 13.2722222 0.333422 13.2750000 0.335911 13.2777778 0.335556 13.2805556 0.335911 13.2833333 0.336622 13.2861111 0.337689 13.2888889 0.339467 13.2916667 0.341244 13.2944444 0.341956 13.2972222 0.341600 13.3000000 0.341956 13.3027778 0.342667 13.3055556 0.343733 13.3083333 0.345511 13.3111111 0.346222 13.3138889 0.345511 13.3166667 0.345511 13.3194444 0.345511 13.3222222 0.347289 13.3250000 0.348000 13.3277778 0.348000 13.3305556 0.346222 13.3333333 0.346222 13.3361111 0.345867 13.3388889 0.346222 13.3416667 0.345867 13.3444444 0.344800 13.3472222 0.343733 13.3500000 0.341956 13.3527778 0.341244 13.3555556 0.340889 13.3583333 0.339822 13.3611111 0.337333 13.3638889 0.335556 13.3666667 0.332356 13.3694444 0.330933 13.3722222 0.329867 13.3750000 0.329511 13.3777778 0.328089 13.3805556 0.325244 13.3833333 0.322400 13.3861111 0.321333 13.3888889 0.320978 13.3916667 0.319556 13.3944444 0.318133 13.3972222 0.316711 13.3997778 0.300000 13.4000000 0.314222 13.4027778 0.313511 13.4055556 0.313156 13.4083333 0.312800 13.4111111 0.312444 13.4138889 0.311022 13.4166667 0.309600 13.4194444 0.309600 13.4222222 0.309956 13.4250000 0.309956 13.4277778 0.309600 13.4305556 0.308178 13.4333333 0.307111 13.4361111 0.308533 13.4388889 0.308178 13.4416667 0.309244 13.4444444 0.308889 13.4472222 0.306756 13.4500000 0.306400 13.4527778 0.307467 13.4555556 0.307822 13.4583333 0.308178 13.4611111 0.308533 13.4613333 0.300000 13.4638889 0.307467 13.4666667 0.306756 13.4694444 0.307111 13.4722222 0.307111 13.4750000 0.309244 13.4777778 0.307822 13.4805556 0.307467 13.4833333 0.306044 13.4861111 0.306756 13.4888889 0.307822 13.4916667 0.308533 13.4944444 0.308889 13.4972222 0.307467 13.5000000 0.306400 13.5027778 0.307822 13.5055556 0.308533 13.5083333 0.309244 13.5111111 0.308178 13.5138889 0.308178 13.5166667 0.307467 13.5194444 0.308178 13.5222222 0.308178 13.5250000 0.308533 13.5277778 0.307822 13.5305556 0.307822 13.5333333 0.307111 13.5361111 0.307467 13.5388889 0.308889 13.5416667 0.308178 13.5444444 0.306756 13.5472222 0.306756 13.5500000 0.306400 13.5527778 0.306756 13.5555556 0.307467 13.5583333 0.307822 13.5611111 0.308178 13.5638889 0.306756 13.5666667 0.306400 13.5694444 0.307467 13.5722222 0.307822 13.5750000 0.309244 13.5777778 0.309244 13.5805556 0.307822 13.5833333 0.307111 13.5861111 0.308533 13.5888889 0.307111 13.5916667 0.306756 13.5944444 0.304978 13.5972222 0.302844 13.6000000 0.299644 13.6027778 0.296800 13.6055556 0.293244 13.6083333 0.289689 13.6111111 0.284000 13.6138889 0.275467 13.6166667 0.268000 13.6194444 0.260889 13.6222222 0.255556 13.6250000 0.252000 13.6277778 0.247022 13.6305556 0.242400 13.6333333 0.237067 13.6361111 0.234222 13.6388889 0.230311 13.6416667 0.228889 13.6444444 0.227467 13.6472222 0.225333 13.6500000 0.223911 13.6527778 0.225333 13.6555556 0.227111 13.6583333 0.231022 13.6611111 0.234578 13.6638889 0.237778 13.6666667 0.241689 13.6694444 0.246667 13.6722222 0.253778 13.6750000 0.261244 13.6777778 0.267289 13.6805556 0.271556 13.6833333 0.274400 13.6861111 0.277956 13.6888889 0.280444 13.6916667 0.282933 13.6944444 0.283644 13.6972222 0.285067 13.7000000 0.285067 13.7027778 0.286133 13.7055556 0.285778 13.7083333 0.287200 13.7111111 0.287911 13.7138889 0.289333 13.7166667 0.291822 13.7194444 0.294667 13.7222222 0.300711 13.7250000 0.305689 13.7277778 0.310667 13.7305556 0.312089 13.7333333 0.314578 13.7361111 0.316356 13.7388889 0.318133 13.7416667 0.320622 13.7444444 0.322044 13.7472222 0.321333 13.7500000 0.321333 13.7527778 0.322756 13.7555556 0.323822 13.7583333 0.326311 13.7611111 0.325956 13.7638889 0.325956 13.7666667 0.326311 13.7694444 0.327022 13.7722222 0.328444 13.7750000 0.329511 13.7777778 0.330578 13.7805556 0.330933 13.7833333 0.331289 13.7861111 0.332000 13.7888889 0.334133 13.7916667 0.335556 13.7944444 0.336267 13.7972222 0.336622 13.8000000 0.337333 13.8027778 0.338756 13.8055556 0.340533 13.8083333 0.341600 13.8111111 0.341600 13.8138889 0.342667 13.8166667 0.342667 13.8194444 0.344089 13.8222222 0.345867 13.8250000 0.347644 13.8277778 0.348711 13.8305556 0.349067 13.8333333 0.348711 13.8361111 0.349778 13.8388889 0.351911 13.8416667 0.351556 13.8444444 0.351911 13.8472222 0.352267 13.8500000 0.351200 13.8527778 0.351556 13.8555556 0.351911 13.8583333 0.352267 13.8611111 0.352267 13.8638889 0.349778 13.8666667 0.348711 13.8694444 0.348000 13.8722222 0.348356 13.8750000 0.345867 13.8777778 0.344800 13.8805556 0.341600 13.8833333 0.340889 13.8861111 0.338400 13.8888889 0.337333 13.8916667 0.335556 13.8944444 0.333067 13.8972222 0.330578 13.9000000 0.327022 13.9027778 0.325244 13.9055556 0.324178 13.9083333 0.323111 13.9111111 0.320267 13.9138889 0.317778 13.9166667 0.315289 13.9194444 0.314222 13.9222222 0.313867 13.9250000 0.312800 13.9277778 0.311378 13.9305556 0.310311 13.9333333 0.309244 13.9361111 0.308178 13.9388889 0.308178 13.9416667 0.308889 13.9444444 0.307822 13.9472222 0.307111 13.9500000 0.306044 13.9557778 0.300000 14.0997778 0.300000 14.1027778 0.305689 14.1055556 0.305689 14.1083333 0.306756 14.1111111 0.306044 14.1138889 0.305333 14.1166667 0.304622 14.1194444 0.304978 14.1222222 0.304978 14.1250000 0.306400 14.1277778 0.304978 14.1305556 0.304267 14.1333333 0.304622 14.1361111 0.304622 14.1388889 0.305333 14.1416667 0.305333 14.1444444 0.305689 14.1472222 0.304978 14.1500000 0.303911 14.1527778 0.303556 14.1555556 0.304978 14.1583333 0.304978 14.1611111 0.305333 14.1638889 0.303911 14.1666667 0.302489 14.1694444 0.303200 14.1722222 0.304267 14.1750000 0.304267 14.1777778 0.304622 14.1805556 0.303556 14.1833333 0.302489 14.1861111 0.303556 14.1888889 0.304267 14.1916667 0.304622 14.1944444 0.304267 14.1972222 0.303556 14.2000000 0.303911 14.2027778 0.303556 14.2055556 0.304978 14.2083333 0.305689 14.2111111 0.306044 14.2138889 0.306044 14.2166667 0.305689 14.2194444 0.306044 14.2222222 0.307467 14.2250000 0.308178 14.2277778 0.307111 14.2305556 0.305689 14.2333333 0.302844 14.2361111 0.301067 14.2388889 0.300711 14.2416667 0.301422 14.2444444 0.301067 14.2472222 0.300711 14.2500000 0.299289 14.2527778 0.299644 14.2555556 0.299644 14.2583333 0.300711 14.2611111 0.301422 14.2638889 0.301067 14.2666667 0.301778 14.2694444 0.301067 14.2722222 0.301422 14.2750000 0.302133 14.2777778 0.301778 14.2805556 0.300711 14.2833333 0.300711 14.2861111 0.300356 14.2888889 0.301067 14.2916667 0.301778 14.2944444 0.301067 14.2972222 0.299644 14.3000000 0.299644 14.3027778 0.300000 14.3055556 0.301422 14.3083333 0.301067 14.3111111 0.300356 14.3138889 0.299644 14.3166667 0.298222 14.3194444 0.298933 14.3222222 0.298222 14.3250000 0.298578 14.3277778 0.298222 14.3305556 0.297867 14.3333333 0.296089 14.3361111 0.291111 14.3388889 0.286133 14.3416667 0.281511 14.3444444 0.277600 14.3472222 0.275111 14.3500000 0.270844 14.3527778 0.269778 14.3555556 0.273333 14.3583333 0.279733 14.3611111 0.285778 14.3638889 0.287556 14.3666667 0.288267 14.3694444 0.288978 14.3722222 0.289689 14.3750000 0.291467 14.3777778 0.293956 14.3805556 0.295733 14.3833333 0.296800 14.3861111 0.298933 14.3888889 0.300711 14.3916667 0.302844 14.3944444 0.303911 14.3972222 0.303556 14.4000000 0.302844 14.4027778 0.302844 14.4055556 0.304978 14.4083333 0.304978 14.4111111 0.305333 14.4138889 0.304622 14.4166667 0.303911 14.4194444 0.304267 14.4222222 0.306044 14.4250000 0.307111 14.4277778 0.305689 14.4305556 0.305689 14.4333333 0.304622 14.4361111 0.305333 14.4388889 0.305333 14.4416667 0.306044 14.4444444 0.306044 14.4472222 0.305689 14.4500000 0.304978 14.4527778 0.305689 14.4555556 0.306044 14.4583333 0.306400 14.4611111 0.306400 14.4638889 0.305689 14.4666667 0.305333 14.4694444 0.304978 14.4722222 0.304622 14.4750000 0.306400 14.4777778 0.304978 14.4805556 0.303200 14.4833333 0.302489 14.4861111 0.303200 14.4888889 0.302844 14.4916667 0.303200 14.4944444 0.302489 14.4972222 0.301067 14.5000000 0.300356 14.5027778 0.299644 14.5055556 0.299289 14.5083333 0.299289 14.5111111 0.299289 14.5138889 0.297511 14.5166667 0.295733 14.5194444 0.294667 14.5222222 0.294667 14.5250000 0.295022 14.5277778 0.293956 14.5305556 0.291822 14.5333333 0.290044 14.5361111 0.289689 14.5388889 0.288978 14.5416667 0.288622 14.5444444 0.288267 14.5472222 0.285778 14.5500000 0.284356 14.5527778 0.284711 14.5555556 0.284356 14.5583333 0.284356 14.5611111 0.283644 14.5638889 0.282933 14.5666667 0.282222 14.5694444 0.282578 14.5722222 0.283289 14.5750000 0.284356 14.5777778 0.282933 14.5805556 0.282578 14.5833333 0.282578 14.5861111 0.284711 14.5888889 0.286489 14.5916667 0.288622 14.5944444 0.290044 14.5972222 0.290044 14.6000000 0.291111 14.6027778 0.292533 14.6055556 0.295022 14.6083333 0.297867 14.6111111 0.298578 14.6138889 0.300000 14.6166667 0.299644 14.6194444 0.301778 14.6222222 0.302844 14.6250000 0.305689 14.6277778 0.307467 14.6305556 0.306400 14.6333333 0.306400 14.6361111 0.307111 14.6388889 0.307822 14.6416667 0.310311 14.6444444 0.309600 14.6472222 0.309600 14.6500000 0.309244 14.6557778 0.300000 14.7053333 0.300000 14.7083333 0.312089 14.7111111 0.311022 14.7138889 0.310311 14.7166667 0.309244 14.7194444 0.308889 14.7222222 0.309600 14.7250000 0.310667 14.7277778 0.310311 14.7305556 0.308889 14.7333333 0.307822 14.7361111 0.308533 14.7388889 0.308889 14.7416667 0.309244 14.7444444 0.309244 14.7472222 0.308533 14.7500000 0.308533 14.7527778 0.308533 14.7555556 0.309600 14.7583333 0.309600 14.7611111 0.309244 14.7638889 0.308889 14.7666667 0.308178 14.7694444 0.308178 14.7722222 0.308889 14.7750000 0.309244 14.7777778 0.308889 14.7805556 0.308889 14.7833333 0.307822 14.7861111 0.308178 14.7888889 0.309244 14.7916667 0.310667 14.7944444 0.310667 14.7972222 0.310311 14.8000000 0.310311 14.8027778 0.310311 14.8055556 0.311378 14.8083333 0.312089 14.8111111 0.311378 14.8138889 0.311022 14.8166667 0.308889 14.8194444 0.308178 14.8222222 0.309244 14.8250000 0.308889 14.8277778 0.307822 14.8305556 0.304978 14.8333333 0.303911 14.8361111 0.303911 14.8388889 0.305333 14.8416667 0.306044 14.8444444 0.306756 14.8472222 0.306756 14.8500000 0.306400 14.8527778 0.306756 14.8555556 0.308178 14.8583333 0.310311 14.8611111 0.310667 14.8638889 0.309956 14.8666667 0.308178 14.8694444 0.306044 14.8722222 0.303911 14.8750000 0.301778 14.8777778 0.298578 14.8805556 0.294667 14.8833333 0.289333 14.8861111 0.286844 14.8888889 0.282578 14.8916667 0.277956 14.8944444 0.270489 14.8972222 0.263378 14.9000000 0.257333 14.9027778 0.251644 14.9055556 0.248089 14.9083333 0.244178 14.9111111 0.239200 14.9138889 0.233511 14.9166667 0.228178 14.9194444 0.225333 14.9222222 0.223556 14.9250000 0.222133 14.9277778 0.218222 14.9305556 0.215022 14.9333333 0.212889 14.9361111 0.213956 14.9388889 0.217511 14.9416667 0.221422 14.9444444 0.222489 14.9472222 0.222489 14.9500000 0.220711 14.9527778 0.222844 14.9555556 0.227467 14.9583333 0.234222 14.9611111 0.241689 14.9638889 0.246311 14.9666667 0.251289 14.9694444 0.259822 14.9722222 0.271200 14.9750000 0.281511 14.9777778 0.290756 14.9805556 0.298578 14.9833333 0.302133 14.9861111 0.306044 14.9888889 0.309956 14.9916667 0.313156 14.9944444 0.316000 14.9972222 0.317422 15.0000000 0.318844 15.0027778 0.320267 15.0055556 0.322756 15.0083333 0.323467 15.0111111 0.325600 15.0138889 0.325600 15.0166667 0.325600 15.0194444 0.325956 15.0222222 0.327378 15.0250000 0.328800 15.0277778 0.329867 15.0305556 0.328800 15.0333333 0.329156 15.0361111 0.330222 15.0388889 0.331289 15.0416667 0.332356 15.0444444 0.332711 15.0472222 0.332000 15.0500000 0.332711 15.0527778 0.333422 15.0555556 0.334844 15.0583333 0.336622 15.0611111 0.336267 15.0638889 0.336978 15.0666667 0.337333 15.0694444 0.336978 15.0722222 0.339111 15.0750000 0.339467 15.0777778 0.340533 15.0805556 0.341244 15.0833333 0.340178 15.0861111 0.342667 15.0888889 0.343733 15.0916667 0.345867 15.0944444 0.346933 15.0972222 0.345867 15.1000000 0.347289 15.1027778 0.348356 15.1055556 0.350133 15.1083333 0.351556 15.1111111 0.352267 15.1138889 0.351556 15.1166667 0.351556 15.1194444 0.352267 15.1222222 0.354400 15.1250000 0.355822 15.1277778 0.355822 15.1305556 0.354400 15.1331111 0.300000 15.1333333 0.354756 15.1361111 0.354400 15.1388889 0.355822 15.1416667 0.355467 15.1444444 0.354756 15.1472222 0.353689 15.1500000 0.352267 15.1527778 0.352267 15.1555556 0.351911 15.1583333 0.351200 15.1611111 0.349422 15.1638889 0.347289 15.1666667 0.345511 15.1694444 0.344444 15.1722222 0.342667 15.1750000 0.340889 15.1777778 0.339111 15.1805556 0.336622 15.1833333 0.334489 15.1861111 0.333067 15.1888889 0.332000 15.1916667 0.330578 15.1944444 0.327733 15.1972222 0.325600 15.2000000 0.323822 15.2027778 0.320978 15.2055556 0.321689 15.2083333 0.320622 15.2111111 0.318489 15.2138889 0.317422 15.2166667 0.315289 15.2194444 0.314933 15.2222222 0.315644 15.2250000 0.314933 15.2277778 0.313867 15.2305556 0.312800 15.2333333 0.312800 15.2361111 0.312089 15.2388889 0.313867 15.2416667 0.313511 15.2444444 0.312444 15.2472222 0.311733 15.2500000 0.311733 15.2527778 0.312089 15.2555556 0.312800 15.2583333 0.313867 15.2611111 0.313867 15.2613333 0.300000 15.2638889 0.312089 15.2666667 0.311378 15.2694444 0.311733 15.2722222 0.312444 15.2750000 0.312089 15.2777778 0.312800 15.2805556 0.311733 15.2833333 0.311378 15.2861111 0.311378 15.2888889 0.312089 15.2916667 0.312800 15.2944444 0.312444 15.2972222 0.311022 15.3000000 0.311378 15.3027778 0.312089 15.3055556 0.312800 15.3083333 0.312800 15.3111111 0.312444 15.3138889 0.311022 15.3166667 0.309956 15.3194444 0.308178 15.3222222 0.309244 15.3250000 0.308533 15.3277778 0.306400 15.3305556 0.303556 15.3333333 0.299644 15.3361111 0.297867 15.3388889 0.295378 15.3416667 0.292178 15.3444444 0.288267 15.3472222 0.282933 15.3500000 0.277600 15.3527778 0.272978 15.3555556 0.269067 15.3583333 0.265867 15.3611111 0.261956 15.3638889 0.256622 15.3666667 0.252356 15.3694444 0.248444 15.3722222 0.245956 15.3750000 0.244178 15.3777778 0.242044 15.3805556 0.240978 15.3833333 0.239556 15.3861111 0.239556 15.3888889 0.241333 15.3916667 0.242400 15.3944444 0.247022 15.3972222 0.249156 15.4000000 0.253422 15.4027778 0.259467 15.4055556 0.264800 15.4083333 0.271911 15.4111111 0.277956 15.4138889 0.280444 15.4166667 0.282578 15.4194444 0.283289 15.4222222 0.285422 15.4250000 0.287556 15.4277778 0.287200 15.4305556 0.287556 15.4333333 0.286844 15.4361111 0.287911 15.4388889 0.286844 15.4416667 0.288267 15.4444444 0.289333 15.4472222 0.291822 15.4500000 0.296444 15.4527778 0.302489 15.4555556 0.307822 15.4583333 0.311378 15.4611111 0.313867 15.4638889 0.315289 15.4666667 0.315644 15.4694444 0.317067 15.4722222 0.319200 15.4750000 0.319911 15.4777778 0.321689 15.4805556 0.320978 15.4833333 0.321689 15.4861111 0.323467 15.4888889 0.325956 15.4916667 0.326667 15.4944444 0.327378 15.4972222 0.326667 15.5000000 0.326311 15.5027778 0.327022 15.5055556 0.328800 15.5083333 0.328800 15.5111111 0.329867 15.5138889 0.328800 15.5166667 0.329156 15.5194444 0.329156 15.5222222 0.331289 15.5250000 0.332356 15.5277778 0.332711 15.5305556 0.332356 15.5333333 0.332356 15.5361111 0.333422 15.5388889 0.334489 15.5416667 0.335556 15.5444444 0.335200 15.5472222 0.335200 15.5500000 0.334844 15.5527778 0.336267 15.5555556 0.336978 15.5583333 0.338400 15.5611111 0.339111 15.5638889 0.338044 15.5666667 0.338044 15.5694444 0.338756 15.5722222 0.340533 15.5750000 0.340889 15.5777778 0.341244 15.5805556 0.340533 15.5833333 0.339111 15.5861111 0.339111 15.5888889 0.340178 15.5916667 0.340533 15.5944444 0.339822 15.5972222 0.338756 15.6000000 0.336978 15.6027778 0.337333 15.6055556 0.336622 15.6083333 0.336978 15.6111111 0.335911 15.6138889 0.334133 15.6166667 0.332711 15.6194444 0.332000 15.6222222 0.331289 15.6250000 0.329867 15.6277778 0.329156 15.6305556 0.328444 15.6333333 0.325244 15.6361111 0.323822 15.6388889 0.324533 15.6416667 0.322756 15.6444444 0.321333 15.6472222 0.319911 15.6500000 0.317422 15.6527778 0.316711 15.6555556 0.317778 15.6583333 0.316711 15.6611111 0.315644 15.6638889 0.313511 15.6666667 0.312800 15.6694444 0.312444 15.6722222 0.312444 15.6750000 0.312800 15.6777778 0.311733 15.6805556 0.310667 15.6833333 0.309600 15.6891111 0.300000 16.0525556 0.300000 16.0555556 0.306756 16.0583333 0.306756 16.0611111 0.305689 16.0638889 0.306044 16.0666667 0.305333 16.0694444 0.304978 16.0722222 0.305689 16.0750000 0.306044 16.0777778 0.306400 16.0805556 0.305333 16.0833333 0.304978 16.0861111 0.306044 16.0888889 0.306044 16.0916667 0.307111 16.0944444 0.306756 16.0972222 0.306044 16.1000000 0.305689 16.1027778 0.306756 16.1055556 0.306756 16.1083333 0.307467 16.1111111 0.307822 16.1138889 0.306044 16.1166667 0.306400 16.1194444 0.306400 16.1222222 0.306756 16.1250000 0.307467 16.1277778 0.308533 16.1305556 0.307111 16.1333333 0.306400 16.1361111 0.306756 16.1388889 0.307822 16.1416667 0.309600 16.1444444 0.310311 16.1472222 0.309600 16.1500000 0.309244 16.1527778 0.309956 16.1555556 0.310667 16.1583333 0.311733 16.1611111 0.311022 16.1638889 0.309600 16.1666667 0.309244 16.1694444 0.308889 16.1722222 0.307467 16.1750000 0.307111 16.1777778 0.305689 16.1805556 0.304267 16.1833333 0.304267 16.1861111 0.304978 16.1888889 0.305333 16.1916667 0.305333 16.1944444 0.304267 16.1972222 0.303911 16.2000000 0.303911 16.2027778 0.303911 16.2055556 0.305333 16.2083333 0.304978 16.2111111 0.306044 16.2138889 0.306400 16.2166667 0.304978 16.2194444 0.305689 16.2222222 0.306044 16.2250000 0.306400 16.2277778 0.306756 16.2305556 0.305689 16.2333333 0.304267 16.2361111 0.305333 16.2388889 0.304978 16.2416667 0.306400 16.2444444 0.306400 16.2472222 0.304978 16.2500000 0.304622 16.2527778 0.305689 16.2555556 0.306044 16.2583333 0.306756 16.2611111 0.306044 16.2638889 0.304978 16.2666667 0.304978 16.2694444 0.303911 16.2722222 0.303911 16.2750000 0.304267 16.2777778 0.305333 16.2805556 0.304622 16.2833333 0.302133 16.2861111 0.298222 16.2888889 0.293600 16.2916667 0.290044 16.2944444 0.287911 16.2972222 0.286844 16.3000000 0.284356 16.3027778 0.282578 16.3055556 0.283289 16.3083333 0.286489 16.3111111 0.291822 16.3138889 0.293244 16.3166667 0.294667 16.3194444 0.296089 16.3222222 0.297511 16.3250000 0.297156 16.3277778 0.296800 16.3305556 0.296089 16.3333333 0.298222 16.3361111 0.301067 16.3388889 0.303911 16.3416667 0.305333 16.3444444 0.306756 16.3472222 0.306044 16.3500000 0.307111 16.3527778 0.307467 16.3555556 0.308533 16.3583333 0.308533 16.3611111 0.308533 16.3638889 0.308178 16.3666667 0.307822 16.3694444 0.307467 16.3722222 0.308889 16.3750000 0.309244 16.3777778 0.309244 16.3805556 0.308533 16.3833333 0.307467 16.3861111 0.307822 16.3888889 0.308533 16.3916667 0.309244 16.3944444 0.308533 16.3972222 0.307822 16.4000000 0.308889 16.4027778 0.308889 16.4055556 0.309244 16.4083333 0.308533 16.4111111 0.307467 16.4138889 0.307467 16.4166667 0.306400 16.4194444 0.306044 16.4222222 0.307111 16.4250000 0.307822 16.4277778 0.307111 16.4305556 0.306044 16.4333333 0.304622 16.4361111 0.304978 16.4388889 0.305689 16.4416667 0.304978 16.4444444 0.304978 16.4472222 0.304622 16.4500000 0.303911 16.4527778 0.303911 16.4555556 0.304622 16.4583333 0.305333 16.4611111 0.304267 16.4638889 0.303200 16.4666667 0.302133 16.4694444 0.302844 16.4722222 0.302489 16.4750000 0.303200 16.4777778 0.302133 16.4805556 0.300711 16.4833333 0.299289 16.4861111 0.299289 16.4888889 0.299644 16.4916667 0.298933 16.4944444 0.298222 16.4972222 0.296800 16.5000000 0.296089 16.5027778 0.295733 16.5055556 0.294667 16.5083333 0.295378 16.5111111 0.294311 16.5138889 0.292889 16.5166667 0.292178 16.5194444 0.291822 16.5222222 0.292178 16.5250000 0.291822 16.5277778 0.291111 16.5305556 0.288978 16.5333333 0.288622 16.5361111 0.288978 16.5388889 0.289333 16.5416667 0.289689 16.5444444 0.289333 16.5472222 0.288622 16.5500000 0.287556 16.5527778 0.288622 16.5555556 0.289333 16.5583333 0.289689 16.5611111 0.290400 16.5638889 0.290044 16.5666667 0.290044 16.5694444 0.292178 16.5722222 0.293244 16.5750000 0.294311 16.5777778 0.295022 16.5805556 0.295378 16.5833333 0.295733 16.5861111 0.297156 16.5888889 0.299644 16.5916667 0.300711 16.5944444 0.302133 16.5972222 0.302489 16.6000000 0.303556 16.6027778 0.304622 16.6085556 0.300000 16.6247778 0.300000 16.6277778 0.311733 16.6305556 0.311378 16.6333333 0.311733 16.6361111 0.313156 16.6388889 0.313511 16.6416667 0.314222 16.6444444 0.314222 16.6472222 0.313156 16.6500000 0.313156 16.6527778 0.313511 16.6555556 0.314222 16.6583333 0.313867 16.6611111 0.314578 16.6638889 0.312800 16.6666667 0.312800 16.6694444 0.313511 16.6722222 0.314222 16.6750000 0.314222 16.6777778 0.313511 16.6805556 0.313511 16.6833333 0.312444 16.6861111 0.313156 16.6888889 0.314578 16.6916667 0.314933 16.6944444 0.313867 16.6972222 0.313156 16.7000000 0.313156 16.7027778 0.312800 16.7055556 0.313867 16.7083333 0.313867 16.7111111 0.313511 16.7138889 0.312800 16.7166667 0.311378 16.7194444 0.311378 16.7222222 0.312800 16.7250000 0.312800 16.7277778 0.312800 16.7305556 0.311022 16.7333333 0.309956 16.7361111 0.311733 16.7388889 0.312089 16.7416667 0.312444 16.7444444 0.312444 16.7472222 0.311022 16.7500000 0.311378 16.7527778 0.311378 16.7555556 0.311733 16.7583333 0.312089 16.7611111 0.311733 16.7638889 0.311378 16.7666667 0.311022 16.7694444 0.311022 16.7722222 0.312444 16.7750000 0.313867 16.7777778 0.313156 16.7805556 0.314222 16.7833333 0.314222 16.7861111 0.315289 16.7888889 0.316711 16.7916667 0.318133 16.7944444 0.318489 16.7972222 0.316711 16.8000000 0.315644 16.8027778 0.315644 16.8055556 0.314933 16.8083333 0.314222 16.8111111 0.311378 16.8138889 0.307822 16.8166667 0.303911 16.8194444 0.302133 16.8222222 0.300711 16.8250000 0.299289 16.8277778 0.294311 16.8305556 0.287911 16.8333333 0.279378 16.8361111 0.272267 16.8388889 0.266222 16.8416667 0.260178 16.8444444 0.255556 16.8472222 0.250933 16.8500000 0.246311 16.8527778 0.242400 16.8555556 0.238489 16.8583333 0.231733 16.8611111 0.228533 16.8638889 0.224267 16.8666667 0.222133 16.8694444 0.220711 16.8722222 0.218933 16.8750000 0.216800 16.8777778 0.216444 16.8805556 0.217511 16.8833333 0.220356 16.8861111 0.224267 16.8888889 0.229956 16.8916667 0.235644 16.8944444 0.242044 16.8972222 0.248089 16.9000000 0.256622 16.9027778 0.265867 16.9055556 0.274044 16.9083333 0.278311 16.9111111 0.283289 16.9138889 0.284711 16.9166667 0.286489 16.9194444 0.289333 16.9222222 0.291111 16.9250000 0.292533 16.9277778 0.292178 16.9305556 0.292533 16.9333333 0.292889 16.9361111 0.293600 16.9388889 0.294667 16.9416667 0.296444 16.9444444 0.297867 16.9472222 0.301778 16.9500000 0.306044 16.9527778 0.311733 16.9555556 0.317778 16.9583333 0.321689 16.9611111 0.324178 16.9638889 0.326311 16.9666667 0.326667 16.9694444 0.328444 16.9722222 0.330222 16.9750000 0.331289 16.9777778 0.332356 16.9805556 0.332356 16.9833333 0.332356 16.9861111 0.332711 16.9888889 0.334489 16.9916667 0.336267 16.9944444 0.336267 16.9972222 0.335556 17.0000000 0.335911 17.0027778 0.336978 17.0055556 0.338400 17.0083333 0.340533 17.0111111 0.340533 17.0138889 0.339822 17.0166667 0.341244 17.0194444 0.341600 17.0222222 0.343022 17.0250000 0.345156 17.0277778 0.345156 17.0305556 0.346222 17.0333333 0.346933 17.0361111 0.347644 17.0388889 0.349778 17.0416667 0.350844 17.0444444 0.352267 17.0472222 0.352267 17.0500000 0.353333 17.0527778 0.354400 17.0555556 0.356533 17.0583333 0.357956 17.0611111 0.358311 17.0638889 0.358667 17.0666667 0.359022 17.0694444 0.360444 17.0722222 0.361511 17.0750000 0.362578 17.0777778 0.362933 17.0805556 0.362578 17.0833333 0.362578 17.0861111 0.364000 17.0888889 0.364711 17.0916667 0.366133 17.0944444 0.365067 17.0972222 0.363289 17.1000000 0.362222 17.1027778 0.361867 17.1055556 0.361867 17.1083333 0.361511 17.1111111 0.358667 17.1138889 0.357600 17.1166667 0.355467 17.1194444 0.353689 17.1222222 0.352622 17.1250000 0.351911 17.1277778 0.349422 17.1305556 0.346933 17.1333333 0.343733 17.1361111 0.343022 17.1388889 0.341956 17.1416667 0.340533 17.1444444 0.337333 17.1472222 0.334133 17.1500000 0.332000 17.1527778 0.330578 17.1555556 0.329867 17.1583333 0.329156 17.1611111 0.326667 17.1638889 0.323822 17.1666667 0.322756 17.1694444 0.323111 17.1722222 0.323467 17.1750000 0.323467 17.1775556 0.300000 17.1805556 0.320978 17.1807778 0.300000 17.1833333 0.320267 17.1861111 0.320978 17.1888889 0.322044 17.1916667 0.321333 17.1944444 0.321333 17.1972222 0.320978 17.2000000 0.320267 17.2027778 0.320622 17.2055556 0.320978 17.2083333 0.321689 17.2111111 0.321333 17.2138889 0.320267 17.2166667 0.319200 17.2194444 0.319911 17.2222222 0.320267 17.2250000 0.320622 17.2277778 0.320267 17.2305556 0.319200 17.2333333 0.318489 17.2361111 0.320622 17.2388889 0.320622 17.2416667 0.321333 17.2444444 0.320267 17.2472222 0.319200 17.2500000 0.319911 17.2527778 0.319911 17.2555556 0.320622 17.2583333 0.321689 17.2611111 0.322044 17.2638889 0.322400 17.2666667 0.322400 17.2694444 0.322400 17.2722222 0.323822 17.2750000 0.324178 17.2777778 0.323467 17.2805556 0.322400 17.2833333 0.323111 17.2861111 0.325244 17.2888889 0.327733 17.2916667 0.327378 17.2944444 0.327378 17.2972222 0.325600 17.3000000 0.325244 17.3027778 0.324889 17.3055556 0.324533 17.3083333 0.323111 17.3111111 0.323111 17.3138889 0.321333 17.3166667 0.320267 17.3194444 0.320622 17.3222222 0.320978 17.3250000 0.321689 17.3277778 0.320978 17.3305556 0.319911 17.3333333 0.319911 17.3361111 0.319911 17.3388889 0.319911 17.3416667 0.319911 17.3444444 0.318844 17.3472222 0.318489 17.3500000 0.317422 17.3527778 0.318133 17.3555556 0.318844 17.3583333 0.319556 17.3611111 0.318844 17.3638889 0.316711 17.3666667 0.315289 17.3694444 0.314933 17.3722222 0.314933 17.3750000 0.311733 17.3777778 0.309956 17.3805556 0.307111 17.3833333 0.302844 17.3861111 0.298933 17.3888889 0.294311 17.3916667 0.288622 17.3944444 0.280444 17.3972222 0.271200 17.4000000 0.263378 17.4027778 0.256267 17.4055556 0.252356 17.4083333 0.246667 17.4111111 0.240267 17.4138889 0.234933 17.4166667 0.229244 17.4194444 0.224978 17.4222222 0.223200 17.4250000 0.221422 17.4277778 0.218933 17.4305556 0.216089 17.4333333 0.215733 17.4361111 0.217511 17.4388889 0.221067 17.4416667 0.225689 17.4444444 0.229956 17.4472222 0.232800 17.4500000 0.239556 17.4527778 0.248089 17.4555556 0.257689 17.4583333 0.264800 17.4611111 0.270489 17.4638889 0.273689 17.4666667 0.277600 17.4694444 0.282222 17.4722222 0.285778 17.4750000 0.288267 17.4777778 0.291467 17.4805556 0.293600 17.4833333 0.295378 17.4861111 0.295733 17.4888889 0.297867 17.4916667 0.298578 17.4944444 0.302133 17.4972222 0.306400 17.5000000 0.313156 17.5027778 0.319556 17.5055556 0.327022 17.5083333 0.332356 17.5111111 0.334133 17.5138889 0.335911 17.5166667 0.338044 17.5194444 0.339822 17.5222222 0.341956 17.5250000 0.343022 17.5277778 0.343378 17.5305556 0.343733 17.5333333 0.344444 17.5361111 0.347644 17.5388889 0.350844 17.5416667 0.353689 17.5444444 0.356533 17.5472222 0.358667 17.5500000 0.361156 17.5527778 0.360444 17.5555556 0.360089 17.5583333 0.359378 17.5611111 0.356889 17.5638889 0.355467 17.5666667 0.353689 17.5694444 0.353333 17.5722222 0.355111 17.5750000 0.354756 17.5777778 0.353689 17.5805556 0.351911 17.5833333 0.351911 17.5861111 0.352978 17.5888889 0.354044 17.5916667 0.354400 17.5944444 0.354400 17.5972222 0.354400 17.6000000 0.354400 17.6027778 0.355467 17.6055556 0.356178 17.6083333 0.358311 17.6111111 0.359022 17.6138889 0.358667 17.6166667 0.358667 17.6194444 0.359733 17.6222222 0.361867 17.6250000 0.362933 17.6277778 0.363644 17.6305556 0.363289 17.6333333 0.361511 17.6361111 0.362933 17.6388889 0.362933 17.6416667 0.363644 17.6444444 0.362578 17.6472222 0.361156 17.6500000 0.359733 17.6527778 0.358311 17.6555556 0.357956 17.6583333 0.356533 17.6611111 0.356178 17.6638889 0.354044 17.6666667 0.350489 17.6694444 0.348711 17.6722222 0.346578 17.6750000 0.344800 17.6777778 0.340533 17.6805556 0.336978 17.6833333 0.332711 17.6861111 0.329511 17.6888889 0.328444 17.6916667 0.326311 17.6944444 0.322400 17.6972222 0.317778 17.7000000 0.315289 17.7027778 0.312800 17.7055556 0.311022 17.7083333 0.309956 17.7111111 0.307822 17.7138889 0.304978 17.7166667 0.303911 17.7194444 0.303556 17.7222222 0.303200 17.7250000 0.302844 17.7277778 0.301422 17.7335556 0.300000 17.9414444 0.300000 17.9444444 0.306756 17.9472222 0.304978 17.9500000 0.304267 17.9527778 0.304267 17.9555556 0.305333 17.9583333 0.305333 17.9611111 0.303556 17.9638889 0.303556 17.9666667 0.301778 17.9694444 0.302844 17.9722222 0.303200 17.9750000 0.303200 17.9777778 0.302489 17.9805556 0.301067 17.9833333 0.300356 17.9861111 0.300711 17.9888889 0.301067 17.9916667 0.299644 17.9944444 0.300000 17.9972222 0.298933 18.0000000 0.298222 18.0027778 0.297867 18.0055556 0.298578 18.0083333 0.297867 18.0111111 0.297156 18.0138889 0.295022 18.0166667 0.295022 18.0194444 0.294311 18.0222222 0.296444 18.0250000 0.295733 18.0277778 0.295733 18.0305556 0.296089 18.0333333 0.295378 18.0361111 0.296089 18.0388889 0.297511 18.0416667 0.297867 18.0444444 0.296800 18.0472222 0.296089 18.0500000 0.295022 18.0527778 0.294667 18.0555556 0.295378 18.0583333 0.295022 18.0611111 0.294667 18.0638889 0.292178 18.0666667 0.290044 18.0694444 0.288622 18.0722222 0.290044 18.0750000 0.289689 18.0777778 0.290044 18.0805556 0.289333 18.0833333 0.289689 18.0861111 0.290044 18.0888889 0.290044 18.0916667 0.290044 18.0944444 0.290400 18.0972222 0.290044 18.1000000 0.291111 18.1027778 0.291822 18.1055556 0.293244 18.1083333 0.293600 18.1111111 0.293244 18.1138889 0.292178 18.1166667 0.292533 18.1194444 0.293244 18.1222222 0.295022 18.1250000 0.294667 18.1277778 0.295378 18.1305556 0.294667 18.1333333 0.292889 18.1361111 0.294311 18.1388889 0.294667 18.1416667 0.295022 18.1444444 0.295022 18.1472222 0.293600 18.1500000 0.293244 18.1527778 0.293956 18.1555556 0.293956 18.1583333 0.293600 18.1611111 0.292178 18.1638889 0.290044 18.1666667 0.291467 18.1694444 0.292533 18.1722222 0.290756 18.1750000 0.286133 18.1777778 0.277956 18.1805556 0.272267 18.1833333 0.265867 18.1861111 0.264444 18.1888889 0.263733 18.1916667 0.263022 18.1944444 0.265867 18.1972222 0.272267 18.2000000 0.279733 18.2027778 0.287911 18.2055556 0.293244 18.2083333 0.294311 18.2111111 0.290756 18.2138889 0.285422 18.2166667 0.283644 18.2194444 0.284356 18.2222222 0.286844 18.2250000 0.288978 18.2277778 0.290400 18.2305556 0.289333 18.2333333 0.288978 18.2361111 0.290044 18.2388889 0.291467 18.2416667 0.292178 18.2444444 0.291467 18.2472222 0.291111 18.2500000 0.290756 18.2527778 0.291111 18.2555556 0.291822 18.2583333 0.290756 18.2611111 0.290756 18.2638889 0.289333 18.2666667 0.288267 18.2694444 0.288267 18.2722222 0.288622 18.2750000 0.287911 18.2777778 0.287200 18.2805556 0.285778 18.2833333 0.286489 18.2861111 0.287911 18.2888889 0.288622 18.2916667 0.289333 18.2944444 0.289333 18.2972222 0.288978 18.3000000 0.288267 18.3027778 0.287911 18.3055556 0.288267 18.3083333 0.289333 18.3111111 0.290400 18.3138889 0.290400 18.3166667 0.290756 18.3194444 0.290044 18.3222222 0.290400 18.3250000 0.290756 18.3277778 0.291822 18.3305556 0.289333 18.3333333 0.288622 18.3361111 0.289689 18.3388889 0.291822 18.3416667 0.291111 18.3444444 0.291111 18.3472222 0.290400 18.3500000 0.290044 18.3527778 0.289333 18.3555556 0.290044 18.3583333 0.289333 18.3611111 0.288622 18.3638889 0.287200 18.3666667 0.288622 18.3694444 0.288978 18.3722222 0.288978 18.3750000 0.288622 18.3777778 0.287556 18.3805556 0.285778 18.3833333 0.282222 18.3861111 0.281156 18.3888889 0.280800 18.3916667 0.279378 18.3944444 0.276889 18.3972222 0.274756 18.4000000 0.273689 18.4027778 0.274044 18.4055556 0.274756 18.4083333 0.274756 18.4111111 0.274400 18.4138889 0.271200 18.4166667 0.270489 18.4194444 0.270489 18.4222222 0.271556 18.4250000 0.272978 18.4277778 0.273689 18.4305556 0.274400 18.4333333 0.275467 18.4361111 0.276889 18.4388889 0.279022 18.4416667 0.280444 18.4444444 0.281511 18.4472222 0.283289 18.4500000 0.283289 18.4527778 0.286489 18.4555556 0.289333 18.4583333 0.290400 18.4611111 0.292178 18.4638889 0.292889 18.4666667 0.293956 18.4694444 0.296089 18.4722222 0.298578 18.4750000 0.300000 18.4777778 0.300000 18.4805556 0.299644 18.4833333 0.299289 18.4861111 0.299644 18.4886667 0.300000 18.4888889 0.301422 18.4916667 0.302489 18.4944444 0.302844 18.4972222 0.304267 18.4974444 0.300000 18.5000000 0.306400 18.5027778 0.308533 18.5055556 0.309600 18.5083333 0.309600 18.5111111 0.309600 18.5138889 0.309244 18.5166667 0.308889 18.5194444 0.309600 18.5222222 0.308178 18.5250000 0.306400 18.5277778 0.304267 18.5305556 0.301778 18.5333333 0.302133 18.5361111 0.303911 18.5388889 0.304978 18.5416667 0.304267 18.5444444 0.303911 18.5472222 0.301067 18.5500000 0.300711 18.5527778 0.300356 18.5555556 0.301067 18.5583333 0.301422 18.5611111 0.301067 18.5638889 0.300356 18.5666667 0.300711 18.5694444 0.300711 18.5722222 0.302133 18.5750000 0.302489 18.5777778 0.303556 18.5805556 0.303200 18.5833333 0.302844 18.5861111 0.304267 18.5888889 0.304267 18.5916667 0.304978 18.5944444 0.304622 18.5972222 0.303911 18.6000000 0.302844 18.6027778 0.303556 18.6055556 0.303556 18.6083333 0.303911 18.6111111 0.301778 18.6138889 0.299644 18.6166667 0.298222 18.6194444 0.296800 18.6222222 0.297511 18.6250000 0.297511 18.6277778 0.298578 18.6305556 0.298933 18.6333333 0.297511 18.6361111 0.298222 18.6388889 0.300711 18.6416667 0.302489 18.6444444 0.303556 18.6472222 0.303911 18.6500000 0.303556 18.6527778 0.302844 18.6555556 0.302844 18.6583333 0.302133 18.6611111 0.302489 18.6638889 0.300356 18.6666667 0.300000 18.6694444 0.298933 18.6722222 0.300356 18.6750000 0.301778 18.6777778 0.302844 18.6805556 0.302489 18.6833333 0.302133 18.6861111 0.302489 18.6888889 0.304622 18.6916667 0.307467 18.6944444 0.307467 18.6972222 0.307822 18.7000000 0.304622 18.7027778 0.301778 18.7055556 0.297867 18.7083333 0.292178 18.7111111 0.284711 18.7138889 0.276533 18.7166667 0.271200 18.7194444 0.264800 18.7222222 0.256267 18.7250000 0.246667 18.7277778 0.236356 18.7305556 0.226756 18.7333333 0.222133 18.7361111 0.219644 18.7388889 0.218578 18.7416667 0.221422 18.7444444 0.228889 18.7472222 0.239556 18.7500000 0.251644 18.7527778 0.263378 18.7555556 0.274044 18.7583333 0.280089 18.7611111 0.283644 18.7638889 0.286133 18.7666667 0.288978 18.7694444 0.292889 18.7722222 0.297156 18.7750000 0.300000 18.7777778 0.300356 18.7805556 0.300711 18.7833333 0.300356 18.7861111 0.302489 18.7888889 0.302489 18.7916667 0.302844 18.7944444 0.301067 18.7972222 0.300711 18.8000000 0.302489 18.8027778 0.306400 18.8055556 0.310667 18.8083333 0.310667 18.8111111 0.311022 18.8138889 0.311733 18.8166667 0.312800 18.8194444 0.313511 18.8222222 0.312444 18.8250000 0.311733 18.8277778 0.312089 18.8305556 0.311378 18.8333333 0.307467 18.8361111 0.303556 18.8388889 0.301778 18.8416667 0.304267 18.8444444 0.309244 18.8472222 0.311733 18.8500000 0.311022 18.8527778 0.308533 18.8555556 0.306044 18.8583333 0.306400 18.8611111 0.308533 18.8638889 0.310667 18.8666667 0.312444 18.8694444 0.314933 18.8722222 0.313867 18.8750000 0.310311 18.8777778 0.307467 18.8805556 0.306044 18.8833333 0.307111 18.8861111 0.310667 18.8888889 0.311733 18.8916667 0.312089 18.8944444 0.311733 18.8972222 0.311378 18.9000000 0.312089 18.9027778 0.313156 18.9055556 0.314578 18.9083333 0.315644 18.9111111 0.318489 18.9138889 0.320267 18.9166667 0.318489 18.9194444 0.314933 18.9222222 0.309600 18.9250000 0.302844 18.9277778 0.302489 18.9305556 0.303556 18.9333333 0.304978 18.9361111 0.302844 18.9388889 0.300000 18.9416667 0.301778 18.9444444 0.306044 18.9470000 0.300000 18.9472222 0.312089 18.9500000 0.316711 18.9527778 0.319911 18.9555556 0.318844 18.9583333 0.311733 18.9611111 0.304622 18.9638889 0.297511 18.9666667 0.297867 18.9694444 0.300711 18.9722222 0.305333 18.9750000 0.304978 18.9777778 0.301778 18.9805556 0.299644 18.9833333 0.304267 18.9861111 0.317778 18.9888889 0.330578 18.9916667 0.332000 18.9944444 0.322400 18.9972222 0.309956 19.0000000 0.308178 19.0027778 0.318133 19.0055556 0.329511 19.0083333 0.331644 19.0111111 0.321689 19.0138889 0.309600 19.0166667 0.305689 19.0194444 0.309956 19.0222222 0.317422 19.0250000 0.322756 19.0277778 0.329867 19.0305556 0.348000 19.0333333 0.375733 19.0361111 0.403467 19.0388889 0.418400 19.0416667 0.413778 19.0444444 0.389600 19.0446667 0.300000 19.0472222 0.357244 19.0500000 0.328444 19.0527778 0.312800 19.0555556 0.309600 19.0583333 0.302489 19.0611111 0.285067 19.0638889 0.266222 19.0666667 0.260178 19.0694444 0.266578 19.0722222 0.275111 19.0750000 0.276178 19.0777778 0.274400 19.0805556 0.277600 19.0833333 0.284356 19.0861111 0.289689 19.0888889 0.297511 19.0916667 0.313156 19.0944444 0.333422 19.0972222 0.347289 19.1000000 0.343378 19.1027778 0.320978 19.1055556 0.298933 19.1083333 0.287911 19.1111111 0.290044 19.1138889 0.301778 19.1166667 0.315289 19.1194444 0.321689 19.1222222 0.316000 19.1250000 0.308178 19.1277778 0.303200 19.1305556 0.301422 19.1333333 0.299644 19.1361111 0.296444 19.1388889 0.297867 19.1416667 0.302844 19.1444444 0.313156 19.1472222 0.318133 19.1500000 0.309600 19.1527778 0.289689 19.1555556 0.269067 19.1583333 0.259467 19.1611111 0.256978 19.1638889 0.254489 19.1666667 0.249156 19.1694444 0.248444 19.1722222 0.258044 19.1750000 0.266578 19.1777778 0.260178 19.1805556 0.238844 19.1833333 0.216089 19.1861111 0.205067 19.1888889 0.205422 19.1916667 0.211111 19.1944444 0.214667 19.1972222 0.211111 19.2000000 0.202933 19.2027778 0.195111 19.2055556 0.195822 19.2083333 0.202578 19.2111111 0.212533 19.2138889 0.223200 19.2166667 0.233511 19.2194444 0.246667 19.2222222 0.257333 19.2250000 0.263378 19.2277778 0.267644 19.2305556 0.270844 19.2333333 0.274400 19.2361111 0.278667 19.2388889 0.279378 19.2416667 0.276178 19.2444444 0.274400 19.2472222 0.274400 19.2500000 0.278667 19.2527778 0.282222 19.2555556 0.282222 19.2583333 0.282222 19.2611111 0.282222 19.2638889 0.285067 19.2666667 0.291467 19.2694444 0.301778 19.2722222 0.312444 19.2750000 0.318133 19.2777778 0.317422 19.2805556 0.313511 19.2833333 0.312089 19.2861111 0.315289 19.2888889 0.318844 19.2916667 0.317422 19.2944444 0.316000 19.2972222 0.319556 19.3000000 0.322044 19.3027778 0.323467 19.3055556 0.324178 19.3083333 0.324533 19.3111111 0.325600 19.3138889 0.325600 19.3166667 0.323467 19.3194444 0.324178 19.3222222 0.327378 19.3250000 0.332356 19.3277778 0.333778 19.3305556 0.330578 19.3333333 0.330222 19.3361111 0.333067 19.3388889 0.336622 19.3416667 0.338400 19.3444444 0.338044 19.3472222 0.337689 19.3500000 0.338400 19.3527778 0.341600 19.3555556 0.344800 19.3583333 0.347644 19.3611111 0.348356 19.3638889 0.347644 19.3666667 0.349422 19.3694444 0.353333 19.3722222 0.354400 19.3750000 0.353333 19.3777778 0.352622 19.3805556 0.351556 19.3833333 0.352267 19.3861111 0.354400 19.3888889 0.356533 19.3916667 0.356178 19.3944444 0.355822 19.3972222 0.354044 19.4000000 0.349778 19.4027778 0.348711 19.4055556 0.350844 19.4083333 0.352622 19.4111111 0.351911 19.4138889 0.346933 19.4166667 0.343733 19.4194444 0.343378 19.4222222 0.343022 19.4250000 0.340889 19.4277778 0.335911 19.4305556 0.331289 19.4333333 0.325956 19.4361111 0.321689 19.4388889 0.322756 19.4416667 0.322756 19.4444444 0.320978 19.4472222 0.318489 19.4500000 0.314578 19.4527778 0.310667 19.4555556 0.308533 19.4583333 0.307111 19.4611111 0.304978 19.4638889 0.301422 19.4666667 0.298933 19.4694444 0.297156 19.4722222 0.296800 19.4750000 0.294311 19.4777778 0.291111 19.4805556 0.288622 19.4833333 0.285778 19.4861111 0.282933 19.4888889 0.283289 19.4916667 0.284711 19.4944444 0.285778 19.4972222 0.285422 19.5030000 0.300000 19.5803333 0.300000 19.5833333 0.295733 19.5861111 0.297511 19.5888889 0.300356 19.5916667 0.300356 19.5944444 0.297867 19.5972222 0.296089 19.6000000 0.294667 19.6027778 0.295378 19.6055556 0.297156 19.6083333 0.298578 19.6111111 0.298222 19.6138889 0.298578 19.6166667 0.299289 19.6194444 0.301422 19.6222222 0.303911 19.6250000 0.304978 19.6277778 0.306400 19.6305556 0.307467 19.6333333 0.309244 19.6361111 0.311733 19.6388889 0.314222 19.6416667 0.316711 19.6444444 0.318844 19.6472222 0.318489 19.6500000 0.320267 19.6527778 0.322400 19.6555556 0.325244 19.6583333 0.328089 19.6611111 0.328444 19.6638889 0.329867 19.6666667 0.329511 19.6694444 0.332000 19.6722222 0.333778 19.6750000 0.334489 19.6777778 0.333778 19.6805556 0.333067 19.6833333 0.332356 19.6861111 0.333422 19.6888889 0.334489 19.6916667 0.334489 19.6944444 0.335200 19.6972222 0.332711 19.7000000 0.330933 19.7027778 0.328089 19.7055556 0.323467 19.7083333 0.317778 19.7111111 0.309600 19.7138889 0.303556 19.7166667 0.297867 19.7194444 0.294667 19.7222222 0.293600 19.7250000 0.293244 19.7277778 0.292178 19.7305556 0.290400 19.7333333 0.290756 19.7361111 0.292178 19.7388889 0.295022 19.7416667 0.294667 19.7444444 0.293600 19.7472222 0.290756 19.7500000 0.289333 19.7527778 0.288622 19.7555556 0.290044 19.7583333 0.290756 19.7611111 0.291467 19.7638889 0.291111 19.7666667 0.291111 19.7694444 0.292178 19.7722222 0.293244 19.7750000 0.293956 19.7777778 0.293956 19.7805556 0.291467 19.7833333 0.292533 19.7861111 0.292889 19.7888889 0.294311 19.7916667 0.294311 19.7944444 0.294311 19.7972222 0.293244 19.8000000 0.292533 19.8027778 0.292178 19.8055556 0.292178 19.8083333 0.293600 19.8111111 0.293244 19.8138889 0.291111 19.8166667 0.287911 19.8194444 0.282933 19.8222222 0.278667 19.8250000 0.276889 19.8277778 0.275467 19.8305556 0.273689 19.8333333 0.273333 19.8361111 0.276533 19.8388889 0.284711 19.8416667 0.293244 19.8444444 0.297156 19.8472222 0.295378 19.8500000 0.294311 19.8527778 0.292533 19.8555556 0.291467 19.8583333 0.290756 19.8611111 0.291111 19.8638889 0.291467 19.8666667 0.293244 19.8694444 0.293956 19.8722222 0.293956 19.8750000 0.295022 19.8777778 0.294667 19.8805556 0.294311 19.8833333 0.292889 19.8861111 0.292533 19.8888889 0.293956 19.8916667 0.294667 19.8944444 0.295733 19.8972222 0.296444 19.9000000 0.297511 19.9027778 0.299644 19.9055556 0.301778 19.9083333 0.303556 19.9111111 0.303556 19.9138889 0.303556 19.9166667 0.303200 19.9194444 0.304622 19.9222222 0.304978 19.9250000 0.304978 19.9277778 0.303911 19.9305556 0.303911 19.9333333 0.302489 19.9361111 0.303556 19.9388889 0.304267 19.9416667 0.305689 19.9444444 0.305333 19.9472222 0.306044 19.9500000 0.304622 19.9527778 0.304978 19.9555556 0.305689 19.9583333 0.305333 19.9611111 0.303911 19.9638889 0.302489 19.9666667 0.300711 19.9694444 0.301067 19.9722222 0.299644 19.9750000 0.297867 19.9777778 0.295022 19.9805556 0.292889 19.9833333 0.291111 19.9861111 0.289689 19.9888889 0.288978 19.9916667 0.286489 19.9944444 0.284356 19.9972222 0.281867 20.0000000 0.279733 20.0027778 0.278311 20.0055556 0.278667 20.0083333 0.276889 20.0111111 0.274756 20.0138889 0.273689 20.0166667 0.273333 20.0194444 0.272978 20.0222222 0.274044 20.0250000 0.271911 20.0277778 0.270489 20.0305556 0.268000 20.0333333 0.266578 20.0361111 0.266222 20.0388889 0.267644 20.0416667 0.266578 20.0444444 0.265511 20.0472222 0.262667 20.0500000 0.261956 20.0527778 0.263378 20.0555556 0.264444 20.0583333 0.265511 20.0611111 0.265867 20.0638889 0.266222 20.0666667 0.267289 20.0694444 0.269067 20.0722222 0.270844 20.0750000 0.275111 20.0777778 0.277244 20.0803333 0.300000 20.0805556 0.279022 20.0833333 0.280800 20.0861111 0.282933 20.0888889 0.285422 20.0916667 0.288267 20.0944444 0.289689 20.0972222 0.288978 20.1000000 0.290756 20.1027778 0.291822 20.1055556 0.294311 20.1083333 0.296089 20.1111111 0.296089 20.1138889 0.296800 20.1166667 0.296444 20.1194444 0.297511 20.1222222 0.296444 20.1250000 0.296089 20.1277778 0.293956 20.1305556 0.292178 20.1333333 0.292178 20.1361111 0.291822 20.1363333 0.300000 20.1388889 0.292178 20.1416667 0.291822 20.1444444 0.290044 20.1472222 0.288267 20.1500000 0.287556 20.1527778 0.288622 20.1555556 0.288622 20.1583333 0.289689 20.1611111 0.290400 20.1638889 0.291111 20.1666667 0.290756 20.1694444 0.291467 20.1722222 0.293956 20.1750000 0.294667 20.1777778 0.295733 20.1805556 0.295378 20.1833333 0.296089 20.1861111 0.296444 20.1888889 0.297511 20.1916667 0.297156 20.1944444 0.295022 20.1972222 0.294311 20.2000000 0.293244 20.2027778 0.292533 20.2055556 0.293244 20.2083333 0.292533 20.2111111 0.293956 20.2138889 0.292533 20.2166667 0.290400 20.2194444 0.291111 20.2222222 0.293244 20.2250000 0.295733 20.2277778 0.296444 20.2305556 0.297511 20.2333333 0.295733 20.2361111 0.292178 20.2388889 0.288978 20.2416667 0.286133 20.2444444 0.285778 20.2472222 0.287200 20.2500000 0.288978 20.2527778 0.291111 20.2555556 0.293956 20.2583333 0.296444 20.2611111 0.299644 20.2638889 0.300711 20.2666667 0.303200 20.2694444 0.303911 20.2722222 0.305333 20.2750000 0.307467 20.2777778 0.308178 20.2805556 0.308889 20.2833333 0.309244 20.2861111 0.309956 20.2888889 0.309600 20.2916667 0.309600 20.2944444 0.308178 20.2972222 0.307822 20.3000000 0.308889 20.3027778 0.309600 20.3055556 0.311733 20.3083333 0.313156 20.3111111 0.314933 20.3138889 0.316356 20.3166667 0.314578 20.3194444 0.308178 20.3222222 0.302489 20.3250000 0.300711 20.3277778 0.301067 20.3305556 0.301067 20.3333333 0.299644 20.3361111 0.298578 20.3388889 0.301778 20.3416667 0.303911 20.3444444 0.304978 20.3472222 0.304978 20.3500000 0.305333 20.3527778 0.308889 20.3555556 0.311378 20.3583333 0.316711 20.3611111 0.321689 20.3638889 0.326667 20.3666667 0.328800 20.3694444 0.331644 20.3722222 0.334133 20.3750000 0.336622 20.3777778 0.337689 20.3805556 0.336622 20.3833333 0.336622 20.3861111 0.338044 20.3888889 0.337333 20.3916667 0.336267 20.3944444 0.334133 20.3972222 0.329156 20.4000000 0.325600 20.4027778 0.323822 20.4055556 0.324533 20.4083333 0.324533 20.4111111 0.323822 20.4138889 0.322400 20.4166667 0.321333 20.4194444 0.322044 20.4222222 0.322756 20.4250000 0.323111 20.4277778 0.322044 20.4305556 0.322044 20.4333333 0.321689 20.4361111 0.322044 20.4388889 0.323111 20.4416667 0.324178 20.4444444 0.324533 20.4472222 0.323467 20.4500000 0.323111 20.4527778 0.325244 20.4555556 0.325600 20.4583333 0.325244 20.4611111 0.324889 20.4638889 0.322756 20.4666667 0.322756 20.4694444 0.325244 20.4722222 0.325600 20.4750000 0.325600 20.4777778 0.324178 20.4805556 0.320978 20.4833333 0.317778 20.4861111 0.316711 20.4888889 0.316711 20.4916667 0.315289 20.4944444 0.313511 20.4972222 0.312800 20.5000000 0.312089 20.5027778 0.312800 20.5055556 0.312800 20.5083333 0.312800 20.5111111 0.311378 20.5138889 0.310667 20.5166667 0.308533 20.5194444 0.307822 20.5222222 0.308889 20.5250000 0.308178 20.5277778 0.307822 20.5305556 0.306400 20.5333333 0.304267 20.5361111 0.303911 20.5388889 0.302489 20.5416667 0.302844 20.5444444 0.301778 20.5472222 0.301422 20.5500000 0.300000 20.5527778 0.300711 20.5555556 0.300356 20.5583333 0.301067 20.5611111 0.301422 20.5638889 0.301422 20.5666667 0.301778 20.5694444 0.302844 20.5722222 0.304267 20.5750000 0.306756 20.5777778 0.309600 20.5805556 0.312444 20.5833333 0.314578 20.5861111 0.316356 20.5888889 0.318844 20.5916667 0.318844 20.5944444 0.317778 20.5972222 0.317422 20.6000000 0.318133 20.6027778 0.319556 20.6055556 0.320978 20.6083333 0.323467 20.6111111 0.324178 20.6138889 0.323822 20.6166667 0.323822 20.6194444 0.325600 20.6222222 0.328444 20.6250000 0.329867 20.6277778 0.328800 20.6303333 0.300000 20.6305556 0.327022 20.6333333 0.326667 20.6361111 0.325956 20.6363333 0.300000 20.6388889 0.327022 20.6416667 0.327378 20.6444444 0.325956 20.6472222 0.325600 20.6500000 0.325600 20.6527778 0.326667 20.6555556 0.328800 20.6583333 0.329511 20.6611111 0.329511 20.6638889 0.328800 20.6666667 0.327733 20.6694444 0.328444 20.6722222 0.329156 20.6750000 0.329867 20.6777778 0.328800 20.6805556 0.327022 20.6833333 0.325956 20.6861111 0.325956 20.6888889 0.327378 20.6916667 0.328089 20.6944444 0.327733 20.6972222 0.326667 20.7000000 0.325956 20.7027778 0.326311 20.7055556 0.326311 20.7083333 0.326311 20.7111111 0.324889 20.7138889 0.323467 20.7166667 0.323467 20.7194444 0.325244 20.7222222 0.327378 20.7250000 0.328444 20.7277778 0.328444 20.7305556 0.327733 20.7333333 0.327022 20.7361111 0.328089 20.7388889 0.328800 20.7416667 0.329511 20.7444444 0.328089 20.7472222 0.326667 20.7500000 0.325244 20.7527778 0.324889 20.7555556 0.324178 20.7583333 0.325600 20.7611111 0.323467 20.7638889 0.322400 20.7666667 0.322044 20.7694444 0.322756 20.7722222 0.322756 20.7750000 0.322400 20.7777778 0.321333 20.7805556 0.318489 20.7833333 0.317422 20.7861111 0.317778 20.7888889 0.318489 20.7916667 0.318489 20.7944444 0.318133 20.7972222 0.315644 20.8000000 0.314933 20.8027778 0.314222 20.8055556 0.314578 20.8083333 0.314933 20.8111111 0.313511 20.8138889 0.310667 20.8166667 0.308889 20.8194444 0.307111 20.8222222 0.305333 20.8250000 0.302489 20.8277778 0.297156 20.8305556 0.291111 20.8333333 0.284356 20.8361111 0.277600 20.8388889 0.271911 20.8416667 0.267289 20.8444444 0.261244 20.8472222 0.253422 20.8500000 0.244889 20.8527778 0.237067 20.8555556 0.229244 20.8583333 0.223911 20.8611111 0.221067 20.8638889 0.217511 20.8666667 0.213600 20.8694444 0.208622 20.8722222 0.205778 20.8750000 0.206844 20.8777778 0.210400 20.8805556 0.214667 20.8833333 0.222844 20.8861111 0.236000 20.8888889 0.252356 20.8916667 0.268356 20.8944444 0.283644 20.8972222 0.295378 20.9000000 0.305333 20.9027778 0.311378 20.9055556 0.315644 20.9083333 0.319556 20.9111111 0.323111 20.9138889 0.325244 20.9166667 0.327733 20.9194444 0.331644 20.9222222 0.335200 20.9250000 0.338400 20.9277778 0.339822 20.9305556 0.341244 20.9333333 0.343378 20.9361111 0.346933 20.9388889 0.348000 20.9416667 0.349422 20.9444444 0.350133 20.9472222 0.349422 20.9500000 0.348000 20.9527778 0.346933 20.9555556 0.344089 20.9583333 0.340178 20.9611111 0.334489 20.9638889 0.328089 20.9666667 0.324178 20.9694444 0.322400 20.9722222 0.323467 20.9750000 0.323467 20.9777778 0.323822 20.9805556 0.324178 20.9833333 0.325244 20.9861111 0.328444 20.9888889 0.329867 20.9916667 0.331289 20.9944444 0.332000 20.9972222 0.333067 21.0000000 0.334133 21.0027778 0.336622 21.0055556 0.340533 21.0083333 0.341956 21.0111111 0.343733 21.0138889 0.344089 21.0166667 0.344444 21.0194444 0.345867 21.0222222 0.348000 21.0250000 0.348000 21.0277778 0.349067 21.0305556 0.349067 21.0333333 0.349067 21.0361111 0.350489 21.0388889 0.351556 21.0416667 0.351556 21.0444444 0.351200 21.0472222 0.349422 21.0500000 0.349422 21.0527778 0.350489 21.0555556 0.350844 21.0583333 0.350844 21.0611111 0.349778 21.0638889 0.349067 21.0666667 0.347644 21.0694444 0.346933 21.0722222 0.348356 21.0750000 0.346933 21.0777778 0.346578 21.0805556 0.344800 21.0833333 0.343733 21.0861111 0.342667 21.0888889 0.342311 21.0916667 0.341956 21.0944444 0.340178 21.0972222 0.337689 21.1000000 0.334844 21.1027778 0.334133 21.1055556 0.332711 21.1083333 0.330933 21.1111111 0.328800 21.1138889 0.325600 21.1166667 0.322400 21.1194444 0.321333 21.1222222 0.319556 21.1250000 0.318133 21.1277778 0.316711 21.1305556 0.312800 21.1333333 0.310311 21.1361111 0.309600 21.1388889 0.308533 21.1416667 0.308178 21.1444444 0.306756 21.1472222 0.304622 21.1500000 0.304267 21.1527778 0.303200 21.1555556 0.303556 21.1583333 0.303556 21.1611111 0.302133 21.1638889 0.300711 21.1666667 0.300356 21.1694444 0.298933 21.1722222 0.300000 21.1750000 0.299289 21.1777778 0.299289 21.1805556 0.297867 21.1863333 0.300000 21.1942222 0.300000 21.1972222 0.293600 21.2000000 0.293600 21.2027778 0.293600 21.2055556 0.291822 21.2083333 0.291111 21.2111111 0.290044 21.2138889 0.287200 21.2166667 0.286489 21.2194444 0.286133 21.2222222 0.285067 21.2250000 0.283644 21.2277778 0.281867 21.2305556 0.280089 21.2333333 0.279022 21.2361111 0.279022 21.2388889 0.279022 21.2416667 0.278311 21.2444444 0.275467 21.2472222 0.274756 21.2500000 0.274400 21.2527778 0.273689 21.2555556 0.272622 21.2583333 0.272267 21.2611111 0.271911 21.2638889 0.271556 21.2666667 0.273333 21.2694444 0.275467 21.2722222 0.278667 21.2750000 0.281867 21.2777778 0.285067 21.2805556 0.287556 21.2833333 0.290756 21.2861111 0.295378 21.2888889 0.298578 21.2916667 0.298222 21.2944444 0.299289 21.2972222 0.299644 21.3000000 0.299289 21.3027778 0.299289 21.3055556 0.298222 21.3083333 0.297511 21.3111111 0.296444 21.3138889 0.295733 21.3166667 0.296444 21.3194444 0.295378 21.3222222 0.296444 21.3250000 0.296089 21.3277778 0.295022 21.3305556 0.293244 21.3333333 0.291822 21.3361111 0.290044 21.3388889 0.290400 21.3416667 0.291467 21.3444444 0.292889 21.3472222 0.292889 21.3500000 0.292889 21.3527778 0.292889 21.3555556 0.293600 21.3583333 0.295022 21.3611111 0.293600 21.3638889 0.292533 21.3666667 0.291111 21.3694444 0.292889 21.3722222 0.292178 21.3750000 0.293244 21.3777778 0.291822 21.3805556 0.290756 21.3833333 0.289333 21.3861111 0.290044 21.3888889 0.290044 21.3916667 0.289689 21.3944444 0.288267 21.3972222 0.286133 21.4000000 0.285422 21.4027778 0.286133 21.4055556 0.286489 21.4083333 0.286489 21.4111111 0.284000 21.4138889 0.282578 21.4166667 0.282578 21.4194444 0.283644 21.4222222 0.283644 21.4250000 0.281156 21.4277778 0.276533 21.4305556 0.273333 21.4333333 0.274044 21.4361111 0.277956 21.4388889 0.282933 21.4416667 0.286133 21.4444444 0.288622 21.4472222 0.293244 21.4500000 0.296800 21.4527778 0.299289 21.4555556 0.297511 21.4583333 0.293244 21.4611111 0.288622 21.4638889 0.282578 21.4666667 0.278311 21.4694444 0.275111 21.4722222 0.276178 21.4750000 0.276533 21.4777778 0.276889 21.4805556 0.275467 21.4833333 0.274400 21.4861111 0.275467 21.4888889 0.275111 21.4916667 0.274400 21.4944444 0.273689 21.4972222 0.272267 21.5000000 0.271911 21.5027778 0.273689 21.5055556 0.275111 21.5083333 0.274756 21.5111111 0.275111 21.5138889 0.273689 21.5166667 0.274756 21.5194444 0.273689 21.5222222 0.275111 21.5250000 0.274756 21.5277778 0.274044 21.5305556 0.273689 21.5333333 0.272267 21.5361111 0.274756 21.5388889 0.275822 21.5416667 0.277244 21.5444444 0.279022 21.5472222 0.280089 21.5500000 0.281511 21.5527778 0.284000 21.5555556 0.286133 21.5583333 0.288978 21.5611111 0.290400 21.5638889 0.290756 21.5666667 0.292889 21.5694444 0.295378 21.5722222 0.298933 21.5750000 0.302133 21.5777778 0.303911 21.5805556 0.306756 21.5833333 0.308889 21.5861111 0.312800 21.5888889 0.315644 21.5916667 0.317067 21.5944444 0.313867 21.5972222 0.309600 21.6000000 0.305689 21.6027778 0.304622 21.6055556 0.303911 21.6083333 0.303911 21.6111111 0.302489 21.6138889 0.300711 21.6166667 0.300711 21.6194444 0.299644 21.6222222 0.299289 21.6250000 0.298222 21.6277778 0.297156 21.6305556 0.296089 21.6333333 0.295378 21.6361111 0.294311 21.6388889 0.295378 21.6416667 0.295022 21.6444444 0.293244 21.6472222 0.290756 21.6500000 0.289689 21.6527778 0.287556 21.6555556 0.287556 21.6583333 0.284711 21.6611111 0.284000 21.6638889 0.281511 21.6666667 0.280444 21.6694444 0.279022 21.6722222 0.279022 21.6750000 0.276889 21.6777778 0.275822 21.6805556 0.273333 21.6833333 0.272978 21.6861111 0.272267 21.6888889 0.271911 21.6916667 0.273333 21.6944444 0.272978 21.6972222 0.272267 21.7000000 0.273689 21.7027778 0.274756 21.7055556 0.277956 21.7083333 0.279733 21.7111111 0.281156 21.7138889 0.282933 21.7166667 0.284000 21.7194444 0.286489 21.7222222 0.288978 21.7250000 0.291467 21.7277778 0.291111 21.7305556 0.291111 21.7333333 0.291111 21.7361111 0.292533 21.7388889 0.294667 21.7416667 0.295378 21.7444444 0.296089 21.7502222 0.300000 21.9472222 0.300000)

* ============================================================
* ANALOG SUPPLEMENTARY CIRCUITS
* ============================================================

.include "C:/Users/kadhi/OneDrive/Desktop/amux/verilogLearning/Leaky-Integrate-Fire---SNN-model-on-FPGA/experiments/frontend_optimization/complete_frontend/inverter.spice"
.include "C:/Users/kadhi/OneDrive/Desktop/amux/verilogLearning/Leaky-Integrate-Fire---SNN-model-on-FPGA/experiments/frontend_optimization/complete_frontend/bias_gen.spice"
.include "C:/Users/kadhi/OneDrive/Desktop/amux/verilogLearning/Leaky-Integrate-Fire---SNN-model-on-FPGA/experiments/frontend_optimization/complete_frontend/rpeak_detector.spice"
.include "C:/Users/kadhi/OneDrive/Desktop/amux/verilogLearning/Leaky-Integrate-Fire---SNN-model-on-FPGA/experiments/frontend_optimization/complete_frontend/pulse_gen.spice"
.include "C:/Users/kadhi/OneDrive/Desktop/amux/verilogLearning/Leaky-Integrate-Fire---SNN-model-on-FPGA/experiments/frontend_optimization/complete_frontend/long_pulse_gen.spice"
.include "C:/Users/kadhi/OneDrive/Desktop/amux/verilogLearning/Leaky-Integrate-Fire---SNN-model-on-FPGA/experiments/frontend_optimization/complete_frontend/delay_timer.spice"
.include "C:/Users/kadhi/OneDrive/Desktop/amux/verilogLearning/Leaky-Integrate-Fire---SNN-model-on-FPGA/experiments/frontend_optimization/complete_frontend/edge_buffer.spice"

* --- Bias generator (replaces ideal Vbias) ---
Xbias vbias vref vdd vss bias_gen
.ic V(xbias.iref)=0.3

* --- R-peak detector + pulse_gen (analog rpeak) ---
Vthresh rpeak_threshold 0 0.348000
Xrpk ecg_l0 rpeak_threshold rpeak_level vdd vss vbias rpeak_detector
Xpg_rpk rpeak_level rpeak_pulse_raw vdd vss vbias pulse_gen
Xeb_rpk rpeak_pulse_raw rpeak_pulse vdd vss edge_buffer

* --- Delay timer (triggered by analog rpeak pulse) ---
Vth14 vth_14_node 0 0.274000
Vth69 vth_69_node 0 0.446645
Vth28 vth_28_node 0 0.468112
Vth300 vth_300_node 0 0.329200
Vth10 vth_10_node 0 0.309477

Xdt rpeak_pulse trig_s14_level trig_s69_level trig_wid_level trig_bi_level trig_rr_level dt_sf_out vdd vss vbias vth_14_node vth_69_node vth_28_node vth_300_node vth_10_node delay_timer

* --- Pulse generators for delay_timer outputs ---
Xpg_s14 trig_s14_level pg_s14_raw vdd vss vbias pulse_gen
Xpg_s69 trig_s69_level pg_s69_raw vdd vss vbias long_pulse_gen
Xpg_wid trig_wid_level pg_wid_raw vdd vss vbias long_pulse_gen
Xpg_bi  trig_bi_level  pg_bi_raw  vdd vss vbias long_pulse_gen
Xpg_rr  trig_rr_level  pg_rr_raw  vdd vss vbias pulse_gen

* --- Edge buffers for cleaner trigger edges ---
Xeb_s14 pg_s14_raw trig_s14 vdd vss edge_buffer
Xeb_s69 pg_s69_raw trig_s69 vdd vss edge_buffer
Xeb_wid pg_wid_raw trig_wid vdd vss edge_buffer
Xeb_bi  pg_bi_raw  trig_bi_copy vdd vss edge_buffer
Xeb_rr  pg_rr_raw  trig_rr_copy vdd vss edge_buffer

* ============================================================
* IDEAL TRIGGERS (kept for rr_timing + pwave)
* ============================================================
Vrpk_ideal trig_rpeak_ideal 0 PWL(0.0000000 0.000000 0.4996000 0.000000 0.5000000 0.900000 0.5005000 0.900000 0.5009000 0.000000 1.2607111 0.000000 1.2611111 0.900000 1.2616111 0.900000 1.2620111 0.000000 1.8551556 0.000000 1.8555556 0.900000 1.8560556 0.900000 1.8564556 0.000000 2.2884889 0.000000 2.2888889 0.900000 2.2893889 0.900000 2.2897889 0.000000 3.1996000 0.000000 3.2000000 0.900000 3.2005000 0.900000 3.2009000 0.000000 3.7468222 0.000000 3.7472222 0.900000 3.7477222 0.900000 3.7481222 0.000000 4.3051556 0.000000 4.3055556 0.900000 4.3060556 0.900000 4.3064556 0.000000 5.0857111 0.000000 5.0861111 0.900000 5.0866111 0.900000 5.0870111 0.000000 5.6357111 0.000000 5.6361111 0.900000 5.6366111 0.900000 5.6370111 0.000000 6.1468222 0.000000 6.1472222 0.900000 6.1477222 0.900000 6.1481222 0.000000 7.0246000 0.000000 7.0250000 0.900000 7.0255000 0.900000 7.0259000 0.000000 7.5496000 0.000000 7.5500000 0.900000 7.5505000 0.900000 7.5509000 0.000000 8.0579333 0.000000 8.0583333 0.900000 8.0588333 0.900000 8.0592333 0.000000 8.8107111 0.000000 8.8111111 0.900000 8.8116111 0.900000 8.8120111 0.000000 9.3940444 0.000000 9.3944444 0.900000 9.3949444 0.900000 9.3953444 0.000000 9.9357111 0.000000 9.9361111 0.900000 9.9366111 0.900000 9.9370111 0.000000 10.7134889 0.000000 10.7138889 0.900000 10.7143889 0.900000 10.7147889 0.000000 11.2996000 0.000000 11.3000000 0.900000 11.3005000 0.900000 11.3009000 0.000000 11.7579333 0.000000 11.7583333 0.900000 11.7588333 0.900000 11.7592333 0.000000 12.5996000 0.000000 12.6000000 0.900000 12.6005000 0.900000 12.6009000 0.000000 13.1579333 0.000000 13.1583333 0.900000 13.1588333 0.900000 13.1592333 0.000000 13.6523778 0.000000 13.6527778 0.900000 13.6532778 0.900000 13.6536778 0.000000 14.3523778 0.000000 14.3527778 0.900000 14.3532778 0.900000 14.3536778 0.000000 14.9579333 0.000000 14.9583333 0.900000 14.9588333 0.900000 14.9592333 0.000000 15.3857111 0.000000 15.3861111 0.900000 15.3866111 0.900000 15.3870111 0.000000 16.3051556 0.000000 16.3055556 0.900000 16.3060556 0.900000 16.3064556 0.000000 16.8773778 0.000000 16.8777778 0.900000 16.8782778 0.900000 16.8786778 0.000000 17.4301556 0.000000 17.4305556 0.900000 17.4310556 0.900000 17.4314556 0.000000 18.1940444 0.000000 18.1944444 0.900000 18.1949444 0.900000 18.1953444 0.000000 18.7412667 0.000000 18.7416667 0.900000 18.7421667 0.900000 18.7425667 0.000000 19.1996000 0.000000 19.2000000 0.900000 19.2005000 0.900000 19.2009000 0.000000 19.8329333 0.000000 19.8333333 0.900000 19.8338333 0.900000 19.8342333 0.000000 20.3329333 0.000000 20.3333333 0.900000 20.3338333 0.900000 20.3342333 0.000000 20.8829333 0.000000 20.8833333 0.900000 20.8838333 0.900000 20.8842333 0.000000 21.4468222 0.000000 21.4472222 0.900000 21.4477222 0.900000 21.4481222 0.000000 21.9472222 0.000000)
Vrrc trig_rr_cap 0 PWL(0.0000000 0.000000 0.4396000 0.000000 0.4400000 0.900000 0.4900000 0.900000 0.4904000 0.000000 1.2007111 0.000000 1.2011111 0.900000 1.2511111 0.900000 1.2515111 0.000000 1.7951556 0.000000 1.7955556 0.900000 1.8455556 0.900000 1.8459556 0.000000 2.2284889 0.000000 2.2288889 0.900000 2.2788889 0.900000 2.2792889 0.000000 3.1396000 0.000000 3.1400000 0.900000 3.1900000 0.900000 3.1904000 0.000000 3.6868222 0.000000 3.6872222 0.900000 3.7372222 0.900000 3.7376222 0.000000 4.2451556 0.000000 4.2455556 0.900000 4.2955556 0.900000 4.2959556 0.000000 5.0257111 0.000000 5.0261111 0.900000 5.0761111 0.900000 5.0765111 0.000000 5.5757111 0.000000 5.5761111 0.900000 5.6261111 0.900000 5.6265111 0.000000 6.0868222 0.000000 6.0872222 0.900000 6.1372222 0.900000 6.1376222 0.000000 6.9646000 0.000000 6.9650000 0.900000 7.0150000 0.900000 7.0154000 0.000000 7.4896000 0.000000 7.4900000 0.900000 7.5400000 0.900000 7.5404000 0.000000 7.9979333 0.000000 7.9983333 0.900000 8.0483333 0.900000 8.0487333 0.000000 8.7507111 0.000000 8.7511111 0.900000 8.8011111 0.900000 8.8015111 0.000000 9.3340444 0.000000 9.3344444 0.900000 9.3844444 0.900000 9.3848444 0.000000 9.8757111 0.000000 9.8761111 0.900000 9.9261111 0.900000 9.9265111 0.000000 10.6534889 0.000000 10.6538889 0.900000 10.7038889 0.900000 10.7042889 0.000000 11.2396000 0.000000 11.2400000 0.900000 11.2900000 0.900000 11.2904000 0.000000 11.6979333 0.000000 11.6983333 0.900000 11.7483333 0.900000 11.7487333 0.000000 12.5396000 0.000000 12.5400000 0.900000 12.5900000 0.900000 12.5904000 0.000000 13.0979333 0.000000 13.0983333 0.900000 13.1483333 0.900000 13.1487333 0.000000 13.5923778 0.000000 13.5927778 0.900000 13.6427778 0.900000 13.6431778 0.000000 14.2923778 0.000000 14.2927778 0.900000 14.3427778 0.900000 14.3431778 0.000000 14.8979333 0.000000 14.8983333 0.900000 14.9483333 0.900000 14.9487333 0.000000 15.3257111 0.000000 15.3261111 0.900000 15.3761111 0.900000 15.3765111 0.000000 16.2451556 0.000000 16.2455556 0.900000 16.2955556 0.900000 16.2959556 0.000000 16.8173778 0.000000 16.8177778 0.900000 16.8677778 0.900000 16.8681778 0.000000 17.3701556 0.000000 17.3705556 0.900000 17.4205556 0.900000 17.4209556 0.000000 18.1340444 0.000000 18.1344444 0.900000 18.1844444 0.900000 18.1848444 0.000000 18.6812667 0.000000 18.6816667 0.900000 18.7316667 0.900000 18.7320667 0.000000 19.1396000 0.000000 19.1400000 0.900000 19.1900000 0.900000 19.1904000 0.000000 19.7729333 0.000000 19.7733333 0.900000 19.8233333 0.900000 19.8237333 0.000000 20.2729333 0.000000 20.2733333 0.900000 20.3233333 0.900000 20.3237333 0.000000 20.8229333 0.000000 20.8233333 0.900000 20.8733333 0.900000 20.8737333 0.000000 21.3868222 0.000000 21.3872222 0.900000 21.4372222 0.900000 21.4376222 0.000000 21.9472222 0.000000)
Vpwb trig_pw_base 0 PWL(0.0000000 0.000000 0.2940444 0.000000 0.2944444 0.900000 0.2949444 0.900000 0.2953444 0.000000 1.0551556 0.000000 1.0555556 0.900000 1.0560556 0.900000 1.0564556 0.000000 1.6496000 0.000000 1.6500000 0.900000 1.6505000 0.900000 1.6509000 0.000000 2.0829333 0.000000 2.0833333 0.900000 2.0838333 0.900000 2.0842333 0.000000 2.9940444 0.000000 2.9944444 0.900000 2.9949444 0.900000 2.9953444 0.000000 3.5412667 0.000000 3.5416667 0.900000 3.5421667 0.900000 3.5425667 0.000000 4.0996000 0.000000 4.1000000 0.900000 4.1005000 0.900000 4.1009000 0.000000 4.8801556 0.000000 4.8805556 0.900000 4.8810556 0.900000 4.8814556 0.000000 5.4301556 0.000000 5.4305556 0.900000 5.4310556 0.900000 5.4314556 0.000000 5.9412667 0.000000 5.9416667 0.900000 5.9421667 0.900000 5.9425667 0.000000 6.8190444 0.000000 6.8194444 0.900000 6.8199444 0.900000 6.8203444 0.000000 7.3440444 0.000000 7.3444444 0.900000 7.3449444 0.900000 7.3453444 0.000000 7.8523778 0.000000 7.8527778 0.900000 7.8532778 0.900000 7.8536778 0.000000 8.6051556 0.000000 8.6055556 0.900000 8.6060556 0.900000 8.6064556 0.000000 9.1884889 0.000000 9.1888889 0.900000 9.1893889 0.900000 9.1897889 0.000000 9.7301556 0.000000 9.7305556 0.900000 9.7310556 0.900000 9.7314556 0.000000 10.5079333 0.000000 10.5083333 0.900000 10.5088333 0.900000 10.5092333 0.000000 11.0940444 0.000000 11.0944444 0.900000 11.0949444 0.900000 11.0953444 0.000000 11.5523778 0.000000 11.5527778 0.900000 11.5532778 0.900000 11.5536778 0.000000 12.3940444 0.000000 12.3944444 0.900000 12.3949444 0.900000 12.3953444 0.000000 12.9523778 0.000000 12.9527778 0.900000 12.9532778 0.900000 12.9536778 0.000000 13.4468222 0.000000 13.4472222 0.900000 13.4477222 0.900000 13.4481222 0.000000 14.1468222 0.000000 14.1472222 0.900000 14.1477222 0.900000 14.1481222 0.000000 14.7523778 0.000000 14.7527778 0.900000 14.7532778 0.900000 14.7536778 0.000000 15.1801556 0.000000 15.1805556 0.900000 15.1810556 0.900000 15.1814556 0.000000 16.0996000 0.000000 16.1000000 0.900000 16.1005000 0.900000 16.1009000 0.000000 16.6718222 0.000000 16.6722222 0.900000 16.6727222 0.900000 16.6731222 0.000000 17.2246000 0.000000 17.2250000 0.900000 17.2255000 0.900000 17.2259000 0.000000 17.9884889 0.000000 17.9888889 0.900000 17.9893889 0.900000 17.9897889 0.000000 18.5357111 0.000000 18.5361111 0.900000 18.5366111 0.900000 18.5370111 0.000000 18.9940444 0.000000 18.9944444 0.900000 18.9949444 0.900000 18.9953444 0.000000 19.6273778 0.000000 19.6277778 0.900000 19.6282778 0.900000 19.6286778 0.000000 20.1273778 0.000000 20.1277778 0.900000 20.1282778 0.900000 20.1286778 0.000000 20.6773778 0.000000 20.6777778 0.900000 20.6782778 0.900000 20.6786778 0.000000 21.2412667 0.000000 21.2416667 0.900000 21.2421667 0.900000 21.2425667 0.000000 21.9472222 0.000000)
Vpwp trig_pw_peak 0 PWL(0.0000000 0.000000 0.3690444 0.000000 0.3694444 0.900000 0.3699444 0.900000 0.3703444 0.000000 1.1301556 0.000000 1.1305556 0.900000 1.1310556 0.900000 1.1314556 0.000000 1.7246000 0.000000 1.7250000 0.900000 1.7255000 0.900000 1.7259000 0.000000 2.1579333 0.000000 2.1583333 0.900000 2.1588333 0.900000 2.1592333 0.000000 3.0690444 0.000000 3.0694444 0.900000 3.0699444 0.900000 3.0703444 0.000000 3.6162667 0.000000 3.6166667 0.900000 3.6171667 0.900000 3.6175667 0.000000 4.1746000 0.000000 4.1750000 0.900000 4.1755000 0.900000 4.1759000 0.000000 4.9551556 0.000000 4.9555556 0.900000 4.9560556 0.900000 4.9564556 0.000000 5.5051556 0.000000 5.5055556 0.900000 5.5060556 0.900000 5.5064556 0.000000 6.0162667 0.000000 6.0166667 0.900000 6.0171667 0.900000 6.0175667 0.000000 6.8940444 0.000000 6.8944444 0.900000 6.8949444 0.900000 6.8953444 0.000000 7.4190444 0.000000 7.4194444 0.900000 7.4199444 0.900000 7.4203444 0.000000 7.9273778 0.000000 7.9277778 0.900000 7.9282778 0.900000 7.9286778 0.000000 8.6801556 0.000000 8.6805556 0.900000 8.6810556 0.900000 8.6814556 0.000000 9.2634889 0.000000 9.2638889 0.900000 9.2643889 0.900000 9.2647889 0.000000 9.8051556 0.000000 9.8055556 0.900000 9.8060556 0.900000 9.8064556 0.000000 10.5829333 0.000000 10.5833333 0.900000 10.5838333 0.900000 10.5842333 0.000000 11.1690444 0.000000 11.1694444 0.900000 11.1699444 0.900000 11.1703444 0.000000 11.6273778 0.000000 11.6277778 0.900000 11.6282778 0.900000 11.6286778 0.000000 12.4690444 0.000000 12.4694444 0.900000 12.4699444 0.900000 12.4703444 0.000000 13.0273778 0.000000 13.0277778 0.900000 13.0282778 0.900000 13.0286778 0.000000 13.5218222 0.000000 13.5222222 0.900000 13.5227222 0.900000 13.5231222 0.000000 14.2218222 0.000000 14.2222222 0.900000 14.2227222 0.900000 14.2231222 0.000000 14.8273778 0.000000 14.8277778 0.900000 14.8282778 0.900000 14.8286778 0.000000 15.2551556 0.000000 15.2555556 0.900000 15.2560556 0.900000 15.2564556 0.000000 16.1746000 0.000000 16.1750000 0.900000 16.1755000 0.900000 16.1759000 0.000000 16.7468222 0.000000 16.7472222 0.900000 16.7477222 0.900000 16.7481222 0.000000 17.2996000 0.000000 17.3000000 0.900000 17.3005000 0.900000 17.3009000 0.000000 18.0634889 0.000000 18.0638889 0.900000 18.0643889 0.900000 18.0647889 0.000000 18.6107111 0.000000 18.6111111 0.900000 18.6116111 0.900000 18.6120111 0.000000 19.0690444 0.000000 19.0694444 0.900000 19.0699444 0.900000 19.0703444 0.000000 19.7023778 0.000000 19.7027778 0.900000 19.7032778 0.900000 19.7036778 0.000000 20.2023778 0.000000 20.2027778 0.900000 20.2032778 0.900000 20.2036778 0.000000 20.7523778 0.000000 20.7527778 0.900000 20.7532778 0.900000 20.7536778 0.000000 21.3162667 0.000000 21.3166667 0.900000 21.3171667 0.900000 21.3175667 0.000000 21.9472222 0.000000)

* ============================================================
* FEATURE CIRCUITS
* ============================================================
.include "C:/Users/kadhi/OneDrive/Desktop/amux/verilogLearning/Leaky-Integrate-Fire---SNN-model-on-FPGA/experiments/frontend_optimization/complete_frontend/rr_timing.spice"
.include "C:/Users/kadhi/OneDrive/Desktop/amux/verilogLearning/Leaky-Integrate-Fire---SNN-model-on-FPGA/experiments/frontend_optimization/complete_frontend/beat_instability.spice"
.include "C:/Users/kadhi/OneDrive/Desktop/amux/verilogLearning/Leaky-Integrate-Fire---SNN-model-on-FPGA/experiments/frontend_optimization/complete_frontend/pwave_diff.spice"
.include "C:/Users/kadhi/OneDrive/Desktop/amux/verilogLearning/Leaky-Integrate-Fire---SNN-model-on-FPGA/experiments/frontend_optimization/complete_frontend/qrs_width.spice"
.include "C:/Users/kadhi/OneDrive/Desktop/amux/verilogLearning/Leaky-Integrate-Fire---SNN-model-on-FPGA/experiments/frontend_optimization/complete_frontend/qrs_slope.spice"
.include "C:/Users/kadhi/OneDrive/Desktop/amux/verilogLearning/Leaky-Integrate-Fire---SNN-model-on-FPGA/experiments/frontend_optimization/complete_frontend/qrs_symmetry.spice"

* F1/F2: rr_timing (ideal rpeak + ideal rr_cap, analog rr_copy)
Xrr ecg_l0 trig_rr_cap trig_rpeak_ideal trig_rr_copy f1_rr_ratio f2_rr_asym rr_timer rr_ewma vdd vss vbias rr_timing

* F3/F4: beat_instability (ANALOG rpeak, ANALOG bi_copy)
Xbi0 ecg_l0 rpeak_pulse trig_bi_copy f3_bi_l0 vdd vss vbias beat_instability
Xbi1 ecg_l1 rpeak_pulse trig_bi_copy f4_bi_l1 vdd vss vbias beat_instability

* F5: pwave_diff (IDEAL pw triggers)
Xpw ecg_l0 trig_pw_base trig_pw_peak f5_pwave vdd vss vbias pwave_diff

* F6: qrs_width (ANALOG wid trigger)
Xwid ecg_l0 trig_wid f6_width vdd vss qrs_width

* F7: qrs_slope (ANALOG s14, s69 triggers)
Xslp ecg_l0 trig_s14 trig_s69 f7_slope vdd vss vbias qrs_slope

* F8: qrs_symmetry (ANALOG rpeak pulse)
Xsym ecg_l0 rpeak_pulse f8_symmetry vdd vss qrs_symmetry

* ============================================================
* INITIAL CONDITIONS
* ============================================================
.ic V(xrr.net_timer)=0.9
.ic V(xrr.ewma_node)=0.431536
.ic V(xrr.esamp_node)=0.431536
.ic V(xrr.prev_node)=0.431536
.ic V(xbi0.prev_node)=0.3
.ic V(xbi0.esamp_node)=0.3
.ic V(xbi1.prev_node)=0.3
.ic V(xbi1.esamp_node)=0.3

.tran 0.5m 21.9472

.meas tran f1_5 FIND V(f1_rr_ratio) AT=3.7372222
.meas tran f2_5 FIND V(f2_rr_asym) AT=4.2405556
.meas tran f3_5 FIND V(f3_bi_l0) AT=3.8472222
.meas tran f4_5 FIND V(f4_bi_l1) AT=3.8472222
.meas tran f5_5 FIND V(f5_pwave) AT=3.8472222
.meas tran f6_5 FIND V(f6_width) AT=3.8472222
.meas tran f7_5 FIND V(f7_slope) AT=3.8472222
.meas tran f8_5 FIND V(f8_symmetry) AT=3.8472222
.meas tran f1_6 FIND V(f1_rr_ratio) AT=4.2955556
.meas tran f2_6 FIND V(f2_rr_asym) AT=5.0211111
.meas tran f3_6 FIND V(f3_bi_l0) AT=4.4055556
.meas tran f4_6 FIND V(f4_bi_l1) AT=4.4055556
.meas tran f5_6 FIND V(f5_pwave) AT=4.4055556
.meas tran f6_6 FIND V(f6_width) AT=4.4055556
.meas tran f7_6 FIND V(f7_slope) AT=4.4055556
.meas tran f8_6 FIND V(f8_symmetry) AT=4.4055556
.meas tran f1_7 FIND V(f1_rr_ratio) AT=5.0761111
.meas tran f2_7 FIND V(f2_rr_asym) AT=5.5711111
.meas tran f3_7 FIND V(f3_bi_l0) AT=5.1861111
.meas tran f4_7 FIND V(f4_bi_l1) AT=5.1861111
.meas tran f5_7 FIND V(f5_pwave) AT=5.1861111
.meas tran f6_7 FIND V(f6_width) AT=5.1861111
.meas tran f7_7 FIND V(f7_slope) AT=5.1861111
.meas tran f8_7 FIND V(f8_symmetry) AT=5.1861111
.meas tran f1_8 FIND V(f1_rr_ratio) AT=5.6261111
.meas tran f2_8 FIND V(f2_rr_asym) AT=6.0822222
.meas tran f3_8 FIND V(f3_bi_l0) AT=5.7361111
.meas tran f4_8 FIND V(f4_bi_l1) AT=5.7361111
.meas tran f5_8 FIND V(f5_pwave) AT=5.7361111
.meas tran f6_8 FIND V(f6_width) AT=5.7361111
.meas tran f7_8 FIND V(f7_slope) AT=5.7361111
.meas tran f8_8 FIND V(f8_symmetry) AT=5.7361111
.meas tran f1_9 FIND V(f1_rr_ratio) AT=6.1372222
.meas tran f2_9 FIND V(f2_rr_asym) AT=6.9600000
.meas tran f3_9 FIND V(f3_bi_l0) AT=6.2472222
.meas tran f4_9 FIND V(f4_bi_l1) AT=6.2472222
.meas tran f5_9 FIND V(f5_pwave) AT=6.2472222
.meas tran f6_9 FIND V(f6_width) AT=6.2472222
.meas tran f7_9 FIND V(f7_slope) AT=6.2472222
.meas tran f8_9 FIND V(f8_symmetry) AT=6.2472222
.meas tran f1_10 FIND V(f1_rr_ratio) AT=7.0150000
.meas tran f2_10 FIND V(f2_rr_asym) AT=7.4850000
.meas tran f3_10 FIND V(f3_bi_l0) AT=7.1250000
.meas tran f4_10 FIND V(f4_bi_l1) AT=7.1250000
.meas tran f5_10 FIND V(f5_pwave) AT=7.1250000
.meas tran f6_10 FIND V(f6_width) AT=7.1250000
.meas tran f7_10 FIND V(f7_slope) AT=7.1250000
.meas tran f8_10 FIND V(f8_symmetry) AT=7.1250000
.meas tran f1_11 FIND V(f1_rr_ratio) AT=7.5400000
.meas tran f2_11 FIND V(f2_rr_asym) AT=7.9933333
.meas tran f3_11 FIND V(f3_bi_l0) AT=7.6500000
.meas tran f4_11 FIND V(f4_bi_l1) AT=7.6500000
.meas tran f5_11 FIND V(f5_pwave) AT=7.6500000
.meas tran f6_11 FIND V(f6_width) AT=7.6500000
.meas tran f7_11 FIND V(f7_slope) AT=7.6500000
.meas tran f8_11 FIND V(f8_symmetry) AT=7.6500000
.meas tran f1_12 FIND V(f1_rr_ratio) AT=8.0483333
.meas tran f2_12 FIND V(f2_rr_asym) AT=8.7461111
.meas tran f3_12 FIND V(f3_bi_l0) AT=8.1583333
.meas tran f4_12 FIND V(f4_bi_l1) AT=8.1583333
.meas tran f5_12 FIND V(f5_pwave) AT=8.1583333
.meas tran f6_12 FIND V(f6_width) AT=8.1583333
.meas tran f7_12 FIND V(f7_slope) AT=8.1583333
.meas tran f8_12 FIND V(f8_symmetry) AT=8.1583333
.meas tran f1_13 FIND V(f1_rr_ratio) AT=8.8011111
.meas tran f2_13 FIND V(f2_rr_asym) AT=9.3294444
.meas tran f3_13 FIND V(f3_bi_l0) AT=8.9111111
.meas tran f4_13 FIND V(f4_bi_l1) AT=8.9111111
.meas tran f5_13 FIND V(f5_pwave) AT=8.9111111
.meas tran f6_13 FIND V(f6_width) AT=8.9111111
.meas tran f7_13 FIND V(f7_slope) AT=8.9111111
.meas tran f8_13 FIND V(f8_symmetry) AT=8.9111111
.meas tran f1_14 FIND V(f1_rr_ratio) AT=9.3844444
.meas tran f2_14 FIND V(f2_rr_asym) AT=9.8711111
.meas tran f3_14 FIND V(f3_bi_l0) AT=9.4944444
.meas tran f4_14 FIND V(f4_bi_l1) AT=9.4944444
.meas tran f5_14 FIND V(f5_pwave) AT=9.4944444
.meas tran f6_14 FIND V(f6_width) AT=9.4944444
.meas tran f7_14 FIND V(f7_slope) AT=9.4944444
.meas tran f8_14 FIND V(f8_symmetry) AT=9.4944444
.meas tran f1_15 FIND V(f1_rr_ratio) AT=9.9261111
.meas tran f2_15 FIND V(f2_rr_asym) AT=10.6488889
.meas tran f3_15 FIND V(f3_bi_l0) AT=10.0361111
.meas tran f4_15 FIND V(f4_bi_l1) AT=10.0361111
.meas tran f5_15 FIND V(f5_pwave) AT=10.0361111
.meas tran f6_15 FIND V(f6_width) AT=10.0361111
.meas tran f7_15 FIND V(f7_slope) AT=10.0361111
.meas tran f8_15 FIND V(f8_symmetry) AT=10.0361111
.meas tran f1_16 FIND V(f1_rr_ratio) AT=10.7038889
.meas tran f2_16 FIND V(f2_rr_asym) AT=11.2350000
.meas tran f3_16 FIND V(f3_bi_l0) AT=10.8138889
.meas tran f4_16 FIND V(f4_bi_l1) AT=10.8138889
.meas tran f5_16 FIND V(f5_pwave) AT=10.8138889
.meas tran f6_16 FIND V(f6_width) AT=10.8138889
.meas tran f7_16 FIND V(f7_slope) AT=10.8138889
.meas tran f8_16 FIND V(f8_symmetry) AT=10.8138889
.meas tran f1_17 FIND V(f1_rr_ratio) AT=11.2900000
.meas tran f2_17 FIND V(f2_rr_asym) AT=11.6933333
.meas tran f3_17 FIND V(f3_bi_l0) AT=11.4000000
.meas tran f4_17 FIND V(f4_bi_l1) AT=11.4000000
.meas tran f5_17 FIND V(f5_pwave) AT=11.4000000
.meas tran f6_17 FIND V(f6_width) AT=11.4000000
.meas tran f7_17 FIND V(f7_slope) AT=11.4000000
.meas tran f8_17 FIND V(f8_symmetry) AT=11.4000000
.meas tran f1_18 FIND V(f1_rr_ratio) AT=11.7483333
.meas tran f2_18 FIND V(f2_rr_asym) AT=12.5350000
.meas tran f3_18 FIND V(f3_bi_l0) AT=11.8583333
.meas tran f4_18 FIND V(f4_bi_l1) AT=11.8583333
.meas tran f5_18 FIND V(f5_pwave) AT=11.8583333
.meas tran f6_18 FIND V(f6_width) AT=11.8583333
.meas tran f7_18 FIND V(f7_slope) AT=11.8583333
.meas tran f8_18 FIND V(f8_symmetry) AT=11.8583333
.meas tran f1_19 FIND V(f1_rr_ratio) AT=12.5900000
.meas tran f2_19 FIND V(f2_rr_asym) AT=13.0933333
.meas tran f3_19 FIND V(f3_bi_l0) AT=12.7000000
.meas tran f4_19 FIND V(f4_bi_l1) AT=12.7000000
.meas tran f5_19 FIND V(f5_pwave) AT=12.7000000
.meas tran f6_19 FIND V(f6_width) AT=12.7000000
.meas tran f7_19 FIND V(f7_slope) AT=12.7000000
.meas tran f8_19 FIND V(f8_symmetry) AT=12.7000000
.meas tran f1_20 FIND V(f1_rr_ratio) AT=13.1483333
.meas tran f2_20 FIND V(f2_rr_asym) AT=13.5877778
.meas tran f3_20 FIND V(f3_bi_l0) AT=13.2583333
.meas tran f4_20 FIND V(f4_bi_l1) AT=13.2583333
.meas tran f5_20 FIND V(f5_pwave) AT=13.2583333
.meas tran f6_20 FIND V(f6_width) AT=13.2583333
.meas tran f7_20 FIND V(f7_slope) AT=13.2583333
.meas tran f8_20 FIND V(f8_symmetry) AT=13.2583333
.meas tran f1_21 FIND V(f1_rr_ratio) AT=13.6427778
.meas tran f2_21 FIND V(f2_rr_asym) AT=14.2877778
.meas tran f3_21 FIND V(f3_bi_l0) AT=13.7527778
.meas tran f4_21 FIND V(f4_bi_l1) AT=13.7527778
.meas tran f5_21 FIND V(f5_pwave) AT=13.7527778
.meas tran f6_21 FIND V(f6_width) AT=13.7527778
.meas tran f7_21 FIND V(f7_slope) AT=13.7527778
.meas tran f8_21 FIND V(f8_symmetry) AT=13.7527778
.meas tran f1_22 FIND V(f1_rr_ratio) AT=14.3427778
.meas tran f2_22 FIND V(f2_rr_asym) AT=14.8933333
.meas tran f3_22 FIND V(f3_bi_l0) AT=14.4527778
.meas tran f4_22 FIND V(f4_bi_l1) AT=14.4527778
.meas tran f5_22 FIND V(f5_pwave) AT=14.4527778
.meas tran f6_22 FIND V(f6_width) AT=14.4527778
.meas tran f7_22 FIND V(f7_slope) AT=14.4527778
.meas tran f8_22 FIND V(f8_symmetry) AT=14.4527778
.meas tran f1_23 FIND V(f1_rr_ratio) AT=14.9483333
.meas tran f2_23 FIND V(f2_rr_asym) AT=15.3211111
.meas tran f3_23 FIND V(f3_bi_l0) AT=15.0583333
.meas tran f4_23 FIND V(f4_bi_l1) AT=15.0583333
.meas tran f5_23 FIND V(f5_pwave) AT=15.0583333
.meas tran f6_23 FIND V(f6_width) AT=15.0583333
.meas tran f7_23 FIND V(f7_slope) AT=15.0583333
.meas tran f8_23 FIND V(f8_symmetry) AT=15.0583333
.meas tran f1_24 FIND V(f1_rr_ratio) AT=15.3761111
.meas tran f2_24 FIND V(f2_rr_asym) AT=16.2405556
.meas tran f3_24 FIND V(f3_bi_l0) AT=15.4861111
.meas tran f4_24 FIND V(f4_bi_l1) AT=15.4861111
.meas tran f5_24 FIND V(f5_pwave) AT=15.4861111
.meas tran f6_24 FIND V(f6_width) AT=15.4861111
.meas tran f7_24 FIND V(f7_slope) AT=15.4861111
.meas tran f8_24 FIND V(f8_symmetry) AT=15.4861111
.meas tran f1_25 FIND V(f1_rr_ratio) AT=16.2955556
.meas tran f2_25 FIND V(f2_rr_asym) AT=16.8127778
.meas tran f3_25 FIND V(f3_bi_l0) AT=16.4055556
.meas tran f4_25 FIND V(f4_bi_l1) AT=16.4055556
.meas tran f5_25 FIND V(f5_pwave) AT=16.4055556
.meas tran f6_25 FIND V(f6_width) AT=16.4055556
.meas tran f7_25 FIND V(f7_slope) AT=16.4055556
.meas tran f8_25 FIND V(f8_symmetry) AT=16.4055556
.meas tran f1_26 FIND V(f1_rr_ratio) AT=16.8677778
.meas tran f2_26 FIND V(f2_rr_asym) AT=17.3655556
.meas tran f3_26 FIND V(f3_bi_l0) AT=16.9777778
.meas tran f4_26 FIND V(f4_bi_l1) AT=16.9777778
.meas tran f5_26 FIND V(f5_pwave) AT=16.9777778
.meas tran f6_26 FIND V(f6_width) AT=16.9777778
.meas tran f7_26 FIND V(f7_slope) AT=16.9777778
.meas tran f8_26 FIND V(f8_symmetry) AT=16.9777778
.meas tran f1_27 FIND V(f1_rr_ratio) AT=17.4205556
.meas tran f2_27 FIND V(f2_rr_asym) AT=18.1294444
.meas tran f3_27 FIND V(f3_bi_l0) AT=17.5305556
.meas tran f4_27 FIND V(f4_bi_l1) AT=17.5305556
.meas tran f5_27 FIND V(f5_pwave) AT=17.5305556
.meas tran f6_27 FIND V(f6_width) AT=17.5305556
.meas tran f7_27 FIND V(f7_slope) AT=17.5305556
.meas tran f8_27 FIND V(f8_symmetry) AT=17.5305556
.meas tran f1_28 FIND V(f1_rr_ratio) AT=18.1844444
.meas tran f2_28 FIND V(f2_rr_asym) AT=18.6766667
.meas tran f3_28 FIND V(f3_bi_l0) AT=18.2944444
.meas tran f4_28 FIND V(f4_bi_l1) AT=18.2944444
.meas tran f5_28 FIND V(f5_pwave) AT=18.2944444
.meas tran f6_28 FIND V(f6_width) AT=18.2944444
.meas tran f7_28 FIND V(f7_slope) AT=18.2944444
.meas tran f8_28 FIND V(f8_symmetry) AT=18.2944444
.meas tran f1_29 FIND V(f1_rr_ratio) AT=18.7316667
.meas tran f2_29 FIND V(f2_rr_asym) AT=19.1350000
.meas tran f3_29 FIND V(f3_bi_l0) AT=18.8416667
.meas tran f4_29 FIND V(f4_bi_l1) AT=18.8416667
.meas tran f5_29 FIND V(f5_pwave) AT=18.8416667
.meas tran f6_29 FIND V(f6_width) AT=18.8416667
.meas tran f7_29 FIND V(f7_slope) AT=18.8416667
.meas tran f8_29 FIND V(f8_symmetry) AT=18.8416667
.meas tran f1_30 FIND V(f1_rr_ratio) AT=19.1900000
.meas tran f2_30 FIND V(f2_rr_asym) AT=19.7683333
.meas tran f3_30 FIND V(f3_bi_l0) AT=19.3000000
.meas tran f4_30 FIND V(f4_bi_l1) AT=19.3000000
.meas tran f5_30 FIND V(f5_pwave) AT=19.3000000
.meas tran f6_30 FIND V(f6_width) AT=19.3000000
.meas tran f7_30 FIND V(f7_slope) AT=19.3000000
.meas tran f8_30 FIND V(f8_symmetry) AT=19.3000000
.meas tran f1_31 FIND V(f1_rr_ratio) AT=19.8233333
.meas tran f2_31 FIND V(f2_rr_asym) AT=20.2683333
.meas tran f3_31 FIND V(f3_bi_l0) AT=19.9333333
.meas tran f4_31 FIND V(f4_bi_l1) AT=19.9333333
.meas tran f5_31 FIND V(f5_pwave) AT=19.9333333
.meas tran f6_31 FIND V(f6_width) AT=19.9333333
.meas tran f7_31 FIND V(f7_slope) AT=19.9333333
.meas tran f8_31 FIND V(f8_symmetry) AT=19.9333333
.meas tran f1_32 FIND V(f1_rr_ratio) AT=20.3233333
.meas tran f2_32 FIND V(f2_rr_asym) AT=20.8183333
.meas tran f3_32 FIND V(f3_bi_l0) AT=20.4333333
.meas tran f4_32 FIND V(f4_bi_l1) AT=20.4333333
.meas tran f5_32 FIND V(f5_pwave) AT=20.4333333
.meas tran f6_32 FIND V(f6_width) AT=20.4333333
.meas tran f7_32 FIND V(f7_slope) AT=20.4333333
.meas tran f8_32 FIND V(f8_symmetry) AT=20.4333333
.meas tran f1_33 FIND V(f1_rr_ratio) AT=20.8733333
.meas tran f2_33 FIND V(f2_rr_asym) AT=21.3822222
.meas tran f3_33 FIND V(f3_bi_l0) AT=20.9833333
.meas tran f4_33 FIND V(f4_bi_l1) AT=20.9833333
.meas tran f5_33 FIND V(f5_pwave) AT=20.9833333
.meas tran f6_33 FIND V(f6_width) AT=20.9833333
.meas tran f7_33 FIND V(f7_slope) AT=20.9833333
.meas tran f8_33 FIND V(f8_symmetry) AT=20.9833333
.meas tran f1_34 FIND V(f1_rr_ratio) AT=21.4372222
.meas tran f3_34 FIND V(f3_bi_l0) AT=21.5472222
.meas tran f4_34 FIND V(f4_bi_l1) AT=21.5472222
.meas tran f5_34 FIND V(f5_pwave) AT=21.5472222
.meas tran f6_34 FIND V(f6_width) AT=21.5472222
.meas tran f7_34 FIND V(f7_slope) AT=21.5472222
.meas tran f8_34 FIND V(f8_symmetry) AT=21.5472222
.meas tran trpk_0 WHEN V(rpeak_pulse)=0.45 RISE=1 TD=0.4500000
.meas tran ts14_0 WHEN V(trig_s14)=0.45 RISE=1 TD=0.4500000
.meas tran ts69_0 WHEN V(trig_s69)=0.45 RISE=1 TD=0.4500000
.meas tran twid_0 WHEN V(trig_wid)=0.45 RISE=1 TD=0.4500000
.meas tran trpk_1 WHEN V(rpeak_pulse)=0.45 RISE=1 TD=1.2111111
.meas tran ts14_1 WHEN V(trig_s14)=0.45 RISE=1 TD=1.2111111
.meas tran ts69_1 WHEN V(trig_s69)=0.45 RISE=1 TD=1.2111111
.meas tran twid_1 WHEN V(trig_wid)=0.45 RISE=1 TD=1.2111111
.meas tran trpk_2 WHEN V(rpeak_pulse)=0.45 RISE=1 TD=1.8055556
.meas tran ts14_2 WHEN V(trig_s14)=0.45 RISE=1 TD=1.8055556
.meas tran ts69_2 WHEN V(trig_s69)=0.45 RISE=1 TD=1.8055556
.meas tran twid_2 WHEN V(trig_wid)=0.45 RISE=1 TD=1.8055556
.meas tran trpk_3 WHEN V(rpeak_pulse)=0.45 RISE=1 TD=2.2388889
.meas tran ts14_3 WHEN V(trig_s14)=0.45 RISE=1 TD=2.2388889
.meas tran ts69_3 WHEN V(trig_s69)=0.45 RISE=1 TD=2.2388889
.meas tran twid_3 WHEN V(trig_wid)=0.45 RISE=1 TD=2.2388889
.meas tran trpk_4 WHEN V(rpeak_pulse)=0.45 RISE=1 TD=3.1500000
.meas tran ts14_4 WHEN V(trig_s14)=0.45 RISE=1 TD=3.1500000
.meas tran ts69_4 WHEN V(trig_s69)=0.45 RISE=1 TD=3.1500000
.meas tran twid_4 WHEN V(trig_wid)=0.45 RISE=1 TD=3.1500000
.meas tran trpk_5 WHEN V(rpeak_pulse)=0.45 RISE=1 TD=3.6972222
.meas tran ts14_5 WHEN V(trig_s14)=0.45 RISE=1 TD=3.6972222
.meas tran ts69_5 WHEN V(trig_s69)=0.45 RISE=1 TD=3.6972222
.meas tran twid_5 WHEN V(trig_wid)=0.45 RISE=1 TD=3.6972222
.meas tran trpk_6 WHEN V(rpeak_pulse)=0.45 RISE=1 TD=4.2555556
.meas tran ts14_6 WHEN V(trig_s14)=0.45 RISE=1 TD=4.2555556
.meas tran ts69_6 WHEN V(trig_s69)=0.45 RISE=1 TD=4.2555556
.meas tran twid_6 WHEN V(trig_wid)=0.45 RISE=1 TD=4.2555556
.meas tran trpk_7 WHEN V(rpeak_pulse)=0.45 RISE=1 TD=5.0361111
.meas tran ts14_7 WHEN V(trig_s14)=0.45 RISE=1 TD=5.0361111
.meas tran ts69_7 WHEN V(trig_s69)=0.45 RISE=1 TD=5.0361111
.meas tran twid_7 WHEN V(trig_wid)=0.45 RISE=1 TD=5.0361111
.meas tran trpk_8 WHEN V(rpeak_pulse)=0.45 RISE=1 TD=5.5861111
.meas tran ts14_8 WHEN V(trig_s14)=0.45 RISE=1 TD=5.5861111
.meas tran ts69_8 WHEN V(trig_s69)=0.45 RISE=1 TD=5.5861111
.meas tran twid_8 WHEN V(trig_wid)=0.45 RISE=1 TD=5.5861111
.meas tran trpk_9 WHEN V(rpeak_pulse)=0.45 RISE=1 TD=6.0972222
.meas tran ts14_9 WHEN V(trig_s14)=0.45 RISE=1 TD=6.0972222
.meas tran ts69_9 WHEN V(trig_s69)=0.45 RISE=1 TD=6.0972222
.meas tran twid_9 WHEN V(trig_wid)=0.45 RISE=1 TD=6.0972222
.meas tran trpk_10 WHEN V(rpeak_pulse)=0.45 RISE=1 TD=6.9750000
.meas tran ts14_10 WHEN V(trig_s14)=0.45 RISE=1 TD=6.9750000
.meas tran ts69_10 WHEN V(trig_s69)=0.45 RISE=1 TD=6.9750000
.meas tran twid_10 WHEN V(trig_wid)=0.45 RISE=1 TD=6.9750000
.meas tran trpk_11 WHEN V(rpeak_pulse)=0.45 RISE=1 TD=7.5000000
.meas tran ts14_11 WHEN V(trig_s14)=0.45 RISE=1 TD=7.5000000
.meas tran ts69_11 WHEN V(trig_s69)=0.45 RISE=1 TD=7.5000000
.meas tran twid_11 WHEN V(trig_wid)=0.45 RISE=1 TD=7.5000000
.meas tran trpk_12 WHEN V(rpeak_pulse)=0.45 RISE=1 TD=8.0083333
.meas tran ts14_12 WHEN V(trig_s14)=0.45 RISE=1 TD=8.0083333
.meas tran ts69_12 WHEN V(trig_s69)=0.45 RISE=1 TD=8.0083333
.meas tran twid_12 WHEN V(trig_wid)=0.45 RISE=1 TD=8.0083333
.meas tran trpk_13 WHEN V(rpeak_pulse)=0.45 RISE=1 TD=8.7611111
.meas tran ts14_13 WHEN V(trig_s14)=0.45 RISE=1 TD=8.7611111
.meas tran ts69_13 WHEN V(trig_s69)=0.45 RISE=1 TD=8.7611111
.meas tran twid_13 WHEN V(trig_wid)=0.45 RISE=1 TD=8.7611111
.meas tran trpk_14 WHEN V(rpeak_pulse)=0.45 RISE=1 TD=9.3444444
.meas tran ts14_14 WHEN V(trig_s14)=0.45 RISE=1 TD=9.3444444
.meas tran ts69_14 WHEN V(trig_s69)=0.45 RISE=1 TD=9.3444444
.meas tran twid_14 WHEN V(trig_wid)=0.45 RISE=1 TD=9.3444444
.meas tran trpk_15 WHEN V(rpeak_pulse)=0.45 RISE=1 TD=9.8861111
.meas tran ts14_15 WHEN V(trig_s14)=0.45 RISE=1 TD=9.8861111
.meas tran ts69_15 WHEN V(trig_s69)=0.45 RISE=1 TD=9.8861111
.meas tran twid_15 WHEN V(trig_wid)=0.45 RISE=1 TD=9.8861111
.meas tran trpk_16 WHEN V(rpeak_pulse)=0.45 RISE=1 TD=10.6638889
.meas tran ts14_16 WHEN V(trig_s14)=0.45 RISE=1 TD=10.6638889
.meas tran ts69_16 WHEN V(trig_s69)=0.45 RISE=1 TD=10.6638889
.meas tran twid_16 WHEN V(trig_wid)=0.45 RISE=1 TD=10.6638889
.meas tran trpk_17 WHEN V(rpeak_pulse)=0.45 RISE=1 TD=11.2500000
.meas tran ts14_17 WHEN V(trig_s14)=0.45 RISE=1 TD=11.2500000
.meas tran ts69_17 WHEN V(trig_s69)=0.45 RISE=1 TD=11.2500000
.meas tran twid_17 WHEN V(trig_wid)=0.45 RISE=1 TD=11.2500000
.meas tran trpk_18 WHEN V(rpeak_pulse)=0.45 RISE=1 TD=11.7083333
.meas tran ts14_18 WHEN V(trig_s14)=0.45 RISE=1 TD=11.7083333
.meas tran ts69_18 WHEN V(trig_s69)=0.45 RISE=1 TD=11.7083333
.meas tran twid_18 WHEN V(trig_wid)=0.45 RISE=1 TD=11.7083333
.meas tran trpk_19 WHEN V(rpeak_pulse)=0.45 RISE=1 TD=12.5500000
.meas tran ts14_19 WHEN V(trig_s14)=0.45 RISE=1 TD=12.5500000
.meas tran ts69_19 WHEN V(trig_s69)=0.45 RISE=1 TD=12.5500000
.meas tran twid_19 WHEN V(trig_wid)=0.45 RISE=1 TD=12.5500000
.meas tran trpk_20 WHEN V(rpeak_pulse)=0.45 RISE=1 TD=13.1083333
.meas tran ts14_20 WHEN V(trig_s14)=0.45 RISE=1 TD=13.1083333
.meas tran ts69_20 WHEN V(trig_s69)=0.45 RISE=1 TD=13.1083333
.meas tran twid_20 WHEN V(trig_wid)=0.45 RISE=1 TD=13.1083333
.meas tran trpk_21 WHEN V(rpeak_pulse)=0.45 RISE=1 TD=13.6027778
.meas tran ts14_21 WHEN V(trig_s14)=0.45 RISE=1 TD=13.6027778
.meas tran ts69_21 WHEN V(trig_s69)=0.45 RISE=1 TD=13.6027778
.meas tran twid_21 WHEN V(trig_wid)=0.45 RISE=1 TD=13.6027778
.meas tran trpk_22 WHEN V(rpeak_pulse)=0.45 RISE=1 TD=14.3027778
.meas tran ts14_22 WHEN V(trig_s14)=0.45 RISE=1 TD=14.3027778
.meas tran ts69_22 WHEN V(trig_s69)=0.45 RISE=1 TD=14.3027778
.meas tran twid_22 WHEN V(trig_wid)=0.45 RISE=1 TD=14.3027778
.meas tran trpk_23 WHEN V(rpeak_pulse)=0.45 RISE=1 TD=14.9083333
.meas tran ts14_23 WHEN V(trig_s14)=0.45 RISE=1 TD=14.9083333
.meas tran ts69_23 WHEN V(trig_s69)=0.45 RISE=1 TD=14.9083333
.meas tran twid_23 WHEN V(trig_wid)=0.45 RISE=1 TD=14.9083333
.meas tran trpk_24 WHEN V(rpeak_pulse)=0.45 RISE=1 TD=15.3361111
.meas tran ts14_24 WHEN V(trig_s14)=0.45 RISE=1 TD=15.3361111
.meas tran ts69_24 WHEN V(trig_s69)=0.45 RISE=1 TD=15.3361111
.meas tran twid_24 WHEN V(trig_wid)=0.45 RISE=1 TD=15.3361111
.meas tran trpk_25 WHEN V(rpeak_pulse)=0.45 RISE=1 TD=16.2555556
.meas tran ts14_25 WHEN V(trig_s14)=0.45 RISE=1 TD=16.2555556
.meas tran ts69_25 WHEN V(trig_s69)=0.45 RISE=1 TD=16.2555556
.meas tran twid_25 WHEN V(trig_wid)=0.45 RISE=1 TD=16.2555556
.meas tran trpk_26 WHEN V(rpeak_pulse)=0.45 RISE=1 TD=16.8277778
.meas tran ts14_26 WHEN V(trig_s14)=0.45 RISE=1 TD=16.8277778
.meas tran ts69_26 WHEN V(trig_s69)=0.45 RISE=1 TD=16.8277778
.meas tran twid_26 WHEN V(trig_wid)=0.45 RISE=1 TD=16.8277778
.meas tran trpk_27 WHEN V(rpeak_pulse)=0.45 RISE=1 TD=17.3805556
.meas tran ts14_27 WHEN V(trig_s14)=0.45 RISE=1 TD=17.3805556
.meas tran ts69_27 WHEN V(trig_s69)=0.45 RISE=1 TD=17.3805556
.meas tran twid_27 WHEN V(trig_wid)=0.45 RISE=1 TD=17.3805556
.meas tran trpk_28 WHEN V(rpeak_pulse)=0.45 RISE=1 TD=18.1444444
.meas tran ts14_28 WHEN V(trig_s14)=0.45 RISE=1 TD=18.1444444
.meas tran ts69_28 WHEN V(trig_s69)=0.45 RISE=1 TD=18.1444444
.meas tran twid_28 WHEN V(trig_wid)=0.45 RISE=1 TD=18.1444444
.meas tran trpk_29 WHEN V(rpeak_pulse)=0.45 RISE=1 TD=18.6916667
.meas tran ts14_29 WHEN V(trig_s14)=0.45 RISE=1 TD=18.6916667
.meas tran ts69_29 WHEN V(trig_s69)=0.45 RISE=1 TD=18.6916667
.meas tran twid_29 WHEN V(trig_wid)=0.45 RISE=1 TD=18.6916667
.meas tran trpk_30 WHEN V(rpeak_pulse)=0.45 RISE=1 TD=19.1500000
.meas tran ts14_30 WHEN V(trig_s14)=0.45 RISE=1 TD=19.1500000
.meas tran ts69_30 WHEN V(trig_s69)=0.45 RISE=1 TD=19.1500000
.meas tran twid_30 WHEN V(trig_wid)=0.45 RISE=1 TD=19.1500000
.meas tran trpk_31 WHEN V(rpeak_pulse)=0.45 RISE=1 TD=19.7833333
.meas tran ts14_31 WHEN V(trig_s14)=0.45 RISE=1 TD=19.7833333
.meas tran ts69_31 WHEN V(trig_s69)=0.45 RISE=1 TD=19.7833333
.meas tran twid_31 WHEN V(trig_wid)=0.45 RISE=1 TD=19.7833333
.meas tran trpk_32 WHEN V(rpeak_pulse)=0.45 RISE=1 TD=20.2833333
.meas tran ts14_32 WHEN V(trig_s14)=0.45 RISE=1 TD=20.2833333
.meas tran ts69_32 WHEN V(trig_s69)=0.45 RISE=1 TD=20.2833333
.meas tran twid_32 WHEN V(trig_wid)=0.45 RISE=1 TD=20.2833333
.meas tran trpk_33 WHEN V(rpeak_pulse)=0.45 RISE=1 TD=20.8333333
.meas tran ts14_33 WHEN V(trig_s14)=0.45 RISE=1 TD=20.8333333
.meas tran ts69_33 WHEN V(trig_s69)=0.45 RISE=1 TD=20.8333333
.meas tran twid_33 WHEN V(trig_wid)=0.45 RISE=1 TD=20.8333333
.meas tran trpk_34 WHEN V(rpeak_pulse)=0.45 RISE=1 TD=21.3972222
.meas tran ts14_34 WHEN V(trig_s14)=0.45 RISE=1 TD=21.3972222
.meas tran ts69_34 WHEN V(trig_s69)=0.45 RISE=1 TD=21.3972222
.meas tran twid_34 WHEN V(trig_wid)=0.45 RISE=1 TD=21.3972222

.end
