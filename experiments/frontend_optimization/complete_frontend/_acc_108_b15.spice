.title acc_test_108_b15
.lib "C:/Users/kadhi/OneDrive/Desktop/amux/verilogLearning/Leaky-Integrate-Fire---SNN-model-on-FPGA/experiments/frontend_optimization/ngspice_frontend/sky130_minimal.lib.spice" tt
.option scale=1.0u method=gear reltol=0.01 gmin=1e-15
.temp 27

Vdd vdd 0 0.9
Vss vss 0 0
Vbias vbias 0 0.300

Vecg0 ecg_l0 0 PWL(0.0000000 0.300000 1.7470000 0.300000 1.7500000 0.288628 1.7527778 0.288893 1.7555556 0.289686 1.7583333 0.288893 1.7611111 0.289421 1.7638889 0.288364 1.7666667 0.289686 1.7694444 0.290215 1.7722222 0.291273 1.7750000 0.291537 1.7777778 0.291273 1.7805556 0.291008 1.7833333 0.291537 1.7861111 0.292595 1.7888889 0.294446 1.7916667 0.295504 1.7944444 0.295769 1.7972222 0.295240 1.8000000 0.296298 1.8027778 0.297355 1.8055556 0.298678 1.8083333 0.298942 1.8111111 0.298678 1.8138889 0.298149 1.8166667 0.299471 1.8194444 0.300000 1.8222222 0.300793 1.8250000 0.301058 1.8277778 0.300793 1.8305556 0.298678 1.8333333 0.296298 1.8361111 0.294182 1.8388889 0.292860 1.8416667 0.291008 1.8444444 0.288893 1.8472222 0.286777 1.8500000 0.284661 1.8527778 0.284132 1.8555556 0.285455 1.8583333 0.285719 1.8611111 0.285190 1.8638889 0.284397 1.8666667 0.284397 1.8694444 0.284661 1.8722222 0.285983 1.8750000 0.285455 1.8777778 0.285455 1.8805556 0.284132 1.8833333 0.285190 1.8861111 0.285455 1.8888889 0.285719 1.8916667 0.285719 1.8944444 0.284661 1.8972222 0.284397 1.9000000 0.285190 1.9027778 0.285719 1.9055556 0.286512 1.9083333 0.285719 1.9111111 0.284926 1.9138889 0.284926 1.9166667 0.284661 1.9194444 0.285190 1.9222222 0.286248 1.9250000 0.286512 1.9277778 0.285719 1.9305556 0.284661 1.9333333 0.285719 1.9361111 0.285719 1.9388889 0.286248 1.9416667 0.285455 1.9444444 0.285983 1.9472222 0.284926 1.9500000 0.284926 1.9527778 0.287306 1.9555556 0.290215 1.9583333 0.293917 1.9611111 0.298678 1.9638889 0.303702 1.9666667 0.310314 1.9694444 0.317719 1.9722222 0.322744 1.9750000 0.322479 1.9777778 0.320628 1.9805556 0.320893 1.9833333 0.325124 1.9861111 0.328033 1.9888889 0.330678 1.9916667 0.332264 1.9944444 0.332793 1.9972222 0.332793 2.0000000 0.335174 2.0027778 0.336231 2.0055556 0.337289 2.0083333 0.336231 2.0111111 0.331736 2.0138889 0.322744 2.0166667 0.311901 2.0194444 0.303438 2.0222222 0.295769 2.0250000 0.284661 2.0277778 0.273554 2.0305556 0.265355 2.0333333 0.261917 2.0361111 0.262182 2.0388889 0.264562 2.0416667 0.268000 2.0444444 0.269587 2.0472222 0.269322 2.0500000 0.269851 2.0527778 0.271174 2.0555556 0.273554 2.0583333 0.276198 2.0611111 0.276992 2.0638889 0.276727 2.0666667 0.275934 2.0694444 0.276463 2.0722222 0.277256 2.0750000 0.278050 2.0777778 0.277521 2.0805556 0.277256 2.0833333 0.277256 2.0861111 0.276992 2.0888889 0.276727 2.0916667 0.276198 2.0944444 0.276198 2.0972222 0.276198 2.1000000 0.276463 2.1027778 0.276463 2.1055556 0.276198 2.1083333 0.275934 2.1111111 0.275405 2.1138889 0.275405 2.1166667 0.275140 2.1194444 0.275669 2.1222222 0.275405 2.1250000 0.275934 2.1277778 0.275669 2.1305556 0.275669 2.1333333 0.275405 2.1361111 0.275934 2.1388889 0.275405 2.1416667 0.275405 2.1444444 0.274347 2.1472222 0.274347 2.1500000 0.275405 2.1527778 0.276727 2.1555556 0.276992 2.1583333 0.276463 2.1611111 0.275405 2.1638889 0.275140 2.1666667 0.275669 2.1694444 0.275934 2.1722222 0.276463 2.1750000 0.275669 2.1777778 0.275140 2.1805556 0.274876 2.1833333 0.275140 2.1861111 0.275669 2.1888889 0.276198 2.1916667 0.276463 2.1944444 0.275669 2.1972222 0.274876 2.2000000 0.275669 2.2027778 0.277256 2.2055556 0.276727 2.2083333 0.276463 2.2111111 0.276198 2.2138889 0.276198 2.2166667 0.276992 2.2194444 0.277256 2.2222222 0.277521 2.2250000 0.278050 2.2277778 0.277256 2.2305556 0.276992 2.2333333 0.277521 2.2361111 0.278314 2.2388889 0.279107 2.2416667 0.279372 2.2444444 0.278843 2.2472222 0.279107 2.2500000 0.279901 2.2527778 0.280959 2.2555556 0.281488 2.2583333 0.281488 2.2611111 0.281488 2.2638889 0.280430 2.2666667 0.281223 2.2694444 0.282281 2.2722222 0.282810 2.2750000 0.282545 2.2777778 0.282017 2.2805556 0.281488 2.2833333 0.281223 2.2861111 0.282017 2.2888889 0.284132 2.2916667 0.283868 2.2944444 0.283074 2.2972222 0.282810 2.3030000 0.300000 2.4470000 0.300000 2.4500000 0.284397 2.4527778 0.285983 2.4555556 0.285455 2.4583333 0.285719 2.4611111 0.286512 2.4638889 0.287306 2.4666667 0.287570 2.4694444 0.287041 2.4722222 0.287570 2.4750000 0.288364 2.4777778 0.289686 2.4805556 0.291537 2.4833333 0.292331 2.4861111 0.292860 2.4888889 0.292595 2.4916667 0.293653 2.4944444 0.294446 2.4972222 0.295504 2.5000000 0.296033 2.5027778 0.296033 2.5055556 0.295769 2.5083333 0.296562 2.5111111 0.297884 2.5138889 0.298678 2.5166667 0.297620 2.5194444 0.294975 2.5222222 0.290479 2.5250000 0.287835 2.5277778 0.286512 2.5305556 0.285719 2.5333333 0.284132 2.5361111 0.283074 2.5388889 0.281752 2.5416667 0.281488 2.5444444 0.282281 2.5472222 0.282545 2.5500000 0.281752 2.5527778 0.280959 2.5555556 0.281752 2.5583333 0.282545 2.5611111 0.282017 2.5638889 0.282545 2.5666667 0.283868 2.5694444 0.284132 2.5722222 0.282545 2.5750000 0.282545 2.5777778 0.283868 2.5805556 0.283868 2.5833333 0.282810 2.5861111 0.282810 2.5888889 0.283074 2.5916667 0.283603 2.5944444 0.284132 2.5972222 0.283868 2.6000000 0.283603 2.6027778 0.282545 2.6055556 0.280959 2.6083333 0.281488 2.6111111 0.283868 2.6138889 0.285719 2.6166667 0.285719 2.6194444 0.284132 2.6222222 0.282545 2.6250000 0.282017 2.6277778 0.283074 2.6305556 0.283339 2.6333333 0.283868 2.6361111 0.283603 2.6388889 0.281752 2.6416667 0.283074 2.6444444 0.285983 2.6472222 0.290744 2.6500000 0.296033 2.6527778 0.301587 2.6555556 0.309256 2.6583333 0.317455 2.6611111 0.323008 2.6638889 0.323537 2.6666667 0.321686 2.6694444 0.322744 2.6722222 0.325388 2.6750000 0.329355 2.6777778 0.332264 2.6805556 0.334116 2.6833333 0.335702 2.6861111 0.337554 2.6888889 0.340198 2.6916667 0.342843 2.6944444 0.344430 2.6972222 0.344430 2.7000000 0.344694 2.7027778 0.343372 2.7055556 0.338876 2.7083333 0.334909 2.7111111 0.331207 2.7138889 0.330942 2.7166667 0.330149 2.7194444 0.324860 2.7222222 0.313223 2.7250000 0.298413 2.7277778 0.283603 2.7305556 0.274876 2.7333333 0.273025 2.7361111 0.273818 2.7388889 0.273818 2.7416667 0.272231 2.7444444 0.272231 2.7472222 0.273025 2.7500000 0.274347 2.7527778 0.275140 2.7555556 0.275669 2.7583333 0.276198 2.7611111 0.277521 2.7638889 0.278579 2.7666667 0.278314 2.7694444 0.276727 2.7722222 0.276463 2.7750000 0.277785 2.7777778 0.279372 2.7805556 0.278579 2.7833333 0.277785 2.7861111 0.276992 2.7888889 0.276727 2.7916667 0.276463 2.7944444 0.276463 2.7972222 0.276992 2.8000000 0.276727 2.8027778 0.275934 2.8055556 0.274083 2.8083333 0.274083 2.8111111 0.274612 2.8138889 0.275669 2.8166667 0.276463 2.8194444 0.275140 2.8222222 0.273818 2.8250000 0.273554 2.8277778 0.274347 2.8305556 0.275140 2.8333333 0.275669 2.8361111 0.274612 2.8388889 0.272760 2.8416667 0.272760 2.8444444 0.273554 2.8472222 0.274612 2.8500000 0.273818 2.8527778 0.273289 2.8555556 0.271967 2.8583333 0.272496 2.8611111 0.273554 2.8638889 0.274347 2.8666667 0.274083 2.8694444 0.273818 2.8722222 0.273818 2.8750000 0.273289 2.8777778 0.273025 2.8805556 0.274083 2.8833333 0.274347 2.8861111 0.273818 2.8888889 0.274347 2.8916667 0.274347 2.8944444 0.274083 2.8972222 0.274083 2.9000000 0.273554 2.9027778 0.273554 2.9055556 0.274083 2.9083333 0.275405 2.9111111 0.274612 2.9138889 0.275140 2.9166667 0.274876 2.9194444 0.274876 2.9222222 0.274876 2.9250000 0.275140 2.9277778 0.275934 2.9305556 0.276727 2.9333333 0.276727 2.9361111 0.275934 2.9388889 0.274876 2.9416667 0.275669 2.9444444 0.275934 2.9472222 0.276727 2.9500000 0.276992 2.9527778 0.278050 2.9555556 0.278579 2.9583333 0.278843 2.9611111 0.278314 2.9638889 0.278314 2.9666667 0.277785 2.9694444 0.278579 2.9722222 0.278314 2.9750000 0.279901 2.9777778 0.279372 2.9805556 0.279372 2.9833333 0.279372 2.9861111 0.279901 2.9888889 0.279636 2.9916667 0.280694 2.9944444 0.282281 2.9972222 0.282281 3.0030000 0.300000 3.1470000 0.300000 3.1500000 0.296826 3.1527778 0.297355 3.1555556 0.297620 3.1583333 0.297620 3.1611111 0.297884 3.1638889 0.298413 3.1666667 0.300000 3.1694444 0.301058 3.1722222 0.301851 3.1750000 0.302380 3.1777778 0.302380 3.1805556 0.303438 3.1833333 0.303702 3.1861111 0.304496 3.1888889 0.305025 3.1916667 0.304760 3.1944444 0.304760 3.1972222 0.306347 3.2000000 0.307140 3.2027778 0.308463 3.2055556 0.308727 3.2083333 0.308463 3.2111111 0.307140 3.2138889 0.306612 3.2166667 0.304496 3.2194444 0.303438 3.2222222 0.301322 3.2250000 0.299471 3.2277778 0.297884 3.2305556 0.296033 3.2333333 0.294975 3.2361111 0.293917 3.2388889 0.293124 3.2416667 0.292331 3.2444444 0.292595 3.2472222 0.292860 3.2500000 0.293124 3.2527778 0.293388 3.2555556 0.293388 3.2583333 0.293124 3.2611111 0.292595 3.2638889 0.292595 3.2666667 0.293124 3.2694444 0.293124 3.2722222 0.293653 3.2750000 0.293124 3.2777778 0.292860 3.2805556 0.292860 3.2833333 0.293388 3.2861111 0.294446 3.2888889 0.293917 3.2916667 0.293653 3.2944444 0.293124 3.2972222 0.293653 3.3000000 0.294182 3.3027778 0.294975 3.3055556 0.294711 3.3083333 0.294182 3.3111111 0.294182 3.3138889 0.294446 3.3166667 0.294446 3.3194444 0.294711 3.3222222 0.294975 3.3250000 0.294975 3.3277778 0.294711 3.3305556 0.294711 3.3333333 0.294446 3.3361111 0.293653 3.3388889 0.293653 3.3416667 0.293388 3.3444444 0.293653 3.3472222 0.294182 3.3500000 0.296033 3.3527778 0.299207 3.3555556 0.302909 3.3583333 0.308992 3.3611111 0.314810 3.3638889 0.321950 3.3666667 0.327769 3.3694444 0.328033 3.3722222 0.325388 3.3750000 0.325653 3.3777778 0.328562 3.3805556 0.331471 3.3833333 0.333587 3.3861111 0.335438 3.3888889 0.336231 3.3916667 0.335702 3.3944444 0.337289 3.3972222 0.341256 3.4000000 0.343901 3.4027778 0.345223 3.4055556 0.343636 3.4083333 0.339405 3.4111111 0.331471 3.4138889 0.322744 3.4166667 0.316397 3.4194444 0.311107 3.4222222 0.303967 3.4250000 0.295769 3.4277778 0.284132 3.4305556 0.276463 3.4333333 0.273025 3.4361111 0.274083 3.4388889 0.277256 3.4416667 0.278843 3.4444444 0.279636 3.4472222 0.280694 3.4500000 0.282545 3.4527778 0.284661 3.4555556 0.286512 3.4583333 0.287306 3.4611111 0.288099 3.4638889 0.288099 3.4666667 0.288364 3.4694444 0.288364 3.4722222 0.288364 3.4750000 0.288099 3.4777778 0.287570 3.4805556 0.287835 3.4833333 0.287835 3.4861111 0.288099 3.4888889 0.288364 3.4916667 0.287570 3.4944444 0.286777 3.4972222 0.287041 3.5000000 0.286777 3.5027778 0.287306 3.5055556 0.287041 3.5083333 0.286777 3.5111111 0.286248 3.5138889 0.286512 3.5166667 0.286248 3.5194444 0.286248 3.5222222 0.285983 3.5250000 0.285190 3.5277778 0.284661 3.5305556 0.284661 3.5333333 0.285455 3.5361111 0.285719 3.5388889 0.285455 3.5416667 0.284926 3.5444444 0.284397 3.5472222 0.284661 3.5500000 0.285455 3.5527778 0.286248 3.5555556 0.285983 3.5583333 0.285190 3.5611111 0.284661 3.5638889 0.284661 3.5666667 0.285455 3.5694444 0.284926 3.5722222 0.285455 3.5750000 0.285719 3.5777778 0.285455 3.5805556 0.285983 3.5833333 0.285455 3.5861111 0.286512 3.5888889 0.285983 3.5916667 0.286248 3.5944444 0.285719 3.5972222 0.285983 3.6000000 0.286512 3.6027778 0.287041 3.6055556 0.286777 3.6083333 0.287041 3.6111111 0.286777 3.6138889 0.286777 3.6166667 0.287041 3.6194444 0.287570 3.6222222 0.287041 3.6250000 0.287041 3.6277778 0.286248 3.6305556 0.288099 3.6333333 0.289421 3.6361111 0.289950 3.6388889 0.289421 3.6416667 0.289950 3.6444444 0.289686 3.6472222 0.290215 3.6500000 0.290479 3.6527778 0.290744 3.6555556 0.290744 3.6583333 0.290744 3.6611111 0.291273 3.6638889 0.291537 3.6666667 0.292066 3.6694444 0.292066 3.6722222 0.292331 3.6750000 0.292860 3.6777778 0.293124 3.6805556 0.293917 3.6833333 0.294182 3.6861111 0.294182 3.6888889 0.294446 3.6916667 0.294711 3.6944444 0.294446 3.6972222 0.294446 3.7030000 0.300000 3.8470000 0.300000 3.8500000 0.294711 3.8527778 0.294182 3.8555556 0.294446 3.8583333 0.296826 3.8611111 0.298678 3.8638889 0.298413 3.8666667 0.298413 3.8694444 0.297884 3.8722222 0.297884 3.8750000 0.298678 3.8777778 0.300264 3.8805556 0.300793 3.8833333 0.301587 3.8861111 0.302116 3.8888889 0.301851 3.8916667 0.301851 3.8944444 0.302380 3.8972222 0.303438 3.9000000 0.303967 3.9027778 0.303967 3.9055556 0.303702 3.9083333 0.304231 3.9111111 0.305818 3.9138889 0.306876 3.9166667 0.307140 3.9194444 0.306347 3.9222222 0.305818 3.9250000 0.304760 3.9277778 0.302645 3.9305556 0.301058 3.9333333 0.298678 3.9361111 0.296298 3.9388889 0.294182 3.9416667 0.293653 3.9444444 0.292860 3.9472222 0.292066 3.9500000 0.292066 3.9527778 0.290744 3.9555556 0.290744 3.9583333 0.292066 3.9611111 0.293124 3.9638889 0.293917 3.9666667 0.293388 3.9694444 0.292860 3.9722222 0.291537 3.9750000 0.291537 3.9777778 0.291802 3.9805556 0.292066 3.9833333 0.291537 3.9861111 0.291273 3.9888889 0.290744 3.9916667 0.291008 3.9944444 0.292066 3.9972222 0.292860 4.0000000 0.293388 4.0027778 0.292860 4.0055556 0.291802 4.0083333 0.292066 4.0111111 0.292331 4.0138889 0.293124 4.0166667 0.292860 4.0194444 0.293653 4.0222222 0.292066 4.0250000 0.291537 4.0277778 0.292595 4.0305556 0.293124 4.0333333 0.293124 4.0361111 0.292860 4.0388889 0.292066 4.0416667 0.291802 4.0444444 0.291802 4.0472222 0.291008 4.0500000 0.291008 4.0527778 0.293388 4.0555556 0.297091 4.0583333 0.302380 4.0611111 0.308198 4.0638889 0.315603 4.0666667 0.322215 4.0694444 0.324595 4.0722222 0.323537 4.0750000 0.323537 4.0777778 0.326446 4.0805556 0.330413 4.0833333 0.332264 4.0861111 0.332793 4.0888889 0.333851 4.0916667 0.336231 4.0944444 0.340727 4.0972222 0.344959 4.1000000 0.347074 4.1027778 0.347868 4.1055556 0.347339 4.1083333 0.343901 4.1111111 0.337554 4.1138889 0.328298 4.1166667 0.320364 4.1194444 0.313223 4.1222222 0.303438 4.1250000 0.292595 4.1277778 0.282017 4.1305556 0.274347 4.1333333 0.270909 4.1361111 0.271702 4.1388889 0.273554 4.1416667 0.276463 4.1444444 0.277785 4.1472222 0.277785 4.1500000 0.278579 4.1527778 0.280165 4.1555556 0.280959 4.1583333 0.282017 4.1611111 0.283603 4.1638889 0.285190 4.1666667 0.284926 4.1694444 0.283868 4.1722222 0.282545 4.1750000 0.282545 4.1777778 0.283868 4.1805556 0.283868 4.1833333 0.283339 4.1861111 0.283339 4.1888889 0.282281 4.1916667 0.282545 4.1944444 0.282017 4.1972222 0.281752 4.2000000 0.281752 4.2027778 0.282281 4.2055556 0.282545 4.2083333 0.283868 4.2111111 0.283603 4.2138889 0.284397 4.2166667 0.283339 4.2194444 0.282281 4.2222222 0.280694 4.2250000 0.279901 4.2277778 0.280959 4.2305556 0.282281 4.2333333 0.282545 4.2361111 0.282017 4.2388889 0.281752 4.2416667 0.280694 4.2444444 0.280165 4.2472222 0.280165 4.2500000 0.282545 4.2527778 0.282810 4.2555556 0.282017 4.2583333 0.282281 4.2611111 0.282017 4.2638889 0.281488 4.2666667 0.281223 4.2694444 0.280959 4.2722222 0.281752 4.2750000 0.280959 4.2777778 0.280430 4.2805556 0.281488 4.2833333 0.281488 4.2861111 0.280959 4.2888889 0.280430 4.2916667 0.280430 4.2944444 0.280694 4.2972222 0.280430 4.3000000 0.280959 4.3027778 0.280165 4.3055556 0.280430 4.3083333 0.281223 4.3111111 0.282545 4.3138889 0.282810 4.3166667 0.281752 4.3194444 0.281752 4.3222222 0.281752 4.3250000 0.283339 4.3277778 0.283868 4.3305556 0.284132 4.3333333 0.284926 4.3361111 0.284926 4.3388889 0.284397 4.3416667 0.284397 4.3444444 0.286512 4.3472222 0.287570 4.3500000 0.288628 4.3527778 0.286248 4.3555556 0.285983 4.3583333 0.285983 4.3611111 0.286777 4.3638889 0.287306 4.3666667 0.286777 4.3694444 0.286512 4.3722222 0.286248 4.3750000 0.288099 4.3777778 0.290215 4.3805556 0.290744 4.3833333 0.290744 4.3861111 0.289686 4.3888889 0.288628 4.3916667 0.289421 4.3944444 0.289950 4.3972222 0.291008 4.4030000 0.300000 4.5470000 0.300000 4.5500000 0.291802 4.5527778 0.291537 4.5555556 0.291802 4.5583333 0.292860 4.5611111 0.294182 4.5638889 0.295240 4.5666667 0.296562 4.5694444 0.296562 4.5722222 0.296562 4.5750000 0.296826 4.5777778 0.296562 4.5805556 0.296298 4.5833333 0.298413 4.5861111 0.299736 4.5888889 0.300264 4.5916667 0.300264 4.5944444 0.299736 4.5972222 0.301058 4.6000000 0.302116 4.6027778 0.302645 4.6055556 0.303174 4.6083333 0.303438 4.6111111 0.303967 4.6138889 0.303967 4.6166667 0.303702 4.6194444 0.303967 4.6222222 0.303702 4.6250000 0.302380 4.6277778 0.299471 4.6305556 0.296298 4.6333333 0.294711 4.6361111 0.294446 4.6388889 0.292860 4.6416667 0.289686 4.6444444 0.287570 4.6472222 0.287835 4.6500000 0.289421 4.6527778 0.290215 4.6555556 0.291273 4.6583333 0.289686 4.6611111 0.288893 4.6638889 0.287835 4.6666667 0.288893 4.6694444 0.290215 4.6722222 0.289950 4.6750000 0.289950 4.6777778 0.289157 4.6805556 0.288364 4.6833333 0.288099 4.6861111 0.288628 4.6888889 0.289686 4.6916667 0.289157 4.6944444 0.289421 4.6972222 0.288628 4.7000000 0.288893 4.7027778 0.288893 4.7055556 0.288364 4.7083333 0.289157 4.7111111 0.288628 4.7138889 0.288099 4.7166667 0.288893 4.7194444 0.289421 4.7222222 0.289157 4.7250000 0.289157 4.7277778 0.290479 4.7305556 0.290215 4.7333333 0.289950 4.7361111 0.290479 4.7388889 0.289950 4.7416667 0.288628 4.7444444 0.288364 4.7472222 0.287306 4.7500000 0.287041 4.7527778 0.287570 4.7555556 0.289421 4.7583333 0.292331 4.7611111 0.298149 4.7638889 0.304231 4.7666667 0.311636 4.7694444 0.316132 4.7722222 0.316661 4.7750000 0.316397 4.7777778 0.317719 4.7805556 0.321157 4.7833333 0.324331 4.7861111 0.326711 4.7888889 0.329620 4.7916667 0.332000 4.7944444 0.334380 4.7972222 0.337025 4.8000000 0.338347 4.8027778 0.338876 4.8055556 0.338083 4.8083333 0.334909 4.8111111 0.329355 4.8138889 0.321421 4.8166667 0.315339 4.8194444 0.309785 4.8222222 0.303967 4.8250000 0.293653 4.8277778 0.282810 4.8305556 0.271702 4.8333333 0.266413 4.8361111 0.266678 4.8388889 0.271174 4.8416667 0.273818 4.8444444 0.275140 4.8472222 0.275934 4.8500000 0.277785 4.8527778 0.280694 4.8555556 0.281488 4.8583333 0.281223 4.8611111 0.281752 4.8638889 0.282017 4.8666667 0.282281 4.8694444 0.282545 4.8722222 0.282281 4.8750000 0.282545 4.8777778 0.281752 4.8805556 0.281752 4.8833333 0.281752 4.8861111 0.281223 4.8888889 0.281752 4.8916667 0.280959 4.8944444 0.280959 4.8972222 0.280959 4.9000000 0.281488 4.9027778 0.282017 4.9055556 0.282017 4.9083333 0.280959 4.9111111 0.281223 4.9138889 0.281488 4.9166667 0.281488 4.9194444 0.281488 4.9222222 0.279636 4.9250000 0.279107 4.9277778 0.279107 4.9305556 0.280165 4.9333333 0.280430 4.9361111 0.280959 4.9388889 0.280694 4.9416667 0.279636 4.9444444 0.279372 4.9472222 0.278843 4.9500000 0.278843 4.9527778 0.279901 4.9555556 0.279901 4.9583333 0.279901 4.9611111 0.279636 4.9638889 0.279372 4.9666667 0.280959 4.9694444 0.280430 4.9722222 0.279636 4.9750000 0.279636 4.9777778 0.280430 4.9805556 0.280959 4.9833333 0.281752 4.9861111 0.282017 4.9888889 0.281223 4.9916667 0.280959 4.9944444 0.279901 4.9972222 0.279636 5.0000000 0.280959 5.0027778 0.282281 5.0055556 0.282545 5.0083333 0.282017 5.0111111 0.281223 5.0138889 0.281223 5.0166667 0.280959 5.0194444 0.281752 5.0222222 0.282017 5.0250000 0.282017 5.0277778 0.282810 5.0305556 0.283339 5.0333333 0.283868 5.0361111 0.283868 5.0388889 0.284132 5.0416667 0.284397 5.0444444 0.284661 5.0472222 0.284926 5.0500000 0.285719 5.0527778 0.285719 5.0555556 0.285719 5.0583333 0.285190 5.0611111 0.284926 5.0638889 0.285983 5.0666667 0.287570 5.0694444 0.289421 5.0722222 0.288628 5.0750000 0.288364 5.0777778 0.288893 5.0805556 0.289421 5.0833333 0.289157 5.0861111 0.289686 5.0888889 0.290215 5.0916667 0.290479 5.0944444 0.290215 5.0972222 0.289950 5.1030000 0.300000 5.2470000 0.300000 5.2500000 0.289686 5.2527778 0.289950 5.2555556 0.291008 5.2583333 0.290215 5.2611111 0.291008 5.2638889 0.291537 5.2666667 0.293653 5.2694444 0.293917 5.2722222 0.294182 5.2750000 0.293653 5.2777778 0.293653 5.2805556 0.293124 5.2833333 0.294446 5.2861111 0.296562 5.2888889 0.297355 5.2916667 0.297355 5.2944444 0.298149 5.2972222 0.299471 5.3000000 0.300793 5.3027778 0.301058 5.3055556 0.301322 5.3083333 0.301587 5.3111111 0.302116 5.3138889 0.301851 5.3166667 0.302909 5.3194444 0.303702 5.3222222 0.303174 5.3250000 0.302380 5.3277778 0.299471 5.3305556 0.297091 5.3333333 0.294446 5.3361111 0.293653 5.3388889 0.291537 5.3416667 0.290215 5.3444444 0.287570 5.3472222 0.285983 5.3500000 0.286248 5.3527778 0.286777 5.3555556 0.287306 5.3583333 0.287570 5.3611111 0.287570 5.3638889 0.287041 5.3666667 0.287835 5.3694444 0.288364 5.3722222 0.288628 5.3750000 0.288099 5.3777778 0.287570 5.3805556 0.287570 5.3833333 0.287570 5.3861111 0.287835 5.3888889 0.287835 5.3916667 0.286777 5.3944444 0.286777 5.3972222 0.286248 5.4000000 0.287570 5.4027778 0.288364 5.4055556 0.287835 5.4083333 0.287041 5.4111111 0.286777 5.4138889 0.286248 5.4166667 0.287306 5.4194444 0.287570 5.4222222 0.287570 5.4250000 0.287835 5.4277778 0.287570 5.4305556 0.287570 5.4333333 0.288099 5.4361111 0.288628 5.4388889 0.288364 5.4416667 0.286777 5.4444444 0.285983 5.4472222 0.285983 5.4500000 0.285190 5.4527778 0.284132 5.4555556 0.284661 5.4583333 0.287306 5.4611111 0.291802 5.4638889 0.298149 5.4666667 0.305289 5.4694444 0.311636 5.4722222 0.314545 5.4750000 0.313752 5.4777778 0.311901 5.4805556 0.313488 5.4833333 0.317455 5.4861111 0.320364 5.4888889 0.322215 5.4916667 0.324066 5.4944444 0.325388 5.4972222 0.326711 5.5000000 0.328562 5.5027778 0.329091 5.5055556 0.328562 5.5083333 0.326446 5.5111111 0.321421 5.5138889 0.314545 5.5166667 0.306612 5.5194444 0.300529 5.5222222 0.293917 5.5250000 0.285983 5.5277778 0.275140 5.5305556 0.265355 5.5333333 0.260860 5.5361111 0.261653 5.5388889 0.264826 5.5416667 0.268793 5.5444444 0.270380 5.5472222 0.271438 5.5500000 0.271174 5.5527778 0.273818 5.5555556 0.276463 5.5583333 0.279372 5.5611111 0.279636 5.5638889 0.280430 5.5666667 0.280694 5.5694444 0.282017 5.5722222 0.282281 5.5750000 0.282281 5.5777778 0.281752 5.5805556 0.280959 5.5833333 0.280694 5.5861111 0.279901 5.5888889 0.279372 5.5916667 0.280694 5.5944444 0.281488 5.5972222 0.280430 5.6000000 0.279901 5.6027778 0.280430 5.6055556 0.281223 5.6083333 0.280694 5.6111111 0.279636 5.6138889 0.278843 5.6166667 0.279107 5.6194444 0.280165 5.6222222 0.279372 5.6250000 0.279372 5.6277778 0.278843 5.6305556 0.278050 5.6333333 0.279372 5.6361111 0.279901 5.6388889 0.280694 5.6416667 0.279901 5.6444444 0.279107 5.6472222 0.278579 5.6500000 0.279107 5.6527778 0.279636 5.6555556 0.279636 5.6583333 0.279372 5.6611111 0.278843 5.6638889 0.279107 5.6666667 0.280430 5.6694444 0.281488 5.6722222 0.280959 5.6750000 0.280694 5.6777778 0.279372 5.6805556 0.278843 5.6833333 0.279636 5.6861111 0.280430 5.6888889 0.281223 5.6916667 0.280959 5.6944444 0.280430 5.6972222 0.280694 5.7000000 0.282017 5.7027778 0.282281 5.7055556 0.281488 5.7083333 0.281488 5.7111111 0.280959 5.7138889 0.281488 5.7166667 0.282017 5.7194444 0.282281 5.7222222 0.282545 5.7250000 0.282810 5.7277778 0.282281 5.7305556 0.282281 5.7333333 0.283868 5.7361111 0.284661 5.7388889 0.284661 5.7416667 0.284397 5.7444444 0.283074 5.7472222 0.283603 5.7500000 0.284926 5.7527778 0.284661 5.7555556 0.285190 5.7583333 0.285983 5.7611111 0.286248 5.7638889 0.286248 5.7666667 0.287041 5.7694444 0.287570 5.7722222 0.287570 5.7750000 0.287570 5.7777778 0.287570 5.7805556 0.287570 5.7833333 0.288364 5.7861111 0.288628 5.7888889 0.288893 5.7916667 0.288628 5.7944444 0.288099 5.7972222 0.288099 5.8030000 0.300000 5.9470000 0.300000 5.9500000 0.284926 5.9527778 0.285983 5.9555556 0.286777 5.9583333 0.287041 5.9611111 0.285719 5.9638889 0.285719 5.9666667 0.287041 5.9694444 0.288099 5.9722222 0.288893 5.9750000 0.288628 5.9777778 0.288628 5.9805556 0.288628 5.9833333 0.290479 5.9861111 0.291802 5.9888889 0.292595 5.9916667 0.293124 5.9944444 0.293388 5.9972222 0.293917 6.0000000 0.294711 6.0027778 0.294446 6.0055556 0.295240 6.0083333 0.296033 6.0111111 0.296826 6.0138889 0.296562 6.0166667 0.297091 6.0194444 0.297620 6.0222222 0.297091 6.0250000 0.294975 6.0277778 0.292066 6.0305556 0.289157 6.0333333 0.288628 6.0361111 0.287835 6.0388889 0.285719 6.0416667 0.282810 6.0444444 0.280959 6.0472222 0.280959 6.0500000 0.282281 6.0527778 0.282545 6.0555556 0.282545 6.0583333 0.281223 6.0611111 0.282017 6.0638889 0.281752 6.0666667 0.282810 6.0694444 0.282810 6.0722222 0.282545 6.0750000 0.281488 6.0777778 0.281223 6.0805556 0.281223 6.0833333 0.282281 6.0861111 0.282545 6.0888889 0.282810 6.0916667 0.282017 6.0944444 0.282281 6.0972222 0.281223 6.1000000 0.282017 6.1027778 0.282545 6.1055556 0.282017 6.1083333 0.281488 6.1111111 0.281223 6.1138889 0.280694 6.1166667 0.281752 6.1194444 0.282017 6.1222222 0.282281 6.1250000 0.281488 6.1277778 0.280694 6.1305556 0.280165 6.1333333 0.281752 6.1361111 0.281488 6.1388889 0.282281 6.1416667 0.281752 6.1444444 0.280694 6.1472222 0.280430 6.1500000 0.282017 6.1527778 0.283074 6.1555556 0.284926 6.1583333 0.287306 6.1611111 0.291008 6.1638889 0.294975 6.1666667 0.300000 6.1694444 0.306876 6.1722222 0.313223 6.1750000 0.315603 6.1777778 0.313488 6.1805556 0.313223 6.1833333 0.315868 6.1861111 0.318777 6.1888889 0.321421 6.1916667 0.324331 6.1944444 0.326711 6.1972222 0.327769 6.2000000 0.329884 6.2027778 0.331471 6.2055556 0.330942 6.2083333 0.328562 6.2111111 0.323273 6.2138889 0.315868 6.2166667 0.309785 6.2194444 0.304231 6.2222222 0.296826 6.2250000 0.287570 6.2277778 0.276198 6.2305556 0.266413 6.2333333 0.260860 6.2361111 0.259008 6.2388889 0.259802 6.2416667 0.261388 6.2444444 0.262975 6.2472222 0.263769 6.2500000 0.265091 6.2527778 0.266413 6.2555556 0.267736 6.2583333 0.269322 6.2611111 0.270909 6.2638889 0.271702 6.2666667 0.273289 6.2694444 0.273025 6.2722222 0.273025 6.2750000 0.272760 6.2777778 0.271438 6.2805556 0.270380 6.2833333 0.270909 6.2861111 0.271174 6.2888889 0.271702 6.2916667 0.271702 6.2944444 0.271702 6.2972222 0.270645 6.3000000 0.270116 6.3027778 0.270116 6.3055556 0.270380 6.3083333 0.270380 6.3111111 0.269322 6.3138889 0.268529 6.3166667 0.268793 6.3194444 0.270116 6.3222222 0.270909 6.3250000 0.270380 6.3277778 0.269058 6.3305556 0.268529 6.3333333 0.268529 6.3361111 0.269851 6.3388889 0.270116 6.3416667 0.270116 6.3444444 0.269322 6.3472222 0.268529 6.3500000 0.269058 6.3527778 0.269587 6.3555556 0.270116 6.3583333 0.269322 6.3611111 0.268793 6.3638889 0.268529 6.3666667 0.269587 6.3694444 0.269851 6.3722222 0.269322 6.3750000 0.268793 6.3777778 0.268793 6.3805556 0.268529 6.3833333 0.269322 6.3861111 0.270380 6.3888889 0.270116 6.3916667 0.270380 6.3944444 0.269322 6.3972222 0.270116 6.4000000 0.270116 6.4027778 0.270380 6.4055556 0.270909 6.4083333 0.270645 6.4111111 0.270116 6.4138889 0.270380 6.4166667 0.269851 6.4194444 0.270645 6.4222222 0.270909 6.4250000 0.270116 6.4277778 0.270380 6.4305556 0.270380 6.4333333 0.271438 6.4361111 0.271702 6.4388889 0.271438 6.4416667 0.271967 6.4444444 0.271438 6.4472222 0.271702 6.4500000 0.273025 6.4527778 0.274083 6.4555556 0.274083 6.4583333 0.273554 6.4611111 0.273025 6.4638889 0.273289 6.4666667 0.274347 6.4694444 0.275140 6.4722222 0.275669 6.4750000 0.275140 6.4777778 0.275140 6.4805556 0.275140 6.4833333 0.275405 6.4861111 0.276198 6.4888889 0.277256 6.4916667 0.277256 6.4944444 0.276463 6.4972222 0.276992 6.5030000 0.300000 6.6470000 0.300000 6.6500000 0.284661 6.6527778 0.284397 6.6555556 0.284661 6.6583333 0.285983 6.6611111 0.286777 6.6638889 0.287306 6.6666667 0.286512 6.6694444 0.286512 6.6722222 0.287306 6.6750000 0.288099 6.6777778 0.288893 6.6805556 0.289157 6.6833333 0.289421 6.6861111 0.290479 6.6888889 0.292066 6.6916667 0.291802 6.6944444 0.293917 6.6972222 0.294182 6.7000000 0.294446 6.7027778 0.293653 6.7055556 0.294711 6.7083333 0.296033 6.7111111 0.296826 6.7138889 0.296562 6.7166667 0.296826 6.7194444 0.297355 6.7222222 0.297091 6.7250000 0.295769 6.7277778 0.294446 6.7305556 0.291802 6.7333333 0.289157 6.7361111 0.286512 6.7388889 0.285455 6.7416667 0.283603 6.7444444 0.282017 6.7472222 0.281223 6.7500000 0.281223 6.7527778 0.281223 6.7555556 0.282545 6.7583333 0.283074 6.7611111 0.283074 6.7638889 0.282281 6.7666667 0.281488 6.7694444 0.281223 6.7722222 0.281488 6.7750000 0.282017 6.7777778 0.282281 6.7805556 0.282545 6.7833333 0.282545 6.7861111 0.282545 6.7888889 0.282545 6.7916667 0.282545 6.7944444 0.282545 6.7972222 0.282545 6.8000000 0.282281 6.8027778 0.282810 6.8055556 0.283074 6.8083333 0.283339 6.8111111 0.283603 6.8138889 0.283074 6.8166667 0.283074 6.8194444 0.283074 6.8222222 0.283868 6.8250000 0.284132 6.8277778 0.284132 6.8305556 0.284397 6.8333333 0.283868 6.8361111 0.283074 6.8388889 0.283074 6.8416667 0.283074 6.8444444 0.283868 6.8472222 0.282810 6.8500000 0.283339 6.8527778 0.283868 6.8555556 0.286248 6.8583333 0.290215 6.8611111 0.294975 6.8638889 0.300793 6.8666667 0.307669 6.8694444 0.314545 6.8722222 0.319041 6.8750000 0.318248 6.8777778 0.317719 6.8805556 0.320099 6.8833333 0.321950 6.8861111 0.324066 6.8888889 0.328033 6.8916667 0.331207 6.8944444 0.332793 6.8972222 0.334380 6.9000000 0.336496 6.9027778 0.337289 6.9055556 0.337025 6.9083333 0.334116 6.9111111 0.326711 6.9138889 0.318512 6.9166667 0.310579 6.9194444 0.303174 6.9222222 0.295504 6.9250000 0.286248 6.9277778 0.275669 6.9305556 0.267471 6.9333333 0.261917 6.9361111 0.260066 6.9388889 0.262711 6.9416667 0.266149 6.9444444 0.268000 6.9472222 0.268000 6.9500000 0.268793 6.9527778 0.270116 6.9555556 0.273025 6.9583333 0.275405 6.9611111 0.275405 6.9638889 0.276463 6.9666667 0.276198 6.9694444 0.276198 6.9722222 0.275934 6.9750000 0.276198 6.9777778 0.277256 6.9805556 0.277256 6.9833333 0.276463 6.9861111 0.275669 6.9888889 0.275934 6.9916667 0.276463 6.9944444 0.276463 6.9972222 0.275669 7.0000000 0.275140 7.0027778 0.274612 7.0055556 0.274876 7.0083333 0.275669 7.0111111 0.275405 7.0138889 0.275405 7.0166667 0.275140 7.0194444 0.274612 7.0222222 0.274876 7.0250000 0.274876 7.0277778 0.274876 7.0305556 0.274876 7.0333333 0.273818 7.0361111 0.274083 7.0388889 0.274612 7.0416667 0.274876 7.0444444 0.275140 7.0472222 0.274083 7.0500000 0.273818 7.0527778 0.273818 7.0555556 0.274876 7.0583333 0.275405 7.0611111 0.274876 7.0638889 0.274876 7.0666667 0.275140 7.0694444 0.274083 7.0722222 0.274612 7.0750000 0.275140 7.0777778 0.275405 7.0805556 0.275140 7.0833333 0.275669 7.0861111 0.275669 7.0888889 0.276198 7.0916667 0.276727 7.0944444 0.276198 7.0972222 0.275669 7.1000000 0.275140 7.1027778 0.275669 7.1055556 0.276198 7.1083333 0.275934 7.1111111 0.275934 7.1138889 0.276198 7.1166667 0.276727 7.1194444 0.276727 7.1222222 0.277521 7.1250000 0.278579 7.1277778 0.277785 7.1305556 0.278050 7.1333333 0.277785 7.1361111 0.277521 7.1388889 0.278579 7.1416667 0.279901 7.1444444 0.279901 7.1472222 0.280165 7.1500000 0.280165 7.1527778 0.279636 7.1555556 0.280959 7.1583333 0.280959 7.1611111 0.281752 7.1638889 0.281752 7.1666667 0.281488 7.1694444 0.280959 7.1722222 0.282281 7.1750000 0.282810 7.1777778 0.282810 7.1805556 0.283074 7.1833333 0.283339 7.1861111 0.283339 7.1888889 0.284397 7.1916667 0.285190 7.1944444 0.285190 7.1972222 0.284926 7.2030000 0.300000 7.3470000 0.300000 7.3500000 0.292595 7.3527778 0.292860 7.3555556 0.292331 7.3583333 0.293653 7.3611111 0.294711 7.3638889 0.294711 7.3666667 0.295504 7.3694444 0.295769 7.3722222 0.296562 7.3750000 0.298413 7.3777778 0.298942 7.3805556 0.299736 7.3833333 0.299736 7.3861111 0.300000 7.3888889 0.299471 7.3916667 0.300529 7.3944444 0.302380 7.3972222 0.302909 7.4000000 0.302909 7.4027778 0.303702 7.4055556 0.302909 7.4083333 0.304496 7.4111111 0.304231 7.4138889 0.302380 7.4166667 0.299736 7.4194444 0.298149 7.4222222 0.296033 7.4250000 0.294975 7.4277778 0.293388 7.4305556 0.291273 7.4333333 0.288893 7.4361111 0.286512 7.4388889 0.286777 7.4416667 0.288099 7.4444444 0.288893 7.4472222 0.289686 7.4500000 0.289157 7.4527778 0.287570 7.4555556 0.287835 7.4583333 0.288628 7.4611111 0.288893 7.4638889 0.288893 7.4666667 0.288364 7.4694444 0.287306 7.4722222 0.287570 7.4750000 0.288364 7.4777778 0.288893 7.4805556 0.288099 7.4833333 0.287835 7.4861111 0.287835 7.4888889 0.287835 7.4916667 0.288364 7.4944444 0.288628 7.4972222 0.289157 7.5000000 0.288364 7.5027778 0.288364 7.5055556 0.288099 7.5083333 0.288628 7.5111111 0.289157 7.5138889 0.288893 7.5166667 0.288893 7.5194444 0.288364 7.5222222 0.288628 7.5250000 0.289157 7.5277778 0.289686 7.5305556 0.289686 7.5333333 0.288893 7.5361111 0.288099 7.5388889 0.288099 7.5416667 0.288628 7.5444444 0.289157 7.5472222 0.289157 7.5500000 0.290744 7.5527778 0.292860 7.5555556 0.297620 7.5583333 0.302909 7.5611111 0.309785 7.5638889 0.316132 7.5666667 0.321950 7.5694444 0.324331 7.5722222 0.322744 7.5750000 0.322479 7.5777778 0.324331 7.5805556 0.328033 7.5833333 0.329884 7.5861111 0.331471 7.5888889 0.333058 7.5916667 0.335702 7.5944444 0.337289 7.5972222 0.338083 7.6000000 0.340198 7.6027778 0.341256 7.6055556 0.340198 7.6083333 0.337818 7.6111111 0.333058 7.6138889 0.324860 7.6166667 0.316926 7.6194444 0.310579 7.6222222 0.303438 7.6250000 0.296033 7.6277778 0.286512 7.6305556 0.276727 7.6333333 0.269851 7.6361111 0.265355 7.6388889 0.265091 7.6416667 0.268793 7.6444444 0.272231 7.6472222 0.273818 7.6500000 0.273554 7.6527778 0.274347 7.6555556 0.275669 7.6583333 0.278050 7.6611111 0.280165 7.6638889 0.280959 7.6666667 0.281752 7.6694444 0.281488 7.6722222 0.282281 7.6750000 0.282017 7.6777778 0.282545 7.6805556 0.282810 7.6833333 0.282281 7.6861111 0.281752 7.6888889 0.281488 7.6916667 0.282017 7.6944444 0.282017 7.6972222 0.282017 7.7000000 0.282545 7.7027778 0.281488 7.7055556 0.281223 7.7083333 0.281488 7.7111111 0.282017 7.7138889 0.281752 7.7166667 0.281488 7.7194444 0.281223 7.7222222 0.280694 7.7250000 0.281488 7.7277778 0.282281 7.7305556 0.281488 7.7333333 0.280430 7.7361111 0.280165 7.7388889 0.280430 7.7416667 0.280694 7.7444444 0.281223 7.7472222 0.280694 7.7500000 0.280694 7.7527778 0.279901 7.7555556 0.280165 7.7583333 0.279372 7.7611111 0.280430 7.7638889 0.280959 7.7666667 0.280165 7.7694444 0.279901 7.7722222 0.279636 7.7750000 0.280430 7.7777778 0.281488 7.7805556 0.280959 7.7833333 0.280694 7.7861111 0.280165 7.7888889 0.280694 7.7916667 0.281488 7.7944444 0.282281 7.7972222 0.282281 7.8000000 0.281488 7.8027778 0.281488 7.8055556 0.280959 7.8083333 0.281752 7.8111111 0.282281 7.8138889 0.282545 7.8166667 0.282810 7.8194444 0.282017 7.8222222 0.282017 7.8250000 0.282545 7.8277778 0.283339 7.8305556 0.282545 7.8333333 0.282017 7.8361111 0.283603 7.8388889 0.283868 7.8416667 0.284661 7.8444444 0.285190 7.8472222 0.284926 7.8500000 0.285983 7.8527778 0.285983 7.8555556 0.285719 7.8583333 0.286248 7.8611111 0.287041 7.8638889 0.287041 7.8666667 0.287835 7.8694444 0.287570 7.8722222 0.287835 7.8750000 0.288628 7.8777778 0.288893 7.8805556 0.289157 7.8833333 0.288893 7.8861111 0.288893 7.8888889 0.289157 7.8916667 0.289421 7.8944444 0.291273 7.8972222 0.290744 7.9030000 0.300000 8.0470000 0.300000 8.0500000 0.292331 8.0527778 0.292860 8.0555556 0.293124 8.0583333 0.294711 8.0611111 0.294711 8.0638889 0.294446 8.0666667 0.294182 8.0694444 0.294975 8.0722222 0.296033 8.0750000 0.297620 8.0777778 0.297355 8.0805556 0.297355 8.0833333 0.297884 8.0861111 0.298942 8.0888889 0.300529 8.0916667 0.301587 8.0944444 0.301587 8.0972222 0.301322 8.1000000 0.301587 8.1027778 0.302909 8.1055556 0.303967 8.1083333 0.304760 8.1111111 0.303967 8.1138889 0.303438 8.1166667 0.301058 8.1194444 0.298942 8.1222222 0.296826 8.1250000 0.296033 8.1277778 0.294446 8.1305556 0.292860 8.1333333 0.290479 8.1361111 0.287835 8.1388889 0.287570 8.1416667 0.287570 8.1444444 0.287835 8.1472222 0.288893 8.1500000 0.289157 8.1527778 0.288893 8.1555556 0.288893 8.1583333 0.288893 8.1611111 0.288628 8.1638889 0.286777 8.1666667 0.287041 8.1694444 0.287570 8.1722222 0.288364 8.1750000 0.288364 8.1777778 0.288099 8.1805556 0.288364 8.1833333 0.288628 8.1861111 0.288893 8.1888889 0.289421 8.1916667 0.289421 8.1944444 0.288893 8.1972222 0.288099 8.2000000 0.288099 8.2027778 0.288628 8.2055556 0.289421 8.2083333 0.289950 8.2111111 0.289686 8.2138889 0.288628 8.2166667 0.288099 8.2194444 0.288893 8.2222222 0.289421 8.2250000 0.289686 8.2277778 0.289686 8.2305556 0.290215 8.2333333 0.289950 8.2361111 0.289157 8.2388889 0.289421 8.2416667 0.289950 8.2444444 0.289686 8.2472222 0.290479 8.2500000 0.290744 8.2527778 0.293653 8.2555556 0.298149 8.2583333 0.303174 8.2611111 0.308992 8.2638889 0.316661 8.2666667 0.323802 8.2694444 0.328826 8.2722222 0.328033 8.2750000 0.327240 8.2777778 0.329091 8.2805556 0.332529 8.2833333 0.334909 8.2861111 0.338083 8.2888889 0.340727 8.2916667 0.342843 8.2944444 0.344165 8.2972222 0.347339 8.3000000 0.349983 8.3027778 0.350248 8.3055556 0.349455 8.3083333 0.345752 8.3111111 0.337818 8.3138889 0.328033 8.3166667 0.319041 8.3194444 0.311107 8.3222222 0.302380 8.3250000 0.291537 8.3277778 0.280959 8.3305556 0.272496 8.3333333 0.266942 8.3361111 0.266413 8.3388889 0.269851 8.3416667 0.273025 8.3444444 0.274347 8.3472222 0.274083 8.3500000 0.274876 8.3527778 0.276463 8.3555556 0.278579 8.3583333 0.280959 8.3611111 0.281752 8.3638889 0.281488 8.3666667 0.280959 8.3694444 0.281223 8.3722222 0.280694 8.3750000 0.281752 8.3777778 0.281223 8.3805556 0.280694 8.3833333 0.280165 8.3861111 0.280165 8.3888889 0.280959 8.3916667 0.281223 8.3944444 0.280694 8.3972222 0.279901 8.4000000 0.279107 8.4027778 0.279107 8.4055556 0.279636 8.4083333 0.279901 8.4111111 0.279636 8.4138889 0.278579 8.4166667 0.278050 8.4194444 0.278314 8.4222222 0.278314 8.4250000 0.279636 8.4277778 0.278579 8.4305556 0.278843 8.4333333 0.278050 8.4361111 0.278579 8.4388889 0.279107 8.4416667 0.279107 8.4444444 0.278843 8.4472222 0.278579 8.4500000 0.277521 8.4527778 0.278050 8.4555556 0.278843 8.4583333 0.279372 8.4611111 0.279636 8.4638889 0.278843 8.4666667 0.278314 8.4694444 0.278843 8.4722222 0.279372 8.4750000 0.280430 8.4777778 0.280694 8.4805556 0.279901 8.4833333 0.279107 8.4861111 0.279636 8.4888889 0.280430 8.4916667 0.280694 8.4944444 0.280959 8.4972222 0.280165 8.5000000 0.280165 8.5027778 0.280694 8.5055556 0.281488 8.5083333 0.282281 8.5111111 0.282017 8.5138889 0.281488 8.5166667 0.281488 8.5194444 0.281752 8.5222222 0.282281 8.5250000 0.283074 8.5277778 0.283603 8.5305556 0.284132 8.5333333 0.283339 8.5361111 0.283339 8.5388889 0.285190 8.5416667 0.285983 8.5444444 0.285719 8.5472222 0.285983 8.5500000 0.285455 8.5527778 0.285983 8.5555556 0.286512 8.5583333 0.288099 8.5611111 0.288364 8.5638889 0.288628 8.5666667 0.288099 8.5694444 0.288099 8.5722222 0.288893 8.5750000 0.288628 8.5777778 0.289421 8.5805556 0.290215 8.5833333 0.291273 8.5861111 0.290744 8.5888889 0.290744 8.5916667 0.292066 8.5944444 0.293124 8.5972222 0.293653 8.6030000 0.300000 8.7470000 0.300000 8.7500000 0.295769 8.7527778 0.294975 8.7555556 0.295504 8.7583333 0.295504 8.7611111 0.295769 8.7638889 0.297355 8.7666667 0.297884 8.7694444 0.298678 8.7722222 0.298942 8.7750000 0.298942 8.7777778 0.299207 8.7805556 0.299736 8.7833333 0.300264 8.7861111 0.300000 8.7888889 0.300793 8.7916667 0.302116 8.7944444 0.303438 8.7972222 0.303702 8.8000000 0.304496 8.8027778 0.304496 8.8055556 0.304496 8.8083333 0.305025 8.8111111 0.306347 8.8138889 0.307405 8.8166667 0.308463 8.8194444 0.307669 8.8222222 0.307934 8.8250000 0.308463 8.8277778 0.309256 8.8305556 0.308727 8.8333333 0.307405 8.8361111 0.305289 8.8388889 0.302116 8.8416667 0.300000 8.8444444 0.298149 8.8472222 0.298149 8.8500000 0.296826 8.8527778 0.294182 8.8555556 0.292595 8.8583333 0.292595 8.8611111 0.293388 8.8638889 0.293917 8.8666667 0.294711 8.8694444 0.294182 8.8722222 0.293653 8.8750000 0.293124 8.8777778 0.293917 8.8805556 0.295240 8.8833333 0.295240 8.8861111 0.294975 8.8888889 0.293653 8.8916667 0.293124 8.8944444 0.293124 8.8972222 0.294182 8.9000000 0.294182 8.9027778 0.294182 8.9055556 0.293653 8.9083333 0.294182 8.9111111 0.294446 8.9138889 0.294711 8.9166667 0.294711 8.9194444 0.294446 8.9222222 0.294711 8.9250000 0.294975 8.9277778 0.295240 8.9305556 0.295769 8.9333333 0.295504 8.9361111 0.295504 8.9388889 0.294975 8.9416667 0.294446 8.9444444 0.295240 8.9472222 0.294711 8.9500000 0.294711 8.9527778 0.294711 8.9555556 0.294446 8.9583333 0.296298 8.9611111 0.300529 8.9638889 0.307934 8.9666667 0.314810 8.9694444 0.323008 8.9722222 0.326446 8.9750000 0.326975 8.9777778 0.326182 8.9805556 0.329355 8.9833333 0.332264 8.9861111 0.334909 8.9888889 0.337025 8.9916667 0.338612 8.9944444 0.341785 8.9972222 0.346017 9.0000000 0.348661 9.0027778 0.348132 9.0055556 0.346810 9.0083333 0.342314 9.0111111 0.335174 9.0138889 0.326975 9.0166667 0.319835 9.0194444 0.311636 9.0222222 0.301587 9.0250000 0.289421 9.0277778 0.279636 9.0305556 0.274083 9.0333333 0.273818 9.0361111 0.276463 9.0388889 0.279636 9.0416667 0.280694 9.0444444 0.282017 9.0472222 0.283339 9.0500000 0.285455 9.0527778 0.286512 9.0555556 0.287306 9.0583333 0.287570 9.0611111 0.288364 9.0638889 0.288893 9.0666667 0.288364 9.0694444 0.287570 9.0722222 0.287041 9.0750000 0.287041 9.0777778 0.288364 9.0805556 0.288628 9.0833333 0.288628 9.0861111 0.288099 9.0888889 0.286777 9.0916667 0.286512 9.0944444 0.286777 9.0972222 0.287306 9.1000000 0.286777 9.1027778 0.286512 9.1055556 0.285983 9.1083333 0.286512 9.1111111 0.286777 9.1138889 0.286777 9.1166667 0.287041 9.1194444 0.286777 9.1222222 0.285719 9.1250000 0.285719 9.1277778 0.285719 9.1305556 0.286777 9.1333333 0.286248 9.1361111 0.285190 9.1388889 0.285190 9.1416667 0.285190 9.1444444 0.285983 9.1472222 0.286248 9.1500000 0.285983 9.1527778 0.286248 9.1555556 0.285455 9.1583333 0.285455 9.1611111 0.286248 9.1638889 0.286777 9.1666667 0.286777 9.1694444 0.285983 9.1722222 0.285719 9.1750000 0.285719 9.1777778 0.287041 9.1805556 0.288099 9.1833333 0.288099 9.1861111 0.287835 9.1888889 0.285983 9.1916667 0.286512 9.1944444 0.287570 9.1972222 0.288099 9.2000000 0.288628 9.2027778 0.288364 9.2055556 0.287306 9.2083333 0.287570 9.2111111 0.288099 9.2138889 0.288893 9.2166667 0.289950 9.2194444 0.289686 9.2222222 0.288893 9.2250000 0.289950 9.2277778 0.289950 9.2305556 0.291273 9.2333333 0.291008 9.2361111 0.290744 9.2388889 0.290479 9.2416667 0.291802 9.2444444 0.292595 9.2472222 0.293653 9.2500000 0.293653 9.2527778 0.294182 9.2555556 0.293917 9.2583333 0.293388 9.2611111 0.293653 9.2638889 0.294975 9.2666667 0.295240 9.2694444 0.294975 9.2722222 0.294975 9.2750000 0.295240 9.2777778 0.296298 9.2805556 0.297091 9.2833333 0.297355 9.2861111 0.296826 9.2888889 0.296826 9.2916667 0.297091 9.2944444 0.297620 9.2972222 0.298413 9.3030000 0.300000 9.4470000 0.300000 9.4500000 0.295769 9.4527778 0.296298 9.4555556 0.297091 9.4583333 0.297620 9.4611111 0.297884 9.4638889 0.297884 9.4666667 0.297355 9.4694444 0.298413 9.4722222 0.299471 9.4750000 0.299471 9.4777778 0.300264 9.4805556 0.300529 9.4833333 0.300529 9.4861111 0.301058 9.4888889 0.301322 9.4916667 0.302645 9.4944444 0.303438 9.4972222 0.303967 9.5000000 0.303967 9.5027778 0.304496 9.5055556 0.305554 9.5083333 0.306612 9.5111111 0.307934 9.5138889 0.307669 9.5166667 0.307669 9.5194444 0.308198 9.5222222 0.308992 9.5250000 0.310579 9.5277778 0.310314 9.5305556 0.308463 9.5333333 0.306876 9.5361111 0.305289 9.5388889 0.302909 9.5416667 0.301587 9.5444444 0.298942 9.5472222 0.296826 9.5500000 0.294182 9.5527778 0.293124 9.5555556 0.293917 9.5583333 0.293917 9.5611111 0.294182 9.5638889 0.293388 9.5666667 0.292331 9.5694444 0.292595 9.5722222 0.293653 9.5750000 0.294182 9.5777778 0.293653 9.5805556 0.293653 9.5833333 0.293388 9.5861111 0.293917 9.5888889 0.294446 9.5916667 0.294182 9.5944444 0.293388 9.5972222 0.293653 9.6000000 0.293124 9.6027778 0.293124 9.6055556 0.294182 9.6083333 0.294711 9.6111111 0.294975 9.6138889 0.294182 9.6166667 0.293388 9.6194444 0.292860 9.6222222 0.293388 9.6250000 0.293653 9.6277778 0.294711 9.6305556 0.294446 9.6333333 0.293917 9.6361111 0.293653 9.6388889 0.293653 9.6416667 0.293917 9.6444444 0.293388 9.6472222 0.293388 9.6500000 0.292331 9.6527778 0.292066 9.6555556 0.292066 9.6583333 0.294182 9.6611111 0.297091 9.6638889 0.302380 9.6666667 0.309521 9.6694444 0.316661 9.6722222 0.322744 9.6750000 0.325124 9.6777778 0.324860 9.6805556 0.326711 9.6833333 0.328562 9.6861111 0.331471 9.6888889 0.333851 9.6916667 0.336760 9.6944444 0.337289 9.6972222 0.339140 9.7000000 0.340992 9.7027778 0.342314 9.7055556 0.342050 9.7083333 0.341521 9.7111111 0.337818 9.7138889 0.329884 9.7166667 0.320893 9.7194444 0.314281 9.7222222 0.308463 9.7250000 0.299207 9.7277778 0.288099 9.7305556 0.277785 9.7333333 0.270909 9.7361111 0.269587 9.7388889 0.271967 9.7416667 0.274612 9.7444444 0.275934 9.7472222 0.276992 9.7500000 0.277785 9.7527778 0.279107 9.7555556 0.280430 9.7583333 0.282545 9.7611111 0.283074 9.7638889 0.282810 9.7666667 0.282810 9.7694444 0.283339 9.7722222 0.283603 9.7750000 0.283603 9.7777778 0.283868 9.7805556 0.283868 9.7833333 0.282810 9.7861111 0.282545 9.7888889 0.283074 9.7916667 0.283603 9.7944444 0.283339 9.7972222 0.282017 9.8000000 0.281223 9.8027778 0.281223 9.8055556 0.280959 9.8083333 0.281488 9.8111111 0.281488 9.8138889 0.281752 9.8166667 0.280430 9.8194444 0.279901 9.8222222 0.280694 9.8250000 0.281488 9.8277778 0.280430 9.8305556 0.279636 9.8333333 0.279636 9.8361111 0.279901 9.8388889 0.280430 9.8416667 0.280165 9.8444444 0.280165 9.8472222 0.280430 9.8500000 0.279901 9.8527778 0.279372 9.8555556 0.280165 9.8583333 0.281488 9.8611111 0.281752 9.8638889 0.280959 9.8666667 0.279372 9.8694444 0.278050 9.8722222 0.279107 9.8750000 0.279901 9.8777778 0.280165 9.8805556 0.280430 9.8833333 0.279901 9.8861111 0.279901 9.8888889 0.280165 9.8916667 0.279901 9.8944444 0.279901 9.8972222 0.279901 9.9000000 0.279636 9.9027778 0.279636 9.9055556 0.279901 9.9083333 0.280959 9.9111111 0.282017 9.9138889 0.282810 9.9166667 0.282281 9.9194444 0.281223 9.9222222 0.282810 9.9250000 0.283603 9.9277778 0.284132 9.9305556 0.284132 9.9333333 0.283339 9.9361111 0.283339 9.9388889 0.283603 9.9416667 0.284132 9.9444444 0.284661 9.9472222 0.285455 9.9500000 0.285455 9.9527778 0.284926 9.9555556 0.285455 9.9583333 0.286248 9.9611111 0.287306 9.9638889 0.287570 9.9666667 0.286777 9.9694444 0.287570 9.9722222 0.288628 9.9750000 0.289950 9.9777778 0.289421 9.9805556 0.288893 9.9833333 0.289157 9.9861111 0.289950 9.9888889 0.289686 9.9916667 0.291273 9.9944444 0.290744 9.9972222 0.290479 10.0030000 0.300000 10.1470000 0.300000 10.1500000 0.297620 10.1527778 0.297884 10.1555556 0.297355 10.1583333 0.297091 10.1611111 0.297620 10.1638889 0.298678 10.1666667 0.299471 10.1694444 0.299736 10.1722222 0.300793 10.1750000 0.301322 10.1777778 0.301587 10.1805556 0.302645 10.1833333 0.303967 10.1861111 0.304231 10.1888889 0.304231 10.1916667 0.303438 10.1944444 0.305025 10.1972222 0.305818 10.2000000 0.306876 10.2027778 0.308198 10.2055556 0.308463 10.2083333 0.308463 10.2111111 0.308727 10.2138889 0.308198 10.2166667 0.306612 10.2194444 0.304496 10.2222222 0.301587 10.2250000 0.298942 10.2277778 0.297091 10.2305556 0.295240 10.2333333 0.293388 10.2361111 0.291537 10.2388889 0.291537 10.2416667 0.292331 10.2444444 0.292860 10.2472222 0.293653 10.2500000 0.293653 10.2527778 0.293388 10.2555556 0.293653 10.2583333 0.292595 10.2611111 0.293124 10.2638889 0.292860 10.2666667 0.292595 10.2694444 0.292595 10.2722222 0.292595 10.2750000 0.292066 10.2777778 0.292595 10.2805556 0.293124 10.2833333 0.293388 10.2861111 0.293124 10.2888889 0.292860 10.2916667 0.292331 10.2944444 0.293124 10.2972222 0.293388 10.3000000 0.293653 10.3027778 0.292860 10.3055556 0.292860 10.3083333 0.292066 10.3111111 0.293124 10.3138889 0.294182 10.3166667 0.293653 10.3194444 0.294446 10.3222222 0.294182 10.3250000 0.294446 10.3277778 0.294182 10.3305556 0.294182 10.3333333 0.293653 10.3361111 0.293653 10.3388889 0.293124 10.3416667 0.292860 10.3444444 0.292860 10.3472222 0.293653 10.3500000 0.294975 10.3527778 0.298678 10.3555556 0.304231 10.3583333 0.309785 10.3611111 0.316132 10.3638889 0.323273 10.3666667 0.327504 10.3694444 0.327240 10.3722222 0.325388 10.3750000 0.325917 10.3777778 0.329884 10.3805556 0.333058 10.3833333 0.335174 10.3861111 0.337025 10.3888889 0.338612 10.3916667 0.339934 10.3944444 0.342314 10.3972222 0.346810 10.4000000 0.348397 10.4027778 0.347868 10.4055556 0.346810 10.4083333 0.342050 10.4111111 0.334909 10.4138889 0.326975 10.4166667 0.319835 10.4194444 0.313223 10.4222222 0.304760 10.4250000 0.295504 10.4277778 0.285455 10.4305556 0.278050 10.4333333 0.272231 10.4361111 0.271438 10.4388889 0.272760 10.4416667 0.275140 10.4444444 0.277256 10.4472222 0.278050 10.4500000 0.279107 10.4527778 0.280165 10.4555556 0.281223 10.4583333 0.282545 10.4611111 0.283603 10.4638889 0.284661 10.4666667 0.285719 10.4694444 0.286777 10.4722222 0.286248 10.4750000 0.285455 10.4777778 0.285455 10.4805556 0.285455 10.4833333 0.286248 10.4861111 0.286512 10.4888889 0.286248 10.4916667 0.285719 10.4944444 0.284926 10.4972222 0.285719 10.5000000 0.285719 10.5027778 0.285455 10.5055556 0.285190 10.5083333 0.284661 10.5111111 0.283868 10.5138889 0.285190 10.5166667 0.285719 10.5194444 0.284926 10.5222222 0.284397 10.5250000 0.283603 10.5277778 0.283868 10.5305556 0.283868 10.5333333 0.283603 10.5361111 0.283339 10.5388889 0.283868 10.5416667 0.282810 10.5444444 0.282545 10.5472222 0.282545 10.5500000 0.282810 10.5527778 0.283603 10.5555556 0.282281 10.5583333 0.282810 10.5611111 0.283074 10.5638889 0.283339 10.5666667 0.283868 10.5694444 0.283603 10.5722222 0.283868 10.5750000 0.282810 10.5777778 0.283074 10.5805556 0.283339 10.5833333 0.283339 10.5861111 0.283074 10.5888889 0.282545 10.5916667 0.282017 10.5944444 0.281752 10.5972222 0.283074 10.6000000 0.284132 10.6027778 0.284397 10.6055556 0.284132 10.6083333 0.283339 10.6111111 0.283603 10.6138889 0.283868 10.6166667 0.284397 10.6194444 0.284397 10.6222222 0.284397 10.6250000 0.283868 10.6277778 0.284132 10.6305556 0.285190 10.6333333 0.286248 10.6361111 0.285983 10.6388889 0.286248 10.6416667 0.285719 10.6444444 0.285983 10.6472222 0.287570 10.6500000 0.287835 10.6527778 0.287835 10.6555556 0.287306 10.6583333 0.287041 10.6611111 0.287306 10.6638889 0.288364 10.6666667 0.288893 10.6694444 0.289421 10.6722222 0.289157 10.6750000 0.289157 10.6777778 0.289421 10.6805556 0.290215 10.6833333 0.291008 10.6861111 0.291008 10.6888889 0.291008 10.6916667 0.290744 10.6944444 0.290744 10.6972222 0.292331 10.7030000 0.300000 10.8470000 0.300000 10.8500000 0.298149 10.8527778 0.297884 10.8555556 0.298413 10.8583333 0.298942 10.8611111 0.298678 10.8638889 0.300000 10.8666667 0.301058 10.8694444 0.302116 10.8722222 0.302909 10.8750000 0.302645 10.8777778 0.302380 10.8805556 0.303702 10.8833333 0.305025 10.8861111 0.306083 10.8888889 0.306083 10.8916667 0.305818 10.8944444 0.305554 10.8972222 0.306876 10.9000000 0.307934 10.9027778 0.308727 10.9055556 0.308198 10.9083333 0.306876 10.9111111 0.304760 10.9138889 0.303438 10.9166667 0.302645 10.9194444 0.301322 10.9222222 0.298942 10.9250000 0.296826 10.9277778 0.294711 10.9305556 0.293124 10.9333333 0.292595 10.9361111 0.292595 10.9388889 0.293124 10.9416667 0.292860 10.9444444 0.292331 10.9472222 0.292860 10.9500000 0.292860 10.9527778 0.293653 10.9555556 0.293917 10.9583333 0.293124 10.9611111 0.292860 10.9638889 0.292066 10.9666667 0.292331 10.9694444 0.293124 10.9722222 0.292595 10.9750000 0.291537 10.9777778 0.292331 10.9805556 0.292066 10.9833333 0.292066 10.9861111 0.292595 10.9888889 0.292595 10.9916667 0.291273 10.9944444 0.290479 10.9972222 0.291537 11.0000000 0.292595 11.0027778 0.293653 11.0055556 0.293124 11.0083333 0.292595 11.0111111 0.292331 11.0138889 0.292066 11.0166667 0.292860 11.0194444 0.292860 11.0222222 0.293124 11.0250000 0.292595 11.0277778 0.292595 11.0305556 0.292331 11.0333333 0.292860 11.0361111 0.292331 11.0388889 0.291537 11.0416667 0.291008 11.0444444 0.290215 11.0472222 0.292066 11.0500000 0.294446 11.0527778 0.298149 11.0555556 0.303174 11.0583333 0.308992 11.0611111 0.314810 11.0638889 0.321157 11.0666667 0.325124 11.0694444 0.325388 11.0722222 0.323537 11.0750000 0.325124 11.0777778 0.327240 11.0805556 0.331736 11.0833333 0.334645 11.0861111 0.336760 11.0888889 0.338083 11.0916667 0.339140 11.0944444 0.341521 11.0972222 0.344959 11.1000000 0.346810 11.1027778 0.347074 11.1055556 0.344694 11.1083333 0.340992 11.1111111 0.333587 11.1138889 0.325388 11.1166667 0.318512 11.1194444 0.312430 11.1222222 0.305554 11.1250000 0.295240 11.1277778 0.284397 11.1305556 0.275405 11.1333333 0.269851 11.1361111 0.269058 11.1388889 0.271967 11.1416667 0.274347 11.1444444 0.274876 11.1472222 0.275669 11.1500000 0.277521 11.1527778 0.278843 11.1555556 0.279901 11.1583333 0.280959 11.1611111 0.281488 11.1638889 0.282810 11.1666667 0.283074 11.1694444 0.283339 11.1722222 0.282545 11.1750000 0.282281 11.1777778 0.282281 11.1805556 0.282017 11.1833333 0.282545 11.1861111 0.283074 11.1888889 0.283074 11.1916667 0.282017 11.1944444 0.281223 11.1972222 0.281752 11.2000000 0.282281 11.2027778 0.282545 11.2055556 0.281752 11.2083333 0.281223 11.2111111 0.281488 11.2138889 0.280165 11.2166667 0.280430 11.2194444 0.280959 11.2222222 0.280694 11.2250000 0.280430 11.2277778 0.279107 11.2305556 0.279372 11.2333333 0.279901 11.2361111 0.280430 11.2388889 0.280694 11.2416667 0.279901 11.2444444 0.279372 11.2472222 0.279636 11.2500000 0.280165 11.2527778 0.280430 11.2555556 0.279636 11.2583333 0.279636 11.2611111 0.279372 11.2638889 0.279372 11.2666667 0.279372 11.2694444 0.279636 11.2722222 0.279636 11.2750000 0.279107 11.2777778 0.279107 11.2805556 0.280165 11.2833333 0.280959 11.2861111 0.280694 11.2888889 0.280430 11.2916667 0.280694 11.2944444 0.279901 11.2972222 0.279372 11.3000000 0.280430 11.3027778 0.280959 11.3055556 0.281223 11.3083333 0.280694 11.3111111 0.280165 11.3138889 0.280165 11.3166667 0.281488 11.3194444 0.281752 11.3222222 0.281752 11.3250000 0.282017 11.3277778 0.281488 11.3305556 0.281488 11.3333333 0.282810 11.3361111 0.283074 11.3388889 0.283339 11.3416667 0.282810 11.3444444 0.283074 11.3472222 0.283603 11.3500000 0.284926 11.3527778 0.285983 11.3555556 0.285455 11.3583333 0.285190 11.3611111 0.284661 11.3638889 0.285190 11.3666667 0.286777 11.3694444 0.287835 11.3722222 0.287835 11.3750000 0.286777 11.3777778 0.286777 11.3805556 0.287306 11.3833333 0.288364 11.3861111 0.289421 11.3888889 0.289157 11.3916667 0.288364 11.3944444 0.288099 11.3972222 0.289157 11.4030000 0.300000 11.5470000 0.300000 11.5500000 0.291008 11.5527778 0.291273 11.5555556 0.291537 11.5583333 0.292331 11.5611111 0.293917 11.5638889 0.294975 11.5666667 0.294446 11.5694444 0.294711 11.5722222 0.294182 11.5750000 0.294711 11.5777778 0.296826 11.5805556 0.297620 11.5833333 0.297884 11.5861111 0.297884 11.5888889 0.298413 11.5916667 0.300264 11.5944444 0.301058 11.5972222 0.301587 11.6000000 0.300529 11.6027778 0.301587 11.6055556 0.301058 11.6083333 0.303438 11.6111111 0.304496 11.6138889 0.304760 11.6166667 0.303967 11.6194444 0.302380 11.6222222 0.300264 11.6250000 0.298942 11.6277778 0.297355 11.6305556 0.296033 11.6333333 0.294446 11.6361111 0.291273 11.6388889 0.288893 11.6416667 0.287835 11.6444444 0.288364 11.6472222 0.288099 11.6500000 0.289157 11.6527778 0.288628 11.6555556 0.287835 11.6583333 0.288099 11.6611111 0.288893 11.6638889 0.289421 11.6666667 0.288893 11.6694444 0.288893 11.6722222 0.287041 11.6750000 0.287570 11.6777778 0.288628 11.6805556 0.289157 11.6833333 0.288099 11.6861111 0.287570 11.6888889 0.287570 11.6916667 0.288893 11.6944444 0.289421 11.6972222 0.289421 11.7000000 0.289421 11.7027778 0.288893 11.7055556 0.288628 11.7083333 0.288893 11.7111111 0.289950 11.7138889 0.289157 11.7166667 0.289421 11.7194444 0.289950 11.7222222 0.289421 11.7250000 0.289421 11.7277778 0.289686 11.7305556 0.289686 11.7333333 0.289157 11.7361111 0.288099 11.7388889 0.287041 11.7416667 0.288099 11.7444444 0.287835 11.7472222 0.287041 11.7500000 0.287041 11.7527778 0.286777 11.7555556 0.288099 11.7583333 0.292331 11.7611111 0.299207 11.7638889 0.306612 11.7666667 0.313488 11.7694444 0.317455 11.7722222 0.317719 11.7750000 0.317190 11.7777778 0.318512 11.7805556 0.321950 11.7833333 0.325653 11.7861111 0.327504 11.7888889 0.329355 11.7916667 0.330942 11.7944444 0.332264 11.7972222 0.335702 11.8000000 0.337818 11.8027778 0.337554 11.8055556 0.335438 11.8083333 0.332000 11.8111111 0.326446 11.8138889 0.318512 11.8166667 0.311636 11.8194444 0.304760 11.8222222 0.296298 11.8250000 0.287570 11.8277778 0.278579 11.8305556 0.270645 11.8333333 0.265620 11.8361111 0.265620 11.8388889 0.268529 11.8416667 0.271702 11.8444444 0.273554 11.8472222 0.275140 11.8500000 0.275140 11.8527778 0.276463 11.8555556 0.277785 11.8583333 0.280165 11.8611111 0.281488 11.8638889 0.282017 11.8666667 0.281488 11.8694444 0.281223 11.8722222 0.280694 11.8750000 0.280694 11.8777778 0.281488 11.8805556 0.282017 11.8833333 0.281488 11.8861111 0.280694 11.8888889 0.280165 11.8916667 0.280430 11.8944444 0.280694 11.8972222 0.280959 11.9000000 0.280959 11.9027778 0.280694 11.9055556 0.279901 11.9083333 0.280694 11.9111111 0.280430 11.9138889 0.280694 11.9166667 0.279901 11.9194444 0.280430 11.9222222 0.279636 11.9250000 0.279372 11.9277778 0.278843 11.9305556 0.279636 11.9333333 0.279901 11.9361111 0.279901 11.9388889 0.279107 11.9416667 0.278843 11.9444444 0.279107 11.9472222 0.280430 11.9500000 0.280959 11.9527778 0.280430 11.9555556 0.279107 11.9583333 0.279372 11.9611111 0.280165 11.9638889 0.280959 11.9666667 0.280959 11.9694444 0.280165 11.9722222 0.279372 11.9750000 0.279372 11.9777778 0.279636 11.9805556 0.279901 11.9833333 0.282017 11.9861111 0.282281 11.9888889 0.281223 11.9916667 0.281223 11.9944444 0.281223 11.9972222 0.282281 12.0000000 0.282810 12.0027778 0.282810 12.0055556 0.282545 12.0083333 0.282545 12.0111111 0.283868 12.0138889 0.284397 12.0166667 0.284397 12.0194444 0.283603 12.0222222 0.283074 12.0250000 0.283868 12.0277778 0.284397 12.0305556 0.284661 12.0333333 0.285455 12.0361111 0.284926 12.0388889 0.284397 12.0416667 0.285719 12.0444444 0.286512 12.0472222 0.288099 12.0500000 0.287835 12.0527778 0.287835 12.0555556 0.287570 12.0583333 0.288364 12.0611111 0.288893 12.0638889 0.289421 12.0666667 0.289157 12.0694444 0.288893 12.0722222 0.288893 12.0750000 0.289421 12.0777778 0.289421 12.0805556 0.290479 12.0833333 0.291008 12.0861111 0.291537 12.0888889 0.291537 12.0916667 0.291537 12.0944444 0.290479 12.0972222 0.290744 12.1030000 0.300000 12.2470000 0.300000 12.2500000 0.289686 12.2527778 0.289686 12.2555556 0.289421 12.2583333 0.288893 12.2611111 0.288893 12.2638889 0.289157 12.2666667 0.289421 12.2694444 0.289157 12.2722222 0.289950 12.2750000 0.290744 12.2777778 0.290744 12.2805556 0.292595 12.2833333 0.293388 12.2861111 0.293653 12.2888889 0.293917 12.2916667 0.293917 12.2944444 0.293653 12.2972222 0.294446 12.3000000 0.295504 12.3027778 0.296298 12.3055556 0.297620 12.3083333 0.298149 12.3111111 0.299207 12.3138889 0.301058 12.3166667 0.302116 12.3194444 0.302116 12.3222222 0.301587 12.3250000 0.301058 12.3277778 0.302116 12.3305556 0.302909 12.3333333 0.303967 12.3361111 0.303174 12.3388889 0.301587 12.3416667 0.300000 12.3444444 0.297355 12.3472222 0.295769 12.3500000 0.293917 12.3527778 0.292331 12.3555556 0.288893 12.3583333 0.287306 12.3611111 0.286512 12.3638889 0.287570 12.3666667 0.288628 12.3694444 0.288628 12.3722222 0.288099 12.3750000 0.287306 12.3777778 0.287041 12.3805556 0.288364 12.3833333 0.288893 12.3861111 0.289421 12.3888889 0.288893 12.3916667 0.288628 12.3944444 0.287570 12.3972222 0.287306 12.4000000 0.287835 12.4027778 0.288364 12.4055556 0.289157 12.4083333 0.289157 12.4111111 0.288628 12.4138889 0.288628 12.4166667 0.288099 12.4194444 0.289157 12.4222222 0.288628 12.4250000 0.287835 12.4277778 0.287306 12.4305556 0.288628 12.4333333 0.289950 12.4361111 0.289950 12.4388889 0.289421 12.4416667 0.288364 12.4444444 0.287570 12.4472222 0.287570 12.4500000 0.287570 12.4527778 0.287570 12.4555556 0.287570 12.4583333 0.288364 12.4611111 0.290215 12.4638889 0.295504 12.4666667 0.301587 12.4694444 0.308727 12.4722222 0.314281 12.4750000 0.317719 12.4777778 0.316926 12.4805556 0.316661 12.4833333 0.319835 12.4861111 0.323008 12.4888889 0.325917 12.4916667 0.326446 12.4944444 0.328033 12.4972222 0.329091 12.5000000 0.331207 12.5027778 0.333058 12.5055556 0.332793 12.5083333 0.331207 12.5111111 0.325653 12.5138889 0.317455 12.5166667 0.309256 12.5194444 0.303174 12.5222222 0.297091 12.5250000 0.288628 12.5277778 0.278579 12.5305556 0.270645 12.5333333 0.265884 12.5361111 0.264033 12.5388889 0.265620 12.5416667 0.269587 12.5444444 0.272231 12.5472222 0.273025 12.5500000 0.273289 12.5527778 0.275140 12.5555556 0.276992 12.5583333 0.278843 12.5611111 0.280430 12.5638889 0.282017 12.5666667 0.283339 12.5694444 0.284397 12.5722222 0.283603 12.5750000 0.283074 12.5777778 0.282545 12.5805556 0.282281 12.5833333 0.282810 12.5861111 0.284132 12.5888889 0.284132 12.5916667 0.283603 12.5944444 0.283074 12.5972222 0.282017 12.6000000 0.282017 12.6027778 0.283339 12.6055556 0.283868 12.6083333 0.283603 12.6111111 0.282810 12.6138889 0.283074 12.6166667 0.283074 12.6194444 0.283339 12.6222222 0.282810 12.6250000 0.282545 12.6277778 0.282281 12.6305556 0.281752 12.6333333 0.282545 12.6361111 0.283074 12.6388889 0.282545 12.6416667 0.281488 12.6444444 0.281488 12.6472222 0.282281 12.6500000 0.282545 12.6527778 0.283339 12.6555556 0.282545 12.6583333 0.281752 12.6611111 0.282017 12.6638889 0.283868 12.6666667 0.283339 12.6694444 0.283339 12.6722222 0.283339 12.6750000 0.282281 12.6777778 0.282281 12.6805556 0.283603 12.6833333 0.284397 12.6861111 0.284926 12.6888889 0.283868 12.6916667 0.283074 12.6944444 0.282281 12.6972222 0.283339 12.7000000 0.284397 12.7027778 0.284926 12.7055556 0.285190 12.7083333 0.284926 12.7111111 0.284661 12.7138889 0.285719 12.7166667 0.285190 12.7194444 0.285455 12.7222222 0.285719 12.7250000 0.285455 12.7277778 0.285190 12.7305556 0.286248 12.7333333 0.287041 12.7361111 0.287041 12.7388889 0.287835 12.7416667 0.287306 12.7444444 0.287570 12.7472222 0.288628 12.7500000 0.288893 12.7527778 0.289157 12.7555556 0.289686 12.7583333 0.289686 12.7611111 0.289686 12.7638889 0.289421 12.7666667 0.289686 12.7694444 0.290479 12.7722222 0.290479 12.7750000 0.290744 12.7777778 0.291008 12.7805556 0.291008 12.7833333 0.291802 12.7861111 0.292066 12.7888889 0.292595 12.7916667 0.292331 12.7944444 0.292066 12.7972222 0.292595 12.8030000 0.300000 12.9470000 0.300000 12.9500000 0.292066 12.9527778 0.291802 12.9555556 0.291802 12.9583333 0.292595 12.9611111 0.293653 12.9638889 0.296298 12.9666667 0.295769 12.9694444 0.295504 12.9722222 0.295504 12.9750000 0.296562 12.9777778 0.297884 12.9805556 0.298942 12.9833333 0.298942 12.9861111 0.298942 12.9888889 0.299207 12.9916667 0.301058 12.9944444 0.301587 12.9972222 0.302116 13.0000000 0.303438 13.0027778 0.303702 13.0055556 0.303174 13.0083333 0.304496 13.0111111 0.305554 13.0138889 0.306612 13.0166667 0.305554 13.0194444 0.305025 13.0222222 0.303967 13.0250000 0.302909 13.0277778 0.301851 13.0305556 0.300000 13.0333333 0.297091 13.0361111 0.293917 13.0388889 0.291008 13.0416667 0.288628 13.0444444 0.288364 13.0472222 0.288628 13.0500000 0.289157 13.0527778 0.290479 13.0555556 0.290215 13.0583333 0.289950 13.0611111 0.290744 13.0638889 0.291537 13.0666667 0.291008 13.0694444 0.289421 13.0722222 0.289686 13.0750000 0.290744 13.0777778 0.291008 13.0805556 0.291273 13.0833333 0.291008 13.0861111 0.290479 13.0888889 0.289421 13.0916667 0.289686 13.0944444 0.289950 13.0972222 0.290215 13.1000000 0.289950 13.1027778 0.289421 13.1055556 0.289157 13.1083333 0.290479 13.1111111 0.290479 13.1138889 0.290479 13.1166667 0.290744 13.1194444 0.290479 13.1222222 0.289950 13.1250000 0.290215 13.1277778 0.291008 13.1305556 0.291537 13.1333333 0.290744 13.1361111 0.290215 13.1388889 0.289686 13.1416667 0.290479 13.1444444 0.291008 13.1472222 0.291273 13.1500000 0.289421 13.1527778 0.289157 13.1555556 0.291008 13.1583333 0.294446 13.1611111 0.299207 13.1638889 0.304231 13.1666667 0.312165 13.1694444 0.316132 13.1722222 0.317455 13.1750000 0.315868 13.1777778 0.315603 13.1805556 0.319041 13.1833333 0.321157 13.1861111 0.323008 13.1888889 0.323537 13.1916667 0.325917 13.1944444 0.327769 13.1972222 0.328562 13.2000000 0.329091 13.2027778 0.328298 13.2055556 0.326711 13.2083333 0.324595 13.2111111 0.319835 13.2138889 0.312430 13.2166667 0.305025 13.2194444 0.298413 13.2222222 0.292331 13.2250000 0.284926 13.2277778 0.275405 13.2305556 0.268000 13.2333333 0.262711 13.2361111 0.262975 13.2388889 0.266678 13.2416667 0.271174 13.2444444 0.273289 13.2472222 0.274876 13.2500000 0.275934 13.2527778 0.277256 13.2555556 0.279636 13.2583333 0.282017 13.2611111 0.284132 13.2638889 0.285455 13.2666667 0.285455 13.2694444 0.285455 13.2722222 0.284926 13.2750000 0.284926 13.2777778 0.284926 13.2805556 0.284926 13.2833333 0.285455 13.2861111 0.285719 13.2888889 0.284926 13.2916667 0.284926 13.2944444 0.285455 13.2972222 0.284661 13.3000000 0.284397 13.3027778 0.284132 13.3055556 0.284397 13.3083333 0.284132 13.3111111 0.284661 13.3138889 0.285190 13.3166667 0.284926 13.3194444 0.283868 13.3222222 0.283603 13.3250000 0.284397 13.3277778 0.284926 13.3305556 0.285190 13.3333333 0.285455 13.3361111 0.284661 13.3388889 0.283603 13.3416667 0.284661 13.3444444 0.284926 13.3472222 0.285719 13.3500000 0.284661 13.3527778 0.284926 13.3555556 0.284397 13.3583333 0.284132 13.3611111 0.284397 13.3638889 0.285190 13.3666667 0.285190 13.3694444 0.284397 13.3722222 0.284397 13.3750000 0.284926 13.3777778 0.285983 13.3805556 0.286248 13.3833333 0.285983 13.3861111 0.285190 13.3888889 0.284661 13.3916667 0.285719 13.3944444 0.285983 13.3972222 0.286248 13.4000000 0.285719 13.4027778 0.285983 13.4055556 0.286248 13.4083333 0.286248 13.4111111 0.287041 13.4138889 0.287041 13.4166667 0.287041 13.4194444 0.286777 13.4222222 0.286512 13.4250000 0.287835 13.4277778 0.288628 13.4305556 0.288893 13.4333333 0.288099 13.4361111 0.287835 13.4388889 0.288893 13.4416667 0.289686 13.4444444 0.289686 13.4472222 0.290215 13.4500000 0.291008 13.4527778 0.291537 13.4555556 0.291008 13.4583333 0.291273 13.4611111 0.291802 13.4638889 0.291802 13.4666667 0.291802 13.4694444 0.291802 13.4722222 0.292331 13.4750000 0.293653 13.4777778 0.293388 13.4805556 0.293653 13.4833333 0.292860 13.4861111 0.293653 13.4888889 0.293653 13.4916667 0.294446 13.4944444 0.294711 13.4972222 0.294446 13.5030000 0.300000 13.6470000 0.300000 13.6500000 0.288099 13.6527778 0.288893 13.6555556 0.288893 13.6583333 0.288628 13.6611111 0.288364 13.6638889 0.289157 13.6666667 0.290479 13.6694444 0.292331 13.6722222 0.292860 13.6750000 0.292860 13.6777778 0.292860 13.6805556 0.293388 13.6833333 0.294711 13.6861111 0.295769 13.6888889 0.296562 13.6916667 0.297620 13.6944444 0.297355 13.6972222 0.297620 13.7000000 0.296562 13.7027778 0.298678 13.7055556 0.300000 13.7083333 0.301322 13.7111111 0.301322 13.7138889 0.300529 13.7166667 0.300529 13.7194444 0.299736 13.7222222 0.297884 13.7250000 0.295769 13.7277778 0.292860 13.7305556 0.290215 13.7333333 0.289157 13.7361111 0.288099 13.7388889 0.287041 13.7416667 0.285719 13.7444444 0.284397 13.7472222 0.284397 13.7500000 0.284926 13.7527778 0.284926 13.7555556 0.285455 13.7583333 0.285455 13.7611111 0.284661 13.7638889 0.284132 13.7666667 0.284926 13.7694444 0.286248 13.7722222 0.285983 13.7750000 0.284926 13.7777778 0.284132 13.7805556 0.284132 13.7833333 0.284397 13.7861111 0.285455 13.7888889 0.285190 13.7916667 0.286512 13.7944444 0.286512 13.7972222 0.285719 13.8000000 0.285455 13.8027778 0.286512 13.8055556 0.285983 13.8083333 0.285455 13.8111111 0.284926 13.8138889 0.283339 13.8166667 0.285190 13.8194444 0.285719 13.8222222 0.286512 13.8250000 0.285983 13.8277778 0.285719 13.8305556 0.287041 13.8333333 0.286512 13.8361111 0.285719 13.8388889 0.286248 13.8416667 0.285455 13.8444444 0.285455 13.8472222 0.285455 13.8500000 0.286248 13.8527778 0.288364 13.8555556 0.292066 13.8583333 0.296826 13.8611111 0.302116 13.8638889 0.308727 13.8666667 0.316926 13.8694444 0.321950 13.8722222 0.322479 13.8750000 0.321686 13.8777778 0.321950 13.8805556 0.324595 13.8833333 0.328298 13.8861111 0.330942 13.8888889 0.333851 13.8916667 0.335702 13.8944444 0.337025 13.8972222 0.339405 13.9000000 0.342843 13.9027778 0.343636 13.9055556 0.342579 13.9083333 0.339934 13.9111111 0.333851 13.9138889 0.325917 13.9166667 0.317719 13.9194444 0.310843 13.9222222 0.301851 13.9250000 0.291537 13.9277778 0.279372 13.9305556 0.269851 13.9333333 0.265091 13.9361111 0.264562 13.9388889 0.266678 13.9416667 0.268793 13.9444444 0.269322 13.9472222 0.269058 13.9500000 0.270116 13.9527778 0.271174 13.9555556 0.272760 13.9583333 0.274876 13.9611111 0.276198 13.9638889 0.275934 13.9666667 0.276463 13.9694444 0.277521 13.9722222 0.277521 13.9750000 0.276992 13.9777778 0.276198 13.9805556 0.275934 13.9833333 0.276198 13.9861111 0.276463 13.9888889 0.276463 13.9916667 0.275934 13.9944444 0.276463 13.9972222 0.276198 14.0000000 0.276992 14.0027778 0.275934 14.0055556 0.275934 14.0083333 0.275140 14.0111111 0.273818 14.0138889 0.274083 14.0166667 0.274347 14.0194444 0.275405 14.0222222 0.275140 14.0250000 0.274612 14.0277778 0.274083 14.0305556 0.273025 14.0333333 0.273289 14.0361111 0.274083 14.0388889 0.274347 14.0416667 0.274347 14.0444444 0.274083 14.0472222 0.273554 14.0500000 0.273554 14.0527778 0.274083 14.0555556 0.274612 14.0583333 0.274347 14.0611111 0.273289 14.0638889 0.273818 14.0666667 0.274612 14.0694444 0.274612 14.0722222 0.275140 14.0750000 0.275405 14.0777778 0.274612 14.0805556 0.274347 14.0833333 0.274083 14.0861111 0.275140 14.0888889 0.275140 14.0916667 0.275669 14.0944444 0.274876 14.0972222 0.274876 14.1000000 0.275669 14.1027778 0.275934 14.1055556 0.276198 14.1083333 0.276198 14.1111111 0.276463 14.1138889 0.276463 14.1166667 0.276463 14.1194444 0.277256 14.1222222 0.278050 14.1250000 0.277256 14.1277778 0.276727 14.1305556 0.276727 14.1333333 0.277785 14.1361111 0.278314 14.1388889 0.279107 14.1416667 0.280165 14.1444444 0.280430 14.1472222 0.279372 14.1500000 0.280430 14.1527778 0.281223 14.1555556 0.281752 14.1583333 0.282017 14.1611111 0.281752 14.1638889 0.282017 14.1666667 0.282545 14.1694444 0.283603 14.1722222 0.284397 14.1750000 0.283868 14.1777778 0.284661 14.1805556 0.284661 14.1833333 0.284397 14.1861111 0.285455 14.1888889 0.285983 14.1916667 0.286248 14.1944444 0.286248 14.1972222 0.286777 14.2030000 0.300000 14.3470000 0.300000 14.3500000 0.292860 14.3527778 0.292331 14.3555556 0.293124 14.3583333 0.293388 14.3611111 0.294446 14.3638889 0.294711 14.3666667 0.293653 14.3694444 0.295769 14.3722222 0.296826 14.3750000 0.297884 14.3777778 0.298149 14.3805556 0.298413 14.3833333 0.298413 14.3861111 0.299471 14.3888889 0.300264 14.3916667 0.301058 14.3944444 0.300793 14.3972222 0.301587 14.4000000 0.301851 14.4027778 0.302116 14.4055556 0.303438 14.4083333 0.303702 14.4111111 0.302380 14.4138889 0.299736 14.4166667 0.297884 14.4194444 0.295504 14.4222222 0.293653 14.4250000 0.292595 14.4277778 0.291802 14.4305556 0.289157 14.4333333 0.287041 14.4361111 0.286248 14.4388889 0.286248 14.4416667 0.287306 14.4444444 0.287835 14.4472222 0.287041 14.4500000 0.287041 14.4527778 0.287306 14.4555556 0.288364 14.4583333 0.288364 14.4611111 0.288099 14.4638889 0.288099 14.4666667 0.287570 14.4694444 0.287041 14.4722222 0.287570 14.4750000 0.288364 14.4777778 0.288364 14.4805556 0.288099 14.4833333 0.287306 14.4861111 0.287570 14.4888889 0.287570 14.4916667 0.287835 14.4944444 0.288364 14.4972222 0.288628 14.5000000 0.288099 14.5027778 0.288099 14.5055556 0.288364 14.5083333 0.288364 14.5111111 0.288364 14.5138889 0.287835 14.5166667 0.287570 14.5194444 0.287041 14.5222222 0.287570 14.5250000 0.288364 14.5277778 0.288364 14.5305556 0.288628 14.5333333 0.288099 14.5361111 0.288099 14.5388889 0.288628 14.5416667 0.288364 14.5444444 0.288364 14.5472222 0.288099 14.5500000 0.289421 14.5527778 0.292331 14.5555556 0.297884 14.5583333 0.303967 14.5611111 0.311636 14.5638889 0.318248 14.5666667 0.321686 14.5694444 0.321686 14.5722222 0.320628 14.5750000 0.322215 14.5777778 0.326446 14.5805556 0.329091 14.5833333 0.330678 14.5861111 0.333058 14.5888889 0.335174 14.5916667 0.337818 14.5944444 0.340198 14.5972222 0.342314 14.6000000 0.342050 14.6027778 0.342314 14.6055556 0.340727 14.6083333 0.336496 14.6111111 0.328562 14.6138889 0.319306 14.6166667 0.312165 14.6194444 0.304496 14.6222222 0.296826 14.6250000 0.287570 14.6277778 0.277256 14.6305556 0.269322 14.6333333 0.264826 14.6361111 0.265355 14.6388889 0.268793 14.6416667 0.270909 14.6444444 0.272496 14.6472222 0.273025 14.6500000 0.273289 14.6527778 0.274612 14.6555556 0.277256 14.6583333 0.279107 14.6611111 0.280430 14.6638889 0.280694 14.6666667 0.280430 14.6694444 0.280165 14.6722222 0.280165 14.6750000 0.279636 14.6777778 0.279636 14.6805556 0.279901 14.6833333 0.279901 14.6861111 0.280165 14.6888889 0.280430 14.6916667 0.279901 14.6944444 0.279636 14.6972222 0.279107 14.7000000 0.279107 14.7027778 0.278314 14.7055556 0.278579 14.7083333 0.279107 14.7111111 0.279901 14.7138889 0.279372 14.7166667 0.279107 14.7194444 0.278843 14.7222222 0.278314 14.7250000 0.279107 14.7277778 0.278314 14.7305556 0.278050 14.7333333 0.277256 14.7361111 0.276992 14.7388889 0.278050 14.7416667 0.278050 14.7444444 0.277785 14.7472222 0.277256 14.7500000 0.277521 14.7527778 0.276992 14.7555556 0.277256 14.7583333 0.278579 14.7611111 0.278843 14.7638889 0.277785 14.7666667 0.276463 14.7694444 0.276463 14.7722222 0.276992 14.7750000 0.278050 14.7777778 0.278314 14.7805556 0.277521 14.7833333 0.276727 14.7861111 0.277521 14.7888889 0.278579 14.7916667 0.279636 14.7944444 0.279901 14.7972222 0.279636 14.8000000 0.279107 14.8027778 0.278579 14.8055556 0.278579 14.8083333 0.279372 14.8111111 0.279636 14.8138889 0.280165 14.8166667 0.279636 14.8194444 0.280430 14.8222222 0.280694 14.8250000 0.280959 14.8277778 0.280430 14.8305556 0.280694 14.8333333 0.279901 14.8361111 0.280165 14.8388889 0.281752 14.8416667 0.283339 14.8444444 0.283074 14.8472222 0.283339 14.8500000 0.283074 14.8527778 0.283074 14.8555556 0.284397 14.8583333 0.284132 14.8611111 0.284661 14.8638889 0.284132 14.8666667 0.284397 14.8694444 0.284926 14.8722222 0.285719 14.8750000 0.286777 14.8777778 0.286512 14.8805556 0.286512 14.8833333 0.286512 14.8861111 0.286777 14.8888889 0.287306 14.8916667 0.288364 14.8944444 0.288628 14.8972222 0.289157 14.9030000 0.300000 15.0470000 0.300000 15.0500000 0.291802 15.0527778 0.292595 15.0555556 0.293388 15.0583333 0.293653 15.0611111 0.293917 15.0638889 0.293653 15.0666667 0.293124 15.0694444 0.294182 15.0722222 0.295504 15.0750000 0.296033 15.0777778 0.296033 15.0805556 0.297091 15.0833333 0.297355 15.0861111 0.298942 15.0888889 0.300264 15.0916667 0.300793 15.0944444 0.301322 15.0972222 0.301587 15.1000000 0.301058 15.1027778 0.302380 15.1055556 0.303174 15.1083333 0.304496 15.1111111 0.303967 15.1138889 0.303967 15.1166667 0.303967 15.1194444 0.302909 15.1222222 0.301587 15.1250000 0.299736 15.1277778 0.297091 15.1305556 0.294711 15.1333333 0.293388 15.1361111 0.292595 15.1388889 0.291537 15.1416667 0.289686 15.1444444 0.288364 15.1472222 0.288364 15.1500000 0.288628 15.1527778 0.289421 15.1555556 0.289950 15.1583333 0.289157 15.1611111 0.288099 15.1638889 0.287835 15.1666667 0.288628 15.1694444 0.289157 15.1722222 0.289950 15.1750000 0.289421 15.1777778 0.289421 15.1805556 0.288628 15.1833333 0.288893 15.1861111 0.289421 15.1888889 0.290215 15.1916667 0.289421 15.1944444 0.289157 15.1972222 0.288628 15.2000000 0.288364 15.2027778 0.288893 15.2055556 0.288893 15.2083333 0.288628 15.2111111 0.289686 15.2138889 0.289421 15.2166667 0.289421 15.2194444 0.289157 15.2222222 0.289686 15.2250000 0.290215 15.2277778 0.289686 15.2305556 0.288364 15.2333333 0.288628 15.2361111 0.289686 15.2388889 0.288628 15.2416667 0.289421 15.2444444 0.288628 15.2472222 0.287041 15.2500000 0.287041 15.2527778 0.288364 15.2555556 0.291537 15.2583333 0.296562 15.2611111 0.302645 15.2638889 0.309785 15.2666667 0.316661 15.2694444 0.321950 15.2722222 0.323273 15.2750000 0.321950 15.2777778 0.323273 15.2805556 0.326446 15.2833333 0.328562 15.2861111 0.330942 15.2888889 0.333322 15.2916667 0.334909 15.2944444 0.335438 15.2972222 0.336496 15.3000000 0.338083 15.3027778 0.339669 15.3055556 0.340463 15.3083333 0.337818 15.3111111 0.333587 15.3138889 0.326182 15.3166667 0.317719 15.3194444 0.311372 15.3222222 0.304231 15.3250000 0.293917 15.3277778 0.282810 15.3305556 0.274083 15.3333333 0.267471 15.3361111 0.265091 15.3388889 0.267471 15.3416667 0.270116 15.3444444 0.271967 15.3472222 0.273025 15.3500000 0.273025 15.3527778 0.274612 15.3555556 0.275669 15.3583333 0.277521 15.3611111 0.278579 15.3638889 0.278579 15.3666667 0.279636 15.3694444 0.280959 15.3722222 0.280959 15.3750000 0.280694 15.3777778 0.281223 15.3805556 0.280694 15.3833333 0.280430 15.3861111 0.280959 15.3888889 0.280694 15.3916667 0.280430 15.3944444 0.280694 15.3972222 0.280165 15.4000000 0.279901 15.4027778 0.280959 15.4055556 0.280959 15.4083333 0.280165 15.4111111 0.279901 15.4138889 0.278843 15.4166667 0.278579 15.4194444 0.278843 15.4222222 0.279636 15.4250000 0.279372 15.4277778 0.279107 15.4305556 0.279372 15.4333333 0.278843 15.4361111 0.279107 15.4388889 0.279372 15.4416667 0.279636 15.4444444 0.279107 15.4472222 0.278314 15.4500000 0.278314 15.4527778 0.278579 15.4555556 0.279107 15.4583333 0.279372 15.4611111 0.279107 15.4638889 0.278314 15.4666667 0.278050 15.4694444 0.278579 15.4722222 0.279636 15.4750000 0.280430 15.4777778 0.279901 15.4805556 0.279372 15.4833333 0.279107 15.4861111 0.279636 15.4888889 0.279901 15.4916667 0.280165 15.4944444 0.280430 15.4972222 0.279372 15.5000000 0.279901 15.5027778 0.279901 15.5055556 0.280430 15.5083333 0.280694 15.5111111 0.280694 15.5138889 0.280430 15.5166667 0.279901 15.5194444 0.281752 15.5222222 0.282545 15.5250000 0.282810 15.5277778 0.281752 15.5305556 0.281488 15.5333333 0.281752 15.5361111 0.282545 15.5388889 0.283074 15.5416667 0.283868 15.5444444 0.284397 15.5472222 0.283603 15.5500000 0.284132 15.5527778 0.284132 15.5555556 0.284926 15.5583333 0.285719 15.5611111 0.285719 15.5638889 0.285719 15.5666667 0.285983 15.5694444 0.286777 15.5722222 0.287306 15.5750000 0.287041 15.5777778 0.287835 15.5805556 0.287041 15.5833333 0.287306 15.5861111 0.288364 15.5888889 0.289686 15.5916667 0.289157 15.5944444 0.289950 15.5972222 0.288628 15.6030000 0.300000 15.7470000 0.300000 15.7500000 0.290215 15.7527778 0.289686 15.7555556 0.289686 15.7583333 0.289421 15.7611111 0.289950 15.7638889 0.290479 15.7666667 0.291273 15.7694444 0.291802 15.7722222 0.292066 15.7750000 0.291802 15.7777778 0.292595 15.7805556 0.292860 15.7833333 0.293653 15.7861111 0.295240 15.7888889 0.296298 15.7916667 0.297091 15.7944444 0.297884 15.7972222 0.298413 15.8000000 0.300264 15.8027778 0.300264 15.8055556 0.299471 15.8083333 0.298678 15.8111111 0.298942 15.8138889 0.300793 15.8166667 0.302645 15.8194444 0.303438 15.8222222 0.303174 15.8250000 0.301058 15.8277778 0.299207 15.8305556 0.295769 15.8333333 0.293653 15.8361111 0.292860 15.8388889 0.291273 15.8416667 0.289686 15.8444444 0.287835 15.8472222 0.286512 15.8500000 0.286248 15.8527778 0.286248 15.8555556 0.286777 15.8583333 0.286512 15.8611111 0.287306 15.8638889 0.287835 15.8666667 0.287570 15.8694444 0.286512 15.8722222 0.285719 15.8750000 0.284926 15.8777778 0.285455 15.8805556 0.285455 15.8833333 0.286248 15.8861111 0.286248 15.8888889 0.287306 15.8916667 0.287306 15.8944444 0.286777 15.8972222 0.286777 15.9000000 0.286777 15.9027778 0.286512 15.9055556 0.286248 15.9083333 0.285455 15.9111111 0.286248 15.9138889 0.285983 15.9166667 0.287306 15.9194444 0.287041 15.9222222 0.287041 15.9250000 0.285719 15.9277778 0.285719 15.9305556 0.286777 15.9333333 0.287041 15.9361111 0.286777 15.9388889 0.286512 15.9416667 0.286512 15.9444444 0.286248 15.9472222 0.286777 15.9500000 0.287835 15.9527778 0.288628 15.9555556 0.291273 15.9583333 0.294446 15.9611111 0.298678 15.9638889 0.304760 15.9666667 0.312430 15.9694444 0.320893 15.9722222 0.326182 15.9750000 0.326182 15.9777778 0.323802 15.9805556 0.326711 15.9833333 0.330678 15.9861111 0.333851 15.9888889 0.336231 15.9916667 0.337818 15.9944444 0.338876 15.9972222 0.341256 16.0000000 0.346017 16.0027778 0.348397 16.0055556 0.347603 16.0083333 0.344165 16.0111111 0.337554 16.0138889 0.329091 16.0166667 0.319306 16.0194444 0.309521 16.0222222 0.299207 16.0250000 0.288099 16.0277778 0.276463 16.0305556 0.268264 16.0333333 0.264298 16.0361111 0.264298 16.0388889 0.266678 16.0416667 0.268000 16.0444444 0.268529 16.0472222 0.269322 16.0500000 0.270380 16.0527778 0.272231 16.0555556 0.273025 16.0583333 0.274612 16.0611111 0.275669 16.0638889 0.276727 16.0666667 0.277256 16.0694444 0.276992 16.0722222 0.276727 16.0750000 0.276463 16.0777778 0.276198 16.0805556 0.276198 16.0833333 0.276727 16.0861111 0.276727 16.0888889 0.275934 16.0916667 0.275934 16.0944444 0.275405 16.0972222 0.275140 16.1000000 0.275669 16.1027778 0.275405 16.1055556 0.274876 16.1083333 0.274612 16.1111111 0.273025 16.1138889 0.273818 16.1166667 0.274612 16.1194444 0.274612 16.1222222 0.274612 16.1250000 0.274083 16.1277778 0.273818 16.1305556 0.274083 16.1333333 0.274612 16.1361111 0.274876 16.1388889 0.274083 16.1416667 0.273289 16.1444444 0.273554 16.1472222 0.274612 16.1500000 0.274612 16.1527778 0.274347 16.1555556 0.274083 16.1583333 0.273554 16.1611111 0.273025 16.1638889 0.273818 16.1666667 0.273818 16.1694444 0.275140 16.1722222 0.275405 16.1750000 0.273818 16.1777778 0.273554 16.1805556 0.274612 16.1833333 0.273818 16.1861111 0.273554 16.1888889 0.274083 16.1916667 0.274347 16.1944444 0.275140 16.1972222 0.275405 16.2000000 0.275669 16.2027778 0.275934 16.2055556 0.275669 16.2083333 0.274876 16.2111111 0.275405 16.2138889 0.276727 16.2166667 0.278314 16.2194444 0.278314 16.2222222 0.277521 16.2250000 0.276727 16.2277778 0.276463 16.2305556 0.278050 16.2333333 0.279372 16.2361111 0.279636 16.2388889 0.279107 16.2416667 0.279107 16.2444444 0.279107 16.2472222 0.279901 16.2500000 0.281223 16.2527778 0.281488 16.2555556 0.281223 16.2583333 0.280694 16.2611111 0.280430 16.2638889 0.281752 16.2666667 0.282810 16.2694444 0.283868 16.2722222 0.284661 16.2750000 0.284661 16.2777778 0.284661 16.2805556 0.285455 16.2833333 0.286248 16.2861111 0.285719 16.2888889 0.285719 16.2916667 0.285190 16.2944444 0.285455 16.2972222 0.286248 16.3030000 0.300000 16.4470000 0.300000 16.4500000 0.290215 16.4527778 0.289686 16.4555556 0.288893 16.4583333 0.288893 16.4611111 0.289950 16.4638889 0.290215 16.4666667 0.290215 16.4694444 0.291008 16.4722222 0.291537 16.4750000 0.291273 16.4777778 0.292595 16.4805556 0.293388 16.4833333 0.292860 16.4861111 0.293653 16.4888889 0.293653 16.4916667 0.295240 16.4944444 0.296033 16.4972222 0.298149 16.5000000 0.298678 16.5027778 0.299207 16.5055556 0.299736 16.5083333 0.299736 16.5111111 0.299471 16.5138889 0.300793 16.5166667 0.301587 16.5194444 0.303438 16.5222222 0.303438 16.5250000 0.301851 16.5277778 0.301851 16.5305556 0.301058 16.5333333 0.298942 16.5361111 0.296562 16.5388889 0.293653 16.5416667 0.291273 16.5444444 0.290215 16.5472222 0.289157 16.5500000 0.287570 16.5527778 0.286777 16.5555556 0.286512 16.5583333 0.286777 16.5611111 0.287835 16.5638889 0.288893 16.5666667 0.288364 16.5694444 0.288364 16.5722222 0.287570 16.5750000 0.287041 16.5777778 0.287570 16.5805556 0.288893 16.5833333 0.288628 16.5861111 0.288628 16.5888889 0.287306 16.5916667 0.287570 16.5944444 0.288364 16.5972222 0.289157 16.6000000 0.289157 16.6027778 0.288893 16.6055556 0.288628 16.6083333 0.287570 16.6111111 0.287306 16.6138889 0.288364 16.6166667 0.288628 16.6194444 0.288099 16.6222222 0.288099 16.6250000 0.288099 16.6277778 0.288893 16.6305556 0.289421 16.6333333 0.289157 16.6361111 0.288628 16.6388889 0.287570 16.6416667 0.287835 16.6444444 0.287835 16.6472222 0.288364 16.6500000 0.288364 16.6527778 0.288893 16.6555556 0.289686 16.6583333 0.292066 16.6611111 0.297091 16.6638889 0.303967 16.6666667 0.311107 16.6694444 0.318777 16.6722222 0.321421 16.6750000 0.319835 16.6777778 0.319306 16.6805556 0.321421 16.6833333 0.324595 16.6861111 0.327240 16.6888889 0.329884 16.6916667 0.331471 16.6944444 0.333058 16.6972222 0.335174 16.7000000 0.337818 16.7027778 0.338347 16.7055556 0.337818 16.7083333 0.334909 16.7111111 0.329620 16.7138889 0.322479 16.7166667 0.314545 16.7194444 0.307934 16.7222222 0.301058 16.7250000 0.291008 16.7277778 0.280694 16.7305556 0.273554 16.7333333 0.266678 16.7361111 0.264562 16.7388889 0.265620 16.7416667 0.269058 16.7444444 0.271702 16.7472222 0.272231 16.7500000 0.273025 16.7527778 0.274083 16.7555556 0.274876 16.7583333 0.275934 16.7611111 0.279636 16.7638889 0.280694 16.7666667 0.280959 16.7694444 0.280694 16.7722222 0.280430 16.7750000 0.280165 16.7777778 0.280959 16.7805556 0.281488 16.7833333 0.280430 16.7861111 0.279901 16.7888889 0.279901 16.7916667 0.279901 16.7944444 0.279372 16.7972222 0.280165 16.8000000 0.279636 16.8027778 0.278579 16.8055556 0.278843 16.8083333 0.279636 16.8111111 0.279901 16.8138889 0.279901 16.8166667 0.279901 16.8194444 0.279107 16.8222222 0.278314 16.8250000 0.278050 16.8277778 0.278314 16.8305556 0.279107 16.8333333 0.279372 16.8361111 0.278314 16.8388889 0.278050 16.8416667 0.278050 16.8444444 0.278579 16.8472222 0.279107 16.8500000 0.278843 16.8527778 0.278579 16.8555556 0.277521 16.8583333 0.277256 16.8611111 0.278314 16.8638889 0.278843 16.8666667 0.278843 16.8694444 0.279107 16.8722222 0.278314 16.8750000 0.278050 16.8777778 0.278843 16.8805556 0.278579 16.8833333 0.278050 16.8861111 0.278314 16.8888889 0.279107 16.8916667 0.279636 16.8944444 0.279901 16.8972222 0.279901 16.9000000 0.279372 16.9027778 0.279372 16.9055556 0.279636 16.9083333 0.279636 16.9111111 0.279901 16.9138889 0.280959 16.9166667 0.281223 16.9194444 0.280694 16.9222222 0.280694 16.9250000 0.280694 16.9277778 0.281223 16.9305556 0.280694 16.9333333 0.281223 16.9361111 0.281488 16.9388889 0.282017 16.9416667 0.282281 16.9444444 0.282545 16.9472222 0.283074 16.9500000 0.283074 16.9527778 0.283603 16.9555556 0.283603 16.9583333 0.283868 16.9611111 0.284926 16.9638889 0.285455 16.9666667 0.285455 16.9694444 0.285983 16.9722222 0.285190 16.9750000 0.285190 16.9777778 0.286248 16.9805556 0.288099 16.9833333 0.287835 16.9861111 0.287835 16.9888889 0.287570 16.9916667 0.287835 16.9944444 0.288893 16.9972222 0.289686 17.0030000 0.300000 17.1470000 0.300000 17.1500000 0.289950 17.1527778 0.291008 17.1555556 0.292066 17.1583333 0.292066 17.1611111 0.292066 17.1638889 0.291537 17.1666667 0.292066 17.1694444 0.292595 17.1722222 0.292595 17.1750000 0.294711 17.1777778 0.295769 17.1805556 0.295769 17.1833333 0.296298 17.1861111 0.296826 17.1888889 0.297620 17.1916667 0.298413 17.1944444 0.299471 17.1972222 0.298413 17.2000000 0.299207 17.2027778 0.300264 17.2055556 0.301587 17.2083333 0.302380 17.2111111 0.302380 17.2138889 0.302380 17.2166667 0.301851 17.2194444 0.302116 17.2222222 0.300000 17.2250000 0.297884 17.2277778 0.295504 17.2305556 0.293653 17.2333333 0.292066 17.2361111 0.290744 17.2388889 0.289950 17.2416667 0.288364 17.2444444 0.286248 17.2472222 0.285455 17.2500000 0.286512 17.2527778 0.286512 17.2555556 0.287306 17.2583333 0.287306 17.2611111 0.286777 17.2638889 0.286512 17.2666667 0.286248 17.2694444 0.287041 17.2722222 0.287570 17.2750000 0.287041 17.2777778 0.286248 17.2805556 0.285719 17.2833333 0.285983 17.2861111 0.286777 17.2888889 0.287306 17.2916667 0.287041 17.2944444 0.287306 17.2972222 0.285983 17.3000000 0.286777 17.3027778 0.287306 17.3055556 0.286777 17.3083333 0.286777 17.3111111 0.286777 17.3138889 0.286248 17.3166667 0.286512 17.3194444 0.287570 17.3222222 0.287835 17.3250000 0.287835 17.3277778 0.287570 17.3305556 0.286512 17.3333333 0.287306 17.3361111 0.287570 17.3388889 0.287835 17.3416667 0.287306 17.3444444 0.286512 17.3472222 0.286777 17.3500000 0.288099 17.3527778 0.288893 17.3555556 0.292595 17.3583333 0.296826 17.3611111 0.302645 17.3638889 0.309256 17.3666667 0.316926 17.3694444 0.322215 17.3722222 0.324066 17.3750000 0.322744 17.3777778 0.322479 17.3805556 0.324331 17.3833333 0.327240 17.3861111 0.331207 17.3888889 0.334116 17.3916667 0.334909 17.3944444 0.336231 17.3972222 0.336231 17.4000000 0.338876 17.4027778 0.340463 17.4055556 0.340463 17.4083333 0.338612 17.4111111 0.333587 17.4138889 0.325653 17.4166667 0.317190 17.4194444 0.310050 17.4222222 0.302909 17.4250000 0.292066 17.4277778 0.280430 17.4305556 0.271174 17.4333333 0.265355 17.4361111 0.263240 17.4388889 0.264826 17.4416667 0.267471 17.4444444 0.268793 17.4472222 0.269587 17.4500000 0.270380 17.4527778 0.271438 17.4555556 0.273025 17.4583333 0.275140 17.4611111 0.275934 17.4638889 0.276198 17.4666667 0.276992 17.4694444 0.277521 17.4722222 0.277521 17.4750000 0.277256 17.4777778 0.277521 17.4805556 0.277256 17.4833333 0.276992 17.4861111 0.276727 17.4888889 0.277256 17.4916667 0.276992 17.4944444 0.276463 17.4972222 0.275934 17.5000000 0.276198 17.5027778 0.276198 17.5055556 0.276992 17.5083333 0.276463 17.5111111 0.275669 17.5138889 0.274347 17.5166667 0.274612 17.5194444 0.275405 17.5222222 0.275934 17.5250000 0.275405 17.5277778 0.274612 17.5305556 0.273554 17.5333333 0.274347 17.5361111 0.274612 17.5388889 0.275140 17.5416667 0.274876 17.5444444 0.274347 17.5472222 0.273818 17.5500000 0.274876 17.5527778 0.275669 17.5555556 0.275669 17.5583333 0.274876 17.5611111 0.274876 17.5638889 0.274347 17.5666667 0.274347 17.5694444 0.274347 17.5722222 0.275140 17.5750000 0.275140 17.5777778 0.275140 17.5805556 0.275140 17.5833333 0.275405 17.5861111 0.274612 17.5888889 0.275405 17.5916667 0.275405 17.5944444 0.275140 17.5972222 0.275405 17.6000000 0.275934 17.6027778 0.276198 17.6055556 0.275934 17.6083333 0.276198 17.6111111 0.275669 17.6138889 0.275405 17.6166667 0.275934 17.6194444 0.277256 17.6222222 0.279107 17.6250000 0.279636 17.6277778 0.279107 17.6305556 0.278050 17.6333333 0.278314 17.6361111 0.279107 17.6388889 0.279636 17.6416667 0.280430 17.6444444 0.279636 17.6472222 0.279372 17.6500000 0.279901 17.6527778 0.281488 17.6555556 0.281752 17.6583333 0.282545 17.6611111 0.282017 17.6638889 0.281752 17.6666667 0.282281 17.6694444 0.283339 17.6722222 0.283603 17.6750000 0.283603 17.6777778 0.283074 17.6805556 0.284132 17.6833333 0.285719 17.6861111 0.286512 17.6888889 0.287041 17.6916667 0.287041 17.6944444 0.286777 17.6972222 0.286777 17.7030000 0.300000 17.8470000 0.300000 17.8500000 0.289686 17.8527778 0.290744 17.8555556 0.291537 17.8583333 0.292331 17.8611111 0.292331 17.8638889 0.291802 17.8666667 0.292595 17.8694444 0.293388 17.8722222 0.293917 17.8750000 0.294446 17.8777778 0.294975 17.8805556 0.295769 17.8833333 0.296826 17.8861111 0.297884 17.8888889 0.298413 17.8916667 0.298678 17.8944444 0.299207 17.8972222 0.299207 17.9000000 0.299471 17.9027778 0.300529 17.9055556 0.302116 17.9083333 0.302116 17.9111111 0.302645 17.9138889 0.301587 17.9166667 0.302116 17.9194444 0.301587 17.9222222 0.300264 17.9250000 0.297355 17.9277778 0.294975 17.9305556 0.292331 17.9333333 0.290744 17.9361111 0.289421 17.9388889 0.287570 17.9416667 0.287306 17.9444444 0.286248 17.9472222 0.286248 17.9500000 0.286512 17.9527778 0.287041 17.9555556 0.287570 17.9583333 0.287041 17.9611111 0.287041 17.9638889 0.286777 17.9666667 0.286777 17.9694444 0.287041 17.9722222 0.287570 17.9750000 0.287570 17.9777778 0.287306 17.9805556 0.286777 17.9833333 0.287041 17.9861111 0.287306 17.9888889 0.287835 17.9916667 0.287570 17.9944444 0.287570 17.9972222 0.287041 18.0000000 0.286777 18.0027778 0.287306 18.0055556 0.287835 18.0083333 0.287835 18.0111111 0.287570 18.0138889 0.287835 18.0166667 0.288099 18.0194444 0.288628 18.0222222 0.288893 18.0250000 0.288628 18.0277778 0.288628 18.0305556 0.288099 18.0333333 0.288099 18.0361111 0.288099 18.0388889 0.288099 18.0416667 0.288628 18.0444444 0.287835 18.0472222 0.288364 18.0500000 0.288893 18.0527778 0.292860 18.0555556 0.298149 18.0583333 0.302909 18.0611111 0.309256 18.0638889 0.316132 18.0666667 0.321686 18.0694444 0.323537 18.0722222 0.322215 18.0750000 0.321686 18.0777778 0.323802 18.0805556 0.326446 18.0833333 0.328826 18.0861111 0.332000 18.0888889 0.333851 18.0916667 0.334380 18.0944444 0.336760 18.0972222 0.339405 18.1000000 0.341256 18.1027778 0.341521 18.1055556 0.341256 18.1083333 0.337289 18.1111111 0.330942 18.1138889 0.322744 18.1166667 0.315339 18.1194444 0.308992 18.1222222 0.300793 18.1250000 0.291537 18.1277778 0.279901 18.1305556 0.271438 18.1333333 0.266942 18.1361111 0.267207 18.1388889 0.270380 18.1416667 0.271967 18.1444444 0.272231 18.1472222 0.271967 18.1500000 0.273818 18.1527778 0.276463 18.1555556 0.278314 18.1583333 0.279107 18.1611111 0.279372 18.1638889 0.279901 18.1666667 0.281223 18.1694444 0.281223 18.1722222 0.280959 18.1750000 0.280165 18.1777778 0.279636 18.1805556 0.280165 18.1833333 0.280430 18.1861111 0.280430 18.1888889 0.279901 18.1916667 0.279636 18.1944444 0.280430 18.1972222 0.279636 18.2000000 0.279107 18.2027778 0.279107 18.2055556 0.280165 18.2083333 0.279636 18.2111111 0.279107 18.2138889 0.278579 18.2166667 0.278314 18.2194444 0.279107 18.2222222 0.278843 18.2250000 0.278314 18.2277778 0.278050 18.2305556 0.276727 18.2333333 0.277256 18.2361111 0.277521 18.2388889 0.278314 18.2416667 0.277521 18.2444444 0.276992 18.2472222 0.276727 18.2500000 0.277521 18.2527778 0.278314 18.2555556 0.278843 18.2583333 0.277785 18.2611111 0.277785 18.2638889 0.276992 18.2666667 0.276992 18.2694444 0.277256 18.2722222 0.277256 18.2750000 0.277256 18.2777778 0.277256 18.2805556 0.276727 18.2833333 0.277785 18.2861111 0.278050 18.2888889 0.278843 18.2916667 0.278579 18.2944444 0.278579 18.2972222 0.278579 18.3000000 0.278579 18.3027778 0.279107 18.3055556 0.278579 18.3083333 0.279107 18.3111111 0.278843 18.3138889 0.279107 18.3166667 0.278843 18.3194444 0.280165 18.3222222 0.279636 18.3250000 0.280430 18.3277778 0.280694 18.3305556 0.280959 18.3333333 0.280430 18.3361111 0.280959 18.3388889 0.281223 18.3416667 0.281488 18.3444444 0.281752 18.3472222 0.281488 18.3500000 0.283603 18.3527778 0.283603 18.3555556 0.284132 18.3583333 0.284132 18.3611111 0.284397 18.3638889 0.284661 18.3666667 0.284661 18.3694444 0.285455 18.3722222 0.285983 18.3750000 0.285719 18.3777778 0.285719 18.3805556 0.285719 18.3833333 0.286512 18.3861111 0.286512 18.3888889 0.287570 18.3916667 0.287570 18.3944444 0.287835 18.3972222 0.287570 18.4030000 0.300000 18.5470000 0.300000 18.5500000 0.294446 18.5527778 0.294182 18.5555556 0.294711 18.5583333 0.294446 18.5611111 0.295504 18.5638889 0.297355 18.5666667 0.298413 18.5694444 0.298678 18.5722222 0.298413 18.5750000 0.298942 18.5777778 0.299736 18.5805556 0.300793 18.5833333 0.301058 18.5861111 0.301322 18.5888889 0.301058 18.5916667 0.301322 18.5944444 0.302645 18.5972222 0.302645 18.6000000 0.302645 18.6027778 0.303438 18.6055556 0.302645 18.6083333 0.301322 18.6111111 0.300000 18.6138889 0.298678 18.6166667 0.296826 18.6194444 0.294182 18.6222222 0.292331 18.6250000 0.290215 18.6277778 0.288628 18.6305556 0.287041 18.6333333 0.287306 18.6361111 0.288364 18.6388889 0.288364 18.6416667 0.288364 18.6444444 0.288099 18.6472222 0.288893 18.6500000 0.288628 18.6527778 0.288364 18.6555556 0.287835 18.6583333 0.286777 18.6611111 0.287306 18.6638889 0.288099 18.6666667 0.289157 18.6694444 0.288893 18.6722222 0.288099 18.6750000 0.287570 18.6777778 0.288628 18.6805556 0.288893 18.6833333 0.288364 18.6861111 0.288364 18.6888889 0.287570 18.6916667 0.287041 18.6944444 0.287835 18.6972222 0.288364 18.7000000 0.288628 18.7027778 0.288364 18.7055556 0.288099 18.7083333 0.288364 18.7111111 0.287835 18.7138889 0.288099 18.7166667 0.288364 18.7194444 0.288628 18.7222222 0.288893 18.7250000 0.288628 18.7277778 0.288099 18.7305556 0.288099 18.7333333 0.288099 18.7361111 0.288099 18.7388889 0.287306 18.7416667 0.286777 18.7444444 0.287306 18.7472222 0.288893 18.7500000 0.291802 18.7527778 0.297091 18.7555556 0.303438 18.7583333 0.310050 18.7611111 0.317190 18.7638889 0.321421 18.7666667 0.320628 18.7694444 0.319306 18.7722222 0.320364 18.7750000 0.323273 18.7777778 0.326182 18.7805556 0.327769 18.7833333 0.328826 18.7861111 0.330678 18.7888889 0.332793 18.7916667 0.334116 18.7944444 0.336760 18.7972222 0.338612 18.8000000 0.340198 18.8027778 0.339140 18.8055556 0.338347 18.8083333 0.335438 18.8111111 0.330413 18.8138889 0.324331 18.8166667 0.317190 18.8194444 0.310579 18.8222222 0.304231 18.8250000 0.297355 18.8277778 0.289157 18.8305556 0.279636 18.8333333 0.272760 18.8361111 0.267207 18.8388889 0.265355 18.8416667 0.266149 18.8444444 0.269587 18.8472222 0.271702 18.8500000 0.272496 18.8527778 0.273554 18.8555556 0.274083 18.8583333 0.275405 18.8611111 0.276727 18.8638889 0.278314 18.8666667 0.279636 18.8694444 0.279901 18.8722222 0.280694 18.8750000 0.280959 18.8777778 0.280694 18.8805556 0.280430 18.8833333 0.280694 18.8861111 0.280694 18.8888889 0.280959 18.8916667 0.280694 18.8944444 0.279901 18.8972222 0.280165 18.9000000 0.280959 18.9027778 0.280694 18.9055556 0.281223 18.9083333 0.280430 18.9111111 0.280694 18.9138889 0.279636 18.9166667 0.279901 18.9194444 0.280430 18.9222222 0.279372 18.9250000 0.279107 18.9277778 0.279372 18.9305556 0.279636 18.9333333 0.279901 18.9361111 0.279636 18.9388889 0.278843 18.9416667 0.277785 18.9444444 0.277785 18.9472222 0.278579 18.9500000 0.278579 18.9527778 0.278579 18.9555556 0.278579 18.9583333 0.278579 18.9611111 0.278314 18.9638889 0.279107 18.9666667 0.279901 18.9694444 0.279372 18.9722222 0.278843 18.9750000 0.278579 18.9777778 0.278843 18.9805556 0.278843 18.9833333 0.278843 18.9861111 0.278843 18.9888889 0.279107 18.9916667 0.278843 18.9944444 0.279107 18.9972222 0.279372 19.0000000 0.279636 19.0027778 0.279636 19.0055556 0.279636 19.0083333 0.279107 19.0111111 0.279372 19.0138889 0.279107 19.0166667 0.280430 19.0194444 0.280165 19.0222222 0.280165 19.0250000 0.279636 19.0277778 0.279901 19.0305556 0.280959 19.0333333 0.281488 19.0361111 0.281488 19.0388889 0.281223 19.0416667 0.280694 19.0444444 0.281223 19.0472222 0.282281 19.0500000 0.282017 19.0527778 0.282281 19.0555556 0.282017 19.0583333 0.282545 19.0611111 0.283339 19.0638889 0.283074 19.0666667 0.283074 19.0694444 0.284397 19.0722222 0.284661 19.0750000 0.284397 19.0777778 0.284661 19.0805556 0.285455 19.0833333 0.286248 19.0861111 0.286248 19.0888889 0.285983 19.0916667 0.286248 19.0944444 0.286777 19.0972222 0.286777 19.1030000 0.300000 19.2470000 0.300000 19.2500000 0.287835 19.2527778 0.288628 19.2555556 0.289686 19.2583333 0.289157 19.2611111 0.289157 19.2638889 0.289157 19.2666667 0.289157 19.2694444 0.289157 19.2722222 0.289686 19.2750000 0.291537 19.2777778 0.293124 19.2805556 0.293388 19.2833333 0.292860 19.2861111 0.293388 19.2888889 0.294975 19.2916667 0.296298 19.2944444 0.296033 19.2972222 0.296298 19.3000000 0.296298 19.3027778 0.296298 19.3055556 0.296562 19.3083333 0.297884 19.3111111 0.299207 19.3138889 0.298942 19.3166667 0.297355 19.3194444 0.295240 19.3222222 0.293124 19.3250000 0.291537 19.3277778 0.289421 19.3305556 0.287570 19.3333333 0.285455 19.3361111 0.284132 19.3388889 0.283339 19.3416667 0.283074 19.3444444 0.282810 19.3472222 0.282810 19.3500000 0.282810 19.3527778 0.283074 19.3555556 0.283603 19.3583333 0.283339 19.3611111 0.282810 19.3638889 0.282281 19.3666667 0.281752 19.3694444 0.283074 19.3722222 0.284132 19.3750000 0.283868 19.3777778 0.283868 19.3805556 0.283074 19.3833333 0.283074 19.3861111 0.283339 19.3888889 0.283603 19.3916667 0.283339 19.3944444 0.282810 19.3972222 0.283074 19.4000000 0.282545 19.4027778 0.283074 19.4055556 0.283074 19.4083333 0.283868 19.4111111 0.284132 19.4138889 0.283074 19.4166667 0.282281 19.4194444 0.283074 19.4222222 0.284661 19.4250000 0.284661 19.4277778 0.283868 19.4305556 0.283339 19.4333333 0.282810 19.4361111 0.284132 19.4388889 0.284661 19.4416667 0.284926 19.4444444 0.284132 19.4472222 0.283868 19.4500000 0.285190 19.4527778 0.287041 19.4555556 0.290479 19.4583333 0.294975 19.4611111 0.301322 19.4638889 0.308198 19.4666667 0.315868 19.4694444 0.320628 19.4722222 0.321950 19.4750000 0.320364 19.4777778 0.320364 19.4805556 0.323273 19.4833333 0.325917 19.4861111 0.329355 19.4888889 0.332000 19.4916667 0.333322 19.4944444 0.335438 19.4972222 0.338876 19.5000000 0.341785 19.5027778 0.343107 19.5055556 0.341785 19.5083333 0.336760 19.5111111 0.329620 19.5138889 0.319835 19.5166667 0.309785 19.5194444 0.302116 19.5222222 0.294446 19.5250000 0.284661 19.5277778 0.273818 19.5305556 0.266678 19.5333333 0.262975 19.5361111 0.262975 19.5388889 0.266149 19.5416667 0.268793 19.5444444 0.269587 19.5472222 0.269851 19.5500000 0.270116 19.5527778 0.271438 19.5555556 0.273554 19.5583333 0.274612 19.5611111 0.275669 19.5638889 0.275934 19.5666667 0.276727 19.5694444 0.276727 19.5722222 0.277256 19.5750000 0.277521 19.5777778 0.277256 19.5805556 0.276992 19.5833333 0.276992 19.5861111 0.276992 19.5888889 0.277521 19.5916667 0.277256 19.5944444 0.277256 19.5972222 0.276198 19.6000000 0.275405 19.6027778 0.276463 19.6055556 0.276463 19.6083333 0.276463 19.6111111 0.276198 19.6138889 0.276463 19.6166667 0.275669 19.6194444 0.275934 19.6222222 0.275669 19.6250000 0.275140 19.6277778 0.275405 19.6305556 0.274612 19.6333333 0.275405 19.6361111 0.274876 19.6388889 0.275140 19.6416667 0.275405 19.6444444 0.276198 19.6472222 0.275140 19.6500000 0.275405 19.6527778 0.275405 19.6555556 0.275934 19.6583333 0.275934 19.6611111 0.276198 19.6638889 0.276198 19.6666667 0.275405 19.6694444 0.275934 19.6722222 0.275669 19.6750000 0.276198 19.6777778 0.275934 19.6805556 0.276198 19.6833333 0.275934 19.6861111 0.276463 19.6888889 0.276992 19.6916667 0.277256 19.6944444 0.276992 19.6972222 0.276198 19.7000000 0.275934 19.7027778 0.277256 19.7055556 0.277785 19.7083333 0.278579 19.7111111 0.277785 19.7138889 0.277785 19.7166667 0.277521 19.7194444 0.278050 19.7222222 0.278050 19.7250000 0.278579 19.7277778 0.279372 19.7305556 0.278843 19.7333333 0.279636 19.7361111 0.279636 19.7388889 0.280959 19.7416667 0.282017 19.7444444 0.281752 19.7472222 0.281223 19.7500000 0.281488 19.7527778 0.281752 19.7555556 0.282545 19.7583333 0.283603 19.7611111 0.283603 19.7638889 0.283603 19.7666667 0.284132 19.7694444 0.284926 19.7722222 0.285190 19.7750000 0.284926 19.7777778 0.285983 19.7805556 0.286248 19.7833333 0.285190 19.7861111 0.286512 19.7888889 0.287570 19.7916667 0.288099 19.7944444 0.288099 19.7972222 0.288364 19.8030000 0.300000 19.9470000 0.300000 19.9500000 0.289950 19.9527778 0.289421 19.9555556 0.290215 19.9583333 0.291008 19.9611111 0.292595 19.9638889 0.292595 19.9666667 0.292595 19.9694444 0.292595 19.9722222 0.294182 19.9750000 0.295504 19.9777778 0.296562 19.9805556 0.296298 19.9833333 0.296826 19.9861111 0.297091 19.9888889 0.297355 19.9916667 0.297355 19.9944444 0.298942 19.9972222 0.300793 20.0000000 0.300793 20.0027778 0.300529 20.0055556 0.300529 20.0083333 0.300793 20.0111111 0.301587 20.0138889 0.302645 20.0166667 0.304496 20.0194444 0.306083 20.0222222 0.305289 20.0250000 0.304231 20.0277778 0.303702 20.0305556 0.302380 20.0333333 0.300264 20.0361111 0.298678 20.0388889 0.296562 20.0416667 0.293917 20.0444444 0.292595 20.0472222 0.290744 20.0500000 0.289686 20.0527778 0.289157 20.0555556 0.289421 20.0583333 0.289686 20.0611111 0.289686 20.0638889 0.290215 20.0666667 0.289421 20.0694444 0.289157 20.0722222 0.288893 20.0750000 0.289421 20.0777778 0.289950 20.0805556 0.289686 20.0833333 0.290479 20.0861111 0.290215 20.0888889 0.289421 20.0916667 0.288893 20.0944444 0.288628 20.0972222 0.289157 20.1000000 0.290215 20.1027778 0.291008 20.1055556 0.290744 20.1083333 0.289421 20.1111111 0.288364 20.1138889 0.288893 20.1166667 0.289157 20.1194444 0.286777 20.1222222 0.285455 20.1250000 0.286512 20.1277778 0.288099 20.1305556 0.290479 20.1333333 0.292331 20.1361111 0.291802 20.1388889 0.291008 20.1416667 0.290215 20.1444444 0.291008 20.1472222 0.289950 20.1500000 0.289421 20.1527778 0.288628 20.1555556 0.289157 20.1583333 0.291273 20.1611111 0.294446 20.1638889 0.300264 20.1666667 0.306612 20.1694444 0.313223 20.1722222 0.316397 20.1750000 0.316132 20.1777778 0.315074 20.1805556 0.316132 20.1833333 0.319041 20.1861111 0.321686 20.1888889 0.323802 20.1916667 0.324860 20.1944444 0.326711 20.1972222 0.329620 20.2000000 0.331207 20.2027778 0.331471 20.2055556 0.329884 20.2083333 0.326182 20.2111111 0.320364 20.2138889 0.312694 20.2166667 0.305554 20.2194444 0.298413 20.2222222 0.291802 20.2250000 0.282545 20.2277778 0.272496 20.2305556 0.266413 20.2333333 0.266149 20.2361111 0.270909 20.2388889 0.274083 20.2416667 0.275405 20.2444444 0.275934 20.2472222 0.276463 20.2500000 0.279107 20.2527778 0.281752 20.2555556 0.283339 20.2583333 0.283603 20.2611111 0.284661 20.2638889 0.284661 20.2666667 0.284397 20.2694444 0.283074 20.2722222 0.282810 20.2750000 0.283603 20.2777778 0.283339 20.2805556 0.284926 20.2833333 0.285190 20.2861111 0.283868 20.2888889 0.282545 20.2916667 0.283868 20.2944444 0.283603 20.2972222 0.283603 20.3000000 0.283339 20.3027778 0.283339 20.3055556 0.282545 20.3083333 0.282017 20.3111111 0.283074 20.3138889 0.283868 20.3166667 0.283603 20.3194444 0.283074 20.3222222 0.282810 20.3250000 0.283074 20.3277778 0.283339 20.3305556 0.283074 20.3333333 0.282017 20.3361111 0.283339 20.3388889 0.282545 20.3416667 0.281488 20.3444444 0.281488 20.3472222 0.282017 20.3500000 0.282545 20.3527778 0.282545 20.3555556 0.282281 20.3583333 0.282545 20.3611111 0.283074 20.3638889 0.282545 20.3666667 0.283074 20.3694444 0.283074 20.3722222 0.282281 20.3750000 0.281488 20.3777778 0.281752 20.3805556 0.283339 20.3833333 0.284132 20.3861111 0.283339 20.3888889 0.283074 20.3916667 0.282810 20.3944444 0.283603 20.3972222 0.283868 20.4000000 0.283868 20.4027778 0.284132 20.4055556 0.284132 20.4083333 0.285190 20.4111111 0.285455 20.4138889 0.285719 20.4166667 0.286248 20.4194444 0.285719 20.4222222 0.285719 20.4250000 0.285719 20.4277778 0.286512 20.4305556 0.287570 20.4333333 0.288099 20.4361111 0.288099 20.4388889 0.287570 20.4416667 0.287570 20.4444444 0.287570 20.4472222 0.288099 20.4500000 0.288364 20.4527778 0.288893 20.4555556 0.288893 20.4583333 0.289157 20.4611111 0.289421 20.4638889 0.290744 20.4666667 0.291008 20.4694444 0.291273 20.4722222 0.290479 20.4750000 0.290215 20.4777778 0.291008 20.4805556 0.291537 20.4833333 0.291537 20.4861111 0.291273 20.4888889 0.290744 20.4916667 0.290744 20.4944444 0.291537 20.4972222 0.292595 20.5030000 0.300000 20.6470000 0.300000 20.6500000 0.287835 20.6527778 0.287570 20.6555556 0.287835 20.6583333 0.288893 20.6611111 0.289686 20.6638889 0.289686 20.6666667 0.289950 20.6694444 0.289950 20.6722222 0.290215 20.6750000 0.291537 20.6777778 0.292066 20.6805556 0.292066 20.6833333 0.292860 20.6861111 0.292595 20.6888889 0.293124 20.6916667 0.294182 20.6944444 0.295240 20.6972222 0.296562 20.7000000 0.297355 20.7027778 0.297884 20.7055556 0.298678 20.7083333 0.299736 20.7111111 0.300000 20.7138889 0.300000 20.7166667 0.300529 20.7194444 0.301322 20.7222222 0.302116 20.7250000 0.302645 20.7277778 0.301851 20.7305556 0.301058 20.7333333 0.299471 20.7361111 0.298149 20.7388889 0.295769 20.7416667 0.293917 20.7444444 0.291802 20.7472222 0.289950 20.7500000 0.287570 20.7527778 0.285983 20.7555556 0.285455 20.7583333 0.286777 20.7611111 0.287570 20.7638889 0.288099 20.7666667 0.287570 20.7694444 0.287041 20.7722222 0.287041 20.7750000 0.288099 20.7777778 0.288364 20.7805556 0.287835 20.7833333 0.287570 20.7861111 0.286777 20.7888889 0.287306 20.7916667 0.287570 20.7944444 0.288628 20.7972222 0.288364 20.8000000 0.288364 20.8027778 0.287306 20.8055556 0.287570 20.8083333 0.287570 20.8111111 0.288364 20.8138889 0.288628 20.8166667 0.288364 20.8194444 0.287835 20.8222222 0.287306 20.8250000 0.287835 20.8277778 0.288893 20.8305556 0.288893 20.8333333 0.288364 20.8361111 0.287835 20.8388889 0.287306 20.8416667 0.287835 20.8444444 0.287306 20.8472222 0.287306 20.8500000 0.287041 20.8527778 0.285719 20.8555556 0.286248 20.8583333 0.288893 20.8611111 0.292595 20.8638889 0.297620 20.8666667 0.303702 20.8694444 0.309785 20.8722222 0.315603 20.8750000 0.318777 20.8777778 0.317983 20.8805556 0.316926 20.8833333 0.319570 20.8861111 0.322744 20.8888889 0.324595 20.8916667 0.328298 20.8944444 0.331471 20.8972222 0.332793 20.9000000 0.333851 20.9027778 0.334645 20.9055556 0.334380 20.9083333 0.333058 20.9111111 0.329091 20.9138889 0.321686 20.9166667 0.312959 20.9194444 0.304231 20.9222222 0.297355 20.9250000 0.289157 20.9277778 0.281223 20.9305556 0.273025 20.9333333 0.266678 20.9361111 0.264298 20.9388889 0.266149 20.9416667 0.270380 20.9444444 0.272760 20.9472222 0.273554 20.9500000 0.273818 20.9527778 0.274612 20.9555556 0.276727 20.9583333 0.278579 20.9611111 0.280165 20.9638889 0.280959 20.9666667 0.281223 20.9694444 0.281223 20.9722222 0.280165 20.9750000 0.280959 20.9777778 0.281223 20.9805556 0.281488 20.9833333 0.280959 20.9861111 0.280430 20.9888889 0.280959 20.9916667 0.281223 20.9944444 0.281752 20.9972222 0.281223 21.0000000 0.280694 21.0027778 0.280430 21.0055556 0.279372 21.0083333 0.279636 21.0111111 0.280959 21.0138889 0.281488 21.0166667 0.280165 21.0194444 0.279901 21.0222222 0.279636 21.0250000 0.279901 21.0277778 0.279901 21.0305556 0.280165 21.0333333 0.279372 21.0361111 0.279107 21.0388889 0.279107 21.0416667 0.279636 21.0444444 0.280430 21.0472222 0.280959 21.0500000 0.280165 21.0527778 0.279636 21.0555556 0.279107 21.0583333 0.279372 21.0611111 0.279636 21.0638889 0.279636 21.0666667 0.280165 21.0694444 0.279901 21.0722222 0.280694 21.0750000 0.281752 21.0777778 0.281223 21.0805556 0.280959 21.0833333 0.280694 21.0861111 0.280430 21.0888889 0.280430 21.0916667 0.281752 21.0944444 0.282810 21.0972222 0.282545 21.1000000 0.282017 21.1027778 0.281488 21.1055556 0.281223 21.1083333 0.282545 21.1111111 0.283339 21.1138889 0.283868 21.1166667 0.283074 21.1194444 0.283074 21.1222222 0.282810 21.1250000 0.284132 21.1277778 0.284132 21.1305556 0.284132 21.1333333 0.284661 21.1361111 0.284132 21.1388889 0.284926 21.1416667 0.285719 21.1444444 0.285190 21.1472222 0.285190 21.1500000 0.285983 21.1527778 0.285983 21.1555556 0.286248 21.1583333 0.287306 21.1611111 0.288099 21.1638889 0.288628 21.1666667 0.288099 21.1694444 0.288364 21.1722222 0.288628 21.1750000 0.289421 21.1777778 0.289686 21.1805556 0.290215 21.1833333 0.290479 21.1861111 0.289421 21.1888889 0.289686 21.1916667 0.291008 21.1944444 0.291802 21.1972222 0.291802 21.2030000 0.300000 21.3470000 0.300000 21.3500000 0.295769 21.3527778 0.296298 21.3555556 0.296562 21.3583333 0.296033 21.3611111 0.295240 21.3638889 0.294711 21.3666667 0.296562 21.3694444 0.297884 21.3722222 0.298942 21.3750000 0.300264 21.3777778 0.300264 21.3805556 0.300529 21.3833333 0.301587 21.3861111 0.302909 21.3888889 0.302909 21.3916667 0.302116 21.3944444 0.302116 21.3972222 0.303702 21.4000000 0.305025 21.4027778 0.305554 21.4055556 0.305289 21.4083333 0.305289 21.4111111 0.304496 21.4138889 0.303174 21.4166667 0.301058 21.4194444 0.299471 21.4222222 0.297355 21.4250000 0.294975 21.4277778 0.293653 21.4305556 0.291008 21.4333333 0.290479 21.4361111 0.289421 21.4388889 0.289686 21.4416667 0.290479 21.4444444 0.290479 21.4472222 0.290215 21.4500000 0.290479 21.4527778 0.291537 21.4555556 0.291008 21.4583333 0.290479 21.4611111 0.289950 21.4638889 0.289686 21.4666667 0.290479 21.4694444 0.291008 21.4722222 0.291008 21.4750000 0.290744 21.4777778 0.290479 21.4805556 0.290744 21.4833333 0.290479 21.4861111 0.291008 21.4888889 0.291008 21.4916667 0.290479 21.4944444 0.290744 21.4972222 0.290479 21.5000000 0.291008 21.5027778 0.291273 21.5055556 0.291008 21.5083333 0.290744 21.5111111 0.290744 21.5138889 0.290479 21.5166667 0.291802 21.5194444 0.292331 21.5222222 0.292066 21.5250000 0.291273 21.5277778 0.290479 21.5305556 0.290215 21.5333333 0.291008 21.5361111 0.291273 21.5388889 0.291537 21.5416667 0.291008 21.5444444 0.290479 21.5472222 0.291273 21.5500000 0.293653 21.5527778 0.297884 21.5555556 0.302909 21.5583333 0.308463 21.5611111 0.313752 21.5638889 0.319570 21.5666667 0.322744 21.5694444 0.323537 21.5722222 0.321950 21.5750000 0.322744 21.5777778 0.324860 21.5805556 0.326711 21.5833333 0.329355 21.5861111 0.331207 21.5888889 0.332793 21.5916667 0.333851 21.5944444 0.333851 21.5972222 0.335702 21.6000000 0.337025 21.6027778 0.336760 21.6055556 0.335438 21.6083333 0.331207 21.6111111 0.324860 21.6138889 0.317190 21.6166667 0.311901 21.6194444 0.306876 21.6222222 0.299736 21.6250000 0.292331 21.6277778 0.283339 21.6305556 0.274612 21.6333333 0.269851 21.6361111 0.268264 21.6388889 0.268793 21.6416667 0.271174 21.6444444 0.274083 21.6472222 0.274612 21.6500000 0.275934 21.6527778 0.277256 21.6555556 0.279107 21.6583333 0.280430 21.6611111 0.281752 21.6638889 0.282017 21.6666667 0.283339 21.6694444 0.284661 21.6722222 0.284926 21.6750000 0.284132 21.6777778 0.284926 21.6805556 0.284926 21.6833333 0.284926 21.6861111 0.285455 21.6888889 0.284926 21.6916667 0.284132 21.6944444 0.283339 21.6972222 0.283603 21.7000000 0.283868 21.7027778 0.284926 21.7055556 0.283868 21.7083333 0.283868 21.7111111 0.283074 21.7138889 0.282017 21.7166667 0.283074 21.7194444 0.283868 21.7222222 0.283603 21.7250000 0.282810 21.7277778 0.282810 21.7305556 0.281488 21.7333333 0.282545 21.7361111 0.283603 21.7388889 0.283074 21.7416667 0.282810 21.7444444 0.282545 21.7472222 0.282281 21.7500000 0.283074 21.7527778 0.283074 21.7555556 0.283339 21.7583333 0.282810 21.7611111 0.282281 21.7638889 0.282545 21.7666667 0.283074 21.7694444 0.283868 21.7722222 0.283868 21.7750000 0.283868 21.7777778 0.283074 21.7805556 0.283074 21.7833333 0.283868 21.7861111 0.284132 21.7888889 0.284132 21.7916667 0.284397 21.7944444 0.284397 21.7972222 0.284661 21.8000000 0.284132 21.8027778 0.285190 21.8055556 0.284926 21.8083333 0.284926 21.8111111 0.284926 21.8138889 0.285719 21.8166667 0.286248 21.8194444 0.286777 21.8222222 0.285983 21.8250000 0.285983 21.8277778 0.286512 21.8305556 0.286248 21.8333333 0.287306 21.8361111 0.288364 21.8388889 0.289157 21.8416667 0.289157 21.8444444 0.288628 21.8472222 0.288893 21.8500000 0.289157 21.8527778 0.290215 21.8555556 0.290479 21.8583333 0.290744 21.8611111 0.291008 21.8638889 0.290744 21.8666667 0.291537 21.8694444 0.292066 21.8722222 0.292331 21.8750000 0.292595 21.8777778 0.291802 21.8805556 0.292066 21.8833333 0.292860 21.8861111 0.293917 21.8888889 0.294711 21.8916667 0.294446 21.8944444 0.294182 21.8972222 0.293917 21.9030000 0.300000 22.0470000 0.300000 22.0500000 0.296298 22.0527778 0.296033 22.0555556 0.296562 22.0583333 0.297620 22.0611111 0.298149 22.0638889 0.298942 22.0666667 0.299207 22.0694444 0.298413 22.0722222 0.298942 22.0750000 0.299471 22.0777778 0.300264 22.0805556 0.301587 22.0833333 0.302380 22.0861111 0.302380 22.0888889 0.303174 22.0916667 0.304760 22.0944444 0.306347 22.0972222 0.305818 22.1000000 0.305554 22.1027778 0.305554 22.1055556 0.306347 22.1083333 0.307934 22.1111111 0.308463 22.1138889 0.308727 22.1166667 0.308463 22.1194444 0.307934 22.1222222 0.306876 22.1250000 0.305818 22.1277778 0.305025 22.1305556 0.302380 22.1333333 0.300264 22.1361111 0.298413 22.1388889 0.296562 22.1416667 0.294711 22.1444444 0.294446 22.1472222 0.293388 22.1500000 0.293124 22.1527778 0.292860 22.1555556 0.293653 22.1583333 0.293917 22.1611111 0.294446 22.1638889 0.294446 22.1666667 0.293917 22.1694444 0.293917 22.1722222 0.293653 22.1750000 0.293388 22.1777778 0.294446 22.1805556 0.294446 22.1833333 0.294446 22.1861111 0.293388 22.1888889 0.294446 22.1916667 0.295240 22.1944444 0.295240 22.1972222 0.294975 22.2000000 0.294446 22.2027778 0.293388 22.2055556 0.293388 22.2083333 0.294446 22.2111111 0.294711 22.2138889 0.294446 22.2166667 0.294975 22.2194444 0.293917 22.2222222 0.294182 22.2250000 0.294446 22.2277778 0.294446 22.2305556 0.294711 22.2333333 0.294711 22.2361111 0.294446 22.2388889 0.294446 22.2416667 0.294711 22.2444444 0.295240 22.2472222 0.294446 22.2500000 0.293917 22.2527778 0.293388 22.2555556 0.294182 22.2583333 0.297355 22.2611111 0.301851 22.2638889 0.307140 22.2666667 0.314017 22.2694444 0.319570 22.2722222 0.323802 22.2750000 0.325388 22.2777778 0.324595 22.2805556 0.325124 22.2833333 0.328298 22.2861111 0.329884 22.2888889 0.333058 22.2916667 0.335174 22.2944444 0.337025 22.2972222 0.336760 22.3000000 0.337818 22.3027778 0.338347 22.3055556 0.338347 22.3083333 0.336496 22.3111111 0.331207 22.3138889 0.323802 22.3166667 0.316661 22.3194444 0.311107 22.3222222 0.304760 22.3250000 0.297884 22.3277778 0.290215 22.3305556 0.280959 22.3333333 0.274347 22.3361111 0.271174 22.3388889 0.271702 22.3416667 0.275140 22.3444444 0.277785 22.3472222 0.279107 22.3500000 0.279107 22.3527778 0.279901 22.3555556 0.282017 22.3583333 0.284397 22.3611111 0.286777 22.3638889 0.287570 22.3666667 0.288364 22.3694444 0.287306 22.3722222 0.287570 22.3750000 0.287570 22.3777778 0.288364 22.3805556 0.288364 22.3833333 0.287835 22.3861111 0.287041 22.3888889 0.287041 22.3916667 0.288099 22.3944444 0.288364 22.3972222 0.288364 22.4000000 0.287306 22.4027778 0.286512 22.4055556 0.287306 22.4083333 0.287306 22.4111111 0.287835 22.4138889 0.286512 22.4166667 0.285983 22.4194444 0.285983 22.4222222 0.286512 22.4250000 0.286777 22.4277778 0.286777 22.4305556 0.287041 22.4333333 0.286248 22.4361111 0.285455 22.4388889 0.286512 22.4416667 0.286512 22.4444444 0.286777 22.4472222 0.286248 22.4500000 0.285719 22.4527778 0.285719 22.4555556 0.285190 22.4583333 0.285455 22.4611111 0.286248 22.4638889 0.287041 22.4666667 0.287041 22.4694444 0.286512 22.4722222 0.285983 22.4750000 0.286248 22.4777778 0.287306 22.4805556 0.287570 22.4833333 0.286512 22.4861111 0.285983 22.4888889 0.286248 22.4916667 0.287570 22.4944444 0.288099 22.4972222 0.288364 22.5000000 0.287570 22.5027778 0.287306 22.5055556 0.287835 22.5083333 0.287041 22.5111111 0.287570 22.5138889 0.288364 22.5166667 0.288099 22.5194444 0.288099 22.5222222 0.288364 22.5250000 0.288628 22.5277778 0.289157 22.5305556 0.289421 22.5333333 0.289686 22.5361111 0.288628 22.5388889 0.289157 22.5416667 0.290479 22.5444444 0.290744 22.5472222 0.291537 22.5500000 0.291008 22.5527778 0.290215 22.5555556 0.291008 22.5583333 0.291537 22.5611111 0.292595 22.5638889 0.293653 22.5666667 0.292860 22.5694444 0.293124 22.5722222 0.293653 22.5750000 0.294975 22.5777778 0.294711 22.5805556 0.294711 22.5833333 0.294711 22.5861111 0.294711 22.5888889 0.294711 22.5916667 0.295504 22.5944444 0.295769 22.5972222 0.296033 22.6030000 0.300000 22.7470000 0.300000 22.7500000 0.289950 22.7527778 0.290744 22.7555556 0.292066 22.7583333 0.292066 22.7611111 0.292595 22.7638889 0.292860 22.7666667 0.293653 22.7694444 0.294182 22.7722222 0.294975 22.7750000 0.297091 22.7777778 0.298413 22.7805556 0.298413 22.7833333 0.296562 22.7861111 0.295504 22.7888889 0.295504 22.7916667 0.297620 22.7944444 0.299736 22.7972222 0.301322 22.8000000 0.301587 22.8027778 0.299207 22.8055556 0.298678 22.8083333 0.300264 22.8111111 0.302116 22.8138889 0.300529 22.8166667 0.296562 22.8194444 0.292066 22.8222222 0.289421 22.8250000 0.289421 22.8277778 0.288893 22.8305556 0.288099 22.8333333 0.286248 22.8361111 0.285455 22.8388889 0.285455 22.8416667 0.285719 22.8444444 0.283868 22.8472222 0.281752 22.8500000 0.281223 22.8527778 0.280959 22.8555556 0.281223 22.8583333 0.281752 22.8611111 0.283339 22.8638889 0.283868 22.8666667 0.283339 22.8694444 0.282281 22.8722222 0.282281 22.8750000 0.284661 22.8777778 0.286512 22.8805556 0.284926 22.8833333 0.283339 22.8861111 0.281223 22.8888889 0.280165 22.8916667 0.281223 22.8944444 0.282017 22.8972222 0.282017 22.9000000 0.282281 22.9027778 0.283074 22.9055556 0.282281 22.9083333 0.282281 22.9111111 0.282545 22.9138889 0.281752 22.9166667 0.281488 22.9194444 0.280165 22.9222222 0.277256 22.9250000 0.276727 22.9277778 0.278843 22.9305556 0.281752 22.9333333 0.284926 22.9361111 0.286777 22.9388889 0.285455 22.9416667 0.281752 22.9444444 0.279636 22.9472222 0.281223 22.9500000 0.284661 22.9527778 0.285455 22.9555556 0.286777 22.9583333 0.290215 22.9611111 0.294711 22.9638889 0.300529 22.9666667 0.307934 22.9694444 0.313488 22.9722222 0.314281 22.9750000 0.312430 22.9777778 0.313223 22.9805556 0.316926 22.9833333 0.319306 22.9861111 0.320364 22.9888889 0.322215 22.9916667 0.324066 22.9944444 0.324860 22.9972222 0.324595 23.0000000 0.325124 23.0027778 0.327240 23.0055556 0.329091 23.0083333 0.327769 23.0111111 0.321950 23.0138889 0.312165 23.0166667 0.302909 23.0194444 0.295769 23.0222222 0.290215 23.0250000 0.283074 23.0277778 0.276463 23.0305556 0.271174 23.0333333 0.266149 23.0361111 0.261124 23.0388889 0.257157 23.0416667 0.256099 23.0444444 0.258215 23.0472222 0.261388 23.0500000 0.264298 23.0527778 0.266149 23.0555556 0.267207 23.0583333 0.267736 23.0611111 0.269322 23.0638889 0.270380 23.0666667 0.271702 23.0694444 0.272496 23.0722222 0.274083 23.0750000 0.275140 23.0777778 0.274876 23.0805556 0.273554 23.0833333 0.271174 23.0861111 0.270116 23.0888889 0.269851 23.0916667 0.271174 23.0944444 0.272760 23.0972222 0.273289 23.1000000 0.272231 23.1027778 0.271438 23.1055556 0.270645 23.1083333 0.270116 23.1111111 0.271174 23.1138889 0.271702 23.1166667 0.273025 23.1194444 0.273818 23.1222222 0.273025 23.1250000 0.271702 23.1277778 0.270909 23.1305556 0.269851 23.1333333 0.268529 23.1361111 0.268264 23.1388889 0.270645 23.1416667 0.272231 23.1444444 0.271702 23.1472222 0.269851 23.1500000 0.268529 23.1527778 0.269587 23.1555556 0.270116 23.1583333 0.269322 23.1611111 0.268264 23.1638889 0.268000 23.1666667 0.268264 23.1694444 0.267736 23.1722222 0.267736 23.1750000 0.267471 23.1777778 0.268000 23.1805556 0.268793 23.1833333 0.269851 23.1861111 0.270380 23.1888889 0.270909 23.1916667 0.270909 23.1944444 0.271438 23.1972222 0.270909 23.2000000 0.270116 23.2027778 0.269058 23.2055556 0.266413 23.2083333 0.266149 23.2111111 0.267207 23.2138889 0.268793 23.2166667 0.269322 23.2194444 0.270116 23.2222222 0.269851 23.2250000 0.268793 23.2277778 0.268264 23.2305556 0.269322 23.2333333 0.271438 23.2361111 0.274083 23.2388889 0.273554 23.2416667 0.271967 23.2444444 0.271174 23.2472222 0.272231 23.2500000 0.271702 23.2527778 0.270909 23.2555556 0.269851 23.2583333 0.269322 23.2611111 0.270909 23.2638889 0.272496 23.2666667 0.273025 23.2694444 0.273289 23.2722222 0.271967 23.2750000 0.273025 23.2777778 0.272760 23.2805556 0.272496 23.2833333 0.272760 23.2861111 0.272496 23.2888889 0.273025 23.2916667 0.274876 23.2944444 0.277521 23.2972222 0.279901 23.3030000 0.300000 23.4470000 0.300000 23.4500000 0.275405 23.4527778 0.274083 23.4555556 0.272231 23.4583333 0.273289 23.4611111 0.274612 23.4638889 0.275669 23.4666667 0.276727 23.4694444 0.277521 23.4722222 0.276992 23.4750000 0.275934 23.4777778 0.275934 23.4805556 0.275669 23.4833333 0.275669 23.4861111 0.279107 23.4888889 0.283339 23.4916667 0.283868 23.4944444 0.280694 23.4972222 0.279372 23.5000000 0.281752 23.5027778 0.284926 23.5055556 0.287041 23.5083333 0.288364 23.5111111 0.289686 23.5138889 0.291802 23.5166667 0.289950 23.5194444 0.287306 23.5222222 0.286248 23.5250000 0.287041 23.5277778 0.285455 23.5305556 0.282545 23.5333333 0.280165 23.5361111 0.278579 23.5388889 0.276992 23.5416667 0.276463 23.5444444 0.275140 23.5472222 0.274612 23.5500000 0.273818 23.5527778 0.272760 23.5555556 0.271702 23.5583333 0.271967 23.5611111 0.273025 23.5638889 0.274612 23.5666667 0.276198 23.5694444 0.276198 23.5722222 0.273818 23.5750000 0.273818 23.5777778 0.274612 23.5805556 0.274347 23.5833333 0.273289 23.5861111 0.272496 23.5888889 0.273554 23.5916667 0.275669 23.5944444 0.276463 23.5972222 0.276463 23.6000000 0.274612 23.6027778 0.272760 23.6055556 0.271967 23.6083333 0.271702 23.6111111 0.273025 23.6138889 0.274347 23.6166667 0.274347 23.6194444 0.274612 23.6222222 0.275669 23.6250000 0.276727 23.6277778 0.276992 23.6305556 0.276463 23.6333333 0.275669 23.6361111 0.275405 23.6388889 0.276198 23.6416667 0.276198 23.6444444 0.275405 23.6472222 0.274347 23.6500000 0.275405 23.6527778 0.277521 23.6555556 0.281223 23.6583333 0.283339 23.6611111 0.283868 23.6638889 0.287835 23.6666667 0.293124 23.6694444 0.299736 23.6722222 0.306083 23.6750000 0.308992 23.6777778 0.307934 23.6805556 0.305818 23.6833333 0.307140 23.6861111 0.311901 23.6888889 0.314810 23.6916667 0.316397 23.6944444 0.316661 23.6972222 0.316926 23.7000000 0.316397 23.7027778 0.316926 23.7055556 0.317983 23.7083333 0.316926 23.7111111 0.313752 23.7138889 0.306612 23.7166667 0.297091 23.7194444 0.287041 23.7222222 0.276198 23.7250000 0.263504 23.7277778 0.253719 23.7305556 0.249752 23.7333333 0.251074 23.7361111 0.251868 23.7388889 0.250281 23.7416667 0.251074 23.7444444 0.253719 23.7472222 0.257686 23.7500000 0.259537 23.7527778 0.260860 23.7555556 0.262975 23.7583333 0.266413 23.7611111 0.268529 23.7638889 0.269587 23.7666667 0.270116 23.7694444 0.269851 23.7722222 0.270116 23.7750000 0.270380 23.7777778 0.270380 23.7805556 0.274083 23.7833333 0.276992 23.7861111 0.275140 23.7888889 0.269851 23.7916667 0.266413 23.7944444 0.265620 23.7972222 0.268529 23.8000000 0.269587 23.8027778 0.270909 23.8055556 0.272231 23.8083333 0.273025 23.8111111 0.272760 23.8138889 0.272496 23.8166667 0.271967 23.8194444 0.269587 23.8222222 0.267471 23.8250000 0.268793 23.8277778 0.269322 23.8305556 0.269851 23.8333333 0.270380 23.8361111 0.270645 23.8388889 0.271438 23.8416667 0.271702 23.8444444 0.270909 23.8472222 0.269851 23.8500000 0.269058 23.8527778 0.271174 23.8555556 0.273818 23.8583333 0.272760 23.8611111 0.270116 23.8638889 0.268529 23.8666667 0.269058 23.8694444 0.271438 23.8722222 0.272760 23.8750000 0.271438 23.8777778 0.269058 23.8805556 0.268529 23.8833333 0.269058 23.8861111 0.271967 23.8888889 0.274612 23.8916667 0.275405 23.8944444 0.273818 23.8972222 0.273025 23.9000000 0.270645 23.9027778 0.270909 23.9055556 0.270645 23.9083333 0.270909 23.9111111 0.270909 23.9138889 0.272231 23.9166667 0.273289 23.9194444 0.273289 23.9222222 0.271438 23.9250000 0.271174 23.9277778 0.273554 23.9305556 0.275669 23.9333333 0.276727 23.9361111 0.275669 23.9388889 0.274083 23.9416667 0.274347 23.9444444 0.273289 23.9472222 0.273818 23.9500000 0.274083 23.9527778 0.276727 23.9555556 0.277785 23.9583333 0.277785 23.9611111 0.276727 23.9638889 0.275934 23.9666667 0.276198 23.9694444 0.277785 23.9722222 0.279107 23.9750000 0.278843 23.9777778 0.278314 23.9805556 0.278843 23.9833333 0.279901 23.9861111 0.281752 23.9888889 0.281223 23.9916667 0.279636 23.9944444 0.279372 23.9972222 0.280165 24.0030000 0.300000 24.1470000 0.300000 24.1500000 0.284397 24.1527778 0.284132 24.1555556 0.286512 24.1583333 0.288628 24.1611111 0.288628 24.1638889 0.287835 24.1666667 0.288364 24.1694444 0.290215 24.1722222 0.292066 24.1750000 0.291273 24.1777778 0.289421 24.1805556 0.290215 24.1833333 0.291802 24.1861111 0.293653 24.1888889 0.293917 24.1916667 0.294711 24.1944444 0.293917 24.1972222 0.292331 24.2000000 0.291802 24.2027778 0.292860 24.2055556 0.295240 24.2083333 0.298413 24.2111111 0.300793 24.2138889 0.300793 24.2166667 0.300264 24.2194444 0.299736 24.2222222 0.299471 24.2250000 0.300000 24.2277778 0.299736 24.2305556 0.297355 24.2333333 0.294975 24.2361111 0.294446 24.2388889 0.293388 24.2416667 0.291008 24.2444444 0.287835 24.2472222 0.284397 24.2500000 0.281752 24.2527778 0.281488 24.2555556 0.283074 24.2583333 0.283868 24.2611111 0.284397 24.2638889 0.284132 24.2666667 0.285719 24.2694444 0.286512 24.2722222 0.287041 24.2750000 0.286777 24.2777778 0.285455 24.2805556 0.285190 24.2833333 0.285455 24.2861111 0.285719 24.2888889 0.286512 24.2916667 0.286248 24.2944444 0.284661 24.2972222 0.283603 24.3000000 0.284661 24.3027778 0.286512 24.3055556 0.288099 24.3083333 0.289950 24.3111111 0.290215 24.3138889 0.287306 24.3166667 0.284926 24.3194444 0.283603 24.3222222 0.283868 24.3250000 0.284661 24.3277778 0.284661 24.3305556 0.284926 24.3333333 0.285719 24.3361111 0.286248 24.3388889 0.286777 24.3416667 0.286777 24.3444444 0.286777 24.3472222 0.286777 24.3500000 0.286248 24.3527778 0.286512 24.3555556 0.287835 24.3583333 0.290479 24.3611111 0.294446 24.3638889 0.298413 24.3666667 0.302645 24.3694444 0.309785 24.3722222 0.317190 24.3750000 0.322479 24.3777778 0.321950 24.3805556 0.319041 24.3833333 0.317983 24.3861111 0.319306 24.3888889 0.321686 24.3916667 0.325124 24.3944444 0.328826 24.3972222 0.327769 24.4000000 0.325124 24.4027778 0.323802 24.4055556 0.324066 24.4083333 0.324860 24.4111111 0.326182 24.4138889 0.321157 24.4166667 0.310843 24.4194444 0.300000 24.4222222 0.291537 24.4250000 0.284132 24.4277778 0.275669 24.4305556 0.268264 24.4333333 0.264033 24.4361111 0.261653 24.4388889 0.260860 24.4416667 0.261124 24.4444444 0.264562 24.4472222 0.268000 24.4500000 0.270909 24.4527778 0.272231 24.4555556 0.273025 24.4583333 0.273818 24.4611111 0.275405 24.4638889 0.278314 24.4666667 0.278843 24.4694444 0.279372 24.4722222 0.279901 24.4750000 0.279636 24.4777778 0.279636 24.4805556 0.279107 24.4833333 0.279636 24.4861111 0.279107 24.4888889 0.279372 24.4916667 0.280430 24.4944444 0.280694 24.4972222 0.279901 24.5000000 0.278843 24.5027778 0.277785 24.5055556 0.279901 24.5083333 0.281223 24.5111111 0.281752 24.5138889 0.281223 24.5166667 0.279901 24.5194444 0.279636 24.5222222 0.279636 24.5250000 0.279372 24.5277778 0.278579 24.5305556 0.278314 24.5333333 0.278579 24.5361111 0.278843 24.5388889 0.278579 24.5416667 0.278314 24.5444444 0.279107 24.5472222 0.280430 24.5500000 0.280959 24.5527778 0.279372 24.5555556 0.278843 24.5583333 0.278579 24.5611111 0.278314 24.5638889 0.278314 24.5666667 0.279107 24.5694444 0.279372 24.5722222 0.280165 24.5750000 0.282281 24.5777778 0.282545 24.5805556 0.280694 24.5833333 0.277785 24.5861111 0.276463 24.5888889 0.276463 24.5916667 0.277521 24.5944444 0.277256 24.5972222 0.276992 24.6000000 0.276727 24.6027778 0.277521 24.6055556 0.279107 24.6083333 0.280430 24.6111111 0.281488 24.6138889 0.282545 24.6166667 0.282017 24.6194444 0.280694 24.6222222 0.282017 24.6250000 0.281488 24.6277778 0.282810 24.6305556 0.281752 24.6333333 0.280430 24.6361111 0.279901 24.6388889 0.281223 24.6416667 0.282810 24.6444444 0.283339 24.6472222 0.283868 24.6500000 0.284132 24.6527778 0.284661 24.6555556 0.285455 24.6583333 0.286248 24.6611111 0.285455 24.6638889 0.284132 24.6666667 0.282810 24.6694444 0.283868 24.6722222 0.285983 24.6750000 0.287835 24.6777778 0.288893 24.6805556 0.286777 24.6833333 0.285190 24.6861111 0.284397 24.6888889 0.287041 24.6916667 0.290215 24.6944444 0.291273 24.6972222 0.289950 24.7030000 0.300000 24.8470000 0.300000 24.8500000 0.294446 24.8527778 0.294446 24.8555556 0.293653 24.8583333 0.293388 24.8611111 0.293653 24.8638889 0.295504 24.8666667 0.297355 24.8694444 0.298942 24.8722222 0.297091 24.8750000 0.293917 24.8777778 0.292331 24.8805556 0.293124 24.8833333 0.295504 24.8861111 0.296562 24.8888889 0.297091 24.8916667 0.296826 24.8944444 0.297620 24.8972222 0.298413 24.9000000 0.300264 24.9027778 0.301058 24.9055556 0.302380 24.9083333 0.304231 24.9111111 0.304496 24.9138889 0.303967 24.9166667 0.304760 24.9194444 0.304760 24.9222222 0.306083 24.9250000 0.307140 24.9277778 0.307669 24.9305556 0.307669 24.9333333 0.306347 24.9361111 0.304760 24.9388889 0.301587 24.9416667 0.298678 24.9444444 0.295769 24.9472222 0.294182 24.9500000 0.292860 24.9527778 0.291273 24.9555556 0.290744 24.9583333 0.290479 24.9611111 0.291802 24.9638889 0.291273 24.9666667 0.292331 24.9694444 0.292595 24.9722222 0.293653 24.9750000 0.294182 24.9777778 0.292860 24.9805556 0.291273 24.9833333 0.291008 24.9861111 0.290215 24.9888889 0.290215 24.9916667 0.289950 24.9944444 0.289421 24.9972222 0.288628 25.0000000 0.289686 25.0027778 0.291537 25.0055556 0.293653 25.0083333 0.294182 25.0111111 0.292860 25.0138889 0.291008 25.0166667 0.290744 25.0194444 0.292066 25.0222222 0.290479 25.0250000 0.290479 25.0277778 0.291273 25.0305556 0.291273 25.0333333 0.291802 25.0361111 0.293124 25.0388889 0.294182 25.0416667 0.292595 25.0444444 0.290215 25.0472222 0.289157 25.0500000 0.291273 25.0527778 0.294446 25.0555556 0.295504 25.0583333 0.296298 25.0611111 0.297355 25.0638889 0.302116 25.0666667 0.308727 25.0694444 0.316132 25.0722222 0.322744 25.0750000 0.327240 25.0777778 0.328033 25.0805556 0.325124 25.0833333 0.325653 25.0861111 0.329355 25.0888889 0.332000 25.0916667 0.335438 25.0944444 0.338347 25.0972222 0.338083 25.1000000 0.339140 25.1027778 0.340727 25.1055556 0.340463 25.1083333 0.338612 25.1111111 0.333587 25.1138889 0.324860 25.1166667 0.315603 25.1194444 0.307405 25.1222222 0.298942 25.1250000 0.290215 25.1277778 0.281752 25.1305556 0.274347 25.1333333 0.269058 25.1361111 0.266942 25.1388889 0.268264 25.1416667 0.273025 25.1444444 0.276992 25.1472222 0.279372 25.1500000 0.279901 25.1527778 0.281223 25.1555556 0.282545 25.1583333 0.284132 25.1611111 0.286777 25.1638889 0.287041 25.1666667 0.287306 25.1694444 0.285983 25.1722222 0.285455 25.1750000 0.285719 25.1777778 0.285983 25.1805556 0.287041 25.1833333 0.286777 25.1861111 0.285983 25.1888889 0.285983 25.1916667 0.285983 25.1944444 0.285719 25.1972222 0.284397 25.2000000 0.284661 25.2027778 0.285190 25.2055556 0.285190 25.2083333 0.285455 25.2111111 0.284397 25.2138889 0.284397 25.2166667 0.284926 25.2194444 0.286248 25.2222222 0.285983 25.2250000 0.285455 25.2277778 0.284397 25.2305556 0.284132 25.2333333 0.284661 25.2361111 0.285190 25.2388889 0.284661 25.2416667 0.284661 25.2444444 0.284926 25.2472222 0.284397 25.2500000 0.284661 25.2527778 0.284926 25.2555556 0.285719 25.2583333 0.286248 25.2611111 0.285455 25.2638889 0.284661 25.2666667 0.285719 25.2694444 0.287041 25.2722222 0.286512 25.2750000 0.285455 25.2777778 0.285719 25.2805556 0.285719 25.2833333 0.285983 25.2861111 0.285983 25.2888889 0.285983 25.2916667 0.286248 25.2944444 0.285719 25.2972222 0.285983 25.3000000 0.286512 25.3027778 0.287835 25.3055556 0.288364 25.3083333 0.288628 25.3111111 0.287835 25.3138889 0.286777 25.3166667 0.287570 25.3194444 0.289157 25.3222222 0.289950 25.3250000 0.289950 25.3277778 0.289157 25.3305556 0.289157 25.3333333 0.290479 25.3361111 0.291008 25.3388889 0.290744 25.3416667 0.290479 25.3444444 0.289950 25.3472222 0.289950 25.3500000 0.291273 25.3527778 0.291273 25.3555556 0.292066 25.3583333 0.292066 25.3611111 0.292331 25.3638889 0.292595 25.3666667 0.293653 25.3694444 0.294975 25.3722222 0.295769 25.3750000 0.295769 25.3777778 0.295769 25.3805556 0.295769 25.3833333 0.296033 25.3861111 0.297091 25.3888889 0.297355 25.3916667 0.297620 25.3944444 0.296826 25.3972222 0.296562 25.4030000 0.300000 25.5470000 0.300000 25.5500000 0.303702 25.5527778 0.303967 25.5555556 0.303702 25.5583333 0.304231 25.5611111 0.305025 25.5638889 0.306612 25.5666667 0.307934 25.5694444 0.307934 25.5722222 0.307669 25.5750000 0.307669 25.5777778 0.308198 25.5805556 0.310314 25.5833333 0.311107 25.5861111 0.310843 25.5888889 0.311107 25.5916667 0.310314 25.5944444 0.311372 25.5972222 0.313488 25.6000000 0.314810 25.6027778 0.315339 25.6055556 0.315339 25.6083333 0.314017 25.6111111 0.311636 25.6138889 0.309785 25.6166667 0.308992 25.6194444 0.307140 25.6222222 0.304760 25.6250000 0.303174 25.6277778 0.302116 25.6305556 0.300000 25.6333333 0.300264 25.6361111 0.300264 25.6388889 0.300264 25.6416667 0.299736 25.6444444 0.299736 25.6472222 0.300264 25.6500000 0.300000 25.6527778 0.299207 25.6555556 0.299207 25.6583333 0.299471 25.6611111 0.299471 25.6638889 0.300264 25.6666667 0.299736 25.6694444 0.299207 25.6722222 0.299736 25.6750000 0.298942 25.6777778 0.298942 25.6805556 0.299736 25.6833333 0.299736 25.6861111 0.299736 25.6888889 0.300000 25.6916667 0.299471 25.6944444 0.298942 25.6972222 0.299471 25.7000000 0.300000 25.7027778 0.299736 25.7055556 0.300000 25.7083333 0.300529 25.7111111 0.300793 25.7138889 0.301058 25.7166667 0.300793 25.7194444 0.301058 25.7222222 0.301322 25.7250000 0.300529 25.7277778 0.300264 25.7305556 0.300264 25.7333333 0.300529 25.7361111 0.300793 25.7388889 0.300793 25.7416667 0.300264 25.7444444 0.301851 25.7472222 0.304760 25.7500000 0.310050 25.7527778 0.315074 25.7555556 0.321157 25.7583333 0.327769 25.7611111 0.333322 25.7638889 0.336760 25.7666667 0.336496 25.7694444 0.334645 25.7722222 0.335967 25.7750000 0.338083 25.7777778 0.339669 25.7805556 0.340992 25.7833333 0.342579 25.7861111 0.344430 25.7888889 0.344430 25.7916667 0.344959 25.7944444 0.347868 25.7972222 0.351570 25.8000000 0.353157 25.8027778 0.351306 25.8055556 0.349719 25.8083333 0.344694 25.8111111 0.335702 25.8138889 0.327769 25.8166667 0.321950 25.8194444 0.315603 25.8222222 0.307934 25.8250000 0.300529 25.8277778 0.292066 25.8305556 0.285455 25.8333333 0.279636 25.8361111 0.277256 25.8388889 0.279372 25.8416667 0.281223 25.8444444 0.283074 25.8472222 0.284132 25.8500000 0.285983 25.8527778 0.287306 25.8555556 0.288628 25.8583333 0.290215 25.8611111 0.290744 25.8638889 0.291802 25.8666667 0.292331 25.8694444 0.292595 25.8722222 0.292595 25.8750000 0.291537 25.8777778 0.291008 25.8805556 0.292066 25.8833333 0.292860 25.8861111 0.293917 25.8888889 0.293124 25.8916667 0.292860 25.8944444 0.292331 25.8972222 0.292331 25.9000000 0.293124 25.9027778 0.292595 25.9055556 0.292331 25.9083333 0.291273 25.9111111 0.291273 25.9138889 0.292066 25.9166667 0.292595 25.9194444 0.292331 25.9222222 0.291802 25.9250000 0.291537 25.9277778 0.291008 25.9305556 0.291537 25.9333333 0.292595 25.9361111 0.291537 25.9388889 0.290744 25.9416667 0.290215 25.9444444 0.290479 25.9472222 0.291537 25.9500000 0.292331 25.9527778 0.291802 25.9555556 0.291802 25.9583333 0.291802 25.9611111 0.291008 25.9638889 0.291273 25.9666667 0.292066 25.9694444 0.291802 25.9722222 0.291802 25.9750000 0.291537 25.9777778 0.291273 25.9805556 0.290744 25.9833333 0.291537 25.9861111 0.291273 25.9888889 0.291537 25.9916667 0.291802 25.9944444 0.291537 25.9972222 0.291273 26.0000000 0.291537 26.0027778 0.292331 26.0055556 0.292595 26.0083333 0.292331 26.0111111 0.292066 26.0138889 0.292860 26.0166667 0.293388 26.0194444 0.293917 26.0222222 0.293653 26.0250000 0.293124 26.0277778 0.293653 26.0305556 0.294182 26.0333333 0.294975 26.0361111 0.294975 26.0388889 0.294975 26.0416667 0.294975 26.0444444 0.294711 26.0472222 0.295240 26.0500000 0.296033 26.0527778 0.296298 26.0555556 0.296298 26.0583333 0.296298 26.0611111 0.295769 26.0638889 0.297091 26.0666667 0.298149 26.0694444 0.298678 26.0722222 0.298413 26.0750000 0.298413 26.0777778 0.298678 26.0805556 0.299471 26.0833333 0.300000 26.0861111 0.300000 26.0888889 0.300793 26.0916667 0.301058 26.0944444 0.300793 26.0972222 0.301058 26.1030000 0.300000 26.2470000 0.300000 26.2500000 0.303967 26.2527778 0.305289 26.2555556 0.305289 26.2583333 0.305818 26.2611111 0.305818 26.2638889 0.305818 26.2666667 0.306083 26.2694444 0.306612 26.2722222 0.307669 26.2750000 0.308463 26.2777778 0.308463 26.2805556 0.308463 26.2833333 0.308992 26.2861111 0.310050 26.2888889 0.310579 26.2916667 0.311372 26.2944444 0.311372 26.2972222 0.310579 26.3000000 0.311372 26.3027778 0.313752 26.3055556 0.314017 26.3083333 0.313752 26.3111111 0.313488 26.3138889 0.312165 26.3166667 0.311372 26.3194444 0.310050 26.3222222 0.307669 26.3250000 0.305818 26.3277778 0.303438 26.3305556 0.301851 26.3333333 0.300529 26.3361111 0.299471 26.3388889 0.297884 26.3416667 0.297091 26.3444444 0.297620 26.3472222 0.298678 26.3500000 0.300264 26.3527778 0.300529 26.3555556 0.299736 26.3583333 0.298149 26.3611111 0.297884 26.3638889 0.297091 26.3666667 0.297355 26.3694444 0.297355 26.3722222 0.297884 26.3750000 0.297620 26.3777778 0.298413 26.3805556 0.299207 26.3833333 0.299471 26.3861111 0.299471 26.3888889 0.298942 26.3916667 0.298678 26.3944444 0.298413 26.3972222 0.298149 26.4000000 0.297620 26.4027778 0.298149 26.4055556 0.298942 26.4083333 0.298678 26.4111111 0.298149 26.4138889 0.298678 26.4166667 0.299207 26.4194444 0.299736 26.4222222 0.298678 26.4250000 0.299207 26.4277778 0.298942 26.4305556 0.298942 26.4333333 0.298413 26.4361111 0.298942 26.4388889 0.298678 26.4416667 0.298678 26.4444444 0.297884 26.4472222 0.298149 26.4500000 0.298942 26.4527778 0.299471 26.4555556 0.302645 26.4583333 0.306083 26.4611111 0.312165 26.4638889 0.318777 26.4666667 0.327240 26.4694444 0.333058 26.4722222 0.334909 26.4750000 0.333587 26.4777778 0.333587 26.4805556 0.336231 26.4833333 0.338876 26.4861111 0.340992 26.4888889 0.342314 26.4916667 0.342579 26.4944444 0.343372 26.4972222 0.345223 26.5000000 0.347339 26.5027778 0.349190 26.5055556 0.348397 26.5083333 0.346545 26.5111111 0.340727 26.5138889 0.333587 26.5166667 0.325917 26.5194444 0.318777 26.5222222 0.312430 26.5250000 0.304760 26.5277778 0.296826 26.5305556 0.288099 26.5333333 0.280959 26.5361111 0.276992 26.5388889 0.275140 26.5416667 0.277785 26.5444444 0.279901 26.5472222 0.280165 26.5500000 0.280959 26.5527778 0.283074 26.5555556 0.284132 26.5583333 0.285455 26.5611111 0.287306 26.5638889 0.287835 26.5666667 0.288628 26.5694444 0.289686 26.5722222 0.288364 26.5750000 0.287835 26.5777778 0.288628 26.5805556 0.288628 26.5833333 0.289421 26.5861111 0.289686 26.5888889 0.289157 26.5916667 0.288628 26.5944444 0.287570 26.5972222 0.287570 26.6000000 0.288364 26.6027778 0.289157 26.6055556 0.289950 26.6083333 0.288628 26.6111111 0.288099 26.6138889 0.288099 26.6166667 0.288099 26.6194444 0.288628 26.6222222 0.287835 26.6250000 0.286777 26.6277778 0.286248 26.6305556 0.286248 26.6333333 0.286512 26.6361111 0.287041 26.6388889 0.287041 26.6416667 0.286777 26.6444444 0.286512 26.6472222 0.285983 26.6500000 0.286512 26.6527778 0.286777 26.6555556 0.287306 26.6583333 0.286248 26.6611111 0.285455 26.6638889 0.285719 26.6666667 0.286777 26.6694444 0.286777 26.6722222 0.286777 26.6750000 0.285190 26.6777778 0.285455 26.6805556 0.285455 26.6833333 0.286512 26.6861111 0.287041 26.6888889 0.286777 26.6916667 0.286512 26.6944444 0.285719 26.6972222 0.285719 26.7000000 0.285719 26.7027778 0.287041 26.7055556 0.287835 26.7083333 0.288099 26.7111111 0.288364 26.7138889 0.287835 26.7166667 0.288099 26.7194444 0.288628 26.7222222 0.287570 26.7250000 0.287835 26.7277778 0.288099 26.7305556 0.288628 26.7333333 0.288628 26.7361111 0.290215 26.7388889 0.289950 26.7416667 0.289950 26.7444444 0.290479 26.7472222 0.289421 26.7500000 0.289686 26.7527778 0.290744 26.7555556 0.291273 26.7583333 0.291537 26.7611111 0.291537 26.7638889 0.291537 26.7666667 0.292066 26.7694444 0.292595 26.7722222 0.292860 26.7750000 0.292331 26.7777778 0.292066 26.7805556 0.293124 26.7833333 0.294711 26.7861111 0.295240 26.7888889 0.294975 26.7916667 0.294975 26.7944444 0.294711 26.7972222 0.295240 26.8030000 0.300000 26.9470000 0.300000 26.9500000 0.299207 26.9527778 0.299207 26.9555556 0.299736 26.9583333 0.300529 26.9611111 0.301058 26.9638889 0.301058 26.9666667 0.302645 26.9694444 0.302645 26.9722222 0.303702 26.9750000 0.305554 26.9777778 0.305289 26.9805556 0.305289 26.9833333 0.305289 26.9861111 0.306347 26.9888889 0.307140 26.9916667 0.307140 26.9944444 0.307934 26.9972222 0.308198 27.0000000 0.309521 27.0027778 0.310050 27.0055556 0.310579 27.0083333 0.310843 27.0111111 0.310579 27.0138889 0.310050 27.0166667 0.308198 27.0194444 0.305289 27.0222222 0.303967 27.0250000 0.303438 27.0277778 0.301322 27.0305556 0.300000 27.0333333 0.297620 27.0361111 0.295504 27.0388889 0.295240 27.0416667 0.295769 27.0444444 0.295769 27.0472222 0.295769 27.0500000 0.295504 27.0527778 0.295504 27.0555556 0.296033 27.0583333 0.296298 27.0611111 0.295769 27.0638889 0.296033 27.0666667 0.296033 27.0694444 0.295769 27.0722222 0.296298 27.0750000 0.296298 27.0777778 0.294975 27.0805556 0.295240 27.0833333 0.294975 27.0861111 0.295769 27.0888889 0.295769 27.0916667 0.296562 27.0944444 0.296562 27.0972222 0.296298 27.1000000 0.295504 27.1027778 0.294975 27.1055556 0.296033 27.1083333 0.296298 27.1111111 0.297091 27.1138889 0.296562 27.1166667 0.296033 27.1194444 0.295769 27.1222222 0.296298 27.1250000 0.296298 27.1277778 0.296033 27.1305556 0.295769 27.1333333 0.295769 27.1361111 0.296562 27.1388889 0.296562 27.1416667 0.296562 27.1444444 0.296562 27.1472222 0.296826 27.1500000 0.297620 27.1527778 0.300000 27.1555556 0.303967 27.1583333 0.310050 27.1611111 0.315603 27.1638889 0.323008 27.1666667 0.329620 27.1694444 0.332793 27.1722222 0.333058 27.1750000 0.332264 27.1777778 0.333851 27.1805556 0.336231 27.1833333 0.337554 27.1861111 0.339140 27.1888889 0.340727 27.1916667 0.342579 27.1944444 0.343901 27.1972222 0.346017 27.2000000 0.347074 27.2027778 0.346810 27.2055556 0.345752 27.2083333 0.343107 27.2111111 0.336760 27.2138889 0.327769 27.2166667 0.319306 27.2194444 0.312430 27.2222222 0.306347 27.2250000 0.299471 27.2277778 0.291008 27.2305556 0.283339 27.2333333 0.276463 27.2361111 0.272496 27.2388889 0.273554 27.2416667 0.276992 27.2444444 0.278579 27.2472222 0.279107 27.2500000 0.280165 27.2527778 0.280959 27.2555556 0.283339 27.2583333 0.286512 27.2611111 0.287041 27.2638889 0.287570 27.2666667 0.288364 27.2694444 0.288364 27.2722222 0.288628 27.2750000 0.289157 27.2777778 0.288628 27.2805556 0.288628 27.2833333 0.288364 27.2861111 0.287835 27.2888889 0.288099 27.2916667 0.288099 27.2944444 0.287041 27.2972222 0.286248 27.3000000 0.285719 27.3027778 0.285719 27.3055556 0.287041 27.3083333 0.287306 27.3111111 0.287570 27.3138889 0.286777 27.3166667 0.285983 27.3194444 0.285983 27.3222222 0.286248 27.3250000 0.287041 27.3277778 0.286248 27.3305556 0.285719 27.3333333 0.285455 27.3361111 0.285719 27.3388889 0.285983 27.3416667 0.286248 27.3444444 0.286512 27.3472222 0.285455 27.3500000 0.284397 27.3527778 0.284926 27.3555556 0.285190 27.3583333 0.285190 27.3611111 0.284926 27.3638889 0.284926 27.3666667 0.285455 27.3694444 0.285719 27.3722222 0.285455 27.3750000 0.286248 27.3777778 0.286248 27.3805556 0.286248 27.3833333 0.285719 27.3861111 0.285983 27.3888889 0.286248 27.3916667 0.287041 27.3944444 0.287041 27.3972222 0.286512 27.4000000 0.286248 27.4027778 0.285455 27.4055556 0.286248 27.4083333 0.286777 27.4111111 0.286777 27.4138889 0.287041 27.4166667 0.287570 27.4194444 0.287570 27.4222222 0.288099 27.4250000 0.288628 27.4277778 0.289157 27.4305556 0.288628 27.4333333 0.288893 27.4361111 0.289421 27.4388889 0.290215 27.4416667 0.290744 27.4444444 0.290744 27.4472222 0.291008 27.4500000 0.290744 27.4527778 0.291273 27.4555556 0.292331 27.4583333 0.293388 27.4611111 0.292860 27.4638889 0.293124 27.4666667 0.292595 27.4694444 0.293917 27.4722222 0.294182 27.4750000 0.294711 27.4777778 0.294711 27.4805556 0.294446 27.4833333 0.294711 27.4861111 0.294975 27.4888889 0.295240 27.4916667 0.296562 27.4944444 0.296562 27.4972222 0.296562 27.5030000 0.300000 27.6470000 0.300000 27.6500000 0.293653 27.6527778 0.293917 27.6555556 0.294446 27.6583333 0.294975 27.6611111 0.295769 27.6638889 0.296033 27.6666667 0.295769 27.6694444 0.297091 27.6722222 0.296298 27.6750000 0.296826 27.6777778 0.297091 27.6805556 0.296298 27.6833333 0.297355 27.6861111 0.298149 27.6888889 0.299736 27.6916667 0.301058 27.6944444 0.302380 27.6972222 0.302645 27.7000000 0.301851 27.7027778 0.302380 27.7055556 0.302645 27.7083333 0.303174 27.7111111 0.303967 27.7138889 0.304496 27.7166667 0.304496 27.7194444 0.305554 27.7222222 0.306083 27.7250000 0.306347 27.7277778 0.305818 27.7305556 0.303967 27.7333333 0.302116 27.7361111 0.300264 27.7388889 0.298678 27.7416667 0.297884 27.7444444 0.295504 27.7472222 0.293917 27.7500000 0.292066 27.7527778 0.290479 27.7555556 0.290744 27.7583333 0.291273 27.7611111 0.291802 27.7638889 0.290744 27.7666667 0.289950 27.7694444 0.289686 27.7722222 0.290744 27.7750000 0.291802 27.7777778 0.291008 27.7805556 0.290215 27.7833333 0.290744 27.7861111 0.289686 27.7888889 0.289686 27.7916667 0.290215 27.7944444 0.290479 27.7972222 0.291008 27.8000000 0.291008 27.8027778 0.291008 27.8055556 0.291537 27.8083333 0.291537 27.8111111 0.291273 27.8138889 0.290479 27.8166667 0.289950 27.8194444 0.290479 27.8222222 0.291008 27.8250000 0.291273 27.8277778 0.292066 27.8305556 0.291537 27.8333333 0.290479 27.8361111 0.290215 27.8388889 0.291008 27.8416667 0.291537 27.8444444 0.291008 27.8472222 0.289421 27.8500000 0.289421 27.8527778 0.289421 27.8555556 0.291273 27.8583333 0.293653 27.8611111 0.297355 27.8638889 0.301851 27.8666667 0.307669 27.8694444 0.315603 27.8722222 0.324331 27.8750000 0.329884 27.8777778 0.329884 27.8805556 0.327769 27.8833333 0.328298 27.8861111 0.331471 27.8888889 0.334116 27.8916667 0.336760 27.8944444 0.337818 27.8972222 0.338612 27.9000000 0.339669 27.9027778 0.341521 27.9055556 0.342579 27.9083333 0.340992 27.9111111 0.338083 27.9138889 0.330413 27.9166667 0.320364 27.9194444 0.310843 27.9222222 0.302909 27.9250000 0.294446 27.9277778 0.285719 27.9305556 0.275669 27.9333333 0.267471 27.9361111 0.264033 27.9388889 0.266413 27.9416667 0.270645 27.9444444 0.273025 27.9472222 0.273554 27.9500000 0.273289 27.9527778 0.273818 27.9555556 0.276727 27.9583333 0.278579 27.9611111 0.279372 27.9638889 0.279636 27.9666667 0.280694 27.9694444 0.281488 27.9722222 0.281752 27.9750000 0.281488 27.9777778 0.280694 27.9805556 0.280165 27.9833333 0.279372 27.9861111 0.278050 27.9888889 0.278314 27.9916667 0.279636 27.9944444 0.279901 27.9972222 0.279372 28.0000000 0.278579 28.0027778 0.278314 28.0055556 0.279107 28.0083333 0.278843 28.0111111 0.277521 28.0138889 0.276992 28.0166667 0.275405 28.0194444 0.275140 28.0222222 0.276463 28.0250000 0.276727 28.0277778 0.276992 28.0305556 0.276727 28.0333333 0.276463 28.0361111 0.276463 28.0388889 0.276198 28.0416667 0.276198 28.0444444 0.276198 28.0472222 0.276463 28.0500000 0.275405 28.0527778 0.275669 28.0555556 0.275934 28.0583333 0.276198 28.0611111 0.275669 28.0638889 0.275934 28.0666667 0.275934 28.0694444 0.276198 28.0722222 0.276727 28.0750000 0.276727 28.0777778 0.276727 28.0805556 0.275934 28.0833333 0.275669 28.0861111 0.276992 28.0888889 0.276992 28.0916667 0.277521 28.0944444 0.277785 28.0972222 0.276992 28.1000000 0.276463 28.1027778 0.276992 28.1055556 0.278050 28.1083333 0.279107 28.1111111 0.279372 28.1138889 0.279107 28.1166667 0.278843 28.1194444 0.278843 28.1222222 0.279107 28.1250000 0.280165 28.1277778 0.281223 28.1305556 0.280694 28.1333333 0.280165 28.1361111 0.280430 28.1388889 0.282017 28.1416667 0.282281 28.1444444 0.283074 28.1472222 0.282545 28.1500000 0.281488 28.1527778 0.281752 28.1555556 0.282810 28.1583333 0.284132 28.1611111 0.284661 28.1638889 0.285455 28.1666667 0.284926 28.1694444 0.285455 28.1722222 0.285983 28.1750000 0.287041 28.1777778 0.287306 28.1805556 0.286512 28.1833333 0.285983 28.1861111 0.286512 28.1888889 0.287306 28.1916667 0.288364 28.1944444 0.288099 28.1972222 0.287835 28.2030000 0.300000 28.3470000 0.300000 28.3500000 0.287570 28.3527778 0.288364 28.3555556 0.288628 28.3583333 0.288364 28.3611111 0.288099 28.3638889 0.288099 28.3666667 0.288364 28.3694444 0.288893 28.3722222 0.289157 28.3750000 0.289686 28.3777778 0.289686 28.3805556 0.289421 28.3833333 0.290479 28.3861111 0.291008 28.3888889 0.292066 28.3916667 0.293124 28.3944444 0.292331 28.3972222 0.291802 28.4000000 0.292595 28.4027778 0.293917 28.4055556 0.295504 28.4083333 0.296298 28.4111111 0.296562 28.4138889 0.296826 28.4166667 0.297355 28.4194444 0.297355 28.4222222 0.298149 28.4250000 0.298149 28.4277778 0.298678 28.4305556 0.298942 28.4333333 0.300793 28.4361111 0.301587 28.4388889 0.301851 28.4416667 0.300000 28.4444444 0.297884 28.4472222 0.295504 28.4500000 0.294182 28.4527778 0.292331 28.4555556 0.290744 28.4583333 0.288364 28.4611111 0.285455 28.4638889 0.284926 28.4666667 0.285455 28.4694444 0.286512 28.4722222 0.287041 28.4750000 0.287041 28.4777778 0.286248 28.4805556 0.285983 28.4833333 0.286512 28.4861111 0.287041 28.4888889 0.286777 28.4916667 0.286512 28.4944444 0.286512 28.4972222 0.285719 28.5000000 0.285719 28.5027778 0.286777 28.5055556 0.287306 28.5083333 0.287570 28.5111111 0.287041 28.5138889 0.285719 28.5166667 0.286248 28.5194444 0.286248 28.5222222 0.287041 28.5250000 0.287306 28.5277778 0.286777 28.5305556 0.286777 28.5333333 0.286512 28.5361111 0.287835 28.5388889 0.288099 28.5416667 0.287835 28.5444444 0.287570 28.5472222 0.286248 28.5500000 0.286248 28.5527778 0.286512 28.5555556 0.286777 28.5583333 0.288099 28.5611111 0.289950 28.5638889 0.294711 28.5666667 0.301058 28.5694444 0.308992 28.5722222 0.317190 28.5750000 0.323273 28.5777778 0.323273 28.5805556 0.321421 28.5833333 0.323008 28.5861111 0.325917 28.5888889 0.328298 28.5916667 0.329884 28.5944444 0.330678 28.5972222 0.330678 28.6000000 0.332793 28.6027778 0.335174 28.6055556 0.335702 28.6083333 0.334380 28.6111111 0.329620 28.6138889 0.321950 28.6166667 0.311901 28.6194444 0.304231 28.6222222 0.296826 28.6250000 0.288628 28.6277778 0.279901 28.6305556 0.270909 28.6333333 0.265091 28.6361111 0.264298 28.6388889 0.268000 28.6416667 0.270116 28.6444444 0.271967 28.6472222 0.272760 28.6500000 0.273025 28.6527778 0.275669 28.6555556 0.278314 28.6583333 0.279636 28.6611111 0.279901 28.6638889 0.279636 28.6666667 0.279901 28.6694444 0.280430 28.6722222 0.280959 28.6750000 0.280959 28.6777778 0.280430 28.6805556 0.280165 28.6833333 0.279636 28.6861111 0.279901 28.6888889 0.281223 28.6916667 0.280165 28.6944444 0.279901 28.6972222 0.279372 28.7000000 0.279107 28.7027778 0.279636 28.7055556 0.279901 28.7083333 0.279901 28.7111111 0.279636 28.7138889 0.279107 28.7166667 0.279372 28.7194444 0.279901 28.7222222 0.280165 28.7250000 0.280430 28.7277778 0.279901 28.7305556 0.278843 28.7333333 0.278843 28.7361111 0.278579 28.7388889 0.280165 28.7416667 0.279901 28.7444444 0.279636 28.7472222 0.279636 28.7500000 0.279372 28.7527778 0.279636 28.7555556 0.279901 28.7583333 0.280694 28.7611111 0.280694 28.7638889 0.279901 28.7666667 0.279636 28.7694444 0.280430 28.7722222 0.280430 28.7750000 0.280430 28.7777778 0.279636 28.7805556 0.279901 28.7833333 0.280165 28.7861111 0.280430 28.7888889 0.280959 28.7916667 0.281223 28.7944444 0.282017 28.7972222 0.281488 28.8000000 0.282281 28.8027778 0.282281 28.8055556 0.282810 28.8083333 0.282281 28.8111111 0.282545 28.8138889 0.282281 28.8166667 0.282545 28.8194444 0.283339 28.8222222 0.283603 28.8250000 0.283868 28.8277778 0.283603 28.8305556 0.283339 28.8333333 0.283074 28.8361111 0.284132 28.8388889 0.285190 28.8416667 0.285983 28.8444444 0.285983 28.8472222 0.285455 28.8500000 0.285983 28.8527778 0.287041 28.8555556 0.287570 28.8583333 0.287306 28.8611111 0.287570 28.8638889 0.286777 28.8666667 0.287835 28.8694444 0.288628 28.8722222 0.288628 28.8750000 0.289157 28.8777778 0.289421 28.8805556 0.288893 28.8833333 0.289157 28.8861111 0.289157 28.8888889 0.290215 28.8916667 0.290744 28.8944444 0.290744 28.8972222 0.289950 28.9030000 0.300000 29.0470000 0.300000 29.0500000 0.288099 29.0527778 0.287835 29.0555556 0.287835 29.0583333 0.289157 29.0611111 0.289686 29.0638889 0.291008 29.0666667 0.291008 29.0694444 0.290479 29.0722222 0.290479 29.0750000 0.291537 29.0777778 0.291537 29.0805556 0.292331 29.0833333 0.292595 29.0861111 0.292860 29.0888889 0.293124 29.0916667 0.294446 29.0944444 0.295240 29.0972222 0.296562 29.1000000 0.296298 29.1027778 0.296033 29.1055556 0.296033 29.1083333 0.296298 29.1111111 0.297884 29.1138889 0.298413 29.1166667 0.298678 29.1194444 0.298942 29.1222222 0.298413 29.1250000 0.298678 29.1277778 0.298149 29.1305556 0.296562 29.1333333 0.293917 29.1361111 0.291008 29.1388889 0.289421 29.1416667 0.287835 29.1444444 0.286777 29.1472222 0.285190 29.1500000 0.283603 29.1527778 0.283339 29.1555556 0.283339 29.1583333 0.284661 29.1611111 0.284661 29.1638889 0.284926 29.1666667 0.285190 29.1694444 0.284661 29.1722222 0.283868 29.1750000 0.283868 29.1777778 0.284926 29.1805556 0.284926 29.1833333 0.284132 29.1861111 0.283868 29.1888889 0.283339 29.1916667 0.283868 29.1944444 0.283339 29.1972222 0.284661 29.2000000 0.284132 29.2027778 0.284397 29.2055556 0.283868 29.2083333 0.283603 29.2111111 0.284132 29.2138889 0.285190 29.2166667 0.284926 29.2194444 0.284926 29.2222222 0.283868 29.2250000 0.284926 29.2277778 0.285190 29.2305556 0.285719 29.2333333 0.285983 29.2361111 0.284661 29.2388889 0.284132 29.2416667 0.284132 29.2444444 0.284926 29.2472222 0.285719 29.2500000 0.285190 29.2527778 0.285190 29.2555556 0.285190 29.2583333 0.288364 29.2611111 0.293388 29.2638889 0.299207 29.2666667 0.306083 29.2694444 0.313488 29.2722222 0.319041 29.2750000 0.321157 29.2777778 0.320364 29.2805556 0.320893 29.2833333 0.323273 29.2861111 0.324860 29.2888889 0.325388 29.2916667 0.326975 29.2944444 0.328562 29.2972222 0.329884 29.3000000 0.330942 29.3027778 0.332529 29.3055556 0.332529 29.3083333 0.330942 29.3111111 0.328033 29.3138889 0.322215 29.3166667 0.313223 29.3194444 0.305554 29.3222222 0.298942 29.3250000 0.292860 29.3277778 0.286512 29.3305556 0.278579 29.3333333 0.270909 29.3361111 0.264562 29.3388889 0.261388 29.3416667 0.262446 29.3444444 0.265884 29.3472222 0.267471 29.3500000 0.268793 29.3527778 0.268529 29.3555556 0.269058 29.3583333 0.271438 29.3611111 0.274083 29.3638889 0.275405 29.3666667 0.275669 29.3694444 0.275934 29.3722222 0.275934 29.3750000 0.276198 29.3777778 0.276198 29.3805556 0.276463 29.3833333 0.276198 29.3861111 0.276463 29.3888889 0.275669 29.3916667 0.275140 29.3944444 0.275405 29.3972222 0.275934 29.4000000 0.275140 29.4027778 0.275140 29.4055556 0.274876 29.4083333 0.274876 29.4111111 0.274612 29.4138889 0.275405 29.4166667 0.274876 29.4194444 0.274876 29.4222222 0.274612 29.4250000 0.273818 29.4277778 0.273818 29.4305556 0.274347 29.4333333 0.274083 29.4361111 0.273818 29.4388889 0.272760 29.4416667 0.273554 29.4444444 0.274347 29.4472222 0.274347 29.4500000 0.274083 29.4527778 0.273025 29.4555556 0.273289 29.4583333 0.273818 29.4611111 0.273554 29.4638889 0.273289 29.4666667 0.273818 29.4694444 0.273025 29.4722222 0.273025 29.4750000 0.273554 29.4777778 0.274347 29.4805556 0.274876 29.4833333 0.274347 29.4861111 0.273818 29.4888889 0.274083 29.4916667 0.275140 29.4944444 0.276198 29.4972222 0.275669 29.5000000 0.275405 29.5027778 0.275669 29.5055556 0.274876 29.5083333 0.275140 29.5111111 0.275669 29.5138889 0.276198 29.5166667 0.276198 29.5194444 0.276198 29.5222222 0.275405 29.5250000 0.275934 29.5277778 0.276992 29.5305556 0.277521 29.5333333 0.277785 29.5361111 0.277256 29.5388889 0.276992 29.5416667 0.277256 29.5444444 0.278050 29.5472222 0.278843 29.5500000 0.279636 29.5527778 0.278843 29.5555556 0.278579 29.5583333 0.278843 29.5611111 0.279636 29.5638889 0.280694 29.5666667 0.280959 29.5694444 0.280694 29.5722222 0.280694 29.5750000 0.281488 29.5777778 0.281752 29.5805556 0.282281 29.5833333 0.282281 29.5861111 0.282545 29.5888889 0.282810 29.5916667 0.283603 29.5944444 0.283339 29.5972222 0.284132 29.6030000 0.300000 29.7470000 0.300000 29.7500000 0.288364 29.7527778 0.287835 29.7555556 0.289421 29.7583333 0.290215 29.7611111 0.290215 29.7638889 0.290744 29.7666667 0.291008 29.7694444 0.291273 29.7722222 0.292331 29.7750000 0.293388 29.7777778 0.293917 29.7805556 0.294446 29.7833333 0.294446 29.7861111 0.294711 29.7888889 0.295504 29.7916667 0.296298 29.7944444 0.296826 29.7972222 0.297620 29.8000000 0.297620 29.8027778 0.297355 29.8055556 0.297620 29.8083333 0.297884 29.8111111 0.298149 29.8138889 0.296298 29.8166667 0.294711 29.8194444 0.292331 29.8222222 0.290479 29.8250000 0.289686 29.8277778 0.288364 29.8305556 0.287041 29.8333333 0.284397 29.8361111 0.282810 29.8388889 0.282545 29.8416667 0.283339 29.8444444 0.284397 29.8472222 0.283603 29.8500000 0.283603 29.8527778 0.283339 29.8555556 0.284132 29.8583333 0.284397 29.8611111 0.285190 29.8638889 0.284397 29.8666667 0.284132 29.8694444 0.283074 29.8722222 0.283868 29.8750000 0.284397 29.8777778 0.284397 29.8805556 0.284397 29.8833333 0.283868 29.8861111 0.283339 29.8888889 0.283339 29.8916667 0.283074 29.8944444 0.283339 29.8972222 0.283603 29.9000000 0.283339 29.9027778 0.283074 29.9055556 0.283074 29.9083333 0.283074 29.9111111 0.283339 29.9138889 0.283603 29.9166667 0.282810 29.9194444 0.283339 29.9222222 0.284661 29.9250000 0.285455 29.9277778 0.285983 29.9305556 0.284926 29.9333333 0.284397 29.9361111 0.283339 29.9388889 0.284397 29.9416667 0.284661 29.9444444 0.284926 29.9472222 0.284132 29.9500000 0.284661 29.9527778 0.285719 29.9555556 0.289950 29.9583333 0.295240 29.9611111 0.301851 29.9638889 0.309521 29.9666667 0.316132 29.9694444 0.320099 29.9722222 0.319835 29.9750000 0.319570 29.9777778 0.320893 29.9805556 0.323802 29.9833333 0.325388 29.9861111 0.325917 29.9888889 0.328033 29.9916667 0.329620 29.9944444 0.330413 29.9972222 0.331471 30.0000000 0.332529 30.0027778 0.332000 30.0055556 0.330413 30.0083333 0.328562 30.0111111 0.323537 30.0138889 0.315339 30.0166667 0.306612 30.0194444 0.300000 30.0222222 0.293653 30.0250000 0.287306 30.0277778 0.279107 30.0305556 0.271174 30.0333333 0.264298 30.0361111 0.260860 30.0388889 0.261917 30.0416667 0.265091 30.0444444 0.267471 30.0472222 0.267736 30.0500000 0.268264 30.0527778 0.269851 30.0555556 0.272231 30.0583333 0.274876 30.0611111 0.276463 30.0638889 0.276992 30.0666667 0.276727 30.0694444 0.276727 30.0722222 0.276463 30.0750000 0.276727 30.0777778 0.276992 30.0805556 0.276727 30.0833333 0.276463 30.0861111 0.275669 30.0888889 0.276463 30.0916667 0.276992 30.0944444 0.276727 30.0972222 0.276198 30.1000000 0.275669 30.1027778 0.275140 30.1055556 0.275934 30.1083333 0.276463 30.1111111 0.275934 30.1138889 0.275934 30.1166667 0.274612 30.1194444 0.275140 30.1222222 0.274876 30.1250000 0.274876 30.1277778 0.275140 30.1305556 0.275140 30.1333333 0.274876 30.1361111 0.274876 30.1388889 0.274612 30.1416667 0.274612 30.1444444 0.274876 30.1472222 0.274876 30.1500000 0.274876 30.1527778 0.274083 30.1555556 0.274876 30.1583333 0.275405 30.1611111 0.275405 30.1638889 0.275669 30.1666667 0.274612 30.1694444 0.274083 30.1722222 0.274612 30.1750000 0.275405 30.1777778 0.275669 30.1805556 0.275934 30.1833333 0.275669 30.1861111 0.275669 30.1888889 0.276198 30.1916667 0.276727 30.1944444 0.276727 30.1972222 0.277256 30.2000000 0.276727 30.2027778 0.277256 30.2055556 0.277256 30.2083333 0.277256 30.2111111 0.276992 30.2138889 0.276992 30.2166667 0.277256 30.2194444 0.277256 30.2222222 0.278314 30.2250000 0.278843 30.2277778 0.279372 30.2305556 0.279107 30.2333333 0.279107 30.2361111 0.278314 30.2388889 0.278843 30.2416667 0.279636 30.2444444 0.280959 30.2472222 0.280959 30.2500000 0.281488 30.2527778 0.281223 30.2555556 0.281488 30.2583333 0.282281 30.2611111 0.282017 30.2638889 0.282545 30.2666667 0.282545 30.2694444 0.283339 30.2722222 0.283868 30.2750000 0.283868 30.2777778 0.284132 30.2805556 0.284132 30.2833333 0.284132 30.2861111 0.284397 30.2888889 0.284397 30.2916667 0.284397 30.2944444 0.285190 30.2972222 0.285983 30.3030000 0.300000 30.5000000 0.300000)
Vecg1 ecg_l1 0 PWL(0.0000000 0.300000 1.7470000 0.300000 1.7500000 0.307934 1.7527778 0.308198 1.7555556 0.308463 1.7583333 0.308198 1.7611111 0.307405 1.7638889 0.307934 1.7666667 0.308727 1.7694444 0.309785 1.7722222 0.309785 1.7750000 0.309521 1.7777778 0.309521 1.7805556 0.309785 1.7833333 0.309521 1.7861111 0.310050 1.7888889 0.309785 1.7916667 0.308992 1.7944444 0.308727 1.7972222 0.308198 1.8000000 0.307934 1.8027778 0.308727 1.8055556 0.308727 1.8083333 0.308463 1.8111111 0.308463 1.8138889 0.307669 1.8166667 0.308727 1.8194444 0.308992 1.8222222 0.309521 1.8250000 0.309521 1.8277778 0.309521 1.8305556 0.307934 1.8333333 0.308463 1.8361111 0.308463 1.8388889 0.308198 1.8416667 0.308463 1.8444444 0.308198 1.8472222 0.307405 1.8500000 0.306876 1.8527778 0.307405 1.8555556 0.307140 1.8583333 0.307140 1.8611111 0.306083 1.8638889 0.305818 1.8666667 0.306612 1.8694444 0.307140 1.8722222 0.307405 1.8750000 0.307140 1.8777778 0.306612 1.8805556 0.306612 1.8833333 0.307140 1.8861111 0.308463 1.8888889 0.307934 1.8916667 0.307140 1.8944444 0.306083 1.8972222 0.305554 1.9000000 0.306083 1.9027778 0.306347 1.9055556 0.306083 1.9083333 0.306083 1.9111111 0.305289 1.9138889 0.305818 1.9166667 0.306083 1.9194444 0.306612 1.9222222 0.307140 1.9250000 0.306347 1.9277778 0.306347 1.9305556 0.306347 1.9333333 0.306612 1.9361111 0.307140 1.9388889 0.307669 1.9416667 0.307669 1.9444444 0.307140 1.9472222 0.306083 1.9500000 0.304231 1.9527778 0.301851 1.9555556 0.298942 1.9583333 0.295504 1.9611111 0.291008 1.9638889 0.285455 1.9666667 0.276727 1.9694444 0.268264 1.9722222 0.260331 1.9750000 0.256364 1.9777778 0.255306 1.9805556 0.256364 1.9833333 0.257686 1.9861111 0.259273 1.9888889 0.260595 1.9916667 0.261653 1.9944444 0.262182 1.9972222 0.264033 2.0000000 0.265620 2.0027778 0.267207 2.0055556 0.268000 2.0083333 0.269587 2.0111111 0.271438 2.0138889 0.272760 2.0166667 0.275405 2.0194444 0.277256 2.0222222 0.278314 2.0250000 0.279372 2.0277778 0.281752 2.0305556 0.285719 2.0333333 0.289157 2.0361111 0.291802 2.0388889 0.294182 2.0416667 0.296562 2.0444444 0.298678 2.0472222 0.302380 2.0500000 0.305818 2.0527778 0.308727 2.0555556 0.311372 2.0583333 0.312959 2.0611111 0.313488 2.0638889 0.312959 2.0666667 0.313752 2.0694444 0.314810 2.0722222 0.314810 2.0750000 0.315868 2.0777778 0.315603 2.0805556 0.315339 2.0833333 0.316397 2.0861111 0.316661 2.0888889 0.316926 2.0916667 0.316926 2.0944444 0.316926 2.0972222 0.317455 2.1000000 0.318512 2.1027778 0.318777 2.1055556 0.319041 2.1083333 0.318777 2.1111111 0.317983 2.1138889 0.318512 2.1166667 0.318777 2.1194444 0.319041 2.1222222 0.318777 2.1250000 0.318248 2.1277778 0.318512 2.1305556 0.317983 2.1333333 0.319041 2.1361111 0.319306 2.1388889 0.319306 2.1416667 0.319041 2.1444444 0.318777 2.1472222 0.319570 2.1500000 0.319041 2.1527778 0.319835 2.1555556 0.319570 2.1583333 0.319835 2.1611111 0.320099 2.1638889 0.319570 2.1666667 0.319835 2.1694444 0.320099 2.1722222 0.320099 2.1750000 0.319306 2.1777778 0.318777 2.1805556 0.318512 2.1833333 0.319041 2.1861111 0.319306 2.1888889 0.319306 2.1916667 0.319306 2.1944444 0.318248 2.1972222 0.318512 2.2000000 0.319041 2.2027778 0.319570 2.2055556 0.320099 2.2083333 0.319570 2.2111111 0.319306 2.2138889 0.318777 2.2166667 0.319306 2.2194444 0.320364 2.2222222 0.320099 2.2250000 0.319570 2.2277778 0.318777 2.2305556 0.317983 2.2333333 0.317983 2.2361111 0.318777 2.2388889 0.318512 2.2416667 0.317983 2.2444444 0.317455 2.2472222 0.317455 2.2500000 0.317719 2.2527778 0.317719 2.2555556 0.317983 2.2583333 0.317190 2.2611111 0.316926 2.2638889 0.316397 2.2666667 0.316661 2.2694444 0.317190 2.2722222 0.317190 2.2750000 0.316926 2.2777778 0.315603 2.2805556 0.314281 2.2833333 0.315074 2.2861111 0.315074 2.2888889 0.314810 2.2916667 0.313752 2.2944444 0.313223 2.2972222 0.312165 2.3030000 0.300000 2.4470000 0.300000 2.4500000 0.307405 2.4527778 0.307405 2.4555556 0.307934 2.4583333 0.308727 2.4611111 0.308992 2.4638889 0.308992 2.4666667 0.309785 2.4694444 0.309256 2.4722222 0.309521 2.4750000 0.309521 2.4777778 0.309785 2.4805556 0.308198 2.4833333 0.307405 2.4861111 0.306612 2.4888889 0.305818 2.4916667 0.306083 2.4944444 0.307669 2.4972222 0.306612 2.5000000 0.306612 2.5027778 0.306347 2.5055556 0.306612 2.5083333 0.307405 2.5111111 0.307405 2.5138889 0.307669 2.5166667 0.306876 2.5194444 0.306876 2.5222222 0.306347 2.5250000 0.307669 2.5277778 0.307934 2.5305556 0.307405 2.5333333 0.306612 2.5361111 0.305554 2.5388889 0.305289 2.5416667 0.304760 2.5444444 0.305554 2.5472222 0.305289 2.5500000 0.305554 2.5527778 0.304760 2.5555556 0.303702 2.5583333 0.304760 2.5611111 0.305818 2.5638889 0.305289 2.5666667 0.305554 2.5694444 0.304760 2.5722222 0.304760 2.5750000 0.305554 2.5777778 0.306347 2.5805556 0.306347 2.5833333 0.305289 2.5861111 0.304760 2.5888889 0.304760 2.5916667 0.305554 2.5944444 0.305818 2.5972222 0.304760 2.6000000 0.305025 2.6027778 0.304496 2.6055556 0.304231 2.6083333 0.305025 2.6111111 0.305289 2.6138889 0.305818 2.6166667 0.305289 2.6194444 0.303702 2.6222222 0.303967 2.6250000 0.304760 2.6277778 0.306347 2.6305556 0.307405 2.6333333 0.306612 2.6361111 0.306083 2.6388889 0.305554 2.6416667 0.304760 2.6444444 0.303438 2.6472222 0.300264 2.6500000 0.296033 2.6527778 0.290215 2.6555556 0.282810 2.6583333 0.275140 2.6611111 0.267471 2.6638889 0.263240 2.6666667 0.262182 2.6694444 0.261388 2.6722222 0.261917 2.6750000 0.262975 2.6777778 0.264033 2.6805556 0.264298 2.6833333 0.265091 2.6861111 0.265884 2.6888889 0.266413 2.6916667 0.267207 2.6944444 0.268793 2.6972222 0.270116 2.7000000 0.270380 2.7027778 0.270645 2.7055556 0.272496 2.7083333 0.273554 2.7111111 0.274876 2.7138889 0.276198 2.7166667 0.277785 2.7194444 0.279107 2.7222222 0.280959 2.7250000 0.285455 2.7277778 0.288364 2.7305556 0.290744 2.7333333 0.292860 2.7361111 0.294711 2.7388889 0.297091 2.7416667 0.300529 2.7444444 0.303438 2.7472222 0.305025 2.7500000 0.306612 2.7527778 0.308198 2.7555556 0.309256 2.7583333 0.310314 2.7611111 0.311901 2.7638889 0.312430 2.7666667 0.312165 2.7694444 0.312430 2.7722222 0.312430 2.7750000 0.312959 2.7777778 0.314017 2.7805556 0.314017 2.7833333 0.313488 2.7861111 0.314017 2.7888889 0.313752 2.7916667 0.314810 2.7944444 0.315074 2.7972222 0.315074 2.8000000 0.314545 2.8027778 0.314545 2.8055556 0.315603 2.8083333 0.315868 2.8111111 0.317190 2.8138889 0.316661 2.8166667 0.316926 2.8194444 0.316661 2.8222222 0.316397 2.8250000 0.316397 2.8277778 0.317719 2.8305556 0.316926 2.8333333 0.316926 2.8361111 0.316661 2.8388889 0.316926 2.8416667 0.317455 2.8444444 0.317719 2.8472222 0.316926 2.8500000 0.317190 2.8527778 0.316926 2.8555556 0.316397 2.8583333 0.316926 2.8611111 0.317190 2.8638889 0.317455 2.8666667 0.317190 2.8694444 0.317455 2.8722222 0.317983 2.8750000 0.317455 2.8777778 0.318512 2.8805556 0.318248 2.8833333 0.317983 2.8861111 0.317719 2.8888889 0.317983 2.8916667 0.318512 2.8944444 0.318248 2.8972222 0.317983 2.9000000 0.317983 2.9027778 0.317719 2.9055556 0.317190 2.9083333 0.317983 2.9111111 0.319041 2.9138889 0.318777 2.9166667 0.318512 2.9194444 0.318512 2.9222222 0.318777 2.9250000 0.319041 2.9277778 0.319570 2.9305556 0.318777 2.9333333 0.319041 2.9361111 0.319041 2.9388889 0.318512 2.9416667 0.319041 2.9444444 0.319041 2.9472222 0.319041 2.9500000 0.318512 2.9527778 0.317719 2.9555556 0.317455 2.9583333 0.317983 2.9611111 0.317983 2.9638889 0.317455 2.9666667 0.317190 2.9694444 0.316926 2.9722222 0.316132 2.9750000 0.316132 2.9777778 0.316661 2.9805556 0.316132 2.9833333 0.315603 2.9861111 0.315074 2.9888889 0.315603 2.9916667 0.314810 2.9944444 0.315339 2.9972222 0.315074 3.0030000 0.300000 3.1470000 0.300000 3.1500000 0.312430 3.1527778 0.311636 3.1555556 0.311372 3.1583333 0.310843 3.1611111 0.311901 3.1638889 0.312430 3.1666667 0.312694 3.1694444 0.312165 3.1722222 0.311372 3.1750000 0.310843 3.1777778 0.309785 3.1805556 0.310314 3.1833333 0.310843 3.1861111 0.311107 3.1888889 0.310843 3.1916667 0.310579 3.1944444 0.310579 3.1972222 0.311636 3.2000000 0.312430 3.2027778 0.311901 3.2055556 0.311372 3.2083333 0.311107 3.2111111 0.310314 3.2138889 0.310843 3.2166667 0.311636 3.2194444 0.311107 3.2222222 0.310314 3.2250000 0.310314 3.2277778 0.309521 3.2305556 0.310314 3.2333333 0.310314 3.2361111 0.310314 3.2388889 0.310050 3.2416667 0.309256 3.2444444 0.308992 3.2472222 0.309785 3.2500000 0.310314 3.2527778 0.310579 3.2555556 0.310050 3.2583333 0.309785 3.2611111 0.309785 3.2638889 0.310314 3.2666667 0.310579 3.2694444 0.310314 3.2722222 0.309785 3.2750000 0.309256 3.2777778 0.309256 3.2805556 0.309785 3.2833333 0.310050 3.2861111 0.309521 3.2888889 0.308992 3.2916667 0.308463 3.2944444 0.308727 3.2972222 0.309256 3.3000000 0.309785 3.3027778 0.309785 3.3055556 0.309785 3.3083333 0.308992 3.3111111 0.308992 3.3138889 0.310050 3.3166667 0.310314 3.3194444 0.309785 3.3222222 0.310050 3.3250000 0.310050 3.3277778 0.308992 3.3305556 0.309521 3.3333333 0.310050 3.3361111 0.309785 3.3388889 0.310314 3.3416667 0.309785 3.3444444 0.308992 3.3472222 0.307405 3.3500000 0.305289 3.3527778 0.302116 3.3555556 0.298149 3.3583333 0.292331 3.3611111 0.285719 3.3638889 0.276463 3.3666667 0.269058 3.3694444 0.263504 3.3722222 0.261917 3.3750000 0.262446 3.3777778 0.263240 3.3805556 0.263769 3.3833333 0.264826 3.3861111 0.264562 3.3888889 0.265884 3.3916667 0.266413 3.3944444 0.267471 3.3972222 0.268000 3.4000000 0.269587 3.4027778 0.271174 3.4055556 0.271967 3.4083333 0.272760 3.4111111 0.274083 3.4138889 0.276198 3.4166667 0.278050 3.4194444 0.279901 3.4222222 0.281488 3.4250000 0.283868 3.4277778 0.287570 3.4305556 0.292066 3.4333333 0.295240 3.4361111 0.297884 3.4388889 0.300000 3.4416667 0.302645 3.4444444 0.305554 3.4472222 0.308463 3.4500000 0.311901 3.4527778 0.313223 3.4555556 0.314810 3.4583333 0.315868 3.4611111 0.316661 3.4638889 0.316926 3.4666667 0.317719 3.4694444 0.318248 3.4722222 0.317983 3.4750000 0.318512 3.4777778 0.318512 3.4805556 0.319041 3.4833333 0.320364 3.4861111 0.320099 3.4888889 0.320893 3.4916667 0.319835 3.4944444 0.320893 3.4972222 0.321157 3.5000000 0.321686 3.5027778 0.321950 3.5055556 0.321421 3.5083333 0.320628 3.5111111 0.320893 3.5138889 0.321421 3.5166667 0.322479 3.5194444 0.322215 3.5222222 0.322479 3.5250000 0.321950 3.5277778 0.321686 3.5305556 0.322479 3.5333333 0.323537 3.5361111 0.323008 3.5388889 0.323008 3.5416667 0.322744 3.5444444 0.322479 3.5472222 0.323537 3.5500000 0.324331 3.5527778 0.324331 3.5555556 0.323273 3.5583333 0.323273 3.5611111 0.322744 3.5638889 0.323273 3.5666667 0.324066 3.5694444 0.323802 3.5722222 0.323537 3.5750000 0.323008 3.5777778 0.322744 3.5805556 0.323802 3.5833333 0.324331 3.5861111 0.323273 3.5888889 0.323008 3.5916667 0.323273 3.5944444 0.323802 3.5972222 0.324331 3.6000000 0.324595 3.6027778 0.324595 3.6055556 0.323802 3.6083333 0.323802 3.6111111 0.323537 3.6138889 0.324331 3.6166667 0.324595 3.6194444 0.323802 3.6222222 0.323273 3.6250000 0.322479 3.6277778 0.322744 3.6305556 0.321950 3.6333333 0.323273 3.6361111 0.323008 3.6388889 0.322744 3.6416667 0.322479 3.6444444 0.321950 3.6472222 0.323273 3.6500000 0.323273 3.6527778 0.322744 3.6555556 0.322479 3.6583333 0.321686 3.6611111 0.321686 3.6638889 0.321686 3.6666667 0.322215 3.6694444 0.322215 3.6722222 0.320628 3.6750000 0.320099 3.6777778 0.319835 3.6805556 0.320099 3.6833333 0.320628 3.6861111 0.319570 3.6888889 0.318777 3.6916667 0.317983 3.6944444 0.317190 3.6972222 0.317719 3.7030000 0.300000 3.8470000 0.300000 3.8500000 0.314281 3.8527778 0.313488 3.8555556 0.313752 3.8583333 0.314281 3.8611111 0.314017 3.8638889 0.314281 3.8666667 0.314017 3.8694444 0.314281 3.8722222 0.313752 3.8750000 0.314810 3.8777778 0.315339 3.8805556 0.315339 3.8833333 0.314810 3.8861111 0.314281 3.8888889 0.314017 3.8916667 0.314545 3.8944444 0.314810 3.8972222 0.314017 3.9000000 0.314545 3.9027778 0.314017 3.9055556 0.314017 3.9083333 0.313488 3.9111111 0.314810 3.9138889 0.313752 3.9166667 0.314017 3.9194444 0.313223 3.9222222 0.313488 3.9250000 0.313488 3.9277778 0.313488 3.9305556 0.313223 3.9333333 0.312959 3.9361111 0.312165 3.9388889 0.312694 3.9416667 0.312430 3.9444444 0.312430 3.9472222 0.311901 3.9500000 0.311372 3.9527778 0.310314 3.9555556 0.311636 3.9583333 0.312165 3.9611111 0.312430 3.9638889 0.311636 3.9666667 0.311107 3.9694444 0.310579 3.9722222 0.310843 3.9750000 0.311636 3.9777778 0.311636 3.9805556 0.311107 3.9833333 0.311372 3.9861111 0.310843 3.9888889 0.310314 3.9916667 0.311372 3.9944444 0.311636 3.9972222 0.311636 4.0000000 0.310579 4.0027778 0.310843 4.0055556 0.310579 4.0083333 0.311372 4.0111111 0.312165 4.0138889 0.311636 4.0166667 0.311372 4.0194444 0.310843 4.0222222 0.310579 4.0250000 0.310050 4.0277778 0.310579 4.0305556 0.310050 4.0333333 0.310843 4.0361111 0.310314 4.0388889 0.310579 4.0416667 0.311372 4.0444444 0.312165 4.0472222 0.310314 4.0500000 0.307934 4.0527778 0.304760 4.0555556 0.301058 4.0583333 0.296826 4.0611111 0.291537 4.0638889 0.282017 4.0666667 0.272496 4.0694444 0.265355 4.0722222 0.261917 4.0750000 0.262711 4.0777778 0.264562 4.0805556 0.264562 4.0833333 0.265355 4.0861111 0.265620 4.0888889 0.266678 4.0916667 0.267736 4.0944444 0.269851 4.0972222 0.269322 4.1000000 0.270380 4.1027778 0.270645 4.1055556 0.272760 4.1083333 0.275405 4.1111111 0.277256 4.1138889 0.279372 4.1166667 0.280165 4.1194444 0.281223 4.1222222 0.283603 4.1250000 0.287041 4.1277778 0.290215 4.1305556 0.293388 4.1333333 0.296298 4.1361111 0.297620 4.1388889 0.300793 4.1416667 0.303438 4.1444444 0.306347 4.1472222 0.309785 4.1500000 0.310050 4.1527778 0.312165 4.1555556 0.314017 4.1583333 0.315339 4.1611111 0.316132 4.1638889 0.316926 4.1666667 0.317455 4.1694444 0.317190 4.1722222 0.317455 4.1750000 0.318512 4.1777778 0.319570 4.1805556 0.319570 4.1833333 0.318777 4.1861111 0.318777 4.1888889 0.318512 4.1916667 0.318512 4.1944444 0.319306 4.1972222 0.319306 4.2000000 0.319041 4.2027778 0.318777 4.2055556 0.318248 4.2083333 0.319570 4.2111111 0.320364 4.2138889 0.320099 4.2166667 0.320364 4.2194444 0.320099 4.2222222 0.319306 4.2250000 0.320364 4.2277778 0.320893 4.2305556 0.321157 4.2333333 0.321157 4.2361111 0.320628 4.2388889 0.320364 4.2416667 0.320893 4.2444444 0.321157 4.2472222 0.320628 4.2500000 0.320893 4.2527778 0.319835 4.2555556 0.319570 4.2583333 0.320099 4.2611111 0.321157 4.2638889 0.320364 4.2666667 0.320628 4.2694444 0.320364 4.2722222 0.319835 4.2750000 0.319835 4.2777778 0.320628 4.2805556 0.320628 4.2833333 0.320364 4.2861111 0.320099 4.2888889 0.320099 4.2916667 0.320364 4.2944444 0.321686 4.2972222 0.320628 4.3000000 0.320893 4.3027778 0.320099 4.3055556 0.319570 4.3083333 0.320099 4.3111111 0.320364 4.3138889 0.320628 4.3166667 0.319835 4.3194444 0.319306 4.3222222 0.319041 4.3250000 0.319306 4.3277778 0.319835 4.3305556 0.319835 4.3333333 0.319835 4.3361111 0.319306 4.3388889 0.319570 4.3416667 0.319570 4.3444444 0.319835 4.3472222 0.320099 4.3500000 0.319041 4.3527778 0.318248 4.3555556 0.318777 4.3583333 0.319041 4.3611111 0.319306 4.3638889 0.317983 4.3666667 0.317455 4.3694444 0.317190 4.3722222 0.316926 4.3750000 0.315603 4.3777778 0.314545 4.3805556 0.313223 4.3833333 0.312959 4.3861111 0.312430 4.3888889 0.313488 4.3916667 0.314281 4.3944444 0.316397 4.3972222 0.316926 4.4030000 0.300000 4.5470000 0.300000 4.5500000 0.310050 4.5527778 0.310579 4.5555556 0.310579 4.5583333 0.310579 4.5611111 0.309521 4.5638889 0.310579 4.5666667 0.310843 4.5694444 0.312430 4.5722222 0.312165 4.5750000 0.311636 4.5777778 0.311372 4.5805556 0.311636 4.5833333 0.311901 4.5861111 0.311372 4.5888889 0.311372 4.5916667 0.311372 4.5944444 0.310843 4.5972222 0.310314 4.6000000 0.310579 4.6027778 0.310579 4.6055556 0.310579 4.6083333 0.310314 4.6111111 0.310314 4.6138889 0.309521 4.6166667 0.310579 4.6194444 0.310843 4.6222222 0.311107 4.6250000 0.310050 4.6277778 0.309256 4.6305556 0.309256 4.6333333 0.309521 4.6361111 0.310579 4.6388889 0.309521 4.6416667 0.308727 4.6444444 0.308727 4.6472222 0.308198 4.6500000 0.308992 4.6527778 0.309521 4.6555556 0.309785 4.6583333 0.308992 4.6611111 0.307669 4.6638889 0.307934 4.6666667 0.308727 4.6694444 0.308727 4.6722222 0.308198 4.6750000 0.307934 4.6777778 0.307669 4.6805556 0.307405 4.6833333 0.308463 4.6861111 0.308463 4.6888889 0.308198 4.6916667 0.307669 4.6944444 0.307669 4.6972222 0.307669 4.7000000 0.307669 4.7027778 0.308992 4.7055556 0.308198 4.7083333 0.307405 4.7111111 0.306876 4.7138889 0.307405 4.7166667 0.307405 4.7194444 0.307669 4.7222222 0.306876 4.7250000 0.306876 4.7277778 0.306347 4.7305556 0.306876 4.7333333 0.307934 4.7361111 0.308198 4.7388889 0.308463 4.7416667 0.308198 4.7444444 0.307140 4.7472222 0.306612 4.7500000 0.304760 4.7527778 0.301851 4.7555556 0.297620 4.7583333 0.291802 4.7611111 0.283868 4.7638889 0.275140 4.7666667 0.265355 4.7694444 0.257686 4.7722222 0.253719 4.7750000 0.252926 4.7777778 0.253190 4.7805556 0.253719 4.7833333 0.254248 4.7861111 0.255306 4.7888889 0.256099 4.7916667 0.256628 4.7944444 0.256364 4.7972222 0.257157 4.8000000 0.258479 4.8027778 0.260860 4.8055556 0.261917 4.8083333 0.263240 4.8111111 0.264826 4.8138889 0.268000 4.8166667 0.270116 4.8194444 0.272760 4.8222222 0.275405 4.8250000 0.277785 4.8277778 0.281223 4.8305556 0.285719 4.8333333 0.289686 4.8361111 0.293917 4.8388889 0.297355 4.8416667 0.299207 4.8444444 0.301851 4.8472222 0.305025 4.8500000 0.308198 4.8527778 0.311372 4.8555556 0.312959 4.8583333 0.314017 4.8611111 0.314017 4.8638889 0.315603 4.8666667 0.316397 4.8694444 0.317190 4.8722222 0.317983 4.8750000 0.317983 4.8777778 0.317719 4.8805556 0.317983 4.8833333 0.319041 4.8861111 0.319041 4.8888889 0.319306 4.8916667 0.318777 4.8944444 0.318512 4.8972222 0.318777 4.9000000 0.319306 4.9027778 0.319835 4.9055556 0.320099 4.9083333 0.319835 4.9111111 0.319835 4.9138889 0.319570 4.9166667 0.319835 4.9194444 0.320893 4.9222222 0.320364 4.9250000 0.320099 4.9277778 0.320364 4.9305556 0.320893 4.9333333 0.321950 4.9361111 0.322215 4.9388889 0.321950 4.9416667 0.320893 4.9444444 0.319835 4.9472222 0.320099 4.9500000 0.321421 4.9527778 0.321421 4.9555556 0.320628 4.9583333 0.320893 4.9611111 0.320099 4.9638889 0.321421 4.9666667 0.321686 4.9694444 0.322215 4.9722222 0.322215 4.9750000 0.321686 4.9777778 0.320893 4.9805556 0.321950 4.9833333 0.322215 4.9861111 0.322479 4.9888889 0.321686 4.9916667 0.321950 4.9944444 0.321421 4.9972222 0.320893 5.0000000 0.321157 5.0027778 0.322215 5.0055556 0.321686 5.0083333 0.321157 5.0111111 0.320893 5.0138889 0.320628 5.0166667 0.321157 5.0194444 0.321686 5.0222222 0.320893 5.0250000 0.321421 5.0277778 0.320099 5.0305556 0.320099 5.0333333 0.321421 5.0361111 0.321686 5.0388889 0.321421 5.0416667 0.319835 5.0444444 0.319570 5.0472222 0.320099 5.0500000 0.321157 5.0527778 0.320628 5.0555556 0.319835 5.0583333 0.319041 5.0611111 0.317983 5.0638889 0.318248 5.0666667 0.318512 5.0694444 0.318248 5.0722222 0.318512 5.0750000 0.317983 5.0777778 0.316397 5.0805556 0.316661 5.0833333 0.316926 5.0861111 0.316926 5.0888889 0.316132 5.0916667 0.315074 5.0944444 0.315074 5.0972222 0.314810 5.1030000 0.300000 5.2470000 0.300000 5.2500000 0.303438 5.2527778 0.303702 5.2555556 0.302909 5.2583333 0.302909 5.2611111 0.302645 5.2638889 0.303702 5.2666667 0.304496 5.2694444 0.305289 5.2722222 0.305818 5.2750000 0.305289 5.2777778 0.305025 5.2805556 0.305818 5.2833333 0.305818 5.2861111 0.305818 5.2888889 0.305025 5.2916667 0.304496 5.2944444 0.303174 5.2972222 0.303702 5.3000000 0.303967 5.3027778 0.304496 5.3055556 0.304231 5.3083333 0.304231 5.3111111 0.303438 5.3138889 0.303702 5.3166667 0.304231 5.3194444 0.303967 5.3222222 0.304496 5.3250000 0.303967 5.3277778 0.303174 5.3305556 0.303967 5.3333333 0.303174 5.3361111 0.303702 5.3388889 0.303967 5.3416667 0.302909 5.3444444 0.301058 5.3472222 0.301058 5.3500000 0.301587 5.3527778 0.301851 5.3555556 0.301587 5.3583333 0.301058 5.3611111 0.299736 5.3638889 0.301058 5.3666667 0.301587 5.3694444 0.301851 5.3722222 0.301587 5.3750000 0.300793 5.3777778 0.300529 5.3805556 0.300793 5.3833333 0.301587 5.3861111 0.302116 5.3888889 0.302116 5.3916667 0.301322 5.3944444 0.300793 5.3972222 0.301058 5.4000000 0.301587 5.4027778 0.301587 5.4055556 0.301587 5.4083333 0.301322 5.4111111 0.300529 5.4138889 0.301058 5.4166667 0.301322 5.4194444 0.301058 5.4222222 0.301322 5.4250000 0.300529 5.4277778 0.300000 5.4305556 0.300000 5.4333333 0.300529 5.4361111 0.300793 5.4388889 0.301322 5.4416667 0.301322 5.4444444 0.301587 5.4472222 0.301322 5.4500000 0.300529 5.4527778 0.296562 5.4555556 0.292331 5.4583333 0.286248 5.4611111 0.279107 5.4638889 0.271438 5.4666667 0.261917 5.4694444 0.252926 5.4722222 0.246314 5.4750000 0.242876 5.4777778 0.242612 5.4805556 0.243405 5.4833333 0.243669 5.4861111 0.244198 5.4888889 0.244992 5.4916667 0.245256 5.4944444 0.246050 5.4972222 0.247107 5.5000000 0.247636 5.5027778 0.249223 5.5055556 0.250017 5.5083333 0.251603 5.5111111 0.252397 5.5138889 0.253983 5.5166667 0.257157 5.5194444 0.260595 5.5222222 0.263240 5.5250000 0.265620 5.5277778 0.269851 5.5305556 0.274612 5.5333333 0.279107 5.5361111 0.283603 5.5388889 0.286777 5.5416667 0.290215 5.5444444 0.292331 5.5472222 0.295504 5.5500000 0.299736 5.5527778 0.302645 5.5555556 0.305025 5.5583333 0.306876 5.5611111 0.308198 5.5638889 0.308463 5.5666667 0.310050 5.5694444 0.311107 5.5722222 0.311372 5.5750000 0.311372 5.5777778 0.311901 5.5805556 0.312165 5.5833333 0.312694 5.5861111 0.313223 5.5888889 0.312959 5.5916667 0.313223 5.5944444 0.312694 5.5972222 0.313488 5.6000000 0.314281 5.6027778 0.314281 5.6055556 0.315603 5.6083333 0.314810 5.6111111 0.315074 5.6138889 0.315868 5.6166667 0.316397 5.6194444 0.316132 5.6222222 0.316397 5.6250000 0.315868 5.6277778 0.315339 5.6305556 0.314810 5.6333333 0.315868 5.6361111 0.316397 5.6388889 0.316397 5.6416667 0.315868 5.6444444 0.315603 5.6472222 0.316397 5.6500000 0.316926 5.6527778 0.317190 5.6555556 0.317190 5.6583333 0.316397 5.6611111 0.315868 5.6638889 0.317190 5.6666667 0.317983 5.6694444 0.317719 5.6722222 0.317455 5.6750000 0.316397 5.6777778 0.316132 5.6805556 0.316397 5.6833333 0.317190 5.6861111 0.317190 5.6888889 0.317190 5.6916667 0.317455 5.6944444 0.316397 5.6972222 0.317190 5.7000000 0.317190 5.7027778 0.316926 5.7055556 0.317190 5.7083333 0.316132 5.7111111 0.316661 5.7138889 0.316397 5.7166667 0.317455 5.7194444 0.317190 5.7222222 0.317719 5.7250000 0.316132 5.7277778 0.315868 5.7305556 0.316397 5.7333333 0.316661 5.7361111 0.317190 5.7388889 0.316132 5.7416667 0.315868 5.7444444 0.315339 5.7472222 0.316132 5.7500000 0.316397 5.7527778 0.316926 5.7555556 0.316397 5.7583333 0.315339 5.7611111 0.314545 5.7638889 0.315074 5.7666667 0.315603 5.7694444 0.315868 5.7722222 0.315868 5.7750000 0.314545 5.7777778 0.314017 5.7805556 0.314017 5.7833333 0.314281 5.7861111 0.314017 5.7888889 0.312694 5.7916667 0.311372 5.7944444 0.310843 5.7972222 0.310314 5.8030000 0.300000 5.9470000 0.300000 5.9500000 0.292331 5.9527778 0.292066 5.9555556 0.292860 5.9583333 0.291802 5.9611111 0.291802 5.9638889 0.292860 5.9666667 0.293124 5.9694444 0.293653 5.9722222 0.293388 5.9750000 0.293124 5.9777778 0.292595 5.9805556 0.293653 5.9833333 0.294446 5.9861111 0.294182 5.9888889 0.293388 5.9916667 0.292595 5.9944444 0.293388 5.9972222 0.293388 6.0000000 0.293917 6.0027778 0.293388 6.0055556 0.292595 6.0083333 0.292066 6.0111111 0.291537 6.0138889 0.292331 6.0166667 0.292860 6.0194444 0.293124 6.0222222 0.292595 6.0250000 0.291273 6.0277778 0.290744 6.0305556 0.291008 6.0333333 0.292595 6.0361111 0.292860 6.0388889 0.292331 6.0416667 0.291537 6.0444444 0.290744 6.0472222 0.291008 6.0500000 0.291008 6.0527778 0.291537 6.0555556 0.290744 6.0583333 0.290744 6.0611111 0.290215 6.0638889 0.290215 6.0666667 0.291008 6.0694444 0.290744 6.0722222 0.290744 6.0750000 0.290479 6.0777778 0.289686 6.0805556 0.290215 6.0833333 0.290744 6.0861111 0.290744 6.0888889 0.290215 6.0916667 0.289421 6.0944444 0.289421 6.0972222 0.289686 6.1000000 0.290479 6.1027778 0.290744 6.1055556 0.291273 6.1083333 0.290479 6.1111111 0.289950 6.1138889 0.289950 6.1166667 0.290215 6.1194444 0.290744 6.1222222 0.290479 6.1250000 0.289686 6.1277778 0.289157 6.1305556 0.289686 6.1333333 0.289686 6.1361111 0.290479 6.1388889 0.289686 6.1416667 0.289950 6.1444444 0.290215 6.1472222 0.290215 6.1500000 0.289157 6.1527778 0.286777 6.1555556 0.284132 6.1583333 0.280694 6.1611111 0.276463 6.1638889 0.271438 6.1666667 0.264826 6.1694444 0.256099 6.1722222 0.246314 6.1750000 0.239967 6.1777778 0.237058 6.1805556 0.237587 6.1833333 0.238645 6.1861111 0.238645 6.1888889 0.239174 6.1916667 0.239967 6.1944444 0.241289 6.1972222 0.243140 6.2000000 0.245785 6.2027778 0.246579 6.2055556 0.248430 6.2083333 0.249752 6.2111111 0.250810 6.2138889 0.253719 6.2166667 0.256893 6.2194444 0.259537 6.2222222 0.261653 6.2250000 0.262446 6.2277778 0.264826 6.2305556 0.269322 6.2333333 0.273025 6.2361111 0.275934 6.2388889 0.278314 6.2416667 0.280694 6.2444444 0.283339 6.2472222 0.286777 6.2500000 0.290479 6.2527778 0.293388 6.2555556 0.295769 6.2583333 0.296826 6.2611111 0.298149 6.2638889 0.299207 6.2666667 0.300264 6.2694444 0.301322 6.2722222 0.301587 6.2750000 0.301851 6.2777778 0.301322 6.2805556 0.302116 6.2833333 0.303174 6.2861111 0.303174 6.2888889 0.302909 6.2916667 0.302645 6.2944444 0.302380 6.2972222 0.302909 6.3000000 0.303438 6.3027778 0.303702 6.3055556 0.303438 6.3083333 0.302909 6.3111111 0.303174 6.3138889 0.303702 6.3166667 0.303702 6.3194444 0.304760 6.3222222 0.304760 6.3250000 0.304496 6.3277778 0.304760 6.3305556 0.305554 6.3333333 0.306083 6.3361111 0.306876 6.3388889 0.307669 6.3416667 0.307669 6.3444444 0.307405 6.3472222 0.307405 6.3500000 0.307669 6.3527778 0.307934 6.3555556 0.307669 6.3583333 0.307140 6.3611111 0.307140 6.3638889 0.307405 6.3666667 0.307934 6.3694444 0.308463 6.3722222 0.307405 6.3750000 0.307140 6.3777778 0.306876 6.3805556 0.307405 6.3833333 0.308198 6.3861111 0.308198 6.3888889 0.308198 6.3916667 0.307669 6.3944444 0.308198 6.3972222 0.308198 6.4000000 0.308198 6.4027778 0.307934 6.4055556 0.306876 6.4083333 0.306083 6.4111111 0.305025 6.4138889 0.305289 6.4166667 0.305289 6.4194444 0.305289 6.4222222 0.305554 6.4250000 0.304231 6.4277778 0.304231 6.4305556 0.304760 6.4333333 0.305025 6.4361111 0.305554 6.4388889 0.304760 6.4416667 0.304231 6.4444444 0.303702 6.4472222 0.303967 6.4500000 0.304760 6.4527778 0.305554 6.4555556 0.304496 6.4583333 0.303702 6.4611111 0.302909 6.4638889 0.303174 6.4666667 0.302909 6.4694444 0.302645 6.4722222 0.302645 6.4750000 0.302116 6.4777778 0.302380 6.4805556 0.301851 6.4833333 0.302380 6.4861111 0.301851 6.4888889 0.301322 6.4916667 0.301058 6.4944444 0.299736 6.4972222 0.300264 6.5030000 0.300000 6.6470000 0.300000 6.6500000 0.293388 6.6527778 0.293917 6.6555556 0.294182 6.6583333 0.294446 6.6611111 0.295240 6.6638889 0.294975 6.6666667 0.295240 6.6694444 0.295240 6.6722222 0.295769 6.6750000 0.296298 6.6777778 0.296826 6.6805556 0.296033 6.6833333 0.296298 6.6861111 0.295769 6.6888889 0.296298 6.6916667 0.296298 6.6944444 0.295240 6.6972222 0.294975 6.7000000 0.294446 6.7027778 0.294711 6.7055556 0.294711 6.7083333 0.294975 6.7111111 0.294446 6.7138889 0.294711 6.7166667 0.294711 6.7194444 0.294446 6.7222222 0.294711 6.7250000 0.294711 6.7277778 0.294446 6.7305556 0.293917 6.7333333 0.294182 6.7361111 0.293917 6.7388889 0.294446 6.7416667 0.294446 6.7444444 0.294446 6.7472222 0.293388 6.7500000 0.292595 6.7527778 0.292860 6.7555556 0.293917 6.7583333 0.293653 6.7611111 0.293917 6.7638889 0.293124 6.7666667 0.292066 6.7694444 0.292331 6.7722222 0.292860 6.7750000 0.292595 6.7777778 0.293124 6.7805556 0.292595 6.7833333 0.291802 6.7861111 0.291802 6.7888889 0.292595 6.7916667 0.293124 6.7944444 0.292860 6.7972222 0.292331 6.8000000 0.292066 6.8027778 0.292066 6.8055556 0.292331 6.8083333 0.293653 6.8111111 0.292860 6.8138889 0.292331 6.8166667 0.292066 6.8194444 0.292066 6.8222222 0.291802 6.8250000 0.292066 6.8277778 0.291802 6.8305556 0.291802 6.8333333 0.291537 6.8361111 0.291273 6.8388889 0.291802 6.8416667 0.292595 6.8444444 0.292595 6.8472222 0.291802 6.8500000 0.290479 6.8527778 0.287835 6.8555556 0.285190 6.8583333 0.282017 6.8611111 0.276992 6.8638889 0.270116 6.8666667 0.260331 6.8694444 0.250281 6.8722222 0.243140 6.8750000 0.240231 6.8777778 0.240231 6.8805556 0.240496 6.8833333 0.240760 6.8861111 0.241025 6.8888889 0.242347 6.8916667 0.244727 6.8944444 0.245785 6.8972222 0.246843 6.9000000 0.247636 6.9027778 0.248959 6.9055556 0.250810 6.9083333 0.252132 6.9111111 0.253719 6.9138889 0.255570 6.9166667 0.257157 6.9194444 0.259008 6.9222222 0.261124 6.9250000 0.262975 6.9277778 0.267207 6.9305556 0.270380 6.9333333 0.272760 6.9361111 0.276463 6.9388889 0.279901 6.9416667 0.282545 6.9444444 0.285455 6.9472222 0.287835 6.9500000 0.290744 6.9527778 0.293388 6.9555556 0.296033 6.9583333 0.298149 6.9611111 0.298942 6.9638889 0.299471 6.9666667 0.299471 6.9694444 0.300529 6.9722222 0.301322 6.9750000 0.301851 6.9777778 0.302645 6.9805556 0.302116 6.9833333 0.301587 6.9861111 0.302380 6.9888889 0.302909 6.9916667 0.303174 6.9944444 0.303174 6.9972222 0.302645 7.0000000 0.302645 7.0027778 0.303174 7.0055556 0.304231 7.0083333 0.303967 7.0111111 0.304760 7.0138889 0.303967 7.0166667 0.304496 7.0194444 0.304760 7.0222222 0.305818 7.0250000 0.305289 7.0277778 0.305289 7.0305556 0.305289 7.0333333 0.304231 7.0361111 0.305025 7.0388889 0.305289 7.0416667 0.304760 7.0444444 0.305025 7.0472222 0.305025 7.0500000 0.304496 7.0527778 0.305818 7.0555556 0.306083 7.0583333 0.305554 7.0611111 0.305554 7.0638889 0.305025 7.0666667 0.305025 7.0694444 0.305554 7.0722222 0.305818 7.0750000 0.306083 7.0777778 0.306083 7.0805556 0.305554 7.0833333 0.305289 7.0861111 0.306347 7.0888889 0.306083 7.0916667 0.306612 7.0944444 0.306347 7.0972222 0.305554 7.1000000 0.305289 7.1027778 0.305025 7.1055556 0.305554 7.1083333 0.306083 7.1111111 0.305289 7.1138889 0.304496 7.1166667 0.305025 7.1194444 0.305025 7.1222222 0.305554 7.1250000 0.305554 7.1277778 0.305289 7.1305556 0.305025 7.1333333 0.304231 7.1361111 0.304231 7.1388889 0.304760 7.1416667 0.305554 7.1444444 0.305289 7.1472222 0.304231 7.1500000 0.303702 7.1527778 0.304231 7.1555556 0.303967 7.1583333 0.303967 7.1611111 0.303174 7.1638889 0.302909 7.1666667 0.302380 7.1694444 0.302645 7.1722222 0.302645 7.1750000 0.302645 7.1777778 0.302645 7.1805556 0.301587 7.1833333 0.301322 7.1861111 0.301058 7.1888889 0.301058 7.1916667 0.301058 7.1944444 0.300529 7.1972222 0.300264 7.2030000 0.300000 7.3470000 0.300000 7.3500000 0.291008 7.3527778 0.290744 7.3555556 0.290479 7.3583333 0.290744 7.3611111 0.291273 7.3638889 0.292066 7.3666667 0.291273 7.3694444 0.290744 7.3722222 0.290215 7.3750000 0.291273 7.3777778 0.290744 7.3805556 0.289950 7.3833333 0.289686 7.3861111 0.289950 7.3888889 0.289686 7.3916667 0.290215 7.3944444 0.291273 7.3972222 0.291008 7.4000000 0.290479 7.4027778 0.290744 7.4055556 0.290479 7.4083333 0.290215 7.4111111 0.290479 7.4138889 0.290215 7.4166667 0.289157 7.4194444 0.288364 7.4222222 0.288628 7.4250000 0.289421 7.4277778 0.289421 7.4305556 0.289421 7.4333333 0.288364 7.4361111 0.288099 7.4388889 0.288099 7.4416667 0.288364 7.4444444 0.288364 7.4472222 0.288628 7.4500000 0.287835 7.4527778 0.288099 7.4555556 0.288364 7.4583333 0.288364 7.4611111 0.288364 7.4638889 0.288628 7.4666667 0.288364 7.4694444 0.288099 7.4722222 0.288099 7.4750000 0.288099 7.4777778 0.288099 7.4805556 0.287835 7.4833333 0.287306 7.4861111 0.287041 7.4888889 0.287306 7.4916667 0.287570 7.4944444 0.287306 7.4972222 0.287306 7.5000000 0.287041 7.5027778 0.286512 7.5055556 0.287306 7.5083333 0.287835 7.5111111 0.288364 7.5138889 0.288099 7.5166667 0.287306 7.5194444 0.287306 7.5222222 0.287570 7.5250000 0.287835 7.5277778 0.288099 7.5305556 0.286777 7.5333333 0.287041 7.5361111 0.287041 7.5388889 0.287570 7.5416667 0.287306 7.5444444 0.285719 7.5472222 0.283074 7.5500000 0.279372 7.5527778 0.275934 7.5555556 0.271967 7.5583333 0.266942 7.5611111 0.259537 7.5638889 0.251074 7.5666667 0.242347 7.5694444 0.237058 7.5722222 0.234413 7.5750000 0.235207 7.5777778 0.236793 7.5805556 0.236000 7.5833333 0.235736 7.5861111 0.236529 7.5888889 0.237851 7.5916667 0.239967 7.5944444 0.240496 7.5972222 0.241554 7.6000000 0.242083 7.6027778 0.243405 7.6055556 0.244727 7.6083333 0.246843 7.6111111 0.248694 7.6138889 0.249752 7.6166667 0.251074 7.6194444 0.252661 7.6222222 0.255570 7.6250000 0.257686 7.6277778 0.261388 7.6305556 0.264562 7.6333333 0.267471 7.6361111 0.270116 7.6388889 0.274083 7.6416667 0.277256 7.6444444 0.279372 7.6472222 0.282545 7.6500000 0.284397 7.6527778 0.286512 7.6555556 0.289157 7.6583333 0.291537 7.6611111 0.293917 7.6638889 0.294446 7.6666667 0.294182 7.6694444 0.294975 7.6722222 0.296033 7.6750000 0.296562 7.6777778 0.297355 7.6805556 0.297355 7.6833333 0.296826 7.6861111 0.297355 7.6888889 0.298149 7.6916667 0.298942 7.6944444 0.299207 7.6972222 0.299736 7.7000000 0.298942 7.7027778 0.299207 7.7055556 0.299207 7.7083333 0.299736 7.7111111 0.299471 7.7138889 0.299736 7.7166667 0.299207 7.7194444 0.299207 7.7222222 0.298942 7.7250000 0.300000 7.7277778 0.300529 7.7305556 0.299736 7.7333333 0.299736 7.7361111 0.299736 7.7388889 0.300529 7.7416667 0.301322 7.7444444 0.300793 7.7472222 0.301058 7.7500000 0.300793 7.7527778 0.300793 7.7555556 0.300529 7.7583333 0.301851 7.7611111 0.301851 7.7638889 0.301322 7.7666667 0.300793 7.7694444 0.300529 7.7722222 0.300000 7.7750000 0.301587 7.7777778 0.301322 7.7805556 0.301058 7.7833333 0.300793 7.7861111 0.300529 7.7888889 0.300793 7.7916667 0.300793 7.7944444 0.301058 7.7972222 0.301058 7.8000000 0.300529 7.8027778 0.300000 7.8055556 0.300793 7.8083333 0.300793 7.8111111 0.301322 7.8138889 0.301058 7.8166667 0.300529 7.8194444 0.300529 7.8222222 0.300264 7.8250000 0.300529 7.8277778 0.301058 7.8305556 0.300264 7.8333333 0.299471 7.8361111 0.299207 7.8388889 0.299471 7.8416667 0.300264 7.8444444 0.300264 7.8472222 0.300000 7.8500000 0.298942 7.8527778 0.298413 7.8555556 0.299471 7.8583333 0.299207 7.8611111 0.299471 7.8638889 0.299207 7.8666667 0.299207 7.8694444 0.298678 7.8722222 0.298149 7.8750000 0.298678 7.8777778 0.298942 7.8805556 0.298149 7.8833333 0.297355 7.8861111 0.296033 7.8888889 0.296033 7.8916667 0.296562 7.8944444 0.296562 7.8972222 0.296033 7.9030000 0.300000 8.0470000 0.300000 8.0500000 0.286248 8.0527778 0.287041 8.0555556 0.287835 8.0583333 0.287570 8.0611111 0.288364 8.0638889 0.287570 8.0666667 0.288364 8.0694444 0.288628 8.0722222 0.289421 8.0750000 0.288893 8.0777778 0.288628 8.0805556 0.287835 8.0833333 0.286777 8.0861111 0.287041 8.0888889 0.287041 8.0916667 0.287041 8.0944444 0.287306 8.0972222 0.285983 8.1000000 0.285719 8.1027778 0.286248 8.1055556 0.287570 8.1083333 0.287041 8.1111111 0.287570 8.1138889 0.286248 8.1166667 0.286248 8.1194444 0.286248 8.1222222 0.285983 8.1250000 0.286248 8.1277778 0.286777 8.1305556 0.285455 8.1333333 0.285455 8.1361111 0.285190 8.1388889 0.285983 8.1416667 0.284661 8.1444444 0.285719 8.1472222 0.284397 8.1500000 0.283868 8.1527778 0.284661 8.1555556 0.284397 8.1583333 0.284926 8.1611111 0.284661 8.1638889 0.284132 8.1666667 0.283339 8.1694444 0.284397 8.1722222 0.284132 8.1750000 0.284661 8.1777778 0.284397 8.1805556 0.284397 8.1833333 0.283868 8.1861111 0.284661 8.1888889 0.284397 8.1916667 0.284397 8.1944444 0.284397 8.1972222 0.283868 8.2000000 0.284397 8.2027778 0.284132 8.2055556 0.284397 8.2083333 0.283868 8.2111111 0.284397 8.2138889 0.283603 8.2166667 0.283603 8.2194444 0.283603 8.2222222 0.284132 8.2250000 0.284132 8.2277778 0.284397 8.2305556 0.283603 8.2333333 0.283074 8.2361111 0.283868 8.2388889 0.285719 8.2416667 0.286248 8.2444444 0.285719 8.2472222 0.283868 8.2500000 0.280430 8.2527778 0.277256 8.2555556 0.274347 8.2583333 0.269322 8.2611111 0.262182 8.2638889 0.253983 8.2666667 0.243934 8.2694444 0.236793 8.2722222 0.234942 8.2750000 0.235207 8.2777778 0.235736 8.2805556 0.235471 8.2833333 0.235471 8.2861111 0.236793 8.2888889 0.237587 8.2916667 0.239438 8.2944444 0.240496 8.2972222 0.242083 8.3000000 0.242083 8.3027778 0.244198 8.3055556 0.246050 8.3083333 0.248165 8.3111111 0.249223 8.3138889 0.250545 8.3166667 0.251339 8.3194444 0.252661 8.3222222 0.255306 8.3250000 0.257950 8.3277778 0.260860 8.3305556 0.264033 8.3333333 0.266149 8.3361111 0.269851 8.3388889 0.272496 8.3416667 0.275669 8.3444444 0.279372 8.3472222 0.282017 8.3500000 0.283868 8.3527778 0.286777 8.3555556 0.289686 8.3583333 0.291802 8.3611111 0.292066 8.3638889 0.292331 8.3666667 0.292331 8.3694444 0.292860 8.3722222 0.293124 8.3750000 0.293388 8.3777778 0.293388 8.3805556 0.293388 8.3833333 0.293124 8.3861111 0.293917 8.3888889 0.294446 8.3916667 0.295769 8.3944444 0.295769 8.3972222 0.294711 8.4000000 0.294711 8.4027778 0.295504 8.4055556 0.296562 8.4083333 0.296298 8.4111111 0.297355 8.4138889 0.297091 8.4166667 0.297355 8.4194444 0.297620 8.4222222 0.298149 8.4250000 0.296826 8.4277778 0.296562 8.4305556 0.295504 8.4333333 0.294711 8.4361111 0.295769 8.4388889 0.297091 8.4416667 0.297355 8.4444444 0.296562 8.4472222 0.296298 8.4500000 0.296826 8.4527778 0.297355 8.4555556 0.297620 8.4583333 0.298149 8.4611111 0.297620 8.4638889 0.297620 8.4666667 0.297884 8.4694444 0.297884 8.4722222 0.297884 8.4750000 0.297884 8.4777778 0.297355 8.4805556 0.296826 8.4833333 0.296033 8.4861111 0.295240 8.4888889 0.295769 8.4916667 0.296562 8.4944444 0.296298 8.4972222 0.295504 8.5000000 0.295240 8.5027778 0.295769 8.5055556 0.296562 8.5083333 0.295769 8.5111111 0.296033 8.5138889 0.295504 8.5166667 0.295769 8.5194444 0.295769 8.5222222 0.295240 8.5250000 0.294975 8.5277778 0.294711 8.5305556 0.293917 8.5333333 0.293653 8.5361111 0.294182 8.5388889 0.294446 8.5416667 0.293388 8.5444444 0.293653 8.5472222 0.293124 8.5500000 0.292595 8.5527778 0.291802 8.5555556 0.292860 8.5583333 0.292331 8.5611111 0.292331 8.5638889 0.291273 8.5666667 0.290479 8.5694444 0.291537 8.5722222 0.291537 8.5750000 0.291537 8.5777778 0.291273 8.5805556 0.290215 8.5833333 0.289686 8.5861111 0.289421 8.5888889 0.288893 8.5916667 0.288364 8.5944444 0.287835 8.5972222 0.286512 8.6030000 0.300000 8.7470000 0.300000 8.7500000 0.284397 8.7527778 0.283074 8.7555556 0.283074 8.7583333 0.283868 8.7611111 0.283868 8.7638889 0.284132 8.7666667 0.283868 8.7694444 0.283868 8.7722222 0.284132 8.7750000 0.284132 8.7777778 0.285190 8.7805556 0.284926 8.7833333 0.285190 8.7861111 0.284926 8.7888889 0.284661 8.7916667 0.284926 8.7944444 0.285190 8.7972222 0.284926 8.8000000 0.284132 8.8027778 0.283868 8.8055556 0.283339 8.8083333 0.284926 8.8111111 0.284661 8.8138889 0.284397 8.8166667 0.284132 8.8194444 0.283339 8.8222222 0.283074 8.8250000 0.283603 8.8277778 0.284397 8.8305556 0.284661 8.8333333 0.283868 8.8361111 0.283074 8.8388889 0.283074 8.8416667 0.283074 8.8444444 0.284132 8.8472222 0.283339 8.8500000 0.283074 8.8527778 0.282545 8.8555556 0.282017 8.8583333 0.283339 8.8611111 0.283339 8.8638889 0.282810 8.8666667 0.282810 8.8694444 0.283074 8.8722222 0.282017 8.8750000 0.283074 8.8777778 0.282545 8.8805556 0.282545 8.8833333 0.282281 8.8861111 0.281752 8.8888889 0.281752 8.8916667 0.281752 8.8944444 0.283074 8.8972222 0.282545 8.9000000 0.282281 8.9027778 0.281488 8.9055556 0.282281 8.9083333 0.282810 8.9111111 0.282810 8.9138889 0.282810 8.9166667 0.282810 8.9194444 0.282281 8.9222222 0.282545 8.9250000 0.282017 8.9277778 0.282281 8.9305556 0.282281 8.9333333 0.282281 8.9361111 0.281488 8.9388889 0.281488 8.9416667 0.281488 8.9444444 0.282810 8.9472222 0.283074 8.9500000 0.281752 8.9527778 0.279107 8.9555556 0.275405 8.9583333 0.270909 8.9611111 0.266413 8.9638889 0.259008 8.9666667 0.249223 8.9694444 0.237322 8.9722222 0.228595 8.9750000 0.225157 8.9777778 0.226479 8.9805556 0.227537 8.9833333 0.228066 8.9861111 0.228066 8.9888889 0.228595 8.9916667 0.230975 8.9944444 0.232562 8.9972222 0.233620 9.0000000 0.234149 9.0027778 0.234678 9.0055556 0.236529 9.0083333 0.238909 9.0111111 0.242876 9.0138889 0.244463 9.0166667 0.246843 9.0194444 0.248430 9.0222222 0.251339 9.0250000 0.256099 9.0277778 0.260860 9.0305556 0.264033 9.0333333 0.267471 9.0361111 0.269851 9.0388889 0.273025 9.0416667 0.276727 9.0444444 0.279901 9.0472222 0.283339 9.0500000 0.285455 9.0527778 0.287570 9.0555556 0.287835 9.0583333 0.289157 9.0611111 0.289686 9.0638889 0.290744 9.0666667 0.290744 9.0694444 0.291537 9.0722222 0.291537 9.0750000 0.292066 9.0777778 0.292331 9.0805556 0.292066 9.0833333 0.292331 9.0861111 0.292066 9.0888889 0.292066 9.0916667 0.292066 9.0944444 0.293124 9.0972222 0.293124 9.1000000 0.293653 9.1027778 0.293124 9.1055556 0.293124 9.1083333 0.293124 9.1111111 0.293653 9.1138889 0.293917 9.1166667 0.294711 9.1194444 0.294182 9.1222222 0.294182 9.1250000 0.294182 9.1277778 0.294711 9.1305556 0.295240 9.1333333 0.294975 9.1361111 0.294182 9.1388889 0.293917 9.1416667 0.294446 9.1444444 0.294711 9.1472222 0.295504 9.1500000 0.294446 9.1527778 0.294182 9.1555556 0.293388 9.1583333 0.294182 9.1611111 0.295240 9.1638889 0.294975 9.1666667 0.295504 9.1694444 0.293917 9.1722222 0.294446 9.1750000 0.294975 9.1777778 0.296033 9.1805556 0.295504 9.1833333 0.295240 9.1861111 0.294975 9.1888889 0.294711 9.1916667 0.294446 9.1944444 0.294182 9.1972222 0.294711 9.2000000 0.294975 9.2027778 0.294711 9.2055556 0.293917 9.2083333 0.294182 9.2111111 0.294975 9.2138889 0.294711 9.2166667 0.293653 9.2194444 0.294182 9.2222222 0.293917 9.2250000 0.293917 9.2277778 0.294975 9.2305556 0.294446 9.2333333 0.293388 9.2361111 0.293124 9.2388889 0.292331 9.2416667 0.292860 9.2444444 0.292595 9.2472222 0.292331 9.2500000 0.291537 9.2527778 0.291008 9.2555556 0.291008 9.2583333 0.290744 9.2611111 0.291537 9.2638889 0.290479 9.2666667 0.289950 9.2694444 0.289157 9.2722222 0.288364 9.2750000 0.288364 9.2777778 0.288364 9.2805556 0.288628 9.2833333 0.287835 9.2861111 0.287041 9.2888889 0.286777 9.2916667 0.286512 9.2944444 0.286512 9.2972222 0.285719 9.3030000 0.300000 9.4470000 0.300000 9.4500000 0.274347 9.4527778 0.275405 9.4555556 0.275934 9.4583333 0.275669 9.4611111 0.275934 9.4638889 0.274876 9.4666667 0.275669 9.4694444 0.276198 9.4722222 0.277521 9.4750000 0.277521 9.4777778 0.277521 9.4805556 0.278050 9.4833333 0.277521 9.4861111 0.278579 9.4888889 0.278843 9.4916667 0.278579 9.4944444 0.277256 9.4972222 0.276198 9.5000000 0.275669 9.5027778 0.276198 9.5055556 0.276198 9.5083333 0.276727 9.5111111 0.276198 9.5138889 0.275934 9.5166667 0.275934 9.5194444 0.276992 9.5222222 0.277521 9.5250000 0.277521 9.5277778 0.277521 9.5305556 0.277256 9.5333333 0.276463 9.5361111 0.276727 9.5388889 0.276992 9.5416667 0.276727 9.5444444 0.276463 9.5472222 0.275405 9.5500000 0.275669 9.5527778 0.275405 9.5555556 0.275405 9.5583333 0.275140 9.5611111 0.274612 9.5638889 0.274347 9.5666667 0.274612 9.5694444 0.275140 9.5722222 0.275140 9.5750000 0.275669 9.5777778 0.274876 9.5805556 0.274876 9.5833333 0.274876 9.5861111 0.275140 9.5888889 0.275669 9.5916667 0.275934 9.5944444 0.275405 9.5972222 0.275405 9.6000000 0.274612 9.6027778 0.274876 9.6055556 0.275405 9.6083333 0.274876 9.6111111 0.275669 9.6138889 0.274347 9.6166667 0.274612 9.6194444 0.274347 9.6222222 0.275405 9.6250000 0.275140 9.6277778 0.275405 9.6305556 0.274876 9.6333333 0.274876 9.6361111 0.275140 9.6388889 0.276463 9.6416667 0.276463 9.6444444 0.276198 9.6472222 0.275934 9.6500000 0.275405 9.6527778 0.273554 9.6555556 0.270116 9.6583333 0.266413 9.6611111 0.261124 9.6638889 0.254248 9.6666667 0.244727 9.6694444 0.234942 9.6722222 0.225421 9.6750000 0.220661 9.6777778 0.220132 9.6805556 0.221455 9.6833333 0.221455 9.6861111 0.222512 9.6888889 0.224364 9.6916667 0.224893 9.6944444 0.225421 9.6972222 0.224893 9.7000000 0.224364 9.7027778 0.225950 9.7055556 0.228860 9.7083333 0.230182 9.7111111 0.231769 9.7138889 0.233620 9.7166667 0.236000 9.7194444 0.238645 9.7222222 0.241289 9.7250000 0.244198 9.7277778 0.247901 9.7305556 0.251868 9.7333333 0.255306 9.7361111 0.258744 9.7388889 0.261917 9.7416667 0.265091 9.7444444 0.268264 9.7472222 0.269851 9.7500000 0.273289 9.7527778 0.276992 9.7555556 0.279901 9.7583333 0.281488 9.7611111 0.281752 9.7638889 0.282017 9.7666667 0.283339 9.7694444 0.283339 9.7722222 0.284661 9.7750000 0.284132 9.7777778 0.284926 9.7805556 0.284397 9.7833333 0.285190 9.7861111 0.285719 9.7888889 0.286512 9.7916667 0.285983 9.7944444 0.287306 9.7972222 0.286777 9.8000000 0.287041 9.8027778 0.287835 9.8055556 0.287835 9.8083333 0.288364 9.8111111 0.287570 9.8138889 0.287835 9.8166667 0.287835 9.8194444 0.288099 9.8222222 0.288628 9.8250000 0.288628 9.8277778 0.288099 9.8305556 0.288628 9.8333333 0.288628 9.8361111 0.288628 9.8388889 0.289157 9.8416667 0.288893 9.8444444 0.288628 9.8472222 0.288628 9.8500000 0.288628 9.8527778 0.289686 9.8555556 0.290215 9.8583333 0.290215 9.8611111 0.289157 9.8638889 0.288893 9.8666667 0.288364 9.8694444 0.288628 9.8722222 0.289421 9.8750000 0.288893 9.8777778 0.289421 9.8805556 0.288628 9.8833333 0.288628 9.8861111 0.288628 9.8888889 0.289157 9.8916667 0.289421 9.8944444 0.289421 9.8972222 0.288893 9.9000000 0.288628 9.9027778 0.289421 9.9055556 0.289950 9.9083333 0.289950 9.9111111 0.289950 9.9138889 0.288893 9.9166667 0.288893 9.9194444 0.289157 9.9222222 0.289157 9.9250000 0.288628 9.9277778 0.288628 9.9305556 0.287570 9.9333333 0.287570 9.9361111 0.288628 9.9388889 0.288364 9.9416667 0.288628 9.9444444 0.288364 9.9472222 0.287570 9.9500000 0.287041 9.9527778 0.287306 9.9555556 0.288099 9.9583333 0.288099 9.9611111 0.288099 9.9638889 0.286777 9.9666667 0.287041 9.9694444 0.286777 9.9722222 0.287041 9.9750000 0.286777 9.9777778 0.285983 9.9805556 0.285455 9.9833333 0.284397 9.9861111 0.285719 9.9888889 0.284661 9.9916667 0.284397 9.9944444 0.284397 9.9972222 0.283603 10.0030000 0.300000 10.1470000 0.300000 10.1500000 0.289421 10.1527778 0.289421 10.1555556 0.288628 10.1583333 0.288893 10.1611111 0.290215 10.1638889 0.290479 10.1666667 0.290744 10.1694444 0.290744 10.1722222 0.290215 10.1750000 0.289950 10.1777778 0.289686 10.1805556 0.289421 10.1833333 0.289421 10.1861111 0.289421 10.1888889 0.288364 10.1916667 0.288364 10.1944444 0.288628 10.1972222 0.289421 10.2000000 0.289157 10.2027778 0.289157 10.2055556 0.289421 10.2083333 0.288628 10.2111111 0.289950 10.2138889 0.289950 10.2166667 0.289950 10.2194444 0.289686 10.2222222 0.289686 10.2250000 0.288628 10.2277778 0.289421 10.2305556 0.289950 10.2333333 0.289686 10.2361111 0.289421 10.2388889 0.288099 10.2416667 0.287835 10.2444444 0.288099 10.2472222 0.288893 10.2500000 0.288628 10.2527778 0.288364 10.2555556 0.288628 10.2583333 0.288099 10.2611111 0.288628 10.2638889 0.288893 10.2666667 0.288628 10.2694444 0.288893 10.2722222 0.288628 10.2750000 0.288628 10.2777778 0.289421 10.2805556 0.289421 10.2833333 0.289686 10.2861111 0.289421 10.2888889 0.289421 10.2916667 0.289157 10.2944444 0.288628 10.2972222 0.288893 10.3000000 0.289421 10.3027778 0.289157 10.3055556 0.288364 10.3083333 0.288099 10.3111111 0.288893 10.3138889 0.289421 10.3166667 0.289950 10.3194444 0.289157 10.3222222 0.288628 10.3250000 0.288628 10.3277778 0.289421 10.3305556 0.289421 10.3333333 0.290215 10.3361111 0.289950 10.3388889 0.291008 10.3416667 0.289950 10.3444444 0.289157 10.3472222 0.288099 10.3500000 0.284661 10.3527778 0.280430 10.3555556 0.275934 10.3583333 0.268264 10.3611111 0.261124 10.3638889 0.252132 10.3666667 0.243934 10.3694444 0.240231 10.3722222 0.239702 10.3750000 0.240496 10.3777778 0.241818 10.3805556 0.242612 10.3833333 0.243140 10.3861111 0.243934 10.3888889 0.244727 10.3916667 0.246050 10.3944444 0.247372 10.3972222 0.249488 10.4000000 0.249223 10.4027778 0.250810 10.4055556 0.251868 10.4083333 0.252926 10.4111111 0.254777 10.4138889 0.257157 10.4166667 0.258744 10.4194444 0.260066 10.4222222 0.261917 10.4250000 0.264562 10.4277778 0.268264 10.4305556 0.271702 10.4333333 0.274612 10.4361111 0.277521 10.4388889 0.279372 10.4416667 0.282545 10.4444444 0.285719 10.4472222 0.288628 10.4500000 0.291537 10.4527778 0.293388 10.4555556 0.296033 10.4583333 0.297620 10.4611111 0.299207 10.4638889 0.301322 10.4666667 0.301587 10.4694444 0.301587 10.4722222 0.301587 10.4750000 0.301058 10.4777778 0.301851 10.4805556 0.302645 10.4833333 0.303174 10.4861111 0.303702 10.4888889 0.302645 10.4916667 0.303174 10.4944444 0.304231 10.4972222 0.305289 10.5000000 0.305289 10.5027778 0.305025 10.5055556 0.304760 10.5083333 0.305289 10.5111111 0.305289 10.5138889 0.306347 10.5166667 0.306876 10.5194444 0.306876 10.5222222 0.306083 10.5250000 0.306347 10.5277778 0.307140 10.5305556 0.307405 10.5333333 0.307934 10.5361111 0.307669 10.5388889 0.307140 10.5416667 0.306612 10.5444444 0.306612 10.5472222 0.307140 10.5500000 0.307405 10.5527778 0.307934 10.5555556 0.307405 10.5583333 0.307405 10.5611111 0.307669 10.5638889 0.308198 10.5666667 0.308463 10.5694444 0.308198 10.5722222 0.308198 10.5750000 0.308198 10.5777778 0.308198 10.5805556 0.308727 10.5833333 0.309256 10.5861111 0.309256 10.5888889 0.309256 10.5916667 0.308992 10.5944444 0.309256 10.5972222 0.309256 10.6000000 0.309521 10.6027778 0.308992 10.6055556 0.308463 10.6083333 0.308198 10.6111111 0.308992 10.6138889 0.309256 10.6166667 0.309256 10.6194444 0.309256 10.6222222 0.308992 10.6250000 0.308727 10.6277778 0.308992 10.6305556 0.309256 10.6333333 0.309256 10.6361111 0.309256 10.6388889 0.308727 10.6416667 0.308727 10.6444444 0.308727 10.6472222 0.309256 10.6500000 0.309256 10.6527778 0.308992 10.6555556 0.307934 10.6583333 0.308463 10.6611111 0.308992 10.6638889 0.308992 10.6666667 0.308463 10.6694444 0.308463 10.6722222 0.306876 10.6750000 0.307934 10.6777778 0.308198 10.6805556 0.308198 10.6833333 0.307934 10.6861111 0.307669 10.6888889 0.307140 10.6916667 0.306612 10.6944444 0.307140 10.6972222 0.306612 10.7030000 0.300000 10.8470000 0.300000 10.8500000 0.305025 10.8527778 0.305289 10.8555556 0.305289 10.8583333 0.304760 10.8611111 0.304496 10.8638889 0.305289 10.8666667 0.304760 10.8694444 0.304760 10.8722222 0.303967 10.8750000 0.302645 10.8777778 0.302380 10.8805556 0.302909 10.8833333 0.303438 10.8861111 0.303174 10.8888889 0.303438 10.8916667 0.302645 10.8944444 0.302645 10.8972222 0.303174 10.9000000 0.304231 10.9027778 0.304231 10.9055556 0.304231 10.9083333 0.303438 10.9111111 0.303174 10.9138889 0.303702 10.9166667 0.304231 10.9194444 0.304231 10.9222222 0.304231 10.9250000 0.303174 10.9277778 0.303438 10.9305556 0.303174 10.9333333 0.303438 10.9361111 0.302380 10.9388889 0.302645 10.9416667 0.302380 10.9444444 0.301322 10.9472222 0.302645 10.9500000 0.302380 10.9527778 0.302909 10.9555556 0.302645 10.9583333 0.302116 10.9611111 0.301851 10.9638889 0.302116 10.9666667 0.303174 10.9694444 0.302380 10.9722222 0.302909 10.9750000 0.302645 10.9777778 0.302645 10.9805556 0.303174 10.9833333 0.303702 10.9861111 0.303702 10.9888889 0.302909 10.9916667 0.302116 10.9944444 0.301587 10.9972222 0.302380 11.0000000 0.302909 11.0027778 0.302909 11.0055556 0.302116 11.0083333 0.301851 11.0111111 0.301058 11.0138889 0.301851 11.0166667 0.302645 11.0194444 0.302909 11.0222222 0.302116 11.0250000 0.301851 11.0277778 0.302116 11.0305556 0.302909 11.0333333 0.303702 11.0361111 0.303967 11.0388889 0.303702 11.0416667 0.301587 11.0444444 0.299207 11.0472222 0.296826 11.0500000 0.293917 11.0527778 0.290479 11.0555556 0.284397 11.0583333 0.277785 11.0611111 0.268000 11.0638889 0.259802 11.0666667 0.253719 11.0694444 0.250545 11.0722222 0.249488 11.0750000 0.250545 11.0777778 0.251339 11.0805556 0.252132 11.0833333 0.252661 11.0861111 0.253719 11.0888889 0.255570 11.0916667 0.256364 11.0944444 0.257421 11.0972222 0.258479 11.1000000 0.260595 11.1027778 0.261388 11.1055556 0.262182 11.1083333 0.263240 11.1111111 0.264826 11.1138889 0.267471 11.1166667 0.269851 11.1194444 0.271438 11.1222222 0.273554 11.1250000 0.275405 11.1277778 0.279372 11.1305556 0.283074 11.1333333 0.287306 11.1361111 0.289686 11.1388889 0.292860 11.1416667 0.295504 11.1444444 0.297620 11.1472222 0.300793 11.1500000 0.303967 11.1527778 0.306347 11.1555556 0.308992 11.1583333 0.310314 11.1611111 0.310843 11.1638889 0.311901 11.1666667 0.312165 11.1694444 0.312694 11.1722222 0.312959 11.1750000 0.312694 11.1777778 0.313223 11.1805556 0.314017 11.1833333 0.314545 11.1861111 0.314810 11.1888889 0.314810 11.1916667 0.315074 11.1944444 0.315074 11.1972222 0.315603 11.2000000 0.315868 11.2027778 0.316661 11.2055556 0.315868 11.2083333 0.316132 11.2111111 0.316397 11.2138889 0.316661 11.2166667 0.317455 11.2194444 0.317190 11.2222222 0.317455 11.2250000 0.316661 11.2277778 0.316926 11.2305556 0.317190 11.2333333 0.317190 11.2361111 0.317455 11.2388889 0.317190 11.2416667 0.316661 11.2444444 0.316661 11.2472222 0.317455 11.2500000 0.318512 11.2527778 0.317719 11.2555556 0.317719 11.2583333 0.317983 11.2611111 0.317719 11.2638889 0.318248 11.2666667 0.318248 11.2694444 0.318512 11.2722222 0.318512 11.2750000 0.317719 11.2777778 0.317983 11.2805556 0.318512 11.2833333 0.319041 11.2861111 0.318777 11.2888889 0.318512 11.2916667 0.318248 11.2944444 0.316926 11.2972222 0.317983 11.3000000 0.318512 11.3027778 0.318248 11.3055556 0.317719 11.3083333 0.317719 11.3111111 0.317719 11.3138889 0.318248 11.3166667 0.318777 11.3194444 0.318512 11.3222222 0.318512 11.3250000 0.317983 11.3277778 0.318512 11.3305556 0.318512 11.3333333 0.319041 11.3361111 0.318777 11.3388889 0.318248 11.3416667 0.317190 11.3444444 0.317455 11.3472222 0.317190 11.3500000 0.317983 11.3527778 0.317190 11.3555556 0.317190 11.3583333 0.317190 11.3611111 0.316926 11.3638889 0.317719 11.3666667 0.317719 11.3694444 0.317455 11.3722222 0.316132 11.3750000 0.315868 11.3777778 0.315868 11.3805556 0.316132 11.3833333 0.316132 11.3861111 0.316397 11.3888889 0.315603 11.3916667 0.314810 11.3944444 0.314545 11.3972222 0.314810 11.4030000 0.300000 11.5470000 0.300000 11.5500000 0.309256 11.5527778 0.308727 11.5555556 0.308727 11.5583333 0.309785 11.5611111 0.310843 11.5638889 0.310579 11.5666667 0.310050 11.5694444 0.309521 11.5722222 0.310314 11.5750000 0.311107 11.5777778 0.311107 11.5805556 0.310314 11.5833333 0.310314 11.5861111 0.309785 11.5888889 0.309521 11.5916667 0.310050 11.5944444 0.310314 11.5972222 0.310314 11.6000000 0.309521 11.6027778 0.309521 11.6055556 0.309521 11.6083333 0.309521 11.6111111 0.310050 11.6138889 0.309785 11.6166667 0.309521 11.6194444 0.309256 11.6222222 0.309521 11.6250000 0.308992 11.6277778 0.309256 11.6305556 0.308992 11.6333333 0.308992 11.6361111 0.308727 11.6388889 0.307405 11.6416667 0.308198 11.6444444 0.308727 11.6472222 0.307934 11.6500000 0.308463 11.6527778 0.307669 11.6555556 0.308198 11.6583333 0.308463 11.6611111 0.308992 11.6638889 0.307934 11.6666667 0.308198 11.6694444 0.306876 11.6722222 0.306876 11.6750000 0.307669 11.6777778 0.307934 11.6805556 0.307934 11.6833333 0.308463 11.6861111 0.307140 11.6888889 0.307140 11.6916667 0.308198 11.6944444 0.308463 11.6972222 0.308198 11.7000000 0.308198 11.7027778 0.307934 11.7055556 0.307669 11.7083333 0.308463 11.7111111 0.308727 11.7138889 0.307934 11.7166667 0.307669 11.7194444 0.307669 11.7222222 0.307140 11.7250000 0.306876 11.7277778 0.307669 11.7305556 0.307405 11.7333333 0.307405 11.7361111 0.307140 11.7388889 0.306876 11.7416667 0.307934 11.7444444 0.308198 11.7472222 0.307140 11.7500000 0.304231 11.7527778 0.300000 11.7555556 0.295504 11.7583333 0.291008 11.7611111 0.284926 11.7638889 0.275140 11.7666667 0.265355 11.7694444 0.256628 11.7722222 0.251868 11.7750000 0.251868 11.7777778 0.252661 11.7805556 0.252661 11.7833333 0.252661 11.7861111 0.252926 11.7888889 0.253983 11.7916667 0.256628 11.7944444 0.258215 11.7972222 0.258744 11.8000000 0.259273 11.8027778 0.260066 11.8055556 0.261917 11.8083333 0.264033 11.8111111 0.266678 11.8138889 0.268529 11.8166667 0.270645 11.8194444 0.272496 11.8222222 0.274612 11.8250000 0.278050 11.8277778 0.283339 11.8305556 0.286777 11.8333333 0.289950 11.8361111 0.292860 11.8388889 0.296033 11.8416667 0.298678 11.8444444 0.302380 11.8472222 0.304760 11.8500000 0.306612 11.8527778 0.309256 11.8555556 0.311901 11.8583333 0.313752 11.8611111 0.315603 11.8638889 0.316397 11.8666667 0.316397 11.8694444 0.316926 11.8722222 0.316926 11.8750000 0.318248 11.8777778 0.318777 11.8805556 0.319041 11.8833333 0.319041 11.8861111 0.318777 11.8888889 0.319041 11.8916667 0.319835 11.8944444 0.320364 11.8972222 0.320364 11.9000000 0.320099 11.9027778 0.319835 11.9055556 0.320099 11.9083333 0.321157 11.9111111 0.321686 11.9138889 0.321157 11.9166667 0.321421 11.9194444 0.320893 11.9222222 0.320628 11.9250000 0.321686 11.9277778 0.322744 11.9305556 0.323008 11.9333333 0.323008 11.9361111 0.322744 11.9388889 0.322215 11.9416667 0.322479 11.9444444 0.323802 11.9472222 0.322744 11.9500000 0.322744 11.9527778 0.321686 11.9555556 0.322479 11.9583333 0.323008 11.9611111 0.323537 11.9638889 0.323008 11.9666667 0.322744 11.9694444 0.321950 11.9722222 0.321950 11.9750000 0.323008 11.9777778 0.323802 11.9805556 0.324066 11.9833333 0.322744 11.9861111 0.322215 11.9888889 0.323008 11.9916667 0.323537 11.9944444 0.323802 11.9972222 0.323537 12.0000000 0.323273 12.0027778 0.322479 12.0055556 0.322744 12.0083333 0.323537 12.0111111 0.323537 12.0138889 0.322744 12.0166667 0.322479 12.0194444 0.321421 12.0222222 0.321686 12.0250000 0.322479 12.0277778 0.322479 12.0305556 0.322479 12.0333333 0.322215 12.0361111 0.321950 12.0388889 0.322215 12.0416667 0.322744 12.0444444 0.323273 12.0472222 0.322215 12.0500000 0.322479 12.0527778 0.320893 12.0555556 0.320628 12.0583333 0.320893 12.0611111 0.321157 12.0638889 0.320628 12.0666667 0.320364 12.0694444 0.319570 12.0722222 0.319041 12.0750000 0.319041 12.0777778 0.319835 12.0805556 0.319041 12.0833333 0.318248 12.0861111 0.317719 12.0888889 0.317719 12.0916667 0.317455 12.0944444 0.318248 12.0972222 0.316926 12.1030000 0.300000 12.2470000 0.300000 12.2500000 0.306612 12.2527778 0.306347 12.2555556 0.305554 12.2583333 0.305554 12.2611111 0.305554 12.2638889 0.305818 12.2666667 0.306612 12.2694444 0.307140 12.2722222 0.306612 12.2750000 0.306876 12.2777778 0.307140 12.2805556 0.307934 12.2833333 0.308992 12.2861111 0.308463 12.2888889 0.308727 12.2916667 0.308992 12.2944444 0.308992 12.2972222 0.309256 12.3000000 0.309256 12.3027778 0.309256 12.3055556 0.308198 12.3083333 0.307405 12.3111111 0.307934 12.3138889 0.308727 12.3166667 0.309785 12.3194444 0.309256 12.3222222 0.308992 12.3250000 0.309256 12.3277778 0.309521 12.3305556 0.310050 12.3333333 0.310579 12.3361111 0.310579 12.3388889 0.309785 12.3416667 0.309521 12.3444444 0.308992 12.3472222 0.308992 12.3500000 0.309785 12.3527778 0.309785 12.3555556 0.309785 12.3583333 0.308463 12.3611111 0.307934 12.3638889 0.308992 12.3666667 0.309785 12.3694444 0.309256 12.3722222 0.308727 12.3750000 0.309521 12.3777778 0.309521 12.3805556 0.310314 12.3833333 0.310843 12.3861111 0.311636 12.3888889 0.311107 12.3916667 0.310579 12.3944444 0.309785 12.3972222 0.310843 12.4000000 0.310579 12.4027778 0.311372 12.4055556 0.310843 12.4083333 0.310314 12.4111111 0.310579 12.4138889 0.311107 12.4166667 0.312165 12.4194444 0.311636 12.4222222 0.311901 12.4250000 0.311636 12.4277778 0.311372 12.4305556 0.312165 12.4333333 0.312694 12.4361111 0.312694 12.4388889 0.312165 12.4416667 0.312430 12.4444444 0.312165 12.4472222 0.313752 12.4500000 0.313752 12.4527778 0.311636 12.4555556 0.308198 12.4583333 0.303438 12.4611111 0.298678 12.4638889 0.293917 12.4666667 0.285983 12.4694444 0.276463 12.4722222 0.265355 12.4750000 0.257686 12.4777778 0.255570 12.4805556 0.256893 12.4833333 0.258215 12.4861111 0.257950 12.4888889 0.259008 12.4916667 0.259537 12.4944444 0.260066 12.4972222 0.261124 12.5000000 0.262711 12.5027778 0.262711 12.5055556 0.264033 12.5083333 0.265620 12.5111111 0.267471 12.5138889 0.269322 12.5166667 0.272231 12.5194444 0.274876 12.5222222 0.276463 12.5250000 0.279372 12.5277778 0.283074 12.5305556 0.287306 12.5333333 0.292066 12.5361111 0.296033 12.5388889 0.299207 12.5416667 0.302645 12.5444444 0.305554 12.5472222 0.309521 12.5500000 0.312430 12.5527778 0.314545 12.5555556 0.317455 12.5583333 0.319041 12.5611111 0.320628 12.5638889 0.322479 12.5666667 0.324066 12.5694444 0.323802 12.5722222 0.324860 12.5750000 0.324066 12.5777778 0.324066 12.5805556 0.325388 12.5833333 0.325917 12.5861111 0.326182 12.5888889 0.326446 12.5916667 0.326182 12.5944444 0.325917 12.5972222 0.327240 12.6000000 0.327769 12.6027778 0.328033 12.6055556 0.328562 12.6083333 0.327769 12.6111111 0.328033 12.6138889 0.328562 12.6166667 0.328826 12.6194444 0.329355 12.6222222 0.328562 12.6250000 0.328562 12.6277778 0.328298 12.6305556 0.329355 12.6333333 0.329355 12.6361111 0.329355 12.6388889 0.329091 12.6416667 0.329620 12.6444444 0.329091 12.6472222 0.330149 12.6500000 0.330942 12.6527778 0.330678 12.6555556 0.330149 12.6583333 0.330149 12.6611111 0.329620 12.6638889 0.330413 12.6666667 0.330413 12.6694444 0.330149 12.6722222 0.329884 12.6750000 0.329620 12.6777778 0.329884 12.6805556 0.330149 12.6833333 0.330678 12.6861111 0.330678 12.6888889 0.330413 12.6916667 0.330413 12.6944444 0.330149 12.6972222 0.330413 12.7000000 0.330678 12.7027778 0.330678 12.7055556 0.331207 12.7083333 0.330413 12.7111111 0.330678 12.7138889 0.330942 12.7166667 0.332264 12.7194444 0.331471 12.7222222 0.330678 12.7250000 0.329884 12.7277778 0.330413 12.7305556 0.330149 12.7333333 0.330678 12.7361111 0.329620 12.7388889 0.329620 12.7416667 0.329091 12.7444444 0.329091 12.7472222 0.329620 12.7500000 0.330149 12.7527778 0.329620 12.7555556 0.328826 12.7583333 0.329091 12.7611111 0.328562 12.7638889 0.329091 12.7666667 0.329620 12.7694444 0.329355 12.7722222 0.328562 12.7750000 0.327769 12.7777778 0.326711 12.7805556 0.326975 12.7833333 0.327240 12.7861111 0.326711 12.7888889 0.326182 12.7916667 0.325124 12.7944444 0.324595 12.7972222 0.324331 12.8030000 0.300000 12.9470000 0.300000 12.9500000 0.316926 12.9527778 0.316661 12.9555556 0.316926 12.9583333 0.317455 12.9611111 0.318248 12.9638889 0.317983 12.9666667 0.318512 12.9694444 0.318248 12.9722222 0.319306 12.9750000 0.319835 12.9777778 0.320628 12.9805556 0.320364 12.9833333 0.319835 12.9861111 0.319041 12.9888889 0.317983 12.9916667 0.318248 12.9944444 0.319041 12.9972222 0.318777 13.0000000 0.317719 13.0027778 0.317719 13.0055556 0.317190 13.0083333 0.317719 13.0111111 0.318777 13.0138889 0.318777 13.0166667 0.317719 13.0194444 0.318512 13.0222222 0.317983 13.0250000 0.317455 13.0277778 0.317983 13.0305556 0.318512 13.0333333 0.317719 13.0361111 0.317190 13.0388889 0.317190 13.0416667 0.316661 13.0444444 0.317190 13.0472222 0.316661 13.0500000 0.315868 13.0527778 0.315603 13.0555556 0.315868 13.0583333 0.315868 13.0611111 0.316397 13.0638889 0.316926 13.0666667 0.316397 13.0694444 0.315868 13.0722222 0.315868 13.0750000 0.316132 13.0777778 0.317455 13.0805556 0.316926 13.0833333 0.316132 13.0861111 0.315868 13.0888889 0.315868 13.0916667 0.316132 13.0944444 0.316661 13.0972222 0.316926 13.1000000 0.316132 13.1027778 0.315603 13.1055556 0.315339 13.1083333 0.315603 13.1111111 0.316132 13.1138889 0.315603 13.1166667 0.315603 13.1194444 0.315074 13.1222222 0.314810 13.1250000 0.315339 13.1277778 0.316397 13.1305556 0.316132 13.1333333 0.315868 13.1361111 0.315074 13.1388889 0.315868 13.1416667 0.316926 13.1444444 0.317983 13.1472222 0.316132 13.1500000 0.313223 13.1527778 0.309256 13.1555556 0.304231 13.1583333 0.298413 13.1611111 0.291802 13.1638889 0.282545 13.1666667 0.272760 13.1694444 0.263769 13.1722222 0.259008 13.1750000 0.257686 13.1777778 0.258479 13.1805556 0.258744 13.1833333 0.258744 13.1861111 0.258479 13.1888889 0.259273 13.1916667 0.260331 13.1944444 0.262182 13.1972222 0.262711 13.2000000 0.262711 13.2027778 0.262975 13.2055556 0.264562 13.2083333 0.266149 13.2111111 0.268264 13.2138889 0.270116 13.2166667 0.272231 13.2194444 0.274347 13.2222222 0.276727 13.2250000 0.280694 13.2277778 0.285190 13.2305556 0.289157 13.2333333 0.293917 13.2361111 0.297355 13.2388889 0.301322 13.2416667 0.305025 13.2444444 0.309785 13.2472222 0.312694 13.2500000 0.315603 13.2527778 0.318248 13.2555556 0.320628 13.2583333 0.324331 13.2611111 0.325653 13.2638889 0.326182 13.2666667 0.325917 13.2694444 0.325917 13.2722222 0.326711 13.2750000 0.327240 13.2777778 0.327769 13.2805556 0.328562 13.2833333 0.328033 13.2861111 0.327769 13.2888889 0.328298 13.2916667 0.329355 13.2944444 0.329620 13.2972222 0.329884 13.3000000 0.329091 13.3027778 0.329091 13.3055556 0.329620 13.3083333 0.330149 13.3111111 0.330942 13.3138889 0.331207 13.3166667 0.330678 13.3194444 0.330942 13.3222222 0.330942 13.3250000 0.332529 13.3277778 0.332264 13.3305556 0.331736 13.3333333 0.331736 13.3361111 0.330942 13.3388889 0.330678 13.3416667 0.331736 13.3444444 0.332793 13.3472222 0.332264 13.3500000 0.332000 13.3527778 0.331207 13.3555556 0.332000 13.3583333 0.332793 13.3611111 0.332793 13.3638889 0.332264 13.3666667 0.332000 13.3694444 0.332529 13.3722222 0.333322 13.3750000 0.333587 13.3777778 0.333587 13.3805556 0.333851 13.3833333 0.333322 13.3861111 0.332529 13.3888889 0.332264 13.3916667 0.333058 13.3944444 0.333058 13.3972222 0.333587 13.4000000 0.332793 13.4027778 0.333058 13.4055556 0.332529 13.4083333 0.332793 13.4111111 0.333587 13.4138889 0.333851 13.4166667 0.332793 13.4194444 0.332793 13.4222222 0.333058 13.4250000 0.333587 13.4277778 0.334116 13.4305556 0.334116 13.4333333 0.333058 13.4361111 0.332529 13.4388889 0.332529 13.4416667 0.332000 13.4444444 0.332793 13.4472222 0.332529 13.4500000 0.331736 13.4527778 0.330942 13.4555556 0.330942 13.4583333 0.330942 13.4611111 0.331207 13.4638889 0.330942 13.4666667 0.330678 13.4694444 0.329884 13.4722222 0.329884 13.4750000 0.330678 13.4777778 0.330678 13.4805556 0.329884 13.4833333 0.328826 13.4861111 0.328562 13.4888889 0.328033 13.4916667 0.328298 13.4944444 0.328033 13.4972222 0.326711 13.5030000 0.300000 13.6470000 0.300000 13.6500000 0.313752 13.6527778 0.314017 13.6555556 0.315074 13.6583333 0.314810 13.6611111 0.314810 13.6638889 0.314810 13.6666667 0.315868 13.6694444 0.315868 13.6722222 0.316397 13.6750000 0.316132 13.6777778 0.315603 13.6805556 0.315603 13.6833333 0.315603 13.6861111 0.315868 13.6888889 0.315339 13.6916667 0.314810 13.6944444 0.314017 13.6972222 0.314545 13.7000000 0.314545 13.7027778 0.315339 13.7055556 0.315603 13.7083333 0.315339 13.7111111 0.315074 13.7138889 0.315074 13.7166667 0.316132 13.7194444 0.315868 13.7222222 0.315603 13.7250000 0.314017 13.7277778 0.313488 13.7305556 0.313752 13.7333333 0.314017 13.7361111 0.314281 13.7388889 0.314017 13.7416667 0.313488 13.7444444 0.312430 13.7472222 0.312165 13.7500000 0.312430 13.7527778 0.313752 13.7555556 0.313488 13.7583333 0.312959 13.7611111 0.312165 13.7638889 0.312694 13.7666667 0.312694 13.7694444 0.313488 13.7722222 0.313488 13.7750000 0.313488 13.7777778 0.312694 13.7805556 0.312694 13.7833333 0.312694 13.7861111 0.313223 13.7888889 0.313223 13.7916667 0.312165 13.7944444 0.312165 13.7972222 0.312165 13.8000000 0.312694 13.8027778 0.313223 13.8055556 0.312430 13.8083333 0.312165 13.8111111 0.311636 13.8138889 0.312165 13.8166667 0.313223 13.8194444 0.313752 13.8222222 0.313223 13.8250000 0.312694 13.8277778 0.311901 13.8305556 0.312694 13.8333333 0.313488 13.8361111 0.313488 13.8388889 0.313752 13.8416667 0.312959 13.8444444 0.312165 13.8472222 0.310314 13.8500000 0.308992 13.8527778 0.306083 13.8555556 0.303702 13.8583333 0.298942 13.8611111 0.292595 13.8638889 0.284397 13.8666667 0.275934 13.8694444 0.268264 13.8722222 0.264298 13.8750000 0.262446 13.8777778 0.262182 13.8805556 0.263240 13.8833333 0.263504 13.8861111 0.265091 13.8888889 0.265620 13.8916667 0.266942 13.8944444 0.267471 13.8972222 0.269587 13.9000000 0.271438 13.9027778 0.272496 13.9055556 0.274347 13.9083333 0.275140 13.9111111 0.276198 13.9138889 0.278843 13.9166667 0.280959 13.9194444 0.282810 13.9222222 0.283603 13.9250000 0.285719 13.9277778 0.288099 13.9305556 0.292860 13.9333333 0.296562 13.9361111 0.300000 13.9388889 0.301851 13.9416667 0.304760 13.9444444 0.306083 13.9472222 0.309256 13.9500000 0.312694 13.9527778 0.315074 13.9555556 0.316926 13.9583333 0.318512 13.9611111 0.318512 13.9638889 0.319306 13.9666667 0.320364 13.9694444 0.321950 13.9722222 0.321950 13.9750000 0.321686 13.9777778 0.321157 13.9805556 0.321950 13.9833333 0.323008 13.9861111 0.324331 13.9888889 0.323273 13.9916667 0.324066 13.9944444 0.323802 13.9972222 0.323802 14.0000000 0.324595 14.0027778 0.325124 14.0055556 0.325124 14.0083333 0.324595 14.0111111 0.324595 14.0138889 0.324331 14.0166667 0.325124 14.0194444 0.325653 14.0222222 0.325653 14.0250000 0.325388 14.0277778 0.324860 14.0305556 0.325124 14.0333333 0.326182 14.0361111 0.326711 14.0388889 0.327504 14.0416667 0.327769 14.0444444 0.328298 14.0472222 0.328826 14.0500000 0.330149 14.0527778 0.330413 14.0555556 0.330149 14.0583333 0.329620 14.0611111 0.329091 14.0638889 0.329620 14.0666667 0.329620 14.0694444 0.330149 14.0722222 0.330149 14.0750000 0.329620 14.0777778 0.329091 14.0805556 0.329620 14.0833333 0.330678 14.0861111 0.331471 14.0888889 0.330678 14.0916667 0.330149 14.0944444 0.329355 14.0972222 0.329884 14.1000000 0.330942 14.1027778 0.331736 14.1055556 0.331471 14.1083333 0.330942 14.1111111 0.330149 14.1138889 0.330413 14.1166667 0.330149 14.1194444 0.330678 14.1222222 0.330413 14.1250000 0.329091 14.1277778 0.329620 14.1305556 0.329620 14.1333333 0.329884 14.1361111 0.330149 14.1388889 0.329884 14.1416667 0.329355 14.1444444 0.329355 14.1472222 0.329355 14.1500000 0.329620 14.1527778 0.329884 14.1555556 0.329355 14.1583333 0.329091 14.1611111 0.328562 14.1638889 0.328562 14.1666667 0.328562 14.1694444 0.329091 14.1722222 0.327769 14.1750000 0.326975 14.1777778 0.326711 14.1805556 0.326711 14.1833333 0.326182 14.1861111 0.326182 14.1888889 0.325653 14.1916667 0.325388 14.1944444 0.324331 14.1972222 0.324066 14.2030000 0.300000 14.3470000 0.300000 14.3500000 0.320099 14.3527778 0.321157 14.3555556 0.322215 14.3583333 0.322215 14.3611111 0.320893 14.3638889 0.317983 14.3666667 0.315074 14.3694444 0.315339 14.3722222 0.317983 14.3750000 0.319306 14.3777778 0.319041 14.3805556 0.319570 14.3833333 0.318512 14.3861111 0.319306 14.3888889 0.320099 14.3916667 0.320628 14.3944444 0.320099 14.3972222 0.319306 14.4000000 0.319306 14.4027778 0.319306 14.4055556 0.320364 14.4083333 0.319835 14.4111111 0.320099 14.4138889 0.319570 14.4166667 0.319041 14.4194444 0.319041 14.4222222 0.319570 14.4250000 0.320099 14.4277778 0.319835 14.4305556 0.319306 14.4333333 0.317983 14.4361111 0.318777 14.4388889 0.319041 14.4416667 0.319570 14.4444444 0.319835 14.4472222 0.319306 14.4500000 0.318512 14.4527778 0.318512 14.4555556 0.319041 14.4583333 0.319041 14.4611111 0.318777 14.4638889 0.318777 14.4666667 0.318512 14.4694444 0.317983 14.4722222 0.318777 14.4750000 0.319570 14.4777778 0.319041 14.4805556 0.318512 14.4833333 0.317983 14.4861111 0.318512 14.4888889 0.319570 14.4916667 0.319835 14.4944444 0.319835 14.4972222 0.319570 14.5000000 0.318248 14.5027778 0.318512 14.5055556 0.319835 14.5083333 0.320099 14.5111111 0.319570 14.5138889 0.318777 14.5166667 0.318512 14.5194444 0.318248 14.5222222 0.319306 14.5250000 0.319041 14.5277778 0.319041 14.5305556 0.317983 14.5333333 0.318248 14.5361111 0.318777 14.5388889 0.319835 14.5416667 0.320099 14.5444444 0.317983 14.5472222 0.314545 14.5500000 0.311636 14.5527778 0.307669 14.5555556 0.303702 14.5583333 0.297620 14.5611111 0.288893 14.5638889 0.278314 14.5666667 0.269851 14.5694444 0.266149 14.5722222 0.265620 14.5750000 0.267471 14.5777778 0.267207 14.5805556 0.267471 14.5833333 0.266942 14.5861111 0.268264 14.5888889 0.269851 14.5916667 0.271438 14.5944444 0.272760 14.5972222 0.273554 14.6000000 0.273554 14.6027778 0.275669 14.6055556 0.277256 14.6083333 0.279636 14.6111111 0.281223 14.6138889 0.283603 14.6166667 0.284661 14.6194444 0.287041 14.6222222 0.289950 14.6250000 0.293124 14.6277778 0.297091 14.6305556 0.300793 14.6333333 0.302909 14.6361111 0.306612 14.6388889 0.309785 14.6416667 0.312430 14.6444444 0.315603 14.6472222 0.318777 14.6500000 0.320893 14.6527778 0.323273 14.6555556 0.325917 14.6583333 0.328562 14.6611111 0.329620 14.6638889 0.329620 14.6666667 0.330149 14.6694444 0.330413 14.6722222 0.331471 14.6750000 0.332529 14.6777778 0.332793 14.6805556 0.333058 14.6833333 0.332793 14.6861111 0.333322 14.6888889 0.334116 14.6916667 0.333587 14.6944444 0.333851 14.6972222 0.333587 14.7000000 0.333587 14.7027778 0.334380 14.7055556 0.335438 14.7083333 0.335174 14.7111111 0.335967 14.7138889 0.334909 14.7166667 0.335174 14.7194444 0.335438 14.7222222 0.335438 14.7250000 0.336231 14.7277778 0.336496 14.7305556 0.336231 14.7333333 0.336496 14.7361111 0.336231 14.7388889 0.336231 14.7416667 0.337289 14.7444444 0.337289 14.7472222 0.336496 14.7500000 0.335702 14.7527778 0.336231 14.7555556 0.336760 14.7583333 0.337025 14.7611111 0.337025 14.7638889 0.336760 14.7666667 0.335702 14.7694444 0.336760 14.7722222 0.337818 14.7750000 0.337554 14.7777778 0.336760 14.7805556 0.337025 14.7833333 0.336496 14.7861111 0.336496 14.7888889 0.338347 14.7916667 0.338612 14.7944444 0.338876 14.7972222 0.337818 14.8000000 0.337554 14.8027778 0.337554 14.8055556 0.338612 14.8083333 0.338876 14.8111111 0.338083 14.8138889 0.337818 14.8166667 0.337025 14.8194444 0.337289 14.8222222 0.336760 14.8250000 0.337554 14.8277778 0.336760 14.8305556 0.336760 14.8333333 0.336496 14.8361111 0.336231 14.8388889 0.337025 14.8416667 0.337818 14.8444444 0.337554 14.8472222 0.337289 14.8500000 0.336760 14.8527778 0.336496 14.8555556 0.337289 14.8583333 0.337289 14.8611111 0.337025 14.8638889 0.336760 14.8666667 0.336231 14.8694444 0.335702 14.8722222 0.335967 14.8750000 0.336231 14.8777778 0.335702 14.8805556 0.334645 14.8833333 0.333851 14.8861111 0.334116 14.8888889 0.334380 14.8916667 0.334116 14.8944444 0.333322 14.8972222 0.332793 14.9030000 0.300000 15.0470000 0.300000 15.0500000 0.328298 15.0527778 0.329091 15.0555556 0.329355 15.0583333 0.329091 15.0611111 0.328298 15.0638889 0.329091 15.0666667 0.329091 15.0694444 0.329620 15.0722222 0.330942 15.0750000 0.330413 15.0777778 0.330413 15.0805556 0.329091 15.0833333 0.329091 15.0861111 0.329355 15.0888889 0.329884 15.0916667 0.329620 15.0944444 0.328826 15.0972222 0.328562 15.1000000 0.329620 15.1027778 0.330149 15.1055556 0.330149 15.1083333 0.329884 15.1111111 0.329355 15.1138889 0.328826 15.1166667 0.328826 15.1194444 0.329091 15.1222222 0.328826 15.1250000 0.329091 15.1277778 0.328298 15.1305556 0.327504 15.1333333 0.328562 15.1361111 0.328298 15.1388889 0.327769 15.1416667 0.327504 15.1444444 0.326182 15.1472222 0.326711 15.1500000 0.327240 15.1527778 0.328033 15.1555556 0.328033 15.1583333 0.328298 15.1611111 0.327504 15.1638889 0.327240 15.1666667 0.327504 15.1694444 0.327240 15.1722222 0.328033 15.1750000 0.326975 15.1777778 0.327240 15.1805556 0.326446 15.1833333 0.326711 15.1861111 0.327504 15.1888889 0.327240 15.1916667 0.327240 15.1944444 0.326446 15.1972222 0.326446 15.2000000 0.326711 15.2027778 0.328033 15.2055556 0.328033 15.2083333 0.328033 15.2111111 0.328562 15.2138889 0.328033 15.2166667 0.327240 15.2194444 0.328033 15.2222222 0.328033 15.2250000 0.328033 15.2277778 0.328033 15.2305556 0.326975 15.2333333 0.327240 15.2361111 0.327240 15.2388889 0.328033 15.2416667 0.328298 15.2444444 0.328033 15.2472222 0.326182 15.2500000 0.323537 15.2527778 0.320099 15.2555556 0.316132 15.2583333 0.311372 15.2611111 0.303438 15.2638889 0.294446 15.2666667 0.284661 15.2694444 0.277521 15.2722222 0.274347 15.2750000 0.273818 15.2777778 0.274876 15.2805556 0.274083 15.2833333 0.274876 15.2861111 0.276198 15.2888889 0.276727 15.2916667 0.278579 15.2944444 0.279372 15.2972222 0.279636 15.3000000 0.280959 15.3027778 0.282810 15.3055556 0.283339 15.3083333 0.285455 15.3111111 0.286512 15.3138889 0.288628 15.3166667 0.291537 15.3194444 0.294446 15.3222222 0.296298 15.3250000 0.298413 15.3277778 0.301851 15.3305556 0.305818 15.3333333 0.309521 15.3361111 0.312694 15.3388889 0.316132 15.3416667 0.319306 15.3444444 0.321686 15.3472222 0.323273 15.3500000 0.326711 15.3527778 0.329355 15.3555556 0.331736 15.3583333 0.334116 15.3611111 0.335174 15.3638889 0.336231 15.3666667 0.337025 15.3694444 0.337818 15.3722222 0.338876 15.3750000 0.339140 15.3777778 0.338876 15.3805556 0.339405 15.3833333 0.340463 15.3861111 0.341521 15.3888889 0.342050 15.3916667 0.342050 15.3944444 0.342050 15.3972222 0.341521 15.4000000 0.342050 15.4027778 0.342843 15.4055556 0.343372 15.4083333 0.342579 15.4111111 0.342314 15.4138889 0.342314 15.4166667 0.343107 15.4194444 0.343372 15.4222222 0.343901 15.4250000 0.343372 15.4277778 0.343372 15.4305556 0.343107 15.4333333 0.343107 15.4361111 0.343901 15.4388889 0.344165 15.4416667 0.344694 15.4444444 0.344694 15.4472222 0.344165 15.4500000 0.344959 15.4527778 0.345488 15.4555556 0.345223 15.4583333 0.345488 15.4611111 0.344959 15.4638889 0.344430 15.4666667 0.344694 15.4694444 0.345488 15.4722222 0.344959 15.4750000 0.345223 15.4777778 0.344959 15.4805556 0.344165 15.4833333 0.344959 15.4861111 0.344959 15.4888889 0.345752 15.4916667 0.344959 15.4944444 0.344959 15.4972222 0.344430 15.5000000 0.345223 15.5027778 0.345752 15.5055556 0.346017 15.5083333 0.346281 15.5111111 0.345488 15.5138889 0.345223 15.5166667 0.344959 15.5194444 0.344959 15.5222222 0.345223 15.5250000 0.345488 15.5277778 0.345223 15.5305556 0.344165 15.5333333 0.344959 15.5361111 0.345223 15.5388889 0.344694 15.5416667 0.344694 15.5444444 0.343901 15.5472222 0.343901 15.5500000 0.343901 15.5527778 0.344430 15.5555556 0.344430 15.5583333 0.344694 15.5611111 0.344430 15.5638889 0.343372 15.5666667 0.344165 15.5694444 0.344694 15.5722222 0.345223 15.5750000 0.344165 15.5777778 0.343372 15.5805556 0.342579 15.5833333 0.343107 15.5861111 0.342579 15.5888889 0.343107 15.5916667 0.342843 15.5944444 0.341785 15.5972222 0.341256 15.6030000 0.300000 15.7470000 0.300000 15.7500000 0.326975 15.7527778 0.326975 15.7555556 0.326446 15.7583333 0.326446 15.7611111 0.327240 15.7638889 0.328562 15.7666667 0.328562 15.7694444 0.328562 15.7722222 0.328562 15.7750000 0.328562 15.7777778 0.328562 15.7805556 0.329091 15.7833333 0.329620 15.7861111 0.328826 15.7888889 0.327769 15.7916667 0.326975 15.7944444 0.326975 15.7972222 0.327769 15.8000000 0.328298 15.8027778 0.327769 15.8055556 0.327504 15.8083333 0.327240 15.8111111 0.326446 15.8138889 0.327769 15.8166667 0.328033 15.8194444 0.328033 15.8222222 0.327240 15.8250000 0.327240 15.8277778 0.327240 15.8305556 0.327504 15.8333333 0.328033 15.8361111 0.327240 15.8388889 0.326182 15.8416667 0.325917 15.8444444 0.325917 15.8472222 0.326182 15.8500000 0.326182 15.8527778 0.325653 15.8555556 0.325124 15.8583333 0.325124 15.8611111 0.324860 15.8638889 0.325653 15.8666667 0.325124 15.8694444 0.324860 15.8722222 0.325653 15.8750000 0.325388 15.8777778 0.325388 15.8805556 0.325653 15.8833333 0.325388 15.8861111 0.325653 15.8888889 0.325653 15.8916667 0.324595 15.8944444 0.325124 15.8972222 0.325124 15.9000000 0.324595 15.9027778 0.324331 15.9055556 0.324066 15.9083333 0.323537 15.9111111 0.324331 15.9138889 0.324066 15.9166667 0.323802 15.9194444 0.324860 15.9222222 0.323802 15.9250000 0.323273 15.9277778 0.323802 15.9305556 0.324066 15.9333333 0.324860 15.9361111 0.324595 15.9388889 0.324595 15.9416667 0.324331 15.9444444 0.324595 15.9472222 0.324595 15.9500000 0.323802 15.9527778 0.320893 15.9555556 0.317719 15.9583333 0.314281 15.9611111 0.310843 15.9638889 0.305554 15.9666667 0.298413 15.9694444 0.288099 15.9722222 0.279107 15.9750000 0.274347 15.9777778 0.274083 15.9805556 0.275405 15.9833333 0.276727 15.9861111 0.277256 15.9888889 0.277521 15.9916667 0.279372 15.9944444 0.281752 15.9972222 0.283339 16.0000000 0.284132 16.0027778 0.285190 16.0055556 0.285983 16.0083333 0.287570 16.0111111 0.289421 16.0138889 0.291008 16.0166667 0.292860 16.0194444 0.294182 16.0222222 0.294182 16.0250000 0.296298 16.0277778 0.299736 16.0305556 0.303702 16.0333333 0.307140 16.0361111 0.308727 16.0388889 0.311107 16.0416667 0.312959 16.0444444 0.316661 16.0472222 0.320893 16.0500000 0.323802 16.0527778 0.325917 16.0555556 0.327240 16.0583333 0.327769 16.0611111 0.328826 16.0638889 0.329620 16.0666667 0.330678 16.0694444 0.330149 16.0722222 0.330413 16.0750000 0.329884 16.0777778 0.330942 16.0805556 0.331207 16.0833333 0.331471 16.0861111 0.332000 16.0888889 0.332000 16.0916667 0.331736 16.0944444 0.332264 16.0972222 0.333587 16.1000000 0.333058 16.1027778 0.333058 16.1055556 0.332793 16.1083333 0.332529 16.1111111 0.333322 16.1138889 0.333587 16.1166667 0.333587 16.1194444 0.333322 16.1222222 0.333587 16.1250000 0.333058 16.1277778 0.333587 16.1305556 0.333587 16.1333333 0.334116 16.1361111 0.333851 16.1388889 0.333058 16.1416667 0.333322 16.1444444 0.334116 16.1472222 0.334116 16.1500000 0.334380 16.1527778 0.334645 16.1555556 0.334380 16.1583333 0.333587 16.1611111 0.334116 16.1638889 0.335174 16.1666667 0.334909 16.1694444 0.334645 16.1722222 0.333587 16.1750000 0.333851 16.1777778 0.334380 16.1805556 0.334116 16.1833333 0.334380 16.1861111 0.334116 16.1888889 0.333851 16.1916667 0.333851 16.1944444 0.333851 16.1972222 0.334645 16.2000000 0.335438 16.2027778 0.335174 16.2055556 0.334380 16.2083333 0.333851 16.2111111 0.334116 16.2138889 0.334645 16.2166667 0.333851 16.2194444 0.333587 16.2222222 0.332000 16.2250000 0.332264 16.2277778 0.332529 16.2305556 0.332264 16.2333333 0.332264 16.2361111 0.332264 16.2388889 0.331471 16.2416667 0.330942 16.2444444 0.330942 16.2472222 0.331471 16.2500000 0.331736 16.2527778 0.331207 16.2555556 0.330942 16.2583333 0.329884 16.2611111 0.329884 16.2638889 0.330149 16.2666667 0.330149 16.2694444 0.329620 16.2722222 0.328562 16.2750000 0.327504 16.2777778 0.327504 16.2805556 0.327504 16.2833333 0.327769 16.2861111 0.326711 16.2888889 0.326182 16.2916667 0.325388 16.2944444 0.325124 16.2972222 0.325653 16.3030000 0.300000 16.4470000 0.300000 16.4500000 0.312694 16.4527778 0.311901 16.4555556 0.311372 16.4583333 0.311372 16.4611111 0.311901 16.4638889 0.312430 16.4666667 0.312430 16.4694444 0.312430 16.4722222 0.311636 16.4750000 0.312694 16.4777778 0.313223 16.4805556 0.313752 16.4833333 0.314017 16.4861111 0.313752 16.4888889 0.313488 16.4916667 0.313488 16.4944444 0.313752 16.4972222 0.313223 16.5000000 0.313488 16.5027778 0.312165 16.5055556 0.311901 16.5083333 0.311901 16.5111111 0.312694 16.5138889 0.312165 16.5166667 0.312694 16.5194444 0.311901 16.5222222 0.312165 16.5250000 0.311901 16.5277778 0.312165 16.5305556 0.311901 16.5333333 0.311372 16.5361111 0.310579 16.5388889 0.311107 16.5416667 0.311636 16.5444444 0.312165 16.5472222 0.311372 16.5500000 0.311107 16.5527778 0.310050 16.5555556 0.309785 16.5583333 0.310843 16.5611111 0.311107 16.5638889 0.310579 16.5666667 0.310314 16.5694444 0.310579 16.5722222 0.309256 16.5750000 0.309521 16.5777778 0.310314 16.5805556 0.310314 16.5833333 0.310050 16.5861111 0.309521 16.5888889 0.310314 16.5916667 0.309521 16.5944444 0.310050 16.5972222 0.310314 16.6000000 0.310314 16.6027778 0.310050 16.6055556 0.310314 16.6083333 0.310314 16.6111111 0.310579 16.6138889 0.310050 16.6166667 0.309785 16.6194444 0.308992 16.6222222 0.309256 16.6250000 0.309521 16.6277778 0.309521 16.6305556 0.309785 16.6333333 0.308992 16.6361111 0.308992 16.6388889 0.308463 16.6416667 0.309256 16.6444444 0.309521 16.6472222 0.309256 16.6500000 0.308463 16.6527778 0.305554 16.6555556 0.300793 16.6583333 0.297355 16.6611111 0.291273 16.6638889 0.283603 16.6666667 0.274347 16.6694444 0.264298 16.6722222 0.256364 16.6750000 0.254248 16.6777778 0.254248 16.6805556 0.255306 16.6833333 0.255835 16.6861111 0.255306 16.6888889 0.256099 16.6916667 0.257686 16.6944444 0.259537 16.6972222 0.260860 16.7000000 0.261388 16.7027778 0.262446 16.7055556 0.262975 16.7083333 0.265091 16.7111111 0.266678 16.7138889 0.268529 16.7166667 0.271174 16.7194444 0.272496 16.7222222 0.273289 16.7250000 0.276463 16.7277778 0.280694 16.7305556 0.284926 16.7333333 0.288628 16.7361111 0.291273 16.7388889 0.293388 16.7416667 0.297620 16.7444444 0.300793 16.7472222 0.303967 16.7500000 0.306612 16.7527778 0.309521 16.7555556 0.311107 16.7583333 0.314017 16.7611111 0.316397 16.7638889 0.317455 16.7666667 0.318248 16.7694444 0.318512 16.7722222 0.318248 16.7750000 0.318248 16.7777778 0.320099 16.7805556 0.320628 16.7833333 0.320099 16.7861111 0.319306 16.7888889 0.319570 16.7916667 0.319835 16.7944444 0.321157 16.7972222 0.321686 16.8000000 0.320628 16.8027778 0.320628 16.8055556 0.320364 16.8083333 0.321157 16.8111111 0.322215 16.8138889 0.322215 16.8166667 0.323008 16.8194444 0.322215 16.8222222 0.321686 16.8250000 0.322479 16.8277778 0.323273 16.8305556 0.322744 16.8333333 0.323008 16.8361111 0.322215 16.8388889 0.321950 16.8416667 0.322215 16.8444444 0.322479 16.8472222 0.322479 16.8500000 0.322215 16.8527778 0.322744 16.8555556 0.322215 16.8583333 0.322479 16.8611111 0.323537 16.8638889 0.322479 16.8666667 0.322744 16.8694444 0.322744 16.8722222 0.321950 16.8750000 0.322215 16.8777778 0.322744 16.8805556 0.323008 16.8833333 0.323008 16.8861111 0.322215 16.8888889 0.321950 16.8916667 0.322215 16.8944444 0.322744 16.8972222 0.322744 16.9000000 0.322744 16.9027778 0.321950 16.9055556 0.321421 16.9083333 0.321950 16.9111111 0.322744 16.9138889 0.322479 16.9166667 0.322215 16.9194444 0.321421 16.9222222 0.321686 16.9250000 0.321421 16.9277778 0.322215 16.9305556 0.322479 16.9333333 0.321950 16.9361111 0.321157 16.9388889 0.321421 16.9416667 0.321421 16.9444444 0.321686 16.9472222 0.321950 16.9500000 0.321157 16.9527778 0.320364 16.9555556 0.319570 16.9583333 0.319306 16.9611111 0.320364 16.9638889 0.320628 16.9666667 0.319835 16.9694444 0.318512 16.9722222 0.318777 16.9750000 0.317983 16.9777778 0.319306 16.9805556 0.318512 16.9833333 0.318512 16.9861111 0.317455 16.9888889 0.317190 16.9916667 0.317455 16.9944444 0.317190 16.9972222 0.317190 17.0030000 0.300000 17.1470000 0.300000 17.1500000 0.301851 17.1527778 0.302909 17.1555556 0.303438 17.1583333 0.303438 17.1611111 0.303438 17.1638889 0.303967 17.1666667 0.304496 17.1694444 0.304496 17.1722222 0.305025 17.1750000 0.304760 17.1777778 0.303967 17.1805556 0.303438 17.1833333 0.303438 17.1861111 0.303702 17.1888889 0.303967 17.1916667 0.303174 17.1944444 0.303174 17.1972222 0.302909 17.2000000 0.303174 17.2027778 0.303967 17.2055556 0.303702 17.2083333 0.303174 17.2111111 0.302116 17.2138889 0.303174 17.2166667 0.303174 17.2194444 0.303967 17.2222222 0.303438 17.2250000 0.303967 17.2277778 0.302380 17.2305556 0.302380 17.2333333 0.303174 17.2361111 0.303174 17.2388889 0.302380 17.2416667 0.301851 17.2444444 0.301322 17.2472222 0.301058 17.2500000 0.301058 17.2527778 0.302116 17.2555556 0.301322 17.2583333 0.301587 17.2611111 0.300793 17.2638889 0.300264 17.2666667 0.300793 17.2694444 0.301587 17.2722222 0.301851 17.2750000 0.301322 17.2777778 0.300529 17.2805556 0.301058 17.2833333 0.301322 17.2861111 0.301851 17.2888889 0.301322 17.2916667 0.301058 17.2944444 0.300264 17.2972222 0.299736 17.3000000 0.300000 17.3027778 0.301058 17.3055556 0.300793 17.3083333 0.300000 17.3111111 0.300000 17.3138889 0.300264 17.3166667 0.300793 17.3194444 0.300793 17.3222222 0.300264 17.3250000 0.300000 17.3277778 0.300000 17.3305556 0.300000 17.3333333 0.300793 17.3361111 0.301322 17.3388889 0.301322 17.3416667 0.301058 17.3444444 0.300529 17.3472222 0.298942 17.3500000 0.296562 17.3527778 0.293653 17.3555556 0.289686 17.3583333 0.285190 17.3611111 0.279107 17.3638889 0.270909 17.3666667 0.261917 17.3694444 0.254512 17.3722222 0.250017 17.3750000 0.248430 17.3777778 0.248165 17.3805556 0.248430 17.3833333 0.249223 17.3861111 0.250281 17.3888889 0.251603 17.3916667 0.252926 17.3944444 0.253983 17.3972222 0.255041 17.4000000 0.257157 17.4027778 0.258215 17.4055556 0.260066 17.4083333 0.261124 17.4111111 0.261653 17.4138889 0.263504 17.4166667 0.265884 17.4194444 0.268264 17.4222222 0.269587 17.4250000 0.271174 17.4277778 0.273554 17.4305556 0.277521 17.4333333 0.281223 17.4361111 0.284926 17.4388889 0.286777 17.4416667 0.289421 17.4444444 0.291802 17.4472222 0.295240 17.4500000 0.298942 17.4527778 0.302380 17.4555556 0.303967 17.4583333 0.305818 17.4611111 0.306876 17.4638889 0.306612 17.4666667 0.307934 17.4694444 0.308463 17.4722222 0.309521 17.4750000 0.308992 17.4777778 0.308992 17.4805556 0.309521 17.4833333 0.309521 17.4861111 0.310314 17.4888889 0.311107 17.4916667 0.310314 17.4944444 0.310843 17.4972222 0.310579 17.5000000 0.311901 17.5027778 0.312430 17.5055556 0.312430 17.5083333 0.312430 17.5111111 0.311636 17.5138889 0.311372 17.5166667 0.311372 17.5194444 0.311636 17.5222222 0.311901 17.5250000 0.311372 17.5277778 0.311372 17.5305556 0.311107 17.5333333 0.311901 17.5361111 0.312430 17.5388889 0.312694 17.5416667 0.313223 17.5444444 0.312430 17.5472222 0.312694 17.5500000 0.312694 17.5527778 0.313488 17.5555556 0.313223 17.5583333 0.313752 17.5611111 0.312694 17.5638889 0.312694 17.5666667 0.312959 17.5694444 0.312959 17.5722222 0.312694 17.5750000 0.312959 17.5777778 0.312165 17.5805556 0.312165 17.5833333 0.312694 17.5861111 0.313223 17.5888889 0.312430 17.5916667 0.312694 17.5944444 0.312165 17.5972222 0.311901 17.6000000 0.312430 17.6027778 0.312959 17.6055556 0.313488 17.6083333 0.313488 17.6111111 0.312694 17.6138889 0.311901 17.6166667 0.311901 17.6194444 0.312430 17.6222222 0.312165 17.6250000 0.311636 17.6277778 0.310579 17.6305556 0.310579 17.6333333 0.311107 17.6361111 0.311372 17.6388889 0.311372 17.6416667 0.310843 17.6444444 0.309785 17.6472222 0.310050 17.6500000 0.309521 17.6527778 0.309785 17.6555556 0.310050 17.6583333 0.310050 17.6611111 0.309256 17.6638889 0.308727 17.6666667 0.308992 17.6694444 0.309521 17.6722222 0.309521 17.6750000 0.308198 17.6777778 0.306612 17.6805556 0.306876 17.6833333 0.306612 17.6861111 0.306876 17.6888889 0.306083 17.6916667 0.305818 17.6944444 0.303967 17.6972222 0.304496 17.7030000 0.300000 17.8470000 0.300000 17.8500000 0.300000 17.8527778 0.300793 17.8555556 0.301322 17.8583333 0.301058 17.8611111 0.300793 17.8638889 0.300793 17.8666667 0.302116 17.8694444 0.302909 17.8722222 0.302909 17.8750000 0.302380 17.8777778 0.301587 17.8805556 0.301322 17.8833333 0.301851 17.8861111 0.300793 17.8888889 0.300793 17.8916667 0.300264 17.8944444 0.300264 17.8972222 0.300000 17.9000000 0.300529 17.9027778 0.301322 17.9055556 0.301058 17.9083333 0.300793 17.9111111 0.300264 17.9138889 0.300793 17.9166667 0.301851 17.9194444 0.301851 17.9222222 0.301587 17.9250000 0.300264 17.9277778 0.300793 17.9305556 0.300264 17.9333333 0.301058 17.9361111 0.300793 17.9388889 0.300264 17.9416667 0.300000 17.9444444 0.299207 17.9472222 0.299207 17.9500000 0.299736 17.9527778 0.299736 17.9555556 0.299471 17.9583333 0.299736 17.9611111 0.298942 17.9638889 0.298942 17.9666667 0.299471 17.9694444 0.300000 17.9722222 0.300000 17.9750000 0.299736 17.9777778 0.299207 17.9805556 0.299736 17.9833333 0.300000 17.9861111 0.300793 17.9888889 0.300793 17.9916667 0.300000 17.9944444 0.298942 17.9972222 0.298678 18.0000000 0.298678 18.0027778 0.299736 18.0055556 0.299471 18.0083333 0.298942 18.0111111 0.298678 18.0138889 0.298942 18.0166667 0.299207 18.0194444 0.298942 18.0222222 0.298942 18.0250000 0.299471 18.0277778 0.298942 18.0305556 0.299207 18.0333333 0.299736 18.0361111 0.301058 18.0388889 0.300793 18.0416667 0.300264 18.0444444 0.298413 18.0472222 0.295504 18.0500000 0.293388 18.0527778 0.290479 18.0555556 0.285983 18.0583333 0.279372 18.0611111 0.271174 18.0638889 0.261917 18.0666667 0.253719 18.0694444 0.249488 18.0722222 0.247636 18.0750000 0.248165 18.0777778 0.248165 18.0805556 0.249488 18.0833333 0.250017 18.0861111 0.251603 18.0888889 0.252397 18.0916667 0.253983 18.0944444 0.254777 18.0972222 0.255570 18.1000000 0.256628 18.1027778 0.258479 18.1055556 0.259273 18.1083333 0.260066 18.1111111 0.260595 18.1138889 0.262975 18.1166667 0.264826 18.1194444 0.266942 18.1222222 0.269058 18.1250000 0.271438 18.1277778 0.275140 18.1305556 0.278314 18.1333333 0.282545 18.1361111 0.285719 18.1388889 0.288893 18.1416667 0.291537 18.1444444 0.294182 18.1472222 0.297620 18.1500000 0.300264 18.1527778 0.302909 18.1555556 0.305025 18.1583333 0.306612 18.1611111 0.307140 18.1638889 0.307669 18.1666667 0.308198 18.1694444 0.308992 18.1722222 0.308463 18.1750000 0.308992 18.1777778 0.308463 18.1805556 0.309256 18.1833333 0.310314 18.1861111 0.310579 18.1888889 0.310579 18.1916667 0.310579 18.1944444 0.310314 18.1972222 0.310843 18.2000000 0.310843 18.2027778 0.312165 18.2055556 0.312165 18.2083333 0.311901 18.2111111 0.311901 18.2138889 0.312430 18.2166667 0.312959 18.2194444 0.312959 18.2222222 0.312694 18.2250000 0.312694 18.2277778 0.312430 18.2305556 0.312165 18.2333333 0.312959 18.2361111 0.313488 18.2388889 0.313752 18.2416667 0.313488 18.2444444 0.312694 18.2472222 0.312430 18.2500000 0.313223 18.2527778 0.314017 18.2555556 0.314281 18.2583333 0.314017 18.2611111 0.314017 18.2638889 0.313488 18.2666667 0.314281 18.2694444 0.314810 18.2722222 0.314810 18.2750000 0.314545 18.2777778 0.313488 18.2805556 0.314017 18.2833333 0.313752 18.2861111 0.314281 18.2888889 0.314810 18.2916667 0.314017 18.2944444 0.314017 18.2972222 0.313488 18.3000000 0.314281 18.3027778 0.315074 18.3055556 0.314281 18.3083333 0.313752 18.3111111 0.314017 18.3138889 0.314017 18.3166667 0.314810 18.3194444 0.314810 18.3222222 0.315074 18.3250000 0.314810 18.3277778 0.313488 18.3305556 0.314017 18.3333333 0.314017 18.3361111 0.314017 18.3388889 0.313752 18.3416667 0.313223 18.3444444 0.312165 18.3472222 0.312430 18.3500000 0.313223 18.3527778 0.312959 18.3555556 0.312694 18.3583333 0.312430 18.3611111 0.312430 18.3638889 0.311636 18.3666667 0.312694 18.3694444 0.312694 18.3722222 0.311901 18.3750000 0.312165 18.3777778 0.310843 18.3805556 0.310579 18.3833333 0.310843 18.3861111 0.311107 18.3888889 0.310843 18.3916667 0.310579 18.3944444 0.308463 18.3972222 0.308463 18.4030000 0.300000 18.5470000 0.300000 18.5500000 0.304760 18.5527778 0.304496 18.5555556 0.303967 18.5583333 0.304496 18.5611111 0.304760 18.5638889 0.305818 18.5666667 0.304496 18.5694444 0.303967 18.5722222 0.302909 18.5750000 0.303174 18.5777778 0.303967 18.5805556 0.303967 18.5833333 0.303967 18.5861111 0.302380 18.5888889 0.302909 18.5916667 0.302909 18.5944444 0.303174 18.5972222 0.304231 18.6000000 0.302909 18.6027778 0.303438 18.6055556 0.302645 18.6083333 0.302380 18.6111111 0.302645 18.6138889 0.303174 18.6166667 0.302909 18.6194444 0.302645 18.6222222 0.302645 18.6250000 0.302645 18.6277778 0.302909 18.6305556 0.302380 18.6333333 0.302380 18.6361111 0.301587 18.6388889 0.301587 18.6416667 0.300793 18.6444444 0.302116 18.6472222 0.301851 18.6500000 0.301058 18.6527778 0.301322 18.6555556 0.301058 18.6583333 0.301058 18.6611111 0.301322 18.6638889 0.301587 18.6666667 0.301851 18.6694444 0.301058 18.6722222 0.300793 18.6750000 0.301322 18.6777778 0.301587 18.6805556 0.302380 18.6833333 0.302116 18.6861111 0.301587 18.6888889 0.301851 18.6916667 0.301058 18.6944444 0.301587 18.6972222 0.301587 18.7000000 0.301587 18.7027778 0.301058 18.7055556 0.300793 18.7083333 0.300529 18.7111111 0.300264 18.7138889 0.301322 18.7166667 0.300529 18.7194444 0.300529 18.7222222 0.300000 18.7250000 0.300000 18.7277778 0.300793 18.7305556 0.301322 18.7333333 0.301851 18.7361111 0.301587 18.7388889 0.300529 18.7416667 0.297884 18.7444444 0.295504 18.7472222 0.292595 18.7500000 0.288364 18.7527778 0.282281 18.7555556 0.274083 18.7583333 0.265091 18.7611111 0.255306 18.7638889 0.248959 18.7666667 0.245785 18.7694444 0.244727 18.7722222 0.245521 18.7750000 0.245785 18.7777778 0.246579 18.7805556 0.248165 18.7833333 0.248165 18.7861111 0.249488 18.7888889 0.250281 18.7916667 0.251339 18.7944444 0.251868 18.7972222 0.253983 18.8000000 0.254248 18.8027778 0.255306 18.8055556 0.256364 18.8083333 0.257686 18.8111111 0.259802 18.8138889 0.262182 18.8166667 0.263769 18.8194444 0.264826 18.8222222 0.266149 18.8250000 0.267736 18.8277778 0.271702 18.8305556 0.275140 18.8333333 0.278843 18.8361111 0.282281 18.8388889 0.284661 18.8416667 0.287570 18.8444444 0.290744 18.8472222 0.293917 18.8500000 0.296033 18.8527778 0.298413 18.8555556 0.301058 18.8583333 0.302909 18.8611111 0.307140 18.8638889 0.308992 18.8666667 0.309256 18.8694444 0.310314 18.8722222 0.309785 18.8750000 0.310843 18.8777778 0.311636 18.8805556 0.312430 18.8833333 0.312165 18.8861111 0.312959 18.8888889 0.312430 18.8916667 0.311901 18.8944444 0.312959 18.8972222 0.313752 18.9000000 0.313488 18.9027778 0.314017 18.9055556 0.313223 18.9083333 0.314017 18.9111111 0.314545 18.9138889 0.315074 18.9166667 0.314810 18.9194444 0.314281 18.9222222 0.314281 18.9250000 0.314545 18.9277778 0.315074 18.9305556 0.315868 18.9333333 0.315339 18.9361111 0.315603 18.9388889 0.314810 18.9416667 0.315074 18.9444444 0.315074 18.9472222 0.315603 18.9500000 0.315339 18.9527778 0.315074 18.9555556 0.315074 18.9583333 0.314281 18.9611111 0.315603 18.9638889 0.316132 18.9666667 0.315868 18.9694444 0.315868 18.9722222 0.314810 18.9750000 0.315074 18.9777778 0.315074 18.9805556 0.315603 18.9833333 0.316397 18.9861111 0.315868 18.9888889 0.316132 18.9916667 0.315603 18.9944444 0.316132 18.9972222 0.316661 19.0000000 0.315868 19.0027778 0.315603 19.0055556 0.315603 19.0083333 0.315339 19.0111111 0.314810 19.0138889 0.315603 19.0166667 0.315603 19.0194444 0.315339 19.0222222 0.315603 19.0250000 0.315603 19.0277778 0.315603 19.0305556 0.315868 19.0333333 0.315868 19.0361111 0.314810 19.0388889 0.314810 19.0416667 0.314810 19.0444444 0.315868 19.0472222 0.315603 19.0500000 0.315868 19.0527778 0.314545 19.0555556 0.315074 19.0583333 0.314545 19.0611111 0.315074 19.0638889 0.314810 19.0666667 0.314810 19.0694444 0.313752 19.0722222 0.313223 19.0750000 0.312694 19.0777778 0.313223 19.0805556 0.312694 19.0833333 0.313223 19.0861111 0.312430 19.0888889 0.311636 19.0916667 0.311636 19.0944444 0.311901 19.0972222 0.311901 19.1030000 0.300000 19.2470000 0.300000 19.2500000 0.294711 19.2527778 0.296033 19.2555556 0.295769 19.2583333 0.295769 19.2611111 0.296298 19.2638889 0.295769 19.2666667 0.296033 19.2694444 0.297091 19.2722222 0.297355 19.2750000 0.297091 19.2777778 0.296562 19.2805556 0.295504 19.2833333 0.295240 19.2861111 0.294975 19.2888889 0.295769 19.2916667 0.296033 19.2944444 0.295504 19.2972222 0.294446 19.3000000 0.294975 19.3027778 0.296033 19.3055556 0.296033 19.3083333 0.295240 19.3111111 0.295504 19.3138889 0.294182 19.3166667 0.294711 19.3194444 0.294446 19.3222222 0.294711 19.3250000 0.294711 19.3277778 0.294182 19.3305556 0.293653 19.3333333 0.294182 19.3361111 0.294182 19.3388889 0.293653 19.3416667 0.293917 19.3444444 0.293388 19.3472222 0.293388 19.3500000 0.293917 19.3527778 0.293653 19.3555556 0.293917 19.3583333 0.294182 19.3611111 0.293388 19.3638889 0.292066 19.3666667 0.293388 19.3694444 0.293124 19.3722222 0.293388 19.3750000 0.293388 19.3777778 0.293124 19.3805556 0.292860 19.3833333 0.293124 19.3861111 0.293388 19.3888889 0.293653 19.3916667 0.293653 19.3944444 0.293124 19.3972222 0.292860 19.4000000 0.293124 19.4027778 0.293917 19.4055556 0.294182 19.4083333 0.293917 19.4111111 0.293124 19.4138889 0.292860 19.4166667 0.292595 19.4194444 0.292595 19.4222222 0.292860 19.4250000 0.292595 19.4277778 0.291802 19.4305556 0.291537 19.4333333 0.291802 19.4361111 0.292860 19.4388889 0.294446 19.4416667 0.294182 19.4444444 0.292595 19.4472222 0.291273 19.4500000 0.289157 19.4527778 0.287835 19.4555556 0.285719 19.4583333 0.282545 19.4611111 0.276727 19.4638889 0.268264 19.4666667 0.259537 19.4694444 0.252132 19.4722222 0.247901 19.4750000 0.246843 19.4777778 0.247107 19.4805556 0.246050 19.4833333 0.247372 19.4861111 0.247901 19.4888889 0.249752 19.4916667 0.251074 19.4944444 0.251868 19.4972222 0.252397 19.5000000 0.253455 19.5027778 0.255041 19.5055556 0.257421 19.5083333 0.258479 19.5111111 0.260860 19.5138889 0.261388 19.5166667 0.262975 19.5194444 0.265355 19.5222222 0.266942 19.5250000 0.268793 19.5277778 0.272496 19.5305556 0.275669 19.5333333 0.279636 19.5361111 0.282017 19.5388889 0.284661 19.5416667 0.287041 19.5444444 0.289421 19.5472222 0.292066 19.5500000 0.294711 19.5527778 0.297355 19.5555556 0.300000 19.5583333 0.301058 19.5611111 0.301851 19.5638889 0.301851 19.5666667 0.302909 19.5694444 0.303702 19.5722222 0.304231 19.5750000 0.305289 19.5777778 0.305025 19.5805556 0.303702 19.5833333 0.305289 19.5861111 0.305818 19.5888889 0.306347 19.5916667 0.306612 19.5944444 0.306083 19.5972222 0.305818 19.6000000 0.306083 19.6027778 0.307669 19.6055556 0.307405 19.6083333 0.306876 19.6111111 0.307405 19.6138889 0.306876 19.6166667 0.307405 19.6194444 0.307405 19.6222222 0.308463 19.6250000 0.307934 19.6277778 0.307934 19.6305556 0.307669 19.6333333 0.308198 19.6361111 0.308992 19.6388889 0.309256 19.6416667 0.308992 19.6444444 0.308727 19.6472222 0.307934 19.6500000 0.307669 19.6527778 0.308463 19.6555556 0.309256 19.6583333 0.308992 19.6611111 0.308198 19.6638889 0.307934 19.6666667 0.308727 19.6694444 0.308992 19.6722222 0.308992 19.6750000 0.308992 19.6777778 0.309256 19.6805556 0.308727 19.6833333 0.308727 19.6861111 0.309521 19.6888889 0.310050 19.6916667 0.310314 19.6944444 0.309521 19.6972222 0.308463 19.7000000 0.308992 19.7027778 0.308463 19.7055556 0.308992 19.7083333 0.309256 19.7111111 0.307934 19.7138889 0.307140 19.7166667 0.307405 19.7194444 0.307669 19.7222222 0.308198 19.7250000 0.307934 19.7277778 0.307405 19.7305556 0.307405 19.7333333 0.306876 19.7361111 0.307405 19.7388889 0.307669 19.7416667 0.308198 19.7444444 0.306876 19.7472222 0.306347 19.7500000 0.306347 19.7527778 0.306612 19.7555556 0.306612 19.7583333 0.306083 19.7611111 0.305289 19.7638889 0.304496 19.7666667 0.305025 19.7694444 0.304496 19.7722222 0.304496 19.7750000 0.303967 19.7777778 0.303438 19.7805556 0.302645 19.7833333 0.302645 19.7861111 0.302909 19.7888889 0.302380 19.7916667 0.302645 19.7944444 0.302116 19.7972222 0.300793 19.8030000 0.300000 19.9470000 0.300000 19.9500000 0.296298 19.9527778 0.296562 19.9555556 0.295504 19.9583333 0.296033 19.9611111 0.296562 19.9638889 0.297355 19.9666667 0.297355 19.9694444 0.297884 19.9722222 0.297620 19.9750000 0.297091 19.9777778 0.298413 19.9805556 0.298413 19.9833333 0.298149 19.9861111 0.297355 19.9888889 0.296562 19.9916667 0.296298 19.9944444 0.296033 19.9972222 0.296298 20.0000000 0.294711 20.0027778 0.294975 20.0055556 0.294446 20.0083333 0.295769 20.0111111 0.295504 20.0138889 0.296298 20.0166667 0.296033 20.0194444 0.295769 20.0222222 0.295240 20.0250000 0.295504 20.0277778 0.295240 20.0305556 0.296033 20.0333333 0.295769 20.0361111 0.294975 20.0388889 0.294182 20.0416667 0.294711 20.0444444 0.294446 20.0472222 0.294446 20.0500000 0.294182 20.0527778 0.292860 20.0555556 0.292331 20.0583333 0.293124 20.0611111 0.293653 20.0638889 0.293388 20.0666667 0.293388 20.0694444 0.292860 20.0722222 0.291802 20.0750000 0.292860 20.0777778 0.293917 20.0805556 0.293653 20.0833333 0.293124 20.0861111 0.293124 20.0888889 0.292331 20.0916667 0.292331 20.0944444 0.292860 20.0972222 0.293124 20.1000000 0.292595 20.1027778 0.292331 20.1055556 0.291273 20.1083333 0.292066 20.1111111 0.292331 20.1138889 0.292595 20.1166667 0.292331 20.1194444 0.291537 20.1222222 0.291537 20.1250000 0.292066 20.1277778 0.292860 20.1305556 0.292066 20.1333333 0.292331 20.1361111 0.292595 20.1388889 0.291008 20.1416667 0.292595 20.1444444 0.292595 20.1472222 0.293388 20.1500000 0.292595 20.1527778 0.289421 20.1555556 0.285719 20.1583333 0.280694 20.1611111 0.275405 20.1638889 0.268000 20.1666667 0.259273 20.1694444 0.248694 20.1722222 0.239967 20.1750000 0.237058 20.1777778 0.238380 20.1805556 0.239702 20.1833333 0.239967 20.1861111 0.240231 20.1888889 0.239967 20.1916667 0.241025 20.1944444 0.242612 20.1972222 0.243140 20.2000000 0.243405 20.2027778 0.243669 20.2055556 0.244727 20.2083333 0.246579 20.2111111 0.248694 20.2138889 0.251603 20.2166667 0.253190 20.2194444 0.256099 20.2222222 0.257950 20.2250000 0.262711 20.2277778 0.268264 20.2305556 0.273025 20.2333333 0.276992 20.2361111 0.280959 20.2388889 0.284132 20.2416667 0.287835 20.2444444 0.290744 20.2472222 0.293917 20.2500000 0.296298 20.2527778 0.296826 20.2555556 0.297884 20.2583333 0.298678 20.2611111 0.299736 20.2638889 0.300793 20.2666667 0.300264 20.2694444 0.300793 20.2722222 0.300529 20.2750000 0.301058 20.2777778 0.301851 20.2805556 0.302116 20.2833333 0.302909 20.2861111 0.302909 20.2888889 0.302645 20.2916667 0.303438 20.2944444 0.304231 20.2972222 0.304231 20.3000000 0.303702 20.3027778 0.303702 20.3055556 0.303174 20.3083333 0.303702 20.3111111 0.304496 20.3138889 0.304496 20.3166667 0.304231 20.3194444 0.303702 20.3222222 0.303702 20.3250000 0.303702 20.3277778 0.304496 20.3305556 0.304760 20.3333333 0.305025 20.3361111 0.305025 20.3388889 0.304760 20.3416667 0.305025 20.3444444 0.305289 20.3472222 0.305554 20.3500000 0.305554 20.3527778 0.305289 20.3555556 0.305025 20.3583333 0.304760 20.3611111 0.305818 20.3638889 0.305289 20.3666667 0.305554 20.3694444 0.305554 20.3722222 0.304760 20.3750000 0.305289 20.3777778 0.305554 20.3805556 0.305289 20.3833333 0.305554 20.3861111 0.305289 20.3888889 0.305289 20.3916667 0.305025 20.3944444 0.306612 20.3972222 0.306083 20.4000000 0.306612 20.4027778 0.306083 20.4055556 0.305025 20.4083333 0.305289 20.4111111 0.305289 20.4138889 0.305025 20.4166667 0.305289 20.4194444 0.304496 20.4222222 0.303702 20.4250000 0.303967 20.4277778 0.304760 20.4305556 0.304496 20.4333333 0.304496 20.4361111 0.304231 20.4388889 0.303438 20.4416667 0.303702 20.4444444 0.303967 20.4472222 0.304231 20.4500000 0.303967 20.4527778 0.303438 20.4555556 0.302645 20.4583333 0.302380 20.4611111 0.302645 20.4638889 0.302380 20.4666667 0.302380 20.4694444 0.300793 20.4722222 0.299736 20.4750000 0.299471 20.4777778 0.299471 20.4805556 0.299736 20.4833333 0.298678 20.4861111 0.297620 20.4888889 0.297091 20.4916667 0.296562 20.4944444 0.297091 20.4972222 0.296298 20.5030000 0.300000 20.6470000 0.300000 20.6500000 0.288364 20.6527778 0.287835 20.6555556 0.288099 20.6583333 0.288628 20.6611111 0.289157 20.6638889 0.288628 20.6666667 0.288628 20.6694444 0.288628 20.6722222 0.288628 20.6750000 0.289421 20.6777778 0.290479 20.6805556 0.290744 20.6833333 0.289950 20.6861111 0.289686 20.6888889 0.290479 20.6916667 0.290479 20.6944444 0.290744 20.6972222 0.289686 20.7000000 0.287835 20.7027778 0.288099 20.7055556 0.287570 20.7083333 0.289157 20.7111111 0.288893 20.7138889 0.289157 20.7166667 0.288628 20.7194444 0.287835 20.7222222 0.288893 20.7250000 0.289686 20.7277778 0.289950 20.7305556 0.289686 20.7333333 0.288893 20.7361111 0.287835 20.7388889 0.287570 20.7416667 0.288099 20.7444444 0.288099 20.7472222 0.287835 20.7500000 0.286512 20.7527778 0.286512 20.7555556 0.285983 20.7583333 0.287041 20.7611111 0.286512 20.7638889 0.286777 20.7666667 0.286777 20.7694444 0.286248 20.7722222 0.286777 20.7750000 0.287041 20.7777778 0.287570 20.7805556 0.286777 20.7833333 0.287306 20.7861111 0.286512 20.7888889 0.286248 20.7916667 0.286777 20.7944444 0.287306 20.7972222 0.285983 20.8000000 0.285719 20.8027778 0.285455 20.8055556 0.285190 20.8083333 0.286248 20.8111111 0.285983 20.8138889 0.286777 20.8166667 0.285190 20.8194444 0.284926 20.8222222 0.285983 20.8250000 0.286512 20.8277778 0.286512 20.8305556 0.286512 20.8333333 0.286248 20.8361111 0.285719 20.8388889 0.286512 20.8416667 0.287306 20.8444444 0.287306 20.8472222 0.287041 20.8500000 0.285719 20.8527778 0.283339 20.8555556 0.280959 20.8583333 0.278314 20.8611111 0.274876 20.8638889 0.268793 20.8666667 0.260860 20.8694444 0.250810 20.8722222 0.241554 20.8750000 0.235471 20.8777778 0.234413 20.8805556 0.234942 20.8833333 0.234678 20.8861111 0.234678 20.8888889 0.234678 20.8916667 0.237058 20.8944444 0.238909 20.8972222 0.239967 20.9000000 0.240496 20.9027778 0.241289 20.9055556 0.241554 20.9083333 0.243140 20.9111111 0.245256 20.9138889 0.246843 20.9166667 0.248694 20.9194444 0.250545 20.9222222 0.252661 20.9250000 0.255835 20.9277778 0.259537 20.9305556 0.263240 20.9333333 0.267471 20.9361111 0.269851 20.9388889 0.273554 20.9416667 0.276727 20.9444444 0.280165 20.9472222 0.282810 20.9500000 0.284926 20.9527778 0.286777 20.9555556 0.289950 20.9583333 0.291537 20.9611111 0.292595 20.9638889 0.292595 20.9666667 0.293124 20.9694444 0.293653 20.9722222 0.294446 20.9750000 0.295240 20.9777778 0.294975 20.9805556 0.294975 20.9833333 0.294182 20.9861111 0.294975 20.9888889 0.295504 20.9916667 0.296298 20.9944444 0.296562 20.9972222 0.297620 21.0000000 0.297091 21.0027778 0.296562 21.0055556 0.297884 21.0083333 0.297884 21.0111111 0.297884 21.0138889 0.297355 21.0166667 0.297091 21.0194444 0.296826 21.0222222 0.297620 21.0250000 0.298149 21.0277778 0.298678 21.0305556 0.298149 21.0333333 0.297620 21.0361111 0.298413 21.0388889 0.297884 21.0416667 0.298413 21.0444444 0.298413 21.0472222 0.298678 21.0500000 0.298942 21.0527778 0.298678 21.0555556 0.299207 21.0583333 0.299471 21.0611111 0.299736 21.0638889 0.299471 21.0666667 0.299207 21.0694444 0.297884 21.0722222 0.298678 21.0750000 0.298678 21.0777778 0.298942 21.0805556 0.298942 21.0833333 0.298413 21.0861111 0.298149 21.0888889 0.298413 21.0916667 0.299207 21.0944444 0.298942 21.0972222 0.299736 21.1000000 0.298678 21.1027778 0.298149 21.1055556 0.298942 21.1083333 0.299471 21.1111111 0.298942 21.1138889 0.299207 21.1166667 0.298942 21.1194444 0.298149 21.1222222 0.298149 21.1250000 0.299207 21.1277778 0.299471 21.1305556 0.298149 21.1333333 0.297355 21.1361111 0.297091 21.1388889 0.296826 21.1416667 0.297620 21.1444444 0.298149 21.1472222 0.297091 21.1500000 0.296298 21.1527778 0.296033 21.1555556 0.296298 21.1583333 0.296562 21.1611111 0.297091 21.1638889 0.297355 21.1666667 0.296562 21.1694444 0.295240 21.1722222 0.295769 21.1750000 0.296298 21.1777778 0.296298 21.1805556 0.295240 21.1833333 0.294446 21.1861111 0.294446 21.1888889 0.294446 21.1916667 0.294446 21.1944444 0.293653 21.1972222 0.293124 21.2030000 0.300000 21.3470000 0.300000 21.3500000 0.285190 21.3527778 0.285719 21.3555556 0.285455 21.3583333 0.286248 21.3611111 0.285719 21.3638889 0.286248 21.3666667 0.287041 21.3694444 0.287041 21.3722222 0.286248 21.3750000 0.285983 21.3777778 0.284926 21.3805556 0.285190 21.3833333 0.285719 21.3861111 0.285719 21.3888889 0.285983 21.3916667 0.285190 21.3944444 0.284926 21.3972222 0.284926 21.4000000 0.284926 21.4027778 0.285190 21.4055556 0.285190 21.4083333 0.283868 21.4111111 0.283868 21.4138889 0.284661 21.4166667 0.284661 21.4194444 0.284661 21.4222222 0.284132 21.4250000 0.283603 21.4277778 0.283868 21.4305556 0.283603 21.4333333 0.283603 21.4361111 0.283339 21.4388889 0.283074 21.4416667 0.283339 21.4444444 0.283074 21.4472222 0.283339 21.4500000 0.283339 21.4527778 0.283603 21.4555556 0.283339 21.4583333 0.282281 21.4611111 0.282281 21.4638889 0.282017 21.4666667 0.283074 21.4694444 0.283074 21.4722222 0.282545 21.4750000 0.282281 21.4777778 0.282017 21.4805556 0.282545 21.4833333 0.282281 21.4861111 0.282810 21.4888889 0.282281 21.4916667 0.281752 21.4944444 0.281752 21.4972222 0.282017 21.5000000 0.283074 21.5027778 0.283074 21.5055556 0.282810 21.5083333 0.282281 21.5111111 0.282281 21.5138889 0.282545 21.5166667 0.282810 21.5194444 0.282810 21.5222222 0.281752 21.5250000 0.281223 21.5277778 0.281223 21.5305556 0.281488 21.5333333 0.282545 21.5361111 0.283074 21.5388889 0.282810 21.5416667 0.281752 21.5444444 0.278579 21.5472222 0.275405 21.5500000 0.272760 21.5527778 0.268793 21.5555556 0.263240 21.5583333 0.255306 21.5611111 0.246314 21.5638889 0.237851 21.5666667 0.231504 21.5694444 0.229388 21.5722222 0.228595 21.5750000 0.228595 21.5777778 0.229124 21.5805556 0.229124 21.5833333 0.230446 21.5861111 0.230711 21.5888889 0.232033 21.5916667 0.232562 21.5944444 0.233884 21.5972222 0.235207 21.6000000 0.236529 21.6027778 0.237587 21.6055556 0.238909 21.6083333 0.239702 21.6111111 0.241554 21.6138889 0.243934 21.6166667 0.246314 21.6194444 0.247901 21.6222222 0.249488 21.6250000 0.251603 21.6277778 0.254777 21.6305556 0.259008 21.6333333 0.263240 21.6361111 0.266413 21.6388889 0.268529 21.6416667 0.270909 21.6444444 0.273289 21.6472222 0.276198 21.6500000 0.279372 21.6527778 0.282281 21.6555556 0.284397 21.6583333 0.286248 21.6611111 0.287306 21.6638889 0.288628 21.6666667 0.290479 21.6694444 0.290479 21.6722222 0.291273 21.6750000 0.290744 21.6777778 0.291537 21.6805556 0.292860 21.6833333 0.293124 21.6861111 0.293124 21.6888889 0.293388 21.6916667 0.292860 21.6944444 0.292595 21.6972222 0.293124 21.7000000 0.293388 21.7027778 0.293653 21.7055556 0.293653 21.7083333 0.292860 21.7111111 0.292595 21.7138889 0.293653 21.7166667 0.294711 21.7194444 0.294446 21.7222222 0.294182 21.7250000 0.294182 21.7277778 0.294182 21.7305556 0.294182 21.7333333 0.294711 21.7361111 0.295504 21.7388889 0.295504 21.7416667 0.294975 21.7444444 0.294182 21.7472222 0.294711 21.7500000 0.295504 21.7527778 0.295769 21.7555556 0.294711 21.7583333 0.294182 21.7611111 0.294182 21.7638889 0.294182 21.7666667 0.295240 21.7694444 0.295504 21.7722222 0.295504 21.7750000 0.294182 21.7777778 0.294446 21.7805556 0.295240 21.7833333 0.295240 21.7861111 0.295240 21.7888889 0.295504 21.7916667 0.294975 21.7944444 0.294711 21.7972222 0.295240 21.8000000 0.296298 21.8027778 0.295504 21.8055556 0.295769 21.8083333 0.295240 21.8111111 0.294446 21.8138889 0.294446 21.8166667 0.294975 21.8194444 0.294711 21.8222222 0.294711 21.8250000 0.294446 21.8277778 0.293917 21.8305556 0.294182 21.8333333 0.294711 21.8361111 0.294711 21.8388889 0.294446 21.8416667 0.293388 21.8444444 0.293653 21.8472222 0.293124 21.8500000 0.294182 21.8527778 0.293653 21.8555556 0.293653 21.8583333 0.292595 21.8611111 0.291802 21.8638889 0.291802 21.8666667 0.292066 21.8694444 0.291537 21.8722222 0.291273 21.8750000 0.290744 21.8777778 0.289157 21.8805556 0.289686 21.8833333 0.290744 21.8861111 0.289950 21.8888889 0.289157 21.8916667 0.288364 21.8944444 0.287570 21.8972222 0.287835 21.9030000 0.300000 22.0470000 0.300000 22.0500000 0.274612 22.0527778 0.274347 22.0555556 0.274876 22.0583333 0.275669 22.0611111 0.275934 22.0638889 0.276463 22.0666667 0.275669 22.0694444 0.275934 22.0722222 0.276992 22.0750000 0.277521 22.0777778 0.276992 22.0805556 0.276727 22.0833333 0.275669 22.0861111 0.275405 22.0888889 0.274612 22.0916667 0.274612 22.0944444 0.274612 22.0972222 0.275140 22.1000000 0.274347 22.1027778 0.273818 22.1055556 0.274083 22.1083333 0.274876 22.1111111 0.274347 22.1138889 0.274083 22.1166667 0.274347 22.1194444 0.273818 22.1222222 0.274347 22.1250000 0.274612 22.1277778 0.274347 22.1305556 0.273818 22.1333333 0.273554 22.1361111 0.272760 22.1388889 0.273025 22.1416667 0.272760 22.1444444 0.273289 22.1472222 0.272231 22.1500000 0.271702 22.1527778 0.271174 22.1555556 0.270909 22.1583333 0.271174 22.1611111 0.271702 22.1638889 0.271174 22.1666667 0.270116 22.1694444 0.270380 22.1722222 0.270380 22.1750000 0.270909 22.1777778 0.270909 22.1805556 0.271174 22.1833333 0.270645 22.1861111 0.270645 22.1888889 0.270645 22.1916667 0.270909 22.1944444 0.271174 22.1972222 0.270909 22.2000000 0.269851 22.2027778 0.269322 22.2055556 0.269587 22.2083333 0.270116 22.2111111 0.270116 22.2138889 0.270116 22.2166667 0.268793 22.2194444 0.268793 22.2222222 0.269058 22.2250000 0.269587 22.2277778 0.269058 22.2305556 0.269322 22.2333333 0.268264 22.2361111 0.268529 22.2388889 0.269058 22.2416667 0.269322 22.2444444 0.270380 22.2472222 0.269587 22.2500000 0.268000 22.2527778 0.264033 22.2555556 0.261653 22.2583333 0.257950 22.2611111 0.253983 22.2638889 0.247107 22.2666667 0.238116 22.2694444 0.226479 22.2722222 0.218545 22.2750000 0.213256 22.2777778 0.213256 22.2805556 0.213521 22.2833333 0.213521 22.2861111 0.213521 22.2888889 0.215372 22.2916667 0.216959 22.2944444 0.218545 22.2972222 0.219339 22.3000000 0.220661 22.3027778 0.221190 22.3055556 0.222248 22.3083333 0.224628 22.3111111 0.226215 22.3138889 0.228066 22.3166667 0.228860 22.3194444 0.230446 22.3222222 0.233355 22.3250000 0.236000 22.3277778 0.239438 22.3305556 0.242083 22.3333333 0.246050 22.3361111 0.248430 22.3388889 0.252397 22.3416667 0.255041 22.3444444 0.258215 22.3472222 0.261124 22.3500000 0.263240 22.3527778 0.266149 22.3555556 0.269058 22.3583333 0.271438 22.3611111 0.272496 22.3638889 0.273554 22.3666667 0.273025 22.3694444 0.273554 22.3722222 0.273818 22.3750000 0.274876 22.3777778 0.274612 22.3805556 0.274876 22.3833333 0.275140 22.3861111 0.274612 22.3888889 0.274876 22.3916667 0.276198 22.3944444 0.275934 22.3972222 0.275669 22.4000000 0.274876 22.4027778 0.275405 22.4055556 0.275669 22.4083333 0.277256 22.4111111 0.277256 22.4138889 0.277256 22.4166667 0.275934 22.4194444 0.276463 22.4222222 0.276992 22.4250000 0.277521 22.4277778 0.277256 22.4305556 0.276727 22.4333333 0.276463 22.4361111 0.275669 22.4388889 0.276727 22.4416667 0.277256 22.4444444 0.277521 22.4472222 0.276727 22.4500000 0.275934 22.4527778 0.275934 22.4555556 0.276463 22.4583333 0.276992 22.4611111 0.276992 22.4638889 0.276463 22.4666667 0.276198 22.4694444 0.275669 22.4722222 0.276463 22.4750000 0.276992 22.4777778 0.276992 22.4805556 0.276198 22.4833333 0.276198 22.4861111 0.274876 22.4888889 0.275405 22.4916667 0.275669 22.4944444 0.276463 22.4972222 0.275405 22.5000000 0.274876 22.5027778 0.274612 22.5055556 0.274612 22.5083333 0.275669 22.5111111 0.275669 22.5138889 0.275140 22.5166667 0.274876 22.5194444 0.274612 22.5222222 0.275405 22.5250000 0.275405 22.5277778 0.275405 22.5305556 0.274876 22.5333333 0.273818 22.5361111 0.273818 22.5388889 0.273818 22.5416667 0.274083 22.5444444 0.273818 22.5472222 0.273025 22.5500000 0.272760 22.5527778 0.272231 22.5555556 0.272496 22.5583333 0.273025 22.5611111 0.272760 22.5638889 0.272231 22.5666667 0.271174 22.5694444 0.270645 22.5722222 0.270380 22.5750000 0.271967 22.5777778 0.271438 22.5805556 0.271702 22.5833333 0.270380 22.5861111 0.269322 22.5888889 0.269851 22.5916667 0.269851 22.5944444 0.268793 22.5972222 0.268000 22.6030000 0.300000 22.7470000 0.300000 22.7500000 0.247107 22.7527778 0.246314 22.7555556 0.247107 22.7583333 0.247636 22.7611111 0.247901 22.7638889 0.247901 22.7666667 0.246843 22.7694444 0.246050 22.7722222 0.246579 22.7750000 0.246843 22.7777778 0.246843 22.7805556 0.246050 22.7833333 0.246050 22.7861111 0.245521 22.7888889 0.245256 22.7916667 0.244992 22.7944444 0.246314 22.7972222 0.246314 22.8000000 0.246314 22.8027778 0.245256 22.8055556 0.245521 22.8083333 0.246314 22.8111111 0.247107 22.8138889 0.246579 22.8166667 0.246314 22.8194444 0.245785 22.8222222 0.245256 22.8250000 0.245785 22.8277778 0.245256 22.8305556 0.244992 22.8333333 0.244198 22.8361111 0.243140 22.8388889 0.243669 22.8416667 0.244463 22.8444444 0.245256 22.8472222 0.244727 22.8500000 0.245521 22.8527778 0.244992 22.8555556 0.245785 22.8583333 0.246314 22.8611111 0.246579 22.8638889 0.245256 22.8666667 0.245256 22.8694444 0.244198 22.8722222 0.244727 22.8750000 0.245521 22.8777778 0.246050 22.8805556 0.246050 22.8833333 0.245521 22.8861111 0.244992 22.8888889 0.245256 22.8916667 0.244992 22.8944444 0.245521 22.8972222 0.246050 22.9000000 0.246050 22.9027778 0.245785 22.9055556 0.246050 22.9083333 0.246050 22.9111111 0.246579 22.9138889 0.246314 22.9166667 0.247107 22.9194444 0.247372 22.9222222 0.247636 22.9250000 0.247372 22.9277778 0.248959 22.9305556 0.249223 22.9333333 0.249488 22.9361111 0.248430 22.9388889 0.247636 22.9416667 0.247107 22.9444444 0.247901 22.9472222 0.246314 22.9500000 0.243405 22.9527778 0.241025 22.9555556 0.237322 22.9583333 0.233620 22.9611111 0.229917 22.9638889 0.221983 22.9666667 0.212727 22.9694444 0.204793 22.9722222 0.199240 22.9750000 0.199240 22.9777778 0.200562 22.9805556 0.200562 22.9833333 0.200562 22.9861111 0.201091 22.9888889 0.202942 22.9916667 0.204000 22.9944444 0.206645 22.9972222 0.208231 23.0000000 0.209289 23.0027778 0.209289 23.0055556 0.210083 23.0083333 0.211669 23.0111111 0.213785 23.0138889 0.215901 23.0166667 0.217752 23.0194444 0.220132 23.0222222 0.221455 23.0250000 0.223041 23.0277778 0.226744 23.0305556 0.229917 23.0333333 0.233355 23.0361111 0.236264 23.0388889 0.237322 23.0416667 0.241289 23.0444444 0.243669 23.0472222 0.245256 23.0500000 0.247636 23.0527778 0.249223 23.0555556 0.251868 23.0583333 0.254777 23.0611111 0.256099 23.0638889 0.257686 23.0666667 0.258215 23.0694444 0.258744 23.0722222 0.260066 23.0750000 0.261124 23.0777778 0.260331 23.0805556 0.259273 23.0833333 0.259273 23.0861111 0.259008 23.0888889 0.260331 23.0916667 0.260331 23.0944444 0.260595 23.0972222 0.260595 23.1000000 0.261124 23.1027778 0.261653 23.1055556 0.262446 23.1083333 0.263769 23.1111111 0.263769 23.1138889 0.262446 23.1166667 0.262182 23.1194444 0.261917 23.1222222 0.262975 23.1250000 0.262975 23.1277778 0.263240 23.1305556 0.262182 23.1333333 0.262711 23.1361111 0.262711 23.1388889 0.262975 23.1416667 0.263769 23.1444444 0.263769 23.1472222 0.263240 23.1500000 0.263240 23.1527778 0.264033 23.1555556 0.265091 23.1583333 0.266149 23.1611111 0.266942 23.1638889 0.266678 23.1666667 0.265620 23.1694444 0.265091 23.1722222 0.264033 23.1750000 0.264562 23.1777778 0.265620 23.1805556 0.265620 23.1833333 0.265091 23.1861111 0.265091 23.1888889 0.265355 23.1916667 0.266413 23.1944444 0.267736 23.1972222 0.267736 23.2000000 0.268264 23.2027778 0.268000 23.2055556 0.267207 23.2083333 0.268000 23.2111111 0.268793 23.2138889 0.268793 23.2166667 0.269322 23.2194444 0.268529 23.2222222 0.269058 23.2250000 0.269322 23.2277778 0.269587 23.2305556 0.269058 23.2333333 0.268793 23.2361111 0.269058 23.2388889 0.268264 23.2416667 0.269851 23.2444444 0.270380 23.2472222 0.270645 23.2500000 0.270116 23.2527778 0.268793 23.2555556 0.268264 23.2583333 0.268793 23.2611111 0.269058 23.2638889 0.269851 23.2666667 0.269851 23.2694444 0.268000 23.2722222 0.266678 23.2750000 0.266942 23.2777778 0.267736 23.2805556 0.268529 23.2833333 0.268793 23.2861111 0.267736 23.2888889 0.267471 23.2916667 0.267736 23.2944444 0.268793 23.2972222 0.268000 23.3030000 0.300000 23.4470000 0.300000 23.4500000 0.260066 23.4527778 0.260860 23.4555556 0.261388 23.4583333 0.261653 23.4611111 0.261388 23.4638889 0.261124 23.4666667 0.261388 23.4694444 0.262446 23.4722222 0.263504 23.4750000 0.263240 23.4777778 0.263504 23.4805556 0.264826 23.4833333 0.268000 23.4861111 0.268264 23.4888889 0.266413 23.4916667 0.263769 23.4944444 0.261124 23.4972222 0.260066 23.5000000 0.259273 23.5027778 0.260066 23.5055556 0.261124 23.5083333 0.260860 23.5111111 0.260066 23.5138889 0.260331 23.5166667 0.260860 23.5194444 0.261124 23.5222222 0.261917 23.5250000 0.262182 23.5277778 0.261653 23.5305556 0.262446 23.5333333 0.262711 23.5361111 0.262711 23.5388889 0.264033 23.5416667 0.264298 23.5444444 0.266149 23.5472222 0.265884 23.5500000 0.264562 23.5527778 0.261124 23.5555556 0.258744 23.5583333 0.258479 23.5611111 0.259802 23.5638889 0.261388 23.5666667 0.262975 23.5694444 0.262975 23.5722222 0.262446 23.5750000 0.259802 23.5777778 0.258215 23.5805556 0.259008 23.5833333 0.260066 23.5861111 0.259537 23.5888889 0.258744 23.5916667 0.258744 23.5944444 0.260595 23.5972222 0.262711 23.6000000 0.264562 23.6027778 0.263769 23.6055556 0.265355 23.6083333 0.263504 23.6111111 0.260860 23.6138889 0.258215 23.6166667 0.257950 23.6194444 0.257950 23.6222222 0.260331 23.6250000 0.259802 23.6277778 0.259802 23.6305556 0.261388 23.6333333 0.262446 23.6361111 0.262711 23.6388889 0.260860 23.6416667 0.260331 23.6444444 0.261124 23.6472222 0.261653 23.6500000 0.261917 23.6527778 0.260860 23.6555556 0.258744 23.6583333 0.256099 23.6611111 0.253719 23.6638889 0.251074 23.6666667 0.246314 23.6694444 0.239174 23.6722222 0.229653 23.6750000 0.222248 23.6777778 0.219603 23.6805556 0.218017 23.6833333 0.217223 23.6861111 0.215636 23.6888889 0.216165 23.6916667 0.217223 23.6944444 0.219603 23.6972222 0.221719 23.7000000 0.224893 23.7027778 0.225686 23.7055556 0.225421 23.7083333 0.223835 23.7111111 0.224099 23.7138889 0.227273 23.7166667 0.230182 23.7194444 0.232826 23.7222222 0.233884 23.7250000 0.234678 23.7277778 0.236529 23.7305556 0.240231 23.7333333 0.242876 23.7361111 0.244992 23.7388889 0.246314 23.7416667 0.248694 23.7444444 0.252132 23.7472222 0.255306 23.7500000 0.257686 23.7527778 0.259008 23.7555556 0.260066 23.7583333 0.262182 23.7611111 0.263504 23.7638889 0.265620 23.7666667 0.266678 23.7694444 0.266678 23.7722222 0.267471 23.7750000 0.267207 23.7777778 0.268000 23.7805556 0.266942 23.7833333 0.266149 23.7861111 0.264298 23.7888889 0.265091 23.7916667 0.265355 23.7944444 0.265620 23.7972222 0.266149 23.8000000 0.266942 23.8027778 0.267736 23.8055556 0.267736 23.8083333 0.266942 23.8111111 0.265355 23.8138889 0.264826 23.8166667 0.266413 23.8194444 0.266678 23.8222222 0.266942 23.8250000 0.266149 23.8277778 0.266413 23.8305556 0.267471 23.8333333 0.267736 23.8361111 0.266149 23.8388889 0.264298 23.8416667 0.264298 23.8444444 0.265355 23.8472222 0.267471 23.8500000 0.269322 23.8527778 0.268000 23.8555556 0.263769 23.8583333 0.259802 23.8611111 0.258215 23.8638889 0.260066 23.8666667 0.262446 23.8694444 0.263240 23.8722222 0.263769 23.8750000 0.263769 23.8777778 0.263769 23.8805556 0.263240 23.8833333 0.264033 23.8861111 0.261917 23.8888889 0.259273 23.8916667 0.256628 23.8944444 0.256893 23.8972222 0.257950 23.9000000 0.259008 23.9027778 0.259008 23.9055556 0.258215 23.9083333 0.258479 23.9111111 0.260331 23.9138889 0.258744 23.9166667 0.256628 23.9194444 0.253983 23.9222222 0.253983 23.9250000 0.253983 23.9277778 0.255570 23.9305556 0.256099 23.9333333 0.258215 23.9361111 0.259802 23.9388889 0.259802 23.9416667 0.258479 23.9444444 0.258215 23.9472222 0.261653 23.9500000 0.263504 23.9527778 0.260066 23.9555556 0.253190 23.9583333 0.247107 23.9611111 0.246843 23.9638889 0.250281 23.9666667 0.255041 23.9694444 0.257686 23.9722222 0.257950 23.9750000 0.256364 23.9777778 0.253455 23.9805556 0.250545 23.9833333 0.248959 23.9861111 0.247901 23.9888889 0.248959 23.9916667 0.249488 23.9944444 0.248165 23.9972222 0.248165 24.0030000 0.300000 24.1470000 0.300000 24.1500000 0.248694 24.1527778 0.253190 24.1555556 0.253983 24.1583333 0.252661 24.1611111 0.250017 24.1638889 0.247107 24.1666667 0.243934 24.1694444 0.242347 24.1722222 0.243934 24.1750000 0.247901 24.1777778 0.252132 24.1805556 0.252661 24.1833333 0.252397 24.1861111 0.251339 24.1888889 0.250017 24.1916667 0.249488 24.1944444 0.249752 24.1972222 0.250545 24.2000000 0.251339 24.2027778 0.251603 24.2055556 0.252661 24.2083333 0.254248 24.2111111 0.255306 24.2138889 0.254248 24.2166667 0.252132 24.2194444 0.250810 24.2222222 0.251074 24.2250000 0.253719 24.2277778 0.255041 24.2305556 0.257157 24.2333333 0.257686 24.2361111 0.257421 24.2388889 0.256893 24.2416667 0.256099 24.2444444 0.257686 24.2472222 0.261653 24.2500000 0.263769 24.2527778 0.262711 24.2555556 0.256893 24.2583333 0.253983 24.2611111 0.254248 24.2638889 0.260331 24.2666667 0.266149 24.2694444 0.270380 24.2722222 0.270116 24.2750000 0.265091 24.2777778 0.260331 24.2805556 0.259537 24.2833333 0.262446 24.2861111 0.264033 24.2888889 0.264298 24.2916667 0.265620 24.2944444 0.268000 24.2972222 0.272760 24.3000000 0.273289 24.3027778 0.270116 24.3055556 0.267207 24.3083333 0.266942 24.3111111 0.268000 24.3138889 0.269587 24.3166667 0.270645 24.3194444 0.273289 24.3222222 0.275140 24.3250000 0.275934 24.3277778 0.276463 24.3305556 0.278579 24.3333333 0.280165 24.3361111 0.282545 24.3388889 0.282281 24.3416667 0.278843 24.3444444 0.274083 24.3472222 0.273289 24.3500000 0.275669 24.3527778 0.277256 24.3555556 0.276463 24.3583333 0.276727 24.3611111 0.273554 24.3638889 0.267736 24.3666667 0.259273 24.3694444 0.250810 24.3722222 0.242876 24.3750000 0.238645 24.3777778 0.236000 24.3805556 0.236000 24.3833333 0.238380 24.3861111 0.243669 24.3888889 0.247636 24.3916667 0.246314 24.3944444 0.241554 24.3972222 0.239967 24.4000000 0.242876 24.4027778 0.247372 24.4055556 0.250545 24.4083333 0.253983 24.4111111 0.255306 24.4138889 0.255570 24.4166667 0.258215 24.4194444 0.261653 24.4222222 0.262711 24.4250000 0.261917 24.4277778 0.262975 24.4305556 0.269587 24.4333333 0.277521 24.4361111 0.280165 24.4388889 0.276992 24.4416667 0.274347 24.4444444 0.274876 24.4472222 0.278843 24.4500000 0.283868 24.4527778 0.288364 24.4555556 0.292331 24.4583333 0.296298 24.4611111 0.300000 24.4638889 0.301587 24.4666667 0.301587 24.4694444 0.304231 24.4722222 0.306612 24.4750000 0.309521 24.4777778 0.311901 24.4805556 0.311901 24.4833333 0.311901 24.4861111 0.312165 24.4888889 0.314810 24.4916667 0.319306 24.4944444 0.323537 24.4972222 0.326182 24.5000000 0.326446 24.5027778 0.326182 24.5055556 0.326711 24.5083333 0.328562 24.5111111 0.329355 24.5138889 0.329884 24.5166667 0.329884 24.5194444 0.329884 24.5222222 0.330413 24.5250000 0.331736 24.5277778 0.334645 24.5305556 0.335702 24.5333333 0.334645 24.5361111 0.332529 24.5388889 0.330413 24.5416667 0.329620 24.5444444 0.327240 24.5472222 0.320364 24.5500000 0.310314 24.5527778 0.304760 24.5555556 0.305554 24.5583333 0.308198 24.5611111 0.309521 24.5638889 0.307934 24.5666667 0.308992 24.5694444 0.311636 24.5722222 0.311372 24.5750000 0.308727 24.5777778 0.307669 24.5805556 0.308198 24.5833333 0.310579 24.5861111 0.310579 24.5888889 0.309256 24.5916667 0.305289 24.5944444 0.302380 24.5972222 0.300793 24.6000000 0.301058 24.6027778 0.303438 24.6055556 0.305025 24.6083333 0.305025 24.6111111 0.302909 24.6138889 0.302116 24.6166667 0.300529 24.6194444 0.298149 24.6222222 0.295240 24.6250000 0.293124 24.6277778 0.291273 24.6305556 0.289950 24.6333333 0.288628 24.6361111 0.289157 24.6388889 0.290215 24.6416667 0.291273 24.6444444 0.292331 24.6472222 0.292331 24.6500000 0.291008 24.6527778 0.290479 24.6555556 0.289421 24.6583333 0.290215 24.6611111 0.292066 24.6638889 0.294182 24.6666667 0.293653 24.6694444 0.292595 24.6722222 0.292860 24.6750000 0.294446 24.6777778 0.296826 24.6805556 0.296033 24.6833333 0.295769 24.6861111 0.296033 24.6888889 0.292860 24.6916667 0.286777 24.6944444 0.282545 24.6972222 0.284132 24.7030000 0.300000 24.8470000 0.300000 24.8500000 0.324595 24.8527778 0.326975 24.8555556 0.326711 24.8583333 0.322744 24.8611111 0.319570 24.8638889 0.320099 24.8666667 0.322744 24.8694444 0.325124 24.8722222 0.326182 24.8750000 0.326446 24.8777778 0.325917 24.8805556 0.326182 24.8833333 0.326446 24.8861111 0.328562 24.8888889 0.331471 24.8916667 0.333322 24.8944444 0.334645 24.8972222 0.335702 24.9000000 0.335438 24.9027778 0.335967 24.9055556 0.336496 24.9083333 0.337554 24.9111111 0.337818 24.9138889 0.339140 24.9166667 0.339405 24.9194444 0.339405 24.9222222 0.339669 24.9250000 0.339934 24.9277778 0.339934 24.9305556 0.340463 24.9333333 0.340992 24.9361111 0.340727 24.9388889 0.341256 24.9416667 0.341785 24.9444444 0.343107 24.9472222 0.343372 24.9500000 0.341256 24.9527778 0.338876 24.9555556 0.336760 24.9583333 0.336496 24.9611111 0.334909 24.9638889 0.336496 24.9666667 0.337025 24.9694444 0.336760 24.9722222 0.334645 24.9750000 0.333587 24.9777778 0.333851 24.9805556 0.335438 24.9833333 0.336760 24.9861111 0.337554 24.9888889 0.337554 24.9916667 0.336496 24.9944444 0.336496 24.9972222 0.333058 25.0000000 0.328033 25.0027778 0.323537 25.0055556 0.323273 25.0083333 0.324066 25.0111111 0.324066 25.0138889 0.324595 25.0166667 0.325388 25.0194444 0.325124 25.0222222 0.324595 25.0250000 0.322479 25.0277778 0.321421 25.0305556 0.321950 25.0333333 0.322744 25.0361111 0.323802 25.0388889 0.324331 25.0416667 0.323537 25.0444444 0.324331 25.0472222 0.325124 25.0500000 0.325653 25.0527778 0.326182 25.0555556 0.323537 25.0583333 0.320364 25.0611111 0.316661 25.0638889 0.313488 25.0666667 0.309785 25.0694444 0.302645 25.0722222 0.292066 25.0750000 0.283339 25.0777778 0.278050 25.0805556 0.278314 25.0833333 0.278843 25.0861111 0.280165 25.0888889 0.280959 25.0916667 0.282545 25.0944444 0.283339 25.0972222 0.285190 25.1000000 0.286777 25.1027778 0.287041 25.1055556 0.288099 25.1083333 0.289157 25.1111111 0.291273 25.1138889 0.294446 25.1166667 0.297884 25.1194444 0.300000 25.1222222 0.300000 25.1250000 0.300529 25.1277778 0.302909 25.1305556 0.308992 25.1333333 0.314281 25.1361111 0.317719 25.1388889 0.320364 25.1416667 0.322744 25.1444444 0.325388 25.1472222 0.327769 25.1500000 0.330678 25.1527778 0.332529 25.1555556 0.334645 25.1583333 0.335438 25.1611111 0.335967 25.1638889 0.336496 25.1666667 0.338347 25.1694444 0.339140 25.1722222 0.340463 25.1750000 0.340727 25.1777778 0.340727 25.1805556 0.342314 25.1833333 0.343107 25.1861111 0.343636 25.1888889 0.343901 25.1916667 0.343636 25.1944444 0.343901 25.1972222 0.344694 25.2000000 0.345488 25.2027778 0.346281 25.2055556 0.345752 25.2083333 0.346017 25.2111111 0.345752 25.2138889 0.346545 25.2166667 0.347339 25.2194444 0.348132 25.2222222 0.348397 25.2250000 0.347603 25.2277778 0.348661 25.2305556 0.348397 25.2333333 0.349719 25.2361111 0.349983 25.2388889 0.349455 25.2416667 0.349983 25.2444444 0.349719 25.2472222 0.350248 25.2500000 0.350248 25.2527778 0.350512 25.2555556 0.350777 25.2583333 0.350512 25.2611111 0.349983 25.2638889 0.351041 25.2666667 0.351306 25.2694444 0.351570 25.2722222 0.351835 25.2750000 0.351570 25.2777778 0.351835 25.2805556 0.352099 25.2833333 0.352628 25.2861111 0.353421 25.2888889 0.353421 25.2916667 0.353421 25.2944444 0.352364 25.2972222 0.353157 25.3000000 0.353686 25.3027778 0.354215 25.3055556 0.354215 25.3083333 0.353950 25.3111111 0.352893 25.3138889 0.353157 25.3166667 0.354215 25.3194444 0.354215 25.3222222 0.353950 25.3250000 0.353686 25.3277778 0.353421 25.3305556 0.353950 25.3333333 0.353421 25.3361111 0.354744 25.3388889 0.354479 25.3416667 0.353950 25.3444444 0.353421 25.3472222 0.353686 25.3500000 0.354215 25.3527778 0.354215 25.3555556 0.353950 25.3583333 0.352628 25.3611111 0.352628 25.3638889 0.352893 25.3666667 0.352628 25.3694444 0.353157 25.3722222 0.352628 25.3750000 0.352099 25.3777778 0.351306 25.3805556 0.351570 25.3833333 0.351835 25.3861111 0.351570 25.3888889 0.351041 25.3916667 0.350248 25.3944444 0.350512 25.3972222 0.349983 25.4030000 0.300000 25.5470000 0.300000 25.5500000 0.346281 25.5527778 0.345752 25.5555556 0.346017 25.5583333 0.346017 25.5611111 0.346810 25.5638889 0.347074 25.5666667 0.347074 25.5694444 0.346810 25.5722222 0.346281 25.5750000 0.345488 25.5777778 0.345752 25.5805556 0.347074 25.5833333 0.348397 25.5861111 0.349455 25.5888889 0.347603 25.5916667 0.345488 25.5944444 0.344430 25.5972222 0.344959 25.6000000 0.344430 25.6027778 0.344959 25.6055556 0.344165 25.6083333 0.343107 25.6111111 0.343372 25.6138889 0.343901 25.6166667 0.344430 25.6194444 0.344694 25.6222222 0.343901 25.6250000 0.343372 25.6277778 0.343636 25.6305556 0.343901 25.6333333 0.342843 25.6361111 0.343107 25.6388889 0.340727 25.6416667 0.337025 25.6444444 0.333851 25.6472222 0.334645 25.6500000 0.336496 25.6527778 0.339140 25.6555556 0.338083 25.6583333 0.337289 25.6611111 0.337554 25.6638889 0.338612 25.6666667 0.339669 25.6694444 0.339405 25.6722222 0.339140 25.6750000 0.338347 25.6777778 0.338876 25.6805556 0.339934 25.6833333 0.339405 25.6861111 0.339934 25.6888889 0.339405 25.6916667 0.339669 25.6944444 0.340463 25.6972222 0.341521 25.7000000 0.342843 25.7027778 0.343372 25.7055556 0.341785 25.7083333 0.340727 25.7111111 0.341521 25.7138889 0.340463 25.7166667 0.340463 25.7194444 0.340198 25.7222222 0.339140 25.7250000 0.339140 25.7277778 0.339669 25.7305556 0.340727 25.7333333 0.341256 25.7361111 0.340463 25.7388889 0.339140 25.7416667 0.336760 25.7444444 0.333851 25.7472222 0.331736 25.7500000 0.328826 25.7527778 0.324331 25.7555556 0.317455 25.7583333 0.308992 25.7611111 0.300793 25.7638889 0.294711 25.7666667 0.291537 25.7694444 0.290744 25.7722222 0.290479 25.7750000 0.290744 25.7777778 0.291802 25.7805556 0.292331 25.7833333 0.293653 25.7861111 0.294975 25.7888889 0.296033 25.7916667 0.297091 25.7944444 0.298942 25.7972222 0.300000 25.8000000 0.301058 25.8027778 0.300529 25.8055556 0.301322 25.8083333 0.301322 25.8111111 0.303702 25.8138889 0.306612 25.8166667 0.309256 25.8194444 0.310579 25.8222222 0.312165 25.8250000 0.314810 25.8277778 0.318777 25.8305556 0.322479 25.8333333 0.326446 25.8361111 0.329091 25.8388889 0.331736 25.8416667 0.332529 25.8444444 0.334380 25.8472222 0.336760 25.8500000 0.339140 25.8527778 0.341521 25.8555556 0.344165 25.8583333 0.345488 25.8611111 0.347603 25.8638889 0.349190 25.8666667 0.350248 25.8694444 0.350512 25.8722222 0.350248 25.8750000 0.350512 25.8777778 0.351306 25.8805556 0.352099 25.8833333 0.352364 25.8861111 0.352893 25.8888889 0.353157 25.8916667 0.353157 25.8944444 0.353950 25.8972222 0.354215 25.9000000 0.353950 25.9027778 0.354744 25.9055556 0.354215 25.9083333 0.355537 25.9111111 0.355537 25.9138889 0.355537 25.9166667 0.355273 25.9194444 0.355008 25.9222222 0.354479 25.9250000 0.353950 25.9277778 0.355008 25.9305556 0.355273 25.9333333 0.356066 25.9361111 0.355273 25.9388889 0.355537 25.9416667 0.356066 25.9444444 0.356860 25.9472222 0.357653 25.9500000 0.357917 25.9527778 0.358711 25.9555556 0.358446 25.9583333 0.357917 25.9611111 0.358182 25.9638889 0.358975 25.9666667 0.358975 25.9694444 0.358446 25.9722222 0.358446 25.9750000 0.357653 25.9777778 0.358446 25.9805556 0.358975 25.9833333 0.360033 25.9861111 0.360298 25.9888889 0.359769 25.9916667 0.358975 25.9944444 0.360033 25.9972222 0.360562 26.0000000 0.360298 26.0027778 0.359504 26.0055556 0.358711 26.0083333 0.358975 26.0111111 0.358975 26.0138889 0.359504 26.0166667 0.358975 26.0194444 0.358446 26.0222222 0.357917 26.0250000 0.357388 26.0277778 0.357388 26.0305556 0.356860 26.0333333 0.357388 26.0361111 0.357653 26.0388889 0.356595 26.0416667 0.356860 26.0444444 0.357124 26.0472222 0.358182 26.0500000 0.357917 26.0527778 0.357917 26.0555556 0.357653 26.0583333 0.357388 26.0611111 0.357388 26.0638889 0.357917 26.0666667 0.358711 26.0694444 0.357917 26.0722222 0.357124 26.0750000 0.356860 26.0777778 0.356860 26.0805556 0.357388 26.0833333 0.357388 26.0861111 0.356595 26.0888889 0.355802 26.0916667 0.355537 26.0944444 0.355537 26.0972222 0.355802 26.1030000 0.300000 26.2470000 0.300000 26.2500000 0.354479 26.2527778 0.352364 26.2555556 0.351306 26.2583333 0.350248 26.2611111 0.350777 26.2638889 0.351570 26.2666667 0.352628 26.2694444 0.353686 26.2722222 0.354215 26.2750000 0.352893 26.2777778 0.351306 26.2805556 0.350248 26.2833333 0.350777 26.2861111 0.350512 26.2888889 0.350512 26.2916667 0.350777 26.2944444 0.349983 26.2972222 0.351041 26.3000000 0.352099 26.3027778 0.352364 26.3055556 0.352099 26.3083333 0.352099 26.3111111 0.351835 26.3138889 0.352364 26.3166667 0.351570 26.3194444 0.352099 26.3222222 0.351835 26.3250000 0.352628 26.3277778 0.352893 26.3305556 0.353157 26.3333333 0.352099 26.3361111 0.351041 26.3388889 0.349455 26.3416667 0.348132 26.3444444 0.348661 26.3472222 0.349190 26.3500000 0.350512 26.3527778 0.350248 26.3555556 0.350777 26.3583333 0.350512 26.3611111 0.350512 26.3638889 0.351041 26.3666667 0.351570 26.3694444 0.353157 26.3722222 0.354744 26.3750000 0.354744 26.3777778 0.353421 26.3805556 0.351041 26.3833333 0.349719 26.3861111 0.349190 26.3888889 0.349190 26.3916667 0.349455 26.3944444 0.349983 26.3972222 0.349719 26.4000000 0.350248 26.4027778 0.349455 26.4055556 0.349190 26.4083333 0.349719 26.4111111 0.349190 26.4138889 0.349719 26.4166667 0.350248 26.4194444 0.350777 26.4222222 0.351306 26.4250000 0.351041 26.4277778 0.350512 26.4305556 0.350777 26.4333333 0.351570 26.4361111 0.352099 26.4388889 0.351835 26.4416667 0.351570 26.4444444 0.351835 26.4472222 0.350512 26.4500000 0.348926 26.4527778 0.346281 26.4555556 0.342314 26.4583333 0.338347 26.4611111 0.333322 26.4638889 0.326975 26.4666667 0.319570 26.4694444 0.310050 26.4722222 0.301322 26.4750000 0.297091 26.4777778 0.297091 26.4805556 0.298678 26.4833333 0.299736 26.4861111 0.301322 26.4888889 0.302116 26.4916667 0.302380 26.4944444 0.304496 26.4972222 0.306083 26.5000000 0.307934 26.5027778 0.309521 26.5055556 0.310843 26.5083333 0.310843 26.5111111 0.311901 26.5138889 0.314281 26.5166667 0.317455 26.5194444 0.321157 26.5222222 0.322744 26.5250000 0.323802 26.5277778 0.325124 26.5305556 0.329355 26.5333333 0.333058 26.5361111 0.336760 26.5388889 0.337818 26.5416667 0.338876 26.5444444 0.340992 26.5472222 0.343372 26.5500000 0.347074 26.5527778 0.349719 26.5555556 0.352099 26.5583333 0.353686 26.5611111 0.355273 26.5638889 0.357388 26.5666667 0.358182 26.5694444 0.358975 26.5722222 0.360033 26.5750000 0.360826 26.5777778 0.360826 26.5805556 0.360298 26.5833333 0.360298 26.5861111 0.361355 26.5888889 0.361620 26.5916667 0.361884 26.5944444 0.362942 26.5972222 0.364264 26.6000000 0.364793 26.6027778 0.364000 26.6055556 0.362413 26.6083333 0.361884 26.6111111 0.361355 26.6138889 0.362942 26.6166667 0.363736 26.6194444 0.363736 26.6222222 0.364000 26.6250000 0.363736 26.6277778 0.363471 26.6305556 0.363471 26.6333333 0.364264 26.6361111 0.364264 26.6388889 0.364264 26.6416667 0.363736 26.6444444 0.364529 26.6472222 0.365058 26.6500000 0.365587 26.6527778 0.366380 26.6555556 0.366116 26.6583333 0.366116 26.6611111 0.365851 26.6638889 0.366380 26.6666667 0.366380 26.6694444 0.366380 26.6722222 0.366909 26.6750000 0.366380 26.6777778 0.366909 26.6805556 0.367967 26.6833333 0.367438 26.6861111 0.365851 26.6888889 0.364793 26.6916667 0.364793 26.6944444 0.365587 26.6972222 0.368496 26.7000000 0.370083 26.7027778 0.370083 26.7055556 0.367702 26.7083333 0.364529 26.7111111 0.363471 26.7138889 0.364264 26.7166667 0.365851 26.7194444 0.366909 26.7222222 0.366909 26.7250000 0.365058 26.7277778 0.364264 26.7305556 0.363207 26.7333333 0.363736 26.7361111 0.364529 26.7388889 0.363736 26.7416667 0.363736 26.7444444 0.363471 26.7472222 0.363471 26.7500000 0.364000 26.7527778 0.364793 26.7555556 0.364000 26.7583333 0.364000 26.7611111 0.363207 26.7638889 0.363207 26.7666667 0.364000 26.7694444 0.364000 26.7722222 0.364000 26.7750000 0.364000 26.7777778 0.364000 26.7805556 0.364000 26.7833333 0.363207 26.7861111 0.362149 26.7888889 0.361620 26.7916667 0.361620 26.7944444 0.361091 26.7972222 0.361091 26.8030000 0.300000 26.9470000 0.300000 26.9500000 0.355008 26.9527778 0.356595 26.9555556 0.357653 26.9583333 0.357124 26.9611111 0.357388 26.9638889 0.355802 26.9666667 0.354744 26.9694444 0.354479 26.9722222 0.353950 26.9750000 0.352893 26.9777778 0.352893 26.9805556 0.351835 26.9833333 0.351570 26.9861111 0.351835 26.9888889 0.352628 26.9916667 0.352893 26.9944444 0.352893 26.9972222 0.352364 27.0000000 0.352099 27.0027778 0.352628 27.0055556 0.353157 27.0083333 0.353421 27.0111111 0.353157 27.0138889 0.352364 27.0166667 0.351835 27.0194444 0.352893 27.0222222 0.353157 27.0250000 0.353421 27.0277778 0.352893 27.0305556 0.351570 27.0333333 0.350512 27.0361111 0.350777 27.0388889 0.351041 27.0416667 0.351041 27.0444444 0.350777 27.0472222 0.350512 27.0500000 0.350777 27.0527778 0.351306 27.0555556 0.351306 27.0583333 0.350777 27.0611111 0.350512 27.0638889 0.349983 27.0666667 0.349190 27.0694444 0.349983 27.0722222 0.350248 27.0750000 0.350248 27.0777778 0.350777 27.0805556 0.351041 27.0833333 0.351835 27.0861111 0.351835 27.0888889 0.351041 27.0916667 0.350248 27.0944444 0.350248 27.0972222 0.349983 27.1000000 0.350512 27.1027778 0.349983 27.1055556 0.348926 27.1083333 0.348132 27.1111111 0.347868 27.1138889 0.347339 27.1166667 0.347074 27.1194444 0.347868 27.1222222 0.348926 27.1250000 0.348397 27.1277778 0.348661 27.1305556 0.348132 27.1333333 0.348132 27.1361111 0.348926 27.1388889 0.350512 27.1416667 0.350777 27.1444444 0.349983 27.1472222 0.347339 27.1500000 0.343901 27.1527778 0.340727 27.1555556 0.337818 27.1583333 0.333587 27.1611111 0.326975 27.1638889 0.316397 27.1666667 0.306612 27.1694444 0.298149 27.1722222 0.294711 27.1750000 0.295504 27.1777778 0.295769 27.1805556 0.295769 27.1833333 0.296562 27.1861111 0.297884 27.1888889 0.299736 27.1916667 0.301851 27.1944444 0.303702 27.1972222 0.304231 27.2000000 0.304760 27.2027778 0.306612 27.2055556 0.307669 27.2083333 0.307934 27.2111111 0.309785 27.2138889 0.311107 27.2166667 0.313488 27.2194444 0.314810 27.2222222 0.317455 27.2250000 0.319570 27.2277778 0.322215 27.2305556 0.324860 27.2333333 0.326446 27.2361111 0.329091 27.2388889 0.333058 27.2416667 0.335967 27.2444444 0.339140 27.2472222 0.342314 27.2500000 0.344694 27.2527778 0.347868 27.2555556 0.351835 27.2583333 0.353421 27.2611111 0.353950 27.2638889 0.354479 27.2666667 0.353421 27.2694444 0.353950 27.2722222 0.354744 27.2750000 0.355008 27.2777778 0.355273 27.2805556 0.354744 27.2833333 0.355008 27.2861111 0.355802 27.2888889 0.356860 27.2916667 0.357124 27.2944444 0.358446 27.2972222 0.359504 27.3000000 0.359769 27.3027778 0.359240 27.3055556 0.358446 27.3083333 0.356595 27.3111111 0.357917 27.3138889 0.357124 27.3166667 0.357653 27.3194444 0.358182 27.3222222 0.358711 27.3250000 0.358975 27.3277778 0.359240 27.3305556 0.358446 27.3333333 0.358182 27.3361111 0.359240 27.3388889 0.359769 27.3416667 0.360298 27.3444444 0.359504 27.3472222 0.359240 27.3500000 0.359769 27.3527778 0.360033 27.3555556 0.361355 27.3583333 0.361620 27.3611111 0.362413 27.3638889 0.360826 27.3666667 0.359240 27.3694444 0.358711 27.3722222 0.358975 27.3750000 0.358711 27.3777778 0.358975 27.3805556 0.357917 27.3833333 0.357917 27.3861111 0.359240 27.3888889 0.359769 27.3916667 0.359769 27.3944444 0.358711 27.3972222 0.358975 27.4000000 0.358711 27.4027778 0.358182 27.4055556 0.359240 27.4083333 0.360033 27.4111111 0.360298 27.4138889 0.360033 27.4166667 0.359240 27.4194444 0.359769 27.4222222 0.359769 27.4250000 0.358975 27.4277778 0.357917 27.4305556 0.357917 27.4333333 0.357388 27.4361111 0.357917 27.4388889 0.359240 27.4416667 0.359240 27.4444444 0.358975 27.4472222 0.358711 27.4500000 0.358446 27.4527778 0.357124 27.4555556 0.357124 27.4583333 0.356066 27.4611111 0.356595 27.4638889 0.356331 27.4666667 0.356331 27.4694444 0.356595 27.4722222 0.356860 27.4750000 0.356595 27.4777778 0.356331 27.4805556 0.355802 27.4833333 0.355802 27.4861111 0.356595 27.4888889 0.355802 27.4916667 0.355537 27.4944444 0.355537 27.4972222 0.354744 27.5030000 0.300000 27.6470000 0.300000 27.6500000 0.339140 27.6527778 0.339934 27.6555556 0.340727 27.6583333 0.340463 27.6611111 0.339669 27.6638889 0.339140 27.6666667 0.339934 27.6694444 0.340727 27.6722222 0.341256 27.6750000 0.341256 27.6777778 0.341521 27.6805556 0.341256 27.6833333 0.341521 27.6861111 0.341521 27.6888889 0.340198 27.6916667 0.339669 27.6944444 0.339140 27.6972222 0.338347 27.7000000 0.338347 27.7027778 0.339140 27.7055556 0.339140 27.7083333 0.338347 27.7111111 0.338083 27.7138889 0.337818 27.7166667 0.337554 27.7194444 0.338612 27.7222222 0.339934 27.7250000 0.340727 27.7277778 0.339669 27.7305556 0.338347 27.7333333 0.337554 27.7361111 0.337025 27.7388889 0.337554 27.7416667 0.338612 27.7444444 0.337818 27.7472222 0.337025 27.7500000 0.336496 27.7527778 0.337025 27.7555556 0.337289 27.7583333 0.337289 27.7611111 0.337025 27.7638889 0.336760 27.7666667 0.336496 27.7694444 0.337025 27.7722222 0.337289 27.7750000 0.337025 27.7777778 0.335967 27.7805556 0.336496 27.7833333 0.336231 27.7861111 0.337025 27.7888889 0.339405 27.7916667 0.339140 27.7944444 0.337818 27.7972222 0.336760 27.8000000 0.335702 27.8027778 0.335967 27.8055556 0.337025 27.8083333 0.336231 27.8111111 0.336760 27.8138889 0.338347 27.8166667 0.339405 27.8194444 0.338347 27.8222222 0.337818 27.8250000 0.335174 27.8277778 0.333587 27.8305556 0.333322 27.8333333 0.333322 27.8361111 0.334380 27.8388889 0.335702 27.8416667 0.336231 27.8444444 0.337289 27.8472222 0.336760 27.8500000 0.336231 27.8527778 0.334909 27.8555556 0.332529 27.8583333 0.329091 27.8611111 0.325388 27.8638889 0.319570 27.8666667 0.312430 27.8694444 0.302380 27.8722222 0.292331 27.8750000 0.283603 27.8777778 0.279901 27.8805556 0.279901 27.8833333 0.280430 27.8861111 0.280694 27.8888889 0.280430 27.8916667 0.281223 27.8944444 0.282281 27.8972222 0.284926 27.9000000 0.286777 27.9027778 0.288628 27.9055556 0.291008 27.9083333 0.292595 27.9111111 0.293917 27.9138889 0.296562 27.9166667 0.297355 27.9194444 0.300000 27.9222222 0.302645 27.9250000 0.304496 27.9277778 0.308992 27.9305556 0.312694 27.9333333 0.316132 27.9361111 0.319570 27.9388889 0.321950 27.9416667 0.324331 27.9444444 0.327504 27.9472222 0.330942 27.9500000 0.334116 27.9527778 0.337289 27.9555556 0.341521 27.9583333 0.345223 27.9611111 0.346810 27.9638889 0.345223 27.9666667 0.342843 27.9694444 0.340727 27.9722222 0.341256 27.9750000 0.342579 27.9777778 0.343107 27.9805556 0.343372 27.9833333 0.343372 27.9861111 0.344165 27.9888889 0.344959 27.9916667 0.345223 27.9944444 0.344959 27.9972222 0.344959 28.0000000 0.345223 28.0027778 0.345752 28.0055556 0.346810 28.0083333 0.346281 28.0111111 0.346281 28.0138889 0.347074 28.0166667 0.346810 28.0194444 0.347603 28.0222222 0.348926 28.0250000 0.348397 28.0277778 0.348397 28.0305556 0.346545 28.0333333 0.344165 28.0361111 0.345223 28.0388889 0.347074 28.0416667 0.347603 28.0444444 0.346810 28.0472222 0.344959 28.0500000 0.344430 28.0527778 0.345488 28.0555556 0.346281 28.0583333 0.346281 28.0611111 0.346810 28.0638889 0.346017 28.0666667 0.346281 28.0694444 0.346545 28.0722222 0.347074 28.0750000 0.347339 28.0777778 0.347868 28.0805556 0.347603 28.0833333 0.347868 28.0861111 0.346810 28.0888889 0.346810 28.0916667 0.346017 28.0944444 0.345752 28.0972222 0.346017 28.1000000 0.345223 28.1027778 0.345223 28.1055556 0.345223 28.1083333 0.344165 28.1111111 0.345223 28.1138889 0.344959 28.1166667 0.344959 28.1194444 0.345488 28.1222222 0.346281 28.1250000 0.345488 28.1277778 0.345488 28.1305556 0.345223 28.1333333 0.344165 28.1361111 0.344430 28.1388889 0.344959 28.1416667 0.345223 28.1444444 0.345488 28.1472222 0.346017 28.1500000 0.347074 28.1527778 0.347074 28.1555556 0.344959 28.1583333 0.342843 28.1611111 0.340992 28.1638889 0.341785 28.1666667 0.342579 28.1694444 0.341521 28.1722222 0.340727 28.1750000 0.340992 28.1777778 0.340992 28.1805556 0.340198 28.1833333 0.339405 28.1861111 0.339934 28.1888889 0.339934 28.1916667 0.339669 28.1944444 0.339140 28.1972222 0.338347 28.2030000 0.300000 28.3470000 0.300000 28.3500000 0.333058 28.3527778 0.334380 28.3555556 0.334380 28.3583333 0.333851 28.3611111 0.333322 28.3638889 0.333058 28.3666667 0.333851 28.3694444 0.334909 28.3722222 0.335702 28.3750000 0.335438 28.3777778 0.335174 28.3805556 0.335702 28.3833333 0.336231 28.3861111 0.336231 28.3888889 0.335967 28.3916667 0.336760 28.3944444 0.337025 28.3972222 0.336496 28.4000000 0.336496 28.4027778 0.336231 28.4055556 0.335702 28.4083333 0.335438 28.4111111 0.335174 28.4138889 0.334645 28.4166667 0.336231 28.4194444 0.337554 28.4222222 0.337818 28.4250000 0.337025 28.4277778 0.335702 28.4305556 0.333851 28.4333333 0.333851 28.4361111 0.334380 28.4388889 0.335174 28.4416667 0.334645 28.4444444 0.334380 28.4472222 0.334116 28.4500000 0.334380 28.4527778 0.336231 28.4555556 0.336496 28.4583333 0.336496 28.4611111 0.334645 28.4638889 0.333058 28.4666667 0.333058 28.4694444 0.333587 28.4722222 0.333851 28.4750000 0.333322 28.4777778 0.333058 28.4805556 0.332793 28.4833333 0.333851 28.4861111 0.334645 28.4888889 0.334909 28.4916667 0.335702 28.4944444 0.334645 28.4972222 0.332793 28.5000000 0.331736 28.5027778 0.332264 28.5055556 0.333058 28.5083333 0.332793 28.5111111 0.332264 28.5138889 0.332529 28.5166667 0.333322 28.5194444 0.333587 28.5222222 0.334645 28.5250000 0.335967 28.5277778 0.336760 28.5305556 0.335702 28.5333333 0.333851 28.5361111 0.332264 28.5388889 0.330942 28.5416667 0.330942 28.5444444 0.330942 28.5472222 0.332000 28.5500000 0.332529 28.5527778 0.333587 28.5555556 0.331736 28.5583333 0.328298 28.5611111 0.324066 28.5638889 0.318777 28.5666667 0.312959 28.5694444 0.303967 28.5722222 0.293124 28.5750000 0.281488 28.5777778 0.275140 28.5805556 0.275405 28.5833333 0.277256 28.5861111 0.278579 28.5888889 0.280165 28.5916667 0.280959 28.5944444 0.281752 28.5972222 0.284397 28.6000000 0.287306 28.6027778 0.290479 28.6055556 0.289686 28.6083333 0.289157 28.6111111 0.291008 28.6138889 0.293124 28.6166667 0.295240 28.6194444 0.297620 28.6222222 0.299736 28.6250000 0.302909 28.6277778 0.306347 28.6305556 0.311636 28.6333333 0.315868 28.6361111 0.320099 28.6388889 0.323273 28.6416667 0.327769 28.6444444 0.333058 28.6472222 0.340463 28.6500000 0.346017 28.6527778 0.350777 28.6555556 0.355273 28.6583333 0.360826 28.6611111 0.366645 28.6638889 0.373785 28.6666667 0.380397 28.6694444 0.385421 28.6722222 0.387802 28.6750000 0.391240 28.6777778 0.393355 28.6805556 0.395207 28.6833333 0.394678 28.6861111 0.395471 28.6888889 0.396529 28.6916667 0.397322 28.6944444 0.399438 28.6972222 0.402612 28.7000000 0.404727 28.7027778 0.405785 28.7055556 0.404727 28.7083333 0.404992 28.7111111 0.405256 28.7138889 0.406843 28.7166667 0.408430 28.7194444 0.409752 28.7222222 0.408694 28.7250000 0.409223 28.7277778 0.409223 28.7305556 0.410281 28.7333333 0.410545 28.7361111 0.411868 28.7388889 0.411868 28.7416667 0.411868 28.7444444 0.411603 28.7472222 0.411074 28.7500000 0.411074 28.7527778 0.414512 28.7555556 0.416099 28.7583333 0.413455 28.7611111 0.409223 28.7638889 0.407901 28.7666667 0.408430 28.7694444 0.410281 28.7722222 0.410810 28.7750000 0.410810 28.7777778 0.409223 28.7805556 0.409488 28.7833333 0.410810 28.7861111 0.411074 28.7888889 0.410810 28.7916667 0.410281 28.7944444 0.409488 28.7972222 0.409752 28.8000000 0.410810 28.8027778 0.411339 28.8055556 0.410281 28.8083333 0.410810 28.8111111 0.411868 28.8138889 0.413983 28.8166667 0.416099 28.8194444 0.417686 28.8222222 0.417686 28.8250000 0.417157 28.8277778 0.417157 28.8305556 0.417950 28.8333333 0.420860 28.8361111 0.420860 28.8388889 0.418744 28.8416667 0.416364 28.8444444 0.415041 28.8472222 0.415570 28.8500000 0.416893 28.8527778 0.418215 28.8555556 0.418215 28.8583333 0.417950 28.8611111 0.417157 28.8638889 0.415835 28.8666667 0.415835 28.8694444 0.415835 28.8722222 0.415306 28.8750000 0.415570 28.8777778 0.415306 28.8805556 0.415306 28.8833333 0.415835 28.8861111 0.416364 28.8888889 0.415041 28.8916667 0.413455 28.8944444 0.412926 28.8972222 0.411868 28.9030000 0.300000 29.0470000 0.300000 29.0500000 0.375372 29.0527778 0.375901 29.0555556 0.376165 29.0583333 0.378545 29.0611111 0.379074 29.0638889 0.379074 29.0666667 0.377752 29.0694444 0.376959 29.0722222 0.377223 29.0750000 0.377488 29.0777778 0.377752 29.0805556 0.378281 29.0833333 0.377752 29.0861111 0.376959 29.0888889 0.376694 29.0916667 0.376165 29.0944444 0.376430 29.0972222 0.376430 29.1000000 0.375372 29.1027778 0.373785 29.1055556 0.373256 29.1083333 0.373521 29.1111111 0.374314 29.1138889 0.375372 29.1166667 0.377488 29.1194444 0.377488 29.1222222 0.374843 29.1250000 0.371140 29.1277778 0.368760 29.1305556 0.368231 29.1333333 0.368231 29.1361111 0.368496 29.1388889 0.369289 29.1416667 0.368760 29.1444444 0.369554 29.1472222 0.369025 29.1500000 0.369289 29.1527778 0.368760 29.1555556 0.366116 29.1583333 0.364529 29.1611111 0.363207 29.1638889 0.361091 29.1666667 0.361091 29.1694444 0.360562 29.1722222 0.360562 29.1750000 0.361091 29.1777778 0.361091 29.1805556 0.361620 29.1833333 0.362413 29.1861111 0.362413 29.1888889 0.362942 29.1916667 0.362678 29.1944444 0.361884 29.1972222 0.360298 29.2000000 0.359240 29.2027778 0.360298 29.2055556 0.361884 29.2083333 0.363736 29.2111111 0.362942 29.2138889 0.363736 29.2166667 0.362678 29.2194444 0.360562 29.2222222 0.359240 29.2250000 0.359504 29.2277778 0.360033 29.2305556 0.361620 29.2333333 0.362149 29.2361111 0.360033 29.2388889 0.358975 29.2416667 0.358711 29.2444444 0.359769 29.2472222 0.360562 29.2500000 0.358975 29.2527778 0.355537 29.2555556 0.350512 29.2583333 0.347074 29.2611111 0.342579 29.2638889 0.335438 29.2666667 0.324331 29.2694444 0.310314 29.2722222 0.296826 29.2750000 0.288893 29.2777778 0.285719 29.2805556 0.287041 29.2833333 0.288628 29.2861111 0.287835 29.2888889 0.287835 29.2916667 0.289421 29.2944444 0.292066 29.2972222 0.294711 29.3000000 0.296033 29.3027778 0.297091 29.3055556 0.297620 29.3083333 0.299207 29.3111111 0.302645 29.3138889 0.305289 29.3166667 0.308727 29.3194444 0.312430 29.3222222 0.314017 29.3250000 0.314017 29.3277778 0.315868 29.3305556 0.318777 29.3333333 0.323802 29.3361111 0.328298 29.3388889 0.331736 29.3416667 0.335438 29.3444444 0.339140 29.3472222 0.341256 29.3500000 0.345223 29.3527778 0.348132 29.3555556 0.350777 29.3583333 0.353421 29.3611111 0.357917 29.3638889 0.360562 29.3666667 0.360826 29.3694444 0.360298 29.3722222 0.360826 29.3750000 0.361355 29.3777778 0.362413 29.3805556 0.362942 29.3833333 0.362678 29.3861111 0.363207 29.3888889 0.363207 29.3916667 0.364264 29.3944444 0.365587 29.3972222 0.366909 29.4000000 0.366909 29.4027778 0.366380 29.4055556 0.365322 29.4083333 0.365851 29.4111111 0.366645 29.4138889 0.366909 29.4166667 0.366645 29.4194444 0.364264 29.4222222 0.362942 29.4250000 0.362678 29.4277778 0.363207 29.4305556 0.365322 29.4333333 0.366380 29.4361111 0.365851 29.4388889 0.365058 29.4416667 0.364000 29.4444444 0.363736 29.4472222 0.364000 29.4500000 0.364264 29.4527778 0.364264 29.4555556 0.364000 29.4583333 0.364793 29.4611111 0.364793 29.4638889 0.365851 29.4666667 0.365851 29.4694444 0.365587 29.4722222 0.365587 29.4750000 0.365322 29.4777778 0.365322 29.4805556 0.365587 29.4833333 0.366116 29.4861111 0.365058 29.4888889 0.362942 29.4916667 0.361091 29.4944444 0.361355 29.4972222 0.362413 29.5000000 0.363471 29.5027778 0.363471 29.5055556 0.362149 29.5083333 0.361355 29.5111111 0.361884 29.5138889 0.362413 29.5166667 0.363471 29.5194444 0.364264 29.5222222 0.364000 29.5250000 0.364529 29.5277778 0.362942 29.5305556 0.361884 29.5333333 0.360562 29.5361111 0.359769 29.5388889 0.360033 29.5416667 0.360298 29.5444444 0.361091 29.5472222 0.361620 29.5500000 0.361091 29.5527778 0.360298 29.5555556 0.359769 29.5583333 0.359769 29.5611111 0.360298 29.5638889 0.359240 29.5666667 0.358975 29.5694444 0.357653 29.5722222 0.357917 29.5750000 0.358975 29.5777778 0.361091 29.5805556 0.361091 29.5833333 0.358446 29.5861111 0.355008 29.5888889 0.352628 29.5916667 0.352893 29.5944444 0.353421 29.5972222 0.353686 29.6030000 0.300000 29.7470000 0.300000 29.7500000 0.325124 29.7527778 0.325653 29.7555556 0.326446 29.7583333 0.327240 29.7611111 0.327504 29.7638889 0.326975 29.7666667 0.326446 29.7694444 0.326975 29.7722222 0.327504 29.7750000 0.327240 29.7777778 0.326446 29.7805556 0.326711 29.7833333 0.326446 29.7861111 0.326182 29.7888889 0.325917 29.7916667 0.326182 29.7944444 0.326182 29.7972222 0.326182 29.8000000 0.326446 29.8027778 0.326446 29.8055556 0.326446 29.8083333 0.327240 29.8111111 0.326711 29.8138889 0.326182 29.8166667 0.325388 29.8194444 0.326446 29.8222222 0.327769 29.8250000 0.328033 29.8277778 0.326182 29.8305556 0.324860 29.8333333 0.323802 29.8361111 0.323802 29.8388889 0.324331 29.8416667 0.324331 29.8444444 0.322479 29.8472222 0.320099 29.8500000 0.319570 29.8527778 0.320364 29.8555556 0.321950 29.8583333 0.323008 29.8611111 0.322215 29.8638889 0.320099 29.8666667 0.318777 29.8694444 0.319570 29.8722222 0.320099 29.8750000 0.320628 29.8777778 0.320364 29.8805556 0.319570 29.8833333 0.320099 29.8861111 0.320628 29.8888889 0.321157 29.8916667 0.321950 29.8944444 0.321421 29.8972222 0.320628 29.9000000 0.319835 29.9027778 0.320099 29.9055556 0.321157 29.9083333 0.321686 29.9111111 0.323273 29.9138889 0.322744 29.9166667 0.320893 29.9194444 0.320099 29.9222222 0.319041 29.9250000 0.319041 29.9277778 0.319306 29.9305556 0.318512 29.9333333 0.316661 29.9361111 0.317455 29.9388889 0.318512 29.9416667 0.319835 29.9444444 0.320099 29.9472222 0.317455 29.9500000 0.314281 29.9527778 0.309785 29.9555556 0.304760 29.9583333 0.299207 29.9611111 0.289686 29.9638889 0.277785 29.9666667 0.262975 29.9694444 0.250545 29.9722222 0.243140 29.9750000 0.242876 29.9777778 0.243405 29.9805556 0.244463 29.9833333 0.244727 29.9861111 0.246050 29.9888889 0.248430 29.9916667 0.251868 29.9944444 0.254512 29.9972222 0.257686 30.0000000 0.261124 30.0027778 0.263504 30.0055556 0.262975 30.0083333 0.262446 30.0111111 0.260595 30.0138889 0.261917 30.0166667 0.264826 30.0194444 0.268529 30.0222222 0.273025 30.0250000 0.276992 30.0277778 0.281488 30.0305556 0.286512 30.0333333 0.291008 30.0361111 0.294711 30.0388889 0.298149 30.0416667 0.302116 30.0444444 0.305289 30.0472222 0.308727 30.0500000 0.311636 30.0527778 0.314017 30.0555556 0.317455 30.0583333 0.321157 30.0611111 0.323802 30.0638889 0.324331 30.0666667 0.325124 30.0694444 0.326182 30.0722222 0.326711 30.0750000 0.327504 30.0777778 0.327504 30.0805556 0.327769 30.0833333 0.329355 30.0861111 0.328826 30.0888889 0.328033 30.0916667 0.327769 30.0944444 0.328298 30.0972222 0.329620 30.1000000 0.330413 30.1027778 0.330942 30.1055556 0.329620 30.1083333 0.328562 30.1111111 0.327240 30.1138889 0.327504 30.1166667 0.328826 30.1194444 0.328826 30.1222222 0.330149 30.1250000 0.330678 30.1277778 0.330413 30.1305556 0.329884 30.1333333 0.329355 30.1361111 0.329620 30.1388889 0.330942 30.1416667 0.332000 30.1444444 0.331471 30.1472222 0.331736 30.1500000 0.333058 30.1527778 0.334909 30.1555556 0.333851 30.1583333 0.332000 30.1611111 0.328562 30.1638889 0.327769 30.1666667 0.327504 30.1694444 0.328562 30.1722222 0.331471 30.1750000 0.333587 30.1777778 0.332793 30.1805556 0.330942 30.1833333 0.329091 30.1861111 0.328033 30.1888889 0.329620 30.1916667 0.331207 30.1944444 0.331471 30.1972222 0.329620 30.2000000 0.327240 30.2027778 0.327769 30.2055556 0.328562 30.2083333 0.330413 30.2111111 0.329884 30.2138889 0.329355 30.2166667 0.329620 30.2194444 0.329355 30.2222222 0.329091 30.2250000 0.329620 30.2277778 0.328826 30.2305556 0.328298 30.2333333 0.328298 30.2361111 0.328298 30.2388889 0.329355 30.2416667 0.330678 30.2444444 0.330149 30.2472222 0.328562 30.2500000 0.327240 30.2527778 0.327240 30.2555556 0.328298 30.2583333 0.328562 30.2611111 0.328298 30.2638889 0.327240 30.2666667 0.326711 30.2694444 0.325917 30.2722222 0.325388 30.2750000 0.324860 30.2777778 0.324595 30.2805556 0.323802 30.2833333 0.323273 30.2861111 0.323008 30.2888889 0.323273 30.2916667 0.323537 30.2944444 0.323008 30.2972222 0.322744 30.3030000 0.300000 30.5000000 0.300000)

Vpwb trig_pw_base 0 PWL(0.0000000 0.000000 1.7940444 0.000000 1.7944444 0.900000 1.7949444 0.900000 1.7953444 0.000000 2.4940444 0.000000 2.4944444 0.900000 2.4949444 0.900000 2.4953444 0.000000 3.1940444 0.000000 3.1944444 0.900000 3.1949444 0.900000 3.1953444 0.000000 3.8940444 0.000000 3.8944444 0.900000 3.8949444 0.900000 3.8953444 0.000000 4.5940444 0.000000 4.5944444 0.900000 4.5949444 0.900000 4.5953444 0.000000 5.2940444 0.000000 5.2944444 0.900000 5.2949444 0.900000 5.2953444 0.000000 5.9940444 0.000000 5.9944444 0.900000 5.9949444 0.900000 5.9953444 0.000000 6.6940444 0.000000 6.6944444 0.900000 6.6949444 0.900000 6.6953444 0.000000 7.3940444 0.000000 7.3944444 0.900000 7.3949444 0.900000 7.3953444 0.000000 8.0940444 0.000000 8.0944444 0.900000 8.0949444 0.900000 8.0953444 0.000000 8.7940444 0.000000 8.7944444 0.900000 8.7949444 0.900000 8.7953444 0.000000 9.4940444 0.000000 9.4944444 0.900000 9.4949444 0.900000 9.4953444 0.000000 10.1940444 0.000000 10.1944444 0.900000 10.1949444 0.900000 10.1953444 0.000000 10.8940444 0.000000 10.8944444 0.900000 10.8949444 0.900000 10.8953444 0.000000 11.5940444 0.000000 11.5944444 0.900000 11.5949444 0.900000 11.5953444 0.000000 12.2940444 0.000000 12.2944444 0.900000 12.2949444 0.900000 12.2953444 0.000000 12.9940444 0.000000 12.9944444 0.900000 12.9949444 0.900000 12.9953444 0.000000 13.6940444 0.000000 13.6944444 0.900000 13.6949444 0.900000 13.6953444 0.000000 14.3940444 0.000000 14.3944444 0.900000 14.3949444 0.900000 14.3953444 0.000000 15.0940444 0.000000 15.0944444 0.900000 15.0949444 0.900000 15.0953444 0.000000 15.7940444 0.000000 15.7944444 0.900000 15.7949444 0.900000 15.7953444 0.000000 16.4940444 0.000000 16.4944444 0.900000 16.4949444 0.900000 16.4953444 0.000000 17.1940444 0.000000 17.1944444 0.900000 17.1949444 0.900000 17.1953444 0.000000 17.8940444 0.000000 17.8944444 0.900000 17.8949444 0.900000 17.8953444 0.000000 18.5940444 0.000000 18.5944444 0.900000 18.5949444 0.900000 18.5953444 0.000000 19.2940444 0.000000 19.2944444 0.900000 19.2949444 0.900000 19.2953444 0.000000 19.9940444 0.000000 19.9944444 0.900000 19.9949444 0.900000 19.9953444 0.000000 20.6940444 0.000000 20.6944444 0.900000 20.6949444 0.900000 20.6953444 0.000000 21.3940444 0.000000 21.3944444 0.900000 21.3949444 0.900000 21.3953444 0.000000 22.0940444 0.000000 22.0944444 0.900000 22.0949444 0.900000 22.0953444 0.000000 22.7940444 0.000000 22.7944444 0.900000 22.7949444 0.900000 22.7953444 0.000000 23.4940444 0.000000 23.4944444 0.900000 23.4949444 0.900000 23.4953444 0.000000 24.1940444 0.000000 24.1944444 0.900000 24.1949444 0.900000 24.1953444 0.000000 24.8940444 0.000000 24.8944444 0.900000 24.8949444 0.900000 24.8953444 0.000000 25.5940444 0.000000 25.5944444 0.900000 25.5949444 0.900000 25.5953444 0.000000 26.2940444 0.000000 26.2944444 0.900000 26.2949444 0.900000 26.2953444 0.000000 26.9940444 0.000000 26.9944444 0.900000 26.9949444 0.900000 26.9953444 0.000000 27.6940444 0.000000 27.6944444 0.900000 27.6949444 0.900000 27.6953444 0.000000 28.3940444 0.000000 28.3944444 0.900000 28.3949444 0.900000 28.3953444 0.000000 29.0940444 0.000000 29.0944444 0.900000 29.0949444 0.900000 29.0953444 0.000000 29.7940444 0.000000 29.7944444 0.900000 29.7949444 0.900000 29.7953444 0.000000 30.5000000 0.000000)
Vpwp trig_pw_peak 0 PWL(0.0000000 0.000000 1.8690444 0.000000 1.8694444 0.900000 1.8699444 0.900000 1.8703444 0.000000 2.5690444 0.000000 2.5694444 0.900000 2.5699444 0.900000 2.5703444 0.000000 3.2690444 0.000000 3.2694444 0.900000 3.2699444 0.900000 3.2703444 0.000000 3.9690444 0.000000 3.9694444 0.900000 3.9699444 0.900000 3.9703444 0.000000 4.6690444 0.000000 4.6694444 0.900000 4.6699444 0.900000 4.6703444 0.000000 5.3690444 0.000000 5.3694444 0.900000 5.3699444 0.900000 5.3703444 0.000000 6.0690444 0.000000 6.0694444 0.900000 6.0699444 0.900000 6.0703444 0.000000 6.7690444 0.000000 6.7694444 0.900000 6.7699444 0.900000 6.7703444 0.000000 7.4690444 0.000000 7.4694444 0.900000 7.4699444 0.900000 7.4703444 0.000000 8.1690444 0.000000 8.1694444 0.900000 8.1699444 0.900000 8.1703444 0.000000 8.8690444 0.000000 8.8694444 0.900000 8.8699444 0.900000 8.8703444 0.000000 9.5690444 0.000000 9.5694444 0.900000 9.5699444 0.900000 9.5703444 0.000000 10.2690444 0.000000 10.2694444 0.900000 10.2699444 0.900000 10.2703444 0.000000 10.9690444 0.000000 10.9694444 0.900000 10.9699444 0.900000 10.9703444 0.000000 11.6690444 0.000000 11.6694444 0.900000 11.6699444 0.900000 11.6703444 0.000000 12.3690444 0.000000 12.3694444 0.900000 12.3699444 0.900000 12.3703444 0.000000 13.0690444 0.000000 13.0694444 0.900000 13.0699444 0.900000 13.0703444 0.000000 13.7690444 0.000000 13.7694444 0.900000 13.7699444 0.900000 13.7703444 0.000000 14.4690444 0.000000 14.4694444 0.900000 14.4699444 0.900000 14.4703444 0.000000 15.1690444 0.000000 15.1694444 0.900000 15.1699444 0.900000 15.1703444 0.000000 15.8690444 0.000000 15.8694444 0.900000 15.8699444 0.900000 15.8703444 0.000000 16.5690444 0.000000 16.5694444 0.900000 16.5699444 0.900000 16.5703444 0.000000 17.2690444 0.000000 17.2694444 0.900000 17.2699444 0.900000 17.2703444 0.000000 17.9690444 0.000000 17.9694444 0.900000 17.9699444 0.900000 17.9703444 0.000000 18.6690444 0.000000 18.6694444 0.900000 18.6699444 0.900000 18.6703444 0.000000 19.3690444 0.000000 19.3694444 0.900000 19.3699444 0.900000 19.3703444 0.000000 20.0690444 0.000000 20.0694444 0.900000 20.0699444 0.900000 20.0703444 0.000000 20.7690444 0.000000 20.7694444 0.900000 20.7699444 0.900000 20.7703444 0.000000 21.4690444 0.000000 21.4694444 0.900000 21.4699444 0.900000 21.4703444 0.000000 22.1690444 0.000000 22.1694444 0.900000 22.1699444 0.900000 22.1703444 0.000000 22.8690444 0.000000 22.8694444 0.900000 22.8699444 0.900000 22.8703444 0.000000 23.5690444 0.000000 23.5694444 0.900000 23.5699444 0.900000 23.5703444 0.000000 24.2690444 0.000000 24.2694444 0.900000 24.2699444 0.900000 24.2703444 0.000000 24.9690444 0.000000 24.9694444 0.900000 24.9699444 0.900000 24.9703444 0.000000 25.6690444 0.000000 25.6694444 0.900000 25.6699444 0.900000 25.6703444 0.000000 26.3690444 0.000000 26.3694444 0.900000 26.3699444 0.900000 26.3703444 0.000000 27.0690444 0.000000 27.0694444 0.900000 27.0699444 0.900000 27.0703444 0.000000 27.7690444 0.000000 27.7694444 0.900000 27.7699444 0.900000 27.7703444 0.000000 28.4690444 0.000000 28.4694444 0.900000 28.4699444 0.900000 28.4703444 0.000000 29.1690444 0.000000 29.1694444 0.900000 29.1699444 0.900000 29.1703444 0.000000 29.8690444 0.000000 29.8694444 0.900000 29.8699444 0.900000 29.8703444 0.000000 30.5000000 0.000000)
Vrsh trig_rpeak_sh 0 PWL(0.0000000 0.000000 1.9996000 0.000000 2.0000000 0.900000 2.0005000 0.900000 2.0009000 0.000000 2.6996000 0.000000 2.7000000 0.900000 2.7005000 0.900000 2.7009000 0.000000 3.3996000 0.000000 3.4000000 0.900000 3.4005000 0.900000 3.4009000 0.000000 4.0996000 0.000000 4.1000000 0.900000 4.1005000 0.900000 4.1009000 0.000000 4.7996000 0.000000 4.8000000 0.900000 4.8005000 0.900000 4.8009000 0.000000 5.4996000 0.000000 5.5000000 0.900000 5.5005000 0.900000 5.5009000 0.000000 6.1996000 0.000000 6.2000000 0.900000 6.2005000 0.900000 6.2009000 0.000000 6.8996000 0.000000 6.9000000 0.900000 6.9005000 0.900000 6.9009000 0.000000 7.5996000 0.000000 7.6000000 0.900000 7.6005000 0.900000 7.6009000 0.000000 8.2996000 0.000000 8.3000000 0.900000 8.3005000 0.900000 8.3009000 0.000000 8.9996000 0.000000 9.0000000 0.900000 9.0005000 0.900000 9.0009000 0.000000 9.6996000 0.000000 9.7000000 0.900000 9.7005000 0.900000 9.7009000 0.000000 10.3996000 0.000000 10.4000000 0.900000 10.4005000 0.900000 10.4009000 0.000000 11.0996000 0.000000 11.1000000 0.900000 11.1005000 0.900000 11.1009000 0.000000 11.7996000 0.000000 11.8000000 0.900000 11.8005000 0.900000 11.8009000 0.000000 12.4996000 0.000000 12.5000000 0.900000 12.5005000 0.900000 12.5009000 0.000000 13.1996000 0.000000 13.2000000 0.900000 13.2005000 0.900000 13.2009000 0.000000 13.8996000 0.000000 13.9000000 0.900000 13.9005000 0.900000 13.9009000 0.000000 14.5996000 0.000000 14.6000000 0.900000 14.6005000 0.900000 14.6009000 0.000000 15.2996000 0.000000 15.3000000 0.900000 15.3005000 0.900000 15.3009000 0.000000 15.9996000 0.000000 16.0000000 0.900000 16.0005000 0.900000 16.0009000 0.000000 16.6996000 0.000000 16.7000000 0.900000 16.7005000 0.900000 16.7009000 0.000000 17.3996000 0.000000 17.4000000 0.900000 17.4005000 0.900000 17.4009000 0.000000 18.0996000 0.000000 18.1000000 0.900000 18.1005000 0.900000 18.1009000 0.000000 18.7996000 0.000000 18.8000000 0.900000 18.8005000 0.900000 18.8009000 0.000000 19.4996000 0.000000 19.5000000 0.900000 19.5005000 0.900000 19.5009000 0.000000 20.1996000 0.000000 20.2000000 0.900000 20.2005000 0.900000 20.2009000 0.000000 20.8996000 0.000000 20.9000000 0.900000 20.9005000 0.900000 20.9009000 0.000000 21.5996000 0.000000 21.6000000 0.900000 21.6005000 0.900000 21.6009000 0.000000 22.2996000 0.000000 22.3000000 0.900000 22.3005000 0.900000 22.3009000 0.000000 22.9996000 0.000000 23.0000000 0.900000 23.0005000 0.900000 23.0009000 0.000000 23.6996000 0.000000 23.7000000 0.900000 23.7005000 0.900000 23.7009000 0.000000 24.3996000 0.000000 24.4000000 0.900000 24.4005000 0.900000 24.4009000 0.000000 25.0996000 0.000000 25.1000000 0.900000 25.1005000 0.900000 25.1009000 0.000000 25.7996000 0.000000 25.8000000 0.900000 25.8005000 0.900000 25.8009000 0.000000 26.4996000 0.000000 26.5000000 0.900000 26.5005000 0.900000 26.5009000 0.000000 27.1996000 0.000000 27.2000000 0.900000 27.2005000 0.900000 27.2009000 0.000000 27.8996000 0.000000 27.9000000 0.900000 27.9005000 0.900000 27.9009000 0.000000 28.5996000 0.000000 28.6000000 0.900000 28.6005000 0.900000 28.6009000 0.000000 29.2996000 0.000000 29.3000000 0.900000 29.3005000 0.900000 29.3009000 0.000000 29.9996000 0.000000 30.0000000 0.900000 30.0005000 0.900000 30.0009000 0.000000 30.5000000 0.000000)
Vs14 trig_s14 0 PWL(0.0000000 0.000000 2.0134889 0.000000 2.0138889 0.900000 2.0143889 0.900000 2.0147889 0.000000 2.7134889 0.000000 2.7138889 0.900000 2.7143889 0.900000 2.7147889 0.000000 3.4134889 0.000000 3.4138889 0.900000 3.4143889 0.900000 3.4147889 0.000000 4.1134889 0.000000 4.1138889 0.900000 4.1143889 0.900000 4.1147889 0.000000 4.8134889 0.000000 4.8138889 0.900000 4.8143889 0.900000 4.8147889 0.000000 5.5134889 0.000000 5.5138889 0.900000 5.5143889 0.900000 5.5147889 0.000000 6.2134889 0.000000 6.2138889 0.900000 6.2143889 0.900000 6.2147889 0.000000 6.9134889 0.000000 6.9138889 0.900000 6.9143889 0.900000 6.9147889 0.000000 7.6134889 0.000000 7.6138889 0.900000 7.6143889 0.900000 7.6147889 0.000000 8.3134889 0.000000 8.3138889 0.900000 8.3143889 0.900000 8.3147889 0.000000 9.0134889 0.000000 9.0138889 0.900000 9.0143889 0.900000 9.0147889 0.000000 9.7134889 0.000000 9.7138889 0.900000 9.7143889 0.900000 9.7147889 0.000000 10.4134889 0.000000 10.4138889 0.900000 10.4143889 0.900000 10.4147889 0.000000 11.1134889 0.000000 11.1138889 0.900000 11.1143889 0.900000 11.1147889 0.000000 11.8134889 0.000000 11.8138889 0.900000 11.8143889 0.900000 11.8147889 0.000000 12.5134889 0.000000 12.5138889 0.900000 12.5143889 0.900000 12.5147889 0.000000 13.2134889 0.000000 13.2138889 0.900000 13.2143889 0.900000 13.2147889 0.000000 13.9134889 0.000000 13.9138889 0.900000 13.9143889 0.900000 13.9147889 0.000000 14.6134889 0.000000 14.6138889 0.900000 14.6143889 0.900000 14.6147889 0.000000 15.3134889 0.000000 15.3138889 0.900000 15.3143889 0.900000 15.3147889 0.000000 16.0134889 0.000000 16.0138889 0.900000 16.0143889 0.900000 16.0147889 0.000000 16.7134889 0.000000 16.7138889 0.900000 16.7143889 0.900000 16.7147889 0.000000 17.4134889 0.000000 17.4138889 0.900000 17.4143889 0.900000 17.4147889 0.000000 18.1134889 0.000000 18.1138889 0.900000 18.1143889 0.900000 18.1147889 0.000000 18.8134889 0.000000 18.8138889 0.900000 18.8143889 0.900000 18.8147889 0.000000 19.5134889 0.000000 19.5138889 0.900000 19.5143889 0.900000 19.5147889 0.000000 20.2134889 0.000000 20.2138889 0.900000 20.2143889 0.900000 20.2147889 0.000000 20.9134889 0.000000 20.9138889 0.900000 20.9143889 0.900000 20.9147889 0.000000 21.6134889 0.000000 21.6138889 0.900000 21.6143889 0.900000 21.6147889 0.000000 22.3134889 0.000000 22.3138889 0.900000 22.3143889 0.900000 22.3147889 0.000000 23.0134889 0.000000 23.0138889 0.900000 23.0143889 0.900000 23.0147889 0.000000 23.7134889 0.000000 23.7138889 0.900000 23.7143889 0.900000 23.7147889 0.000000 24.4134889 0.000000 24.4138889 0.900000 24.4143889 0.900000 24.4147889 0.000000 25.1134889 0.000000 25.1138889 0.900000 25.1143889 0.900000 25.1147889 0.000000 25.8134889 0.000000 25.8138889 0.900000 25.8143889 0.900000 25.8147889 0.000000 26.5134889 0.000000 26.5138889 0.900000 26.5143889 0.900000 26.5147889 0.000000 27.2134889 0.000000 27.2138889 0.900000 27.2143889 0.900000 27.2147889 0.000000 27.9134889 0.000000 27.9138889 0.900000 27.9143889 0.900000 27.9147889 0.000000 28.6134889 0.000000 28.6138889 0.900000 28.6143889 0.900000 28.6147889 0.000000 29.3134889 0.000000 29.3138889 0.900000 29.3143889 0.900000 29.3147889 0.000000 30.0134889 0.000000 30.0138889 0.900000 30.0143889 0.900000 30.0147889 0.000000 30.5000000 0.000000)
Vs69 trig_s69 0 PWL(0.0000000 0.000000 2.0690444 0.000000 2.0694444 0.900000 2.0699444 0.900000 2.0703444 0.000000 2.7690444 0.000000 2.7694444 0.900000 2.7699444 0.900000 2.7703444 0.000000 3.4690444 0.000000 3.4694444 0.900000 3.4699444 0.900000 3.4703444 0.000000 4.1690444 0.000000 4.1694444 0.900000 4.1699444 0.900000 4.1703444 0.000000 4.8690444 0.000000 4.8694444 0.900000 4.8699444 0.900000 4.8703444 0.000000 5.5690444 0.000000 5.5694444 0.900000 5.5699444 0.900000 5.5703444 0.000000 6.2690444 0.000000 6.2694444 0.900000 6.2699444 0.900000 6.2703444 0.000000 6.9690444 0.000000 6.9694444 0.900000 6.9699444 0.900000 6.9703444 0.000000 7.6690444 0.000000 7.6694444 0.900000 7.6699444 0.900000 7.6703444 0.000000 8.3690444 0.000000 8.3694444 0.900000 8.3699444 0.900000 8.3703444 0.000000 9.0690444 0.000000 9.0694444 0.900000 9.0699444 0.900000 9.0703444 0.000000 9.7690444 0.000000 9.7694444 0.900000 9.7699444 0.900000 9.7703444 0.000000 10.4690444 0.000000 10.4694444 0.900000 10.4699444 0.900000 10.4703444 0.000000 11.1690444 0.000000 11.1694444 0.900000 11.1699444 0.900000 11.1703444 0.000000 11.8690444 0.000000 11.8694444 0.900000 11.8699444 0.900000 11.8703444 0.000000 12.5690444 0.000000 12.5694444 0.900000 12.5699444 0.900000 12.5703444 0.000000 13.2690444 0.000000 13.2694444 0.900000 13.2699444 0.900000 13.2703444 0.000000 13.9690444 0.000000 13.9694444 0.900000 13.9699444 0.900000 13.9703444 0.000000 14.6690444 0.000000 14.6694444 0.900000 14.6699444 0.900000 14.6703444 0.000000 15.3690444 0.000000 15.3694444 0.900000 15.3699444 0.900000 15.3703444 0.000000 16.0690444 0.000000 16.0694444 0.900000 16.0699444 0.900000 16.0703444 0.000000 16.7690444 0.000000 16.7694444 0.900000 16.7699444 0.900000 16.7703444 0.000000 17.4690444 0.000000 17.4694444 0.900000 17.4699444 0.900000 17.4703444 0.000000 18.1690444 0.000000 18.1694444 0.900000 18.1699444 0.900000 18.1703444 0.000000 18.8690444 0.000000 18.8694444 0.900000 18.8699444 0.900000 18.8703444 0.000000 19.5690444 0.000000 19.5694444 0.900000 19.5699444 0.900000 19.5703444 0.000000 20.2690444 0.000000 20.2694444 0.900000 20.2699444 0.900000 20.2703444 0.000000 20.9690444 0.000000 20.9694444 0.900000 20.9699444 0.900000 20.9703444 0.000000 21.6690444 0.000000 21.6694444 0.900000 21.6699444 0.900000 21.6703444 0.000000 22.3690444 0.000000 22.3694444 0.900000 22.3699444 0.900000 22.3703444 0.000000 23.0690444 0.000000 23.0694444 0.900000 23.0699444 0.900000 23.0703444 0.000000 23.7690444 0.000000 23.7694444 0.900000 23.7699444 0.900000 23.7703444 0.000000 24.4690444 0.000000 24.4694444 0.900000 24.4699444 0.900000 24.4703444 0.000000 25.1690444 0.000000 25.1694444 0.900000 25.1699444 0.900000 25.1703444 0.000000 25.8690444 0.000000 25.8694444 0.900000 25.8699444 0.900000 25.8703444 0.000000 26.5690444 0.000000 26.5694444 0.900000 26.5699444 0.900000 26.5703444 0.000000 27.2690444 0.000000 27.2694444 0.900000 27.2699444 0.900000 27.2703444 0.000000 27.9690444 0.000000 27.9694444 0.900000 27.9699444 0.900000 27.9703444 0.000000 28.6690444 0.000000 28.6694444 0.900000 28.6699444 0.900000 28.6703444 0.000000 29.3690444 0.000000 29.3694444 0.900000 29.3699444 0.900000 29.3703444 0.000000 30.0690444 0.000000 30.0694444 0.900000 30.0699444 0.900000 30.0703444 0.000000 30.5000000 0.000000)
Vwid trig_wid 0 PWL(0.0000000 0.000000 2.0829333 0.000000 2.0833333 0.900000 2.0838333 0.900000 2.0842333 0.000000 2.7829333 0.000000 2.7833333 0.900000 2.7838333 0.900000 2.7842333 0.000000 3.4829333 0.000000 3.4833333 0.900000 3.4838333 0.900000 3.4842333 0.000000 4.1829333 0.000000 4.1833333 0.900000 4.1838333 0.900000 4.1842333 0.000000 4.8829333 0.000000 4.8833333 0.900000 4.8838333 0.900000 4.8842333 0.000000 5.5829333 0.000000 5.5833333 0.900000 5.5838333 0.900000 5.5842333 0.000000 6.2829333 0.000000 6.2833333 0.900000 6.2838333 0.900000 6.2842333 0.000000 6.9829333 0.000000 6.9833333 0.900000 6.9838333 0.900000 6.9842333 0.000000 7.6829333 0.000000 7.6833333 0.900000 7.6838333 0.900000 7.6842333 0.000000 8.3829333 0.000000 8.3833333 0.900000 8.3838333 0.900000 8.3842333 0.000000 9.0829333 0.000000 9.0833333 0.900000 9.0838333 0.900000 9.0842333 0.000000 9.7829333 0.000000 9.7833333 0.900000 9.7838333 0.900000 9.7842333 0.000000 10.4829333 0.000000 10.4833333 0.900000 10.4838333 0.900000 10.4842333 0.000000 11.1829333 0.000000 11.1833333 0.900000 11.1838333 0.900000 11.1842333 0.000000 11.8829333 0.000000 11.8833333 0.900000 11.8838333 0.900000 11.8842333 0.000000 12.5829333 0.000000 12.5833333 0.900000 12.5838333 0.900000 12.5842333 0.000000 13.2829333 0.000000 13.2833333 0.900000 13.2838333 0.900000 13.2842333 0.000000 13.9829333 0.000000 13.9833333 0.900000 13.9838333 0.900000 13.9842333 0.000000 14.6829333 0.000000 14.6833333 0.900000 14.6838333 0.900000 14.6842333 0.000000 15.3829333 0.000000 15.3833333 0.900000 15.3838333 0.900000 15.3842333 0.000000 16.0829333 0.000000 16.0833333 0.900000 16.0838333 0.900000 16.0842333 0.000000 16.7829333 0.000000 16.7833333 0.900000 16.7838333 0.900000 16.7842333 0.000000 17.4829333 0.000000 17.4833333 0.900000 17.4838333 0.900000 17.4842333 0.000000 18.1829333 0.000000 18.1833333 0.900000 18.1838333 0.900000 18.1842333 0.000000 18.8829333 0.000000 18.8833333 0.900000 18.8838333 0.900000 18.8842333 0.000000 19.5829333 0.000000 19.5833333 0.900000 19.5838333 0.900000 19.5842333 0.000000 20.2829333 0.000000 20.2833333 0.900000 20.2838333 0.900000 20.2842333 0.000000 20.9829333 0.000000 20.9833333 0.900000 20.9838333 0.900000 20.9842333 0.000000 21.6829333 0.000000 21.6833333 0.900000 21.6838333 0.900000 21.6842333 0.000000 22.3829333 0.000000 22.3833333 0.900000 22.3838333 0.900000 22.3842333 0.000000 23.0829333 0.000000 23.0833333 0.900000 23.0838333 0.900000 23.0842333 0.000000 23.7829333 0.000000 23.7833333 0.900000 23.7838333 0.900000 23.7842333 0.000000 24.4829333 0.000000 24.4833333 0.900000 24.4838333 0.900000 24.4842333 0.000000 25.1829333 0.000000 25.1833333 0.900000 25.1838333 0.900000 25.1842333 0.000000 25.8829333 0.000000 25.8833333 0.900000 25.8838333 0.900000 25.8842333 0.000000 26.5829333 0.000000 26.5833333 0.900000 26.5838333 0.900000 26.5842333 0.000000 27.2829333 0.000000 27.2833333 0.900000 27.2838333 0.900000 27.2842333 0.000000 27.9829333 0.000000 27.9833333 0.900000 27.9838333 0.900000 27.9842333 0.000000 28.6829333 0.000000 28.6833333 0.900000 28.6838333 0.900000 28.6842333 0.000000 29.3829333 0.000000 29.3833333 0.900000 29.3838333 0.900000 29.3842333 0.000000 30.0829333 0.000000 30.0833333 0.900000 30.0838333 0.900000 30.0842333 0.000000 30.5000000 0.000000)
Vbco trig_bi_copy 0 PWL(0.0000000 0.000000 2.2996000 0.000000 2.3000000 0.900000 2.3020000 0.900000 2.3024000 0.000000 2.9996000 0.000000 3.0000000 0.900000 3.0020000 0.900000 3.0024000 0.000000 3.6996000 0.000000 3.7000000 0.900000 3.7020000 0.900000 3.7024000 0.000000 4.3996000 0.000000 4.4000000 0.900000 4.4020000 0.900000 4.4024000 0.000000 5.0996000 0.000000 5.1000000 0.900000 5.1020000 0.900000 5.1024000 0.000000 5.7996000 0.000000 5.8000000 0.900000 5.8020000 0.900000 5.8024000 0.000000 6.4996000 0.000000 6.5000000 0.900000 6.5020000 0.900000 6.5024000 0.000000 7.1996000 0.000000 7.2000000 0.900000 7.2020000 0.900000 7.2024000 0.000000 7.8996000 0.000000 7.9000000 0.900000 7.9020000 0.900000 7.9024000 0.000000 8.5996000 0.000000 8.6000000 0.900000 8.6020000 0.900000 8.6024000 0.000000 9.2996000 0.000000 9.3000000 0.900000 9.3020000 0.900000 9.3024000 0.000000 9.9996000 0.000000 10.0000000 0.900000 10.0020000 0.900000 10.0024000 0.000000 10.6996000 0.000000 10.7000000 0.900000 10.7020000 0.900000 10.7024000 0.000000 11.3996000 0.000000 11.4000000 0.900000 11.4020000 0.900000 11.4024000 0.000000 12.0996000 0.000000 12.1000000 0.900000 12.1020000 0.900000 12.1024000 0.000000 12.7996000 0.000000 12.8000000 0.900000 12.8020000 0.900000 12.8024000 0.000000 13.4996000 0.000000 13.5000000 0.900000 13.5020000 0.900000 13.5024000 0.000000 14.1996000 0.000000 14.2000000 0.900000 14.2020000 0.900000 14.2024000 0.000000 14.8996000 0.000000 14.9000000 0.900000 14.9020000 0.900000 14.9024000 0.000000 15.5996000 0.000000 15.6000000 0.900000 15.6020000 0.900000 15.6024000 0.000000 16.2996000 0.000000 16.3000000 0.900000 16.3020000 0.900000 16.3024000 0.000000 16.9996000 0.000000 17.0000000 0.900000 17.0020000 0.900000 17.0024000 0.000000 17.6996000 0.000000 17.7000000 0.900000 17.7020000 0.900000 17.7024000 0.000000 18.3996000 0.000000 18.4000000 0.900000 18.4020000 0.900000 18.4024000 0.000000 19.0996000 0.000000 19.1000000 0.900000 19.1020000 0.900000 19.1024000 0.000000 19.7996000 0.000000 19.8000000 0.900000 19.8020000 0.900000 19.8024000 0.000000 20.4996000 0.000000 20.5000000 0.900000 20.5020000 0.900000 20.5024000 0.000000 21.1996000 0.000000 21.2000000 0.900000 21.2020000 0.900000 21.2024000 0.000000 21.8996000 0.000000 21.9000000 0.900000 21.9020000 0.900000 21.9024000 0.000000 22.5996000 0.000000 22.6000000 0.900000 22.6020000 0.900000 22.6024000 0.000000 23.2996000 0.000000 23.3000000 0.900000 23.3020000 0.900000 23.3024000 0.000000 23.9996000 0.000000 24.0000000 0.900000 24.0020000 0.900000 24.0024000 0.000000 24.6996000 0.000000 24.7000000 0.900000 24.7020000 0.900000 24.7024000 0.000000 25.3996000 0.000000 25.4000000 0.900000 25.4020000 0.900000 25.4024000 0.000000 26.0996000 0.000000 26.1000000 0.900000 26.1020000 0.900000 26.1024000 0.000000 26.7996000 0.000000 26.8000000 0.900000 26.8020000 0.900000 26.8024000 0.000000 27.4996000 0.000000 27.5000000 0.900000 27.5020000 0.900000 27.5024000 0.000000 28.1996000 0.000000 28.2000000 0.900000 28.2020000 0.900000 28.2024000 0.000000 28.8996000 0.000000 28.9000000 0.900000 28.9020000 0.900000 28.9024000 0.000000 29.5996000 0.000000 29.6000000 0.900000 29.6020000 0.900000 29.6024000 0.000000 30.2996000 0.000000 30.3000000 0.900000 30.3020000 0.900000 30.3024000 0.000000 30.5000000 0.000000)

.include "C:/Users/kadhi/OneDrive/Desktop/amux/verilogLearning/Leaky-Integrate-Fire---SNN-model-on-FPGA/experiments/frontend_optimization/complete_frontend/beat_instability.spice"
.include "C:/Users/kadhi/OneDrive/Desktop/amux/verilogLearning/Leaky-Integrate-Fire---SNN-model-on-FPGA/experiments/frontend_optimization/complete_frontend/pwave_diff.spice"
.include "C:/Users/kadhi/OneDrive/Desktop/amux/verilogLearning/Leaky-Integrate-Fire---SNN-model-on-FPGA/experiments/frontend_optimization/complete_frontend/qrs_width.spice"
.include "C:/Users/kadhi/OneDrive/Desktop/amux/verilogLearning/Leaky-Integrate-Fire---SNN-model-on-FPGA/experiments/frontend_optimization/complete_frontend/qrs_slope.spice"
.include "C:/Users/kadhi/OneDrive/Desktop/amux/verilogLearning/Leaky-Integrate-Fire---SNN-model-on-FPGA/experiments/frontend_optimization/complete_frontend/qrs_symmetry.spice"

Xbi0 ecg_l0 trig_rpeak_sh trig_bi_copy f3_bi_l0 vdd vss vbias beat_instability
Xbi1 ecg_l1 trig_rpeak_sh trig_bi_copy f4_bi_l1 vdd vss vbias beat_instability
Xpw ecg_l0 trig_pw_base trig_pw_peak f5_pwave vdd vss vbias pwave_diff
Xwid ecg_l0 trig_wid f6_width vdd vss qrs_width
Xslp ecg_l0 trig_s14 trig_s69 f7_slope vdd vss vbias qrs_slope
Xsym ecg_l0 trig_rpeak_sh f8_symmetry vdd vss qrs_symmetry

.tran 0.5m 30.5000

.meas tran bi0_b1 FIND V(f3_bi_l0) AT=2.8038333
.meas tran bi1_b1 FIND V(f4_bi_l1) AT=2.8038333
.meas tran pw_b1 FIND V(f5_pwave) AT=2.8038333
.meas tran wid_b1 FIND V(f6_width) AT=2.8038333
.meas tran slp_b1 FIND V(f7_slope) AT=2.8038333
.meas tran sym_b1 FIND V(f8_symmetry) AT=2.8038333
.meas tran bi0_b2 FIND V(f3_bi_l0) AT=3.5038333
.meas tran bi1_b2 FIND V(f4_bi_l1) AT=3.5038333
.meas tran pw_b2 FIND V(f5_pwave) AT=3.5038333
.meas tran wid_b2 FIND V(f6_width) AT=3.5038333
.meas tran slp_b2 FIND V(f7_slope) AT=3.5038333
.meas tran sym_b2 FIND V(f8_symmetry) AT=3.5038333
.meas tran bi0_b3 FIND V(f3_bi_l0) AT=4.2038333
.meas tran bi1_b3 FIND V(f4_bi_l1) AT=4.2038333
.meas tran pw_b3 FIND V(f5_pwave) AT=4.2038333
.meas tran wid_b3 FIND V(f6_width) AT=4.2038333
.meas tran slp_b3 FIND V(f7_slope) AT=4.2038333
.meas tran sym_b3 FIND V(f8_symmetry) AT=4.2038333
.meas tran bi0_b4 FIND V(f3_bi_l0) AT=4.9038333
.meas tran bi1_b4 FIND V(f4_bi_l1) AT=4.9038333
.meas tran pw_b4 FIND V(f5_pwave) AT=4.9038333
.meas tran wid_b4 FIND V(f6_width) AT=4.9038333
.meas tran slp_b4 FIND V(f7_slope) AT=4.9038333
.meas tran sym_b4 FIND V(f8_symmetry) AT=4.9038333
.meas tran bi0_b5 FIND V(f3_bi_l0) AT=5.6038333
.meas tran bi1_b5 FIND V(f4_bi_l1) AT=5.6038333
.meas tran pw_b5 FIND V(f5_pwave) AT=5.6038333
.meas tran wid_b5 FIND V(f6_width) AT=5.6038333
.meas tran slp_b5 FIND V(f7_slope) AT=5.6038333
.meas tran sym_b5 FIND V(f8_symmetry) AT=5.6038333
.meas tran bi0_b6 FIND V(f3_bi_l0) AT=6.3038333
.meas tran bi1_b6 FIND V(f4_bi_l1) AT=6.3038333
.meas tran pw_b6 FIND V(f5_pwave) AT=6.3038333
.meas tran wid_b6 FIND V(f6_width) AT=6.3038333
.meas tran slp_b6 FIND V(f7_slope) AT=6.3038333
.meas tran sym_b6 FIND V(f8_symmetry) AT=6.3038333
.meas tran bi0_b7 FIND V(f3_bi_l0) AT=7.0038333
.meas tran bi1_b7 FIND V(f4_bi_l1) AT=7.0038333
.meas tran pw_b7 FIND V(f5_pwave) AT=7.0038333
.meas tran wid_b7 FIND V(f6_width) AT=7.0038333
.meas tran slp_b7 FIND V(f7_slope) AT=7.0038333
.meas tran sym_b7 FIND V(f8_symmetry) AT=7.0038333
.meas tran bi0_b8 FIND V(f3_bi_l0) AT=7.7038333
.meas tran bi1_b8 FIND V(f4_bi_l1) AT=7.7038333
.meas tran pw_b8 FIND V(f5_pwave) AT=7.7038333
.meas tran wid_b8 FIND V(f6_width) AT=7.7038333
.meas tran slp_b8 FIND V(f7_slope) AT=7.7038333
.meas tran sym_b8 FIND V(f8_symmetry) AT=7.7038333
.meas tran bi0_b9 FIND V(f3_bi_l0) AT=8.4038333
.meas tran bi1_b9 FIND V(f4_bi_l1) AT=8.4038333
.meas tran pw_b9 FIND V(f5_pwave) AT=8.4038333
.meas tran wid_b9 FIND V(f6_width) AT=8.4038333
.meas tran slp_b9 FIND V(f7_slope) AT=8.4038333
.meas tran sym_b9 FIND V(f8_symmetry) AT=8.4038333
.meas tran bi0_b10 FIND V(f3_bi_l0) AT=9.1038333
.meas tran bi1_b10 FIND V(f4_bi_l1) AT=9.1038333
.meas tran pw_b10 FIND V(f5_pwave) AT=9.1038333
.meas tran wid_b10 FIND V(f6_width) AT=9.1038333
.meas tran slp_b10 FIND V(f7_slope) AT=9.1038333
.meas tran sym_b10 FIND V(f8_symmetry) AT=9.1038333
.meas tran bi0_b11 FIND V(f3_bi_l0) AT=9.8038333
.meas tran bi1_b11 FIND V(f4_bi_l1) AT=9.8038333
.meas tran pw_b11 FIND V(f5_pwave) AT=9.8038333
.meas tran wid_b11 FIND V(f6_width) AT=9.8038333
.meas tran slp_b11 FIND V(f7_slope) AT=9.8038333
.meas tran sym_b11 FIND V(f8_symmetry) AT=9.8038333
.meas tran bi0_b12 FIND V(f3_bi_l0) AT=10.5038333
.meas tran bi1_b12 FIND V(f4_bi_l1) AT=10.5038333
.meas tran pw_b12 FIND V(f5_pwave) AT=10.5038333
.meas tran wid_b12 FIND V(f6_width) AT=10.5038333
.meas tran slp_b12 FIND V(f7_slope) AT=10.5038333
.meas tran sym_b12 FIND V(f8_symmetry) AT=10.5038333
.meas tran bi0_b13 FIND V(f3_bi_l0) AT=11.2038333
.meas tran bi1_b13 FIND V(f4_bi_l1) AT=11.2038333
.meas tran pw_b13 FIND V(f5_pwave) AT=11.2038333
.meas tran wid_b13 FIND V(f6_width) AT=11.2038333
.meas tran slp_b13 FIND V(f7_slope) AT=11.2038333
.meas tran sym_b13 FIND V(f8_symmetry) AT=11.2038333
.meas tran bi0_b14 FIND V(f3_bi_l0) AT=11.9038333
.meas tran bi1_b14 FIND V(f4_bi_l1) AT=11.9038333
.meas tran pw_b14 FIND V(f5_pwave) AT=11.9038333
.meas tran wid_b14 FIND V(f6_width) AT=11.9038333
.meas tran slp_b14 FIND V(f7_slope) AT=11.9038333
.meas tran sym_b14 FIND V(f8_symmetry) AT=11.9038333
.meas tran bi0_b15 FIND V(f3_bi_l0) AT=12.6038333
.meas tran bi1_b15 FIND V(f4_bi_l1) AT=12.6038333
.meas tran pw_b15 FIND V(f5_pwave) AT=12.6038333
.meas tran wid_b15 FIND V(f6_width) AT=12.6038333
.meas tran slp_b15 FIND V(f7_slope) AT=12.6038333
.meas tran sym_b15 FIND V(f8_symmetry) AT=12.6038333
.meas tran bi0_b16 FIND V(f3_bi_l0) AT=13.3038333
.meas tran bi1_b16 FIND V(f4_bi_l1) AT=13.3038333
.meas tran pw_b16 FIND V(f5_pwave) AT=13.3038333
.meas tran wid_b16 FIND V(f6_width) AT=13.3038333
.meas tran slp_b16 FIND V(f7_slope) AT=13.3038333
.meas tran sym_b16 FIND V(f8_symmetry) AT=13.3038333
.meas tran bi0_b17 FIND V(f3_bi_l0) AT=14.0038333
.meas tran bi1_b17 FIND V(f4_bi_l1) AT=14.0038333
.meas tran pw_b17 FIND V(f5_pwave) AT=14.0038333
.meas tran wid_b17 FIND V(f6_width) AT=14.0038333
.meas tran slp_b17 FIND V(f7_slope) AT=14.0038333
.meas tran sym_b17 FIND V(f8_symmetry) AT=14.0038333
.meas tran bi0_b18 FIND V(f3_bi_l0) AT=14.7038333
.meas tran bi1_b18 FIND V(f4_bi_l1) AT=14.7038333
.meas tran pw_b18 FIND V(f5_pwave) AT=14.7038333
.meas tran wid_b18 FIND V(f6_width) AT=14.7038333
.meas tran slp_b18 FIND V(f7_slope) AT=14.7038333
.meas tran sym_b18 FIND V(f8_symmetry) AT=14.7038333
.meas tran bi0_b19 FIND V(f3_bi_l0) AT=15.4038333
.meas tran bi1_b19 FIND V(f4_bi_l1) AT=15.4038333
.meas tran pw_b19 FIND V(f5_pwave) AT=15.4038333
.meas tran wid_b19 FIND V(f6_width) AT=15.4038333
.meas tran slp_b19 FIND V(f7_slope) AT=15.4038333
.meas tran sym_b19 FIND V(f8_symmetry) AT=15.4038333
.meas tran bi0_b20 FIND V(f3_bi_l0) AT=16.1038333
.meas tran bi1_b20 FIND V(f4_bi_l1) AT=16.1038333
.meas tran pw_b20 FIND V(f5_pwave) AT=16.1038333
.meas tran wid_b20 FIND V(f6_width) AT=16.1038333
.meas tran slp_b20 FIND V(f7_slope) AT=16.1038333
.meas tran sym_b20 FIND V(f8_symmetry) AT=16.1038333
.meas tran bi0_b21 FIND V(f3_bi_l0) AT=16.8038333
.meas tran bi1_b21 FIND V(f4_bi_l1) AT=16.8038333
.meas tran pw_b21 FIND V(f5_pwave) AT=16.8038333
.meas tran wid_b21 FIND V(f6_width) AT=16.8038333
.meas tran slp_b21 FIND V(f7_slope) AT=16.8038333
.meas tran sym_b21 FIND V(f8_symmetry) AT=16.8038333
.meas tran bi0_b22 FIND V(f3_bi_l0) AT=17.5038333
.meas tran bi1_b22 FIND V(f4_bi_l1) AT=17.5038333
.meas tran pw_b22 FIND V(f5_pwave) AT=17.5038333
.meas tran wid_b22 FIND V(f6_width) AT=17.5038333
.meas tran slp_b22 FIND V(f7_slope) AT=17.5038333
.meas tran sym_b22 FIND V(f8_symmetry) AT=17.5038333
.meas tran bi0_b23 FIND V(f3_bi_l0) AT=18.2038333
.meas tran bi1_b23 FIND V(f4_bi_l1) AT=18.2038333
.meas tran pw_b23 FIND V(f5_pwave) AT=18.2038333
.meas tran wid_b23 FIND V(f6_width) AT=18.2038333
.meas tran slp_b23 FIND V(f7_slope) AT=18.2038333
.meas tran sym_b23 FIND V(f8_symmetry) AT=18.2038333
.meas tran bi0_b24 FIND V(f3_bi_l0) AT=18.9038333
.meas tran bi1_b24 FIND V(f4_bi_l1) AT=18.9038333
.meas tran pw_b24 FIND V(f5_pwave) AT=18.9038333
.meas tran wid_b24 FIND V(f6_width) AT=18.9038333
.meas tran slp_b24 FIND V(f7_slope) AT=18.9038333
.meas tran sym_b24 FIND V(f8_symmetry) AT=18.9038333
.meas tran bi0_b25 FIND V(f3_bi_l0) AT=19.6038333
.meas tran bi1_b25 FIND V(f4_bi_l1) AT=19.6038333
.meas tran pw_b25 FIND V(f5_pwave) AT=19.6038333
.meas tran wid_b25 FIND V(f6_width) AT=19.6038333
.meas tran slp_b25 FIND V(f7_slope) AT=19.6038333
.meas tran sym_b25 FIND V(f8_symmetry) AT=19.6038333
.meas tran bi0_b26 FIND V(f3_bi_l0) AT=20.3038333
.meas tran bi1_b26 FIND V(f4_bi_l1) AT=20.3038333
.meas tran pw_b26 FIND V(f5_pwave) AT=20.3038333
.meas tran wid_b26 FIND V(f6_width) AT=20.3038333
.meas tran slp_b26 FIND V(f7_slope) AT=20.3038333
.meas tran sym_b26 FIND V(f8_symmetry) AT=20.3038333
.meas tran bi0_b27 FIND V(f3_bi_l0) AT=21.0038333
.meas tran bi1_b27 FIND V(f4_bi_l1) AT=21.0038333
.meas tran pw_b27 FIND V(f5_pwave) AT=21.0038333
.meas tran wid_b27 FIND V(f6_width) AT=21.0038333
.meas tran slp_b27 FIND V(f7_slope) AT=21.0038333
.meas tran sym_b27 FIND V(f8_symmetry) AT=21.0038333
.meas tran bi0_b28 FIND V(f3_bi_l0) AT=21.7038333
.meas tran bi1_b28 FIND V(f4_bi_l1) AT=21.7038333
.meas tran pw_b28 FIND V(f5_pwave) AT=21.7038333
.meas tran wid_b28 FIND V(f6_width) AT=21.7038333
.meas tran slp_b28 FIND V(f7_slope) AT=21.7038333
.meas tran sym_b28 FIND V(f8_symmetry) AT=21.7038333
.meas tran bi0_b29 FIND V(f3_bi_l0) AT=22.4038333
.meas tran bi1_b29 FIND V(f4_bi_l1) AT=22.4038333
.meas tran pw_b29 FIND V(f5_pwave) AT=22.4038333
.meas tran wid_b29 FIND V(f6_width) AT=22.4038333
.meas tran slp_b29 FIND V(f7_slope) AT=22.4038333
.meas tran sym_b29 FIND V(f8_symmetry) AT=22.4038333
.meas tran bi0_b30 FIND V(f3_bi_l0) AT=23.1038333
.meas tran bi1_b30 FIND V(f4_bi_l1) AT=23.1038333
.meas tran pw_b30 FIND V(f5_pwave) AT=23.1038333
.meas tran wid_b30 FIND V(f6_width) AT=23.1038333
.meas tran slp_b30 FIND V(f7_slope) AT=23.1038333
.meas tran sym_b30 FIND V(f8_symmetry) AT=23.1038333
.meas tran bi0_b31 FIND V(f3_bi_l0) AT=23.8038333
.meas tran bi1_b31 FIND V(f4_bi_l1) AT=23.8038333
.meas tran pw_b31 FIND V(f5_pwave) AT=23.8038333
.meas tran wid_b31 FIND V(f6_width) AT=23.8038333
.meas tran slp_b31 FIND V(f7_slope) AT=23.8038333
.meas tran sym_b31 FIND V(f8_symmetry) AT=23.8038333
.meas tran bi0_b32 FIND V(f3_bi_l0) AT=24.5038333
.meas tran bi1_b32 FIND V(f4_bi_l1) AT=24.5038333
.meas tran pw_b32 FIND V(f5_pwave) AT=24.5038333
.meas tran wid_b32 FIND V(f6_width) AT=24.5038333
.meas tran slp_b32 FIND V(f7_slope) AT=24.5038333
.meas tran sym_b32 FIND V(f8_symmetry) AT=24.5038333
.meas tran bi0_b33 FIND V(f3_bi_l0) AT=25.2038333
.meas tran bi1_b33 FIND V(f4_bi_l1) AT=25.2038333
.meas tran pw_b33 FIND V(f5_pwave) AT=25.2038333
.meas tran wid_b33 FIND V(f6_width) AT=25.2038333
.meas tran slp_b33 FIND V(f7_slope) AT=25.2038333
.meas tran sym_b33 FIND V(f8_symmetry) AT=25.2038333
.meas tran bi0_b34 FIND V(f3_bi_l0) AT=25.9038333
.meas tran bi1_b34 FIND V(f4_bi_l1) AT=25.9038333
.meas tran pw_b34 FIND V(f5_pwave) AT=25.9038333
.meas tran wid_b34 FIND V(f6_width) AT=25.9038333
.meas tran slp_b34 FIND V(f7_slope) AT=25.9038333
.meas tran sym_b34 FIND V(f8_symmetry) AT=25.9038333
.meas tran bi0_b35 FIND V(f3_bi_l0) AT=26.6038333
.meas tran bi1_b35 FIND V(f4_bi_l1) AT=26.6038333
.meas tran pw_b35 FIND V(f5_pwave) AT=26.6038333
.meas tran wid_b35 FIND V(f6_width) AT=26.6038333
.meas tran slp_b35 FIND V(f7_slope) AT=26.6038333
.meas tran sym_b35 FIND V(f8_symmetry) AT=26.6038333
.meas tran bi0_b36 FIND V(f3_bi_l0) AT=27.3038333
.meas tran bi1_b36 FIND V(f4_bi_l1) AT=27.3038333
.meas tran pw_b36 FIND V(f5_pwave) AT=27.3038333
.meas tran wid_b36 FIND V(f6_width) AT=27.3038333
.meas tran slp_b36 FIND V(f7_slope) AT=27.3038333
.meas tran sym_b36 FIND V(f8_symmetry) AT=27.3038333
.meas tran bi0_b37 FIND V(f3_bi_l0) AT=28.0038333
.meas tran bi1_b37 FIND V(f4_bi_l1) AT=28.0038333
.meas tran pw_b37 FIND V(f5_pwave) AT=28.0038333
.meas tran wid_b37 FIND V(f6_width) AT=28.0038333
.meas tran slp_b37 FIND V(f7_slope) AT=28.0038333
.meas tran sym_b37 FIND V(f8_symmetry) AT=28.0038333
.meas tran bi0_b38 FIND V(f3_bi_l0) AT=28.7038333
.meas tran bi1_b38 FIND V(f4_bi_l1) AT=28.7038333
.meas tran pw_b38 FIND V(f5_pwave) AT=28.7038333
.meas tran wid_b38 FIND V(f6_width) AT=28.7038333
.meas tran slp_b38 FIND V(f7_slope) AT=28.7038333
.meas tran sym_b38 FIND V(f8_symmetry) AT=28.7038333
.meas tran bi0_b39 FIND V(f3_bi_l0) AT=29.4038333
.meas tran bi1_b39 FIND V(f4_bi_l1) AT=29.4038333
.meas tran pw_b39 FIND V(f5_pwave) AT=29.4038333
.meas tran wid_b39 FIND V(f6_width) AT=29.4038333
.meas tran slp_b39 FIND V(f7_slope) AT=29.4038333
.meas tran sym_b39 FIND V(f8_symmetry) AT=29.4038333
.meas tran bi0_b40 FIND V(f3_bi_l0) AT=30.1038333
.meas tran bi1_b40 FIND V(f4_bi_l1) AT=30.1038333
.meas tran pw_b40 FIND V(f5_pwave) AT=30.1038333
.meas tran wid_b40 FIND V(f6_width) AT=30.1038333
.meas tran slp_b40 FIND V(f7_slope) AT=30.1038333
.meas tran sym_b40 FIND V(f8_symmetry) AT=30.1038333

.end
