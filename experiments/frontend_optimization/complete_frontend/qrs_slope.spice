* FEATURE 7: QRS Slope — Post-R Descent Difference
*
* Proxy: ECG@R+14ms - ECG@R+69ms (signed). Captures post-R slope asymmetry.
* Two S&H + diode-loaded diff pair.
*
* Triggers: sample14_trig (R+14ms), sample69_trig (R+69ms)

.subckt qrs_slope ecg_in sample14_trig sample69_trig slope_out vdd vss vbias

XMs14 ecg_in sample14_trig sh14 vss sky130_fd_pr__nfet_01v8 L=0.5 W=2 nf=1
XCs14 sh14 vss sky130_fd_pr__cap_mim_m3_1 W=32 L=32

XMs69 ecg_in sample69_trig sh69 vss sky130_fd_pr__nfet_01v8 L=0.5 W=2 nf=1
XCs69 sh69 vss sky130_fd_pr__cap_mim_m3_1 W=32 L=32

XMd_tail dtail vbias vss vss sky130_fd_pr__nfet_01v8 L=8 W=0.42 nf=1
XMd1 dnet sh14 dtail vss sky130_fd_pr__nfet_01v8 L=1 W=8 nf=1
XMd2 slope_out sh69 dtail vss sky130_fd_pr__nfet_01v8 L=1 W=8 nf=1
XMd3 dnet dnet vdd vdd sky130_fd_pr__pfet_01v8 L=1 W=4 nf=1
XMd4 slope_out slope_out vdd vdd sky130_fd_pr__pfet_01v8 L=1 W=4 nf=1

.ends qrs_slope
