R-Peak Detector Testbench
.lib "C:/Users/kadhi/OneDrive/Desktop/amux/verilogLearning/Leaky-Integrate-Fire---SNN-model-on-FPGA/experiments/frontend_optimization/ngspice_frontend/sky130_minimal.lib.spice" tt
.option scale=1.0u method=gear gmin=1e-15

.include "rpeak_detector.spice"

Vdd vdd 0 0.9
Vss vss 0 0
Vbias vbias 0 0.3
Vthresh threshold 0 0.36

Vecg ecg_in 0 PWL(0.0000 0.3 0.3000 0.3 0.3100 0.42 0.3300 0.42 0.3400 0.3 0.3400 0.3 0.6400 0.3 0.6500 0.42 0.6700 0.42 0.6800 0.3 0.6800 0.3 0.9800 0.3 0.9900 0.42 1.0100 0.42 1.0200 0.3)

Xrpeak ecg_in threshold rpeak_out vdd vss vbias rpeak_detector

.tran 0.1m 1.22 uic

.control
run
set wr_singlescale
wrdata C:/Users/kadhi/OneDrive/Desktop/amux/verilogLearning/Leaky-Integrate-Fire---SNN-model-on-FPGA/experiments/frontend_optimization/complete_frontend/_tb_rpeak_data.txt v(rpeak_out) v(ecg_in)
.endc
.end
