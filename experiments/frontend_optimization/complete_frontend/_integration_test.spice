Full ASIC Frontend Integration Test
.lib "C:\Users\kadhi\OneDrive\Desktop\amux\verilogLearning\Leaky-Integrate-Fire---SNN-model-on-FPGA\experiments\frontend_optimization\ngspice_frontend\sky130_minimal.lib.spice" tt
.option scale=1.0u method=gear gmin=1e-15
.temp 27

.include "frontend_top.spice"

Vdd vdd 0 0.9
Vss vss 0 0

Vel0p elec_l0_p 0 PWL(
+ 0.000000 -0.0001558
+ 0.005556 0.0001869
+ 0.011111 -0.0003138
+ 0.016667 -0.0001558
+ 0.022222 0.0001868
+ 0.027778 -0.0002863
+ 0.033333 -0.0001598
+ 0.038889 0.0001869
+ 0.044444 -0.0002942
+ 0.050000 -0.0001558
+ 0.055556 0.0001868
+ 0.061111 -0.0003138
+ 0.066667 -0.0001598
+ 0.072222 0.0001868
+ 0.077778 -0.0002903
+ 0.083333 -0.0001676
+ 0.088889 0.0001869
+ 0.094444 -0.0002786
+ 0.100000 -0.0001637
+ 0.105556 0.0001869
+ 0.111111 -0.0002943
+ 0.116667 -0.0001558
+ 0.122222 0.0001868
+ 0.127778 -0.0002903
+ 0.133333 -0.0001833
+ 0.138889 0.0001868
+ 0.144444 -0.0002943
+ 0.150000 -0.0001754
+ 0.155556 0.0001869
+ 0.161111 -0.0002944
+ 0.166667 -0.0001754
+ 0.172222 0.0001868
+ 0.177778 -0.0002825
+ 0.183333 -0.0001911
+ 0.188889 0.0001870
+ 0.194444 -0.0002433
+ 0.200000 -0.0001558
+ 0.205556 0.0001872
+ 0.211111 -0.0002198
+ 0.216667 -0.0001363
+ 0.222222 0.0001871
+ 0.227778 -0.0002119
+ 0.233333 -0.0001480
+ 0.238889 0.0001870
+ 0.244444 -0.0002238
+ 0.250000 -0.0001637
+ 0.255556 0.0001870
+ 0.261111 -0.0002983
+ 0.266667 -0.0001754
+ 0.272222 0.0001868
+ 0.277778 -0.0003061
+ 0.283333 -0.0001911
+ 0.288889 0.0001867
+ 0.294444 -0.0003257
+ 0.300000 -0.0001872
+ 0.305556 0.0001867
+ 0.311111 -0.0003572
+ 0.316667 -0.0002616
+ 0.322222 0.0001862
+ 0.327778 -0.0003407
+ 0.333333 0.0001067
+ 0.338889 0.0002521
+ 0.344444 -0.0003236
+ 0.350000 -0.0002694
+ 0.355556 0.0001871
+ 0.361111 -0.0004434
+ 0.366667 -0.0002224
+ 0.372222 0.0001866
+ 0.377778 -0.0003336
+ 0.383333 -0.0002224
+ 0.388889 0.0001867
+ 0.394444 -0.0003571
+ 0.400000 -0.0002107
+ 0.405556 0.0001866
+ 0.411111 -0.0003571
+ 0.416667 -0.0002028
+ 0.422222 0.0001866
+ 0.427778 -0.0003532
+ 0.433333 -0.0002146
+ 0.438889 0.0001866
+ 0.444444 -0.0003492
+ 0.450000 -0.0002067
+ 0.455556 0.0001866
+ 0.461111 -0.0003493
+ 0.466667 -0.0002028
+ 0.472222 0.0001866
+ 0.477778 -0.0003492
+ 0.483333 -0.0002224
+ 0.488889 0.0001866
+ 0.494444 -0.0003454
+ 0.500000 -0.0002263
+ 0.505556 0.0001867
+ 0.511111 -0.0003494
+ 0.516667 -0.0002146
+ 0.522222 0.0001866
+ 0.527778 -0.0003376
+ 0.533333 -0.0002694
+ 0.538889 0.0001866
+ 0.544444 -0.0003770
+ 0.550000 -0.0003086
+ 0.555556 0.0001864
+ 0.561111 -0.0004045
+ 0.566667 -0.0003203
+ 0.572222 0.0001864
+ 0.577778 -0.0003731
+ 0.583333 -0.0002851
+ 0.588889 0.0001866
+ 0.594444 -0.0003336
+ 0.600000 -0.0001989
+ 0.605556 0.0001869
+ 0.611111 -0.0002787
+ 0.616667 -0.0001558
+ 0.622222 0.0001870
+ 0.627778 -0.0002511
+ 0.633333 -0.0001598
+ 0.638889 0.0001870
+ 0.644444 -0.0002668
+ 0.650000 -0.0001480
+ 0.655556 0.0001870
+ 0.661111 -0.0002668
+ 0.666667 -0.0001558
+ 0.672222 0.0001869
+ 0.677778 -0.0002629
+ 0.683333 -0.0001754
+ 0.688889 0.0001870
+ 0.694444 -0.0002669
+ 0.700000 -0.0001793
+ 0.705556 0.0001869
+ 0.711111 -0.0002904
+ 0.716667 -0.0001715
+ 0.722222 0.0001869
+ 0.727778 -0.0002707
+ 0.733333 -0.0001872
+ 0.738889 0.0001869
+ 0.744444 -0.0002943
+ 0.750000 -0.0001833
+ 0.755556 0.0001869
+ 0.761111 -0.0003022
+ 0.766667 -0.0001715
+ 0.772222 0.0001868
+ 0.777778 -0.0002825
+ 0.783333 -0.0001872
+ 0.788889 0.0001869
+ 0.794444 -0.0002904
+ 0.800000 -0.0001676
+ 0.805556 0.0001869
+ 0.811111 -0.0002864
+ 0.816667 -0.0001715
+ 0.822222 0.0001870
+ 0.827778 -0.0002354
+ 0.833333 -0.0001598
+ 0.838889 0.0001872
+ 0.844444 -0.0002120
+ 0.850000 -0.0001284
+ 0.855556 0.0001872
+ 0.861111 -0.0002275
+ 0.866667 -0.0001167
+ 0.872222 0.0001872
+ 0.877778 -0.0002393
+ 0.883333 -0.0001558
+ 0.888889 0.0001869
+ 0.894444 -0.0003060
+ 0.900000 -0.0001519
+ 0.905556 0.0001868
+ 0.911111 -0.0003022
+ 0.916667 -0.0001637
+ 0.922222 0.0001868
+ 0.927778 -0.0002942
+ 0.933333 -0.0001754
+ 0.938889 0.0001868
+ 0.944444 -0.0003454
+ 0.950000 -0.0002694
+ 0.955556 0.0001862
+ 0.961111 -0.0003366
+ 0.966667 0.0002555
+ 0.972222 0.0002524
+ 0.977778 -0.0003672
+ 0.983333 -0.0002772
+ 0.988889 0.0001863
+ 0.994444 -0.0003531
+ 1.000000 -0.0002028
+ 1.005556 0.0001867
+ 1.011111 -0.0003532
+ 1.016667 -0.0001950
+ 1.022222 0.0001866
+ 1.027778 -0.0003296
+ 1.033333 -0.0001950
+ 1.038889 0.0001867
+ 1.044444 -0.0003257
+ 1.050000 -0.0001911
+ 1.055556 0.0001867
+ 1.061111 -0.0003218
+ 1.066667 -0.0001872
+ 1.072222 0.0001867
+ 1.077778 -0.0003257
+ 1.083333 -0.0001989
+ 1.088889 0.0001867
+ 1.094444 -0.0003296
+ 1.100000 -0.0002028
+ 1.105556 0.0001867
+ 1.111111 -0.0003218
+ 1.116667 -0.0001989
+ 1.122222 0.0001867
+ 1.127778 -0.0003257
+ 1.133333 -0.0002263
+ 1.138889 0.0001867
+ 1.144444 -0.0003376
+ 1.150000 -0.0002576
+ 1.155556 0.0001867
+ 1.161111 -0.0003456
+ 1.166667 -0.0002890
+ 1.172222 0.0001866
+ 1.177778 -0.0003338
+ 1.183333 -0.0003046
+ 1.188889 0.0001867
+ 1.194444 -0.0003338
+ 1.200000 -0.0002263
+ 1.205556 0.0001869
+ 1.211111 -0.0002747
+ 1.216667 -0.0001558
+ 1.222222 0.0001870
+ 1.227778 -0.0002433
+ 1.233333 -0.0001519
+ 1.238889 0.0001871
+ 1.244444 -0.0002315
+ 1.250000 -0.0001402
+ 1.255556 0.0001871
+ 1.261111 -0.0002433
+ 1.266667 -0.0001363
+ 1.272222 0.0001870
+ 1.277778 -0.0002393
+ 1.283333 -0.0001519
+ 1.288889 0.0001870
+ 1.294444 -0.0002512
+ 1.300000 -0.0001519
+ 1.305556 0.0001870
+ 1.311111 -0.0002708
+ 1.316667 -0.0001558
+ 1.322222 0.0001869
+ 1.327778 -0.0002629
+ 1.333333 -0.0001754
+ 1.338889 0.0001870
+ 1.344444 -0.0002786
+ 1.350000 -0.0001754
+ 1.355556 0.0001869
+ 1.361111 -0.0002825
+ 1.366667 -0.0001598
+ 1.372222 0.0001869
+ 1.377778 -0.0002668
+ 1.383333 -0.0001715
+ 1.388889 0.0001870
+ 1.394444 -0.0002747
+ 1.400000 -0.0001598
+ 1.405556 0.0001870
+ 1.411111 -0.0002747
+ 1.416667 -0.0001402
+ 1.422222 0.0001869
+ 1.427778 -0.0002550
+ 1.433333 -0.0001676
+ 1.438889 0.0001872
+ 1.444444 -0.0002120
+ 1.450000 -0.0001363
+ 1.455556 0.0001872
+ 1.461111 -0.0001884
+ 1.466667 -0.0001089
+ 1.472222 0.0001872
+ 1.477778 -0.0002040
+ 1.483333 -0.0001284
+ 1.488889 0.0001873
+ 1.494444 -0.0002236
+ 1.500000 -0.0001402
+ 1.505556 0.0001870
+ 1.511111 -0.0002864
+ 1.516667 -0.0001519
+ 1.522222 0.0001869
+ 1.527778 -0.0002746
+ 1.533333 -0.0001637
+ 1.538889 0.0001869
+ 1.544444 -0.0002747
+ 1.550000 -0.0001715
+ 1.555556 0.0001867
+ 1.561111 -0.0004083
+ 1.566667 -0.0000658
+ 1.572222 0.0002498
+ 1.577778 0.0003189
+ 1.583333 0.0004200
+ 1.588889 0.0001894
+ 1.594444 -0.0003805
+ 1.600000 -0.0001872
+ 1.605556 0.0001868
+ 1.611111 -0.0003100
+ 1.616667 -0.0001833
+ 1.622222 0.0001867
+ 1.627778 -0.0003139
+ 1.633333 -0.0002028
+ 1.638889 0.0001868
+ 1.644444 -0.0003179
+ 1.650000 -0.0001872
+ 1.655556 0.0001868
+ 1.661111 -0.0003218
+ 1.666667 -0.0001793
+ 1.672222 0.0001867
+ 1.677778 -0.0003061
+ 1.683333 -0.0001911
+ 1.688889 0.0001868
+ 1.694444 -0.0003140
+ 1.700000 -0.0001989
+ 1.705556 0.0001868
+ 1.711111 -0.0003062
+ 1.716667 -0.0001872
+ 1.722222 0.0001868
+ 1.727778 -0.0002983
+ 1.733333 -0.0002302
+ 1.738889 0.0001868
+ 1.744444 -0.0003063
+ 1.750000 -0.0002576
+ 1.755556 0.0001868
+ 1.761111 -0.0003104
+ 1.766667 -0.0002890
+ 1.772222 0.0001867
+ 1.777778 -0.0003065
+ 1.783333 -0.0002929
+ 1.788889 0.0001868
+ 1.794444 -0.0003063
+ 1.800000 -0.0002224
+ 1.805556 0.0001870
+ 1.811111 -0.0002669
+ 1.816667 -0.0001558
+ 1.822222 0.0001870
+ 1.827778 -0.0002197
+ 1.833333 -0.0001402
+ 1.838889 0.0001872
+ 1.844444 -0.0002315
+ 1.850000 -0.0001284
+ 1.855556 0.0001871
+ 1.861111 -0.0002315
+ 1.866667 -0.0001284
+ 1.872222 0.0001871
+ 1.877778 -0.0002276
+ 1.883333 -0.0001480
+ 1.888889 0.0001871
+ 1.894444 -0.0002355
+ 1.900000 -0.0001441
+ 1.905556 0.0001870
+ 1.911111 -0.0002433
+ 1.916667 -0.0001519
+ 1.922222 0.0001870
+ 1.927778 -0.0002472
+ 1.933333 -0.0001637
+ 1.938889 0.0001870
+ 1.944444 -0.0002590
+ 1.950000 -0.0001676
+ 1.955556 0.0001870
+ 1.961111 -0.0002590
+ 1.966667 -0.0001519
+ 1.972222 0.0001870
+ 1.977778 -0.0002511
+ 1.983333 -0.0001558
+ 1.988889 0.0001870
+ 1.994444 -0.0002394
+ 2.000000 -0.0001441
+ 2.005556 0.0001870
+ 2.011111 -0.0002550
+ 2.016667 -0.0001323
+ 2.022222 0.0001870
+ 2.027778 -0.0002002
+ 2.033333 -0.0001519
+ 2.038889 0.0001873
+ 2.044444 -0.0001688
+ 2.050000 -0.0001128
+ 2.055556 0.0001874
+ 2.061111 -0.0001765
+ 2.066667 -0.0000893
+ 2.072222 0.0001873
+ 2.077778 -0.0001452
+ 2.083333 -0.0001128
+ 2.088889 0.0001871
+ 2.094444 -0.0002471
+ 2.100000 -0.0001284
+ 2.105556 0.0001870
+ 2.111111 -0.0002550
+ 2.116667 -0.0001363
+ 2.122222 0.0001870
+ 2.127778 -0.0002628
+ 2.133333 -0.0001480
+ 2.138889 0.0001870
+ 2.144444 -0.0002825
+ 2.150000 -0.0002263
+ 2.155556 0.0001865
+ 2.161111 -0.0003918
+ 2.166667 0.0001537
+ 2.172222 0.0002517
+ 2.177778 -0.0003392
+ 2.183333 -0.0002381
+ 2.188889 0.0001866
+ 2.194444 -0.0003138
+ 2.200000 -0.0001598
+ 2.205556 0.0001869
+ 2.211111 -0.0002825
+ 2.216667 -0.0001598
+ 2.222222 0.0001869
+ 2.227778 -0.0002747
+ 2.233333 -0.0001793
+ 2.238889 0.0001868
+ 2.244444 -0.0002982
+ 2.250000 -0.0001676
+ 2.255556 0.0001869
+ 2.261111 -0.0002747
+ 2.266667 -0.0001598
+ 2.272222 0.0001869
+ 2.277778 -0.0002825
+ 2.283333 -0.0001754
+ 2.288889 0.0001869
+ 2.294444 -0.0002982
+ 2.300000 -0.0001754
+ 2.305556 0.0001869
+ 2.311111 -0.0002747
+ 2.316667 -0.0001872
+ 2.322222 0.0001869
+ 2.327778 -0.0002944
+ 2.333333 -0.0002107
+ 2.338889 0.0001869
+ 2.344444 -0.0002828
+ 2.350000 -0.0002381
+ 2.355556 0.0001869
+ 2.361111 -0.0003142
+ 2.366667 -0.0002576
+ 2.372222 0.0001868
+ 2.377778 -0.0002868
+ 2.383333 -0.0002381
+ 2.388889 0.0001869
+ 2.394444 -0.0002709
+ 2.400000 -0.0001637
+ 2.405556 0.0001871
+ 2.411111 -0.0002316
+ 2.416667 -0.0001480
+ 2.422222 0.0001871
+ 2.427778 -0.0002041
+ 2.433333 -0.0001558
+ 2.438889 0.0001872
+ 2.444444 -0.0002120
+ 2.450000 -0.0001519
+ 2.455556 0.0001871
+ 2.461111 -0.0002316
+ 2.466667 -0.0001598
+ 2.472222 0.0001871
+ 2.477778 -0.0002276
+ 2.483333 -0.0001637
+ 2.488889 0.0001871
+ 2.494444 -0.0002434
+ 2.500000 -0.0001754
+ 2.505556 0.0001870
+ 2.511111 -0.0002552
+ 2.516667 -0.0001754
+ 2.522222 0.0001870
+ 2.527778 -0.0002551
+ 2.533333 -0.0001872
+ 2.538889 0.0001870
+ 2.544444 -0.0002630
+ 2.550000 -0.0001872
+ 2.555556 0.0001870
+ 2.561111 -0.0002474
+ 2.566667 -0.0001754
+ 2.572222 0.0001870
+ 2.577778 -0.0002434
+ 2.583333 -0.0001911
+ 2.588889 0.0001870
+ 2.594444 -0.0002591
+ 2.600000 -0.0001911
+ 2.605556 0.0001872
+ 2.611111 -0.0002161
+ 2.616667 -0.0001676
+ 2.622222 0.0001872
+ 2.627778 -0.0001728
+ 2.633333 -0.0001558
+ 2.638889 0.0001872
+ 2.644444 -0.0002081
+ 2.650000 -0.0001598
+ 2.655556 0.0001873
+ 2.661111 -0.0002277
+ 2.666667 -0.0001911
+ 2.672222 0.0001869
+ 2.677778 -0.0002591
+ 2.683333 -0.0002028
+ 2.688889 0.0001870
+ 2.694444 -0.0002826
+ 2.700000 -0.0002067
+ 2.705556 0.0001869
+ 2.711111 -0.0002866
+ 2.716667 -0.0002028
+ 2.722222 0.0001868
+ 2.727778 -0.0003455
+ 2.733333 -0.0002772
+ 2.738889 0.0001864
+ 2.744444 -0.0001055
+ 2.750000 0.0002634
+ 2.755556 0.0001905
+ 2.761111 0.0000105
+ 2.766667 -0.0002537
+ 2.772222 0.0001866
+ 2.777778 -0.0003023
+ 2.783333 -0.0002420
+ 2.788889 0.0001868
+ 2.794444 -0.0003141
+ 2.800000 -0.0002381
+ 2.805556 0.0001868
+ 2.811111 -0.0003024
+ 2.816667 -0.0002302
+ 2.822222 0.0001868
+ 2.827778 -0.0003141
+ 2.833333 -0.0002459
+ 2.838889 0.0001868
+ 2.844444 -0.0003298
+ 2.850000 -0.0002381
+ 2.855556 0.0001868
+ 2.861111 -0.0003180
+ 2.866667 -0.0002342
+ 2.872222 0.0001867
+ 2.877778 -0.0003219
+ 2.883333 -0.0002459
+ 2.888889 0.0001868
+ 2.894444 -0.0003259
+ 2.900000 -0.0002537
+ 2.905556 0.0001868
+ 2.911111 -0.0003181
+ 2.916667 -0.0002616
+ 2.922222 0.0001868
+ 2.927778 -0.0003299
+ 2.933333 -0.0003125
+ 2.938889 0.0001866
+ 2.944444 -0.0003615
+ 2.950000 -0.0003399
+ 2.955556 0.0001866
+ 2.961111 -0.0003615
+ 2.966667 -0.0003203
+ 2.972222 0.0001866
+ 2.977778 -0.0003142
+ 2.983333 -0.0002537
+ 2.988889 0.0001869
+ 2.994444 -0.0002670
+ 3.000000 -0.0001989
+ 3.005556 0.0001870
+ 3.011111 -0.0002395
+ 3.016667 -0.0001833
+ 3.022222 0.0001871
+ 3.027778 -0.0002238
+ 3.033333 -0.0001754
+ 3.038889 0.0001871
+ 3.044444 -0.0002395
+ 3.050000 -0.0001793
+ 3.055556 0.0001871
+ 3.061111 -0.0002552
+ 3.066667 -0.0001676
+ 3.072222 0.0001870
+ 3.077778 -0.0002434
+ 3.083333 -0.0001911
+ 3.088889 0.0001870
+ 3.094444 -0.0002513
+ 3.100000 -0.0001754
+ 3.105556 0.0001870
+ 3.111111 -0.0002630
+ 3.116667 -0.0001911
+ 3.122222 0.0001869
+ 3.127778 -0.0002630
+ 3.133333 -0.0001911
+ 3.138889 0.0001870
+ 3.144444 -0.0002630
+ 3.150000 -0.0001833
+ 3.155556 0.0001870
+ 3.161111 -0.0002709
+ 3.166667 -0.0001911
+ 3.172222 0.0001869
+ 3.177778 -0.0002552
+ 3.183333 -0.0001872
+ 3.188889 0.0001870
+ 3.194444 -0.0002591
+ 3.200000 -0.0001911
+ 3.205556 0.0001870
+ 3.211111 -0.0002474
+ 3.216667 -0.0001911
+ 3.222222 0.0001871
+ 3.227778 -0.0002003
+ 3.233333 -0.0001715
+ 3.238889 0.0001873
+ 3.244444 -0.0001768
+ 3.250000 -0.0001480
+ 3.255556 0.0001873
+ 3.261111 -0.0001924
+ 3.266667 -0.0001323
+ 3.272222 0.0001872
+ 3.277778 -0.0001611
+ 3.283333 -0.0001676
+ 3.288889 0.0001871
+ 3.294444 -0.0002629
+ 3.300000 -0.0001715
+ 3.305556 0.0001870
+ 3.311111 -0.0002669
+ 3.316667 -0.0001754
+ 3.322222 0.0001870
+ 3.327778 -0.0002630
+ 3.333333 -0.0001911
+ 3.338889 0.0001869
+ 3.344444 -0.0002747
+ 3.350000 -0.0002028
+ 3.355556 0.0001868
+ 3.361111 -0.0003809
+ 3.366667 -0.0001519
+ 3.372222 0.0002496
+ 3.377778 0.0001814
+ 3.383333 0.0004983
+ 3.388889 0.0001905
+ 3.394444 -0.0001928
+ 3.400000 -0.0002146
+ 3.405556 0.0001868
+ 3.411111 -0.0003101
+ 3.416667 -0.0002107
+ 3.422222 0.0001868
+ 3.427778 -0.0003022
+ 3.433333 -0.0002146
+ 3.438889 0.0001868
+ 3.444444 -0.0003101
+ 3.450000 -0.0002107
+ 3.455556 0.0001869
+ 3.461111 -0.0002983
+ 3.466667 -0.0001950
+ 3.472222 0.0001868
+ 3.477778 -0.0002866
+ 3.483333 -0.0002107
+ 3.488889 0.0001869
+ 3.494444 -0.0002905
+ 3.500000 -0.0002028
+ 3.505556 0.0001869
+ 3.511111 -0.0003023
+ 3.516667 -0.0002107
+ 3.522222 0.0001868
+ 3.527778 -0.0002867
+ 3.533333 -0.0002420
+ 3.538889 0.0001868
+ 3.544444 -0.0002946
+ 3.550000 -0.0002655
+ 3.555556 0.0001869
+ 3.561111 -0.0002987
+ 3.566667 -0.0002890
+ 3.572222 0.0001868
+ 3.577778 -0.0003027
+ 3.583333 -0.0003242
+ 3.588889 0.0001868
+ 3.594444 -0.0003144
+ 3.600000 -0.0002772
+ 3.605556 0.0001869
+ 3.611111 -0.0002593
+ 3.616667 -0.0001911
+ 3.622222 0.0001871
+ 3.627778 -0.0002160
+ 3.633333 -0.0001637
+ 3.638889 0.0001872
+ 3.644444 -0.0002159
+ 3.650000 -0.0001480
+ 3.655556 0.0001872
+ 3.661111 -0.0002081
+ 3.666667 -0.0001480
+ 3.672222 0.0001871
+ 3.677778 -0.0002080
+ 3.683333 -0.0001519
+ 3.688889 0.0001871
+ 3.694444 -0.0002276
+ 3.700000 -0.0001637
+ 3.705556 0.0001871
+ 3.711111 -0.0002355
+ 3.716667 -0.0001637
+ 3.722222 0.0001870
+ 3.727778 -0.0002238
+ 3.733333 -0.0001754
+ 3.738889 0.0001870
+ 3.744444 -0.0002512
+ 3.750000 -0.0001715
+ 3.755556 0.0001870
+ 3.761111 -0.0002591
+ 3.766667 -0.0001754
+ 3.772222 0.0001870
+ 3.777778 -0.0002395
+ 3.783333 -0.0001950
+ 3.788889 0.0001870
+ 3.794444 -0.0002552
+ 3.800000 -0.0001872
+ 3.805556 0.0001870
+ 3.811111 -0.0002630
+ 3.816667 -0.0001833
+ 3.822222 0.0001870
+ 3.827778 -0.0002395
+ 3.833333 -0.0001911
+ 3.838889 0.0001870
+ 3.844444 -0.0002434
+ 3.850000 -0.0001833
+ 3.855556 0.0001871
+ 3.861111 -0.0002043
+ 3.866667 -0.0001793
+ 3.872222 0.0001872
+ 3.877778 -0.0001807
+ 3.883333 -0.0001598
+ 3.888889 0.0001874
+ 3.894444 -0.0001806
+ 3.900000 -0.0001519
+ 3.905556 0.0001873
+ 3.911111 -0.0001650
+ 3.916667 -0.0001519
+ 3.922222 0.0001871
+ 3.927778 -0.0002355
+ 3.933333 -0.0001872
+ 3.938889 0.0001870
+ 3.944444 -0.0002708
+ 3.950000 -0.0001833
+ 3.955556 0.0001870
+ 3.961111 -0.0002788
+ 3.966667 -0.0001911
+ 3.972222 0.0001869
+ 3.977778 -0.0002708
+ 3.983333 -0.0002342
+ 3.988889 0.0001866
+ 3.994444 -0.0003652
+ 4.000000 -0.0003399
+ 4.005556 0.0001862
+ 4.011111 -0.0003093
+ 4.016667 0.0002320
+ 4.022222 0.0002522
+ 4.027778 -0.0003196
+ 4.033333 -0.0002694
+ 4.038889 0.0001866
+ 4.044444 -0.0003140
+ 4.050000 -0.0002185
+ 4.055556 0.0001868
+ 4.061111 -0.0003141
+ 4.066667 -0.0002263
+ 4.072222 0.0001868
+ 4.077778 -0.0002984
+ 4.083333 -0.0002302
+ 4.088889 0.0001869
+ 4.094444 -0.0002984
+ 4.100000 -0.0002224
+ 4.105556 0.0001869
+ 4.111111 -0.0002984
+ 4.116667 -0.0002146
+ 4.122222 0.0001868
+ 4.127778 -0.0002983
+ 4.133333 -0.0002263
+ 4.138889 0.0001869
+ 4.144444 -0.0002984
+ 4.150000 -0.0002302
+ 4.155556 0.0001868
+ 4.161111 -0.0002945
+ 4.166667 -0.0002302
+ 4.172222 0.0001868
+ 4.177778 -0.0002749
+ 4.183333 -0.0002576
+ 4.188889 0.0001868
+ 4.194444 -0.0002986
+ 4.200000 -0.0002929
+ 4.205556 0.0001869
+ 4.211111 -0.0003026
+ 4.216667 -0.0003203
+ 4.222222 0.0001868
+ 4.227778 -0.0003027
+ 4.233333 -0.0003360
+ 4.238889 0.0001868
+ 4.244444 -0.0002948
+ 4.250000 -0.0002694
+ 4.255556 0.0001870
+ 4.261111 -0.0002554
+ 4.266667 -0.0001833
+ 4.272222 0.0001871
+ 4.277778 -0.0002160
+ 4.283333 -0.0001676
+ 4.288889 0.0001872
+ 4.294444 -0.0002238
+ 4.300000 -0.0001637
+ 4.305556 0.0001872
+ 4.311111 -0.0002121
+ 4.316667 -0.0001598
+ 4.322222 0.0001870
+ 4.327778 -0.0002316
+ 4.333333 -0.0001833
+ 4.338889 0.0001871
+ 4.344444 -0.0002474
+ 4.350000 -0.0001872
+ 4.355556 0.0001870
+ 4.361111 -0.0002474
+ 4.366667 -0.0001911
+ 4.372222 0.0001870
+ 4.377778 -0.0002513
+ 4.383333 -0.0002185
+ 4.388889 0.0001870
+ 4.394444 -0.0002670
+ 4.400000 -0.0002028
+ 4.405556 0.0001870
+ 4.411111 -0.0002631
+ 4.416667 -0.0002107
+ 4.422222 0.0001869
+ 4.427778 -0.0002591
+ 4.433333 -0.0002028
+ 4.438889 0.0001870
+ 4.444444 -0.0002710
+ 4.450000 -0.0002146
+ 4.455556 0.0001870
+ 4.461111 -0.0002709
+ 4.466667 -0.0001989
+ 4.472222 0.0001870
+ 4.477778 -0.0002357
+ 4.483333 -0.0002263
+ 4.488889 0.0001872
+ 4.494444 -0.0002083
+ 4.500000 -0.0001950
+ 4.505556 0.0001873
+ 4.511111 -0.0001886
+ 4.516667 -0.0001754
+ 4.522222 0.0001872
+ 4.527778 -0.0002081
+ 4.533333 -0.0001989
+ 4.538889 0.0001873
+ 4.544444 -0.0002200
+ 4.550000 -0.0001950
+ 4.555556 0.0001871
+ 4.561111 -0.0002788
+ 4.566667 -0.0002224
+ 4.572222 0.0001868
+ 4.577778 -0.0002827
+ 4.583333 -0.0002342
+ 4.588889 0.0001869
+ 4.594444 -0.0002945
+ 4.600000 -0.0002342
+ 4.605556 0.0001869
+ 4.611111 -0.0003339
+ 4.616667 -0.0003164
+ 4.622222 0.0001862
+ 4.627778 -0.0002978
+ 4.633333 0.0000911
+ 4.638889 0.0002524
+ 4.644444 -0.0004697
+ 4.650000 -0.0003359
+ 4.655556 0.0001865
+ 4.661111 -0.0003574
+ 4.666667 -0.0002616
+ 4.672222 0.0001867
+ 4.677778 -0.0003299
+ 4.683333 -0.0002655
+ 4.688889 0.0001867
+ 4.694444 -0.0003221
+ 4.700000 -0.0002655
+ 4.705556 0.0001867
+ 4.711111 -0.0003338
+ 4.716667 -0.0002576
+ 4.722222 0.0001867
+ 4.727778 -0.0003141
+ 4.733333 -0.0002655
+ 4.738889 0.0001867
+ 4.744444 -0.0003416
+ 4.750000 -0.0002616
+ 4.755556 0.0001867
+ 4.761111 -0.0003417
+ 4.766667 -0.0002655
+ 4.772222 0.0001867
+ 4.777778 -0.0003260
+ 4.783333 -0.0002694
+ 4.788889 0.0001867
+ 4.794444 -0.0003378
+ 4.800000 -0.0002772
+ 4.805556 0.0001867
+ 4.811111 -0.0003340
+ 4.816667 -0.0003046
+ 4.822222 0.0001867
+ 4.827778 -0.0003262
+ 4.833333 -0.0003595
+ 4.838889 0.0001866
+ 4.844444 -0.0003577
+ 4.850000 -0.0003595
+ 4.855556 0.0001866
+ 4.861111 -0.0003577
+ 4.866667 -0.0003164
+ 4.872222 0.0001867
+ 4.877778 -0.0003026
+ 4.883333 -0.0002694
+ 4.888889 0.0001870
+ 4.894444 -0.0002633
+ 4.900000 -0.0002420
+ 4.905556 0.0001870
+ 4.911111 -0.0002710
+ 4.916667 -0.0002420
+ 4.922222 0.0001870
+ 4.927778 -0.0002475
+ 4.933333 -0.0002498
+ 4.938889 0.0001870
+ 4.944444 -0.0002711
+ 4.950000 -0.0002459
+ 4.955556 0.0001870
+ 4.961111 -0.0002750
+ 4.966667 -0.0002459
+ 4.972222 0.0001870
+ 4.977778 -0.0002633
+ 4.983333 -0.0002694
+ 4.988889 0.0001869
+ 4.994444 -0.0002947
+ 5.000000 -0.0002694
+ 5.005556 0.0001869
+ 5.011111 -0.0002908
+ 5.016667 -0.0002733
+ 5.022222 0.0001869
+ 5.027778 -0.0002829
+ 5.033333 -0.0002890
+ 5.038889 0.0001868
+ 5.044444 -0.0002947
+ 5.050000 -0.0002811
+ 5.055556 0.0001869
+ 5.061111 -0.0002791
+ 5.066667 -0.0002811
+ 5.072222 0.0001869
+ 5.077778 -0.0002751
+ 5.083333 -0.0002890
+ 5.088889 0.0001869
+ 5.094444 -0.0002790
+ 5.100000 -0.0002811
+ 5.105556 0.0001870
+ 5.111111 -0.0002477
+ 5.116667 -0.0002537
+ 5.122222 0.0001871
+ 5.127778 -0.0001928
+ 5.133333 -0.0002537
+ 5.138889 0.0001872
+ 5.144444 -0.0002201
+ 5.150000 -0.0002420
+ 5.155556 0.0001872
+ 5.161111 -0.0002281
+ 5.166667 -0.0002537
+ 5.172222 0.0001869
+ 5.177778 -0.0002869
+ 5.183333 -0.0002851
+ 5.188889 0.0001868
+ 5.194444 -0.0003064
+ 5.200000 -0.0002694
+ 5.205556 0.0001868
+ 5.211111 -0.0003182
+ 5.216667 -0.0002655
+ 5.222222 0.0001868
+ 5.227778 -0.0003025
+ 5.233333 -0.0003242
+ 5.238889 0.0001865
+ 5.244444 -0.0004475
+ 5.250000 -0.0000658
+ 5.255556 0.0002505
+ 5.261111 -0.0005000
+ 5.266667 0.0000050
+ 5.272222 0.0001883
+ 5.277778 -0.0003731
+ 5.283333 -0.0002890
+ 5.288889 0.0001867
+ 5.294444 -0.0003378
+ 5.300000 -0.0002694
+ 5.305556 0.0001867
+ 5.311111 -0.0003339
+ 5.316667 -0.0002655
+ 5.322222 0.0001866
+ 5.327778 -0.0003299
+ 5.333333 -0.0002772
+ 5.338889 0.0001867
+ 5.344444 -0.0003377
+ 5.350000 -0.0002616
+ 5.355556 0.0001867
+ 5.361111 -0.0003417
+ 5.366667 -0.0002616
+ 5.372222 0.0001866
+ 5.377778 -0.0003220
+ 5.383333 -0.0002772
+ 5.388889 0.0001867
+ 5.394444 -0.0003456
+ 5.400000 -0.0002733
+ 5.405556 0.0001867
+ 5.411111 -0.0003496
+ 5.416667 -0.0002811
+ 5.422222 0.0001866
+ 5.427778 -0.0003378
+ 5.433333 -0.0003125
+ 5.438889 0.0001867
+ 5.444444 -0.0003536
+ 5.450000 -0.0003438
+ 5.455556 0.0001866
+ 5.461111 -0.0003773
+ 5.466667 -0.0003673
+ 5.472222 0.0001864
+ 5.477778 -0.0003694
+ 5.483333 -0.0003438
+ 5.488889 0.0001866
+ 5.494444 -0.0003300
+ 5.500000 -0.0002655
+ 5.505556 0.0001868
+ 5.511111 -0.0002906
+ 5.516667 -0.0002146
+ 5.522222 0.0001869
+ 5.527778 -0.0002513
+ 5.533333 -0.0002028
+ 5.538889 0.0001870
+ 5.544444 -0.0002592
+ 5.550000 -0.0002028
+ 5.555556 0.0001870
+ 5.561111 -0.0002710
+ )
Vel0n elec_l0_n 0 PWL(
+ 0.000000 0.0001558
+ 0.005556 -0.0001869
+ 0.011111 0.0003138
+ 0.016667 0.0001558
+ 0.022222 -0.0001868
+ 0.027778 0.0002863
+ 0.033333 0.0001598
+ 0.038889 -0.0001869
+ 0.044444 0.0002942
+ 0.050000 0.0001558
+ 0.055556 -0.0001868
+ 0.061111 0.0003138
+ 0.066667 0.0001598
+ 0.072222 -0.0001868
+ 0.077778 0.0002903
+ 0.083333 0.0001676
+ 0.088889 -0.0001869
+ 0.094444 0.0002786
+ 0.100000 0.0001637
+ 0.105556 -0.0001869
+ 0.111111 0.0002943
+ 0.116667 0.0001558
+ 0.122222 -0.0001868
+ 0.127778 0.0002903
+ 0.133333 0.0001833
+ 0.138889 -0.0001868
+ 0.144444 0.0002943
+ 0.150000 0.0001754
+ 0.155556 -0.0001869
+ 0.161111 0.0002944
+ 0.166667 0.0001754
+ 0.172222 -0.0001868
+ 0.177778 0.0002825
+ 0.183333 0.0001911
+ 0.188889 -0.0001870
+ 0.194444 0.0002433
+ 0.200000 0.0001558
+ 0.205556 -0.0001872
+ 0.211111 0.0002198
+ 0.216667 0.0001363
+ 0.222222 -0.0001871
+ 0.227778 0.0002119
+ 0.233333 0.0001480
+ 0.238889 -0.0001870
+ 0.244444 0.0002238
+ 0.250000 0.0001637
+ 0.255556 -0.0001870
+ 0.261111 0.0002983
+ 0.266667 0.0001754
+ 0.272222 -0.0001868
+ 0.277778 0.0003061
+ 0.283333 0.0001911
+ 0.288889 -0.0001867
+ 0.294444 0.0003257
+ 0.300000 0.0001872
+ 0.305556 -0.0001867
+ 0.311111 0.0003572
+ 0.316667 0.0002616
+ 0.322222 -0.0001862
+ 0.327778 0.0003407
+ 0.333333 -0.0001067
+ 0.338889 -0.0002521
+ 0.344444 0.0003236
+ 0.350000 0.0002694
+ 0.355556 -0.0001871
+ 0.361111 0.0004434
+ 0.366667 0.0002224
+ 0.372222 -0.0001866
+ 0.377778 0.0003336
+ 0.383333 0.0002224
+ 0.388889 -0.0001867
+ 0.394444 0.0003571
+ 0.400000 0.0002107
+ 0.405556 -0.0001866
+ 0.411111 0.0003571
+ 0.416667 0.0002028
+ 0.422222 -0.0001866
+ 0.427778 0.0003532
+ 0.433333 0.0002146
+ 0.438889 -0.0001866
+ 0.444444 0.0003492
+ 0.450000 0.0002067
+ 0.455556 -0.0001866
+ 0.461111 0.0003493
+ 0.466667 0.0002028
+ 0.472222 -0.0001866
+ 0.477778 0.0003492
+ 0.483333 0.0002224
+ 0.488889 -0.0001866
+ 0.494444 0.0003454
+ 0.500000 0.0002263
+ 0.505556 -0.0001867
+ 0.511111 0.0003494
+ 0.516667 0.0002146
+ 0.522222 -0.0001866
+ 0.527778 0.0003376
+ 0.533333 0.0002694
+ 0.538889 -0.0001866
+ 0.544444 0.0003770
+ 0.550000 0.0003086
+ 0.555556 -0.0001864
+ 0.561111 0.0004045
+ 0.566667 0.0003203
+ 0.572222 -0.0001864
+ 0.577778 0.0003731
+ 0.583333 0.0002851
+ 0.588889 -0.0001866
+ 0.594444 0.0003336
+ 0.600000 0.0001989
+ 0.605556 -0.0001869
+ 0.611111 0.0002787
+ 0.616667 0.0001558
+ 0.622222 -0.0001870
+ 0.627778 0.0002511
+ 0.633333 0.0001598
+ 0.638889 -0.0001870
+ 0.644444 0.0002668
+ 0.650000 0.0001480
+ 0.655556 -0.0001870
+ 0.661111 0.0002668
+ 0.666667 0.0001558
+ 0.672222 -0.0001869
+ 0.677778 0.0002629
+ 0.683333 0.0001754
+ 0.688889 -0.0001870
+ 0.694444 0.0002669
+ 0.700000 0.0001793
+ 0.705556 -0.0001869
+ 0.711111 0.0002904
+ 0.716667 0.0001715
+ 0.722222 -0.0001869
+ 0.727778 0.0002707
+ 0.733333 0.0001872
+ 0.738889 -0.0001869
+ 0.744444 0.0002943
+ 0.750000 0.0001833
+ 0.755556 -0.0001869
+ 0.761111 0.0003022
+ 0.766667 0.0001715
+ 0.772222 -0.0001868
+ 0.777778 0.0002825
+ 0.783333 0.0001872
+ 0.788889 -0.0001869
+ 0.794444 0.0002904
+ 0.800000 0.0001676
+ 0.805556 -0.0001869
+ 0.811111 0.0002864
+ 0.816667 0.0001715
+ 0.822222 -0.0001870
+ 0.827778 0.0002354
+ 0.833333 0.0001598
+ 0.838889 -0.0001872
+ 0.844444 0.0002120
+ 0.850000 0.0001284
+ 0.855556 -0.0001872
+ 0.861111 0.0002275
+ 0.866667 0.0001167
+ 0.872222 -0.0001872
+ 0.877778 0.0002393
+ 0.883333 0.0001558
+ 0.888889 -0.0001869
+ 0.894444 0.0003060
+ 0.900000 0.0001519
+ 0.905556 -0.0001868
+ 0.911111 0.0003022
+ 0.916667 0.0001637
+ 0.922222 -0.0001868
+ 0.927778 0.0002942
+ 0.933333 0.0001754
+ 0.938889 -0.0001868
+ 0.944444 0.0003454
+ 0.950000 0.0002694
+ 0.955556 -0.0001862
+ 0.961111 0.0003366
+ 0.966667 -0.0002555
+ 0.972222 -0.0002524
+ 0.977778 0.0003672
+ 0.983333 0.0002772
+ 0.988889 -0.0001863
+ 0.994444 0.0003531
+ 1.000000 0.0002028
+ 1.005556 -0.0001867
+ 1.011111 0.0003532
+ 1.016667 0.0001950
+ 1.022222 -0.0001866
+ 1.027778 0.0003296
+ 1.033333 0.0001950
+ 1.038889 -0.0001867
+ 1.044444 0.0003257
+ 1.050000 0.0001911
+ 1.055556 -0.0001867
+ 1.061111 0.0003218
+ 1.066667 0.0001872
+ 1.072222 -0.0001867
+ 1.077778 0.0003257
+ 1.083333 0.0001989
+ 1.088889 -0.0001867
+ 1.094444 0.0003296
+ 1.100000 0.0002028
+ 1.105556 -0.0001867
+ 1.111111 0.0003218
+ 1.116667 0.0001989
+ 1.122222 -0.0001867
+ 1.127778 0.0003257
+ 1.133333 0.0002263
+ 1.138889 -0.0001867
+ 1.144444 0.0003376
+ 1.150000 0.0002576
+ 1.155556 -0.0001867
+ 1.161111 0.0003456
+ 1.166667 0.0002890
+ 1.172222 -0.0001866
+ 1.177778 0.0003338
+ 1.183333 0.0003046
+ 1.188889 -0.0001867
+ 1.194444 0.0003338
+ 1.200000 0.0002263
+ 1.205556 -0.0001869
+ 1.211111 0.0002747
+ 1.216667 0.0001558
+ 1.222222 -0.0001870
+ 1.227778 0.0002433
+ 1.233333 0.0001519
+ 1.238889 -0.0001871
+ 1.244444 0.0002315
+ 1.250000 0.0001402
+ 1.255556 -0.0001871
+ 1.261111 0.0002433
+ 1.266667 0.0001363
+ 1.272222 -0.0001870
+ 1.277778 0.0002393
+ 1.283333 0.0001519
+ 1.288889 -0.0001870
+ 1.294444 0.0002512
+ 1.300000 0.0001519
+ 1.305556 -0.0001870
+ 1.311111 0.0002708
+ 1.316667 0.0001558
+ 1.322222 -0.0001869
+ 1.327778 0.0002629
+ 1.333333 0.0001754
+ 1.338889 -0.0001870
+ 1.344444 0.0002786
+ 1.350000 0.0001754
+ 1.355556 -0.0001869
+ 1.361111 0.0002825
+ 1.366667 0.0001598
+ 1.372222 -0.0001869
+ 1.377778 0.0002668
+ 1.383333 0.0001715
+ 1.388889 -0.0001870
+ 1.394444 0.0002747
+ 1.400000 0.0001598
+ 1.405556 -0.0001870
+ 1.411111 0.0002747
+ 1.416667 0.0001402
+ 1.422222 -0.0001869
+ 1.427778 0.0002550
+ 1.433333 0.0001676
+ 1.438889 -0.0001872
+ 1.444444 0.0002120
+ 1.450000 0.0001363
+ 1.455556 -0.0001872
+ 1.461111 0.0001884
+ 1.466667 0.0001089
+ 1.472222 -0.0001872
+ 1.477778 0.0002040
+ 1.483333 0.0001284
+ 1.488889 -0.0001873
+ 1.494444 0.0002236
+ 1.500000 0.0001402
+ 1.505556 -0.0001870
+ 1.511111 0.0002864
+ 1.516667 0.0001519
+ 1.522222 -0.0001869
+ 1.527778 0.0002746
+ 1.533333 0.0001637
+ 1.538889 -0.0001869
+ 1.544444 0.0002747
+ 1.550000 0.0001715
+ 1.555556 -0.0001867
+ 1.561111 0.0004083
+ 1.566667 0.0000658
+ 1.572222 -0.0002498
+ 1.577778 -0.0003189
+ 1.583333 -0.0004200
+ 1.588889 -0.0001894
+ 1.594444 0.0003805
+ 1.600000 0.0001872
+ 1.605556 -0.0001868
+ 1.611111 0.0003100
+ 1.616667 0.0001833
+ 1.622222 -0.0001867
+ 1.627778 0.0003139
+ 1.633333 0.0002028
+ 1.638889 -0.0001868
+ 1.644444 0.0003179
+ 1.650000 0.0001872
+ 1.655556 -0.0001868
+ 1.661111 0.0003218
+ 1.666667 0.0001793
+ 1.672222 -0.0001867
+ 1.677778 0.0003061
+ 1.683333 0.0001911
+ 1.688889 -0.0001868
+ 1.694444 0.0003140
+ 1.700000 0.0001989
+ 1.705556 -0.0001868
+ 1.711111 0.0003062
+ 1.716667 0.0001872
+ 1.722222 -0.0001868
+ 1.727778 0.0002983
+ 1.733333 0.0002302
+ 1.738889 -0.0001868
+ 1.744444 0.0003063
+ 1.750000 0.0002576
+ 1.755556 -0.0001868
+ 1.761111 0.0003104
+ 1.766667 0.0002890
+ 1.772222 -0.0001867
+ 1.777778 0.0003065
+ 1.783333 0.0002929
+ 1.788889 -0.0001868
+ 1.794444 0.0003063
+ 1.800000 0.0002224
+ 1.805556 -0.0001870
+ 1.811111 0.0002669
+ 1.816667 0.0001558
+ 1.822222 -0.0001870
+ 1.827778 0.0002197
+ 1.833333 0.0001402
+ 1.838889 -0.0001872
+ 1.844444 0.0002315
+ 1.850000 0.0001284
+ 1.855556 -0.0001871
+ 1.861111 0.0002315
+ 1.866667 0.0001284
+ 1.872222 -0.0001871
+ 1.877778 0.0002276
+ 1.883333 0.0001480
+ 1.888889 -0.0001871
+ 1.894444 0.0002355
+ 1.900000 0.0001441
+ 1.905556 -0.0001870
+ 1.911111 0.0002433
+ 1.916667 0.0001519
+ 1.922222 -0.0001870
+ 1.927778 0.0002472
+ 1.933333 0.0001637
+ 1.938889 -0.0001870
+ 1.944444 0.0002590
+ 1.950000 0.0001676
+ 1.955556 -0.0001870
+ 1.961111 0.0002590
+ 1.966667 0.0001519
+ 1.972222 -0.0001870
+ 1.977778 0.0002511
+ 1.983333 0.0001558
+ 1.988889 -0.0001870
+ 1.994444 0.0002394
+ 2.000000 0.0001441
+ 2.005556 -0.0001870
+ 2.011111 0.0002550
+ 2.016667 0.0001323
+ 2.022222 -0.0001870
+ 2.027778 0.0002002
+ 2.033333 0.0001519
+ 2.038889 -0.0001873
+ 2.044444 0.0001688
+ 2.050000 0.0001128
+ 2.055556 -0.0001874
+ 2.061111 0.0001765
+ 2.066667 0.0000893
+ 2.072222 -0.0001873
+ 2.077778 0.0001452
+ 2.083333 0.0001128
+ 2.088889 -0.0001871
+ 2.094444 0.0002471
+ 2.100000 0.0001284
+ 2.105556 -0.0001870
+ 2.111111 0.0002550
+ 2.116667 0.0001363
+ 2.122222 -0.0001870
+ 2.127778 0.0002628
+ 2.133333 0.0001480
+ 2.138889 -0.0001870
+ 2.144444 0.0002825
+ 2.150000 0.0002263
+ 2.155556 -0.0001865
+ 2.161111 0.0003918
+ 2.166667 -0.0001537
+ 2.172222 -0.0002517
+ 2.177778 0.0003392
+ 2.183333 0.0002381
+ 2.188889 -0.0001866
+ 2.194444 0.0003138
+ 2.200000 0.0001598
+ 2.205556 -0.0001869
+ 2.211111 0.0002825
+ 2.216667 0.0001598
+ 2.222222 -0.0001869
+ 2.227778 0.0002747
+ 2.233333 0.0001793
+ 2.238889 -0.0001868
+ 2.244444 0.0002982
+ 2.250000 0.0001676
+ 2.255556 -0.0001869
+ 2.261111 0.0002747
+ 2.266667 0.0001598
+ 2.272222 -0.0001869
+ 2.277778 0.0002825
+ 2.283333 0.0001754
+ 2.288889 -0.0001869
+ 2.294444 0.0002982
+ 2.300000 0.0001754
+ 2.305556 -0.0001869
+ 2.311111 0.0002747
+ 2.316667 0.0001872
+ 2.322222 -0.0001869
+ 2.327778 0.0002944
+ 2.333333 0.0002107
+ 2.338889 -0.0001869
+ 2.344444 0.0002828
+ 2.350000 0.0002381
+ 2.355556 -0.0001869
+ 2.361111 0.0003142
+ 2.366667 0.0002576
+ 2.372222 -0.0001868
+ 2.377778 0.0002868
+ 2.383333 0.0002381
+ 2.388889 -0.0001869
+ 2.394444 0.0002709
+ 2.400000 0.0001637
+ 2.405556 -0.0001871
+ 2.411111 0.0002316
+ 2.416667 0.0001480
+ 2.422222 -0.0001871
+ 2.427778 0.0002041
+ 2.433333 0.0001558
+ 2.438889 -0.0001872
+ 2.444444 0.0002120
+ 2.450000 0.0001519
+ 2.455556 -0.0001871
+ 2.461111 0.0002316
+ 2.466667 0.0001598
+ 2.472222 -0.0001871
+ 2.477778 0.0002276
+ 2.483333 0.0001637
+ 2.488889 -0.0001871
+ 2.494444 0.0002434
+ 2.500000 0.0001754
+ 2.505556 -0.0001870
+ 2.511111 0.0002552
+ 2.516667 0.0001754
+ 2.522222 -0.0001870
+ 2.527778 0.0002551
+ 2.533333 0.0001872
+ 2.538889 -0.0001870
+ 2.544444 0.0002630
+ 2.550000 0.0001872
+ 2.555556 -0.0001870
+ 2.561111 0.0002474
+ 2.566667 0.0001754
+ 2.572222 -0.0001870
+ 2.577778 0.0002434
+ 2.583333 0.0001911
+ 2.588889 -0.0001870
+ 2.594444 0.0002591
+ 2.600000 0.0001911
+ 2.605556 -0.0001872
+ 2.611111 0.0002161
+ 2.616667 0.0001676
+ 2.622222 -0.0001872
+ 2.627778 0.0001728
+ 2.633333 0.0001558
+ 2.638889 -0.0001872
+ 2.644444 0.0002081
+ 2.650000 0.0001598
+ 2.655556 -0.0001873
+ 2.661111 0.0002277
+ 2.666667 0.0001911
+ 2.672222 -0.0001869
+ 2.677778 0.0002591
+ 2.683333 0.0002028
+ 2.688889 -0.0001870
+ 2.694444 0.0002826
+ 2.700000 0.0002067
+ 2.705556 -0.0001869
+ 2.711111 0.0002866
+ 2.716667 0.0002028
+ 2.722222 -0.0001868
+ 2.727778 0.0003455
+ 2.733333 0.0002772
+ 2.738889 -0.0001864
+ 2.744444 0.0001055
+ 2.750000 -0.0002634
+ 2.755556 -0.0001905
+ 2.761111 -0.0000105
+ 2.766667 0.0002537
+ 2.772222 -0.0001866
+ 2.777778 0.0003023
+ 2.783333 0.0002420
+ 2.788889 -0.0001868
+ 2.794444 0.0003141
+ 2.800000 0.0002381
+ 2.805556 -0.0001868
+ 2.811111 0.0003024
+ 2.816667 0.0002302
+ 2.822222 -0.0001868
+ 2.827778 0.0003141
+ 2.833333 0.0002459
+ 2.838889 -0.0001868
+ 2.844444 0.0003298
+ 2.850000 0.0002381
+ 2.855556 -0.0001868
+ 2.861111 0.0003180
+ 2.866667 0.0002342
+ 2.872222 -0.0001867
+ 2.877778 0.0003219
+ 2.883333 0.0002459
+ 2.888889 -0.0001868
+ 2.894444 0.0003259
+ 2.900000 0.0002537
+ 2.905556 -0.0001868
+ 2.911111 0.0003181
+ 2.916667 0.0002616
+ 2.922222 -0.0001868
+ 2.927778 0.0003299
+ 2.933333 0.0003125
+ 2.938889 -0.0001866
+ 2.944444 0.0003615
+ 2.950000 0.0003399
+ 2.955556 -0.0001866
+ 2.961111 0.0003615
+ 2.966667 0.0003203
+ 2.972222 -0.0001866
+ 2.977778 0.0003142
+ 2.983333 0.0002537
+ 2.988889 -0.0001869
+ 2.994444 0.0002670
+ 3.000000 0.0001989
+ 3.005556 -0.0001870
+ 3.011111 0.0002395
+ 3.016667 0.0001833
+ 3.022222 -0.0001871
+ 3.027778 0.0002238
+ 3.033333 0.0001754
+ 3.038889 -0.0001871
+ 3.044444 0.0002395
+ 3.050000 0.0001793
+ 3.055556 -0.0001871
+ 3.061111 0.0002552
+ 3.066667 0.0001676
+ 3.072222 -0.0001870
+ 3.077778 0.0002434
+ 3.083333 0.0001911
+ 3.088889 -0.0001870
+ 3.094444 0.0002513
+ 3.100000 0.0001754
+ 3.105556 -0.0001870
+ 3.111111 0.0002630
+ 3.116667 0.0001911
+ 3.122222 -0.0001869
+ 3.127778 0.0002630
+ 3.133333 0.0001911
+ 3.138889 -0.0001870
+ 3.144444 0.0002630
+ 3.150000 0.0001833
+ 3.155556 -0.0001870
+ 3.161111 0.0002709
+ 3.166667 0.0001911
+ 3.172222 -0.0001869
+ 3.177778 0.0002552
+ 3.183333 0.0001872
+ 3.188889 -0.0001870
+ 3.194444 0.0002591
+ 3.200000 0.0001911
+ 3.205556 -0.0001870
+ 3.211111 0.0002474
+ 3.216667 0.0001911
+ 3.222222 -0.0001871
+ 3.227778 0.0002003
+ 3.233333 0.0001715
+ 3.238889 -0.0001873
+ 3.244444 0.0001768
+ 3.250000 0.0001480
+ 3.255556 -0.0001873
+ 3.261111 0.0001924
+ 3.266667 0.0001323
+ 3.272222 -0.0001872
+ 3.277778 0.0001611
+ 3.283333 0.0001676
+ 3.288889 -0.0001871
+ 3.294444 0.0002629
+ 3.300000 0.0001715
+ 3.305556 -0.0001870
+ 3.311111 0.0002669
+ 3.316667 0.0001754
+ 3.322222 -0.0001870
+ 3.327778 0.0002630
+ 3.333333 0.0001911
+ 3.338889 -0.0001869
+ 3.344444 0.0002747
+ 3.350000 0.0002028
+ 3.355556 -0.0001868
+ 3.361111 0.0003809
+ 3.366667 0.0001519
+ 3.372222 -0.0002496
+ 3.377778 -0.0001814
+ 3.383333 -0.0004983
+ 3.388889 -0.0001905
+ 3.394444 0.0001928
+ 3.400000 0.0002146
+ 3.405556 -0.0001868
+ 3.411111 0.0003101
+ 3.416667 0.0002107
+ 3.422222 -0.0001868
+ 3.427778 0.0003022
+ 3.433333 0.0002146
+ 3.438889 -0.0001868
+ 3.444444 0.0003101
+ 3.450000 0.0002107
+ 3.455556 -0.0001869
+ 3.461111 0.0002983
+ 3.466667 0.0001950
+ 3.472222 -0.0001868
+ 3.477778 0.0002866
+ 3.483333 0.0002107
+ 3.488889 -0.0001869
+ 3.494444 0.0002905
+ 3.500000 0.0002028
+ 3.505556 -0.0001869
+ 3.511111 0.0003023
+ 3.516667 0.0002107
+ 3.522222 -0.0001868
+ 3.527778 0.0002867
+ 3.533333 0.0002420
+ 3.538889 -0.0001868
+ 3.544444 0.0002946
+ 3.550000 0.0002655
+ 3.555556 -0.0001869
+ 3.561111 0.0002987
+ 3.566667 0.0002890
+ 3.572222 -0.0001868
+ 3.577778 0.0003027
+ 3.583333 0.0003242
+ 3.588889 -0.0001868
+ 3.594444 0.0003144
+ 3.600000 0.0002772
+ 3.605556 -0.0001869
+ 3.611111 0.0002593
+ 3.616667 0.0001911
+ 3.622222 -0.0001871
+ 3.627778 0.0002160
+ 3.633333 0.0001637
+ 3.638889 -0.0001872
+ 3.644444 0.0002159
+ 3.650000 0.0001480
+ 3.655556 -0.0001872
+ 3.661111 0.0002081
+ 3.666667 0.0001480
+ 3.672222 -0.0001871
+ 3.677778 0.0002080
+ 3.683333 0.0001519
+ 3.688889 -0.0001871
+ 3.694444 0.0002276
+ 3.700000 0.0001637
+ 3.705556 -0.0001871
+ 3.711111 0.0002355
+ 3.716667 0.0001637
+ 3.722222 -0.0001870
+ 3.727778 0.0002238
+ 3.733333 0.0001754
+ 3.738889 -0.0001870
+ 3.744444 0.0002512
+ 3.750000 0.0001715
+ 3.755556 -0.0001870
+ 3.761111 0.0002591
+ 3.766667 0.0001754
+ 3.772222 -0.0001870
+ 3.777778 0.0002395
+ 3.783333 0.0001950
+ 3.788889 -0.0001870
+ 3.794444 0.0002552
+ 3.800000 0.0001872
+ 3.805556 -0.0001870
+ 3.811111 0.0002630
+ 3.816667 0.0001833
+ 3.822222 -0.0001870
+ 3.827778 0.0002395
+ 3.833333 0.0001911
+ 3.838889 -0.0001870
+ 3.844444 0.0002434
+ 3.850000 0.0001833
+ 3.855556 -0.0001871
+ 3.861111 0.0002043
+ 3.866667 0.0001793
+ 3.872222 -0.0001872
+ 3.877778 0.0001807
+ 3.883333 0.0001598
+ 3.888889 -0.0001874
+ 3.894444 0.0001806
+ 3.900000 0.0001519
+ 3.905556 -0.0001873
+ 3.911111 0.0001650
+ 3.916667 0.0001519
+ 3.922222 -0.0001871
+ 3.927778 0.0002355
+ 3.933333 0.0001872
+ 3.938889 -0.0001870
+ 3.944444 0.0002708
+ 3.950000 0.0001833
+ 3.955556 -0.0001870
+ 3.961111 0.0002788
+ 3.966667 0.0001911
+ 3.972222 -0.0001869
+ 3.977778 0.0002708
+ 3.983333 0.0002342
+ 3.988889 -0.0001866
+ 3.994444 0.0003652
+ 4.000000 0.0003399
+ 4.005556 -0.0001862
+ 4.011111 0.0003093
+ 4.016667 -0.0002320
+ 4.022222 -0.0002522
+ 4.027778 0.0003196
+ 4.033333 0.0002694
+ 4.038889 -0.0001866
+ 4.044444 0.0003140
+ 4.050000 0.0002185
+ 4.055556 -0.0001868
+ 4.061111 0.0003141
+ 4.066667 0.0002263
+ 4.072222 -0.0001868
+ 4.077778 0.0002984
+ 4.083333 0.0002302
+ 4.088889 -0.0001869
+ 4.094444 0.0002984
+ 4.100000 0.0002224
+ 4.105556 -0.0001869
+ 4.111111 0.0002984
+ 4.116667 0.0002146
+ 4.122222 -0.0001868
+ 4.127778 0.0002983
+ 4.133333 0.0002263
+ 4.138889 -0.0001869
+ 4.144444 0.0002984
+ 4.150000 0.0002302
+ 4.155556 -0.0001868
+ 4.161111 0.0002945
+ 4.166667 0.0002302
+ 4.172222 -0.0001868
+ 4.177778 0.0002749
+ 4.183333 0.0002576
+ 4.188889 -0.0001868
+ 4.194444 0.0002986
+ 4.200000 0.0002929
+ 4.205556 -0.0001869
+ 4.211111 0.0003026
+ 4.216667 0.0003203
+ 4.222222 -0.0001868
+ 4.227778 0.0003027
+ 4.233333 0.0003360
+ 4.238889 -0.0001868
+ 4.244444 0.0002948
+ 4.250000 0.0002694
+ 4.255556 -0.0001870
+ 4.261111 0.0002554
+ 4.266667 0.0001833
+ 4.272222 -0.0001871
+ 4.277778 0.0002160
+ 4.283333 0.0001676
+ 4.288889 -0.0001872
+ 4.294444 0.0002238
+ 4.300000 0.0001637
+ 4.305556 -0.0001872
+ 4.311111 0.0002121
+ 4.316667 0.0001598
+ 4.322222 -0.0001870
+ 4.327778 0.0002316
+ 4.333333 0.0001833
+ 4.338889 -0.0001871
+ 4.344444 0.0002474
+ 4.350000 0.0001872
+ 4.355556 -0.0001870
+ 4.361111 0.0002474
+ 4.366667 0.0001911
+ 4.372222 -0.0001870
+ 4.377778 0.0002513
+ 4.383333 0.0002185
+ 4.388889 -0.0001870
+ 4.394444 0.0002670
+ 4.400000 0.0002028
+ 4.405556 -0.0001870
+ 4.411111 0.0002631
+ 4.416667 0.0002107
+ 4.422222 -0.0001869
+ 4.427778 0.0002591
+ 4.433333 0.0002028
+ 4.438889 -0.0001870
+ 4.444444 0.0002710
+ 4.450000 0.0002146
+ 4.455556 -0.0001870
+ 4.461111 0.0002709
+ 4.466667 0.0001989
+ 4.472222 -0.0001870
+ 4.477778 0.0002357
+ 4.483333 0.0002263
+ 4.488889 -0.0001872
+ 4.494444 0.0002083
+ 4.500000 0.0001950
+ 4.505556 -0.0001873
+ 4.511111 0.0001886
+ 4.516667 0.0001754
+ 4.522222 -0.0001872
+ 4.527778 0.0002081
+ 4.533333 0.0001989
+ 4.538889 -0.0001873
+ 4.544444 0.0002200
+ 4.550000 0.0001950
+ 4.555556 -0.0001871
+ 4.561111 0.0002788
+ 4.566667 0.0002224
+ 4.572222 -0.0001868
+ 4.577778 0.0002827
+ 4.583333 0.0002342
+ 4.588889 -0.0001869
+ 4.594444 0.0002945
+ 4.600000 0.0002342
+ 4.605556 -0.0001869
+ 4.611111 0.0003339
+ 4.616667 0.0003164
+ 4.622222 -0.0001862
+ 4.627778 0.0002978
+ 4.633333 -0.0000911
+ 4.638889 -0.0002524
+ 4.644444 0.0004697
+ 4.650000 0.0003359
+ 4.655556 -0.0001865
+ 4.661111 0.0003574
+ 4.666667 0.0002616
+ 4.672222 -0.0001867
+ 4.677778 0.0003299
+ 4.683333 0.0002655
+ 4.688889 -0.0001867
+ 4.694444 0.0003221
+ 4.700000 0.0002655
+ 4.705556 -0.0001867
+ 4.711111 0.0003338
+ 4.716667 0.0002576
+ 4.722222 -0.0001867
+ 4.727778 0.0003141
+ 4.733333 0.0002655
+ 4.738889 -0.0001867
+ 4.744444 0.0003416
+ 4.750000 0.0002616
+ 4.755556 -0.0001867
+ 4.761111 0.0003417
+ 4.766667 0.0002655
+ 4.772222 -0.0001867
+ 4.777778 0.0003260
+ 4.783333 0.0002694
+ 4.788889 -0.0001867
+ 4.794444 0.0003378
+ 4.800000 0.0002772
+ 4.805556 -0.0001867
+ 4.811111 0.0003340
+ 4.816667 0.0003046
+ 4.822222 -0.0001867
+ 4.827778 0.0003262
+ 4.833333 0.0003595
+ 4.838889 -0.0001866
+ 4.844444 0.0003577
+ 4.850000 0.0003595
+ 4.855556 -0.0001866
+ 4.861111 0.0003577
+ 4.866667 0.0003164
+ 4.872222 -0.0001867
+ 4.877778 0.0003026
+ 4.883333 0.0002694
+ 4.888889 -0.0001870
+ 4.894444 0.0002633
+ 4.900000 0.0002420
+ 4.905556 -0.0001870
+ 4.911111 0.0002710
+ 4.916667 0.0002420
+ 4.922222 -0.0001870
+ 4.927778 0.0002475
+ 4.933333 0.0002498
+ 4.938889 -0.0001870
+ 4.944444 0.0002711
+ 4.950000 0.0002459
+ 4.955556 -0.0001870
+ 4.961111 0.0002750
+ 4.966667 0.0002459
+ 4.972222 -0.0001870
+ 4.977778 0.0002633
+ 4.983333 0.0002694
+ 4.988889 -0.0001869
+ 4.994444 0.0002947
+ 5.000000 0.0002694
+ 5.005556 -0.0001869
+ 5.011111 0.0002908
+ 5.016667 0.0002733
+ 5.022222 -0.0001869
+ 5.027778 0.0002829
+ 5.033333 0.0002890
+ 5.038889 -0.0001868
+ 5.044444 0.0002947
+ 5.050000 0.0002811
+ 5.055556 -0.0001869
+ 5.061111 0.0002791
+ 5.066667 0.0002811
+ 5.072222 -0.0001869
+ 5.077778 0.0002751
+ 5.083333 0.0002890
+ 5.088889 -0.0001869
+ 5.094444 0.0002790
+ 5.100000 0.0002811
+ 5.105556 -0.0001870
+ 5.111111 0.0002477
+ 5.116667 0.0002537
+ 5.122222 -0.0001871
+ 5.127778 0.0001928
+ 5.133333 0.0002537
+ 5.138889 -0.0001872
+ 5.144444 0.0002201
+ 5.150000 0.0002420
+ 5.155556 -0.0001872
+ 5.161111 0.0002281
+ 5.166667 0.0002537
+ 5.172222 -0.0001869
+ 5.177778 0.0002869
+ 5.183333 0.0002851
+ 5.188889 -0.0001868
+ 5.194444 0.0003064
+ 5.200000 0.0002694
+ 5.205556 -0.0001868
+ 5.211111 0.0003182
+ 5.216667 0.0002655
+ 5.222222 -0.0001868
+ 5.227778 0.0003025
+ 5.233333 0.0003242
+ 5.238889 -0.0001865
+ 5.244444 0.0004475
+ 5.250000 0.0000658
+ 5.255556 -0.0002505
+ 5.261111 0.0005000
+ 5.266667 -0.0000050
+ 5.272222 -0.0001883
+ 5.277778 0.0003731
+ 5.283333 0.0002890
+ 5.288889 -0.0001867
+ 5.294444 0.0003378
+ 5.300000 0.0002694
+ 5.305556 -0.0001867
+ 5.311111 0.0003339
+ 5.316667 0.0002655
+ 5.322222 -0.0001866
+ 5.327778 0.0003299
+ 5.333333 0.0002772
+ 5.338889 -0.0001867
+ 5.344444 0.0003377
+ 5.350000 0.0002616
+ 5.355556 -0.0001867
+ 5.361111 0.0003417
+ 5.366667 0.0002616
+ 5.372222 -0.0001866
+ 5.377778 0.0003220
+ 5.383333 0.0002772
+ 5.388889 -0.0001867
+ 5.394444 0.0003456
+ 5.400000 0.0002733
+ 5.405556 -0.0001867
+ 5.411111 0.0003496
+ 5.416667 0.0002811
+ 5.422222 -0.0001866
+ 5.427778 0.0003378
+ 5.433333 0.0003125
+ 5.438889 -0.0001867
+ 5.444444 0.0003536
+ 5.450000 0.0003438
+ 5.455556 -0.0001866
+ 5.461111 0.0003773
+ 5.466667 0.0003673
+ 5.472222 -0.0001864
+ 5.477778 0.0003694
+ 5.483333 0.0003438
+ 5.488889 -0.0001866
+ 5.494444 0.0003300
+ 5.500000 0.0002655
+ 5.505556 -0.0001868
+ 5.511111 0.0002906
+ 5.516667 0.0002146
+ 5.522222 -0.0001869
+ 5.527778 0.0002513
+ 5.533333 0.0002028
+ 5.538889 -0.0001870
+ 5.544444 0.0002592
+ 5.550000 0.0002028
+ 5.555556 -0.0001870
+ 5.561111 0.0002710
+ )
Vel1p elec_l1_p 0 PWL(
+ 0.000000 0.0001873
+ 0.005556 -0.0002948
+ 0.011111 -0.0001483
+ 0.016667 0.0001872
+ 0.022222 -0.0003067
+ 0.027778 -0.0001444
+ 0.033333 0.0001872
+ 0.038889 -0.0002869
+ 0.044444 -0.0001562
+ 0.050000 0.0001872
+ 0.055556 -0.0003066
+ 0.061111 -0.0001601
+ 0.066667 0.0001872
+ 0.072222 -0.0002988
+ 0.077778 -0.0001640
+ 0.083333 0.0001872
+ 0.088889 -0.0002791
+ 0.094444 -0.0001562
+ 0.100000 0.0001873
+ 0.105556 -0.0002949
+ 0.111111 -0.0001601
+ 0.116667 0.0001872
+ 0.122222 -0.0003028
+ 0.127778 -0.0001640
+ 0.133333 0.0001872
+ 0.138889 -0.0002949
+ 0.144444 -0.0001836
+ 0.150000 0.0001873
+ 0.155556 -0.0002910
+ 0.161111 -0.0001758
+ 0.166667 0.0001873
+ 0.172222 -0.0002910
+ 0.177778 -0.0001679
+ 0.183333 0.0001873
+ 0.188889 -0.0002478
+ 0.194444 -0.0001719
+ 0.200000 0.0001875
+ 0.205556 -0.0002124
+ 0.211111 -0.0001444
+ 0.216667 0.0001876
+ 0.222222 -0.0002320
+ 0.227778 -0.0001483
+ 0.233333 0.0001874
+ 0.238889 -0.0002242
+ 0.244444 -0.0001758
+ 0.250000 0.0001874
+ 0.255556 -0.0002870
+ 0.261111 -0.0001836
+ 0.266667 0.0001872
+ 0.272222 -0.0003107
+ 0.277778 -0.0001797
+ 0.283333 0.0001871
+ 0.288889 -0.0003145
+ 0.294444 -0.0001915
+ 0.300000 0.0001871
+ 0.305556 -0.0003342
+ 0.311111 -0.0002425
+ 0.316667 0.0001869
+ 0.322222 -0.0004638
+ 0.327778 0.0000089
+ 0.333333 0.0002511
+ 0.338889 -0.0004576
+ 0.344444 0.0001541
+ 0.350000 0.0001890
+ 0.355556 -0.0003464
+ 0.361111 -0.0002386
+ 0.366667 0.0001869
+ 0.372222 -0.0003540
+ 0.377778 -0.0002190
+ 0.383333 0.0001871
+ 0.388889 -0.0003500
+ 0.394444 -0.0002347
+ 0.400000 0.0001870
+ 0.405556 -0.0003618
+ 0.411111 -0.0002150
+ 0.416667 0.0001870
+ 0.422222 -0.0003618
+ 0.427778 -0.0001954
+ 0.433333 0.0001870
+ 0.438889 -0.0003461
+ 0.444444 -0.0002111
+ 0.450000 0.0001870
+ 0.455556 -0.0003578
+ 0.461111 -0.0002072
+ 0.466667 0.0001870
+ 0.472222 -0.0003618
+ 0.477778 -0.0002111
+ 0.483333 0.0001870
+ 0.488889 -0.0003383
+ 0.494444 -0.0002268
+ 0.500000 0.0001871
+ 0.505556 -0.0003383
+ 0.511111 -0.0002190
+ 0.516667 0.0001871
+ 0.522222 -0.0003384
+ 0.527778 -0.0002386
+ 0.533333 0.0001869
+ 0.538889 -0.0003699
+ 0.544444 -0.0003014
+ 0.550000 0.0001869
+ 0.555556 -0.0004014
+ 0.561111 -0.0003249
+ 0.566667 0.0001869
+ 0.572222 -0.0003976
+ 0.577778 -0.0002896
+ 0.583333 0.0001869
+ 0.588889 -0.0003462
+ 0.594444 -0.0002150
+ 0.600000 0.0001872
+ 0.605556 -0.0002910
+ 0.611111 -0.0001640
+ 0.616667 0.0001874
+ 0.622222 -0.0002517
+ 0.627778 -0.0001483
+ 0.633333 0.0001873
+ 0.638889 -0.0002595
+ 0.644444 -0.0001679
+ 0.650000 0.0001874
+ 0.655556 -0.0002674
+ 0.661111 -0.0001601
+ 0.666667 0.0001874
+ 0.672222 -0.0002714
+ 0.677778 -0.0001601
+ 0.683333 0.0001873
+ 0.688889 -0.0002635
+ 0.694444 -0.0001797
+ 0.700000 0.0001873
+ 0.705556 -0.0002910
+ 0.711111 -0.0001797
+ 0.716667 0.0001873
+ 0.722222 -0.0002792
+ 0.727778 -0.0001758
+ 0.733333 0.0001873
+ 0.738889 -0.0002753
+ 0.744444 -0.0001915
+ 0.750000 0.0001873
+ 0.755556 -0.0002949
+ 0.761111 -0.0001836
+ 0.766667 0.0001873
+ 0.772222 -0.0002949
+ 0.777778 -0.0001640
+ 0.783333 0.0001872
+ 0.788889 -0.0002792
+ 0.794444 -0.0001719
+ 0.800000 0.0001873
+ 0.805556 -0.0002988
+ 0.811111 -0.0001719
+ 0.816667 0.0001874
+ 0.822222 -0.0002439
+ 0.827778 -0.0001562
+ 0.833333 0.0001875
+ 0.838889 -0.0002084
+ 0.844444 -0.0001483
+ 0.850000 0.0001876
+ 0.855556 -0.0002319
+ 0.861111 -0.0001248
+ 0.866667 0.0001876
+ 0.872222 -0.0002163
+ 0.877778 -0.0001326
+ 0.883333 0.0001873
+ 0.888889 -0.0002909
+ 0.894444 -0.0001679
+ 0.900000 0.0001872
+ 0.905556 -0.0002989
+ 0.911111 -0.0001679
+ 0.916667 0.0001872
+ 0.922222 -0.0003146
+ 0.927778 -0.0001679
+ 0.933333 0.0001871
+ 0.938889 -0.0003106
+ 0.944444 -0.0002386
+ 0.950000 0.0001868
+ 0.955556 -0.0004715
+ 0.961111 0.0001031
+ 0.966667 0.0002515
+ 0.972222 -0.0003827
+ 0.977778 -0.0000816
+ 0.983333 0.0001877
+ 0.988889 -0.0004010
+ 0.994444 -0.0001954
+ 1.000000 0.0001871
+ 1.005556 -0.0003304
+ 1.011111 -0.0002033
+ 1.016667 0.0001871
+ 1.022222 -0.0003422
+ 1.027778 -0.0001915
+ 1.033333 0.0001871
+ 1.038889 -0.0003146
+ 1.044444 -0.0001993
+ 1.050000 0.0001871
+ 1.055556 -0.0003264
+ 1.061111 -0.0001915
+ 1.066667 0.0001871
+ 1.072222 -0.0003382
+ 1.077778 -0.0001836
+ 1.083333 0.0001871
+ 1.088889 -0.0003342
+ 1.094444 -0.0001993
+ 1.100000 0.0001871
+ 1.105556 -0.0003303
+ 1.111111 -0.0001876
+ 1.116667 0.0001872
+ 1.122222 -0.0003382
+ 1.127778 -0.0002072
+ 1.133333 0.0001871
+ 1.138889 -0.0003265
+ 1.144444 -0.0002464
+ 1.150000 0.0001871
+ 1.155556 -0.0003424
+ 1.161111 -0.0002817
+ 1.166667 0.0001871
+ 1.172222 -0.0003464
+ 1.177778 -0.0002935
+ 1.183333 0.0001870
+ 1.188889 -0.0003306
+ 1.194444 -0.0002386
+ 1.200000 0.0001872
+ 1.205556 -0.0002871
+ 1.211111 -0.0001562
+ 1.216667 0.0001874
+ 1.222222 -0.0002517
+ 1.227778 -0.0001483
+ 1.233333 0.0001874
+ 1.238889 -0.0002241
+ 1.244444 -0.0001444
+ 1.250000 0.0001875
+ 1.255556 -0.0002438
+ 1.261111 -0.0001326
+ 1.266667 0.0001875
+ 1.272222 -0.0002438
+ 1.277778 -0.0001366
+ 1.283333 0.0001874
+ 1.288889 -0.0002516
+ 1.294444 -0.0001601
+ 1.300000 0.0001874
+ 1.305556 -0.0002635
+ 1.311111 -0.0001601
+ 1.316667 0.0001874
+ 1.322222 -0.0002714
+ 1.327778 -0.0001640
+ 1.333333 0.0001873
+ 1.338889 -0.0002595
+ 1.344444 -0.0001758
+ 1.350000 0.0001873
+ 1.355556 -0.0002870
+ 1.361111 -0.0001679
+ 1.366667 0.0001873
+ 1.372222 -0.0002753
+ 1.377778 -0.0001601
+ 1.383333 0.0001873
+ 1.388889 -0.0002595
+ 1.394444 -0.0001679
+ 1.400000 0.0001874
+ 1.405556 -0.0002635
+ 1.411111 -0.0001562
+ 1.416667 0.0001874
+ 1.422222 -0.0002714
+ 1.427778 -0.0001483
+ 1.433333 0.0001874
+ 1.438889 -0.0002085
+ 1.444444 -0.0001562
+ 1.450000 0.0001877
+ 1.455556 -0.0001810
+ 1.461111 -0.0001248
+ 1.466667 0.0001876
+ 1.472222 -0.0002005
+ 1.477778 -0.0001012
+ 1.483333 0.0001877
+ 1.488889 -0.0002045
+ 1.494444 -0.0001405
+ 1.500000 0.0001874
+ 1.505556 -0.0002713
+ 1.511111 -0.0001483
+ 1.516667 0.0001873
+ 1.522222 -0.0002870
+ 1.527778 -0.0001562
+ 1.533333 0.0001872
+ 1.538889 -0.0002752
+ 1.544444 -0.0001719
+ 1.550000 0.0001873
+ 1.555556 -0.0003658
+ 1.561111 -0.0002543
+ 1.566667 0.0002496
+ 1.572222 -0.0000698
+ 1.577778 -0.0004934
+ 1.583333 0.0002540
+ 1.588889 0.0000031
+ 1.594444 -0.0001836
+ 1.600000 0.0001872
+ 1.605556 -0.0003107
+ 1.611111 -0.0001915
+ 1.616667 0.0001872
+ 1.622222 -0.0003147
+ 1.627778 -0.0001915
+ 1.633333 0.0001871
+ 1.638889 -0.0003146
+ 1.644444 -0.0001993
+ 1.650000 0.0001872
+ 1.655556 -0.0003225
+ 1.661111 -0.0001876
+ 1.666667 0.0001872
+ 1.672222 -0.0003146
+ 1.677778 -0.0001719
+ 1.683333 0.0001871
+ 1.688889 -0.0003028
+ 1.694444 -0.0002033
+ 1.700000 0.0001872
+ 1.705556 -0.0003029
+ 1.711111 -0.0001954
+ 1.716667 0.0001872
+ 1.722222 -0.0003029
+ 1.727778 -0.0002111
+ 1.733333 0.0001872
+ 1.738889 -0.0003109
+ 1.744444 -0.0002543
+ 1.750000 0.0001872
+ 1.755556 -0.0003071
+ 1.761111 -0.0002817
+ 1.766667 0.0001872
+ 1.772222 -0.0003150
+ 1.777778 -0.0002817
+ 1.783333 0.0001872
+ 1.788889 -0.0002992
+ 1.794444 -0.0002386
+ 1.800000 0.0001873
+ 1.805556 -0.0002715
+ 1.811111 -0.0001836
+ 1.816667 0.0001874
+ 1.822222 -0.0002360
+ 1.827778 -0.0001366
+ 1.833333 0.0001875
+ 1.838889 -0.0002084
+ 1.844444 -0.0001483
+ 1.850000 0.0001875
+ 1.855556 -0.0002242
+ 1.861111 -0.0001366
+ 1.866667 0.0001875
+ 1.872222 -0.0002360
+ 1.877778 -0.0001405
+ 1.883333 0.0001874
+ 1.888889 -0.0002241
+ 1.894444 -0.0001562
+ 1.900000 0.0001875
+ 1.905556 -0.0002399
+ 1.911111 -0.0001601
+ 1.916667 0.0001875
+ 1.922222 -0.0002595
+ 1.927778 -0.0001523
+ 1.933333 0.0001873
+ 1.938889 -0.0002595
+ 1.944444 -0.0001640
+ 1.950000 0.0001874
+ 1.955556 -0.0002556
+ 1.961111 -0.0001640
+ 1.966667 0.0001874
+ 1.972222 -0.0002635
+ 1.977778 -0.0001483
+ 1.983333 0.0001874
+ 1.988889 -0.0002398
+ 1.994444 -0.0001562
+ 2.000000 0.0001874
+ 2.005556 -0.0002595
+ 2.011111 -0.0001444
+ 2.016667 0.0001874
+ 2.022222 -0.0002399
+ 2.027778 -0.0001444
+ 2.033333 0.0001876
+ 2.038889 -0.0001809
+ 2.044444 -0.0001287
+ 2.050000 0.0001878
+ 2.055556 -0.0001730
+ 2.061111 -0.0000895
+ 2.066667 0.0001877
+ 2.072222 -0.0001769
+ 2.077778 -0.0001169
+ 2.083333 0.0001876
+ 2.088889 -0.0002280
+ 2.094444 -0.0001366
+ 2.100000 0.0001874
+ 2.105556 -0.0002477
+ 2.111111 -0.0001366
+ 2.116667 0.0001874
+ 2.122222 -0.0002673
+ 2.127778 -0.0001405
+ 2.133333 0.0001873
+ 2.138889 -0.0002594
+ 2.144444 -0.0001915
+ 2.150000 0.0001870
+ 2.155556 -0.0004129
+ 2.161111 0.0000167
+ 2.166667 0.0002509
+ 2.172222 0.0005000
+ 2.177778 0.0000991
+ 2.183333 0.0001885
+ 2.188889 -0.0003733
+ 2.194444 -0.0001601
+ 2.200000 0.0001873
+ 2.205556 -0.0002870
+ 2.211111 -0.0001601
+ 2.216667 0.0001873
+ 2.222222 -0.0002832
+ 2.227778 -0.0001601
+ 2.233333 0.0001872
+ 2.238889 -0.0002870
+ 2.244444 -0.0001836
+ 2.250000 0.0001873
+ 2.255556 -0.0002870
+ 2.261111 -0.0001640
+ 2.266667 0.0001873
+ 2.272222 -0.0002831
+ 2.277778 -0.0001679
+ 2.283333 0.0001872
+ 2.288889 -0.0002831
+ 2.294444 -0.0001836
+ 2.300000 0.0001873
+ 2.305556 -0.0002832
+ 2.311111 -0.0001758
+ 2.316667 0.0001873
+ 2.322222 -0.0002912
+ 2.327778 -0.0001954
+ 2.333333 0.0001872
+ 2.338889 -0.0002715
+ 2.344444 -0.0002464
+ 2.350000 0.0001873
+ 2.355556 -0.0002992
+ 2.361111 -0.0002582
+ 2.366667 0.0001873
+ 2.372222 -0.0003032
+ 2.377778 -0.0002504
+ 2.383333 0.0001872
+ 2.388889 -0.0002715
+ 2.394444 -0.0001954
+ 2.400000 0.0001874
+ 2.405556 -0.0002399
+ 2.411111 -0.0001483
+ 2.416667 0.0001876
+ 2.422222 -0.0002124
+ 2.427778 -0.0001366
+ 2.433333 0.0001875
+ 2.438889 -0.0002006
+ 2.444444 -0.0001640
+ 2.450000 0.0001875
+ 2.455556 -0.0002321
+ 2.461111 -0.0001601
+ 2.466667 0.0001875
+ 2.472222 -0.0002322
+ 2.477778 -0.0001562
+ 2.483333 0.0001875
+ 2.488889 -0.0002282
+ 2.494444 -0.0001797
+ 2.500000 0.0001874
+ 2.505556 -0.0002636
+ 2.511111 -0.0001797
+ 2.516667 0.0001874
+ 2.522222 -0.0002557
+ 2.527778 -0.0001758
+ 2.533333 0.0001874
+ 2.538889 -0.0002596
+ 2.544444 -0.0001954
+ 2.550000 0.0001874
+ 2.555556 -0.0002479
+ 2.561111 -0.0001836
+ 2.566667 0.0001874
+ 2.572222 -0.0002557
+ 2.577778 -0.0001876
+ 2.583333 0.0001874
+ 2.588889 -0.0002557
+ 2.594444 -0.0002111
+ 2.600000 0.0001875
+ 2.605556 -0.0002165
+ 2.611111 -0.0001797
+ 2.616667 0.0001877
+ 2.622222 -0.0001850
+ 2.627778 -0.0001640
+ 2.633333 0.0001876
+ 2.638889 -0.0001889
+ 2.644444 -0.0001719
+ 2.650000 0.0001876
+ 2.655556 -0.0002046
+ 2.661111 -0.0001797
+ 2.666667 0.0001874
+ 2.672222 -0.0002794
+ 2.677778 -0.0001876
+ 2.683333 0.0001873
+ 2.688889 -0.0002675
+ 2.694444 -0.0002033
+ 2.700000 0.0001873
+ 2.705556 -0.0002990
+ 2.711111 -0.0002111
+ 2.716667 0.0001873
+ 2.722222 -0.0003109
+ 2.727778 -0.0002778
+ 2.733333 0.0001868
+ 2.738889 -0.0003180
+ 2.744444 0.0000913
+ 2.750000 0.0002530
+ 2.755556 -0.0004513
+ 2.761111 -0.0003210
+ 2.766667 0.0001869
+ 2.772222 -0.0003227
+ 2.777778 -0.0002229
+ 2.783333 0.0001872
+ 2.788889 -0.0003148
+ 2.794444 -0.0002386
+ 2.800000 0.0001872
+ 2.805556 -0.0003108
+ 2.811111 -0.0002268
+ 2.816667 0.0001872
+ 2.822222 -0.0003188
+ 2.827778 -0.0002386
+ 2.833333 0.0001871
+ 2.838889 -0.0003226
+ 2.844444 -0.0002504
+ 2.850000 0.0001872
+ 2.855556 -0.0003226
+ 2.861111 -0.0002425
+ 2.866667 0.0001871
+ 2.872222 -0.0003226
+ 2.877778 -0.0002347
+ 2.883333 0.0001871
+ 2.888889 -0.0003187
+ 2.894444 -0.0002543
+ 2.900000 0.0001872
+ 2.905556 -0.0003148
+ 2.911111 -0.0002582
+ 2.916667 0.0001872
+ 2.922222 -0.0003268
+ 2.927778 -0.0002896
+ 2.933333 0.0001870
+ 2.938889 -0.0003426
+ 2.944444 -0.0003445
+ 2.950000 0.0001870
+ 2.955556 -0.0003662
+ 2.961111 -0.0003328
+ 2.966667 0.0001870
+ 2.972222 -0.0003386
+ 2.977778 -0.0002621
+ 2.983333 0.0001872
+ 2.988889 -0.0002754
+ 2.994444 -0.0002072
+ 3.000000 0.0001874
+ 3.005556 -0.0002400
+ 3.011111 -0.0001836
+ 3.016667 0.0001875
+ 3.022222 -0.0002401
+ 3.027778 -0.0001679
+ 3.033333 0.0001875
+ 3.038889 -0.0002282
+ 3.044444 -0.0001836
+ 3.050000 0.0001874
+ 3.055556 -0.0002518
+ 3.061111 -0.0001719
+ 3.066667 0.0001874
+ 3.072222 -0.0002557
+ 3.077778 -0.0001797
+ 3.083333 0.0001874
+ 3.088889 -0.0002439
+ 3.094444 -0.0001954
+ 3.100000 0.0001874
+ 3.105556 -0.0002597
+ 3.111111 -0.0001954
+ 3.116667 0.0001874
+ 3.122222 -0.0002714
+ 3.127778 -0.0001915
+ 3.133333 0.0001873
+ 3.138889 -0.0002518
+ 3.144444 -0.0001954
+ 3.150000 0.0001874
+ 3.155556 -0.0002597
+ 3.161111 -0.0001954
+ 3.166667 0.0001874
+ 3.172222 -0.0002675
+ 3.177778 -0.0001836
+ 3.183333 0.0001874
+ 3.188889 -0.0002518
+ 3.194444 -0.0001954
+ 3.200000 0.0001874
+ 3.205556 -0.0002518
+ 3.211111 -0.0001915
+ 3.216667 0.0001875
+ 3.222222 -0.0002165
+ 3.227778 -0.0001758
+ 3.233333 0.0001876
+ 3.238889 -0.0001732
+ 3.244444 -0.0001562
+ 3.250000 0.0001877
+ 3.255556 -0.0001850
+ 3.261111 -0.0001483
+ 3.266667 0.0001877
+ 3.272222 -0.0001968
+ 3.277778 -0.0001562
+ 3.283333 0.0001876
+ 3.288889 -0.0002360
+ 3.294444 -0.0001836
+ 3.300000 0.0001874
+ 3.305556 -0.0002675
+ 3.311111 -0.0001915
+ 3.316667 0.0001874
+ 3.322222 -0.0002715
+ 3.327778 -0.0001836
+ 3.333333 0.0001872
+ 3.338889 -0.0002674
+ 3.344444 -0.0001915
+ 3.350000 0.0001873
+ 3.355556 -0.0003463
+ 3.361111 -0.0002896
+ 3.366667 0.0001868
+ 3.372222 -0.0001446
+ 3.377778 0.0004131
+ 3.383333 0.0002538
+ 3.388889 0.0004000
+ 3.394444 -0.0002229
+ 3.400000 0.0001871
+ 3.405556 -0.0002990
+ 3.411111 -0.0002111
+ 3.416667 0.0001872
+ 3.422222 -0.0003108
+ 3.427778 -0.0002072
+ 3.433333 0.0001872
+ 3.438889 -0.0002990
+ 3.444444 -0.0002229
+ 3.450000 0.0001872
+ 3.455556 -0.0002912
+ 3.461111 -0.0002072
+ 3.466667 0.0001873
+ 3.472222 -0.0002951
+ 3.477778 -0.0002072
+ 3.483333 0.0001872
+ 3.488889 -0.0002911
+ 3.494444 -0.0002229
+ 3.500000 0.0001872
+ 3.505556 -0.0002872
+ 3.511111 -0.0002150
+ 3.516667 0.0001873
+ 3.522222 -0.0002991
+ 3.527778 -0.0002229
+ 3.533333 0.0001872
+ 3.538889 -0.0002873
+ 3.544444 -0.0002582
+ 3.550000 0.0001873
+ 3.555556 -0.0002914
+ 3.561111 -0.0002935
+ 3.566667 0.0001872
+ 3.572222 -0.0003151
+ 3.577778 -0.0003092
+ 3.583333 0.0001871
+ 3.588889 -0.0003112
+ 3.594444 -0.0003092
+ 3.600000 0.0001872
+ 3.605556 -0.0002756
+ 3.611111 -0.0002190
+ 3.616667 0.0001875
+ 3.622222 -0.0002322
+ 3.627778 -0.0001601
+ 3.633333 0.0001875
+ 3.638889 -0.0002045
+ 3.644444 -0.0001601
+ 3.650000 0.0001876
+ 3.655556 -0.0002085
+ 3.661111 -0.0001483
+ 3.666667 0.0001876
+ 3.672222 -0.0002164
+ 3.677778 -0.0001405
+ 3.683333 0.0001875
+ 3.688889 -0.0002202
+ 3.694444 -0.0001601
+ 3.700000 0.0001875
+ 3.705556 -0.0002321
+ 3.711111 -0.0001562
+ 3.716667 0.0001875
+ 3.722222 -0.0002400
+ 3.727778 -0.0001601
+ 3.733333 0.0001875
+ 3.738889 -0.0002400
+ 3.744444 -0.0001836
+ 3.750000 0.0001874
+ 3.755556 -0.0002557
+ 3.761111 -0.0001876
+ 3.766667 0.0001874
+ 3.772222 -0.0002597
+ 3.777778 -0.0001836
+ 3.783333 0.0001874
+ 3.788889 -0.0002479
+ 3.794444 -0.0001915
+ 3.800000 0.0001874
+ 3.805556 -0.0002596
+ 3.811111 -0.0001915
+ 3.816667 0.0001874
+ 3.822222 -0.0002518
+ 3.827778 -0.0001797
+ 3.833333 0.0001874
+ 3.838889 -0.0002361
+ 3.844444 -0.0001954
+ 3.850000 0.0001875
+ 3.855556 -0.0002322
+ 3.861111 -0.0001758
+ 3.866667 0.0001876
+ 3.872222 -0.0001851
+ 3.877778 -0.0001601
+ 3.883333 0.0001877
+ 3.888889 -0.0001732
+ 3.894444 -0.0001405
+ 3.900000 0.0001877
+ 3.905556 -0.0001888
+ 3.911111 -0.0001444
+ 3.916667 0.0001877
+ 3.922222 -0.0002282
+ 3.927778 -0.0001758
+ 3.933333 0.0001874
+ 3.938889 -0.0002557
+ 3.944444 -0.0001954
+ 3.950000 0.0001873
+ 3.955556 -0.0002793
+ 3.961111 -0.0001954
+ 3.966667 0.0001873
+ 3.972222 -0.0002754
+ 3.977778 -0.0001954
+ 3.983333 0.0001872
+ 3.988889 -0.0003581
+ 3.994444 -0.0003092
+ 4.000000 0.0001868
+ 4.005556 -0.0004402
+ 4.011111 0.0000756
+ 4.016667 0.0002513
+ 4.022222 -0.0004376
+ 4.027778 0.0000913
+ 4.033333 0.0001884
+ 4.038889 -0.0003657
+ 4.044444 -0.0002268
+ 4.050000 0.0001872
+ 4.055556 -0.0002951
+ 4.061111 -0.0002229
+ 4.066667 0.0001872
+ 4.072222 -0.0003148
+ 4.077778 -0.0002190
+ 4.083333 0.0001872
+ 4.088889 -0.0002912
+ 4.094444 -0.0002307
+ 4.100000 0.0001873
+ 4.105556 -0.0002990
+ 4.111111 -0.0002190
+ 4.116667 0.0001872
+ 4.122222 -0.0003069
+ 4.127778 -0.0002111
+ 4.133333 0.0001872
+ 4.138889 -0.0002833
+ 4.144444 -0.0002268
+ 4.150000 0.0001873
+ 4.155556 -0.0002991
+ 4.161111 -0.0002307
+ 4.166667 0.0001872
+ 4.172222 -0.0002992
+ 4.177778 -0.0002504
+ 4.183333 0.0001872
+ 4.188889 -0.0002952
+ 4.194444 -0.0002896
+ 4.200000 0.0001873
+ 4.205556 -0.0002954
+ 4.211111 -0.0003171
+ 4.216667 0.0001872
+ 4.222222 -0.0003113
+ 4.227778 -0.0003249
+ 4.233333 0.0001872
+ 4.238889 -0.0002915
+ 4.244444 -0.0003014
+ 4.250000 0.0001873
+ 4.255556 -0.0002598
+ 4.261111 -0.0002072
+ 4.266667 0.0001875
+ 4.272222 -0.0002243
+ 4.277778 -0.0001640
+ 4.283333 0.0001875
+ 4.288889 -0.0002164
+ 4.294444 -0.0001719
+ 4.300000 0.0001876
+ 4.305556 -0.0002125
+ 4.311111 -0.0001719
+ 4.316667 0.0001875
+ 4.322222 -0.0002400
+ 4.327778 -0.0001758
+ 4.333333 0.0001875
+ 4.338889 -0.0002243
+ 4.344444 -0.0002033
+ 4.350000 0.0001875
+ 4.355556 -0.0002400
+ 4.361111 -0.0001915
+ 4.366667 0.0001875
+ 4.372222 -0.0002597
+ 4.377778 -0.0001954
+ 4.383333 0.0001873
+ 4.388889 -0.0002597
+ 4.394444 -0.0002111
+ 4.400000 0.0001874
+ 4.405556 -0.0002597
+ 4.411111 -0.0002111
+ 4.416667 0.0001874
+ 4.422222 -0.0002676
+ 4.427778 -0.0001993
+ 4.433333 0.0001873
+ 4.438889 -0.0002558
+ 4.444444 -0.0002268
+ 4.450000 0.0001873
+ 4.455556 -0.0002754
+ 4.461111 -0.0002072
+ 4.466667 0.0001874
+ 4.472222 -0.0002598
+ 4.477778 -0.0002150
+ 4.483333 0.0001876
+ 4.488889 -0.0002126
+ 4.494444 -0.0001993
+ 4.500000 0.0001876
+ 4.505556 -0.0001891
+ 4.511111 -0.0001758
+ 4.516667 0.0001877
+ 4.522222 -0.0001930
+ 4.527778 -0.0001719
+ 4.533333 0.0001876
+ 4.538889 -0.0001812
+ 4.544444 -0.0002190
+ 4.550000 0.0001875
+ 4.555556 -0.0002637
+ 4.561111 -0.0002229
+ 4.566667 0.0001873
+ 4.572222 -0.0002873
+ 4.577778 -0.0002268
+ 4.583333 0.0001872
+ 4.588889 -0.0002873
+ 4.594444 -0.0002464
+ 4.600000 0.0001873
+ 4.605556 -0.0003031
+ 4.611111 -0.0002974
+ 4.616667 0.0001868
+ 4.622222 -0.0004442
+ 4.627778 -0.0000228
+ 4.633333 0.0002514
+ 4.638889 -0.0004304
+ 4.644444 -0.0001915
+ 4.650000 0.0001878
+ 4.655556 -0.0003974
+ 4.661111 -0.0002739
+ 4.666667 0.0001871
+ 4.672222 -0.0003267
+ 4.677778 -0.0002621
+ 4.683333 0.0001871
+ 4.688889 -0.0003188
+ 4.694444 -0.0002857
+ 4.700000 0.0001871
+ 4.705556 -0.0003306
+ 4.711111 -0.0002621
+ 4.716667 0.0001872
+ 4.722222 -0.0003227
+ 4.727778 -0.0002543
+ 4.733333 0.0001871
+ 4.738889 -0.0003345
+ 4.744444 -0.0002700
+ 4.750000 0.0001871
+ 4.755556 -0.0003463
+ 4.761111 -0.0002621
+ 4.766667 0.0001871
+ 4.772222 -0.0003345
+ 4.777778 -0.0002582
+ 4.783333 0.0001870
+ 4.788889 -0.0003267
+ 4.794444 -0.0002778
+ 4.800000 0.0001871
+ 4.805556 -0.0003385
+ 4.811111 -0.0003014
+ 4.816667 0.0001871
+ 4.822222 -0.0003388
+ 4.827778 -0.0003367
+ 4.833333 0.0001870
+ 4.838889 -0.0003545
+ 4.844444 -0.0003681
+ 4.850000 0.0001870
+ 4.855556 -0.0003624
+ 4.861111 -0.0003445
+ 4.866667 0.0001871
+ 4.872222 -0.0003111
+ 4.877778 -0.0002817
+ 4.883333 0.0001872
+ 4.888889 -0.0002520
+ 4.894444 -0.0002582
+ 4.900000 0.0001874
+ 4.905556 -0.0002637
+ 4.911111 -0.0002425
+ 4.916667 0.0001874
+ 4.922222 -0.0002638
+ 4.927778 -0.0002347
+ 4.933333 0.0001874
+ 4.938889 -0.0002598
+ 4.944444 -0.0002543
+ 4.950000 0.0001874
+ 4.955556 -0.0002677
+ 4.961111 -0.0002543
+ 4.966667 0.0001874
+ 4.972222 -0.0002717
+ 4.977778 -0.0002700
+ 4.983333 0.0001873
+ 4.988889 -0.0002835
+ 4.994444 -0.0002778
+ 5.000000 0.0001873
+ 5.005556 -0.0002875
+ 5.011111 -0.0002778
+ 5.016667 0.0001873
+ 5.022222 -0.0002914
+ 5.027778 -0.0002739
+ 5.033333 0.0001872
+ 5.038889 -0.0002874
+ 5.044444 -0.0002739
+ 5.050000 0.0001873
+ 5.055556 -0.0002875
+ 5.061111 -0.0002778
+ 5.066667 0.0001873
+ 5.072222 -0.0002954
+ 5.077778 -0.0002700
+ 5.083333 0.0001873
+ 5.088889 -0.0002757
+ 5.094444 -0.0002817
+ 5.100000 0.0001873
+ 5.105556 -0.0002600
+ 5.111111 -0.0002700
+ 5.116667 0.0001875
+ 5.122222 -0.0002207
+ 5.127778 -0.0002464
+ 5.133333 0.0001876
+ 5.138889 -0.0002088
+ 5.144444 -0.0002425
+ 5.150000 0.0001875
+ 5.155556 -0.0002128
+ 5.161111 -0.0002543
+ 5.166667 0.0001874
+ 5.172222 -0.0002875
+ 5.177778 -0.0002739
+ 5.183333 0.0001872
+ 5.188889 -0.0002914
+ 5.194444 -0.0002778
+ 5.200000 0.0001872
+ 5.205556 -0.0003149
+ 5.211111 -0.0002778
+ 5.216667 0.0001872
+ 5.222222 -0.0003110
+ 5.227778 -0.0002896
+ 5.233333 0.0001870
+ 5.238889 -0.0003937
+ 5.244444 -0.0002268
+ 5.250000 0.0002501
+ 5.255556 0.0001300
+ 5.261111 0.0003032
+ 5.266667 0.0001906
+ 5.272222 -0.0001780
+ 5.277778 -0.0002974
+ 5.283333 0.0001870
+ 5.288889 -0.0003306
+ 5.294444 -0.0002739
+ 5.300000 0.0001871
+ 5.305556 -0.0003267
+ 5.311111 -0.0002817
+ 5.316667 0.0001871
+ 5.322222 -0.0003424
+ 5.327778 -0.0002582
+ 5.333333 0.0001870
+ 5.338889 -0.0003424
+ 5.344444 -0.0002700
+ 5.350000 0.0001871
+ 5.355556 -0.0003463
+ 5.361111 -0.0002621
+ 5.366667 0.0001871
+ 5.372222 -0.0003424
+ 5.377778 -0.0002543
+ 5.383333 0.0001870
+ 5.388889 -0.0003385
+ 5.394444 -0.0002778
+ 5.400000 0.0001870
+ 5.405556 -0.0003463
+ 5.411111 -0.0002896
+ 5.416667 0.0001871
+ 5.422222 -0.0003504
+ 5.427778 -0.0002935
+ 5.433333 0.0001870
+ 5.438889 -0.0003426
+ 5.444444 -0.0003445
+ 5.450000 0.0001871
+ 5.455556 -0.0003702
+ 5.461111 -0.0003641
+ 5.466667 0.0001869
+ 5.472222 -0.0003938
+ 5.477778 -0.0003641
+ 5.483333 0.0001870
+ 5.488889 -0.0003386
+ 5.494444 -0.0002817
+ 5.500000 0.0001872
+ 5.505556 -0.0003030
+ 5.511111 -0.0002268
+ 5.516667 0.0001873
+ 5.522222 -0.0002755
+ 5.527778 -0.0001993
+ 5.533333 0.0001874
+ 5.538889 -0.0002558
+ 5.544444 -0.0002190
+ 5.550000 0.0001874
+ 5.555556 -0.0002715
+ 5.561111 -0.0002150
+ )
Vel1n elec_l1_n 0 PWL(
+ 0.000000 -0.0001873
+ 0.005556 0.0002948
+ 0.011111 0.0001483
+ 0.016667 -0.0001872
+ 0.022222 0.0003067
+ 0.027778 0.0001444
+ 0.033333 -0.0001872
+ 0.038889 0.0002869
+ 0.044444 0.0001562
+ 0.050000 -0.0001872
+ 0.055556 0.0003066
+ 0.061111 0.0001601
+ 0.066667 -0.0001872
+ 0.072222 0.0002988
+ 0.077778 0.0001640
+ 0.083333 -0.0001872
+ 0.088889 0.0002791
+ 0.094444 0.0001562
+ 0.100000 -0.0001873
+ 0.105556 0.0002949
+ 0.111111 0.0001601
+ 0.116667 -0.0001872
+ 0.122222 0.0003028
+ 0.127778 0.0001640
+ 0.133333 -0.0001872
+ 0.138889 0.0002949
+ 0.144444 0.0001836
+ 0.150000 -0.0001873
+ 0.155556 0.0002910
+ 0.161111 0.0001758
+ 0.166667 -0.0001873
+ 0.172222 0.0002910
+ 0.177778 0.0001679
+ 0.183333 -0.0001873
+ 0.188889 0.0002478
+ 0.194444 0.0001719
+ 0.200000 -0.0001875
+ 0.205556 0.0002124
+ 0.211111 0.0001444
+ 0.216667 -0.0001876
+ 0.222222 0.0002320
+ 0.227778 0.0001483
+ 0.233333 -0.0001874
+ 0.238889 0.0002242
+ 0.244444 0.0001758
+ 0.250000 -0.0001874
+ 0.255556 0.0002870
+ 0.261111 0.0001836
+ 0.266667 -0.0001872
+ 0.272222 0.0003107
+ 0.277778 0.0001797
+ 0.283333 -0.0001871
+ 0.288889 0.0003145
+ 0.294444 0.0001915
+ 0.300000 -0.0001871
+ 0.305556 0.0003342
+ 0.311111 0.0002425
+ 0.316667 -0.0001869
+ 0.322222 0.0004638
+ 0.327778 -0.0000089
+ 0.333333 -0.0002511
+ 0.338889 0.0004576
+ 0.344444 -0.0001541
+ 0.350000 -0.0001890
+ 0.355556 0.0003464
+ 0.361111 0.0002386
+ 0.366667 -0.0001869
+ 0.372222 0.0003540
+ 0.377778 0.0002190
+ 0.383333 -0.0001871
+ 0.388889 0.0003500
+ 0.394444 0.0002347
+ 0.400000 -0.0001870
+ 0.405556 0.0003618
+ 0.411111 0.0002150
+ 0.416667 -0.0001870
+ 0.422222 0.0003618
+ 0.427778 0.0001954
+ 0.433333 -0.0001870
+ 0.438889 0.0003461
+ 0.444444 0.0002111
+ 0.450000 -0.0001870
+ 0.455556 0.0003578
+ 0.461111 0.0002072
+ 0.466667 -0.0001870
+ 0.472222 0.0003618
+ 0.477778 0.0002111
+ 0.483333 -0.0001870
+ 0.488889 0.0003383
+ 0.494444 0.0002268
+ 0.500000 -0.0001871
+ 0.505556 0.0003383
+ 0.511111 0.0002190
+ 0.516667 -0.0001871
+ 0.522222 0.0003384
+ 0.527778 0.0002386
+ 0.533333 -0.0001869
+ 0.538889 0.0003699
+ 0.544444 0.0003014
+ 0.550000 -0.0001869
+ 0.555556 0.0004014
+ 0.561111 0.0003249
+ 0.566667 -0.0001869
+ 0.572222 0.0003976
+ 0.577778 0.0002896
+ 0.583333 -0.0001869
+ 0.588889 0.0003462
+ 0.594444 0.0002150
+ 0.600000 -0.0001872
+ 0.605556 0.0002910
+ 0.611111 0.0001640
+ 0.616667 -0.0001874
+ 0.622222 0.0002517
+ 0.627778 0.0001483
+ 0.633333 -0.0001873
+ 0.638889 0.0002595
+ 0.644444 0.0001679
+ 0.650000 -0.0001874
+ 0.655556 0.0002674
+ 0.661111 0.0001601
+ 0.666667 -0.0001874
+ 0.672222 0.0002714
+ 0.677778 0.0001601
+ 0.683333 -0.0001873
+ 0.688889 0.0002635
+ 0.694444 0.0001797
+ 0.700000 -0.0001873
+ 0.705556 0.0002910
+ 0.711111 0.0001797
+ 0.716667 -0.0001873
+ 0.722222 0.0002792
+ 0.727778 0.0001758
+ 0.733333 -0.0001873
+ 0.738889 0.0002753
+ 0.744444 0.0001915
+ 0.750000 -0.0001873
+ 0.755556 0.0002949
+ 0.761111 0.0001836
+ 0.766667 -0.0001873
+ 0.772222 0.0002949
+ 0.777778 0.0001640
+ 0.783333 -0.0001872
+ 0.788889 0.0002792
+ 0.794444 0.0001719
+ 0.800000 -0.0001873
+ 0.805556 0.0002988
+ 0.811111 0.0001719
+ 0.816667 -0.0001874
+ 0.822222 0.0002439
+ 0.827778 0.0001562
+ 0.833333 -0.0001875
+ 0.838889 0.0002084
+ 0.844444 0.0001483
+ 0.850000 -0.0001876
+ 0.855556 0.0002319
+ 0.861111 0.0001248
+ 0.866667 -0.0001876
+ 0.872222 0.0002163
+ 0.877778 0.0001326
+ 0.883333 -0.0001873
+ 0.888889 0.0002909
+ 0.894444 0.0001679
+ 0.900000 -0.0001872
+ 0.905556 0.0002989
+ 0.911111 0.0001679
+ 0.916667 -0.0001872
+ 0.922222 0.0003146
+ 0.927778 0.0001679
+ 0.933333 -0.0001871
+ 0.938889 0.0003106
+ 0.944444 0.0002386
+ 0.950000 -0.0001868
+ 0.955556 0.0004715
+ 0.961111 -0.0001031
+ 0.966667 -0.0002515
+ 0.972222 0.0003827
+ 0.977778 0.0000816
+ 0.983333 -0.0001877
+ 0.988889 0.0004010
+ 0.994444 0.0001954
+ 1.000000 -0.0001871
+ 1.005556 0.0003304
+ 1.011111 0.0002033
+ 1.016667 -0.0001871
+ 1.022222 0.0003422
+ 1.027778 0.0001915
+ 1.033333 -0.0001871
+ 1.038889 0.0003146
+ 1.044444 0.0001993
+ 1.050000 -0.0001871
+ 1.055556 0.0003264
+ 1.061111 0.0001915
+ 1.066667 -0.0001871
+ 1.072222 0.0003382
+ 1.077778 0.0001836
+ 1.083333 -0.0001871
+ 1.088889 0.0003342
+ 1.094444 0.0001993
+ 1.100000 -0.0001871
+ 1.105556 0.0003303
+ 1.111111 0.0001876
+ 1.116667 -0.0001872
+ 1.122222 0.0003382
+ 1.127778 0.0002072
+ 1.133333 -0.0001871
+ 1.138889 0.0003265
+ 1.144444 0.0002464
+ 1.150000 -0.0001871
+ 1.155556 0.0003424
+ 1.161111 0.0002817
+ 1.166667 -0.0001871
+ 1.172222 0.0003464
+ 1.177778 0.0002935
+ 1.183333 -0.0001870
+ 1.188889 0.0003306
+ 1.194444 0.0002386
+ 1.200000 -0.0001872
+ 1.205556 0.0002871
+ 1.211111 0.0001562
+ 1.216667 -0.0001874
+ 1.222222 0.0002517
+ 1.227778 0.0001483
+ 1.233333 -0.0001874
+ 1.238889 0.0002241
+ 1.244444 0.0001444
+ 1.250000 -0.0001875
+ 1.255556 0.0002438
+ 1.261111 0.0001326
+ 1.266667 -0.0001875
+ 1.272222 0.0002438
+ 1.277778 0.0001366
+ 1.283333 -0.0001874
+ 1.288889 0.0002516
+ 1.294444 0.0001601
+ 1.300000 -0.0001874
+ 1.305556 0.0002635
+ 1.311111 0.0001601
+ 1.316667 -0.0001874
+ 1.322222 0.0002714
+ 1.327778 0.0001640
+ 1.333333 -0.0001873
+ 1.338889 0.0002595
+ 1.344444 0.0001758
+ 1.350000 -0.0001873
+ 1.355556 0.0002870
+ 1.361111 0.0001679
+ 1.366667 -0.0001873
+ 1.372222 0.0002753
+ 1.377778 0.0001601
+ 1.383333 -0.0001873
+ 1.388889 0.0002595
+ 1.394444 0.0001679
+ 1.400000 -0.0001874
+ 1.405556 0.0002635
+ 1.411111 0.0001562
+ 1.416667 -0.0001874
+ 1.422222 0.0002714
+ 1.427778 0.0001483
+ 1.433333 -0.0001874
+ 1.438889 0.0002085
+ 1.444444 0.0001562
+ 1.450000 -0.0001877
+ 1.455556 0.0001810
+ 1.461111 0.0001248
+ 1.466667 -0.0001876
+ 1.472222 0.0002005
+ 1.477778 0.0001012
+ 1.483333 -0.0001877
+ 1.488889 0.0002045
+ 1.494444 0.0001405
+ 1.500000 -0.0001874
+ 1.505556 0.0002713
+ 1.511111 0.0001483
+ 1.516667 -0.0001873
+ 1.522222 0.0002870
+ 1.527778 0.0001562
+ 1.533333 -0.0001872
+ 1.538889 0.0002752
+ 1.544444 0.0001719
+ 1.550000 -0.0001873
+ 1.555556 0.0003658
+ 1.561111 0.0002543
+ 1.566667 -0.0002496
+ 1.572222 0.0000698
+ 1.577778 0.0004934
+ 1.583333 -0.0002540
+ 1.588889 -0.0000031
+ 1.594444 0.0001836
+ 1.600000 -0.0001872
+ 1.605556 0.0003107
+ 1.611111 0.0001915
+ 1.616667 -0.0001872
+ 1.622222 0.0003147
+ 1.627778 0.0001915
+ 1.633333 -0.0001871
+ 1.638889 0.0003146
+ 1.644444 0.0001993
+ 1.650000 -0.0001872
+ 1.655556 0.0003225
+ 1.661111 0.0001876
+ 1.666667 -0.0001872
+ 1.672222 0.0003146
+ 1.677778 0.0001719
+ 1.683333 -0.0001871
+ 1.688889 0.0003028
+ 1.694444 0.0002033
+ 1.700000 -0.0001872
+ 1.705556 0.0003029
+ 1.711111 0.0001954
+ 1.716667 -0.0001872
+ 1.722222 0.0003029
+ 1.727778 0.0002111
+ 1.733333 -0.0001872
+ 1.738889 0.0003109
+ 1.744444 0.0002543
+ 1.750000 -0.0001872
+ 1.755556 0.0003071
+ 1.761111 0.0002817
+ 1.766667 -0.0001872
+ 1.772222 0.0003150
+ 1.777778 0.0002817
+ 1.783333 -0.0001872
+ 1.788889 0.0002992
+ 1.794444 0.0002386
+ 1.800000 -0.0001873
+ 1.805556 0.0002715
+ 1.811111 0.0001836
+ 1.816667 -0.0001874
+ 1.822222 0.0002360
+ 1.827778 0.0001366
+ 1.833333 -0.0001875
+ 1.838889 0.0002084
+ 1.844444 0.0001483
+ 1.850000 -0.0001875
+ 1.855556 0.0002242
+ 1.861111 0.0001366
+ 1.866667 -0.0001875
+ 1.872222 0.0002360
+ 1.877778 0.0001405
+ 1.883333 -0.0001874
+ 1.888889 0.0002241
+ 1.894444 0.0001562
+ 1.900000 -0.0001875
+ 1.905556 0.0002399
+ 1.911111 0.0001601
+ 1.916667 -0.0001875
+ 1.922222 0.0002595
+ 1.927778 0.0001523
+ 1.933333 -0.0001873
+ 1.938889 0.0002595
+ 1.944444 0.0001640
+ 1.950000 -0.0001874
+ 1.955556 0.0002556
+ 1.961111 0.0001640
+ 1.966667 -0.0001874
+ 1.972222 0.0002635
+ 1.977778 0.0001483
+ 1.983333 -0.0001874
+ 1.988889 0.0002398
+ 1.994444 0.0001562
+ 2.000000 -0.0001874
+ 2.005556 0.0002595
+ 2.011111 0.0001444
+ 2.016667 -0.0001874
+ 2.022222 0.0002399
+ 2.027778 0.0001444
+ 2.033333 -0.0001876
+ 2.038889 0.0001809
+ 2.044444 0.0001287
+ 2.050000 -0.0001878
+ 2.055556 0.0001730
+ 2.061111 0.0000895
+ 2.066667 -0.0001877
+ 2.072222 0.0001769
+ 2.077778 0.0001169
+ 2.083333 -0.0001876
+ 2.088889 0.0002280
+ 2.094444 0.0001366
+ 2.100000 -0.0001874
+ 2.105556 0.0002477
+ 2.111111 0.0001366
+ 2.116667 -0.0001874
+ 2.122222 0.0002673
+ 2.127778 0.0001405
+ 2.133333 -0.0001873
+ 2.138889 0.0002594
+ 2.144444 0.0001915
+ 2.150000 -0.0001870
+ 2.155556 0.0004129
+ 2.161111 -0.0000167
+ 2.166667 -0.0002509
+ 2.172222 -0.0005000
+ 2.177778 -0.0000991
+ 2.183333 -0.0001885
+ 2.188889 0.0003733
+ 2.194444 0.0001601
+ 2.200000 -0.0001873
+ 2.205556 0.0002870
+ 2.211111 0.0001601
+ 2.216667 -0.0001873
+ 2.222222 0.0002832
+ 2.227778 0.0001601
+ 2.233333 -0.0001872
+ 2.238889 0.0002870
+ 2.244444 0.0001836
+ 2.250000 -0.0001873
+ 2.255556 0.0002870
+ 2.261111 0.0001640
+ 2.266667 -0.0001873
+ 2.272222 0.0002831
+ 2.277778 0.0001679
+ 2.283333 -0.0001872
+ 2.288889 0.0002831
+ 2.294444 0.0001836
+ 2.300000 -0.0001873
+ 2.305556 0.0002832
+ 2.311111 0.0001758
+ 2.316667 -0.0001873
+ 2.322222 0.0002912
+ 2.327778 0.0001954
+ 2.333333 -0.0001872
+ 2.338889 0.0002715
+ 2.344444 0.0002464
+ 2.350000 -0.0001873
+ 2.355556 0.0002992
+ 2.361111 0.0002582
+ 2.366667 -0.0001873
+ 2.372222 0.0003032
+ 2.377778 0.0002504
+ 2.383333 -0.0001872
+ 2.388889 0.0002715
+ 2.394444 0.0001954
+ 2.400000 -0.0001874
+ 2.405556 0.0002399
+ 2.411111 0.0001483
+ 2.416667 -0.0001876
+ 2.422222 0.0002124
+ 2.427778 0.0001366
+ 2.433333 -0.0001875
+ 2.438889 0.0002006
+ 2.444444 0.0001640
+ 2.450000 -0.0001875
+ 2.455556 0.0002321
+ 2.461111 0.0001601
+ 2.466667 -0.0001875
+ 2.472222 0.0002322
+ 2.477778 0.0001562
+ 2.483333 -0.0001875
+ 2.488889 0.0002282
+ 2.494444 0.0001797
+ 2.500000 -0.0001874
+ 2.505556 0.0002636
+ 2.511111 0.0001797
+ 2.516667 -0.0001874
+ 2.522222 0.0002557
+ 2.527778 0.0001758
+ 2.533333 -0.0001874
+ 2.538889 0.0002596
+ 2.544444 0.0001954
+ 2.550000 -0.0001874
+ 2.555556 0.0002479
+ 2.561111 0.0001836
+ 2.566667 -0.0001874
+ 2.572222 0.0002557
+ 2.577778 0.0001876
+ 2.583333 -0.0001874
+ 2.588889 0.0002557
+ 2.594444 0.0002111
+ 2.600000 -0.0001875
+ 2.605556 0.0002165
+ 2.611111 0.0001797
+ 2.616667 -0.0001877
+ 2.622222 0.0001850
+ 2.627778 0.0001640
+ 2.633333 -0.0001876
+ 2.638889 0.0001889
+ 2.644444 0.0001719
+ 2.650000 -0.0001876
+ 2.655556 0.0002046
+ 2.661111 0.0001797
+ 2.666667 -0.0001874
+ 2.672222 0.0002794
+ 2.677778 0.0001876
+ 2.683333 -0.0001873
+ 2.688889 0.0002675
+ 2.694444 0.0002033
+ 2.700000 -0.0001873
+ 2.705556 0.0002990
+ 2.711111 0.0002111
+ 2.716667 -0.0001873
+ 2.722222 0.0003109
+ 2.727778 0.0002778
+ 2.733333 -0.0001868
+ 2.738889 0.0003180
+ 2.744444 -0.0000913
+ 2.750000 -0.0002530
+ 2.755556 0.0004513
+ 2.761111 0.0003210
+ 2.766667 -0.0001869
+ 2.772222 0.0003227
+ 2.777778 0.0002229
+ 2.783333 -0.0001872
+ 2.788889 0.0003148
+ 2.794444 0.0002386
+ 2.800000 -0.0001872
+ 2.805556 0.0003108
+ 2.811111 0.0002268
+ 2.816667 -0.0001872
+ 2.822222 0.0003188
+ 2.827778 0.0002386
+ 2.833333 -0.0001871
+ 2.838889 0.0003226
+ 2.844444 0.0002504
+ 2.850000 -0.0001872
+ 2.855556 0.0003226
+ 2.861111 0.0002425
+ 2.866667 -0.0001871
+ 2.872222 0.0003226
+ 2.877778 0.0002347
+ 2.883333 -0.0001871
+ 2.888889 0.0003187
+ 2.894444 0.0002543
+ 2.900000 -0.0001872
+ 2.905556 0.0003148
+ 2.911111 0.0002582
+ 2.916667 -0.0001872
+ 2.922222 0.0003268
+ 2.927778 0.0002896
+ 2.933333 -0.0001870
+ 2.938889 0.0003426
+ 2.944444 0.0003445
+ 2.950000 -0.0001870
+ 2.955556 0.0003662
+ 2.961111 0.0003328
+ 2.966667 -0.0001870
+ 2.972222 0.0003386
+ 2.977778 0.0002621
+ 2.983333 -0.0001872
+ 2.988889 0.0002754
+ 2.994444 0.0002072
+ 3.000000 -0.0001874
+ 3.005556 0.0002400
+ 3.011111 0.0001836
+ 3.016667 -0.0001875
+ 3.022222 0.0002401
+ 3.027778 0.0001679
+ 3.033333 -0.0001875
+ 3.038889 0.0002282
+ 3.044444 0.0001836
+ 3.050000 -0.0001874
+ 3.055556 0.0002518
+ 3.061111 0.0001719
+ 3.066667 -0.0001874
+ 3.072222 0.0002557
+ 3.077778 0.0001797
+ 3.083333 -0.0001874
+ 3.088889 0.0002439
+ 3.094444 0.0001954
+ 3.100000 -0.0001874
+ 3.105556 0.0002597
+ 3.111111 0.0001954
+ 3.116667 -0.0001874
+ 3.122222 0.0002714
+ 3.127778 0.0001915
+ 3.133333 -0.0001873
+ 3.138889 0.0002518
+ 3.144444 0.0001954
+ 3.150000 -0.0001874
+ 3.155556 0.0002597
+ 3.161111 0.0001954
+ 3.166667 -0.0001874
+ 3.172222 0.0002675
+ 3.177778 0.0001836
+ 3.183333 -0.0001874
+ 3.188889 0.0002518
+ 3.194444 0.0001954
+ 3.200000 -0.0001874
+ 3.205556 0.0002518
+ 3.211111 0.0001915
+ 3.216667 -0.0001875
+ 3.222222 0.0002165
+ 3.227778 0.0001758
+ 3.233333 -0.0001876
+ 3.238889 0.0001732
+ 3.244444 0.0001562
+ 3.250000 -0.0001877
+ 3.255556 0.0001850
+ 3.261111 0.0001483
+ 3.266667 -0.0001877
+ 3.272222 0.0001968
+ 3.277778 0.0001562
+ 3.283333 -0.0001876
+ 3.288889 0.0002360
+ 3.294444 0.0001836
+ 3.300000 -0.0001874
+ 3.305556 0.0002675
+ 3.311111 0.0001915
+ 3.316667 -0.0001874
+ 3.322222 0.0002715
+ 3.327778 0.0001836
+ 3.333333 -0.0001872
+ 3.338889 0.0002674
+ 3.344444 0.0001915
+ 3.350000 -0.0001873
+ 3.355556 0.0003463
+ 3.361111 0.0002896
+ 3.366667 -0.0001868
+ 3.372222 0.0001446
+ 3.377778 -0.0004131
+ 3.383333 -0.0002538
+ 3.388889 -0.0004000
+ 3.394444 0.0002229
+ 3.400000 -0.0001871
+ 3.405556 0.0002990
+ 3.411111 0.0002111
+ 3.416667 -0.0001872
+ 3.422222 0.0003108
+ 3.427778 0.0002072
+ 3.433333 -0.0001872
+ 3.438889 0.0002990
+ 3.444444 0.0002229
+ 3.450000 -0.0001872
+ 3.455556 0.0002912
+ 3.461111 0.0002072
+ 3.466667 -0.0001873
+ 3.472222 0.0002951
+ 3.477778 0.0002072
+ 3.483333 -0.0001872
+ 3.488889 0.0002911
+ 3.494444 0.0002229
+ 3.500000 -0.0001872
+ 3.505556 0.0002872
+ 3.511111 0.0002150
+ 3.516667 -0.0001873
+ 3.522222 0.0002991
+ 3.527778 0.0002229
+ 3.533333 -0.0001872
+ 3.538889 0.0002873
+ 3.544444 0.0002582
+ 3.550000 -0.0001873
+ 3.555556 0.0002914
+ 3.561111 0.0002935
+ 3.566667 -0.0001872
+ 3.572222 0.0003151
+ 3.577778 0.0003092
+ 3.583333 -0.0001871
+ 3.588889 0.0003112
+ 3.594444 0.0003092
+ 3.600000 -0.0001872
+ 3.605556 0.0002756
+ 3.611111 0.0002190
+ 3.616667 -0.0001875
+ 3.622222 0.0002322
+ 3.627778 0.0001601
+ 3.633333 -0.0001875
+ 3.638889 0.0002045
+ 3.644444 0.0001601
+ 3.650000 -0.0001876
+ 3.655556 0.0002085
+ 3.661111 0.0001483
+ 3.666667 -0.0001876
+ 3.672222 0.0002164
+ 3.677778 0.0001405
+ 3.683333 -0.0001875
+ 3.688889 0.0002202
+ 3.694444 0.0001601
+ 3.700000 -0.0001875
+ 3.705556 0.0002321
+ 3.711111 0.0001562
+ 3.716667 -0.0001875
+ 3.722222 0.0002400
+ 3.727778 0.0001601
+ 3.733333 -0.0001875
+ 3.738889 0.0002400
+ 3.744444 0.0001836
+ 3.750000 -0.0001874
+ 3.755556 0.0002557
+ 3.761111 0.0001876
+ 3.766667 -0.0001874
+ 3.772222 0.0002597
+ 3.777778 0.0001836
+ 3.783333 -0.0001874
+ 3.788889 0.0002479
+ 3.794444 0.0001915
+ 3.800000 -0.0001874
+ 3.805556 0.0002596
+ 3.811111 0.0001915
+ 3.816667 -0.0001874
+ 3.822222 0.0002518
+ 3.827778 0.0001797
+ 3.833333 -0.0001874
+ 3.838889 0.0002361
+ 3.844444 0.0001954
+ 3.850000 -0.0001875
+ 3.855556 0.0002322
+ 3.861111 0.0001758
+ 3.866667 -0.0001876
+ 3.872222 0.0001851
+ 3.877778 0.0001601
+ 3.883333 -0.0001877
+ 3.888889 0.0001732
+ 3.894444 0.0001405
+ 3.900000 -0.0001877
+ 3.905556 0.0001888
+ 3.911111 0.0001444
+ 3.916667 -0.0001877
+ 3.922222 0.0002282
+ 3.927778 0.0001758
+ 3.933333 -0.0001874
+ 3.938889 0.0002557
+ 3.944444 0.0001954
+ 3.950000 -0.0001873
+ 3.955556 0.0002793
+ 3.961111 0.0001954
+ 3.966667 -0.0001873
+ 3.972222 0.0002754
+ 3.977778 0.0001954
+ 3.983333 -0.0001872
+ 3.988889 0.0003581
+ 3.994444 0.0003092
+ 4.000000 -0.0001868
+ 4.005556 0.0004402
+ 4.011111 -0.0000756
+ 4.016667 -0.0002513
+ 4.022222 0.0004376
+ 4.027778 -0.0000913
+ 4.033333 -0.0001884
+ 4.038889 0.0003657
+ 4.044444 0.0002268
+ 4.050000 -0.0001872
+ 4.055556 0.0002951
+ 4.061111 0.0002229
+ 4.066667 -0.0001872
+ 4.072222 0.0003148
+ 4.077778 0.0002190
+ 4.083333 -0.0001872
+ 4.088889 0.0002912
+ 4.094444 0.0002307
+ 4.100000 -0.0001873
+ 4.105556 0.0002990
+ 4.111111 0.0002190
+ 4.116667 -0.0001872
+ 4.122222 0.0003069
+ 4.127778 0.0002111
+ 4.133333 -0.0001872
+ 4.138889 0.0002833
+ 4.144444 0.0002268
+ 4.150000 -0.0001873
+ 4.155556 0.0002991
+ 4.161111 0.0002307
+ 4.166667 -0.0001872
+ 4.172222 0.0002992
+ 4.177778 0.0002504
+ 4.183333 -0.0001872
+ 4.188889 0.0002952
+ 4.194444 0.0002896
+ 4.200000 -0.0001873
+ 4.205556 0.0002954
+ 4.211111 0.0003171
+ 4.216667 -0.0001872
+ 4.222222 0.0003113
+ 4.227778 0.0003249
+ 4.233333 -0.0001872
+ 4.238889 0.0002915
+ 4.244444 0.0003014
+ 4.250000 -0.0001873
+ 4.255556 0.0002598
+ 4.261111 0.0002072
+ 4.266667 -0.0001875
+ 4.272222 0.0002243
+ 4.277778 0.0001640
+ 4.283333 -0.0001875
+ 4.288889 0.0002164
+ 4.294444 0.0001719
+ 4.300000 -0.0001876
+ 4.305556 0.0002125
+ 4.311111 0.0001719
+ 4.316667 -0.0001875
+ 4.322222 0.0002400
+ 4.327778 0.0001758
+ 4.333333 -0.0001875
+ 4.338889 0.0002243
+ 4.344444 0.0002033
+ 4.350000 -0.0001875
+ 4.355556 0.0002400
+ 4.361111 0.0001915
+ 4.366667 -0.0001875
+ 4.372222 0.0002597
+ 4.377778 0.0001954
+ 4.383333 -0.0001873
+ 4.388889 0.0002597
+ 4.394444 0.0002111
+ 4.400000 -0.0001874
+ 4.405556 0.0002597
+ 4.411111 0.0002111
+ 4.416667 -0.0001874
+ 4.422222 0.0002676
+ 4.427778 0.0001993
+ 4.433333 -0.0001873
+ 4.438889 0.0002558
+ 4.444444 0.0002268
+ 4.450000 -0.0001873
+ 4.455556 0.0002754
+ 4.461111 0.0002072
+ 4.466667 -0.0001874
+ 4.472222 0.0002598
+ 4.477778 0.0002150
+ 4.483333 -0.0001876
+ 4.488889 0.0002126
+ 4.494444 0.0001993
+ 4.500000 -0.0001876
+ 4.505556 0.0001891
+ 4.511111 0.0001758
+ 4.516667 -0.0001877
+ 4.522222 0.0001930
+ 4.527778 0.0001719
+ 4.533333 -0.0001876
+ 4.538889 0.0001812
+ 4.544444 0.0002190
+ 4.550000 -0.0001875
+ 4.555556 0.0002637
+ 4.561111 0.0002229
+ 4.566667 -0.0001873
+ 4.572222 0.0002873
+ 4.577778 0.0002268
+ 4.583333 -0.0001872
+ 4.588889 0.0002873
+ 4.594444 0.0002464
+ 4.600000 -0.0001873
+ 4.605556 0.0003031
+ 4.611111 0.0002974
+ 4.616667 -0.0001868
+ 4.622222 0.0004442
+ 4.627778 0.0000228
+ 4.633333 -0.0002514
+ 4.638889 0.0004304
+ 4.644444 0.0001915
+ 4.650000 -0.0001878
+ 4.655556 0.0003974
+ 4.661111 0.0002739
+ 4.666667 -0.0001871
+ 4.672222 0.0003267
+ 4.677778 0.0002621
+ 4.683333 -0.0001871
+ 4.688889 0.0003188
+ 4.694444 0.0002857
+ 4.700000 -0.0001871
+ 4.705556 0.0003306
+ 4.711111 0.0002621
+ 4.716667 -0.0001872
+ 4.722222 0.0003227
+ 4.727778 0.0002543
+ 4.733333 -0.0001871
+ 4.738889 0.0003345
+ 4.744444 0.0002700
+ 4.750000 -0.0001871
+ 4.755556 0.0003463
+ 4.761111 0.0002621
+ 4.766667 -0.0001871
+ 4.772222 0.0003345
+ 4.777778 0.0002582
+ 4.783333 -0.0001870
+ 4.788889 0.0003267
+ 4.794444 0.0002778
+ 4.800000 -0.0001871
+ 4.805556 0.0003385
+ 4.811111 0.0003014
+ 4.816667 -0.0001871
+ 4.822222 0.0003388
+ 4.827778 0.0003367
+ 4.833333 -0.0001870
+ 4.838889 0.0003545
+ 4.844444 0.0003681
+ 4.850000 -0.0001870
+ 4.855556 0.0003624
+ 4.861111 0.0003445
+ 4.866667 -0.0001871
+ 4.872222 0.0003111
+ 4.877778 0.0002817
+ 4.883333 -0.0001872
+ 4.888889 0.0002520
+ 4.894444 0.0002582
+ 4.900000 -0.0001874
+ 4.905556 0.0002637
+ 4.911111 0.0002425
+ 4.916667 -0.0001874
+ 4.922222 0.0002638
+ 4.927778 0.0002347
+ 4.933333 -0.0001874
+ 4.938889 0.0002598
+ 4.944444 0.0002543
+ 4.950000 -0.0001874
+ 4.955556 0.0002677
+ 4.961111 0.0002543
+ 4.966667 -0.0001874
+ 4.972222 0.0002717
+ 4.977778 0.0002700
+ 4.983333 -0.0001873
+ 4.988889 0.0002835
+ 4.994444 0.0002778
+ 5.000000 -0.0001873
+ 5.005556 0.0002875
+ 5.011111 0.0002778
+ 5.016667 -0.0001873
+ 5.022222 0.0002914
+ 5.027778 0.0002739
+ 5.033333 -0.0001872
+ 5.038889 0.0002874
+ 5.044444 0.0002739
+ 5.050000 -0.0001873
+ 5.055556 0.0002875
+ 5.061111 0.0002778
+ 5.066667 -0.0001873
+ 5.072222 0.0002954
+ 5.077778 0.0002700
+ 5.083333 -0.0001873
+ 5.088889 0.0002757
+ 5.094444 0.0002817
+ 5.100000 -0.0001873
+ 5.105556 0.0002600
+ 5.111111 0.0002700
+ 5.116667 -0.0001875
+ 5.122222 0.0002207
+ 5.127778 0.0002464
+ 5.133333 -0.0001876
+ 5.138889 0.0002088
+ 5.144444 0.0002425
+ 5.150000 -0.0001875
+ 5.155556 0.0002128
+ 5.161111 0.0002543
+ 5.166667 -0.0001874
+ 5.172222 0.0002875
+ 5.177778 0.0002739
+ 5.183333 -0.0001872
+ 5.188889 0.0002914
+ 5.194444 0.0002778
+ 5.200000 -0.0001872
+ 5.205556 0.0003149
+ 5.211111 0.0002778
+ 5.216667 -0.0001872
+ 5.222222 0.0003110
+ 5.227778 0.0002896
+ 5.233333 -0.0001870
+ 5.238889 0.0003937
+ 5.244444 0.0002268
+ 5.250000 -0.0002501
+ 5.255556 -0.0001300
+ 5.261111 -0.0003032
+ 5.266667 -0.0001906
+ 5.272222 0.0001780
+ 5.277778 0.0002974
+ 5.283333 -0.0001870
+ 5.288889 0.0003306
+ 5.294444 0.0002739
+ 5.300000 -0.0001871
+ 5.305556 0.0003267
+ 5.311111 0.0002817
+ 5.316667 -0.0001871
+ 5.322222 0.0003424
+ 5.327778 0.0002582
+ 5.333333 -0.0001870
+ 5.338889 0.0003424
+ 5.344444 0.0002700
+ 5.350000 -0.0001871
+ 5.355556 0.0003463
+ 5.361111 0.0002621
+ 5.366667 -0.0001871
+ 5.372222 0.0003424
+ 5.377778 0.0002543
+ 5.383333 -0.0001870
+ 5.388889 0.0003385
+ 5.394444 0.0002778
+ 5.400000 -0.0001870
+ 5.405556 0.0003463
+ 5.411111 0.0002896
+ 5.416667 -0.0001871
+ 5.422222 0.0003504
+ 5.427778 0.0002935
+ 5.433333 -0.0001870
+ 5.438889 0.0003426
+ 5.444444 0.0003445
+ 5.450000 -0.0001871
+ 5.455556 0.0003702
+ 5.461111 0.0003641
+ 5.466667 -0.0001869
+ 5.472222 0.0003938
+ 5.477778 0.0003641
+ 5.483333 -0.0001870
+ 5.488889 0.0003386
+ 5.494444 0.0002817
+ 5.500000 -0.0001872
+ 5.505556 0.0003030
+ 5.511111 0.0002268
+ 5.516667 -0.0001873
+ 5.522222 0.0002755
+ 5.527778 0.0001993
+ 5.533333 -0.0001874
+ 5.538889 0.0002558
+ 5.544444 0.0002190
+ 5.550000 -0.0001874
+ 5.555556 0.0002715
+ 5.561111 0.0002150
+ )

Vthresh rpeak_threshold 0 0.33
Vth14 vth_14 0 0.4757
Vth69 vth_69 0 0.4471
Vth83 vth_83 0 0.4684
Vth300 vth_300 0 0.3269
Vth10 vth_10 0 0.2282
Vthpb vth_pw_base 0 0.157
Vthpp vth_pw_peak 0 0.118

Xfe elec_l0_p elec_l0_n elec_l1_p elec_l1_n rpeak_threshold vth_14 vth_69 vth_83 vth_300 vth_10 vth_pw_base vth_pw_peak f1_rr_ratio f2_rr_asym f3_bi_l0 f4_bi_l1 f5_pwave f6_width f7_slope f8_symmetry vdd vss asic_frontend

* Bias generator startup
.ic v(xfe.xbias_gen.vbias) = 0.3
.ic v(xfe.xbias_gen.vref) = 0.3

* IA Lead 0: set internal nodes to VREF so OTA is at operating point
.ic v(xfe.xia_l0.ni_p) = 0.3
.ic v(xfe.xia_l0.ni_n) = 0.3
.ic v(xfe.ecg_amp_l0) = 0.3

* IA Lead 1: same
.ic v(xfe.xia_l1.ni_p) = 0.3
.ic v(xfe.xia_l1.ni_n) = 0.3
.ic v(xfe.ecg_amp_l1) = 0.3

* Timer caps precharged
.ic v(xfe.xrr.net_timer) = 0.9
.ic v(xfe.xdelay.timer_node) = 0.9
.ic v(xfe.xdelay.timer2) = 0.9

* EWMA initial
.ic v(xfe.xrr.ewma_node) = 0.15
.ic v(xfe.xrr.prev_node) = 0.15

.tran 0.5m 5.564 uic

.meas tran f1_rr_ratio_b1 FIND V(f1_rr_ratio) AT=0.842778
.meas tran f2_rr_asym_b1 FIND V(f2_rr_asym) AT=0.842778
.meas tran f3_bi_l0_b1 FIND V(f3_bi_l0) AT=0.842778
.meas tran f4_bi_l1_b1 FIND V(f4_bi_l1) AT=0.842778
.meas tran f5_pwave_b1 FIND V(f5_pwave) AT=0.842778
.meas tran f6_width_b1 FIND V(f6_width) AT=0.842778
.meas tran f7_slope_b1 FIND V(f7_slope) AT=0.842778
.meas tran f8_symmetry_b1 FIND V(f8_symmetry) AT=0.842778
.meas tran ecg_amp_b1 FIND V(xfe.ecg_amp_l0) AT=0.852778
.meas tran rpeak_b1 FIND V(xfe.rpeak_pulse) AT=0.852778
.meas tran f1_rr_ratio_b2 FIND V(f1_rr_ratio) AT=1.837222
.meas tran f2_rr_asym_b2 FIND V(f2_rr_asym) AT=1.837222
.meas tran f3_bi_l0_b2 FIND V(f3_bi_l0) AT=1.837222
.meas tran f4_bi_l1_b2 FIND V(f4_bi_l1) AT=1.837222
.meas tran f5_pwave_b2 FIND V(f5_pwave) AT=1.837222
.meas tran f6_width_b2 FIND V(f6_width) AT=1.837222
.meas tran f7_slope_b2 FIND V(f7_slope) AT=1.837222
.meas tran f8_symmetry_b2 FIND V(f8_symmetry) AT=1.837222
.meas tran ecg_amp_b2 FIND V(xfe.ecg_amp_l0) AT=1.847222
.meas tran rpeak_b2 FIND V(xfe.rpeak_pulse) AT=1.847222
.meas tran f1_rr_ratio_b3 FIND V(f1_rr_ratio) AT=2.681667
.meas tran f2_rr_asym_b3 FIND V(f2_rr_asym) AT=2.681667
.meas tran f3_bi_l0_b3 FIND V(f3_bi_l0) AT=2.681667
.meas tran f4_bi_l1_b3 FIND V(f4_bi_l1) AT=2.681667
.meas tran f5_pwave_b3 FIND V(f5_pwave) AT=2.681667
.meas tran f6_width_b3 FIND V(f6_width) AT=2.681667
.meas tran f7_slope_b3 FIND V(f7_slope) AT=2.681667
.meas tran f8_symmetry_b3 FIND V(f8_symmetry) AT=2.681667
.meas tran ecg_amp_b3 FIND V(xfe.ecg_amp_l0) AT=2.691667
.meas tran rpeak_b3 FIND V(xfe.rpeak_pulse) AT=2.691667
.meas tran f1_rr_ratio_b4 FIND V(f1_rr_ratio) AT=3.492778
.meas tran f2_rr_asym_b4 FIND V(f2_rr_asym) AT=3.492778
.meas tran f3_bi_l0_b4 FIND V(f3_bi_l0) AT=3.492778
.meas tran f4_bi_l1_b4 FIND V(f4_bi_l1) AT=3.492778
.meas tran f5_pwave_b4 FIND V(f5_pwave) AT=3.492778
.meas tran f6_width_b4 FIND V(f6_width) AT=3.492778
.meas tran f7_slope_b4 FIND V(f7_slope) AT=3.492778
.meas tran f8_symmetry_b4 FIND V(f8_symmetry) AT=3.492778
.meas tran ecg_amp_b4 FIND V(xfe.ecg_amp_l0) AT=3.502778
.meas tran rpeak_b4 FIND V(xfe.rpeak_pulse) AT=3.502778
.meas tran f1_rr_ratio_b5 FIND V(f1_rr_ratio) AT=4.281667
.meas tran f2_rr_asym_b5 FIND V(f2_rr_asym) AT=4.281667
.meas tran f3_bi_l0_b5 FIND V(f3_bi_l0) AT=4.281667
.meas tran f4_bi_l1_b5 FIND V(f4_bi_l1) AT=4.281667
.meas tran f5_pwave_b5 FIND V(f5_pwave) AT=4.281667
.meas tran f6_width_b5 FIND V(f6_width) AT=4.281667
.meas tran f7_slope_b5 FIND V(f7_slope) AT=4.281667
.meas tran f8_symmetry_b5 FIND V(f8_symmetry) AT=4.281667
.meas tran ecg_amp_b5 FIND V(xfe.ecg_amp_l0) AT=4.291667
.meas tran rpeak_b5 FIND V(xfe.rpeak_pulse) AT=4.291667
.meas tran trig_s14_b2 FIND V(xfe.trig_s14) AT=1.861222
.meas tran trig_wid_b2 FIND V(xfe.trig_wid) AT=1.875222
.meas tran trig_s69_b2 FIND V(xfe.trig_s69) AT=1.916222
.meas tran trig_s14_b3 FIND V(xfe.trig_s14) AT=2.705667
.meas tran trig_wid_b3 FIND V(xfe.trig_wid) AT=2.719667
.meas tran trig_s69_b3 FIND V(xfe.trig_s69) AT=2.760667
.meas tran trig_s14_b4 FIND V(xfe.trig_s14) AT=3.516778
.meas tran trig_wid_b4 FIND V(xfe.trig_wid) AT=3.530778
.meas tran trig_s69_b4 FIND V(xfe.trig_s69) AT=3.571778
.meas tran trig_s14_b5 FIND V(xfe.trig_s14) AT=4.305667
.meas tran trig_wid_b5 FIND V(xfe.trig_wid) AT=4.319667
.meas tran trig_s69_b5 FIND V(xfe.trig_s69) AT=4.360667
.meas tran avg_idd AVG I(Vdd) FROM=0.5 TO=5.564

.control
run
set wr_singlescale
wrdata _integration_test_data.txt v(f1_rr_ratio) v(f2_rr_asym) v(f3_bi_l0) v(f4_bi_l1) v(f5_pwave) v(f6_width) v(f7_slope) v(f8_symmetry) v(xfe.ecg_amp_l0) v(xfe.rpeak_pulse)
.endc
.end
