.title e2e_analog_100_b7
.lib "C:/Users/kadhi/OneDrive/Desktop/amux/verilogLearning/Leaky-Integrate-Fire---SNN-model-on-FPGA/experiments/frontend_optimization/ngspice_frontend/sky130_minimal.lib.spice" tt
.option scale=1.0u method=gear reltol=0.01 gmin=1e-15
.temp 27

Vdd vdd 0 0.9
Vss vss 0 0

* === ECG INPUTS (PWL — the ONLY non-analog input) ===
Vecg0 ecg_l0 0 PWL(0.0000000 0.300000 0.5831111 0.300000 0.5861111 0.279079 0.5888889 0.279669 0.5916667 0.279963 0.5944444 0.279963 0.5972222 0.279374 0.6000000 0.278490 0.6027778 0.279079 0.6055556 0.279963 0.6083333 0.279963 0.6111111 0.281142 0.6138889 0.280847 0.6166667 0.281731 0.6194444 0.282615 0.6222222 0.282910 0.6250000 0.283794 0.6277778 0.283794 0.6305556 0.283499 0.6333333 0.282615 0.6361111 0.283499 0.6388889 0.284088 0.6416667 0.284678 0.6444444 0.285267 0.6472222 0.285267 0.6500000 0.284972 0.6527778 0.285856 0.6555556 0.286446 0.6583333 0.286740 0.6611111 0.286446 0.6638889 0.285562 0.6666667 0.284972 0.6694444 0.284972 0.6722222 0.284972 0.6750000 0.285562 0.6777778 0.285562 0.6805556 0.285267 0.6833333 0.284088 0.6861111 0.283794 0.6888889 0.284972 0.6916667 0.286740 0.6944444 0.287035 0.6972222 0.286740 0.7000000 0.284678 0.7027778 0.283499 0.7055556 0.283204 0.7083333 0.282320 0.7111111 0.281731 0.7138889 0.280552 0.7166667 0.279079 0.7194444 0.279079 0.7222222 0.279079 0.7250000 0.279374 0.7277778 0.279079 0.7305556 0.278195 0.7333333 0.277901 0.7361111 0.278490 0.7388889 0.277606 0.7416667 0.279079 0.7444444 0.278785 0.7472222 0.278490 0.7500000 0.277311 0.7527778 0.277606 0.7555556 0.277901 0.7583333 0.278195 0.7611111 0.278195 0.7638889 0.278195 0.7666667 0.277017 0.7694444 0.277901 0.7722222 0.278195 0.7750000 0.278785 0.7777778 0.278490 0.7805556 0.277311 0.7833333 0.275543 0.7861111 0.273775 0.7888889 0.272007 0.7916667 0.270829 0.7944444 0.269650 0.7972222 0.266409 0.8000000 0.263757 0.8027778 0.264346 0.8055556 0.267587 0.8083333 0.273481 0.8111111 0.278195 0.8138889 0.282615 0.8166667 0.286446 0.8194444 0.291455 0.8222222 0.297937 0.8250000 0.307956 0.8277778 0.320626 0.8305556 0.334180 0.8333333 0.344788 0.8361111 0.353039 0.8388889 0.357459 0.8416667 0.356869 0.8444444 0.343904 0.8472222 0.320921 0.8500000 0.294696 0.8527778 0.276427 0.8555556 0.270239 0.8583333 0.271418 0.8611111 0.274070 0.8638889 0.276427 0.8666667 0.276427 0.8694444 0.276722 0.8722222 0.276722 0.8750000 0.277017 0.8777778 0.277017 0.8805556 0.276427 0.8833333 0.275543 0.8861111 0.275838 0.8888889 0.275543 0.8916667 0.276427 0.8944444 0.276133 0.8972222 0.275543 0.9000000 0.275838 0.9027778 0.276133 0.9055556 0.275838 0.9083333 0.276722 0.9111111 0.276427 0.9138889 0.276427 0.9166667 0.276133 0.9194444 0.275543 0.9222222 0.275543 0.9250000 0.276722 0.9277778 0.276722 0.9305556 0.276133 0.9333333 0.276133 0.9361111 0.276427 0.9388889 0.275838 0.9416667 0.277017 0.9444444 0.277311 0.9472222 0.276427 0.9500000 0.276133 0.9527778 0.276427 0.9555556 0.276133 0.9583333 0.276722 0.9611111 0.277017 0.9638889 0.276427 0.9666667 0.276133 0.9694444 0.276722 0.9722222 0.276722 0.9750000 0.277311 0.9777778 0.277017 0.9805556 0.276427 0.9833333 0.276427 0.9861111 0.276427 0.9888889 0.277017 0.9916667 0.276427 0.9944444 0.277017 0.9972222 0.277017 1.0000000 0.276427 1.0027778 0.277017 1.0055556 0.277311 1.0083333 0.277606 1.0111111 0.277017 1.0138889 0.276722 1.0166667 0.276427 1.0194444 0.277017 1.0222222 0.277017 1.0250000 0.277311 1.0277778 0.277311 1.0305556 0.277017 1.0333333 0.276722 1.0361111 0.277017 1.0388889 0.276722 1.0416667 0.277311 1.0444444 0.277901 1.0472222 0.276133 1.0500000 0.276427 1.0527778 0.276133 1.0555556 0.276722 1.0583333 0.276722 1.0611111 0.276427 1.0638889 0.276427 1.0666667 0.276427 1.0694444 0.276427 1.0722222 0.276427 1.0750000 0.277017 1.0777778 0.276427 1.0805556 0.276427 1.0833333 0.276133 1.0861111 0.276427 1.0888889 0.276427 1.0916667 0.276427 1.0944444 0.276427 1.0972222 0.276722 1.1000000 0.276133 1.1027778 0.276427 1.1055556 0.276133 1.1083333 0.276427 1.1111111 0.276133 1.1138889 0.276427 1.1166667 0.276427 1.1194444 0.276427 1.1222222 0.277017 1.1250000 0.278195 1.1277778 0.277901 1.1305556 0.278490 1.1333333 0.278490 1.1391111 0.300000 1.4053333 0.300000 1.4083333 0.282026 1.4111111 0.281731 1.4138889 0.281142 1.4166667 0.280847 1.4194444 0.281436 1.4222222 0.282026 1.4250000 0.282320 1.4277778 0.281142 1.4305556 0.281731 1.4333333 0.281142 1.4361111 0.282320 1.4388889 0.283204 1.4416667 0.284383 1.4444444 0.284972 1.4472222 0.284678 1.4500000 0.284972 1.4527778 0.285267 1.4555556 0.286151 1.4583333 0.285856 1.4611111 0.286740 1.4638889 0.287035 1.4666667 0.286446 1.4694444 0.286740 1.4722222 0.288214 1.4750000 0.288803 1.4777778 0.288508 1.4805556 0.288214 1.4833333 0.287624 1.4861111 0.287624 1.4888889 0.288214 1.4916667 0.287624 1.4944444 0.287919 1.4972222 0.286740 1.5000000 0.286151 1.5027778 0.286446 1.5055556 0.287035 1.5083333 0.287035 1.5111111 0.286151 1.5138889 0.286446 1.5166667 0.287035 1.5194444 0.288508 1.5222222 0.289098 1.5250000 0.287330 1.5277778 0.285562 1.5305556 0.284383 1.5333333 0.282320 1.5361111 0.282320 1.5388889 0.282320 1.5416667 0.282026 1.5444444 0.281142 1.5472222 0.280552 1.5500000 0.279963 1.5527778 0.280258 1.5555556 0.281142 1.5583333 0.281436 1.5611111 0.281142 1.5638889 0.280552 1.5666667 0.279669 1.5694444 0.279963 1.5722222 0.279669 1.5750000 0.280552 1.5777778 0.280258 1.5805556 0.279669 1.5833333 0.278785 1.5861111 0.279669 1.5888889 0.279374 1.5916667 0.280258 1.5944444 0.279963 1.5972222 0.279669 1.6000000 0.279079 1.6027778 0.279374 1.6055556 0.279669 1.6083333 0.279963 1.6111111 0.279079 1.6138889 0.278490 1.6166667 0.276722 1.6194444 0.275249 1.6222222 0.273186 1.6250000 0.272302 1.6277778 0.271418 1.6305556 0.268766 1.6333333 0.265525 1.6361111 0.268471 1.6388889 0.275543 1.6416667 0.283204 1.6444444 0.292339 1.6472222 0.302652 1.6500000 0.318269 1.6527778 0.334770 1.6555556 0.346851 1.6583333 0.351565 1.6611111 0.345967 1.6638889 0.328582 1.6666667 0.303831 1.6694444 0.282615 1.6722222 0.272302 1.6750000 0.270829 1.6777778 0.273775 1.6805556 0.276427 1.6833333 0.277311 1.6861111 0.277311 1.6888889 0.278195 1.6916667 0.278195 1.6944444 0.279079 1.6972222 0.278195 1.7000000 0.277311 1.7027778 0.277606 1.7055556 0.277901 1.7083333 0.277901 1.7111111 0.277606 1.7138889 0.277606 1.7166667 0.277311 1.7194444 0.277311 1.7222222 0.277606 1.7250000 0.278195 1.7277778 0.278195 1.7305556 0.277017 1.7333333 0.277311 1.7361111 0.278195 1.7388889 0.278195 1.7416667 0.278785 1.7444444 0.278490 1.7472222 0.278195 1.7500000 0.277311 1.7527778 0.277606 1.7555556 0.277901 1.7583333 0.278490 1.7611111 0.278195 1.7638889 0.277311 1.7666667 0.277606 1.7694444 0.277606 1.7722222 0.278490 1.7750000 0.278490 1.7777778 0.278195 1.7805556 0.277901 1.7833333 0.277311 1.7861111 0.277901 1.7888889 0.277901 1.7916667 0.278490 1.7944444 0.278490 1.7972222 0.277606 1.8000000 0.277901 1.8027778 0.278195 1.8055556 0.278785 1.8083333 0.279669 1.8111111 0.279079 1.8138889 0.278490 1.8166667 0.278195 1.8194444 0.278195 1.8222222 0.279374 1.8250000 0.278785 1.8277778 0.279374 1.8305556 0.278785 1.8333333 0.277901 1.8361111 0.278490 1.8388889 0.278490 1.8416667 0.278785 1.8444444 0.279079 1.8472222 0.278785 1.8500000 0.277901 1.8527778 0.278195 1.8555556 0.278785 1.8583333 0.279079 1.8611111 0.278785 1.8638889 0.278490 1.8666667 0.277901 1.8694444 0.278490 1.8722222 0.279079 1.8750000 0.279079 1.8777778 0.279079 1.8805556 0.279079 1.8833333 0.278785 1.8861111 0.278490 1.8888889 0.278490 1.8916667 0.279374 1.8944444 0.278490 1.8972222 0.278490 1.9000000 0.277901 1.9027778 0.277017 1.9055556 0.277606 1.9083333 0.278195 1.9111111 0.278195 1.9138889 0.277901 1.9166667 0.277606 1.9194444 0.277311 1.9222222 0.278195 1.9250000 0.279079 1.9277778 0.278490 1.9305556 0.277311 1.9333333 0.277311 1.9361111 0.278195 1.9388889 0.278195 1.9416667 0.279079 1.9444444 0.280258 1.9472222 0.279963 1.9500000 0.280258 1.9527778 0.280552 1.9555556 0.281436 1.9613333 0.300000 2.1886667 0.300000 2.1916667 0.279079 2.1944444 0.279079 2.1972222 0.278490 2.2000000 0.277901 2.2027778 0.278490 2.2055556 0.279079 2.2083333 0.278785 2.2111111 0.279079 2.2138889 0.278195 2.2166667 0.277901 2.2194444 0.278490 2.2222222 0.279374 2.2250000 0.279374 2.2277778 0.279963 2.2305556 0.280552 2.2333333 0.280847 2.2361111 0.281142 2.2388889 0.281731 2.2416667 0.282320 2.2444444 0.282910 2.2472222 0.283204 2.2500000 0.283204 2.2527778 0.284088 2.2555556 0.284383 2.2583333 0.285267 2.2611111 0.285562 2.2638889 0.285267 2.2666667 0.284383 2.2694444 0.284383 2.2722222 0.284088 2.2750000 0.284678 2.2777778 0.283794 2.2805556 0.282910 2.2833333 0.282320 2.2861111 0.283204 2.2888889 0.283204 2.2916667 0.283204 2.2944444 0.282615 2.2972222 0.282910 2.3000000 0.282910 2.3027778 0.284383 2.3055556 0.283794 2.3083333 0.282910 2.3111111 0.280847 2.3138889 0.279963 2.3166667 0.278785 2.3194444 0.277901 2.3222222 0.278490 2.3250000 0.277901 2.3277778 0.277606 2.3305556 0.276427 2.3333333 0.275543 2.3361111 0.277311 2.3388889 0.277901 2.3416667 0.278195 2.3444444 0.277606 2.3472222 0.276722 2.3500000 0.276427 2.3527778 0.275838 2.3555556 0.276133 2.3583333 0.276133 2.3611111 0.276427 2.3638889 0.275543 2.3666667 0.274954 2.3694444 0.274954 2.3722222 0.275838 2.3750000 0.276427 2.3777778 0.275838 2.3805556 0.275249 2.3833333 0.274659 2.3861111 0.274659 2.3888889 0.274954 2.3916667 0.276427 2.3944444 0.276427 2.3972222 0.275838 2.4000000 0.274659 2.4027778 0.272597 2.4055556 0.271123 2.4083333 0.270829 2.4111111 0.269650 2.4138889 0.266703 2.4166667 0.264052 2.4194444 0.263462 2.4222222 0.266703 2.4250000 0.273775 2.4277778 0.282026 2.4305556 0.291455 2.4333333 0.304715 2.4361111 0.321805 2.4388889 0.337127 2.4416667 0.345967 2.4444444 0.347145 2.4472222 0.337422 2.4500000 0.319153 2.4527778 0.297053 2.4555556 0.281731 2.4583333 0.273186 2.4611111 0.267587 2.4638889 0.266114 2.4666667 0.267293 2.4694444 0.270829 2.4722222 0.272597 2.4750000 0.273775 2.4777778 0.273481 2.4805556 0.273775 2.4833333 0.273775 2.4861111 0.274070 2.4888889 0.274070 2.4916667 0.274070 2.4944444 0.274070 2.4972222 0.273186 2.5000000 0.272302 2.5027778 0.272302 2.5055556 0.272302 2.5083333 0.272597 2.5111111 0.272891 2.5138889 0.272891 2.5166667 0.272891 2.5194444 0.272597 2.5222222 0.273481 2.5250000 0.273775 2.5277778 0.274070 2.5305556 0.273186 2.5333333 0.272302 2.5361111 0.272597 2.5388889 0.272891 2.5416667 0.274365 2.5444444 0.274070 2.5472222 0.273186 2.5500000 0.271713 2.5527778 0.273186 2.5555556 0.273186 2.5583333 0.273481 2.5611111 0.273481 2.5638889 0.272891 2.5666667 0.272302 2.5694444 0.273186 2.5722222 0.272891 2.5750000 0.272891 2.5777778 0.273481 2.5805556 0.273186 2.5833333 0.272891 2.5861111 0.273481 2.5888889 0.272891 2.5916667 0.272891 2.5944444 0.272597 2.5972222 0.271713 2.6000000 0.270829 2.6027778 0.271713 2.6055556 0.273186 2.6083333 0.273481 2.6111111 0.273481 2.6138889 0.273481 2.6166667 0.272891 2.6194444 0.272597 2.6222222 0.273186 2.6250000 0.274070 2.6277778 0.273481 2.6305556 0.272891 2.6333333 0.272597 2.6361111 0.272891 2.6388889 0.273481 2.6416667 0.273186 2.6444444 0.273481 2.6472222 0.273481 2.6500000 0.272891 2.6527778 0.273481 2.6555556 0.273481 2.6583333 0.273775 2.6611111 0.273775 2.6638889 0.273481 2.6666667 0.272891 2.6694444 0.272597 2.6722222 0.273186 2.6750000 0.273481 2.6777778 0.272891 2.6805556 0.271713 2.6833333 0.271123 2.6861111 0.271418 2.6888889 0.271713 2.6916667 0.272007 2.6944444 0.271713 2.6972222 0.270534 2.7000000 0.269650 2.7027778 0.269355 2.7055556 0.269650 2.7083333 0.269355 2.7111111 0.270239 2.7138889 0.270534 2.7166667 0.269945 2.7194444 0.270534 2.7222222 0.272007 2.7250000 0.273481 2.7277778 0.273481 2.7305556 0.273186 2.7333333 0.273481 2.7361111 0.273775 2.7388889 0.274954 2.7446667 0.300000 2.9331111 0.300000 2.9361111 0.274659 2.9388889 0.274954 2.9416667 0.275838 2.9444444 0.275543 2.9472222 0.274954 2.9500000 0.274954 2.9527778 0.274954 2.9555556 0.275543 2.9583333 0.276722 2.9611111 0.276427 2.9638889 0.275838 2.9666667 0.274954 2.9694444 0.275838 2.9722222 0.275838 2.9750000 0.276722 2.9777778 0.276722 2.9805556 0.276427 2.9833333 0.276133 2.9861111 0.277017 2.9888889 0.277606 2.9916667 0.279079 2.9944444 0.279079 2.9972222 0.279963 3.0000000 0.278785 3.0027778 0.278785 3.0055556 0.279963 3.0083333 0.280552 3.0111111 0.281142 3.0138889 0.281142 3.0166667 0.281731 3.0194444 0.281436 3.0222222 0.282615 3.0250000 0.282910 3.0277778 0.282910 3.0305556 0.281731 3.0333333 0.281731 3.0361111 0.282320 3.0388889 0.283204 3.0416667 0.283794 3.0444444 0.284383 3.0472222 0.285267 3.0500000 0.284678 3.0527778 0.283204 3.0555556 0.282320 3.0583333 0.280552 3.0611111 0.279963 3.0638889 0.278490 3.0666667 0.276427 3.0694444 0.276427 3.0722222 0.276133 3.0750000 0.276722 3.0777778 0.276133 3.0805556 0.275838 3.0833333 0.274659 3.0861111 0.274954 3.0888889 0.275249 3.0916667 0.275543 3.0944444 0.275249 3.0972222 0.274954 3.1000000 0.274070 3.1027778 0.273775 3.1055556 0.274659 3.1083333 0.274954 3.1111111 0.274659 3.1138889 0.274365 3.1166667 0.274070 3.1194444 0.274365 3.1222222 0.274365 3.1250000 0.275249 3.1277778 0.275249 3.1305556 0.274954 3.1333333 0.274659 3.1361111 0.274365 3.1388889 0.274365 3.1416667 0.274659 3.1444444 0.272891 3.1472222 0.269945 3.1500000 0.267882 3.1527778 0.266998 3.1555556 0.266114 3.1583333 0.264346 3.1611111 0.263168 3.1638889 0.266409 3.1666667 0.273186 3.1694444 0.283204 3.1722222 0.292634 3.1750000 0.305009 3.1777778 0.320331 3.1805556 0.335064 3.1833333 0.345672 3.1861111 0.349503 3.1888889 0.344199 3.1916667 0.327403 3.1944444 0.301768 3.1972222 0.280552 3.2000000 0.269061 3.2027778 0.266114 3.2055556 0.267882 3.2083333 0.270829 3.2111111 0.272891 3.2138889 0.272891 3.2166667 0.272007 3.2194444 0.272302 3.2222222 0.273186 3.2250000 0.274070 3.2277778 0.273775 3.2305556 0.272891 3.2333333 0.272597 3.2361111 0.272302 3.2388889 0.272597 3.2416667 0.273186 3.2444444 0.272891 3.2472222 0.272007 3.2500000 0.272597 3.2527778 0.272302 3.2555556 0.272891 3.2583333 0.273775 3.2611111 0.273775 3.2638889 0.272891 3.2666667 0.272891 3.2694444 0.272891 3.2722222 0.273186 3.2750000 0.273481 3.2777778 0.273481 3.2805556 0.272597 3.2833333 0.272597 3.2861111 0.272302 3.2888889 0.272597 3.2916667 0.273186 3.2944444 0.273481 3.2972222 0.273186 3.3000000 0.272302 3.3027778 0.272597 3.3055556 0.272597 3.3083333 0.273481 3.3111111 0.272597 3.3138889 0.272891 3.3166667 0.272302 3.3194444 0.272597 3.3222222 0.273186 3.3250000 0.273775 3.3277778 0.273775 3.3305556 0.272302 3.3333333 0.272597 3.3361111 0.272891 3.3388889 0.273186 3.3416667 0.274070 3.3444444 0.273775 3.3472222 0.273481 3.3500000 0.272597 3.3527778 0.273481 3.3555556 0.273775 3.3583333 0.273775 3.3611111 0.273775 3.3638889 0.273481 3.3666667 0.273481 3.3694444 0.272302 3.3722222 0.273481 3.3750000 0.273775 3.3777778 0.274070 3.3805556 0.273481 3.3833333 0.272891 3.3861111 0.273186 3.3888889 0.273775 3.3916667 0.274070 3.3944444 0.274070 3.3972222 0.273775 3.4000000 0.272891 3.4027778 0.272597 3.4055556 0.272891 3.4083333 0.273186 3.4111111 0.273481 3.4138889 0.272891 3.4166667 0.272891 3.4194444 0.272302 3.4222222 0.273186 3.4250000 0.272891 3.4277778 0.272891 3.4305556 0.272891 3.4333333 0.272597 3.4361111 0.272007 3.4388889 0.272891 3.4416667 0.272597 3.4444444 0.273186 3.4472222 0.271713 3.4500000 0.270829 3.4527778 0.271418 3.4555556 0.272007 3.4583333 0.272302 3.4611111 0.270829 3.4638889 0.271713 3.4666667 0.271123 3.4694444 0.271418 3.4722222 0.272891 3.4750000 0.274070 3.4777778 0.274365 3.4805556 0.274365 3.4833333 0.274365 3.4891111 0.300000 3.7636667 0.300000 3.7666667 0.277017 3.7694444 0.277311 3.7722222 0.277901 3.7750000 0.277606 3.7777778 0.277606 3.7805556 0.277311 3.7833333 0.277901 3.7861111 0.277901 3.7888889 0.278785 3.7916667 0.279374 3.7944444 0.278785 3.7972222 0.278490 3.8000000 0.277901 3.8027778 0.278785 3.8055556 0.279669 3.8083333 0.281142 3.8111111 0.282026 3.8138889 0.281731 3.8166667 0.281142 3.8194444 0.281142 3.8222222 0.282320 3.8250000 0.282910 3.8277778 0.282910 3.8305556 0.283204 3.8333333 0.282910 3.8361111 0.283499 3.8388889 0.284088 3.8416667 0.284972 3.8444444 0.283794 3.8472222 0.284088 3.8500000 0.282910 3.8527778 0.282320 3.8555556 0.283499 3.8583333 0.283499 3.8611111 0.283499 3.8638889 0.282910 3.8666667 0.282320 3.8694444 0.282320 3.8722222 0.283499 3.8750000 0.283794 3.8777778 0.282615 3.8805556 0.283204 3.8833333 0.281731 3.8861111 0.283794 3.8888889 0.284972 3.8916667 0.284972 3.8944444 0.282320 3.8972222 0.280552 3.9000000 0.279079 3.9027778 0.278785 3.9055556 0.278195 3.9083333 0.277901 3.9111111 0.277901 3.9138889 0.277017 3.9166667 0.276133 3.9194444 0.276427 3.9222222 0.276722 3.9250000 0.277017 3.9277778 0.276722 3.9305556 0.276722 3.9333333 0.276133 3.9361111 0.275838 3.9388889 0.276722 3.9416667 0.277017 3.9444444 0.276722 3.9472222 0.276427 3.9500000 0.275543 3.9527778 0.275838 3.9555556 0.275838 3.9583333 0.276427 3.9611111 0.276427 3.9638889 0.275543 3.9666667 0.275249 3.9694444 0.274954 3.9722222 0.273775 3.9750000 0.272597 3.9777778 0.269650 3.9805556 0.267587 3.9833333 0.266703 3.9861111 0.264052 3.9888889 0.263462 3.9916667 0.266409 3.9944444 0.273481 3.9972222 0.281436 4.0000000 0.289982 4.0027778 0.301768 4.0055556 0.317385 4.0083333 0.333591 4.0111111 0.345672 4.0138889 0.353039 4.0166667 0.356869 4.0194444 0.355101 4.0222222 0.344199 4.0250000 0.323573 4.0277778 0.298527 4.0305556 0.278785 4.0333333 0.268766 4.0361111 0.267293 4.0388889 0.269945 4.0416667 0.273186 4.0444444 0.274954 4.0472222 0.274659 4.0500000 0.273775 4.0527778 0.274070 4.0555556 0.274365 4.0583333 0.274659 4.0611111 0.274659 4.0638889 0.273775 4.0666667 0.273186 4.0694444 0.273186 4.0722222 0.273775 4.0750000 0.273481 4.0777778 0.274070 4.0805556 0.273481 4.0833333 0.273481 4.0861111 0.273186 4.0888889 0.273481 4.0916667 0.274365 4.0944444 0.274954 4.0972222 0.274365 4.1000000 0.273775 4.1027778 0.273775 4.1055556 0.273775 4.1083333 0.273775 4.1111111 0.274365 4.1138889 0.274070 4.1166667 0.272891 4.1194444 0.272007 4.1222222 0.273186 4.1250000 0.273481 4.1277778 0.274365 4.1305556 0.273775 4.1333333 0.273186 4.1361111 0.272891 4.1388889 0.273481 4.1416667 0.274070 4.1444444 0.274365 4.1472222 0.273775 4.1500000 0.274070 4.1527778 0.274070 4.1555556 0.274659 4.1583333 0.274659 4.1611111 0.273775 4.1638889 0.273481 4.1666667 0.272891 4.1694444 0.273186 4.1722222 0.273775 4.1750000 0.274365 4.1777778 0.274070 4.1805556 0.274070 4.1833333 0.273481 4.1861111 0.273775 4.1888889 0.273775 4.1916667 0.274954 4.1944444 0.274659 4.1972222 0.274070 4.2000000 0.273775 4.2027778 0.273775 4.2055556 0.274365 4.2083333 0.274954 4.2111111 0.274365 4.2138889 0.274365 4.2166667 0.274365 4.2194444 0.274070 4.2222222 0.274659 4.2250000 0.274954 4.2277778 0.274365 4.2305556 0.274365 4.2333333 0.273775 4.2361111 0.273481 4.2388889 0.274070 4.2416667 0.274659 4.2444444 0.274954 4.2472222 0.274070 4.2500000 0.273481 4.2527778 0.274070 4.2555556 0.274365 4.2583333 0.274954 4.2611111 0.275249 4.2638889 0.274659 4.2666667 0.274365 4.2694444 0.274070 4.2722222 0.274659 4.2750000 0.274659 4.2777778 0.274365 4.2805556 0.274070 4.2833333 0.273186 4.2861111 0.273481 4.2888889 0.273775 4.2916667 0.273481 4.2944444 0.274954 4.2972222 0.274659 4.3000000 0.274070 4.3027778 0.274659 4.3055556 0.276133 4.3083333 0.277017 4.3111111 0.277017 4.3138889 0.277901 4.3196667 0.300000 4.5442222 0.300000 4.5472222 0.277901 4.5500000 0.277311 4.5527778 0.277017 4.5555556 0.278195 4.5583333 0.278195 4.5611111 0.278490 4.5638889 0.277311 4.5666667 0.277311 4.5694444 0.277606 4.5722222 0.277901 4.5750000 0.279079 4.5777778 0.279374 4.5805556 0.279079 4.5833333 0.279374 4.5861111 0.280552 4.5888889 0.281436 4.5916667 0.282026 4.5944444 0.282910 4.5972222 0.282320 4.6000000 0.282615 4.6027778 0.282320 4.6055556 0.283204 4.6083333 0.283794 4.6111111 0.284678 4.6138889 0.283794 4.6166667 0.283499 4.6194444 0.284088 4.6222222 0.284678 4.6250000 0.284972 4.6277778 0.284972 4.6305556 0.284383 4.6333333 0.283794 4.6361111 0.283794 4.6388889 0.283794 4.6416667 0.284088 4.6444444 0.283204 4.6472222 0.282910 4.6500000 0.282910 4.6527778 0.282910 4.6555556 0.283204 4.6583333 0.282615 4.6611111 0.282910 4.6638889 0.283499 4.6666667 0.284972 4.6694444 0.284383 4.6722222 0.283499 4.6750000 0.282026 4.6777778 0.281436 4.6805556 0.280552 4.6833333 0.278785 4.6861111 0.277901 4.6888889 0.278195 4.6916667 0.279079 4.6944444 0.277606 4.6972222 0.277017 4.7000000 0.276427 4.7027778 0.276427 4.7055556 0.276427 4.7083333 0.276427 4.7111111 0.276133 4.7138889 0.275838 4.7166667 0.275543 4.7194444 0.275249 4.7222222 0.276427 4.7250000 0.276722 4.7277778 0.275838 4.7305556 0.276427 4.7333333 0.275838 4.7361111 0.275838 4.7388889 0.276427 4.7416667 0.276722 4.7444444 0.276722 4.7472222 0.275543 4.7500000 0.274365 4.7527778 0.273775 4.7555556 0.272007 4.7583333 0.269945 4.7611111 0.268766 4.7638889 0.266998 4.7666667 0.264346 4.7694444 0.262578 4.7722222 0.264052 4.7750000 0.270239 4.7777778 0.277901 4.7805556 0.285562 4.7833333 0.295285 4.7861111 0.310313 4.7888889 0.326519 4.7916667 0.339190 4.7944444 0.346851 4.7972222 0.351860 4.8000000 0.353628 4.8027778 0.348619 4.8055556 0.338600 4.8083333 0.323867 4.8111111 0.306188 4.8138889 0.289098 4.8166667 0.275838 4.8194444 0.268177 4.8222222 0.266703 4.8250000 0.269355 4.8277778 0.272302 4.8305556 0.273775 4.8333333 0.273481 4.8361111 0.273186 4.8388889 0.273775 4.8416667 0.274954 4.8444444 0.274070 4.8472222 0.274070 4.8500000 0.272891 4.8527778 0.273186 4.8555556 0.273775 4.8583333 0.274365 4.8611111 0.274070 4.8638889 0.274070 4.8666667 0.272891 4.8694444 0.272891 4.8722222 0.273775 4.8750000 0.274659 4.8777778 0.274070 4.8805556 0.273186 4.8833333 0.272302 4.8861111 0.272891 4.8888889 0.273775 4.8916667 0.274365 4.8944444 0.274365 4.8972222 0.273481 4.9000000 0.272597 4.9027778 0.272891 4.9055556 0.273186 4.9083333 0.273481 4.9111111 0.273186 4.9138889 0.272891 4.9166667 0.272597 4.9194444 0.272597 4.9222222 0.273481 4.9250000 0.272891 4.9277778 0.273186 4.9305556 0.273481 4.9333333 0.272891 4.9361111 0.273481 4.9388889 0.273481 4.9416667 0.273775 4.9444444 0.273186 4.9472222 0.272597 4.9500000 0.272597 4.9527778 0.272302 4.9555556 0.272302 4.9583333 0.273775 4.9611111 0.274070 4.9638889 0.273775 4.9666667 0.272302 4.9694444 0.272302 4.9722222 0.272302 4.9750000 0.273186 4.9777778 0.273481 4.9805556 0.273186 4.9833333 0.272007 4.9861111 0.271713 4.9888889 0.273186 4.9916667 0.274070 4.9944444 0.274070 4.9972222 0.274070 5.0000000 0.273186 5.0027778 0.273186 5.0055556 0.273775 5.0083333 0.274659 5.0111111 0.274365 5.0138889 0.273775 5.0166667 0.272597 5.0194444 0.272007 5.0222222 0.273186 5.0250000 0.273775 5.0277778 0.273186 5.0305556 0.273481 5.0333333 0.273186 5.0361111 0.273186 5.0388889 0.272597 5.0416667 0.272891 5.0444444 0.273481 5.0472222 0.272597 5.0500000 0.272007 5.0527778 0.272007 5.0555556 0.272597 5.0583333 0.273481 5.0611111 0.273481 5.0638889 0.272891 5.0666667 0.271418 5.0694444 0.272597 5.0722222 0.272597 5.0750000 0.272302 5.0777778 0.272302 5.0805556 0.271418 5.0833333 0.270829 5.0861111 0.270829 5.0888889 0.272302 5.0916667 0.272597 5.0944444 0.272007 5.1002222 0.300000 5.3747778 0.300000 5.3777778 0.275543 5.3805556 0.275543 5.3833333 0.274954 5.3861111 0.275249 5.3888889 0.275838 5.3916667 0.277017 5.3944444 0.276427 5.3972222 0.275838 5.4000000 0.275543 5.4027778 0.275838 5.4055556 0.277311 5.4083333 0.277901 5.4111111 0.278490 5.4138889 0.279374 5.4166667 0.278785 5.4194444 0.279374 5.4222222 0.280258 5.4250000 0.281142 5.4277778 0.280258 5.4305556 0.279963 5.4333333 0.280258 5.4361111 0.281142 5.4388889 0.282320 5.4416667 0.283204 5.4444444 0.283204 5.4472222 0.282615 5.4500000 0.281731 5.4527778 0.281436 5.4555556 0.280847 5.4583333 0.282320 5.4611111 0.281436 5.4638889 0.281142 5.4666667 0.281142 5.4694444 0.281436 5.4722222 0.281436 5.4750000 0.280552 5.4777778 0.279374 5.4805556 0.279963 5.4833333 0.281436 5.4861111 0.282615 5.4888889 0.282910 5.4916667 0.282026 5.4944444 0.280258 5.4972222 0.278490 5.5000000 0.277017 5.5027778 0.276427 5.5055556 0.276133 5.5083333 0.276133 5.5111111 0.275838 5.5138889 0.274954 5.5166667 0.273775 5.5194444 0.274070 5.5222222 0.274659 5.5250000 0.274954 5.5277778 0.274954 5.5305556 0.275249 5.5333333 0.274659 5.5361111 0.274659 5.5388889 0.274954 5.5416667 0.274954 5.5444444 0.274365 5.5472222 0.273775 5.5500000 0.273775 5.5527778 0.273775 5.5555556 0.274659 5.5583333 0.275249 5.5611111 0.274954 5.5638889 0.274954 5.5666667 0.273481 5.5694444 0.274070 5.5722222 0.273775 5.5750000 0.274365 5.5777778 0.274365 5.5805556 0.274365 5.5833333 0.273186 5.5861111 0.270829 5.5888889 0.269355 5.5916667 0.269061 5.5944444 0.267882 5.5972222 0.265525 5.6000000 0.262284 5.6027778 0.261989 5.6055556 0.265525 5.6083333 0.273186 5.6111111 0.279963 5.6138889 0.287035 5.6166667 0.298232 5.6194444 0.312965 5.6222222 0.329761 5.6250000 0.341252 5.6277778 0.347735 5.6305556 0.348029 5.6333333 0.338600 5.6361111 0.319742 5.6388889 0.300295 5.6416667 0.284972 5.6444444 0.275249 5.6472222 0.269355 5.6500000 0.266114 5.6527778 0.264052 5.6555556 0.263757 5.6583333 0.265525 5.6611111 0.266703 5.6638889 0.268766 5.6666667 0.270239 5.6694444 0.270829 5.6722222 0.271123 5.6750000 0.271418 5.6777778 0.271418 5.6805556 0.272007 5.6833333 0.271418 5.6861111 0.271713 5.6888889 0.272007 5.6916667 0.273481 5.6944444 0.272891 5.6972222 0.272302 5.7000000 0.271713 5.7027778 0.271418 5.7055556 0.272302 5.7083333 0.272891 5.7111111 0.272302 5.7138889 0.272597 5.7166667 0.272007 5.7194444 0.272302 5.7222222 0.273481 5.7250000 0.273775 5.7277778 0.273481 5.7305556 0.272007 5.7333333 0.272007 5.7361111 0.271713 5.7388889 0.273186 5.7416667 0.272597 5.7444444 0.273186 5.7472222 0.272597 5.7500000 0.272007 5.7527778 0.271713 5.7555556 0.272302 5.7583333 0.272597 5.7611111 0.272597 5.7638889 0.272007 5.7666667 0.272302 5.7694444 0.272007 5.7722222 0.272891 5.7750000 0.273186 5.7777778 0.273186 5.7805556 0.272597 5.7833333 0.271713 5.7861111 0.271713 5.7888889 0.272597 5.7916667 0.272891 5.7944444 0.272597 5.7972222 0.272597 5.8000000 0.272007 5.8027778 0.272597 5.8055556 0.272007 5.8083333 0.273775 5.8111111 0.272891 5.8138889 0.273481 5.8166667 0.272597 5.8194444 0.272891 5.8222222 0.273481 5.8250000 0.273775 5.8277778 0.274070 5.8305556 0.273775 5.8333333 0.273481 5.8361111 0.272597 5.8388889 0.273481 5.8416667 0.273481 5.8444444 0.273186 5.8472222 0.272302 5.8500000 0.272597 5.8527778 0.272597 5.8555556 0.273186 5.8583333 0.272891 5.8611111 0.273481 5.8638889 0.272891 5.8666667 0.272302 5.8694444 0.272007 5.8722222 0.272302 5.8750000 0.272007 5.8777778 0.271123 5.8805556 0.270829 5.8833333 0.270239 5.8861111 0.270829 5.8888889 0.272007 5.8916667 0.272302 5.8944444 0.271713 5.8972222 0.270534 5.9000000 0.270534 5.9027778 0.269650 5.9055556 0.269945 5.9083333 0.270534 5.9111111 0.270829 5.9138889 0.269945 5.9166667 0.269355 5.9194444 0.268766 5.9222222 0.269650 5.9250000 0.270534 5.9307778 0.300000 6.2386667 0.300000 6.2416667 0.278785 6.2444444 0.278785 6.2472222 0.278195 6.2500000 0.278490 6.2527778 0.277606 6.2555556 0.278785 6.2583333 0.279079 6.2611111 0.279374 6.2638889 0.278490 6.2666667 0.278785 6.2694444 0.279079 6.2722222 0.279963 6.2750000 0.281436 6.2777778 0.281142 6.2805556 0.281731 6.2833333 0.281436 6.2861111 0.281731 6.2888889 0.282615 6.2916667 0.282910 6.2944444 0.283204 6.2972222 0.283794 6.3000000 0.284088 6.3027778 0.284088 6.3055556 0.284972 6.3083333 0.284972 6.3111111 0.284678 6.3138889 0.284383 6.3166667 0.283794 6.3194444 0.283499 6.3222222 0.283499 6.3250000 0.283499 6.3277778 0.283499 6.3305556 0.283794 6.3333333 0.283204 6.3361111 0.282910 6.3388889 0.283204 6.3416667 0.284678 6.3444444 0.285267 6.3472222 0.286151 6.3500000 0.285267 6.3527778 0.283499 6.3555556 0.282026 6.3583333 0.281142 6.3611111 0.281142 6.3638889 0.279669 6.3666667 0.278785 6.3694444 0.277901 6.3722222 0.278195 6.3750000 0.278195 6.3777778 0.278195 6.3805556 0.277901 6.3833333 0.277901 6.3861111 0.277311 6.3888889 0.277606 6.3916667 0.277901 6.3944444 0.277606 6.3972222 0.277311 6.4000000 0.276722 6.4027778 0.276427 6.4055556 0.277017 6.4083333 0.277901 6.4111111 0.277901 6.4138889 0.277901 6.4166667 0.277311 6.4194444 0.277017 6.4222222 0.277901 6.4250000 0.278785 6.4277778 0.278195 6.4305556 0.278195 6.4333333 0.277606 6.4361111 0.276427 6.4388889 0.277017 6.4416667 0.277311 6.4444444 0.277017 6.4472222 0.275543 6.4500000 0.273481 6.4527778 0.271123 6.4555556 0.269945 6.4583333 0.269650 6.4611111 0.268471 6.4638889 0.266114 6.4666667 0.264346 6.4694444 0.266998 6.4722222 0.274070 6.4750000 0.282615 6.4777778 0.292044 6.4805556 0.302652 6.4833333 0.316796 6.4861111 0.333297 6.4888889 0.346556 6.4916667 0.353628 6.4944444 0.352744 6.4972222 0.340368 6.5000000 0.317385 6.5027778 0.291750 6.5055556 0.274954 6.5083333 0.269650 6.5111111 0.270534 6.5138889 0.273481 6.5166667 0.274659 6.5194444 0.275543 6.5222222 0.275543 6.5250000 0.276427 6.5277778 0.276427 6.5305556 0.276133 6.5333333 0.274954 6.5361111 0.275249 6.5388889 0.274659 6.5416667 0.275543 6.5444444 0.275543 6.5472222 0.275543 6.5500000 0.274954 6.5527778 0.274659 6.5555556 0.275543 6.5583333 0.276133 6.5611111 0.276427 6.5638889 0.275838 6.5666667 0.275249 6.5694444 0.274365 6.5722222 0.275249 6.5750000 0.275543 6.5777778 0.275543 6.5805556 0.274954 6.5833333 0.274659 6.5861111 0.274954 6.5888889 0.275249 6.5916667 0.276427 6.5944444 0.275838 6.5972222 0.275249 6.6000000 0.274659 6.6027778 0.274659 6.6055556 0.275249 6.6083333 0.275838 6.6111111 0.276427 6.6138889 0.275543 6.6166667 0.275249 6.6194444 0.275249 6.6222222 0.275249 6.6250000 0.275543 6.6277778 0.275838 6.6305556 0.275543 6.6333333 0.275543 6.6361111 0.275543 6.6388889 0.275838 6.6416667 0.276427 6.6444444 0.276133 6.6472222 0.275249 6.6500000 0.275543 6.6527778 0.275249 6.6555556 0.276133 6.6583333 0.276427 6.6611111 0.275249 6.6638889 0.275543 6.6666667 0.275543 6.6694444 0.275838 6.6722222 0.275838 6.6750000 0.276133 6.6777778 0.275838 6.6805556 0.276427 6.6833333 0.275838 6.6861111 0.275249 6.6888889 0.276133 6.6916667 0.277017 6.6944444 0.276133 6.6972222 0.276722 6.7000000 0.276722 6.7027778 0.276133 6.7055556 0.276722 6.7083333 0.277606 6.7111111 0.277017 6.7138889 0.276427 6.7166667 0.276133 6.7194444 0.275543 6.7222222 0.275838 6.7250000 0.277017 6.7277778 0.276133 6.7305556 0.276133 6.7333333 0.275838 6.7361111 0.275249 6.7388889 0.275249 6.7416667 0.275543 6.7444444 0.275249 6.7472222 0.274659 6.7500000 0.274365 6.7527778 0.274070 6.7555556 0.274659 6.7583333 0.274659 6.7611111 0.274954 6.7638889 0.275249 6.7666667 0.274365 6.7694444 0.273775 6.7722222 0.274954 6.7750000 0.275838 6.7777778 0.275249 6.7805556 0.275543 6.7833333 0.275543 6.7861111 0.276133 6.7888889 0.276427 6.7946667 0.300000 7.0608889 0.300000 7.0638889 0.281142 7.0666667 0.280258 7.0694444 0.279669 7.0722222 0.280258 7.0750000 0.280847 7.0777778 0.281142 7.0805556 0.279963 7.0833333 0.279374 7.0861111 0.279669 7.0888889 0.280258 7.0916667 0.281142 7.0944444 0.280847 7.0972222 0.280847 7.1000000 0.281142 7.1027778 0.280847 7.1055556 0.282320 7.1083333 0.283204 7.1111111 0.284088 7.1138889 0.283794 7.1166667 0.283499 7.1194444 0.283794 7.1222222 0.284972 7.1250000 0.285856 7.1277778 0.286446 7.1305556 0.286446 7.1333333 0.286740 7.1361111 0.286740 7.1388889 0.287035 7.1416667 0.287624 7.1444444 0.287330 7.1472222 0.286446 7.1500000 0.286151 7.1527778 0.285562 7.1555556 0.285856 7.1583333 0.285562 7.1611111 0.286446 7.1638889 0.285856 7.1666667 0.284383 7.1694444 0.284383 7.1722222 0.285856 7.1750000 0.287035 7.1777778 0.288214 7.1805556 0.287624 7.1833333 0.285562 7.1861111 0.283794 7.1888889 0.283204 7.1916667 0.283499 7.1944444 0.282320 7.1972222 0.280552 7.2000000 0.279963 7.2027778 0.279374 7.2055556 0.279669 7.2083333 0.280258 7.2111111 0.280258 7.2138889 0.280258 7.2166667 0.279669 7.2194444 0.278785 7.2222222 0.279374 7.2250000 0.279963 7.2277778 0.280258 7.2305556 0.279374 7.2333333 0.279374 7.2361111 0.279079 7.2388889 0.279374 7.2416667 0.279669 7.2444444 0.279079 7.2472222 0.279669 7.2500000 0.278785 7.2527778 0.278490 7.2555556 0.279079 7.2583333 0.279374 7.2611111 0.279669 7.2638889 0.278785 7.2666667 0.278195 7.2694444 0.277901 7.2722222 0.277606 7.2750000 0.276427 7.2777778 0.273775 7.2805556 0.271713 7.2833333 0.269945 7.2861111 0.268471 7.2888889 0.266409 7.2916667 0.267587 7.2944444 0.272302 7.2972222 0.279669 7.3000000 0.287330 7.3027778 0.296759 7.3055556 0.309724 7.3083333 0.326225 7.3111111 0.341547 7.3138889 0.350092 7.3166667 0.352449 7.3194444 0.347735 7.3222222 0.331234 7.3250000 0.308545 7.3277778 0.286446 7.3305556 0.273186 7.3333333 0.269945 7.3361111 0.272302 7.3388889 0.274954 7.3416667 0.277311 7.3444444 0.277017 7.3472222 0.277606 7.3500000 0.276722 7.3527778 0.276722 7.3555556 0.277017 7.3583333 0.277606 7.3611111 0.277017 7.3638889 0.277311 7.3666667 0.277017 7.3694444 0.276133 7.3722222 0.276722 7.3750000 0.277017 7.3777778 0.277606 7.3805556 0.277017 7.3833333 0.276427 7.3861111 0.276133 7.3888889 0.277017 7.3916667 0.277901 7.3944444 0.277901 7.3972222 0.277606 7.4000000 0.277311 7.4027778 0.276722 7.4055556 0.277017 7.4083333 0.277606 7.4111111 0.277311 7.4138889 0.277606 7.4166667 0.277311 7.4194444 0.277017 7.4222222 0.277606 7.4250000 0.277606 7.4277778 0.278490 7.4305556 0.277901 7.4333333 0.277311 7.4361111 0.277606 7.4388889 0.277606 7.4416667 0.278490 7.4444444 0.278490 7.4472222 0.277901 7.4500000 0.277606 7.4527778 0.277017 7.4555556 0.277311 7.4583333 0.277606 7.4611111 0.277901 7.4638889 0.277901 7.4666667 0.277606 7.4694444 0.277606 7.4722222 0.277901 7.4750000 0.278195 7.4777778 0.278490 7.4805556 0.277901 7.4833333 0.277311 7.4861111 0.277901 7.4888889 0.278195 7.4916667 0.278490 7.4944444 0.279079 7.4972222 0.278785 7.5000000 0.277606 7.5027778 0.277901 7.5055556 0.277901 7.5083333 0.278785 7.5111111 0.279079 7.5138889 0.278490 7.5166667 0.278195 7.5194444 0.277901 7.5222222 0.277901 7.5250000 0.278785 7.5277778 0.278195 7.5305556 0.278785 7.5333333 0.278490 7.5361111 0.277606 7.5388889 0.277901 7.5416667 0.278490 7.5444444 0.278195 7.5472222 0.277606 7.5500000 0.277606 7.5527778 0.277311 7.5555556 0.277606 7.5583333 0.277901 7.5611111 0.277606 7.5638889 0.277311 7.5666667 0.277311 7.5694444 0.277017 7.5722222 0.277017 7.5750000 0.277901 7.5777778 0.277606 7.5805556 0.277017 7.5833333 0.277017 7.5861111 0.276427 7.5888889 0.277311 7.5916667 0.277606 7.5944444 0.278195 7.5972222 0.278195 7.6000000 0.278785 7.6027778 0.278785 7.6055556 0.279374 7.6083333 0.279963 7.6111111 0.281142 7.6168889 0.300000 7.8636667 0.300000 7.8666667 0.280552 7.8694444 0.280258 7.8722222 0.279963 7.8750000 0.280258 7.8777778 0.280258 7.8805556 0.280552 7.8833333 0.279669 7.8861111 0.280258 7.8888889 0.280552 7.8916667 0.281436 7.8944444 0.281142 7.8972222 0.281142 7.9000000 0.280258 7.9027778 0.280847 7.9055556 0.281436 7.9083333 0.282320 7.9111111 0.283794 7.9138889 0.284088 7.9166667 0.284088 7.9194444 0.283499 7.9222222 0.284088 7.9250000 0.284972 7.9277778 0.285856 7.9305556 0.285856 7.9333333 0.286151 7.9361111 0.286151 7.9388889 0.287035 7.9416667 0.287624 7.9444444 0.287035 7.9472222 0.285856 7.9500000 0.285856 7.9527778 0.284678 7.9555556 0.285856 7.9583333 0.285856 7.9611111 0.286446 7.9638889 0.286151 7.9666667 0.286151 7.9694444 0.285856 7.9722222 0.286446 7.9750000 0.286151 7.9777778 0.286151 7.9805556 0.284972 7.9833333 0.284972 7.9861111 0.285267 7.9888889 0.287035 7.9916667 0.287919 7.9944444 0.287330 7.9972222 0.285267 8.0000000 0.282910 8.0027778 0.282615 8.0055556 0.281436 8.0083333 0.281142 8.0111111 0.279963 8.0138889 0.279374 8.0166667 0.279374 8.0194444 0.279079 8.0222222 0.279079 8.0250000 0.280847 8.0277778 0.280847 8.0305556 0.279963 8.0333333 0.278490 8.0361111 0.278490 8.0388889 0.278490 8.0416667 0.279079 8.0444444 0.278785 8.0472222 0.278490 8.0500000 0.278195 8.0527778 0.278785 8.0555556 0.278785 8.0583333 0.278785 8.0611111 0.279374 8.0638889 0.278490 8.0666667 0.277901 8.0694444 0.277901 8.0722222 0.277606 8.0750000 0.276722 8.0777778 0.274659 8.0805556 0.271713 8.0833333 0.270239 8.0861111 0.268471 8.0888889 0.265525 8.0916667 0.264641 8.0944444 0.267587 8.0972222 0.274659 8.1000000 0.281731 8.1027778 0.290571 8.1055556 0.303536 8.1083333 0.320331 8.1111111 0.335064 8.1138889 0.345083 8.1166667 0.350681 8.1194444 0.351860 8.1222222 0.346851 8.1250000 0.331823 8.1277778 0.310902 8.1305556 0.288803 8.1333333 0.275543 8.1361111 0.269061 8.1388889 0.269650 8.1416667 0.272891 8.1444444 0.275249 8.1472222 0.275838 8.1500000 0.275249 8.1527778 0.274070 8.1555556 0.275249 8.1583333 0.276427 8.1611111 0.276133 8.1638889 0.275838 8.1666667 0.274659 8.1694444 0.275838 8.1722222 0.276133 8.1750000 0.275838 8.1777778 0.276133 8.1805556 0.275249 8.1833333 0.274954 8.1861111 0.274954 8.1888889 0.275543 8.1916667 0.276133 8.1944444 0.275838 8.1972222 0.275249 8.2000000 0.274659 8.2027778 0.274954 8.2055556 0.275249 8.2083333 0.275543 8.2111111 0.275838 8.2138889 0.275543 8.2166667 0.275543 8.2194444 0.274659 8.2222222 0.275838 8.2250000 0.276427 8.2277778 0.275543 8.2305556 0.274659 8.2333333 0.274659 8.2361111 0.274365 8.2388889 0.274954 8.2416667 0.275543 8.2444444 0.275838 8.2472222 0.275249 8.2500000 0.275249 8.2527778 0.274954 8.2555556 0.274954 8.2583333 0.275249 8.2611111 0.274954 8.2638889 0.275249 8.2666667 0.274954 8.2694444 0.274365 8.2722222 0.274659 8.2750000 0.275249 8.2777778 0.274659 8.2805556 0.274659 8.2833333 0.274954 8.2861111 0.274954 8.2888889 0.274954 8.2916667 0.275838 8.2944444 0.275838 8.2972222 0.276133 8.3000000 0.275249 8.3027778 0.275249 8.3055556 0.276133 8.3083333 0.275543 8.3111111 0.275543 8.3138889 0.274954 8.3166667 0.274659 8.3194444 0.273775 8.3222222 0.274365 8.3250000 0.275249 8.3277778 0.275249 8.3305556 0.274954 8.3333333 0.274070 8.3361111 0.274070 8.3388889 0.273775 8.3416667 0.274954 8.3444444 0.274954 8.3472222 0.273481 8.3500000 0.273775 8.3527778 0.273481 8.3555556 0.273481 8.3583333 0.273775 8.3611111 0.274365 8.3638889 0.273481 8.3666667 0.272891 8.3694444 0.272597 8.3722222 0.272597 8.3750000 0.273186 8.3777778 0.273481 8.3805556 0.272891 8.3833333 0.272007 8.3861111 0.272007 8.3888889 0.272007 8.3916667 0.272891 8.3944444 0.273481 8.3972222 0.273775 8.4000000 0.274070 8.4027778 0.274070 8.4055556 0.274954 8.4083333 0.275543 8.4111111 0.276427 8.4138889 0.277017 8.4196667 0.300000 8.6414444 0.300000 8.6444444 0.278195 8.6472222 0.278195 8.6500000 0.277606 8.6527778 0.276427 8.6555556 0.278195 8.6583333 0.278195 8.6611111 0.278785 8.6638889 0.278195 8.6666667 0.277901 8.6694444 0.277606 8.6722222 0.277606 8.6750000 0.278490 8.6777778 0.279374 8.6805556 0.279669 8.6833333 0.280258 8.6861111 0.279963 8.6888889 0.280847 8.6916667 0.280847 8.6944444 0.280847 8.6972222 0.281142 8.7000000 0.280552 8.7027778 0.280847 8.7055556 0.281436 8.7083333 0.282910 8.7111111 0.282910 8.7138889 0.283204 8.7166667 0.283204 8.7194444 0.283499 8.7222222 0.284383 8.7250000 0.284383 8.7277778 0.284678 8.7305556 0.283499 8.7333333 0.283204 8.7361111 0.282026 8.7388889 0.282615 8.7416667 0.283794 8.7444444 0.284383 8.7472222 0.284088 8.7500000 0.283204 8.7527778 0.282026 8.7555556 0.282026 8.7583333 0.282026 8.7611111 0.282320 8.7638889 0.282910 8.7666667 0.282615 8.7694444 0.282320 8.7722222 0.281436 8.7750000 0.280552 8.7777778 0.279669 8.7805556 0.277901 8.7833333 0.277311 8.7861111 0.277017 8.7888889 0.277311 8.7916667 0.277606 8.7944444 0.277311 8.7972222 0.277017 8.8000000 0.277017 8.8027778 0.277017 8.8055556 0.277311 8.8083333 0.276722 8.8111111 0.276722 8.8138889 0.276722 8.8166667 0.274954 8.8194444 0.275543 8.8222222 0.275838 8.8250000 0.276722 8.8277778 0.276722 8.8305556 0.275838 8.8333333 0.276133 8.8361111 0.275543 8.8388889 0.276427 8.8416667 0.276722 8.8444444 0.276133 8.8472222 0.275543 8.8500000 0.274365 8.8527778 0.272302 8.8555556 0.270534 8.8583333 0.271123 8.8611111 0.270829 8.8638889 0.268471 8.8666667 0.264641 8.8694444 0.263757 8.8722222 0.266114 8.8750000 0.272007 8.8777778 0.279374 8.8805556 0.288803 8.8833333 0.300295 8.8861111 0.315617 8.8888889 0.333297 8.8916667 0.345967 8.8944444 0.350681 8.8972222 0.343315 8.9000000 0.323573 8.9027778 0.298527 8.9055556 0.278785 8.9083333 0.271123 8.9111111 0.269061 8.9138889 0.270534 8.9166667 0.272891 8.9194444 0.273775 8.9222222 0.274070 8.9250000 0.274659 8.9277778 0.275543 8.9305556 0.275249 8.9333333 0.274954 8.9361111 0.273481 8.9388889 0.274659 8.9416667 0.274954 8.9444444 0.274954 8.9472222 0.274954 8.9500000 0.274070 8.9527778 0.274365 8.9555556 0.274659 8.9583333 0.274659 8.9611111 0.275543 8.9638889 0.274954 8.9666667 0.274954 8.9694444 0.274659 8.9722222 0.274365 8.9750000 0.275838 8.9777778 0.275543 8.9805556 0.274954 8.9833333 0.274659 8.9861111 0.274070 8.9888889 0.274070 8.9916667 0.275249 8.9944444 0.275249 8.9972222 0.275543 9.0000000 0.274954 9.0027778 0.274070 9.0055556 0.274365 9.0083333 0.275543 9.0111111 0.274659 9.0138889 0.275249 9.0166667 0.274659 9.0194444 0.274365 9.0222222 0.274365 9.0250000 0.274954 9.0277778 0.274954 9.0305556 0.274365 9.0333333 0.274070 9.0361111 0.274365 9.0388889 0.274659 9.0416667 0.274659 9.0444444 0.275249 9.0472222 0.274659 9.0500000 0.274365 9.0527778 0.274070 9.0555556 0.274659 9.0583333 0.275249 9.0611111 0.275249 9.0638889 0.275838 9.0666667 0.274659 9.0694444 0.275249 9.0722222 0.275249 9.0750000 0.275838 9.0777778 0.275543 9.0805556 0.274954 9.0833333 0.275249 9.0861111 0.274365 9.0888889 0.274659 9.0916667 0.275249 9.0944444 0.274659 9.0972222 0.274954 9.1000000 0.274659 9.1027778 0.274365 9.1055556 0.274365 9.1083333 0.274659 9.1111111 0.274659 9.1138889 0.273481 9.1166667 0.273186 9.1194444 0.273186 9.1222222 0.273481 9.1250000 0.272597 9.1277778 0.273481 9.1305556 0.272891 9.1333333 0.272597 9.1361111 0.272597 9.1388889 0.273186 9.1416667 0.273186 9.1444444 0.272891 9.1472222 0.272891 9.1500000 0.272597 9.1527778 0.272007 9.1555556 0.272597 9.1583333 0.274070 9.1611111 0.274365 9.1638889 0.274365 9.1666667 0.275249 9.1694444 0.275543 9.1722222 0.276722 9.1750000 0.277901 9.1777778 0.278785 9.1805556 0.279079 9.1833333 0.279079 9.1861111 0.279079 9.1888889 0.279963 9.1916667 0.280847 9.1974444 0.300000 9.4275556 0.300000 9.4305556 0.281731 9.4333333 0.281731 9.4361111 0.281436 9.4388889 0.281142 9.4416667 0.281731 9.4444444 0.281436 9.4472222 0.282026 9.4500000 0.281142 9.4527778 0.280847 9.4555556 0.282026 9.4583333 0.282910 9.4611111 0.282910 9.4638889 0.283204 9.4666667 0.282910 9.4694444 0.283204 9.4722222 0.284383 9.4750000 0.284972 9.4777778 0.286151 9.4805556 0.285856 9.4833333 0.286151 9.4861111 0.285856 9.4888889 0.286151 9.4916667 0.287035 9.4944444 0.287919 9.4972222 0.287330 9.5000000 0.288508 9.5027778 0.288214 9.5055556 0.288803 9.5083333 0.288803 9.5111111 0.288803 9.5138889 0.288508 9.5166667 0.288214 9.5194444 0.287330 9.5222222 0.287330 9.5250000 0.288214 9.5277778 0.287624 9.5305556 0.286446 9.5333333 0.286740 9.5361111 0.286446 9.5388889 0.286151 9.5416667 0.285856 9.5444444 0.286740 9.5472222 0.287624 9.5500000 0.287919 9.5527778 0.287624 9.5555556 0.286740 9.5583333 0.285267 9.5611111 0.284678 9.5638889 0.283794 9.5666667 0.282320 9.5694444 0.281436 9.5722222 0.280847 9.5750000 0.280847 9.5777778 0.281436 9.5805556 0.281142 9.5833333 0.280847 9.5861111 0.280258 9.5888889 0.280847 9.5916667 0.281142 9.5944444 0.281142 9.5972222 0.280552 9.6000000 0.280258 9.6027778 0.279669 9.6055556 0.279963 9.6083333 0.280258 9.6111111 0.279963 9.6138889 0.279669 9.6166667 0.279079 9.6194444 0.278785 9.6222222 0.279374 9.6250000 0.279374 9.6277778 0.279669 9.6305556 0.278490 9.6333333 0.277606 9.6361111 0.275543 9.6388889 0.274070 9.6416667 0.272597 9.6444444 0.271713 9.6472222 0.269945 9.6500000 0.266998 9.6527778 0.264346 9.6555556 0.265820 9.6583333 0.271123 9.6611111 0.277606 9.6638889 0.285267 9.6666667 0.291160 9.6694444 0.298821 9.6722222 0.312081 9.6750000 0.328287 9.6777778 0.343315 9.6805556 0.354217 9.6833333 0.357753 9.6861111 0.352744 9.6888889 0.336832 9.6916667 0.311786 9.6944444 0.287919 9.6972222 0.273186 9.7000000 0.270829 9.7027778 0.272891 9.7055556 0.275838 9.7083333 0.278490 9.7111111 0.277606 9.7138889 0.277311 9.7166667 0.277606 9.7194444 0.276722 9.7222222 0.277606 9.7250000 0.277901 9.7277778 0.277311 9.7305556 0.277017 9.7333333 0.276722 9.7361111 0.276133 9.7388889 0.277017 9.7416667 0.277606 9.7444444 0.277901 9.7472222 0.277017 9.7500000 0.276427 9.7527778 0.276133 9.7555556 0.276722 9.7583333 0.277311 9.7611111 0.277311 9.7638889 0.276722 9.7666667 0.276722 9.7694444 0.275543 9.7722222 0.277017 9.7750000 0.277606 9.7777778 0.277606 9.7805556 0.277606 9.7833333 0.277017 9.7861111 0.276722 9.7888889 0.277311 9.7916667 0.277606 9.7944444 0.277606 9.7972222 0.277311 9.8000000 0.277017 9.8027778 0.276427 9.8055556 0.276722 9.8083333 0.277606 9.8111111 0.277311 9.8138889 0.277311 9.8166667 0.277311 9.8194444 0.276722 9.8222222 0.277311 9.8250000 0.277606 9.8277778 0.277311 9.8305556 0.277311 9.8333333 0.276722 9.8361111 0.276133 9.8388889 0.277017 9.8416667 0.277311 9.8444444 0.278195 9.8472222 0.277311 9.8500000 0.277017 9.8527778 0.276133 9.8555556 0.277017 9.8583333 0.277606 9.8611111 0.277606 9.8638889 0.277606 9.8666667 0.277017 9.8694444 0.277017 9.8722222 0.277017 9.8750000 0.277606 9.8777778 0.278785 9.8805556 0.278195 9.8833333 0.277606 9.8861111 0.277606 9.8888889 0.276427 9.8916667 0.277901 9.8944444 0.277606 9.8972222 0.277311 9.9000000 0.276722 9.9027778 0.276427 9.9055556 0.276427 9.9083333 0.276427 9.9111111 0.276722 9.9138889 0.276722 9.9166667 0.277017 9.9194444 0.276427 9.9222222 0.277311 9.9250000 0.277311 9.9277778 0.276722 9.9305556 0.277017 9.9333333 0.276427 9.9361111 0.276427 9.9388889 0.276722 9.9416667 0.276722 9.9444444 0.276427 9.9472222 0.276722 9.9500000 0.276427 9.9527778 0.276722 9.9555556 0.277017 9.9583333 0.278195 9.9611111 0.278195 9.9638889 0.277901 9.9666667 0.278195 9.9694444 0.278490 9.9722222 0.279374 9.9750000 0.280258 9.9777778 0.280552 9.9835556 0.300000 10.2275556 0.300000 10.2305556 0.281436 10.2333333 0.281436 10.2361111 0.281142 10.2388889 0.281142 10.2416667 0.281731 10.2444444 0.282026 10.2472222 0.282026 10.2500000 0.281142 10.2527778 0.281436 10.2555556 0.281436 10.2583333 0.282320 10.2611111 0.282910 10.2638889 0.282910 10.2666667 0.283204 10.2694444 0.282910 10.2722222 0.284088 10.2750000 0.285562 10.2777778 0.285562 10.2805556 0.285562 10.2833333 0.284678 10.2861111 0.284383 10.2888889 0.285562 10.2916667 0.286740 10.2944444 0.287330 10.2972222 0.287624 10.3000000 0.288214 10.3027778 0.287035 10.3055556 0.287330 10.3083333 0.287624 10.3111111 0.287330 10.3138889 0.287330 10.3166667 0.286740 10.3194444 0.285856 10.3222222 0.286151 10.3250000 0.287330 10.3277778 0.287035 10.3305556 0.286151 10.3333333 0.286446 10.3361111 0.286446 10.3388889 0.288214 10.3416667 0.289098 10.3444444 0.288508 10.3472222 0.286151 10.3500000 0.284678 10.3527778 0.283794 10.3555556 0.282910 10.3583333 0.283204 10.3611111 0.282320 10.3638889 0.282026 10.3666667 0.280847 10.3694444 0.280258 10.3722222 0.280552 10.3750000 0.281436 10.3777778 0.280847 10.3805556 0.281142 10.3833333 0.279669 10.3861111 0.279374 10.3888889 0.280847 10.3916667 0.281142 10.3944444 0.280847 10.3972222 0.281142 10.4000000 0.280552 10.4027778 0.280258 10.4055556 0.280258 10.4083333 0.280258 10.4111111 0.281436 10.4138889 0.280258 10.4166667 0.280258 10.4194444 0.279669 10.4222222 0.280258 10.4250000 0.280258 10.4277778 0.280552 10.4305556 0.280258 10.4333333 0.279963 10.4361111 0.279374 10.4388889 0.277606 10.4416667 0.275838 10.4444444 0.274070 10.4472222 0.272302 10.4500000 0.270534 10.4527778 0.268471 10.4555556 0.267293 10.4583333 0.270829 10.4611111 0.276722 10.4638889 0.284972 10.4666667 0.293517 10.4694444 0.303536 10.4722222 0.319742 10.4750000 0.336538 10.4777778 0.349208 10.4805556 0.355101 10.4833333 0.353039 10.4861111 0.339779 10.4888889 0.316796 10.4916667 0.294696 10.4944444 0.278785 10.4972222 0.272007 10.5000000 0.271713 10.5027778 0.274365 10.5055556 0.277606 10.5083333 0.279669 10.5111111 0.279374 10.5138889 0.278195 10.5166667 0.278490 10.5194444 0.278195 10.5222222 0.278490 10.5250000 0.278195 10.5277778 0.278195 10.5305556 0.278195 10.5333333 0.277311 10.5361111 0.277311 10.5388889 0.277606 10.5416667 0.277606 10.5444444 0.278195 10.5472222 0.277901 10.5500000 0.277311 10.5527778 0.277017 10.5555556 0.277606 10.5583333 0.278195 10.5611111 0.277311 10.5638889 0.277901 10.5666667 0.278195 10.5694444 0.277901 10.5722222 0.278195 10.5750000 0.278785 10.5777778 0.278490 10.5805556 0.278195 10.5833333 0.277606 10.5861111 0.277017 10.5888889 0.278195 10.5916667 0.278490 10.5944444 0.278785 10.5972222 0.278490 10.6000000 0.277901 10.6027778 0.277311 10.6055556 0.277017 10.6083333 0.277901 10.6111111 0.278490 10.6138889 0.278785 10.6166667 0.277901 10.6194444 0.277311 10.6222222 0.277311 10.6250000 0.278785 10.6277778 0.278785 10.6305556 0.278195 10.6333333 0.277901 10.6361111 0.277606 10.6388889 0.278195 10.6416667 0.278785 10.6444444 0.279079 10.6472222 0.278490 10.6500000 0.278785 10.6527778 0.278195 10.6555556 0.278490 10.6583333 0.278785 10.6611111 0.279669 10.6638889 0.279079 10.6666667 0.278785 10.6694444 0.278195 10.6722222 0.278785 10.6750000 0.279374 10.6777778 0.279079 10.6805556 0.278785 10.6833333 0.277606 10.6861111 0.277901 10.6888889 0.278785 10.6916667 0.279079 10.6944444 0.279079 10.6972222 0.278785 10.7000000 0.277606 10.7027778 0.277901 10.7055556 0.278490 10.7083333 0.279079 10.7111111 0.278785 10.7138889 0.278785 10.7166667 0.278490 10.7194444 0.277311 10.7222222 0.277606 10.7250000 0.278195 10.7277778 0.278785 10.7305556 0.278195 10.7333333 0.277901 10.7361111 0.277311 10.7388889 0.278490 10.7416667 0.277901 10.7444444 0.278195 10.7472222 0.278195 10.7500000 0.277606 10.7527778 0.277606 10.7555556 0.278490 10.7583333 0.278785 10.7611111 0.278785 10.7638889 0.278490 10.7666667 0.277606 10.7694444 0.278195 10.7722222 0.279374 10.7750000 0.280552 10.7777778 0.281436 10.7835556 0.300000 11.0247778 0.300000 11.0277778 0.282026 11.0305556 0.282026 11.0333333 0.281142 11.0361111 0.280552 11.0388889 0.281436 11.0416667 0.281142 11.0444444 0.281436 11.0472222 0.280847 11.0500000 0.280847 11.0527778 0.280552 11.0555556 0.282026 11.0583333 0.282320 11.0611111 0.282615 11.0638889 0.283204 11.0666667 0.284088 11.0694444 0.283499 11.0722222 0.284088 11.0750000 0.284678 11.0777778 0.284972 11.0805556 0.284678 11.0833333 0.285267 11.0861111 0.285267 11.0888889 0.285856 11.0916667 0.286740 11.0944444 0.287624 11.0972222 0.287919 11.1000000 0.287330 11.1027778 0.287035 11.1055556 0.287035 11.1083333 0.287330 11.1111111 0.285856 11.1138889 0.285267 11.1166667 0.284678 11.1194444 0.285856 11.1222222 0.285856 11.1250000 0.285562 11.1277778 0.285562 11.1305556 0.286151 11.1333333 0.286740 11.1361111 0.287035 11.1388889 0.287330 11.1416667 0.285856 11.1444444 0.285267 11.1472222 0.284088 11.1500000 0.282615 11.1527778 0.281436 11.1555556 0.279963 11.1583333 0.280258 11.1611111 0.280258 11.1638889 0.279669 11.1666667 0.279669 11.1694444 0.279079 11.1722222 0.279669 11.1750000 0.280552 11.1777778 0.280258 11.1805556 0.279669 11.1833333 0.278785 11.1861111 0.279079 11.1888889 0.279079 11.1916667 0.279963 11.1944444 0.279963 11.1972222 0.280258 11.2000000 0.279963 11.2027778 0.278785 11.2055556 0.279374 11.2083333 0.279963 11.2111111 0.279669 11.2138889 0.279963 11.2166667 0.279374 11.2194444 0.278785 11.2222222 0.278785 11.2250000 0.279374 11.2277778 0.279374 11.2305556 0.279374 11.2333333 0.278195 11.2361111 0.276133 11.2388889 0.274365 11.2416667 0.273186 11.2444444 0.272302 11.2472222 0.269355 11.2500000 0.266703 11.2527778 0.266114 11.2555556 0.270534 11.2583333 0.277311 11.2611111 0.285562 11.2638889 0.294107 11.2666667 0.306188 11.2694444 0.320626 11.2722222 0.335064 11.2750000 0.345967 11.2777778 0.350387 11.2805556 0.344788 11.2833333 0.330055 11.2861111 0.306777 11.2888889 0.287330 11.2916667 0.276427 11.2944444 0.272007 11.2972222 0.271418 11.3000000 0.273481 11.3027778 0.275249 11.3055556 0.276133 11.3083333 0.277017 11.3111111 0.276722 11.3138889 0.276722 11.3166667 0.277311 11.3194444 0.277017 11.3222222 0.276427 11.3250000 0.276427 11.3277778 0.277017 11.3305556 0.276722 11.3333333 0.276427 11.3361111 0.275543 11.3388889 0.277017 11.3416667 0.277311 11.3444444 0.277901 11.3472222 0.277606 11.3500000 0.276722 11.3527778 0.275838 11.3555556 0.275838 11.3583333 0.276133 11.3611111 0.276722 11.3638889 0.277017 11.3666667 0.276427 11.3694444 0.275249 11.3722222 0.275838 11.3750000 0.276427 11.3777778 0.276722 11.3805556 0.276133 11.3833333 0.275838 11.3861111 0.275543 11.3888889 0.275838 11.3916667 0.276133 11.3944444 0.276427 11.3972222 0.276722 11.4000000 0.275543 11.4027778 0.275543 11.4055556 0.275838 11.4083333 0.275838 11.4111111 0.276427 11.4138889 0.276722 11.4166667 0.275543 11.4194444 0.275249 11.4222222 0.275838 11.4250000 0.276427 11.4277778 0.277017 11.4305556 0.276427 11.4333333 0.275838 11.4361111 0.275838 11.4388889 0.276427 11.4416667 0.276722 11.4444444 0.277017 11.4472222 0.276722 11.4500000 0.276133 11.4527778 0.276427 11.4555556 0.275543 11.4583333 0.275838 11.4611111 0.276133 11.4638889 0.276722 11.4666667 0.276427 11.4694444 0.275838 11.4722222 0.275838 11.4750000 0.276133 11.4777778 0.277017 11.4805556 0.276722 11.4833333 0.276427 11.4861111 0.276427 11.4888889 0.276427 11.4916667 0.276133 11.4944444 0.276133 11.4972222 0.275543 11.5000000 0.275543 11.5027778 0.275249 11.5055556 0.275249 11.5083333 0.275543 11.5111111 0.276427 11.5138889 0.275543 11.5166667 0.274954 11.5194444 0.274070 11.5222222 0.274954 11.5250000 0.275838 11.5277778 0.275543 11.5305556 0.275249 11.5333333 0.274954 11.5361111 0.274365 11.5388889 0.274070 11.5416667 0.274365 11.5444444 0.274659 11.5472222 0.274070 11.5500000 0.274070 11.5527778 0.273186 11.5555556 0.273481 11.5583333 0.273186 11.5611111 0.273186 11.5638889 0.273775 11.5666667 0.273186 11.5694444 0.273186 11.5722222 0.274365 11.5750000 0.275543 11.5807778 0.300000 11.8386667 0.300000 11.8416667 0.278785 11.8444444 0.279079 11.8472222 0.279669 11.8500000 0.278785 11.8527778 0.278195 11.8555556 0.277901 11.8583333 0.278490 11.8611111 0.279374 11.8638889 0.279669 11.8666667 0.279374 11.8694444 0.278490 11.8722222 0.279374 11.8750000 0.279669 11.8777778 0.279669 11.8805556 0.281142 11.8833333 0.281142 11.8861111 0.281436 11.8888889 0.281731 11.8916667 0.282615 11.8944444 0.282615 11.8972222 0.282615 11.9000000 0.282910 11.9027778 0.282910 11.9055556 0.283794 11.9083333 0.284088 11.9111111 0.285267 11.9138889 0.284972 11.9166667 0.283794 11.9194444 0.283499 11.9222222 0.283794 11.9250000 0.283794 11.9277778 0.284383 11.9305556 0.283794 11.9333333 0.283794 11.9361111 0.283499 11.9388889 0.283204 11.9416667 0.282910 11.9444444 0.283499 11.9472222 0.284383 11.9500000 0.284088 11.9527778 0.284678 11.9555556 0.283794 11.9583333 0.283204 11.9611111 0.282320 11.9638889 0.280847 11.9666667 0.279374 11.9694444 0.277901 11.9722222 0.278195 11.9750000 0.277901 11.9777778 0.278195 11.9805556 0.277017 11.9833333 0.277017 11.9861111 0.275838 11.9888889 0.276722 11.9916667 0.277606 11.9944444 0.278195 11.9972222 0.277311 12.0000000 0.277311 12.0027778 0.276427 12.0055556 0.277017 12.0083333 0.277017 12.0111111 0.277901 12.0138889 0.277311 12.0166667 0.277311 12.0194444 0.276722 12.0222222 0.277017 12.0250000 0.277606 12.0277778 0.277901 12.0305556 0.277901 12.0333333 0.277311 12.0361111 0.277017 12.0388889 0.277017 12.0416667 0.277311 12.0444444 0.276427 12.0472222 0.274070 12.0500000 0.272302 12.0527778 0.270534 12.0555556 0.270829 12.0583333 0.270239 12.0611111 0.267587 12.0638889 0.264936 12.0666667 0.264936 12.0694444 0.269061 12.0722222 0.276133 12.0750000 0.283499 12.0777778 0.291455 12.0805556 0.302063 12.0833333 0.316206 12.0861111 0.330939 12.0888889 0.343904 12.0916667 0.350092 12.0944444 0.348029 12.0972222 0.334475 12.1000000 0.312081 12.1027778 0.289687 12.1055556 0.276722 12.1083333 0.271713 12.1111111 0.271123 12.1138889 0.272302 12.1166667 0.274659 12.1194444 0.274954 12.1222222 0.275838 12.1250000 0.275838 12.1277778 0.276722 12.1305556 0.276427 12.1333333 0.276427 12.1361111 0.275543 12.1388889 0.276133 12.1416667 0.276133 12.1444444 0.276133 12.1472222 0.275838 12.1500000 0.275543 12.1527778 0.275249 12.1555556 0.275838 12.1583333 0.275838 12.1611111 0.276133 12.1638889 0.276722 12.1666667 0.276427 12.1694444 0.275838 12.1722222 0.276427 12.1750000 0.276133 12.1777778 0.276427 12.1805556 0.276427 12.1833333 0.276427 12.1861111 0.275838 12.1888889 0.276133 12.1916667 0.276722 12.1944444 0.277311 12.1972222 0.276133 12.2000000 0.275838 12.2027778 0.275543 12.2055556 0.275838 12.2083333 0.276427 12.2111111 0.276722 12.2138889 0.276722 12.2166667 0.276722 12.2194444 0.275838 12.2222222 0.276133 12.2250000 0.276722 12.2277778 0.276427 12.2305556 0.277017 12.2333333 0.276427 12.2361111 0.275543 12.2388889 0.275838 12.2416667 0.276133 12.2444444 0.276722 12.2472222 0.276133 12.2500000 0.275838 12.2527778 0.274954 12.2555556 0.275838 12.2583333 0.275249 12.2611111 0.275838 12.2638889 0.275838 12.2666667 0.276133 12.2694444 0.275838 12.2722222 0.276133 12.2750000 0.276133 12.2777778 0.275838 12.2805556 0.277311 12.2833333 0.276427 12.2861111 0.275838 12.2888889 0.276133 12.2916667 0.277017 12.2944444 0.277017 12.2972222 0.277606 12.3000000 0.276722 12.3027778 0.275838 12.3055556 0.276133 12.3083333 0.276722 12.3111111 0.277017 12.3138889 0.276427 12.3166667 0.276722 12.3194444 0.275543 12.3222222 0.275543 12.3250000 0.275838 12.3277778 0.276133 12.3305556 0.275838 12.3333333 0.275543 12.3361111 0.274954 12.3388889 0.275249 12.3416667 0.274954 12.3444444 0.275543 12.3472222 0.274954 12.3500000 0.274954 12.3527778 0.274365 12.3555556 0.274070 12.3583333 0.274954 12.3611111 0.274954 12.3638889 0.274954 12.3666667 0.274365 12.3694444 0.273481 12.3722222 0.273481 12.3750000 0.274070 12.3777778 0.275249 12.3805556 0.274954 12.3833333 0.274659 12.3861111 0.274659 12.3888889 0.275543 12.3946667 0.300000 12.6858889 0.300000 12.6888889 0.281731 12.6916667 0.282320 12.6944444 0.282615 12.6972222 0.282320 12.7000000 0.282320 12.7027778 0.281731 12.7055556 0.282615 12.7083333 0.283499 12.7111111 0.284088 12.7138889 0.284678 12.7166667 0.284972 12.7194444 0.284383 12.7222222 0.285267 12.7250000 0.285267 12.7277778 0.286740 12.7305556 0.286151 12.7333333 0.286151 12.7361111 0.286151 12.7388889 0.286446 12.7416667 0.287330 12.7444444 0.287919 12.7472222 0.288803 12.7500000 0.287624 12.7527778 0.287330 12.7555556 0.288508 12.7583333 0.289098 12.7611111 0.288508 12.7638889 0.287624 12.7666667 0.287624 12.7694444 0.286446 12.7722222 0.287330 12.7750000 0.287624 12.7777778 0.287330 12.7805556 0.287330 12.7833333 0.287035 12.7861111 0.286446 12.7888889 0.285856 12.7916667 0.287035 12.7944444 0.288508 12.7972222 0.289098 12.8000000 0.287919 12.8027778 0.286446 12.8055556 0.284972 12.8083333 0.284972 12.8111111 0.284088 12.8138889 0.283204 12.8166667 0.282615 12.8194444 0.281142 12.8222222 0.281142 12.8250000 0.280552 12.8277778 0.280847 12.8305556 0.280552 12.8333333 0.280552 12.8361111 0.279963 12.8388889 0.280552 12.8416667 0.280258 12.8444444 0.280847 12.8472222 0.280847 12.8500000 0.279963 12.8527778 0.279669 12.8555556 0.280258 12.8583333 0.280847 12.8611111 0.280552 12.8638889 0.279963 12.8666667 0.279669 12.8694444 0.280258 12.8722222 0.279669 12.8750000 0.280552 12.8777778 0.280847 12.8805556 0.280552 12.8833333 0.279963 12.8861111 0.279079 12.8888889 0.279079 12.8916667 0.278785 12.8944444 0.278785 12.8972222 0.276133 12.9000000 0.273481 12.9027778 0.272007 12.9055556 0.272007 12.9083333 0.269945 12.9111111 0.267882 12.9138889 0.268766 12.9166667 0.273775 12.9194444 0.281436 12.9222222 0.290866 12.9250000 0.300295 12.9277778 0.312376 12.9305556 0.327698 12.9333333 0.342431 12.9361111 0.351271 12.9388889 0.356575 12.9416667 0.353628 12.9444444 0.338306 12.9472222 0.313554 12.9500000 0.290571 12.9527778 0.276133 12.9555556 0.272007 12.9583333 0.274070 12.9611111 0.277017 12.9638889 0.279374 12.9666667 0.279079 12.9694444 0.278195 12.9722222 0.278490 12.9750000 0.278490 12.9777778 0.278785 12.9805556 0.279374 12.9833333 0.278195 12.9861111 0.277606 12.9888889 0.277901 12.9916667 0.278785 12.9944444 0.279079 12.9972222 0.278490 13.0000000 0.277901 13.0027778 0.277606 13.0055556 0.278490 13.0083333 0.278785 13.0111111 0.278785 13.0138889 0.278490 13.0166667 0.278195 13.0194444 0.277311 13.0222222 0.277606 13.0250000 0.277901 13.0277778 0.278490 13.0305556 0.278195 13.0333333 0.277017 13.0361111 0.277017 13.0388889 0.277311 13.0416667 0.277606 13.0444444 0.278195 13.0472222 0.278490 13.0500000 0.277606 13.0527778 0.276722 13.0555556 0.277311 13.0583333 0.278195 13.0611111 0.278490 13.0638889 0.278490 13.0666667 0.277311 13.0694444 0.277311 13.0722222 0.277901 13.0750000 0.278490 13.0777778 0.278195 13.0805556 0.277901 13.0833333 0.277901 13.0861111 0.277901 13.0888889 0.278490 13.0916667 0.278195 13.0944444 0.278785 13.0972222 0.278490 13.1000000 0.278490 13.1027778 0.277901 13.1055556 0.277901 13.1083333 0.278490 13.1111111 0.278195 13.1138889 0.278195 13.1166667 0.278490 13.1194444 0.277606 13.1222222 0.277901 13.1250000 0.277606 13.1277778 0.277901 13.1305556 0.278195 13.1333333 0.278195 13.1361111 0.277606 13.1388889 0.278195 13.1416667 0.278490 13.1444444 0.278490 13.1472222 0.278785 13.1500000 0.278490 13.1527778 0.278195 13.1555556 0.278490 13.1583333 0.278785 13.1611111 0.279079 13.1638889 0.279374 13.1666667 0.279079 13.1694444 0.278195 13.1722222 0.278490 13.1750000 0.278785 13.1777778 0.279079 13.1805556 0.278785 13.1833333 0.277901 13.1861111 0.277311 13.1888889 0.277901 13.1916667 0.277311 13.1944444 0.278195 13.1972222 0.277311 13.2000000 0.277017 13.2027778 0.276722 13.2055556 0.277017 13.2083333 0.276722 13.2111111 0.277311 13.2138889 0.277017 13.2166667 0.277311 13.2194444 0.276722 13.2222222 0.277311 13.2250000 0.277606 13.2277778 0.278195 13.2305556 0.278490 13.2333333 0.278195 13.2361111 0.278195 13.2418889 0.300000 13.5108889 0.300000 13.5138889 0.281142 13.5166667 0.280552 13.5194444 0.279963 13.5222222 0.279963 13.5250000 0.280552 13.5277778 0.281436 13.5305556 0.281142 13.5333333 0.279963 13.5361111 0.279963 13.5388889 0.280552 13.5416667 0.281436 13.5444444 0.281436 13.5472222 0.282026 13.5500000 0.281731 13.5527778 0.281436 13.5555556 0.282320 13.5583333 0.283794 13.5611111 0.285267 13.5638889 0.284972 13.5666667 0.284972 13.5694444 0.284088 13.5722222 0.284383 13.5750000 0.285562 13.5777778 0.285856 13.5805556 0.286740 13.5833333 0.287035 13.5861111 0.286740 13.5888889 0.287035 13.5916667 0.287035 13.5944444 0.287330 13.5972222 0.287330 13.6000000 0.286446 13.6027778 0.285267 13.6055556 0.285856 13.6083333 0.286151 13.6111111 0.286151 13.6138889 0.286151 13.6166667 0.284972 13.6194444 0.284383 13.6222222 0.285856 13.6250000 0.287035 13.6277778 0.287624 13.6305556 0.285856 13.6333333 0.283794 13.6361111 0.282320 13.6388889 0.282026 13.6416667 0.281436 13.6444444 0.281142 13.6472222 0.280552 13.6500000 0.279374 13.6527778 0.278785 13.6555556 0.278195 13.6583333 0.279079 13.6611111 0.279374 13.6638889 0.279669 13.6666667 0.279669 13.6694444 0.279374 13.6722222 0.279669 13.6750000 0.279079 13.6777778 0.279079 13.6805556 0.279079 13.6833333 0.278785 13.6861111 0.277606 13.6888889 0.277901 13.6916667 0.278195 13.6944444 0.278785 13.6972222 0.279079 13.7000000 0.278490 13.7027778 0.278195 13.7055556 0.278490 13.7083333 0.277901 13.7111111 0.278195 13.7138889 0.278195 13.7166667 0.276722 13.7194444 0.276133 13.7222222 0.276133 13.7250000 0.275838 13.7277778 0.273775 13.7305556 0.272007 13.7333333 0.269355 13.7361111 0.266703 13.7388889 0.264641 13.7416667 0.266409 13.7444444 0.271123 13.7472222 0.280258 13.7500000 0.289392 13.7527778 0.301768 13.7555556 0.320037 13.7583333 0.335948 13.7611111 0.346262 13.7638889 0.346851 13.7666667 0.336538 13.7694444 0.315322 13.7722222 0.291455 13.7750000 0.276133 13.7777778 0.270534 13.7805556 0.271418 13.7833333 0.273186 13.7861111 0.275249 13.7888889 0.274954 13.7916667 0.275838 13.7944444 0.275543 13.7972222 0.276427 13.8000000 0.275543 13.8027778 0.274659 13.8055556 0.274954 13.8083333 0.274954 13.8111111 0.274954 13.8138889 0.275249 13.8166667 0.275249 13.8194444 0.274659 13.8222222 0.274659 13.8250000 0.275543 13.8277778 0.275838 13.8305556 0.276133 13.8333333 0.275838 13.8361111 0.275543 13.8388889 0.274954 13.8416667 0.275543 13.8444444 0.275838 13.8472222 0.275543 13.8500000 0.274659 13.8527778 0.273775 13.8555556 0.274365 13.8583333 0.274954 13.8611111 0.275543 13.8638889 0.274954 13.8666667 0.274365 13.8694444 0.274070 13.8722222 0.274070 13.8750000 0.274365 13.8777778 0.275543 13.8805556 0.275249 13.8833333 0.274659 13.8861111 0.274365 13.8888889 0.274659 13.8916667 0.274954 13.8944444 0.276133 13.8972222 0.275543 13.9000000 0.274659 13.9027778 0.274954 13.9055556 0.275249 13.9083333 0.275838 13.9111111 0.276133 13.9138889 0.276133 13.9166667 0.274954 13.9194444 0.274365 13.9222222 0.274954 13.9250000 0.275249 13.9277778 0.275543 13.9305556 0.274954 13.9333333 0.274659 13.9361111 0.273775 13.9388889 0.273775 13.9416667 0.274659 13.9444444 0.275249 13.9472222 0.274954 13.9500000 0.274954 13.9527778 0.274070 13.9555556 0.274659 13.9583333 0.274954 13.9611111 0.275249 13.9638889 0.275249 13.9666667 0.275249 13.9694444 0.274365 13.9722222 0.274365 13.9750000 0.274954 13.9777778 0.275249 13.9805556 0.275249 13.9833333 0.274659 13.9861111 0.274659 13.9888889 0.275249 13.9916667 0.274954 13.9944444 0.274365 13.9972222 0.274070 14.0000000 0.274070 14.0027778 0.272597 14.0055556 0.272891 14.0083333 0.273186 14.0111111 0.273481 14.0138889 0.273481 14.0166667 0.273186 14.0194444 0.272597 14.0222222 0.273186 14.0250000 0.273186 14.0277778 0.273186 14.0305556 0.272891 14.0333333 0.273186 14.0361111 0.272302 14.0388889 0.272891 14.0416667 0.273481 14.0444444 0.274365 14.0472222 0.274070 14.0500000 0.275249 14.0527778 0.275543 14.0555556 0.276722 14.0583333 0.277901 14.0611111 0.278195 14.0668889 0.300000 14.2858889 0.300000 14.2888889 0.276722 14.2916667 0.276722 14.2944444 0.277311 14.2972222 0.277017 14.3000000 0.277017 14.3027778 0.276722 14.3055556 0.277311 14.3083333 0.277311 14.3111111 0.277901 14.3138889 0.276427 14.3166667 0.276427 14.3194444 0.276133 14.3222222 0.276722 14.3250000 0.277017 14.3277778 0.277901 14.3305556 0.278785 14.3333333 0.279079 14.3361111 0.279079 14.3388889 0.279669 14.3416667 0.279374 14.3444444 0.279963 14.3472222 0.279963 14.3500000 0.280258 14.3527778 0.280552 14.3555556 0.281142 14.3583333 0.282026 14.3611111 0.282320 14.3638889 0.282615 14.3666667 0.282320 14.3694444 0.282026 14.3722222 0.281436 14.3750000 0.282026 14.3777778 0.282320 14.3805556 0.282026 14.3833333 0.281436 14.3861111 0.281142 14.3888889 0.281436 14.3916667 0.281436 14.3944444 0.282026 14.3972222 0.280847 14.4000000 0.279669 14.4027778 0.279079 14.4055556 0.281731 14.4083333 0.282615 14.4111111 0.282320 14.4138889 0.279963 14.4166667 0.278195 14.4194444 0.277017 14.4222222 0.275838 14.4250000 0.275838 14.4277778 0.275543 14.4305556 0.275838 14.4333333 0.274954 14.4361111 0.274365 14.4388889 0.274954 14.4416667 0.275838 14.4444444 0.275543 14.4472222 0.275249 14.4500000 0.274954 14.4527778 0.274070 14.4555556 0.274659 14.4583333 0.274365 14.4611111 0.275249 14.4638889 0.275249 14.4666667 0.274365 14.4694444 0.274070 14.4722222 0.274070 14.4750000 0.274365 14.4777778 0.274954 14.4805556 0.274954 14.4833333 0.273775 14.4861111 0.273186 14.4888889 0.272597 14.4916667 0.271418 14.4944444 0.269945 14.4972222 0.268766 14.5000000 0.266998 14.5027778 0.264641 14.5055556 0.261400 14.5083333 0.260221 14.5111111 0.260810 14.5138889 0.264052 14.5166667 0.267293 14.5194444 0.272302 14.5222222 0.278785 14.5250000 0.286151 14.5277778 0.296759 14.5305556 0.312081 14.5333333 0.329171 14.5361111 0.342136 14.5388889 0.348619 14.5416667 0.343610 14.5444444 0.324457 14.5472222 0.298527 14.5500000 0.277901 14.5527778 0.267882 14.5555556 0.266409 14.5583333 0.268177 14.5611111 0.271418 14.5638889 0.272302 14.5666667 0.272891 14.5694444 0.272302 14.5722222 0.272007 14.5750000 0.273186 14.5777778 0.273775 14.5805556 0.272891 14.5833333 0.272597 14.5861111 0.272302 14.5888889 0.272302 14.5916667 0.272597 14.5944444 0.272891 14.5972222 0.272597 14.6000000 0.272891 14.6027778 0.272302 14.6055556 0.272302 14.6083333 0.272597 14.6111111 0.272891 14.6138889 0.273186 14.6166667 0.272597 14.6194444 0.272007 14.6222222 0.272302 14.6250000 0.272891 14.6277778 0.274070 14.6305556 0.273186 14.6333333 0.272891 14.6361111 0.272597 14.6388889 0.272302 14.6416667 0.273186 14.6444444 0.274070 14.6472222 0.273775 14.6500000 0.273186 14.6527778 0.272597 14.6555556 0.272891 14.6583333 0.273481 14.6611111 0.273481 14.6638889 0.272891 14.6666667 0.273186 14.6694444 0.272302 14.6722222 0.272891 14.6750000 0.272891 14.6777778 0.272597 14.6805556 0.272891 14.6833333 0.272007 14.6861111 0.272302 14.6888889 0.272007 14.6916667 0.273186 14.6944444 0.273481 14.6972222 0.273186 14.7000000 0.273186 14.7027778 0.272597 14.7055556 0.273775 14.7083333 0.274365 14.7111111 0.274954 14.7138889 0.274365 14.7166667 0.274070 14.7194444 0.273775 14.7222222 0.273775 14.7250000 0.274070 14.7277778 0.273775 14.7305556 0.273775 14.7333333 0.273481 14.7361111 0.273186 14.7388889 0.272891 14.7416667 0.273481 14.7444444 0.273481 14.7472222 0.273481 14.7500000 0.272597 14.7527778 0.272007 14.7555556 0.272007 14.7583333 0.271418 14.7611111 0.272302 14.7638889 0.272597 14.7666667 0.272302 14.7694444 0.272007 14.7722222 0.271713 14.7750000 0.271713 14.7777778 0.272597 14.7805556 0.271713 14.7833333 0.271418 14.7861111 0.270534 14.7888889 0.270829 14.7916667 0.271418 14.7944444 0.271713 14.7972222 0.271713 14.8000000 0.271123 14.8027778 0.271418 14.8055556 0.272007 14.8083333 0.272597 14.8111111 0.273481 14.8138889 0.273481 14.8166667 0.273775 14.8194444 0.274070 14.8222222 0.275543 14.8250000 0.275543 14.8277778 0.277311 14.8305556 0.278195 14.8333333 0.277606 14.8361111 0.277311 14.8418889 0.300000 15.0470000 0.300000 15.0500000 0.278195 15.0527778 0.277901 15.0555556 0.277901 15.0583333 0.279079 15.0611111 0.279669 15.0638889 0.279079 15.0666667 0.278785 15.0694444 0.277606 15.0722222 0.278195 15.0750000 0.278490 15.0777778 0.278785 15.0805556 0.278785 15.0833333 0.278195 15.0861111 0.278490 15.0888889 0.278195 15.0916667 0.278490 15.0944444 0.279374 15.0972222 0.279669 15.1000000 0.279079 15.1027778 0.278785 15.1055556 0.279963 15.1083333 0.280847 15.1111111 0.282910 15.1138889 0.282615 15.1166667 0.282910 15.1194444 0.282320 15.1222222 0.282910 15.1250000 0.283499 15.1277778 0.284383 15.1305556 0.284383 15.1333333 0.284678 15.1361111 0.283794 15.1388889 0.284972 15.1416667 0.285267 15.1444444 0.285267 15.1472222 0.285267 15.1500000 0.284088 15.1527778 0.283204 15.1555556 0.283499 15.1583333 0.284383 15.1611111 0.284678 15.1638889 0.284088 15.1666667 0.282026 15.1694444 0.282026 15.1722222 0.282910 15.1750000 0.284972 15.1777778 0.286740 15.1805556 0.285562 15.1833333 0.284088 15.1861111 0.281436 15.1888889 0.280847 15.1916667 0.280847 15.1944444 0.280552 15.1972222 0.279669 15.2000000 0.278785 15.2027778 0.277901 15.2055556 0.277901 15.2083333 0.277901 15.2111111 0.278785 15.2138889 0.278195 15.2166667 0.277901 15.2194444 0.277901 15.2222222 0.277901 15.2250000 0.277311 15.2277778 0.277311 15.2305556 0.277606 15.2333333 0.277017 15.2361111 0.276722 15.2388889 0.277017 15.2416667 0.276427 15.2444444 0.276722 15.2472222 0.277606 15.2500000 0.276722 15.2527778 0.276427 15.2555556 0.276427 15.2583333 0.275838 15.2611111 0.274954 15.2638889 0.273186 15.2666667 0.270534 15.2694444 0.268471 15.2722222 0.266703 15.2750000 0.265230 15.2777778 0.265820 15.2805556 0.271418 15.2833333 0.279374 15.2861111 0.288214 15.2888889 0.300000 15.2916667 0.315028 15.2944444 0.332413 15.2972222 0.347145 15.3000000 0.355396 15.3027778 0.356280 15.3055556 0.349503 15.3083333 0.334180 15.3111111 0.313260 15.3138889 0.293223 15.3166667 0.277606 15.3194444 0.268471 15.3222222 0.266703 15.3250000 0.268766 15.3277778 0.272007 15.3305556 0.275249 15.3333333 0.275249 15.3361111 0.274365 15.3388889 0.274070 15.3416667 0.274954 15.3444444 0.274954 15.3472222 0.274954 15.3500000 0.274659 15.3527778 0.273481 15.3555556 0.274070 15.3583333 0.274659 15.3611111 0.274954 15.3638889 0.274954 15.3666667 0.273775 15.3694444 0.272891 15.3722222 0.273481 15.3750000 0.274070 15.3777778 0.274659 15.3805556 0.274365 15.3833333 0.274070 15.3861111 0.273775 15.3888889 0.274070 15.3916667 0.274954 15.3944444 0.274954 15.3972222 0.274954 15.4000000 0.274365 15.4027778 0.273481 15.4055556 0.274365 15.4083333 0.274659 15.4111111 0.274954 15.4138889 0.274954 15.4166667 0.274070 15.4194444 0.273481 15.4222222 0.273775 15.4250000 0.274659 15.4277778 0.274659 15.4305556 0.274954 15.4333333 0.274365 15.4361111 0.274070 15.4388889 0.274365 15.4416667 0.274365 15.4444444 0.274659 15.4472222 0.275249 15.4500000 0.274070 15.4527778 0.273481 15.4555556 0.273775 15.4583333 0.274365 15.4611111 0.275249 15.4638889 0.274954 15.4666667 0.274659 15.4694444 0.274365 15.4722222 0.274659 15.4750000 0.274954 15.4777778 0.274365 15.4805556 0.274954 15.4833333 0.275543 15.4861111 0.274365 15.4888889 0.274365 15.4916667 0.274954 15.4944444 0.275543 15.4972222 0.275838 15.5000000 0.274954 15.5027778 0.275249 15.5055556 0.274954 15.5083333 0.275543 15.5111111 0.275838 15.5138889 0.276427 15.5166667 0.275249 15.5194444 0.274365 15.5222222 0.274954 15.5250000 0.275249 15.5277778 0.275838 15.5305556 0.275543 15.5333333 0.274954 15.5361111 0.274070 15.5388889 0.274659 15.5416667 0.275249 15.5444444 0.274954 15.5472222 0.275249 15.5500000 0.275543 15.5527778 0.274070 15.5555556 0.274070 15.5583333 0.274365 15.5611111 0.274365 15.5638889 0.274659 15.5666667 0.274365 15.5694444 0.273775 15.5722222 0.274365 15.5750000 0.274659 15.5777778 0.274954 15.5805556 0.274954 15.5833333 0.274954 15.5861111 0.274954 15.5888889 0.275543 15.5916667 0.276133 15.5944444 0.277017 15.5972222 0.277606 15.6030000 0.300000 15.8275556 0.300000 15.8305556 0.278195 15.8333333 0.277901 15.8361111 0.277606 15.8388889 0.277901 15.8416667 0.278195 15.8444444 0.278785 15.8472222 0.278490 15.8500000 0.277017 15.8527778 0.277606 15.8555556 0.277901 15.8583333 0.278195 15.8611111 0.278785 15.8638889 0.279079 15.8666667 0.278490 15.8694444 0.278785 15.8722222 0.280552 15.8750000 0.281436 15.8777778 0.282320 15.8805556 0.282026 15.8833333 0.281731 15.8861111 0.281436 15.8888889 0.282615 15.8916667 0.283204 15.8944444 0.284383 15.8972222 0.284383 15.9000000 0.284088 15.9027778 0.283204 15.9055556 0.283794 15.9083333 0.283794 15.9111111 0.284088 15.9138889 0.283499 15.9166667 0.282615 15.9194444 0.281731 15.9222222 0.282615 15.9250000 0.282615 15.9277778 0.282320 15.9305556 0.282320 15.9333333 0.281436 15.9361111 0.282026 15.9388889 0.283794 15.9416667 0.284972 15.9444444 0.285856 15.9472222 0.284678 15.9500000 0.282910 15.9527778 0.281436 15.9555556 0.281142 15.9583333 0.280847 15.9611111 0.280552 15.9638889 0.279079 15.9666667 0.278490 15.9694444 0.277311 15.9722222 0.277606 15.9750000 0.277017 15.9777778 0.277311 15.9805556 0.277311 15.9833333 0.276722 15.9861111 0.276427 15.9888889 0.276133 15.9916667 0.276427 15.9944444 0.276722 15.9972222 0.276722 16.0000000 0.276133 16.0027778 0.275543 16.0055556 0.274954 16.0083333 0.275249 16.0111111 0.276133 16.0138889 0.277017 16.0166667 0.275838 16.0194444 0.275249 16.0222222 0.275249 16.0250000 0.275543 16.0277778 0.276133 16.0305556 0.276133 16.0333333 0.275543 16.0361111 0.274659 16.0388889 0.273481 16.0416667 0.272007 16.0444444 0.270239 16.0472222 0.269355 16.0500000 0.269355 16.0527778 0.266998 16.0555556 0.264052 16.0583333 0.262284 16.0611111 0.265525 16.0638889 0.272007 16.0666667 0.279963 16.0694444 0.287330 16.0722222 0.299705 16.0750000 0.316206 16.0777778 0.332118 16.0805556 0.341842 16.0833333 0.343904 16.0861111 0.333297 16.0888889 0.312376 16.0916667 0.289982 16.0944444 0.273775 16.0972222 0.267587 16.1000000 0.268177 16.1027778 0.270829 16.1055556 0.273186 16.1083333 0.274659 16.1111111 0.274659 16.1138889 0.274070 16.1166667 0.274365 16.1194444 0.273186 16.1222222 0.274365 16.1250000 0.274070 16.1277778 0.274365 16.1305556 0.273775 16.1333333 0.273481 16.1361111 0.272891 16.1388889 0.273481 16.1416667 0.274365 16.1444444 0.274659 16.1472222 0.274659 16.1500000 0.274070 16.1527778 0.274365 16.1555556 0.274365 16.1583333 0.275249 16.1611111 0.275249 16.1638889 0.275838 16.1666667 0.274659 16.1694444 0.274070 16.1722222 0.274365 16.1750000 0.274659 16.1777778 0.274954 16.1805556 0.274365 16.1833333 0.274365 16.1861111 0.273481 16.1888889 0.273775 16.1916667 0.275249 16.1944444 0.274954 16.1972222 0.274659 16.2000000 0.274954 16.2027778 0.274365 16.2055556 0.274954 16.2083333 0.275543 16.2111111 0.276133 16.2138889 0.274954 16.2166667 0.275249 16.2194444 0.275249 16.2222222 0.274954 16.2250000 0.274954 16.2277778 0.274659 16.2305556 0.274659 16.2333333 0.274070 16.2361111 0.274070 16.2388889 0.274365 16.2416667 0.274659 16.2444444 0.275249 16.2472222 0.275838 16.2500000 0.274659 16.2527778 0.274659 16.2555556 0.274954 16.2583333 0.274954 16.2611111 0.275249 16.2638889 0.275838 16.2666667 0.274954 16.2694444 0.274365 16.2722222 0.274365 16.2750000 0.275249 16.2777778 0.276133 16.2805556 0.275543 16.2833333 0.275249 16.2861111 0.274070 16.2888889 0.274070 16.2916667 0.274659 16.2944444 0.275838 16.2972222 0.275543 16.3000000 0.275543 16.3027778 0.274954 16.3055556 0.274659 16.3083333 0.275249 16.3111111 0.275249 16.3138889 0.274365 16.3166667 0.274365 16.3194444 0.273186 16.3222222 0.273775 16.3250000 0.273481 16.3277778 0.273775 16.3305556 0.274365 16.3333333 0.274365 16.3361111 0.273775 16.3388889 0.274365 16.3416667 0.274365 16.3444444 0.274365 16.3472222 0.275543 16.3500000 0.274954 16.3527778 0.273481 16.3555556 0.274954 16.3583333 0.274659 16.3611111 0.275838 16.3638889 0.275543 16.3666667 0.275543 16.3694444 0.275249 16.3722222 0.274954 16.3750000 0.277311 16.3777778 0.278785 16.3835556 0.300000 16.5805556 0.300000)
Vecg1 ecg_l1 0 PWL(0.0000000 0.300000 0.5831111 0.300000 0.5861111 0.286151 0.5888889 0.286740 0.5916667 0.286151 0.5944444 0.286740 0.5972222 0.285856 0.6000000 0.285267 0.6027778 0.286151 0.6055556 0.286446 0.6083333 0.285856 0.6111111 0.286740 0.6138889 0.285267 0.6166667 0.285562 0.6194444 0.285856 0.6222222 0.287035 0.6250000 0.286740 0.6277778 0.285856 0.6305556 0.285562 0.6333333 0.285562 0.6361111 0.286740 0.6388889 0.288214 0.6416667 0.287919 0.6444444 0.288214 0.6472222 0.288214 0.6500000 0.287330 0.6527778 0.288214 0.6555556 0.288803 0.6583333 0.288508 0.6611111 0.287919 0.6638889 0.288214 0.6666667 0.288214 0.6694444 0.289687 0.6722222 0.289687 0.6750000 0.290276 0.6777778 0.289392 0.6805556 0.288803 0.6833333 0.289098 0.6861111 0.289687 0.6888889 0.290571 0.6916667 0.289392 0.6944444 0.288214 0.6972222 0.287919 0.7000000 0.287330 0.7027778 0.287919 0.7055556 0.288508 0.7083333 0.288508 0.7111111 0.287330 0.7138889 0.287035 0.7166667 0.286740 0.7194444 0.287330 0.7222222 0.287919 0.7250000 0.287624 0.7277778 0.287035 0.7305556 0.286740 0.7333333 0.286446 0.7361111 0.287035 0.7388889 0.287919 0.7416667 0.287035 0.7444444 0.287035 0.7472222 0.285856 0.7500000 0.286446 0.7527778 0.287330 0.7555556 0.287624 0.7583333 0.287330 0.7611111 0.286740 0.7638889 0.286446 0.7666667 0.286151 0.7694444 0.286446 0.7722222 0.287035 0.7750000 0.286446 0.7777778 0.284972 0.7805556 0.283499 0.7833333 0.281731 0.7861111 0.280552 0.7888889 0.279669 0.7916667 0.277311 0.7944444 0.277606 0.7972222 0.278785 0.8000000 0.282910 0.8027778 0.289098 0.8055556 0.295285 0.8083333 0.300000 0.8111111 0.303241 0.8138889 0.307366 0.8166667 0.309429 0.8194444 0.314144 0.8222222 0.320331 0.8250000 0.325635 0.8277778 0.331529 0.8305556 0.337127 0.8333333 0.342136 0.8361111 0.343020 0.8388889 0.333591 0.8416667 0.312670 0.8444444 0.291750 0.8472222 0.282320 0.8500000 0.282615 0.8527778 0.285267 0.8555556 0.286446 0.8583333 0.286446 0.8611111 0.286446 0.8638889 0.284972 0.8666667 0.284972 0.8694444 0.285267 0.8722222 0.285267 0.8750000 0.285562 0.8777778 0.285856 0.8805556 0.284972 0.8833333 0.284383 0.8861111 0.285267 0.8888889 0.285562 0.8916667 0.284972 0.8944444 0.285856 0.8972222 0.284678 0.9000000 0.284088 0.9027778 0.285267 0.9055556 0.285267 0.9083333 0.285562 0.9111111 0.284678 0.9138889 0.283794 0.9166667 0.284088 0.9194444 0.284972 0.9222222 0.285562 0.9250000 0.285856 0.9277778 0.285267 0.9305556 0.284088 0.9333333 0.284088 0.9361111 0.285267 0.9388889 0.285562 0.9416667 0.285856 0.9444444 0.285856 0.9472222 0.284678 0.9500000 0.284972 0.9527778 0.285267 0.9555556 0.286151 0.9583333 0.285856 0.9611111 0.285267 0.9638889 0.284678 0.9666667 0.284972 0.9694444 0.285267 0.9722222 0.285562 0.9750000 0.285267 0.9777778 0.284678 0.9805556 0.284088 0.9833333 0.284383 0.9861111 0.285267 0.9888889 0.285562 0.9916667 0.285267 0.9944444 0.284088 0.9972222 0.283794 1.0000000 0.283499 1.0027778 0.284088 1.0055556 0.284383 1.0083333 0.283499 1.0111111 0.283499 1.0138889 0.283499 1.0166667 0.282910 1.0194444 0.283499 1.0222222 0.284678 1.0250000 0.283794 1.0277778 0.283499 1.0305556 0.282026 1.0333333 0.282320 1.0361111 0.282615 1.0388889 0.283204 1.0416667 0.282320 1.0444444 0.282910 1.0472222 0.282320 1.0500000 0.281142 1.0527778 0.280847 1.0555556 0.280847 1.0583333 0.281142 1.0611111 0.280552 1.0638889 0.279963 1.0666667 0.279669 1.0694444 0.279963 1.0722222 0.279963 1.0750000 0.278490 1.0777778 0.277901 1.0805556 0.276722 1.0833333 0.277311 1.0861111 0.277311 1.0888889 0.277901 1.0916667 0.277311 1.0944444 0.277017 1.0972222 0.276427 1.1000000 0.276133 1.1027778 0.277606 1.1055556 0.277606 1.1083333 0.277606 1.1111111 0.278195 1.1138889 0.277901 1.1166667 0.277901 1.1194444 0.279079 1.1222222 0.280552 1.1250000 0.281436 1.1277778 0.281731 1.1305556 0.281142 1.1333333 0.283204 1.1391111 0.300000 1.4053333 0.300000 1.4083333 0.288508 1.4111111 0.287919 1.4138889 0.287624 1.4166667 0.287624 1.4194444 0.287624 1.4222222 0.288214 1.4250000 0.288214 1.4277778 0.288508 1.4305556 0.287624 1.4333333 0.287624 1.4361111 0.287919 1.4388889 0.288508 1.4416667 0.287919 1.4444444 0.287919 1.4472222 0.287919 1.4500000 0.287624 1.4527778 0.288214 1.4555556 0.288508 1.4583333 0.289098 1.4611111 0.289098 1.4638889 0.289098 1.4666667 0.289687 1.4694444 0.290276 1.4722222 0.290571 1.4750000 0.290276 1.4777778 0.289687 1.4805556 0.289982 1.4833333 0.289392 1.4861111 0.289687 1.4888889 0.290276 1.4916667 0.291160 1.4944444 0.291455 1.4972222 0.291160 1.5000000 0.291160 1.5027778 0.291455 1.5055556 0.291750 1.5083333 0.291160 1.5111111 0.291455 1.5138889 0.290571 1.5166667 0.290571 1.5194444 0.290571 1.5222222 0.290571 1.5250000 0.290571 1.5277778 0.290571 1.5305556 0.288803 1.5333333 0.288803 1.5361111 0.289098 1.5388889 0.289098 1.5416667 0.289392 1.5444444 0.288803 1.5472222 0.287919 1.5500000 0.288214 1.5527778 0.288508 1.5555556 0.289392 1.5583333 0.288803 1.5611111 0.288214 1.5638889 0.288214 1.5666667 0.287330 1.5694444 0.288508 1.5722222 0.288803 1.5750000 0.287919 1.5777778 0.288214 1.5805556 0.287919 1.5833333 0.287330 1.5861111 0.287919 1.5888889 0.289098 1.5916667 0.288214 1.5944444 0.287624 1.5972222 0.287035 1.6000000 0.287330 1.6027778 0.287330 1.6055556 0.288214 1.6083333 0.288214 1.6111111 0.287624 1.6138889 0.285267 1.6166667 0.283499 1.6194444 0.282320 1.6222222 0.281436 1.6250000 0.279669 1.6277778 0.279963 1.6305556 0.284383 1.6333333 0.292044 1.6361111 0.299705 1.6388889 0.305893 1.6416667 0.311786 1.6444444 0.317090 1.6472222 0.323278 1.6500000 0.330350 1.6527778 0.335359 1.6555556 0.332118 1.6583333 0.316501 1.6611111 0.296169 1.6638889 0.284088 1.6666667 0.282910 1.6694444 0.285562 1.6722222 0.286446 1.6750000 0.286740 1.6777778 0.287330 1.6805556 0.287035 1.6833333 0.286151 1.6861111 0.286151 1.6888889 0.286446 1.6916667 0.287035 1.6944444 0.285856 1.6972222 0.285562 1.7000000 0.285856 1.7027778 0.286446 1.7055556 0.287035 1.7083333 0.286446 1.7111111 0.285856 1.7138889 0.285562 1.7166667 0.284972 1.7194444 0.285856 1.7222222 0.287035 1.7250000 0.286740 1.7277778 0.287035 1.7305556 0.285267 1.7333333 0.285267 1.7361111 0.285856 1.7388889 0.286740 1.7416667 0.286446 1.7444444 0.287035 1.7472222 0.286446 1.7500000 0.285856 1.7527778 0.286446 1.7555556 0.286740 1.7583333 0.287035 1.7611111 0.286446 1.7638889 0.285856 1.7666667 0.286151 1.7694444 0.286446 1.7722222 0.286740 1.7750000 0.286446 1.7777778 0.287035 1.7805556 0.286151 1.7833333 0.285856 1.7861111 0.286151 1.7888889 0.287330 1.7916667 0.286740 1.7944444 0.285856 1.7972222 0.285562 1.8000000 0.285856 1.8027778 0.287035 1.8055556 0.286740 1.8083333 0.286740 1.8111111 0.285856 1.8138889 0.285562 1.8166667 0.284972 1.8194444 0.285267 1.8222222 0.285856 1.8250000 0.286151 1.8277778 0.284383 1.8305556 0.284383 1.8333333 0.285267 1.8361111 0.284678 1.8388889 0.285856 1.8416667 0.285856 1.8444444 0.284678 1.8472222 0.284383 1.8500000 0.283204 1.8527778 0.283794 1.8555556 0.283794 1.8583333 0.283204 1.8611111 0.283794 1.8638889 0.282910 1.8666667 0.282615 1.8694444 0.282615 1.8722222 0.282026 1.8750000 0.282026 1.8777778 0.281436 1.8805556 0.280552 1.8833333 0.279963 1.8861111 0.280258 1.8888889 0.280258 1.8916667 0.280258 1.8944444 0.279374 1.8972222 0.278195 1.9000000 0.278195 1.9027778 0.278785 1.9055556 0.278785 1.9083333 0.278490 1.9111111 0.277901 1.9138889 0.277606 1.9166667 0.277606 1.9194444 0.277901 1.9222222 0.279669 1.9250000 0.279669 1.9277778 0.280552 1.9305556 0.279963 1.9333333 0.280847 1.9361111 0.281436 1.9388889 0.283204 1.9416667 0.284383 1.9444444 0.284383 1.9472222 0.284678 1.9500000 0.285267 1.9527778 0.285267 1.9555556 0.286446 1.9613333 0.300000 2.1886667 0.300000 2.1916667 0.284678 2.1944444 0.284678 2.1972222 0.284088 2.2000000 0.284088 2.2027778 0.284972 2.2055556 0.284678 2.2083333 0.283794 2.2111111 0.284678 2.2138889 0.283794 2.2166667 0.283499 2.2194444 0.284972 2.2222222 0.284972 2.2250000 0.284383 2.2277778 0.284383 2.2305556 0.283499 2.2333333 0.284088 2.2361111 0.284972 2.2388889 0.285562 2.2416667 0.285562 2.2444444 0.285856 2.2472222 0.285267 2.2500000 0.284678 2.2527778 0.285856 2.2555556 0.285562 2.2583333 0.286446 2.2611111 0.286151 2.2638889 0.285267 2.2666667 0.285562 2.2694444 0.285562 2.2722222 0.285856 2.2750000 0.287035 2.2777778 0.286740 2.2805556 0.286446 2.2833333 0.286151 2.2861111 0.287330 2.2888889 0.287035 2.2916667 0.287330 2.2944444 0.287035 2.2972222 0.286446 2.3000000 0.286151 2.3027778 0.285562 2.3055556 0.286446 2.3083333 0.286446 2.3111111 0.285562 2.3138889 0.284972 2.3166667 0.283794 2.3194444 0.283794 2.3222222 0.284088 2.3250000 0.283794 2.3277778 0.284678 2.3305556 0.283794 2.3333333 0.283204 2.3361111 0.283499 2.3388889 0.284088 2.3416667 0.283794 2.3444444 0.284088 2.3472222 0.282910 2.3500000 0.283499 2.3527778 0.283499 2.3555556 0.283204 2.3583333 0.282910 2.3611111 0.282615 2.3638889 0.282026 2.3666667 0.282026 2.3694444 0.282615 2.3722222 0.283499 2.3750000 0.282910 2.3777778 0.282320 2.3805556 0.282615 2.3833333 0.282615 2.3861111 0.282320 2.3888889 0.283204 2.3916667 0.282910 2.3944444 0.282026 2.3972222 0.280552 2.4000000 0.277901 2.4027778 0.278785 2.4055556 0.278195 2.4083333 0.276427 2.4111111 0.275249 2.4138889 0.275838 2.4166667 0.280847 2.4194444 0.288214 2.4222222 0.294401 2.4250000 0.298232 2.4277778 0.302063 2.4305556 0.306777 2.4333333 0.314733 2.4361111 0.321805 2.4388889 0.324751 2.4416667 0.317680 2.4444444 0.301473 2.4472222 0.284088 2.4500000 0.273481 2.4527778 0.271713 2.4555556 0.274954 2.4583333 0.276722 2.4611111 0.278785 2.4638889 0.278785 2.4666667 0.279963 2.4694444 0.281142 2.4722222 0.281436 2.4750000 0.282026 2.4777778 0.281436 2.4805556 0.280847 2.4833333 0.280258 2.4861111 0.280552 2.4888889 0.281436 2.4916667 0.281436 2.4944444 0.281142 2.4972222 0.280258 2.5000000 0.280258 2.5027778 0.281142 2.5055556 0.281142 2.5083333 0.281142 2.5111111 0.280847 2.5138889 0.281142 2.5166667 0.281142 2.5194444 0.281731 2.5222222 0.281731 2.5250000 0.281436 2.5277778 0.281731 2.5305556 0.280258 2.5333333 0.281142 2.5361111 0.281436 2.5388889 0.281436 2.5416667 0.281436 2.5444444 0.280847 2.5472222 0.281142 2.5500000 0.280847 2.5527778 0.281436 2.5555556 0.281436 2.5583333 0.281436 2.5611111 0.281436 2.5638889 0.280847 2.5666667 0.281142 2.5694444 0.280552 2.5722222 0.281731 2.5750000 0.281731 2.5777778 0.281731 2.5805556 0.281142 2.5833333 0.280847 2.5861111 0.281731 2.5888889 0.281731 2.5916667 0.281142 2.5944444 0.280552 2.5972222 0.280258 2.6000000 0.281142 2.6027778 0.281436 2.6055556 0.281436 2.6083333 0.281731 2.6111111 0.281436 2.6138889 0.280847 2.6166667 0.279963 2.6194444 0.280847 2.6222222 0.280552 2.6250000 0.280552 2.6277778 0.280552 2.6305556 0.279669 2.6333333 0.279374 2.6361111 0.279963 2.6388889 0.279963 2.6416667 0.279963 2.6444444 0.278785 2.6472222 0.278195 2.6500000 0.278490 2.6527778 0.279079 2.6555556 0.279079 2.6583333 0.277901 2.6611111 0.277311 2.6638889 0.276133 2.6666667 0.275543 2.6694444 0.275838 2.6722222 0.275838 2.6750000 0.274954 2.6777778 0.274070 2.6805556 0.273186 2.6833333 0.272891 2.6861111 0.272891 2.6888889 0.272891 2.6916667 0.272891 2.6944444 0.272891 2.6972222 0.272597 2.7000000 0.272007 2.7027778 0.272891 2.7055556 0.272597 2.7083333 0.272891 2.7111111 0.273775 2.7138889 0.273481 2.7166667 0.273775 2.7194444 0.274659 2.7222222 0.276133 2.7250000 0.276722 2.7277778 0.277311 2.7305556 0.277606 2.7333333 0.277901 2.7361111 0.279079 2.7388889 0.280258 2.7446667 0.300000 2.9331111 0.300000 2.9361111 0.279374 2.9388889 0.280258 2.9416667 0.280258 2.9444444 0.279963 2.9472222 0.279669 2.9500000 0.279963 2.9527778 0.280258 2.9555556 0.280847 2.9583333 0.280552 2.9611111 0.279963 2.9638889 0.279669 2.9666667 0.279669 2.9694444 0.279963 2.9722222 0.281436 2.9750000 0.280552 2.9777778 0.280258 2.9805556 0.280258 2.9833333 0.279374 2.9861111 0.280258 2.9888889 0.280847 2.9916667 0.281142 2.9944444 0.281436 2.9972222 0.281142 3.0000000 0.280552 3.0027778 0.281436 3.0055556 0.281142 3.0083333 0.281436 3.0111111 0.281436 3.0138889 0.280847 3.0166667 0.280552 3.0194444 0.280552 3.0222222 0.281436 3.0250000 0.281731 3.0277778 0.281142 3.0305556 0.280552 3.0333333 0.280552 3.0361111 0.280847 3.0388889 0.281731 3.0416667 0.282615 3.0444444 0.282615 3.0472222 0.281142 3.0500000 0.280847 3.0527778 0.280258 3.0555556 0.281142 3.0583333 0.281142 3.0611111 0.281142 3.0638889 0.280552 3.0666667 0.279963 3.0694444 0.280552 3.0722222 0.280552 3.0750000 0.280552 3.0777778 0.280258 3.0805556 0.279963 3.0833333 0.279669 3.0861111 0.280847 3.0888889 0.280552 3.0916667 0.281436 3.0944444 0.280552 3.0972222 0.279669 3.1000000 0.279374 3.1027778 0.279669 3.1055556 0.280847 3.1083333 0.280552 3.1111111 0.280258 3.1138889 0.279963 3.1166667 0.280258 3.1194444 0.280847 3.1222222 0.281142 3.1250000 0.280552 3.1277778 0.281436 3.1305556 0.280847 3.1333333 0.280552 3.1361111 0.280847 3.1388889 0.280552 3.1416667 0.278490 3.1444444 0.276722 3.1472222 0.275543 3.1500000 0.273775 3.1527778 0.273481 3.1555556 0.275838 3.1583333 0.280552 3.1611111 0.286740 3.1638889 0.293223 3.1666667 0.297937 3.1694444 0.302357 3.1722222 0.307956 3.1750000 0.314438 3.1777778 0.321510 3.1805556 0.326225 3.1833333 0.323573 3.1861111 0.310018 3.1888889 0.291160 3.1916667 0.276133 3.1944444 0.272302 3.1972222 0.274365 3.2000000 0.278785 3.2027778 0.279374 3.2055556 0.280552 3.2083333 0.281142 3.2111111 0.280847 3.2138889 0.279963 3.2166667 0.279963 3.2194444 0.280552 3.2222222 0.281436 3.2250000 0.281731 3.2277778 0.281436 3.2305556 0.280552 3.2333333 0.279963 3.2361111 0.280552 3.2388889 0.281142 3.2416667 0.281142 3.2444444 0.280847 3.2472222 0.280552 3.2500000 0.280552 3.2527778 0.281436 3.2555556 0.281142 3.2583333 0.281731 3.2611111 0.281142 3.2638889 0.281142 3.2666667 0.281142 3.2694444 0.282026 3.2722222 0.281731 3.2750000 0.281731 3.2777778 0.282026 3.2805556 0.280552 3.2833333 0.280847 3.2861111 0.280847 3.2888889 0.281731 3.2916667 0.282026 3.2944444 0.282026 3.2972222 0.281436 3.3000000 0.281142 3.3027778 0.281142 3.3055556 0.281731 3.3083333 0.281142 3.3111111 0.281731 3.3138889 0.281142 3.3166667 0.281142 3.3194444 0.282026 3.3222222 0.281731 3.3250000 0.281731 3.3277778 0.281436 3.3305556 0.280847 3.3333333 0.281142 3.3361111 0.281436 3.3388889 0.281436 3.3416667 0.282026 3.3444444 0.281436 3.3472222 0.281142 3.3500000 0.280258 3.3527778 0.281731 3.3555556 0.281436 3.3583333 0.281436 3.3611111 0.280847 3.3638889 0.280847 3.3666667 0.280552 3.3694444 0.279963 3.3722222 0.281142 3.3750000 0.280847 3.3777778 0.280847 3.3805556 0.279963 3.3833333 0.278785 3.3861111 0.279079 3.3888889 0.278785 3.3916667 0.278785 3.3944444 0.277901 3.3972222 0.278195 3.4000000 0.277311 3.4027778 0.277017 3.4055556 0.277311 3.4083333 0.276722 3.4111111 0.276722 3.4138889 0.275543 3.4166667 0.275543 3.4194444 0.274954 3.4222222 0.275543 3.4250000 0.275543 3.4277778 0.275249 3.4305556 0.274954 3.4333333 0.274365 3.4361111 0.274659 3.4388889 0.274954 3.4416667 0.274365 3.4444444 0.272891 3.4472222 0.272891 3.4500000 0.272891 3.4527778 0.273481 3.4555556 0.274070 3.4583333 0.274659 3.4611111 0.274070 3.4638889 0.274070 3.4666667 0.274659 3.4694444 0.275543 3.4722222 0.277311 3.4750000 0.278195 3.4777778 0.278490 3.4805556 0.278785 3.4833333 0.279669 3.4891111 0.300000 3.7636667 0.300000 3.7666667 0.283204 3.7694444 0.284088 3.7722222 0.285267 3.7750000 0.284088 3.7777778 0.284972 3.7805556 0.283499 3.7833333 0.284088 3.7861111 0.283794 3.7888889 0.284383 3.7916667 0.284383 3.7944444 0.284383 3.7972222 0.283794 3.8000000 0.283499 3.8027778 0.284383 3.8055556 0.284678 3.8083333 0.284678 3.8111111 0.284383 3.8138889 0.283794 3.8166667 0.284088 3.8194444 0.284383 3.8222222 0.285562 3.8250000 0.285856 3.8277778 0.285267 3.8305556 0.284678 3.8333333 0.284678 3.8361111 0.285562 3.8388889 0.286446 3.8416667 0.286446 3.8444444 0.285856 3.8472222 0.286151 3.8500000 0.285562 3.8527778 0.286446 3.8555556 0.287035 3.8583333 0.287330 3.8611111 0.287035 3.8638889 0.286446 3.8666667 0.287035 3.8694444 0.287330 3.8722222 0.287919 3.8750000 0.287330 3.8777778 0.287624 3.8805556 0.287330 3.8833333 0.286151 3.8861111 0.286151 3.8888889 0.286151 3.8916667 0.285856 3.8944444 0.286151 3.8972222 0.285267 3.9000000 0.285267 3.9027778 0.285267 3.9055556 0.285856 3.9083333 0.284972 3.9111111 0.284678 3.9138889 0.284383 3.9166667 0.283794 3.9194444 0.284972 3.9222222 0.285562 3.9250000 0.285267 3.9277778 0.284972 3.9305556 0.283794 3.9333333 0.283499 3.9361111 0.284088 3.9388889 0.284972 3.9416667 0.284383 3.9444444 0.284383 3.9472222 0.283499 3.9500000 0.283204 3.9527778 0.283794 3.9555556 0.284972 3.9583333 0.284678 3.9611111 0.284678 3.9638889 0.284088 3.9666667 0.283204 3.9694444 0.282026 3.9722222 0.280847 3.9750000 0.279374 3.9777778 0.278195 3.9805556 0.276427 3.9833333 0.277606 3.9861111 0.281142 3.9888889 0.288214 3.9916667 0.296169 3.9944444 0.302652 3.9972222 0.307661 4.0000000 0.314144 4.0027778 0.322099 4.0055556 0.329171 4.0083333 0.336243 4.0111111 0.341252 4.0138889 0.343020 4.0166667 0.335654 4.0194444 0.317974 4.0222222 0.297937 4.0250000 0.283499 4.0277778 0.279374 4.0305556 0.281436 4.0333333 0.282320 4.0361111 0.282320 4.0388889 0.283499 4.0416667 0.284088 4.0444444 0.282910 4.0472222 0.282320 4.0500000 0.282320 4.0527778 0.282615 4.0555556 0.283204 4.0583333 0.282910 4.0611111 0.282615 4.0638889 0.282615 4.0666667 0.281731 4.0694444 0.282615 4.0722222 0.282910 4.0750000 0.283204 4.0777778 0.282910 4.0805556 0.281731 4.0833333 0.281731 4.0861111 0.282026 4.0888889 0.282615 4.0916667 0.282910 4.0944444 0.282615 4.0972222 0.282026 4.1000000 0.281436 4.1027778 0.282320 4.1055556 0.283204 4.1083333 0.283204 4.1111111 0.282615 4.1138889 0.282026 4.1166667 0.282026 4.1194444 0.282615 4.1222222 0.283204 4.1250000 0.282615 4.1277778 0.282615 4.1305556 0.282320 4.1333333 0.282320 4.1361111 0.282910 4.1388889 0.283204 4.1416667 0.282910 4.1444444 0.282910 4.1472222 0.282026 4.1500000 0.282615 4.1527778 0.282910 4.1555556 0.282910 4.1583333 0.282910 4.1611111 0.282320 4.1638889 0.281436 4.1666667 0.281731 4.1694444 0.282026 4.1722222 0.283204 4.1750000 0.282615 4.1777778 0.282615 4.1805556 0.282026 4.1833333 0.282026 4.1861111 0.281731 4.1888889 0.282026 4.1916667 0.281731 4.1944444 0.282026 4.1972222 0.281142 4.2000000 0.280258 4.2027778 0.281436 4.2055556 0.281436 4.2083333 0.281142 4.2111111 0.281142 4.2138889 0.279669 4.2166667 0.279669 4.2194444 0.279963 4.2222222 0.280258 4.2250000 0.279374 4.2277778 0.279079 4.2305556 0.278195 4.2333333 0.277901 4.2361111 0.278490 4.2388889 0.277901 4.2416667 0.277606 4.2444444 0.277017 4.2472222 0.275838 4.2500000 0.275838 4.2527778 0.276427 4.2555556 0.276722 4.2583333 0.276427 4.2611111 0.275838 4.2638889 0.274954 4.2666667 0.273775 4.2694444 0.274659 4.2722222 0.274659 4.2750000 0.274954 4.2777778 0.274954 4.2805556 0.274659 4.2833333 0.274070 4.2861111 0.275543 4.2888889 0.276133 4.2916667 0.276722 4.2944444 0.277311 4.2972222 0.277901 4.3000000 0.278490 4.3027778 0.279963 4.3055556 0.281142 4.3083333 0.281731 4.3111111 0.282910 4.3138889 0.283204 4.3196667 0.300000 4.5442222 0.300000 4.5472222 0.285562 4.5500000 0.285267 4.5527778 0.285562 4.5555556 0.286446 4.5583333 0.286446 4.5611111 0.286740 4.5638889 0.286151 4.5666667 0.285856 4.5694444 0.286446 4.5722222 0.286151 4.5750000 0.286446 4.5777778 0.286446 4.5805556 0.286151 4.5833333 0.285856 4.5861111 0.285856 4.5888889 0.286740 4.5916667 0.286740 4.5944444 0.286740 4.5972222 0.285856 4.6000000 0.286446 4.6027778 0.286740 4.6055556 0.287624 4.6083333 0.287624 4.6111111 0.288214 4.6138889 0.287919 4.6166667 0.287624 4.6194444 0.287624 4.6222222 0.288508 4.6250000 0.288803 4.6277778 0.289392 4.6305556 0.288214 4.6333333 0.288214 4.6361111 0.287919 4.6388889 0.288803 4.6416667 0.289687 4.6444444 0.289982 4.6472222 0.289982 4.6500000 0.289392 4.6527778 0.289687 4.6555556 0.290276 4.6583333 0.289687 4.6611111 0.289687 4.6638889 0.288508 4.6666667 0.287919 4.6694444 0.287624 4.6722222 0.288214 4.6750000 0.288214 4.6777778 0.288214 4.6805556 0.287624 4.6833333 0.287330 4.6861111 0.287624 4.6888889 0.287330 4.6916667 0.287035 4.6944444 0.286740 4.6972222 0.286151 4.7000000 0.285856 4.7027778 0.286446 4.7055556 0.286446 4.7083333 0.286740 4.7111111 0.286740 4.7138889 0.285856 4.7166667 0.284972 4.7194444 0.286446 4.7222222 0.286740 4.7250000 0.287330 4.7277778 0.286151 4.7305556 0.285267 4.7333333 0.284972 4.7361111 0.285267 4.7388889 0.286446 4.7416667 0.285856 4.7444444 0.285562 4.7472222 0.284383 4.7500000 0.283204 4.7527778 0.282026 4.7555556 0.280847 4.7583333 0.279079 4.7611111 0.277606 4.7638889 0.277017 4.7666667 0.279374 4.7694444 0.284972 4.7722222 0.293223 4.7750000 0.298527 4.7777778 0.303241 4.7805556 0.307956 4.7833333 0.313849 4.7861111 0.319742 4.7888889 0.326225 4.7916667 0.331823 4.7944444 0.335948 4.7972222 0.335064 4.8000000 0.328582 4.8027778 0.315912 4.8055556 0.300884 4.8083333 0.285856 4.8111111 0.277311 4.8138889 0.277311 4.8166667 0.281142 4.8194444 0.282910 4.8222222 0.283794 4.8250000 0.284088 4.8277778 0.284088 4.8305556 0.283499 4.8333333 0.283204 4.8361111 0.283499 4.8388889 0.283794 4.8416667 0.284383 4.8444444 0.283204 4.8472222 0.282615 4.8500000 0.282320 4.8527778 0.283499 4.8555556 0.284678 4.8583333 0.284088 4.8611111 0.284383 4.8638889 0.283794 4.8666667 0.283204 4.8694444 0.283499 4.8722222 0.283794 4.8750000 0.282910 4.8777778 0.283794 4.8805556 0.283499 4.8833333 0.283499 4.8861111 0.283794 4.8888889 0.284088 4.8916667 0.284088 4.8944444 0.283794 4.8972222 0.283204 4.9000000 0.282910 4.9027778 0.283204 4.9055556 0.284678 4.9083333 0.284383 4.9111111 0.283794 4.9138889 0.283204 4.9166667 0.283204 4.9194444 0.282910 4.9222222 0.283794 4.9250000 0.283499 4.9277778 0.283204 4.9305556 0.283499 4.9333333 0.282615 4.9361111 0.283204 4.9388889 0.283499 4.9416667 0.283794 4.9444444 0.283499 4.9472222 0.282615 4.9500000 0.282615 4.9527778 0.283204 4.9555556 0.283794 4.9583333 0.283499 4.9611111 0.283499 4.9638889 0.283204 4.9666667 0.282320 4.9694444 0.282910 4.9722222 0.283794 4.9750000 0.283204 4.9777778 0.283204 4.9805556 0.282320 4.9833333 0.282910 4.9861111 0.282910 4.9888889 0.282910 4.9916667 0.282910 4.9944444 0.282910 4.9972222 0.281731 5.0000000 0.282026 5.0027778 0.282320 5.0055556 0.282615 5.0083333 0.282026 5.0111111 0.280552 5.0138889 0.280258 5.0166667 0.279374 5.0194444 0.279963 5.0222222 0.280258 5.0250000 0.279963 5.0277778 0.279374 5.0305556 0.278785 5.0333333 0.278195 5.0361111 0.277901 5.0388889 0.277901 5.0416667 0.277901 5.0444444 0.278195 5.0472222 0.277901 5.0500000 0.277311 5.0527778 0.277901 5.0555556 0.277017 5.0583333 0.277017 5.0611111 0.277017 5.0638889 0.276427 5.0666667 0.275838 5.0694444 0.275838 5.0722222 0.276722 5.0750000 0.276427 5.0777778 0.276722 5.0805556 0.276133 5.0833333 0.276427 5.0861111 0.276133 5.0888889 0.277017 5.0916667 0.277311 5.0944444 0.277901 5.1002222 0.300000 5.3747778 0.300000 5.3777778 0.283499 5.3805556 0.282910 5.3833333 0.282026 5.3861111 0.282615 5.3888889 0.283794 5.3916667 0.283794 5.3944444 0.283499 5.3972222 0.282615 5.4000000 0.282026 5.4027778 0.282615 5.4055556 0.282615 5.4083333 0.282910 5.4111111 0.282910 5.4138889 0.282910 5.4166667 0.282615 5.4194444 0.282615 5.4222222 0.283499 5.4250000 0.283204 5.4277778 0.283794 5.4305556 0.282910 5.4333333 0.284088 5.4361111 0.284678 5.4388889 0.285267 5.4416667 0.285562 5.4444444 0.285856 5.4472222 0.284383 5.4500000 0.284088 5.4527778 0.284383 5.4555556 0.284972 5.4583333 0.285267 5.4611111 0.286151 5.4638889 0.285562 5.4666667 0.284972 5.4694444 0.285267 5.4722222 0.285267 5.4750000 0.285267 5.4777778 0.285856 5.4805556 0.285267 5.4833333 0.284678 5.4861111 0.284972 5.4888889 0.284972 5.4916667 0.284678 5.4944444 0.284383 5.4972222 0.283204 5.5000000 0.282910 5.5027778 0.282910 5.5055556 0.283204 5.5083333 0.283204 5.5111111 0.282320 5.5138889 0.282026 5.5166667 0.281436 5.5194444 0.282026 5.5222222 0.282615 5.5250000 0.283204 5.5277778 0.282910 5.5305556 0.282026 5.5333333 0.281436 5.5361111 0.281731 5.5388889 0.282320 5.5416667 0.282026 5.5444444 0.282615 5.5472222 0.280847 5.5500000 0.281142 5.5527778 0.281731 5.5555556 0.281731 5.5583333 0.282320 5.5611111 0.282320 5.5638889 0.281731 5.5666667 0.282026 5.5694444 0.281142 5.5722222 0.281731 5.5750000 0.282615 5.5777778 0.282320 5.5805556 0.279963 5.5833333 0.279374 5.5861111 0.278195 5.5888889 0.278195 5.5916667 0.276427 5.5944444 0.274070 5.5972222 0.273775 5.6000000 0.277017 5.6027778 0.283499 5.6055556 0.290866 5.6083333 0.295875 5.6111111 0.299705 5.6138889 0.302947 5.6166667 0.307661 5.6194444 0.315028 5.6222222 0.322099 5.6250000 0.325341 5.6277778 0.321510 5.6305556 0.307956 5.6333333 0.289687 5.6361111 0.275838 5.6388889 0.270534 5.6416667 0.269355 5.6444444 0.270829 5.6472222 0.272302 5.6500000 0.274070 5.6527778 0.275838 5.6555556 0.277901 5.6583333 0.278195 5.6611111 0.278785 5.6638889 0.278785 5.6666667 0.278785 5.6694444 0.279374 5.6722222 0.280258 5.6750000 0.280258 5.6777778 0.279079 5.6805556 0.279079 5.6833333 0.279669 5.6861111 0.280258 5.6888889 0.280258 5.6916667 0.280258 5.6944444 0.279963 5.6972222 0.279079 5.7000000 0.279374 5.7027778 0.279374 5.7055556 0.280552 5.7083333 0.280552 5.7111111 0.281142 5.7138889 0.279963 5.7166667 0.280258 5.7194444 0.280552 5.7222222 0.281142 5.7250000 0.280847 5.7277778 0.280258 5.7305556 0.279963 5.7333333 0.279669 5.7361111 0.280847 5.7388889 0.280847 5.7416667 0.281142 5.7444444 0.281142 5.7472222 0.280552 5.7500000 0.279669 5.7527778 0.280847 5.7555556 0.281436 5.7583333 0.281142 5.7611111 0.280552 5.7638889 0.281142 5.7666667 0.280552 5.7694444 0.279963 5.7722222 0.282026 5.7750000 0.280847 5.7777778 0.280847 5.7805556 0.280847 5.7833333 0.280847 5.7861111 0.280847 5.7888889 0.281731 5.7916667 0.281142 5.7944444 0.281436 5.7972222 0.280552 5.8000000 0.280552 5.8027778 0.281142 5.8055556 0.282320 5.8083333 0.281142 5.8111111 0.281731 5.8138889 0.281142 5.8166667 0.280258 5.8194444 0.281142 5.8222222 0.281436 5.8250000 0.281731 5.8277778 0.280847 5.8305556 0.280552 5.8333333 0.280552 5.8361111 0.280552 5.8388889 0.280552 5.8416667 0.280552 5.8444444 0.280258 5.8472222 0.279669 5.8500000 0.278785 5.8527778 0.279079 5.8555556 0.279963 5.8583333 0.279963 5.8611111 0.279079 5.8638889 0.278195 5.8666667 0.277606 5.8694444 0.277901 5.8722222 0.277901 5.8750000 0.277901 5.8777778 0.277606 5.8805556 0.275838 5.8833333 0.275838 5.8861111 0.275838 5.8888889 0.276722 5.8916667 0.275543 5.8944444 0.274659 5.8972222 0.273775 5.9000000 0.273186 5.9027778 0.273481 5.9055556 0.273775 5.9083333 0.273775 5.9111111 0.274070 5.9138889 0.272891 5.9166667 0.272302 5.9194444 0.272597 5.9222222 0.272891 5.9250000 0.273481 5.9307778 0.300000 6.2386667 0.300000 6.2416667 0.285562 6.2444444 0.285267 6.2472222 0.284088 6.2500000 0.284088 6.2527778 0.284088 6.2555556 0.285562 6.2583333 0.285562 6.2611111 0.285267 6.2638889 0.284088 6.2666667 0.284088 6.2694444 0.284088 6.2722222 0.284088 6.2750000 0.284678 6.2777778 0.284678 6.2805556 0.284383 6.2833333 0.284088 6.2861111 0.284678 6.2888889 0.285267 6.2916667 0.285856 6.2944444 0.285856 6.2972222 0.285856 6.3000000 0.286151 6.3027778 0.286740 6.3055556 0.287330 6.3083333 0.287330 6.3111111 0.287035 6.3138889 0.286151 6.3166667 0.286446 6.3194444 0.287624 6.3222222 0.288508 6.3250000 0.289392 6.3277778 0.288803 6.3305556 0.287624 6.3333333 0.287624 6.3361111 0.287330 6.3388889 0.287919 6.3416667 0.288508 6.3444444 0.287919 6.3472222 0.287035 6.3500000 0.286446 6.3527778 0.286740 6.3555556 0.286446 6.3583333 0.287035 6.3611111 0.286740 6.3638889 0.285856 6.3666667 0.285856 6.3694444 0.285562 6.3722222 0.285562 6.3750000 0.286151 6.3777778 0.285267 6.3805556 0.284678 6.3833333 0.284088 6.3861111 0.284678 6.3888889 0.285562 6.3916667 0.285856 6.3944444 0.284678 6.3972222 0.284678 6.4000000 0.284383 6.4027778 0.284972 6.4055556 0.284678 6.4083333 0.286151 6.4111111 0.285562 6.4138889 0.285562 6.4166667 0.284678 6.4194444 0.285856 6.4222222 0.285856 6.4250000 0.285562 6.4277778 0.285562 6.4305556 0.285267 6.4333333 0.285562 6.4361111 0.284972 6.4388889 0.285562 6.4416667 0.284972 6.4444444 0.284088 6.4472222 0.282026 6.4500000 0.280552 6.4527778 0.279374 6.4555556 0.278785 6.4583333 0.277017 6.4611111 0.277311 6.4638889 0.279963 6.4666667 0.285856 6.4694444 0.294696 6.4722222 0.301179 6.4750000 0.307956 6.4777778 0.314144 6.4805556 0.320037 6.4833333 0.326814 6.4861111 0.334475 6.4888889 0.338306 6.4916667 0.334180 6.4944444 0.317090 6.4972222 0.295875 6.5000000 0.281731 6.5027778 0.279669 6.5055556 0.282615 6.5083333 0.284088 6.5111111 0.284088 6.5138889 0.283794 6.5166667 0.284088 6.5194444 0.284088 6.5222222 0.283794 6.5250000 0.283499 6.5277778 0.283794 6.5305556 0.282615 6.5333333 0.282320 6.5361111 0.282910 6.5388889 0.283499 6.5416667 0.283499 6.5444444 0.283204 6.5472222 0.282615 6.5500000 0.282320 6.5527778 0.282320 6.5555556 0.283204 6.5583333 0.283794 6.5611111 0.284088 6.5638889 0.282910 6.5666667 0.282320 6.5694444 0.282910 6.5722222 0.283499 6.5750000 0.283794 6.5777778 0.283499 6.5805556 0.283499 6.5833333 0.283794 6.5861111 0.283204 6.5888889 0.283794 6.5916667 0.284088 6.5944444 0.284088 6.5972222 0.283794 6.6000000 0.283204 6.6027778 0.283204 6.6055556 0.283499 6.6083333 0.284383 6.6111111 0.283794 6.6138889 0.283499 6.6166667 0.282910 6.6194444 0.283204 6.6222222 0.283499 6.6250000 0.283794 6.6277778 0.283794 6.6305556 0.283204 6.6333333 0.282615 6.6361111 0.282615 6.6388889 0.283499 6.6416667 0.283499 6.6444444 0.283499 6.6472222 0.282910 6.6500000 0.282910 6.6527778 0.282320 6.6555556 0.283204 6.6583333 0.283204 6.6611111 0.282320 6.6638889 0.282615 6.6666667 0.282026 6.6694444 0.281731 6.6722222 0.282026 6.6750000 0.282615 6.6777778 0.281436 6.6805556 0.281436 6.6833333 0.280258 6.6861111 0.280258 6.6888889 0.281142 6.6916667 0.281142 6.6944444 0.281731 6.6972222 0.280847 6.7000000 0.279963 6.7027778 0.280258 6.7055556 0.280847 6.7083333 0.281142 6.7111111 0.279963 6.7138889 0.279963 6.7166667 0.278785 6.7194444 0.278490 6.7222222 0.278490 6.7250000 0.278490 6.7277778 0.277606 6.7305556 0.277017 6.7333333 0.276427 6.7361111 0.277017 6.7388889 0.276427 6.7416667 0.276427 6.7444444 0.275543 6.7472222 0.274659 6.7500000 0.273775 6.7527778 0.275249 6.7555556 0.275838 6.7583333 0.275543 6.7611111 0.275249 6.7638889 0.274365 6.7666667 0.274365 6.7694444 0.274659 6.7722222 0.275543 6.7750000 0.276427 6.7777778 0.276722 6.7805556 0.276722 6.7833333 0.277017 6.7861111 0.278490 6.7888889 0.279374 6.7946667 0.300000 7.0608889 0.300000 7.0638889 0.284678 7.0666667 0.284972 7.0694444 0.284678 7.0722222 0.285267 7.0750000 0.285562 7.0777778 0.284972 7.0805556 0.284383 7.0833333 0.285267 7.0861111 0.284972 7.0888889 0.285267 7.0916667 0.286151 7.0944444 0.285267 7.0972222 0.284972 7.1000000 0.283794 7.1027778 0.283794 7.1055556 0.284972 7.1083333 0.284972 7.1111111 0.284972 7.1138889 0.285267 7.1166667 0.284383 7.1194444 0.285267 7.1222222 0.286151 7.1250000 0.285856 7.1277778 0.286446 7.1305556 0.286151 7.1333333 0.286151 7.1361111 0.287035 7.1388889 0.287330 7.1416667 0.287919 7.1444444 0.287919 7.1472222 0.287330 7.1500000 0.286151 7.1527778 0.287035 7.1555556 0.288508 7.1583333 0.289687 7.1611111 0.289098 7.1638889 0.288803 7.1666667 0.287330 7.1694444 0.288214 7.1722222 0.289098 7.1750000 0.288803 7.1777778 0.287919 7.1805556 0.288214 7.1833333 0.287330 7.1861111 0.286740 7.1888889 0.287035 7.1916667 0.286740 7.1944444 0.286446 7.1972222 0.286446 7.2000000 0.285562 7.2027778 0.286151 7.2055556 0.285856 7.2083333 0.285856 7.2111111 0.285856 7.2138889 0.285562 7.2166667 0.284678 7.2194444 0.285856 7.2222222 0.286446 7.2250000 0.286446 7.2277778 0.286446 7.2305556 0.284972 7.2333333 0.284972 7.2361111 0.285267 7.2388889 0.285562 7.2416667 0.285562 7.2444444 0.285856 7.2472222 0.285267 7.2500000 0.284972 7.2527778 0.285267 7.2555556 0.285856 7.2583333 0.286446 7.2611111 0.285856 7.2638889 0.284972 7.2666667 0.284383 7.2694444 0.283499 7.2722222 0.282026 7.2750000 0.280847 7.2777778 0.279079 7.2805556 0.277017 7.2833333 0.275838 7.2861111 0.277311 7.2888889 0.283204 7.2916667 0.291160 7.2944444 0.299116 7.2972222 0.303831 7.3000000 0.309134 7.3027778 0.315617 7.3055556 0.323278 7.3083333 0.329761 7.3111111 0.335359 7.3138889 0.336832 7.3166667 0.326814 7.3194444 0.307072 7.3222222 0.289392 7.3250000 0.281142 7.3277778 0.281731 7.3305556 0.282615 7.3333333 0.282026 7.3361111 0.283499 7.3388889 0.284383 7.3416667 0.284383 7.3444444 0.283794 7.3472222 0.282615 7.3500000 0.282910 7.3527778 0.282615 7.3555556 0.283499 7.3583333 0.283499 7.3611111 0.282910 7.3638889 0.283499 7.3666667 0.282615 7.3694444 0.283204 7.3722222 0.283499 7.3750000 0.283499 7.3777778 0.283204 7.3805556 0.283204 7.3833333 0.282910 7.3861111 0.283204 7.3888889 0.283794 7.3916667 0.284088 7.3944444 0.283794 7.3972222 0.283499 7.4000000 0.283204 7.4027778 0.283499 7.4055556 0.283794 7.4083333 0.284972 7.4111111 0.284972 7.4138889 0.283204 7.4166667 0.282910 7.4194444 0.283794 7.4222222 0.284972 7.4250000 0.284383 7.4277778 0.284972 7.4305556 0.284088 7.4333333 0.283204 7.4361111 0.284088 7.4388889 0.285562 7.4416667 0.285267 7.4444444 0.284383 7.4472222 0.283794 7.4500000 0.282615 7.4527778 0.283794 7.4555556 0.284088 7.4583333 0.284383 7.4611111 0.284383 7.4638889 0.284088 7.4666667 0.283794 7.4694444 0.283794 7.4722222 0.284383 7.4750000 0.284088 7.4777778 0.284383 7.4805556 0.283794 7.4833333 0.283499 7.4861111 0.283794 7.4888889 0.283204 7.4916667 0.283499 7.4944444 0.282910 7.4972222 0.282910 7.5000000 0.282615 7.5027778 0.282320 7.5055556 0.283204 7.5083333 0.283204 7.5111111 0.282320 7.5138889 0.282026 7.5166667 0.280847 7.5194444 0.281436 7.5222222 0.282320 7.5250000 0.281436 7.5277778 0.281436 7.5305556 0.280847 7.5333333 0.279079 7.5361111 0.279374 7.5388889 0.278785 7.5416667 0.279374 7.5444444 0.279374 7.5472222 0.278490 7.5500000 0.277901 7.5527778 0.277311 7.5555556 0.277311 7.5583333 0.277017 7.5611111 0.277606 7.5638889 0.276427 7.5666667 0.276133 7.5694444 0.275543 7.5722222 0.277017 7.5750000 0.277017 7.5777778 0.277017 7.5805556 0.276427 7.5833333 0.276133 7.5861111 0.277017 7.5888889 0.278195 7.5916667 0.279374 7.5944444 0.279669 7.5972222 0.279669 7.6000000 0.280552 7.6027778 0.280847 7.6055556 0.282910 7.6083333 0.284088 7.6111111 0.284383 7.6168889 0.300000 7.8636667 0.300000 7.8666667 0.284088 7.8694444 0.284678 7.8722222 0.285562 7.8750000 0.286151 7.8777778 0.286151 7.8805556 0.284972 7.8833333 0.284972 7.8861111 0.284972 7.8888889 0.286446 7.8916667 0.286151 7.8944444 0.285856 7.8972222 0.285562 7.9000000 0.284972 7.9027778 0.285267 7.9055556 0.285856 7.9083333 0.286151 7.9111111 0.285562 7.9138889 0.285267 7.9166667 0.285267 7.9194444 0.285562 7.9222222 0.286740 7.9250000 0.287330 7.9277778 0.286446 7.9305556 0.287035 7.9333333 0.287035 7.9361111 0.287330 7.9388889 0.287624 7.9416667 0.287919 7.9444444 0.287624 7.9472222 0.287624 7.9500000 0.287624 7.9527778 0.287624 7.9555556 0.288508 7.9583333 0.289392 7.9611111 0.289982 7.9638889 0.289687 7.9666667 0.287919 7.9694444 0.289098 7.9722222 0.289687 7.9750000 0.289392 7.9777778 0.289392 7.9805556 0.288803 7.9833333 0.287919 7.9861111 0.288214 7.9888889 0.289098 7.9916667 0.288508 7.9944444 0.288214 7.9972222 0.287035 8.0000000 0.286740 8.0027778 0.286446 8.0055556 0.286740 8.0083333 0.286740 8.0111111 0.286446 8.0138889 0.285562 8.0166667 0.285562 8.0194444 0.286151 8.0222222 0.286446 8.0250000 0.286446 8.0277778 0.286151 8.0305556 0.285562 8.0333333 0.285562 8.0361111 0.284678 8.0388889 0.286151 8.0416667 0.286446 8.0444444 0.285856 8.0472222 0.284678 8.0500000 0.284383 8.0527778 0.285562 8.0555556 0.286151 8.0583333 0.286446 8.0611111 0.285856 8.0638889 0.285267 8.0666667 0.284383 8.0694444 0.283794 8.0722222 0.283204 8.0750000 0.282910 8.0777778 0.281142 8.0805556 0.278195 8.0833333 0.276722 8.0861111 0.276427 8.0888889 0.278785 8.0916667 0.285856 8.0944444 0.292634 8.0972222 0.297348 8.1000000 0.299705 8.1027778 0.305304 8.1055556 0.310902 8.1083333 0.317680 8.1111111 0.323573 8.1138889 0.327993 8.1166667 0.327993 8.1194444 0.320331 8.1222222 0.304715 8.1250000 0.286740 8.1277778 0.277017 8.1305556 0.277017 8.1333333 0.279374 8.1361111 0.281436 8.1388889 0.282615 8.1416667 0.283204 8.1444444 0.284383 8.1472222 0.282615 8.1500000 0.282320 8.1527778 0.282615 8.1555556 0.283204 8.1583333 0.283204 8.1611111 0.282910 8.1638889 0.283204 8.1666667 0.282910 8.1694444 0.283204 8.1722222 0.283204 8.1750000 0.283499 8.1777778 0.283794 8.1805556 0.282320 8.1833333 0.282320 8.1861111 0.282615 8.1888889 0.284088 8.1916667 0.284678 8.1944444 0.283794 8.1972222 0.282910 8.2000000 0.282026 8.2027778 0.282320 8.2055556 0.283204 8.2083333 0.283499 8.2111111 0.284383 8.2138889 0.283204 8.2166667 0.283204 8.2194444 0.282910 8.2222222 0.283499 8.2250000 0.284088 8.2277778 0.283794 8.2305556 0.283204 8.2333333 0.282910 8.2361111 0.282615 8.2388889 0.283204 8.2416667 0.283204 8.2444444 0.282910 8.2472222 0.283204 8.2500000 0.282320 8.2527778 0.283204 8.2555556 0.283499 8.2583333 0.284088 8.2611111 0.283204 8.2638889 0.282320 8.2666667 0.282320 8.2694444 0.282910 8.2722222 0.282320 8.2750000 0.283499 8.2777778 0.283499 8.2805556 0.282320 8.2833333 0.282026 8.2861111 0.282320 8.2888889 0.283204 8.2916667 0.282615 8.2944444 0.282320 8.2972222 0.281436 8.3000000 0.281142 8.3027778 0.281436 8.3055556 0.281436 8.3083333 0.281142 8.3111111 0.280847 8.3138889 0.280552 8.3166667 0.279669 8.3194444 0.280258 8.3222222 0.281142 8.3250000 0.280258 8.3277778 0.280552 8.3305556 0.279079 8.3333333 0.277901 8.3361111 0.277901 8.3388889 0.277606 8.3416667 0.278195 8.3444444 0.277606 8.3472222 0.276427 8.3500000 0.275543 8.3527778 0.275543 8.3555556 0.276722 8.3583333 0.276427 8.3611111 0.275838 8.3638889 0.274954 8.3666667 0.274954 8.3694444 0.274659 8.3722222 0.275249 8.3750000 0.275838 8.3777778 0.275543 8.3805556 0.274954 8.3833333 0.274070 8.3861111 0.274659 8.3888889 0.276133 8.3916667 0.276722 8.3944444 0.277017 8.3972222 0.277606 8.4000000 0.277311 8.4027778 0.278490 8.4055556 0.279669 8.4083333 0.280258 8.4111111 0.281436 8.4138889 0.280847 8.4196667 0.300000 8.6414444 0.300000 8.6444444 0.282026 8.6472222 0.281436 8.6500000 0.279963 8.6527778 0.280258 8.6555556 0.281436 8.6583333 0.281142 8.6611111 0.281436 8.6638889 0.280847 8.6666667 0.280258 8.6694444 0.280847 8.6722222 0.281731 8.6750000 0.282026 8.6777778 0.282615 8.6805556 0.281436 8.6833333 0.280552 8.6861111 0.280258 8.6888889 0.280552 8.6916667 0.281436 8.6944444 0.280552 8.6972222 0.280258 8.7000000 0.281142 8.7027778 0.280552 8.7055556 0.282026 8.7083333 0.282320 8.7111111 0.282320 8.7138889 0.282615 8.7166667 0.282910 8.7194444 0.282615 8.7222222 0.282615 8.7250000 0.282615 8.7277778 0.282910 8.7305556 0.282026 8.7333333 0.281731 8.7361111 0.282026 8.7388889 0.282910 8.7416667 0.282910 8.7444444 0.283499 8.7472222 0.283499 8.7500000 0.282320 8.7527778 0.283204 8.7555556 0.283794 8.7583333 0.283499 8.7611111 0.283204 8.7638889 0.282615 8.7666667 0.281436 8.7694444 0.280847 8.7722222 0.281436 8.7750000 0.282026 8.7777778 0.281436 8.7805556 0.281436 8.7833333 0.280552 8.7861111 0.280258 8.7888889 0.279669 8.7916667 0.279963 8.7944444 0.280258 8.7972222 0.280552 8.8000000 0.279963 8.8027778 0.279669 8.8055556 0.280258 8.8083333 0.279963 8.8111111 0.280258 8.8138889 0.279669 8.8166667 0.278785 8.8194444 0.279963 8.8222222 0.280258 8.8250000 0.279963 8.8277778 0.279374 8.8305556 0.279374 8.8333333 0.279079 8.8361111 0.279374 8.8388889 0.280258 8.8416667 0.280847 8.8444444 0.280552 8.8472222 0.277606 8.8500000 0.276427 8.8527778 0.275249 8.8555556 0.275543 8.8583333 0.274365 8.8611111 0.272891 8.8638889 0.272007 8.8666667 0.274659 8.8694444 0.280552 8.8722222 0.287919 8.8750000 0.293223 8.8777778 0.297937 8.8805556 0.301179 8.8833333 0.306483 8.8861111 0.314438 8.8888889 0.320921 8.8916667 0.319742 8.8944444 0.305304 8.8972222 0.285267 8.9000000 0.271418 8.9027778 0.269355 8.9055556 0.272891 8.9083333 0.276133 8.9111111 0.277901 8.9138889 0.277901 8.9166667 0.277017 8.9194444 0.277901 8.9222222 0.278490 8.9250000 0.279374 8.9277778 0.279079 8.9305556 0.278490 8.9333333 0.278195 8.9361111 0.278195 8.9388889 0.278490 8.9416667 0.278490 8.9444444 0.279079 8.9472222 0.279079 8.9500000 0.278785 8.9527778 0.278490 8.9555556 0.279079 8.9583333 0.279374 8.9611111 0.278785 8.9638889 0.279079 8.9666667 0.278490 8.9694444 0.279374 8.9722222 0.279079 8.9750000 0.279963 8.9777778 0.279669 8.9805556 0.278785 8.9833333 0.278490 8.9861111 0.279374 8.9888889 0.280258 8.9916667 0.280258 8.9944444 0.279963 8.9972222 0.279963 9.0000000 0.279079 9.0027778 0.279079 9.0055556 0.279374 9.0083333 0.279669 9.0111111 0.279374 9.0138889 0.278490 9.0166667 0.278785 9.0194444 0.279374 9.0222222 0.280258 9.0250000 0.280552 9.0277778 0.279374 9.0305556 0.279079 9.0333333 0.279079 9.0361111 0.278490 9.0388889 0.279963 9.0416667 0.279963 9.0444444 0.279374 9.0472222 0.278785 9.0500000 0.278785 9.0527778 0.278195 9.0555556 0.279079 9.0583333 0.279374 9.0611111 0.279669 9.0638889 0.279669 9.0666667 0.278785 9.0694444 0.278785 9.0722222 0.278785 9.0750000 0.279374 9.0777778 0.278785 9.0805556 0.278195 9.0833333 0.277311 9.0861111 0.277606 9.0888889 0.277017 9.0916667 0.277606 9.0944444 0.276722 9.0972222 0.276133 9.1000000 0.276133 9.1027778 0.275838 9.1055556 0.276133 9.1083333 0.274659 9.1111111 0.275249 9.1138889 0.274070 9.1166667 0.272891 9.1194444 0.273186 9.1222222 0.273775 9.1250000 0.273481 9.1277778 0.272891 9.1305556 0.271713 9.1333333 0.270829 9.1361111 0.272007 9.1388889 0.272597 9.1416667 0.272597 9.1444444 0.272891 9.1472222 0.272891 9.1500000 0.272891 9.1527778 0.272891 9.1555556 0.274659 9.1583333 0.275543 9.1611111 0.276427 9.1638889 0.277311 9.1666667 0.277311 9.1694444 0.278195 9.1722222 0.279079 9.1750000 0.280552 9.1777778 0.281731 9.1805556 0.281142 9.1833333 0.281436 9.1861111 0.282320 9.1888889 0.283794 9.1916667 0.283794 9.1974444 0.300000 9.4275556 0.300000 9.4305556 0.283499 9.4333333 0.282910 9.4361111 0.283204 9.4388889 0.283499 9.4416667 0.283499 9.4444444 0.283794 9.4472222 0.282910 9.4500000 0.282320 9.4527778 0.283204 9.4555556 0.283794 9.4583333 0.283499 9.4611111 0.284088 9.4638889 0.283794 9.4666667 0.282615 9.4694444 0.282910 9.4722222 0.283204 9.4750000 0.283499 9.4777778 0.284678 9.4805556 0.283499 9.4833333 0.283499 9.4861111 0.284678 9.4888889 0.284972 9.4916667 0.284972 9.4944444 0.285562 9.4972222 0.285267 9.5000000 0.284972 9.5027778 0.285856 9.5055556 0.286446 9.5083333 0.286446 9.5111111 0.286151 9.5138889 0.285562 9.5166667 0.285267 9.5194444 0.285267 9.5222222 0.286151 9.5250000 0.286446 9.5277778 0.286740 9.5305556 0.286446 9.5333333 0.285856 9.5361111 0.286151 9.5388889 0.287035 9.5416667 0.287919 9.5444444 0.286740 9.5472222 0.285856 9.5500000 0.284678 9.5527778 0.284972 9.5555556 0.284972 9.5583333 0.286151 9.5611111 0.285562 9.5638889 0.284678 9.5666667 0.283794 9.5694444 0.283794 9.5722222 0.284383 9.5750000 0.284383 9.5777778 0.283794 9.5805556 0.283794 9.5833333 0.283204 9.5861111 0.283204 9.5888889 0.283499 9.5916667 0.284088 9.5944444 0.283499 9.5972222 0.283499 9.6000000 0.282320 9.6027778 0.283204 9.6055556 0.283794 9.6083333 0.283499 9.6111111 0.283204 9.6138889 0.282615 9.6166667 0.282320 9.6194444 0.283204 9.6222222 0.283499 9.6250000 0.283794 9.6277778 0.283499 9.6305556 0.281731 9.6333333 0.279963 9.6361111 0.277901 9.6388889 0.278195 9.6416667 0.276722 9.6444444 0.275249 9.6472222 0.274070 9.6500000 0.275249 9.6527778 0.280847 9.6555556 0.286740 9.6583333 0.294991 9.6611111 0.301179 9.6638889 0.305893 9.6666667 0.310313 9.6694444 0.317090 9.6722222 0.324457 9.6750000 0.332118 9.6777778 0.337716 9.6805556 0.338011 9.6833333 0.326225 9.6861111 0.304125 9.6888889 0.285562 9.6916667 0.279079 9.6944444 0.280847 9.6972222 0.281731 9.7000000 0.280552 9.7027778 0.281142 9.7055556 0.282026 9.7083333 0.282615 9.7111111 0.281731 9.7138889 0.280847 9.7166667 0.280552 9.7194444 0.279963 9.7222222 0.280552 9.7250000 0.281142 9.7277778 0.280552 9.7305556 0.279963 9.7333333 0.279963 9.7361111 0.279963 9.7388889 0.280847 9.7416667 0.280847 9.7444444 0.280552 9.7472222 0.279374 9.7500000 0.279374 9.7527778 0.280258 9.7555556 0.280847 9.7583333 0.281142 9.7611111 0.280258 9.7638889 0.280258 9.7666667 0.279669 9.7694444 0.280258 9.7722222 0.281142 9.7750000 0.281436 9.7777778 0.281142 9.7805556 0.281142 9.7833333 0.280258 9.7861111 0.280847 9.7888889 0.280552 9.7916667 0.280847 9.7944444 0.281142 9.7972222 0.280258 9.8000000 0.279963 9.8027778 0.280552 9.8055556 0.281436 9.8083333 0.281436 9.8111111 0.281142 9.8138889 0.280552 9.8166667 0.279963 9.8194444 0.279963 9.8222222 0.280552 9.8250000 0.281142 9.8277778 0.281436 9.8305556 0.280552 9.8333333 0.279669 9.8361111 0.279669 9.8388889 0.280552 9.8416667 0.280552 9.8444444 0.280552 9.8472222 0.279963 9.8500000 0.279079 9.8527778 0.279669 9.8555556 0.279669 9.8583333 0.279669 9.8611111 0.279669 9.8638889 0.279079 9.8666667 0.277901 9.8694444 0.277901 9.8722222 0.278490 9.8750000 0.278490 9.8777778 0.278195 9.8805556 0.277311 9.8833333 0.276722 9.8861111 0.276722 9.8888889 0.277017 9.8916667 0.277017 9.8944444 0.276133 9.8972222 0.275838 9.9000000 0.274365 9.9027778 0.273775 9.9055556 0.274954 9.9083333 0.274365 9.9111111 0.274659 9.9138889 0.275249 9.9166667 0.273186 9.9194444 0.273481 9.9222222 0.272891 9.9250000 0.273186 9.9277778 0.273481 9.9305556 0.272007 9.9333333 0.271123 9.9361111 0.272007 9.9388889 0.272007 9.9416667 0.272597 9.9444444 0.272597 9.9472222 0.272007 9.9500000 0.271418 9.9527778 0.272302 9.9555556 0.273481 9.9583333 0.274365 9.9611111 0.275543 9.9638889 0.274954 9.9666667 0.276133 9.9694444 0.277311 9.9722222 0.278195 9.9750000 0.279374 9.9777778 0.279669 9.9835556 0.300000 10.2275556 0.300000 10.2305556 0.283204 10.2333333 0.282320 10.2361111 0.283204 10.2388889 0.284088 10.2416667 0.284088 10.2444444 0.284088 10.2472222 0.283204 10.2500000 0.282026 10.2527778 0.282615 10.2555556 0.284088 10.2583333 0.284383 10.2611111 0.284383 10.2638889 0.283499 10.2666667 0.282615 10.2694444 0.283499 10.2722222 0.283794 10.2750000 0.283499 10.2777778 0.283499 10.2805556 0.283204 10.2833333 0.284088 10.2861111 0.284383 10.2888889 0.285267 10.2916667 0.286446 10.2944444 0.285856 10.2972222 0.285267 10.3000000 0.284678 10.3027778 0.285856 10.3055556 0.286151 10.3083333 0.287035 10.3111111 0.286740 10.3138889 0.286446 10.3166667 0.285856 10.3194444 0.286740 10.3222222 0.287035 10.3250000 0.287035 10.3277778 0.287624 10.3305556 0.286740 10.3333333 0.287035 10.3361111 0.286446 10.3388889 0.286151 10.3416667 0.286446 10.3444444 0.286151 10.3472222 0.285856 10.3500000 0.284972 10.3527778 0.285562 10.3555556 0.285562 10.3583333 0.285562 10.3611111 0.284383 10.3638889 0.284088 10.3666667 0.284088 10.3694444 0.284088 10.3722222 0.284972 10.3750000 0.284972 10.3777778 0.284972 10.3805556 0.284383 10.3833333 0.284088 10.3861111 0.283794 10.3888889 0.284088 10.3916667 0.284088 10.3944444 0.284972 10.3972222 0.283794 10.4000000 0.283794 10.4027778 0.284088 10.4055556 0.284678 10.4083333 0.285267 10.4111111 0.284678 10.4138889 0.283794 10.4166667 0.283204 10.4194444 0.282910 10.4222222 0.283794 10.4250000 0.284383 10.4277778 0.284088 10.4305556 0.283204 10.4333333 0.281436 10.4361111 0.280258 10.4388889 0.279079 10.4416667 0.277606 10.4444444 0.276722 10.4472222 0.274659 10.4500000 0.275838 10.4527778 0.280258 10.4555556 0.287330 10.4583333 0.295285 10.4611111 0.301179 10.4638889 0.307072 10.4666667 0.312965 10.4694444 0.320626 10.4722222 0.328287 10.4750000 0.334770 10.4777778 0.336243 10.4805556 0.326814 10.4833333 0.308545 10.4861111 0.289098 10.4888889 0.279669 10.4916667 0.280258 10.4944444 0.282615 10.4972222 0.281731 10.5000000 0.281731 10.5027778 0.281731 10.5055556 0.282615 10.5083333 0.282910 10.5111111 0.282320 10.5138889 0.281731 10.5166667 0.281731 10.5194444 0.281436 10.5222222 0.281731 10.5250000 0.282910 10.5277778 0.282026 10.5305556 0.281731 10.5333333 0.281436 10.5361111 0.280847 10.5388889 0.281731 10.5416667 0.282910 10.5444444 0.282026 10.5472222 0.281436 10.5500000 0.281142 10.5527778 0.281436 10.5555556 0.281731 10.5583333 0.281436 10.5611111 0.282320 10.5638889 0.281731 10.5666667 0.281731 10.5694444 0.281142 10.5722222 0.282615 10.5750000 0.282320 10.5777778 0.282320 10.5805556 0.281436 10.5833333 0.281142 10.5861111 0.281731 10.5888889 0.282026 10.5916667 0.282615 10.5944444 0.282320 10.5972222 0.281731 10.6000000 0.281436 10.6027778 0.281142 10.6055556 0.281731 10.6083333 0.282615 10.6111111 0.282910 10.6138889 0.282026 10.6166667 0.281436 10.6194444 0.281142 10.6222222 0.281731 10.6250000 0.282910 10.6277778 0.282026 10.6305556 0.281436 10.6333333 0.280847 10.6361111 0.281142 10.6388889 0.281436 10.6416667 0.282320 10.6444444 0.281731 10.6472222 0.280258 10.6500000 0.280847 10.6527778 0.281142 10.6555556 0.281731 10.6583333 0.282026 10.6611111 0.281731 10.6638889 0.280847 10.6666667 0.280258 10.6694444 0.280847 10.6722222 0.280847 10.6750000 0.281436 10.6777778 0.279963 10.6805556 0.280258 10.6833333 0.279374 10.6861111 0.279374 10.6888889 0.279374 10.6916667 0.279374 10.6944444 0.278490 10.6972222 0.278195 10.7000000 0.277311 10.7027778 0.277311 10.7055556 0.277311 10.7083333 0.278195 10.7111111 0.277017 10.7138889 0.275543 10.7166667 0.275543 10.7194444 0.275543 10.7222222 0.276133 10.7250000 0.276427 10.7277778 0.275543 10.7305556 0.274954 10.7333333 0.273775 10.7361111 0.273481 10.7388889 0.274070 10.7416667 0.275249 10.7444444 0.274954 10.7472222 0.274659 10.7500000 0.274365 10.7527778 0.274659 10.7555556 0.275543 10.7583333 0.275838 10.7611111 0.277311 10.7638889 0.277311 10.7666667 0.277901 10.7694444 0.277901 10.7722222 0.279963 10.7750000 0.281142 10.7777778 0.281731 10.7835556 0.300000 11.0247778 0.300000 11.0277778 0.285267 11.0305556 0.284678 11.0333333 0.284383 11.0361111 0.284383 11.0388889 0.284678 11.0416667 0.285562 11.0444444 0.285267 11.0472222 0.285562 11.0500000 0.284972 11.0527778 0.284972 11.0555556 0.284972 11.0583333 0.285267 11.0611111 0.285267 11.0638889 0.284678 11.0666667 0.284678 11.0694444 0.285267 11.0722222 0.285562 11.0750000 0.286446 11.0777778 0.286151 11.0805556 0.285856 11.0833333 0.285267 11.0861111 0.285562 11.0888889 0.286740 11.0916667 0.287919 11.0944444 0.287035 11.0972222 0.287035 11.1000000 0.286446 11.1027778 0.285856 11.1055556 0.287330 11.1083333 0.287919 11.1111111 0.287624 11.1138889 0.288508 11.1166667 0.287919 11.1194444 0.288214 11.1222222 0.288214 11.1250000 0.288508 11.1277778 0.288508 11.1305556 0.288214 11.1333333 0.287035 11.1361111 0.286151 11.1388889 0.286446 11.1416667 0.286740 11.1444444 0.286151 11.1472222 0.285562 11.1500000 0.284678 11.1527778 0.284972 11.1555556 0.285562 11.1583333 0.286740 11.1611111 0.285562 11.1638889 0.285267 11.1666667 0.284088 11.1694444 0.284088 11.1722222 0.284972 11.1750000 0.285562 11.1777778 0.284678 11.1805556 0.284678 11.1833333 0.284678 11.1861111 0.284972 11.1888889 0.284972 11.1916667 0.284678 11.1944444 0.284678 11.1972222 0.284383 11.2000000 0.284678 11.2027778 0.283499 11.2055556 0.284678 11.2083333 0.284972 11.2111111 0.285267 11.2138889 0.284383 11.2166667 0.284088 11.2194444 0.284088 11.2222222 0.284383 11.2250000 0.284678 11.2277778 0.284088 11.2305556 0.283204 11.2333333 0.282026 11.2361111 0.279963 11.2388889 0.278785 11.2416667 0.278195 11.2444444 0.277017 11.2472222 0.277311 11.2500000 0.281731 11.2527778 0.287919 11.2555556 0.293517 11.2583333 0.298821 11.2611111 0.302357 11.2638889 0.306483 11.2666667 0.312081 11.2694444 0.319153 11.2722222 0.324457 11.2750000 0.324751 11.2777778 0.312376 11.2805556 0.294696 11.2833333 0.280258 11.2861111 0.275543 11.2888889 0.277606 11.2916667 0.280847 11.2944444 0.282026 11.2972222 0.281436 11.3000000 0.281731 11.3027778 0.282026 11.3055556 0.282910 11.3083333 0.283204 11.3111111 0.282910 11.3138889 0.281731 11.3166667 0.282026 11.3194444 0.282026 11.3222222 0.282320 11.3250000 0.283204 11.3277778 0.282615 11.3305556 0.282026 11.3333333 0.281436 11.3361111 0.281731 11.3388889 0.282026 11.3416667 0.283204 11.3444444 0.282910 11.3472222 0.282026 11.3500000 0.281731 11.3527778 0.281731 11.3555556 0.282615 11.3583333 0.282910 11.3611111 0.282320 11.3638889 0.281436 11.3666667 0.280847 11.3694444 0.281436 11.3722222 0.281731 11.3750000 0.283204 11.3777778 0.282615 11.3805556 0.282320 11.3833333 0.281731 11.3861111 0.281436 11.3888889 0.281731 11.3916667 0.282320 11.3944444 0.282320 11.3972222 0.281731 11.4000000 0.282026 11.4027778 0.281731 11.4055556 0.282320 11.4083333 0.282026 11.4111111 0.282615 11.4138889 0.281436 11.4166667 0.282026 11.4194444 0.282026 11.4222222 0.282615 11.4250000 0.283794 11.4277778 0.282615 11.4305556 0.282615 11.4333333 0.281731 11.4361111 0.281436 11.4388889 0.282026 11.4416667 0.282615 11.4444444 0.282320 11.4472222 0.282615 11.4500000 0.281436 11.4527778 0.281731 11.4555556 0.282026 11.4583333 0.282615 11.4611111 0.282910 11.4638889 0.282026 11.4666667 0.281142 11.4694444 0.280552 11.4722222 0.281142 11.4750000 0.281731 11.4777778 0.282026 11.4805556 0.281436 11.4833333 0.281142 11.4861111 0.280552 11.4888889 0.280552 11.4916667 0.281436 11.4944444 0.280552 11.4972222 0.279963 11.5000000 0.279374 11.5027778 0.278195 11.5055556 0.279669 11.5083333 0.279374 11.5111111 0.279079 11.5138889 0.278195 11.5166667 0.277017 11.5194444 0.277311 11.5222222 0.277901 11.5250000 0.277311 11.5277778 0.276427 11.5305556 0.276722 11.5333333 0.275543 11.5361111 0.275249 11.5388889 0.275249 11.5416667 0.276133 11.5444444 0.275543 11.5472222 0.275249 11.5500000 0.274365 11.5527778 0.273775 11.5555556 0.274070 11.5583333 0.274659 11.5611111 0.275249 11.5638889 0.275543 11.5666667 0.275543 11.5694444 0.276133 11.5722222 0.277606 11.5750000 0.278195 11.5807778 0.300000 11.8386667 0.300000 11.8416667 0.282615 11.8444444 0.282910 11.8472222 0.282320 11.8500000 0.282026 11.8527778 0.282026 11.8555556 0.282910 11.8583333 0.282910 11.8611111 0.282026 11.8638889 0.281731 11.8666667 0.281142 11.8694444 0.280847 11.8722222 0.282026 11.8750000 0.282615 11.8777778 0.282320 11.8805556 0.281731 11.8833333 0.281731 11.8861111 0.282026 11.8888889 0.282320 11.8916667 0.282910 11.8944444 0.282910 11.8972222 0.282615 11.9000000 0.282615 11.9027778 0.283204 11.9055556 0.283794 11.9083333 0.284383 11.9111111 0.284383 11.9138889 0.283794 11.9166667 0.283794 11.9194444 0.284088 11.9222222 0.284088 11.9250000 0.285856 11.9277778 0.285562 11.9305556 0.285562 11.9333333 0.284678 11.9361111 0.284678 11.9388889 0.285267 11.9416667 0.285856 11.9444444 0.285856 11.9472222 0.284678 11.9500000 0.283794 11.9527778 0.283499 11.9555556 0.283499 11.9583333 0.284088 11.9611111 0.284383 11.9638889 0.283794 11.9666667 0.283794 11.9694444 0.282910 11.9722222 0.282910 11.9750000 0.282910 11.9777778 0.282320 11.9805556 0.282615 11.9833333 0.281731 11.9861111 0.282320 11.9888889 0.282615 11.9916667 0.283204 11.9944444 0.282615 11.9972222 0.282320 12.0000000 0.282026 12.0027778 0.281731 12.0055556 0.282910 12.0083333 0.283204 12.0111111 0.282910 12.0138889 0.282910 12.0166667 0.281731 12.0194444 0.281731 12.0222222 0.282615 12.0250000 0.282910 12.0277778 0.282910 12.0305556 0.282910 12.0333333 0.282910 12.0361111 0.282615 12.0388889 0.282615 12.0416667 0.281731 12.0444444 0.280258 12.0472222 0.279374 12.0500000 0.278195 12.0527778 0.276722 12.0555556 0.275838 12.0583333 0.275543 12.0611111 0.277017 12.0638889 0.279669 12.0666667 0.284972 12.0694444 0.292044 12.0722222 0.297937 12.0750000 0.301473 12.0777778 0.305009 12.0805556 0.310313 12.0833333 0.316206 12.0861111 0.322983 12.0888889 0.326519 12.0916667 0.319742 12.0944444 0.301768 12.0972222 0.282910 12.1000000 0.273481 12.1027778 0.273775 12.1055556 0.278195 12.1083333 0.280847 12.1111111 0.281142 12.1138889 0.282026 12.1166667 0.281731 12.1194444 0.280847 12.1222222 0.281731 12.1250000 0.282026 12.1277778 0.282320 12.1305556 0.282615 12.1333333 0.281731 12.1361111 0.281731 12.1388889 0.282026 12.1416667 0.283499 12.1444444 0.283499 12.1472222 0.282026 12.1500000 0.281731 12.1527778 0.282320 12.1555556 0.283204 12.1583333 0.283204 12.1611111 0.282615 12.1638889 0.282320 12.1666667 0.281436 12.1694444 0.282026 12.1722222 0.282910 12.1750000 0.283794 12.1777778 0.283204 12.1805556 0.283794 12.1833333 0.282910 12.1861111 0.283204 12.1888889 0.283794 12.1916667 0.283794 12.1944444 0.283499 12.1972222 0.282910 12.2000000 0.282910 12.2027778 0.282320 12.2055556 0.282910 12.2083333 0.284088 12.2111111 0.284088 12.2138889 0.284383 12.2166667 0.282615 12.2194444 0.281731 12.2222222 0.282615 12.2250000 0.283794 12.2277778 0.283794 12.2305556 0.283499 12.2333333 0.283204 12.2361111 0.282910 12.2388889 0.283204 12.2416667 0.284088 12.2444444 0.283794 12.2472222 0.282615 12.2500000 0.282320 12.2527778 0.282615 12.2555556 0.283499 12.2583333 0.284088 12.2611111 0.283204 12.2638889 0.282320 12.2666667 0.282026 12.2694444 0.281731 12.2722222 0.282910 12.2750000 0.283499 12.2777778 0.282615 12.2805556 0.282615 12.2833333 0.282320 12.2861111 0.281731 12.2888889 0.281731 12.2916667 0.282615 12.2944444 0.282615 12.2972222 0.282026 12.3000000 0.281142 12.3027778 0.281142 12.3055556 0.281436 12.3083333 0.282026 12.3111111 0.280552 12.3138889 0.280847 12.3166667 0.278785 12.3194444 0.279374 12.3222222 0.279669 12.3250000 0.279963 12.3277778 0.279079 12.3305556 0.278195 12.3333333 0.277311 12.3361111 0.276722 12.3388889 0.277606 12.3416667 0.277901 12.3444444 0.277017 12.3472222 0.276427 12.3500000 0.276133 12.3527778 0.275838 12.3555556 0.275838 12.3583333 0.275543 12.3611111 0.275249 12.3638889 0.274954 12.3666667 0.274070 12.3694444 0.274659 12.3722222 0.275838 12.3750000 0.276133 12.3777778 0.276427 12.3805556 0.276133 12.3833333 0.275838 12.3861111 0.276427 12.3888889 0.277606 12.3946667 0.300000 12.6858889 0.300000 12.6888889 0.286151 12.6916667 0.286151 12.6944444 0.286151 12.6972222 0.285562 12.7000000 0.285267 12.7027778 0.284972 12.7055556 0.285856 12.7083333 0.286446 12.7111111 0.285856 12.7138889 0.285267 12.7166667 0.285267 12.7194444 0.285267 12.7222222 0.284972 12.7250000 0.286151 12.7277778 0.286446 12.7305556 0.286446 12.7333333 0.286151 12.7361111 0.286151 12.7388889 0.286740 12.7416667 0.287624 12.7444444 0.287624 12.7472222 0.287035 12.7500000 0.287035 12.7527778 0.286446 12.7555556 0.287624 12.7583333 0.288214 12.7611111 0.288508 12.7638889 0.287624 12.7666667 0.287624 12.7694444 0.288214 12.7722222 0.288803 12.7750000 0.289982 12.7777778 0.289098 12.7805556 0.288214 12.7833333 0.287919 12.7861111 0.288508 12.7888889 0.288508 12.7916667 0.289687 12.7944444 0.289392 12.7972222 0.287919 12.8000000 0.287330 12.8027778 0.287035 12.8055556 0.287330 12.8083333 0.287624 12.8111111 0.288214 12.8138889 0.286740 12.8166667 0.286740 12.8194444 0.285562 12.8222222 0.286446 12.8250000 0.286446 12.8277778 0.285856 12.8305556 0.286151 12.8333333 0.285856 12.8361111 0.285856 12.8388889 0.286446 12.8416667 0.286740 12.8444444 0.286151 12.8472222 0.284972 12.8500000 0.284678 12.8527778 0.285562 12.8555556 0.286151 12.8583333 0.286740 12.8611111 0.286446 12.8638889 0.286151 12.8666667 0.285856 12.8694444 0.284972 12.8722222 0.285562 12.8750000 0.285856 12.8777778 0.286151 12.8805556 0.285562 12.8833333 0.285267 12.8861111 0.284972 12.8888889 0.284678 12.8916667 0.284383 12.8944444 0.282026 12.8972222 0.280258 12.9000000 0.278785 12.9027778 0.277311 12.9055556 0.276722 12.9083333 0.278490 12.9111111 0.282910 12.9138889 0.289687 12.9166667 0.297937 12.9194444 0.304420 12.9222222 0.311197 12.9250000 0.318564 12.9277778 0.325341 12.9305556 0.331823 12.9333333 0.338600 12.9361111 0.340958 12.9388889 0.333591 12.9416667 0.316796 12.9444444 0.296169 12.9472222 0.283499 12.9500000 0.281436 12.9527778 0.283204 12.9555556 0.284678 12.9583333 0.284972 12.9611111 0.284972 12.9638889 0.284972 12.9666667 0.283499 12.9694444 0.283204 12.9722222 0.283204 12.9750000 0.284678 12.9777778 0.284088 12.9805556 0.283499 12.9833333 0.282910 12.9861111 0.282320 12.9888889 0.282910 12.9916667 0.283204 12.9944444 0.282910 12.9972222 0.283204 13.0000000 0.282320 13.0027778 0.282615 13.0055556 0.283499 13.0083333 0.283499 13.0111111 0.283204 13.0138889 0.283794 13.0166667 0.282320 13.0194444 0.282320 13.0222222 0.282615 13.0250000 0.283204 13.0277778 0.282615 13.0305556 0.282320 13.0333333 0.282615 13.0361111 0.283204 13.0388889 0.283499 13.0416667 0.284088 13.0444444 0.284383 13.0472222 0.283204 13.0500000 0.282615 13.0527778 0.282910 13.0555556 0.282910 13.0583333 0.284383 13.0611111 0.284088 13.0638889 0.283204 13.0666667 0.283204 13.0694444 0.283204 13.0722222 0.283499 13.0750000 0.283499 13.0777778 0.283204 13.0805556 0.283794 13.0833333 0.283204 13.0861111 0.282910 13.0888889 0.282910 13.0916667 0.282910 13.0944444 0.282615 13.0972222 0.282615 13.1000000 0.282615 13.1027778 0.282320 13.1055556 0.282615 13.1083333 0.283794 13.1111111 0.283499 13.1138889 0.282910 13.1166667 0.281731 13.1194444 0.281731 13.1222222 0.282026 13.1250000 0.283204 13.1277778 0.282910 13.1305556 0.282026 13.1333333 0.281731 13.1361111 0.281436 13.1388889 0.281731 13.1416667 0.282910 13.1444444 0.282320 13.1472222 0.281731 13.1500000 0.280258 13.1527778 0.280847 13.1555556 0.281142 13.1583333 0.281731 13.1611111 0.281142 13.1638889 0.280258 13.1666667 0.279963 13.1694444 0.278490 13.1722222 0.279963 13.1750000 0.279374 13.1777778 0.279079 13.1805556 0.278195 13.1833333 0.277901 13.1861111 0.277311 13.1888889 0.277017 13.1916667 0.277606 13.1944444 0.276722 13.1972222 0.275838 13.2000000 0.275543 13.2027778 0.275543 13.2055556 0.275838 13.2083333 0.276427 13.2111111 0.275543 13.2138889 0.275543 13.2166667 0.274954 13.2194444 0.274954 13.2222222 0.275838 13.2250000 0.276427 13.2277778 0.276722 13.2305556 0.276722 13.2333333 0.276133 13.2361111 0.276427 13.2418889 0.300000 13.5108889 0.300000 13.5138889 0.285856 13.5166667 0.284678 13.5194444 0.285267 13.5222222 0.284972 13.5250000 0.286740 13.5277778 0.286446 13.5305556 0.285856 13.5333333 0.284678 13.5361111 0.285562 13.5388889 0.286740 13.5416667 0.286446 13.5444444 0.286151 13.5472222 0.285267 13.5500000 0.285267 13.5527778 0.284678 13.5555556 0.285562 13.5583333 0.286151 13.5611111 0.286740 13.5638889 0.285856 13.5666667 0.286151 13.5694444 0.285267 13.5722222 0.287035 13.5750000 0.287035 13.5777778 0.287330 13.5805556 0.287035 13.5833333 0.287035 13.5861111 0.287330 13.5888889 0.288508 13.5916667 0.287919 13.5944444 0.287919 13.5972222 0.287624 13.6000000 0.287919 13.6027778 0.287624 13.6055556 0.289098 13.6083333 0.289687 13.6111111 0.289392 13.6138889 0.288803 13.6166667 0.288214 13.6194444 0.287624 13.6222222 0.288508 13.6250000 0.288214 13.6277778 0.287330 13.6305556 0.287330 13.6333333 0.286151 13.6361111 0.286446 13.6388889 0.286740 13.6416667 0.287624 13.6444444 0.286740 13.6472222 0.286446 13.6500000 0.286446 13.6527778 0.285267 13.6555556 0.285562 13.6583333 0.286446 13.6611111 0.286151 13.6638889 0.285267 13.6666667 0.284678 13.6694444 0.284088 13.6722222 0.284972 13.6750000 0.285267 13.6777778 0.285267 13.6805556 0.284383 13.6833333 0.284972 13.6861111 0.284678 13.6888889 0.284972 13.6916667 0.285562 13.6944444 0.285562 13.6972222 0.285267 13.7000000 0.284383 13.7027778 0.284383 13.7055556 0.285267 13.7083333 0.285562 13.7111111 0.284972 13.7138889 0.284972 13.7166667 0.284088 13.7194444 0.283499 13.7222222 0.282910 13.7250000 0.282026 13.7277778 0.280258 13.7305556 0.277311 13.7333333 0.274954 13.7361111 0.275543 13.7388889 0.280847 13.7416667 0.288803 13.7444444 0.296169 13.7472222 0.301768 13.7500000 0.306483 13.7527778 0.312965 13.7555556 0.321215 13.7583333 0.327109 13.7611111 0.326519 13.7638889 0.313849 13.7666667 0.294107 13.7694444 0.278490 13.7722222 0.276427 13.7750000 0.281142 13.7777778 0.282615 13.7805556 0.282910 13.7833333 0.282910 13.7861111 0.282320 13.7888889 0.282320 13.7916667 0.283204 13.7944444 0.283204 13.7972222 0.282615 13.8000000 0.282026 13.8027778 0.281731 13.8055556 0.282615 13.8083333 0.283204 13.8111111 0.282320 13.8138889 0.282026 13.8166667 0.282026 13.8194444 0.281142 13.8222222 0.282026 13.8250000 0.282320 13.8277778 0.282910 13.8305556 0.281731 13.8333333 0.282026 13.8361111 0.281436 13.8388889 0.281731 13.8416667 0.281731 13.8444444 0.282320 13.8472222 0.282320 13.8500000 0.281731 13.8527778 0.281436 13.8555556 0.282320 13.8583333 0.282910 13.8611111 0.282026 13.8638889 0.281731 13.8666667 0.281142 13.8694444 0.281731 13.8722222 0.281731 13.8750000 0.282320 13.8777778 0.282026 13.8805556 0.282026 13.8833333 0.281142 13.8861111 0.280847 13.8888889 0.281731 13.8916667 0.282026 13.8944444 0.282026 13.8972222 0.281731 13.9000000 0.281436 13.9027778 0.282026 13.9055556 0.283204 13.9083333 0.282910 13.9111111 0.282026 13.9138889 0.281731 13.9166667 0.280552 13.9194444 0.280258 13.9222222 0.280847 13.9250000 0.281731 13.9277778 0.282026 13.9305556 0.281731 13.9333333 0.281142 13.9361111 0.280258 13.9388889 0.280552 13.9416667 0.281142 13.9444444 0.280552 13.9472222 0.280258 13.9500000 0.279374 13.9527778 0.279669 13.9555556 0.279963 13.9583333 0.280258 13.9611111 0.279669 13.9638889 0.279374 13.9666667 0.277606 13.9694444 0.278195 13.9722222 0.278490 13.9750000 0.278785 13.9777778 0.277606 13.9805556 0.277017 13.9833333 0.276722 13.9861111 0.276427 13.9888889 0.276722 13.9916667 0.277311 13.9944444 0.275543 13.9972222 0.275543 14.0000000 0.274365 14.0027778 0.274070 14.0055556 0.274365 14.0083333 0.273481 14.0111111 0.274365 14.0138889 0.274070 14.0166667 0.274070 14.0194444 0.273481 14.0222222 0.274365 14.0250000 0.274070 14.0277778 0.274954 14.0305556 0.273775 14.0333333 0.273775 14.0361111 0.274659 14.0388889 0.275249 14.0416667 0.275838 14.0444444 0.277017 14.0472222 0.276722 14.0500000 0.277017 14.0527778 0.277901 14.0555556 0.279079 14.0583333 0.280258 14.0611111 0.281142 14.0668889 0.300000 14.2858889 0.300000 14.2888889 0.280847 14.2916667 0.280258 14.2944444 0.280847 14.2972222 0.280847 14.3000000 0.281142 14.3027778 0.280552 14.3055556 0.280552 14.3083333 0.281436 14.3111111 0.281142 14.3138889 0.280847 14.3166667 0.279669 14.3194444 0.279963 14.3222222 0.280552 14.3250000 0.280552 14.3277778 0.280847 14.3305556 0.280258 14.3333333 0.280552 14.3361111 0.280552 14.3388889 0.280847 14.3416667 0.281436 14.3444444 0.280552 14.3472222 0.281142 14.3500000 0.281142 14.3527778 0.280847 14.3555556 0.282615 14.3583333 0.283499 14.3611111 0.283499 14.3638889 0.282320 14.3666667 0.281731 14.3694444 0.282320 14.3722222 0.282615 14.3750000 0.282615 14.3777778 0.282615 14.3805556 0.282615 14.3833333 0.282615 14.3861111 0.283794 14.3888889 0.284383 14.3916667 0.284678 14.3944444 0.283499 14.3972222 0.283499 14.4000000 0.282615 14.4027778 0.282910 14.4055556 0.282910 14.4083333 0.282615 14.4111111 0.282320 14.4138889 0.281436 14.4166667 0.280552 14.4194444 0.280847 14.4222222 0.282026 14.4250000 0.281731 14.4277778 0.281142 14.4305556 0.280552 14.4333333 0.279669 14.4361111 0.279963 14.4388889 0.279963 14.4416667 0.281142 14.4444444 0.281436 14.4472222 0.279963 14.4500000 0.280258 14.4527778 0.279374 14.4555556 0.279669 14.4583333 0.280258 14.4611111 0.280258 14.4638889 0.280258 14.4666667 0.280258 14.4694444 0.279669 14.4722222 0.279963 14.4750000 0.280552 14.4777778 0.280552 14.4805556 0.279963 14.4833333 0.278785 14.4861111 0.278490 14.4888889 0.277311 14.4916667 0.277017 14.4944444 0.275543 14.4972222 0.274070 14.5000000 0.271713 14.5027778 0.270239 14.5055556 0.270239 14.5083333 0.273186 14.5111111 0.276133 14.5138889 0.281731 14.5166667 0.286446 14.5194444 0.292044 14.5222222 0.296169 14.5250000 0.299411 14.5277778 0.303831 14.5305556 0.311786 14.5333333 0.318564 14.5361111 0.322689 14.5388889 0.316206 14.5416667 0.298821 14.5444444 0.278195 14.5472222 0.269355 14.5500000 0.270829 14.5527778 0.275543 14.5555556 0.277311 14.5583333 0.279079 14.5611111 0.279374 14.5638889 0.279374 14.5666667 0.278195 14.5694444 0.277901 14.5722222 0.278490 14.5750000 0.279079 14.5777778 0.279079 14.5805556 0.279079 14.5833333 0.278785 14.5861111 0.278490 14.5888889 0.278785 14.5916667 0.279963 14.5944444 0.279669 14.5972222 0.279669 14.6000000 0.279374 14.6027778 0.279079 14.6055556 0.280258 14.6083333 0.279669 14.6111111 0.280258 14.6138889 0.279079 14.6166667 0.279374 14.6194444 0.279374 14.6222222 0.279963 14.6250000 0.280847 14.6277778 0.279963 14.6305556 0.279669 14.6333333 0.279963 14.6361111 0.279374 14.6388889 0.279963 14.6416667 0.280552 14.6444444 0.280552 14.6472222 0.280258 14.6500000 0.280258 14.6527778 0.279963 14.6555556 0.279963 14.6583333 0.280552 14.6611111 0.280552 14.6638889 0.279963 14.6666667 0.279963 14.6694444 0.280258 14.6722222 0.279963 14.6750000 0.280847 14.6777778 0.280847 14.6805556 0.279669 14.6833333 0.279669 14.6861111 0.279669 14.6888889 0.280847 14.6916667 0.281436 14.6944444 0.280552 14.6972222 0.280552 14.7000000 0.279079 14.7027778 0.279079 14.7055556 0.280552 14.7083333 0.280552 14.7111111 0.279963 14.7138889 0.279669 14.7166667 0.278490 14.7194444 0.278195 14.7222222 0.279079 14.7250000 0.279669 14.7277778 0.278785 14.7305556 0.278490 14.7333333 0.277901 14.7361111 0.277311 14.7388889 0.277606 14.7416667 0.277901 14.7444444 0.277311 14.7472222 0.277311 14.7500000 0.275838 14.7527778 0.276133 14.7555556 0.275543 14.7583333 0.275838 14.7611111 0.275249 14.7638889 0.274659 14.7666667 0.273775 14.7694444 0.274365 14.7722222 0.274365 14.7750000 0.274954 14.7777778 0.274070 14.7805556 0.273481 14.7833333 0.272891 14.7861111 0.272891 14.7888889 0.272891 14.7916667 0.273481 14.7944444 0.274070 14.7972222 0.273775 14.8000000 0.274070 14.8027778 0.274954 14.8055556 0.275249 14.8083333 0.277311 14.8111111 0.277606 14.8138889 0.277606 14.8166667 0.278785 14.8194444 0.278785 14.8222222 0.281142 14.8250000 0.281731 14.8277778 0.282026 14.8305556 0.282615 14.8333333 0.282026 14.8361111 0.283499 14.8418889 0.300000 15.0470000 0.300000 15.0500000 0.282615 15.0527778 0.282615 15.0555556 0.283204 15.0583333 0.284088 15.0611111 0.283499 15.0638889 0.283204 15.0666667 0.282615 15.0694444 0.282615 15.0722222 0.283794 15.0750000 0.284088 15.0777778 0.284383 15.0805556 0.283499 15.0833333 0.283204 15.0861111 0.282910 15.0888889 0.284088 15.0916667 0.284088 15.0944444 0.284383 15.0972222 0.284088 15.1000000 0.283204 15.1027778 0.282910 15.1055556 0.283499 15.1083333 0.284088 15.1111111 0.283794 15.1138889 0.284088 15.1166667 0.283499 15.1194444 0.283499 15.1222222 0.284383 15.1250000 0.284678 15.1277778 0.284678 15.1305556 0.284678 15.1333333 0.284972 15.1361111 0.285562 15.1388889 0.286446 15.1416667 0.286151 15.1444444 0.286151 15.1472222 0.286446 15.1500000 0.286151 15.1527778 0.286740 15.1555556 0.287330 15.1583333 0.287919 15.1611111 0.287330 15.1638889 0.287035 15.1666667 0.286446 15.1694444 0.287035 15.1722222 0.286740 15.1750000 0.287035 15.1777778 0.286151 15.1805556 0.285856 15.1833333 0.285267 15.1861111 0.284678 15.1888889 0.284972 15.1916667 0.284972 15.1944444 0.284972 15.1972222 0.284972 15.2000000 0.283499 15.2027778 0.283499 15.2055556 0.284088 15.2083333 0.284678 15.2111111 0.284088 15.2138889 0.283499 15.2166667 0.282910 15.2194444 0.283499 15.2222222 0.284383 15.2250000 0.284383 15.2277778 0.284088 15.2305556 0.284088 15.2333333 0.282320 15.2361111 0.282026 15.2388889 0.282910 15.2416667 0.283794 15.2444444 0.283794 15.2472222 0.283499 15.2500000 0.282910 15.2527778 0.282910 15.2555556 0.282615 15.2583333 0.281731 15.2611111 0.280258 15.2638889 0.278195 15.2666667 0.276722 15.2694444 0.274365 15.2722222 0.274365 15.2750000 0.278785 15.2777778 0.286446 15.2805556 0.295285 15.2833333 0.301768 15.2861111 0.308840 15.2888889 0.317385 15.2916667 0.325341 15.2944444 0.333297 15.2972222 0.340074 15.3000000 0.341842 15.3027778 0.335654 15.3055556 0.320921 15.3083333 0.301179 15.3111111 0.284383 15.3138889 0.276133 15.3166667 0.275543 15.3194444 0.278490 15.3222222 0.280258 15.3250000 0.281142 15.3277778 0.282026 15.3305556 0.282026 15.3333333 0.281436 15.3361111 0.281142 15.3388889 0.281436 15.3416667 0.281731 15.3444444 0.281436 15.3472222 0.281142 15.3500000 0.279963 15.3527778 0.280552 15.3555556 0.281142 15.3583333 0.281731 15.3611111 0.281142 15.3638889 0.280258 15.3666667 0.280258 15.3694444 0.279669 15.3722222 0.279669 15.3750000 0.281436 15.3777778 0.282320 15.3805556 0.280847 15.3833333 0.280258 15.3861111 0.280258 15.3888889 0.280552 15.3916667 0.281142 15.3944444 0.282026 15.3972222 0.281436 15.4000000 0.281142 15.4027778 0.280258 15.4055556 0.281436 15.4083333 0.281731 15.4111111 0.282026 15.4138889 0.281142 15.4166667 0.280552 15.4194444 0.280552 15.4222222 0.280847 15.4250000 0.281142 15.4277778 0.280847 15.4305556 0.281436 15.4333333 0.280258 15.4361111 0.280847 15.4388889 0.281142 15.4416667 0.281436 15.4444444 0.280847 15.4472222 0.280847 15.4500000 0.279963 15.4527778 0.279669 15.4555556 0.280847 15.4583333 0.280847 15.4611111 0.280847 15.4638889 0.280258 15.4666667 0.280258 15.4694444 0.279374 15.4722222 0.279374 15.4750000 0.280258 15.4777778 0.280258 15.4805556 0.279669 15.4833333 0.279079 15.4861111 0.278490 15.4888889 0.278785 15.4916667 0.279079 15.4944444 0.278490 15.4972222 0.278195 15.5000000 0.277901 15.5027778 0.278195 15.5055556 0.277901 15.5083333 0.278490 15.5111111 0.279079 15.5138889 0.278785 15.5166667 0.277606 15.5194444 0.276427 15.5222222 0.276427 15.5250000 0.277311 15.5277778 0.276722 15.5305556 0.276133 15.5333333 0.275249 15.5361111 0.274659 15.5388889 0.274954 15.5416667 0.274659 15.5444444 0.274365 15.5472222 0.274070 15.5500000 0.272891 15.5527778 0.273186 15.5555556 0.273775 15.5583333 0.274659 15.5611111 0.273775 15.5638889 0.274070 15.5666667 0.272891 15.5694444 0.272891 15.5722222 0.273481 15.5750000 0.274365 15.5777778 0.275249 15.5805556 0.275838 15.5833333 0.275838 15.5861111 0.276722 15.5888889 0.277606 15.5916667 0.278785 15.5944444 0.280258 15.5972222 0.280258 15.6030000 0.300000 15.8275556 0.300000 15.8305556 0.283794 15.8333333 0.283499 15.8361111 0.283204 15.8388889 0.283499 15.8416667 0.284088 15.8444444 0.283794 15.8472222 0.283794 15.8500000 0.283794 15.8527778 0.282910 15.8555556 0.284678 15.8583333 0.284678 15.8611111 0.283794 15.8638889 0.283499 15.8666667 0.283499 15.8694444 0.283204 15.8722222 0.284088 15.8750000 0.284088 15.8777778 0.284383 15.8805556 0.284383 15.8833333 0.283499 15.8861111 0.283794 15.8888889 0.284678 15.8916667 0.285267 15.8944444 0.286446 15.8972222 0.285856 15.9000000 0.285856 15.9027778 0.285562 15.9055556 0.286151 15.9083333 0.286740 15.9111111 0.287330 15.9138889 0.286446 15.9166667 0.287035 15.9194444 0.287035 15.9222222 0.287330 15.9250000 0.287330 15.9277778 0.287330 15.9305556 0.287624 15.9333333 0.286446 15.9361111 0.286740 15.9388889 0.287330 15.9416667 0.288214 15.9444444 0.286740 15.9472222 0.286151 15.9500000 0.285267 15.9527778 0.285267 15.9555556 0.284972 15.9583333 0.286151 15.9611111 0.285856 15.9638889 0.285562 15.9666667 0.284678 15.9694444 0.284088 15.9722222 0.284678 15.9750000 0.284972 15.9777778 0.285267 15.9805556 0.284678 15.9833333 0.284383 15.9861111 0.284088 15.9888889 0.284678 15.9916667 0.284383 15.9944444 0.284678 15.9972222 0.284383 16.0000000 0.283499 16.0027778 0.283499 16.0055556 0.283499 16.0083333 0.284972 16.0111111 0.284383 16.0138889 0.283794 16.0166667 0.283204 16.0194444 0.283204 16.0222222 0.283204 16.0250000 0.284088 16.0277778 0.284972 16.0305556 0.284088 16.0333333 0.282910 16.0361111 0.281731 16.0388889 0.280552 16.0416667 0.279374 16.0444444 0.278785 16.0472222 0.277311 16.0500000 0.275249 16.0527778 0.274070 16.0555556 0.276427 16.0583333 0.282910 16.0611111 0.289392 16.0638889 0.296169 16.0666667 0.301179 16.0694444 0.307661 16.0722222 0.315028 16.0750000 0.322099 16.0777778 0.328287 16.0805556 0.329171 16.0833333 0.319742 16.0861111 0.300000 16.0888889 0.282615 16.0916667 0.278490 16.0944444 0.280258 16.0972222 0.282615 16.1000000 0.281731 16.1027778 0.282026 16.1055556 0.282615 16.1083333 0.283204 16.1111111 0.282320 16.1138889 0.282320 16.1166667 0.281436 16.1194444 0.281436 16.1222222 0.282320 16.1250000 0.282320 16.1277778 0.282320 16.1305556 0.282026 16.1333333 0.281731 16.1361111 0.280847 16.1388889 0.282026 16.1416667 0.282320 16.1444444 0.282615 16.1472222 0.282320 16.1500000 0.281436 16.1527778 0.282026 16.1555556 0.282026 16.1583333 0.282615 16.1611111 0.282615 16.1638889 0.282615 16.1666667 0.282026 16.1694444 0.281731 16.1722222 0.282320 16.1750000 0.282910 16.1777778 0.282615 16.1805556 0.282910 16.1833333 0.282026 16.1861111 0.282615 16.1888889 0.282615 16.1916667 0.283204 16.1944444 0.283204 16.1972222 0.282320 16.2000000 0.282026 16.2027778 0.282026 16.2055556 0.282320 16.2083333 0.283204 16.2111111 0.283499 16.2138889 0.282615 16.2166667 0.282026 16.2194444 0.281731 16.2222222 0.282615 16.2250000 0.282320 16.2277778 0.282910 16.2305556 0.282320 16.2333333 0.281142 16.2361111 0.280552 16.2388889 0.281142 16.2416667 0.281731 16.2444444 0.281142 16.2472222 0.281142 16.2500000 0.280258 16.2527778 0.280258 16.2555556 0.280552 16.2583333 0.280847 16.2611111 0.280552 16.2638889 0.279079 16.2666667 0.279374 16.2694444 0.278490 16.2722222 0.279374 16.2750000 0.279374 16.2777778 0.278785 16.2805556 0.278195 16.2833333 0.276722 16.2861111 0.277017 16.2888889 0.277311 16.2916667 0.277311 16.2944444 0.277901 16.2972222 0.277606 16.3000000 0.276722 16.3027778 0.276133 16.3055556 0.276427 16.3083333 0.276133 16.3111111 0.276427 16.3138889 0.274954 16.3166667 0.274365 16.3194444 0.274365 16.3222222 0.274365 16.3250000 0.274659 16.3277778 0.274659 16.3305556 0.274365 16.3333333 0.274070 16.3361111 0.274070 16.3388889 0.274365 16.3416667 0.275249 16.3444444 0.275838 16.3472222 0.275543 16.3500000 0.274954 16.3527778 0.275249 16.3555556 0.276427 16.3583333 0.277901 16.3611111 0.278490 16.3638889 0.279079 16.3666667 0.278785 16.3694444 0.279669 16.3722222 0.280847 16.3750000 0.281142 16.3777778 0.281436 16.3835556 0.300000 16.5805556 0.300000)

* === THRESHOLD VOLTAGES (set by resistor ladder in ASIC) ===
Vth_rpeak rpeak_threshold 0 0.3415
Vth14  vth_14_fast 0 0.173840
Vth69  vth_69      0 0.448700
Vth28  vth_28      0 0.470236
Vth300 vth_300     0 0.329456
Vth10  vth_10      0 0.263000
* Adaptive pwave thresholds (from EWMA-predicted RR)
Vth_pwb vth_pw_base 0 PWL(0.0000000 0.300000 0.8371111 0.175826 1.6593333 0.175192 2.4426667 0.176503 3.1871111 0.179595 4.0176667 0.178160 4.7982222 0.179328 5.6287778 0.177920 6.4926667 0.175057 7.3148889 0.174499 8.1176667 0.174938 8.8954444 0.176544 9.6815556 0.177586 10.4815556 0.177852 11.2787778 0.178231 12.0926667 0.177754 12.9398889 0.175715 13.7648889 0.174957 14.5398889 0.176696 15.3010000 0.178951 16.0815556 0.180040 16.5805556 0.180040)
Vth_pwp vth_pw_peak 0 PWL(0.0000000 0.300000 0.8371111 0.141927 1.6593333 0.141292 2.4426667 0.142604 3.1871111 0.145668 4.0176667 0.144255 4.7982222 0.145405 5.6287778 0.144019 6.4926667 0.141157 7.3148889 0.140599 8.1176667 0.141039 8.8954444 0.142645 9.6815556 0.143687 10.4815556 0.143952 11.2787778 0.144325 12.0926667 0.143854 12.9398889 0.141816 13.7648889 0.141057 14.5398889 0.142796 15.3010000 0.145034 16.0815556 0.146106 16.5805556 0.146106)
Vth_rrc vth_rr_cap  0 PWL(0.0000000 0.300000 0.8371111 0.103310 1.6593333 0.102690 2.4426667 0.103971 3.1871111 0.106965 4.0176667 0.105585 4.7982222 0.106709 5.6287778 0.105354 6.4926667 0.102558 7.3148889 0.102012 8.1176667 0.102442 8.8954444 0.104011 9.6815556 0.105030 10.4815556 0.105289 11.2787778 0.105654 12.0926667 0.105193 12.9398889 0.103201 13.7648889 0.102460 14.5398889 0.104159 15.3010000 0.106346 16.0815556 0.107394 16.5805556 0.107394)

* === SUBCIRCUIT INCLUDES ===
.include "C:/Users/kadhi/OneDrive/Desktop/amux/verilogLearning/Leaky-Integrate-Fire---SNN-model-on-FPGA/experiments/frontend_optimization/complete_frontend/inverter.spice"
.include "C:/Users/kadhi/OneDrive/Desktop/amux/verilogLearning/Leaky-Integrate-Fire---SNN-model-on-FPGA/experiments/frontend_optimization/complete_frontend/bias_gen.spice"
.include "C:/Users/kadhi/OneDrive/Desktop/amux/verilogLearning/Leaky-Integrate-Fire---SNN-model-on-FPGA/experiments/frontend_optimization/complete_frontend/rpeak_detector.spice"
.include "C:/Users/kadhi/OneDrive/Desktop/amux/verilogLearning/Leaky-Integrate-Fire---SNN-model-on-FPGA/experiments/frontend_optimization/complete_frontend/delay_timer.spice"
.include "C:/Users/kadhi/OneDrive/Desktop/amux/verilogLearning/Leaky-Integrate-Fire---SNN-model-on-FPGA/experiments/frontend_optimization/complete_frontend/pulse_gen.spice"
.include "C:/Users/kadhi/OneDrive/Desktop/amux/verilogLearning/Leaky-Integrate-Fire---SNN-model-on-FPGA/experiments/frontend_optimization/complete_frontend/long_pulse_gen.spice"
.include "C:/Users/kadhi/OneDrive/Desktop/amux/verilogLearning/Leaky-Integrate-Fire---SNN-model-on-FPGA/experiments/frontend_optimization/complete_frontend/edge_buffer.spice"
.include "C:/Users/kadhi/OneDrive/Desktop/amux/verilogLearning/Leaky-Integrate-Fire---SNN-model-on-FPGA/experiments/frontend_optimization/complete_frontend/rr_timing.spice"
.include "C:/Users/kadhi/OneDrive/Desktop/amux/verilogLearning/Leaky-Integrate-Fire---SNN-model-on-FPGA/experiments/frontend_optimization/complete_frontend/beat_instability.spice"
.include "C:/Users/kadhi/OneDrive/Desktop/amux/verilogLearning/Leaky-Integrate-Fire---SNN-model-on-FPGA/experiments/frontend_optimization/complete_frontend/pwave_diff.spice"
.include "C:/Users/kadhi/OneDrive/Desktop/amux/verilogLearning/Leaky-Integrate-Fire---SNN-model-on-FPGA/experiments/frontend_optimization/complete_frontend/qrs_width.spice"
.include "C:/Users/kadhi/OneDrive/Desktop/amux/verilogLearning/Leaky-Integrate-Fire---SNN-model-on-FPGA/experiments/frontend_optimization/complete_frontend/qrs_slope.spice"
.include "C:/Users/kadhi/OneDrive/Desktop/amux/verilogLearning/Leaky-Integrate-Fire---SNN-model-on-FPGA/experiments/frontend_optimization/complete_frontend/qrs_symmetry.spice"

* ============================================================
* FULLY ANALOG FRONTEND — NO IDEAL TRIGGER SOURCES
* ============================================================

* 1. BIAS GENERATOR
Xbias vbias vref vdd vss bias_gen

* 2. R-PEAK DETECTOR (analog comparator)
Xrpeak ecg_l0 rpeak_threshold rpeak_raw vdd vss vbias rpeak_detector

* 3. PULSE GENERATOR: rpeak level -> short pulse (~0.7ms)
Xpg_rpk rpeak_raw rpeak_pulse vdd vss vbias pulse_gen

* 4. DELAY TIMER (driven by rpeak_pulse)
Xdt rpeak_pulse dt_s14_lev dt_s69_lev dt_wid_lev dt_bi_lev dt_rr_lev dt_sf_out vdd vss vbias vth_14_fast vth_69 vth_28 vth_300 vth_10 delay_timer

* 5. EDGE BUFFERS + PULSE GENERATORS for delay timer outputs
* Fast timer outputs: direct to pulse_gen (fast edges, no buffer needed)
Xpg_s14 dt_s14_lev trig_s14 vdd vss vbias pulse_gen
* rr_copy needs long_pulse_gen (2ms) for EWMA charge sharing in rr_timing
Xpg_rr  dt_rr_lev  trig_rr_copy vdd vss vbias long_pulse_gen

* Main timer outputs: edge_buffer -> pulse_gen (slow edges need sharpening)
Xeb_wid dt_wid_lev wid_sharp vdd vss edge_buffer
Xpg_wid wid_sharp  trig_wid  vdd vss vbias pulse_gen

Xeb_s69 dt_s69_lev s69_sharp vdd vss edge_buffer
Xpg_s69 s69_sharp  trig_s69  vdd vss vbias pulse_gen

* bi_copy: long_pulse_gen (2ms) for EWMA charge sharing in beat_instability
Xeb_bi  dt_bi_lev  bi_sharp  vdd vss edge_buffer
Xpg_bi  bi_sharp   trig_bi_copy vdd vss vbias long_pulse_gen

* 6. PWAVE PREDICTION COMPARATORS (on delay timer SF)
* pw_base comparator: fires at R + (ewma_rr - 201)ms
XMcpwb1 cnpwb vth_pw_base ctpwb vss sky130_fd_pr__nfet_01v8 L=4 W=2 nf=1
XMcpwb2 pw_base_lev dt_sf_out ctpwb vss sky130_fd_pr__nfet_01v8 L=4 W=2 nf=1
XMcpwb3 cnpwb cnpwb vdd vdd sky130_fd_pr__pfet_01v8 L=4 W=2 nf=1
XMcpwb4 pw_base_lev cnpwb vdd vdd sky130_fd_pr__pfet_01v8 L=4 W=2 nf=1
XMcpwb5 ctpwb vbias vss vss sky130_fd_pr__nfet_01v8 L=8 W=0.42 nf=1

* pw_peak comparator: fires at R + (ewma_rr - 131)ms
XMcpwp1 cnpwp vth_pw_peak ctpwp vss sky130_fd_pr__nfet_01v8 L=4 W=2 nf=1
XMcpwp2 pw_peak_lev dt_sf_out ctpwp vss sky130_fd_pr__nfet_01v8 L=4 W=2 nf=1
XMcpwp3 cnpwp cnpwp vdd vdd sky130_fd_pr__pfet_01v8 L=4 W=2 nf=1
XMcpwp4 pw_peak_lev cnpwp vdd vdd sky130_fd_pr__pfet_01v8 L=4 W=2 nf=1
XMcpwp5 ctpwp vbias vss vss sky130_fd_pr__nfet_01v8 L=8 W=0.42 nf=1

* rr_cap comparator: fires at R + (ewma_rr - 50)ms for rr_timing capture
XMcrrc1 cnrrc vth_rr_cap ctrrc vss sky130_fd_pr__nfet_01v8 L=4 W=2 nf=1
XMcrrc2 rr_cap_lev dt_sf_out ctrrc vss sky130_fd_pr__nfet_01v8 L=4 W=2 nf=1
XMcrrc3 cnrrc cnrrc vdd vdd sky130_fd_pr__pfet_01v8 L=4 W=2 nf=1
XMcrrc4 rr_cap_lev cnrrc vdd vdd sky130_fd_pr__pfet_01v8 L=4 W=2 nf=1
XMcrrc5 ctrrc vbias vss vss sky130_fd_pr__nfet_01v8 L=8 W=0.42 nf=1

* 6b. EDGE BUFFERS + PULSE GENERATORS for pwave prediction
Xeb_pwb pw_base_lev pwb_sharp vdd vss edge_buffer
Xpg_pwb pwb_sharp   trig_pw_base vdd vss vbias pulse_gen

Xeb_pwp pw_peak_lev pwp_sharp vdd vss edge_buffer
Xpg_pwp pwp_sharp   trig_pw_peak vdd vss vbias pulse_gen

Xeb_rrc rr_cap_lev  rrc_sharp vdd vss edge_buffer
Xpg_rrc rrc_sharp   trig_rr_cap vdd vss vbias pulse_gen

* ============================================================
* 7. FEATURE CIRCUITS — ALL driven by ANALOG triggers
* ============================================================

* F1 & F2: RR Timing
*   capture: trig_rr_cap (from pwave rr_cap comparator)
*   rpeak:   rpeak_raw (HIGH during QRS ~9ms, sufficient for 320pF precharge)
*   copy:    trig_rr_copy (long_pulse_gen, 2ms for EWMA charge sharing)
Xrr ecg_l0 trig_rr_cap rpeak_raw trig_rr_copy f1_rr_ratio f2_rr_asym rr_timer rr_ewma vdd vss vbias rr_timing

* F3: Beat Instability L0 (rpeak_pulse for S&H, trig_bi_copy for EWMA)
Xbi0 ecg_l0 rpeak_pulse trig_bi_copy f3_bi_l0 vdd vss vbias beat_instability
* F4: Beat Instability L1
Xbi1 ecg_l1 rpeak_pulse trig_bi_copy f4_bi_l1 vdd vss vbias beat_instability

* F5: P-wave Difference L0 (analog pwave triggers)
Xpw ecg_l0 trig_pw_base trig_pw_peak f5_pwave vdd vss vbias pwave_diff

* F6: QRS Width L0 (analog wid trigger)
Xwid ecg_l0 trig_wid f6_width vdd vss qrs_width

* F7: QRS Slope L0 (both s14 and s69 from analog delay timer)
Xslp ecg_l0 trig_s14 trig_s69 f7_slope vdd vss vbias qrs_slope

* F8: QRS Symmetry L0 (rpeak_pulse for S&H capture)
Xsym ecg_l0 rpeak_pulse f8_symmetry vdd vss qrs_symmetry

* === INITIAL CONDITIONS ===
.ic V(xbias.iref)=0.3
.ic V(xrr.ewma_node)=0.375814
.ic V(xrr.esamp_node)=0.375365
.ic V(xrr.prev_node)=0.377532
.ic V(xbi0.prev_node)=0.345676
.ic V(xbi0.esamp_node)=0.347277
.ic V(xbi1.prev_node)=0.312909
.ic V(xbi1.esamp_node)=0.303229

.tran 0.5m 16.5806

.meas tran f1_2 FIND V(f1_rr_ratio) AT=2.4316667
.meas tran f2_2 FIND V(f2_rr_asym) AT=3.1211111
.meas tran f3_2 FIND V(f3_bi_l0) AT=2.5416667
.meas tran f4_2 FIND V(f4_bi_l1) AT=2.5416667
.meas tran f5_2 FIND V(f5_pwave) AT=2.5416667
.meas tran f6_2 FIND V(f6_width) AT=2.5416667
.meas tran f7_2 FIND V(f7_slope) AT=2.5416667
.meas tran f8_2 FIND V(f8_symmetry) AT=2.5416667
.meas tran f1_3 FIND V(f1_rr_ratio) AT=3.1761111
.meas tran f2_3 FIND V(f2_rr_asym) AT=3.9516667
.meas tran f3_3 FIND V(f3_bi_l0) AT=3.2861111
.meas tran f4_3 FIND V(f4_bi_l1) AT=3.2861111
.meas tran f5_3 FIND V(f5_pwave) AT=3.2861111
.meas tran f6_3 FIND V(f6_width) AT=3.2861111
.meas tran f7_3 FIND V(f7_slope) AT=3.2861111
.meas tran f8_3 FIND V(f8_symmetry) AT=3.2861111
.meas tran f1_4 FIND V(f1_rr_ratio) AT=4.0066667
.meas tran f2_4 FIND V(f2_rr_asym) AT=4.7322222
.meas tran f3_4 FIND V(f3_bi_l0) AT=4.1166667
.meas tran f4_4 FIND V(f4_bi_l1) AT=4.1166667
.meas tran f5_4 FIND V(f5_pwave) AT=4.1166667
.meas tran f6_4 FIND V(f6_width) AT=4.1166667
.meas tran f7_4 FIND V(f7_slope) AT=4.1166667
.meas tran f8_4 FIND V(f8_symmetry) AT=4.1166667
.meas tran f1_5 FIND V(f1_rr_ratio) AT=4.7872222
.meas tran f2_5 FIND V(f2_rr_asym) AT=5.5627778
.meas tran f3_5 FIND V(f3_bi_l0) AT=4.8972222
.meas tran f4_5 FIND V(f4_bi_l1) AT=4.8972222
.meas tran f5_5 FIND V(f5_pwave) AT=4.8972222
.meas tran f6_5 FIND V(f6_width) AT=4.8972222
.meas tran f7_5 FIND V(f7_slope) AT=4.8972222
.meas tran f8_5 FIND V(f8_symmetry) AT=4.8972222
.meas tran f1_6 FIND V(f1_rr_ratio) AT=5.6177778
.meas tran f2_6 FIND V(f2_rr_asym) AT=6.4266667
.meas tran f3_6 FIND V(f3_bi_l0) AT=5.7277778
.meas tran f4_6 FIND V(f4_bi_l1) AT=5.7277778
.meas tran f5_6 FIND V(f5_pwave) AT=5.7277778
.meas tran f6_6 FIND V(f6_width) AT=5.7277778
.meas tran f7_6 FIND V(f7_slope) AT=5.7277778
.meas tran f8_6 FIND V(f8_symmetry) AT=5.7277778
.meas tran f1_7 FIND V(f1_rr_ratio) AT=6.4816667
.meas tran f2_7 FIND V(f2_rr_asym) AT=7.2488889
.meas tran f3_7 FIND V(f3_bi_l0) AT=6.5916667
.meas tran f4_7 FIND V(f4_bi_l1) AT=6.5916667
.meas tran f5_7 FIND V(f5_pwave) AT=6.5916667
.meas tran f6_7 FIND V(f6_width) AT=6.5916667
.meas tran f7_7 FIND V(f7_slope) AT=6.5916667
.meas tran f8_7 FIND V(f8_symmetry) AT=6.5916667
.meas tran f1_8 FIND V(f1_rr_ratio) AT=7.3038889
.meas tran f2_8 FIND V(f2_rr_asym) AT=8.0516667
.meas tran f3_8 FIND V(f3_bi_l0) AT=7.4138889
.meas tran f4_8 FIND V(f4_bi_l1) AT=7.4138889
.meas tran f5_8 FIND V(f5_pwave) AT=7.4138889
.meas tran f6_8 FIND V(f6_width) AT=7.4138889
.meas tran f7_8 FIND V(f7_slope) AT=7.4138889
.meas tran f8_8 FIND V(f8_symmetry) AT=7.4138889
.meas tran f1_9 FIND V(f1_rr_ratio) AT=8.1066667
.meas tran f2_9 FIND V(f2_rr_asym) AT=8.8294444
.meas tran f3_9 FIND V(f3_bi_l0) AT=8.2166667
.meas tran f4_9 FIND V(f4_bi_l1) AT=8.2166667
.meas tran f5_9 FIND V(f5_pwave) AT=8.2166667
.meas tran f6_9 FIND V(f6_width) AT=8.2166667
.meas tran f7_9 FIND V(f7_slope) AT=8.2166667
.meas tran f8_9 FIND V(f8_symmetry) AT=8.2166667
.meas tran f1_10 FIND V(f1_rr_ratio) AT=8.8844444
.meas tran f2_10 FIND V(f2_rr_asym) AT=9.6155556
.meas tran f3_10 FIND V(f3_bi_l0) AT=8.9944444
.meas tran f4_10 FIND V(f4_bi_l1) AT=8.9944444
.meas tran f5_10 FIND V(f5_pwave) AT=8.9944444
.meas tran f6_10 FIND V(f6_width) AT=8.9944444
.meas tran f7_10 FIND V(f7_slope) AT=8.9944444
.meas tran f8_10 FIND V(f8_symmetry) AT=8.9944444
.meas tran f1_11 FIND V(f1_rr_ratio) AT=9.6705556
.meas tran f2_11 FIND V(f2_rr_asym) AT=10.4155556
.meas tran f3_11 FIND V(f3_bi_l0) AT=9.7805556
.meas tran f4_11 FIND V(f4_bi_l1) AT=9.7805556
.meas tran f5_11 FIND V(f5_pwave) AT=9.7805556
.meas tran f6_11 FIND V(f6_width) AT=9.7805556
.meas tran f7_11 FIND V(f7_slope) AT=9.7805556
.meas tran f8_11 FIND V(f8_symmetry) AT=9.7805556
.meas tran f1_12 FIND V(f1_rr_ratio) AT=10.4705556
.meas tran f2_12 FIND V(f2_rr_asym) AT=11.2127778
.meas tran f3_12 FIND V(f3_bi_l0) AT=10.5805556
.meas tran f4_12 FIND V(f4_bi_l1) AT=10.5805556
.meas tran f5_12 FIND V(f5_pwave) AT=10.5805556
.meas tran f6_12 FIND V(f6_width) AT=10.5805556
.meas tran f7_12 FIND V(f7_slope) AT=10.5805556
.meas tran f8_12 FIND V(f8_symmetry) AT=10.5805556
.meas tran f1_13 FIND V(f1_rr_ratio) AT=11.2677778
.meas tran f2_13 FIND V(f2_rr_asym) AT=12.0266667
.meas tran f3_13 FIND V(f3_bi_l0) AT=11.3777778
.meas tran f4_13 FIND V(f4_bi_l1) AT=11.3777778
.meas tran f5_13 FIND V(f5_pwave) AT=11.3777778
.meas tran f6_13 FIND V(f6_width) AT=11.3777778
.meas tran f7_13 FIND V(f7_slope) AT=11.3777778
.meas tran f8_13 FIND V(f8_symmetry) AT=11.3777778
.meas tran f1_14 FIND V(f1_rr_ratio) AT=12.0816667
.meas tran f2_14 FIND V(f2_rr_asym) AT=12.8738889
.meas tran f3_14 FIND V(f3_bi_l0) AT=12.1916667
.meas tran f4_14 FIND V(f4_bi_l1) AT=12.1916667
.meas tran f5_14 FIND V(f5_pwave) AT=12.1916667
.meas tran f6_14 FIND V(f6_width) AT=12.1916667
.meas tran f7_14 FIND V(f7_slope) AT=12.1916667
.meas tran f8_14 FIND V(f8_symmetry) AT=12.1916667
.meas tran f1_15 FIND V(f1_rr_ratio) AT=12.9288889
.meas tran f2_15 FIND V(f2_rr_asym) AT=13.6988889
.meas tran f3_15 FIND V(f3_bi_l0) AT=13.0388889
.meas tran f4_15 FIND V(f4_bi_l1) AT=13.0388889
.meas tran f5_15 FIND V(f5_pwave) AT=13.0388889
.meas tran f6_15 FIND V(f6_width) AT=13.0388889
.meas tran f7_15 FIND V(f7_slope) AT=13.0388889
.meas tran f8_15 FIND V(f8_symmetry) AT=13.0388889
.meas tran f1_16 FIND V(f1_rr_ratio) AT=13.7538889
.meas tran f2_16 FIND V(f2_rr_asym) AT=14.4738889
.meas tran f3_16 FIND V(f3_bi_l0) AT=13.8638889
.meas tran f4_16 FIND V(f4_bi_l1) AT=13.8638889
.meas tran f5_16 FIND V(f5_pwave) AT=13.8638889
.meas tran f6_16 FIND V(f6_width) AT=13.8638889
.meas tran f7_16 FIND V(f7_slope) AT=13.8638889
.meas tran f8_16 FIND V(f8_symmetry) AT=13.8638889
.meas tran f1_17 FIND V(f1_rr_ratio) AT=14.5288889
.meas tran f2_17 FIND V(f2_rr_asym) AT=15.2350000
.meas tran f3_17 FIND V(f3_bi_l0) AT=14.6388889
.meas tran f4_17 FIND V(f4_bi_l1) AT=14.6388889
.meas tran f5_17 FIND V(f5_pwave) AT=14.6388889
.meas tran f6_17 FIND V(f6_width) AT=14.6388889
.meas tran f7_17 FIND V(f7_slope) AT=14.6388889
.meas tran f8_17 FIND V(f8_symmetry) AT=14.6388889
.meas tran f1_18 FIND V(f1_rr_ratio) AT=15.2900000
.meas tran f2_18 FIND V(f2_rr_asym) AT=16.0155556
.meas tran f3_18 FIND V(f3_bi_l0) AT=15.4000000
.meas tran f4_18 FIND V(f4_bi_l1) AT=15.4000000
.meas tran f5_18 FIND V(f5_pwave) AT=15.4000000
.meas tran f6_18 FIND V(f6_width) AT=15.4000000
.meas tran f7_18 FIND V(f7_slope) AT=15.4000000
.meas tran f8_18 FIND V(f8_symmetry) AT=15.4000000
.meas tran f1_19 FIND V(f1_rr_ratio) AT=16.0705556
.meas tran f3_19 FIND V(f3_bi_l0) AT=16.1805556
.meas tran f4_19 FIND V(f4_bi_l1) AT=16.1805556
.meas tran f5_19 FIND V(f5_pwave) AT=16.1805556
.meas tran f6_19 FIND V(f6_width) AT=16.1805556
.meas tran f7_19 FIND V(f7_slope) AT=16.1805556
.meas tran f8_19 FIND V(f8_symmetry) AT=16.1805556

.meas tran ic_rr_ewma FIND V(xrr.ewma_node) AT=16.1805556
.meas tran ic_rr_esamp FIND V(xrr.esamp_node) AT=16.1805556
.meas tran ic_rr_prev FIND V(xrr.prev_node) AT=16.1805556
.meas tran ic_bi0_prev FIND V(xbi0.prev_node) AT=16.1805556
.meas tran ic_bi0_esamp FIND V(xbi0.esamp_node) AT=16.1805556
.meas tran ic_bi1_prev FIND V(xbi1.prev_node) AT=16.1805556
.meas tran ic_bi1_esamp FIND V(xbi1.esamp_node) AT=16.1805556

.end
