* ============================================================
* TRUE PEAK DETECTOR v3d — 40pF hold cap, 4mV detect threshold
* ============================================================
*
* v3c (20pF, 8.1mV detect): 3.4ms p2p jitter. 8.1mV threshold
*   requires large ECG drop, variable by beat shape.
* v3d: 40pF cap → 16.5mV/ms charge, ~1.7mV overshoot/burst.
*   Hold tracks ~1mV below ECG in steady state.
*   4mV detect threshold: fires when ECG drops ~5mV below peak.
*   Expected jitter: ~1.5ms p2p (from downslope variation only).
*
* Pin: ecg_in arm_signal peak_detected vdd vss vbias
* ============================================================

.subckt true_peak_detector ecg_in arm_signal peak_detected vdd vss vbias

* === PEAK HOLD CAP (40pF, 142x142 MIM) ===
XChold peak_hold vss sky130_fd_pr__cap_mim_m3_1 W=142 L=142

* === TRACKING COMPARATOR (tail ~660pA, L=2 W=4) ===
* Fires when ecg_in > peak_hold + ~2.6mV
XMt1 tn1 peak_hold tt1 vss sky130_fd_pr__nfet_01v8 L=2 W=4.3 nf=1
XMt2 stg1_track ecg_in tt1 vss sky130_fd_pr__nfet_01v8 L=2 W=4 nf=1
XMt3 tn1 tn1 vdd vdd sky130_fd_pr__pfet_01v8 L=2 W=4 nf=1
XMt4 stg1_track tn1 vdd vdd sky130_fd_pr__pfet_01v8 L=2 W=4 nf=1
XMt5 tt1 vbias vss vss sky130_fd_pr__nfet_01v8 L=2 W=4 nf=1
XMt6 track_level stg1_track vdd vdd sky130_fd_pr__pfet_01v8 L=0.5 W=4 nf=1
XMt7 track_level stg1_track vss vss sky130_fd_pr__nfet_01v8 L=0.5 W=2 nf=1

* === AND GATE: track_level AND arm_signal -> charge_en ===
XMg_p1 nand_trk track_level vdd vdd sky130_fd_pr__pfet_01v8 L=0.15 W=2 nf=1
XMg_p2 nand_trk arm_signal vdd vdd sky130_fd_pr__pfet_01v8 L=0.15 W=2 nf=1
XMg_n1 nand_trk track_level nand_mid1 vss sky130_fd_pr__nfet_01v8 L=0.15 W=1 nf=1
XMg_n2 nand_mid1 arm_signal vss vss sky130_fd_pr__nfet_01v8 L=0.15 W=1 nf=1
XMg_i1 charge_en nand_trk vdd vdd sky130_fd_pr__pfet_01v8 L=0.15 W=2 nf=1
XMg_i2 charge_en nand_trk vss vss sky130_fd_pr__nfet_01v8 L=0.15 W=1 nf=1

* === CHARGE PUMP (~660pA, L=2 W=4) ===
* 660pA / 40pF = 16.5mV/ms
XMcp_bias cp_ref vbias vss vss sky130_fd_pr__nfet_01v8 L=2 W=4 nf=1
XMcp_mir cp_ref cp_ref vdd vdd sky130_fd_pr__pfet_01v8 L=2 W=4 nf=1
XMcp_out cp_int cp_ref vdd vdd sky130_fd_pr__pfet_01v8 L=2 W=4 nf=1
Xinv_ce charge_en charge_en_bar vdd vss inverter_sub
XMcp_sw peak_hold charge_en_bar cp_int vdd sky130_fd_pr__pfet_01v8 L=0.5 W=4 nf=1

* === GATED DISCHARGE TO VBASE ===
Xinv_arm arm_signal arm_bar vdd vss inverter_sub
XMdis peak_hold arm_bar vbias vss sky130_fd_pr__nfet_01v8 L=4 W=2 nf=1

* === PEAK-DETECT COMPARATOR (tail ~660pA, 4mV threshold) ===
* Fires when peak_hold > ecg_in + ~4.0mV
* offset = 1.4*26mV * ln(4.44/4) = 36.4 * 0.104 = 3.8mV
XMd1 dn1 ecg_in dt1 vss sky130_fd_pr__nfet_01v8 L=2 W=4.44 nf=1
XMd2 stg1_det peak_hold dt1 vss sky130_fd_pr__nfet_01v8 L=2 W=4 nf=1
XMd3 dn1 dn1 vdd vdd sky130_fd_pr__pfet_01v8 L=2 W=4 nf=1
XMd4 stg1_det dn1 vdd vdd sky130_fd_pr__pfet_01v8 L=2 W=4 nf=1
XMd5 dt1 vbias vss vss sky130_fd_pr__nfet_01v8 L=2 W=4 nf=1
XMd6 detect_raw stg1_det vdd vdd sky130_fd_pr__pfet_01v8 L=0.5 W=4 nf=1
XMd7 detect_raw stg1_det vss vss sky130_fd_pr__nfet_01v8 L=0.5 W=2 nf=1

* === AND GATE: detect_raw AND arm_signal -> peak_detected ===
XMa_p1 nand_det detect_raw vdd vdd sky130_fd_pr__pfet_01v8 L=0.15 W=2 nf=1
XMa_p2 nand_det arm_signal vdd vdd sky130_fd_pr__pfet_01v8 L=0.15 W=2 nf=1
XMa_n1 nand_det detect_raw nand_mid2 vss sky130_fd_pr__nfet_01v8 L=0.15 W=1 nf=1
XMa_n2 nand_mid2 arm_signal vss vss sky130_fd_pr__nfet_01v8 L=0.15 W=1 nf=1
XMa_i1 peak_detected nand_det vdd vdd sky130_fd_pr__pfet_01v8 L=0.15 W=2 nf=1
XMa_i2 peak_detected nand_det vss vss sky130_fd_pr__nfet_01v8 L=0.15 W=1 nf=1

.ends true_peak_detector
