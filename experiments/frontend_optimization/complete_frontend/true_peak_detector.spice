* ============================================================
* TRUE PEAK DETECTOR v6 — Source follower input level shifting
* ============================================================
*
* v5d FAILURE on real ECG (0/8 beats detected):
*   NFET diff pair comparators collapse when inputs exceed ~0.65V.
*   Real ECG crossover at ~0.74V (baseline 0.59V, peak 0.74V) causes
*   diff pair NFET Vds < Vdsat (tn1-tt1 = 0.55-0.39 = 0.16V at 0.74V
*   CM; drops to 0.09V at 0.80V CM → triode). Tracking comparator
*   locks HIGH, pump runs peak_hold to VDD rail.
*   Diagnostic test passed only because baseline=0.35V put crossover
*   at 0.52V where NFET diff pair has 0.40V Vds headroom.
*
* v6 FIX: NFET source followers before both comparators.
*   Each follower: drain=VDD, gate=input, source=output, with matched
*   vbias-controlled current source (L=2 W=4, same as diff pair tail).
*   Output ≈ input - Vgs ≈ input - 0.38V (subthreshold at ~660pA).
*   At ecg=0.74V: sf_ecg ≈ 0.36V → diff pair Vds ≈ 0.40V (safe).
*   Matched followers preserve differential signal; Vgs offset cancels.
*   Adds 4 transistors (2 followers + 2 bias NFETs).
*
* Pin: ecg_in arm_signal peak_detected vdd vss vbias
* ============================================================

.subckt true_peak_detector ecg_in arm_signal peak_detected vdd vss vbias

* === PEAK HOLD CAP (2pF, 32x32 MIM) ===
XChold peak_hold vss sky130_fd_pr__cap_mim_m3_1 W=32 L=32

* === SOURCE FOLLOWERS for comparator input level shifting ===
* Shift both inputs down by ~Vgs (~0.38V), keeping diff signal intact.
* Prevents NFET diff pair collapse when inputs approach VDD.
* Both followers use L=2 W=4 (matched to each other and diff pair).
XMsf_e vdd ecg_in sf_ecg vss sky130_fd_pr__nfet_01v8 L=2 W=4 nf=1
XMsf_eb sf_ecg vbias vss vss sky130_fd_pr__nfet_01v8 L=2 W=4 nf=1
XMsf_p vdd peak_hold sf_ph vss sky130_fd_pr__nfet_01v8 L=2 W=4 nf=1
XMsf_pb sf_ph vbias vss vss sky130_fd_pr__nfet_01v8 L=2 W=4 nf=1

* === TRACKING COMPARATOR (tail ~660pA, L=2 W=4) ===
* Fires HIGH when sf_ecg > sf_ph + ~2.6mV (offset from W mismatch)
* Inputs level-shifted: sf_ph ≈ peak_hold - 0.38V, sf_ecg ≈ ecg_in - 0.38V
XMt1 tn1 sf_ph tt1 vss sky130_fd_pr__nfet_01v8 L=2 W=4.3 nf=1
XMt2 stg1_track sf_ecg tt1 vss sky130_fd_pr__nfet_01v8 L=2 W=4 nf=1
XMt3 tn1 tn1 vdd vdd sky130_fd_pr__pfet_01v8 L=2 W=4 nf=1
XMt4 stg1_track tn1 vdd vdd sky130_fd_pr__pfet_01v8 L=2 W=4 nf=1
XMt5 tt1 vbias vss vss sky130_fd_pr__nfet_01v8 L=2 W=4 nf=1
XMt6 track_level stg1_track vdd vdd sky130_fd_pr__pfet_01v8 L=0.5 W=4 nf=1
XMt7 track_level stg1_track vss vss sky130_fd_pr__nfet_01v8 L=0.5 W=2 nf=1

* === AND GATE: track_level AND arm_signal -> charge_en ===
XMg_p1 nand_trk track_level vdd vdd sky130_fd_pr__pfet_01v8 L=0.15 W=2 nf=1
XMg_p2 nand_trk arm_signal vdd vdd sky130_fd_pr__pfet_01v8 L=0.15 W=2 nf=1
XMg_n1 nand_trk track_level nand_mid1 vss sky130_fd_pr__nfet_01v8 L=0.15 W=1 nf=1
XMg_n2 nand_mid1 arm_signal vss vss sky130_fd_pr__nfet_01v8 L=0.15 W=1 nf=1
XMg_i1 charge_en nand_trk vdd vdd sky130_fd_pr__pfet_01v8 L=0.15 W=2 nf=1
XMg_i2 charge_en nand_trk vss vss sky130_fd_pr__nfet_01v8 L=0.15 W=1 nf=1

* === CHARGE PUMP: unidirectional ~80pA into peak_hold ===
* v5d: L=20 output PMOS for correct current scaling.
* Target 80pA / 2pF = 40mV/ms << 100mV/ms QRS upslope.
XMcp_nb cp_bias vbias vss vss sky130_fd_pr__nfet_01v8 L=2 W=4 nf=1
XMcp_pd cp_bias cp_bias vdd vdd sky130_fd_pr__pfet_01v8 L=2 W=4 nf=1
XMcp_po cp_node cp_bias vdd vdd sky130_fd_pr__pfet_01v8 L=20 W=0.5 nf=1
* PMOS switch: ON when charge_en HIGH (charge_en_bar LOW)
Xinv_ce charge_en charge_en_bar vdd vss inverter_sub
XMcp_sw cp_node charge_en_bar peak_hold vdd sky130_fd_pr__pfet_01v8 L=0.5 W=2 nf=1

* === ECG PRECHARGE (replaces vbias discharge) ===
* When arm_signal=LOW: peak_hold tracks ecg_in through NFET.
* When arm_signal=HIGH: NFET OFF, cap holds.
Xinv_arm arm_signal arm_bar vdd vss inverter_sub
XMdis peak_hold arm_bar ecg_in vss sky130_fd_pr__nfet_01v8 L=0.5 W=2 nf=1

* === PEAK-DETECT COMPARATOR (tail ~660pA, ~15mV threshold) ===
* Fires HIGH when sf_ph > sf_ecg + ~15mV (i.e. peak_hold > ecg_in + ~15mV)
* Uses same level-shifted inputs as tracking comparator.
XMd1 dn1 sf_ecg dt1 vss sky130_fd_pr__nfet_01v8 L=2 W=6 nf=1
XMd2 stg1_det sf_ph dt1 vss sky130_fd_pr__nfet_01v8 L=2 W=4 nf=1
XMd3 dn1 dn1 vdd vdd sky130_fd_pr__pfet_01v8 L=2 W=4 nf=1
XMd4 stg1_det dn1 vdd vdd sky130_fd_pr__pfet_01v8 L=2 W=4 nf=1
XMd5 dt1 vbias vss vss sky130_fd_pr__nfet_01v8 L=2 W=4 nf=1
XMd6 detect_raw stg1_det vdd vdd sky130_fd_pr__pfet_01v8 L=0.5 W=4 nf=1
XMd7 detect_raw stg1_det vss vss sky130_fd_pr__nfet_01v8 L=0.5 W=2 nf=1

* === TRACK-LEVEL INVERSION (for detect blanking) ===
Xinv_tl track_level track_level_bar vdd vss inverter_sub

* === 3-INPUT AND: detect_raw AND arm_signal AND track_level_bar -> peak_detected ===
XMa_p1 nand_det detect_raw vdd vdd sky130_fd_pr__pfet_01v8 L=0.15 W=2 nf=1
XMa_p2 nand_det arm_signal vdd vdd sky130_fd_pr__pfet_01v8 L=0.15 W=2 nf=1
XMa_p3 nand_det track_level_bar vdd vdd sky130_fd_pr__pfet_01v8 L=0.15 W=2 nf=1
XMa_n1 nand_det detect_raw nand_mid2 vss sky130_fd_pr__nfet_01v8 L=0.15 W=1 nf=1
XMa_n2 nand_mid2 arm_signal nand_mid3 vss sky130_fd_pr__nfet_01v8 L=0.15 W=1 nf=1
XMa_n3 nand_mid3 track_level_bar vss vss sky130_fd_pr__nfet_01v8 L=0.15 W=1 nf=1
XMa_i1 peak_detected nand_det vdd vdd sky130_fd_pr__pfet_01v8 L=0.15 W=2 nf=1
XMa_i2 peak_detected nand_det vss vss sky130_fd_pr__nfet_01v8 L=0.15 W=1 nf=1

.ends true_peak_detector
