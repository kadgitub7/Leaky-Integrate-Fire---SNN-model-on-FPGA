* ============================================================
* R-PEAK DETECTOR — Threshold Comparator
* ============================================================
*
* Detects R-peak by comparing IA output with adaptive threshold.
* When ECG exceeds threshold: output goes HIGH (near VDD).
*
* Topology: Two-stage comparator
*   Stage 1: Diff pair with current mirror loads (high gain)
*   Stage 2: Common-source inverting amplifier (rail-to-rail output)
*
* The threshold voltage should be set to ~60% of expected R-peak.
* For VREF=0.30V and gain=100 IA, R-peak of 1mV gives 0.40V.
* Threshold ≈ 0.36V (60mV above VREF).
*
* Pin: ecg_in threshold rpeak_out vdd vss vbias
* ============================================================

.subckt rpeak_detector ecg_in threshold rpeak_out vdd vss vbias

* Stage 1: diff pair comparator
XM1 net1 threshold tail1 vss sky130_fd_pr__nfet_01v8 L=2 W=4 nf=1
XM2 stg1_out ecg_in tail1 vss sky130_fd_pr__nfet_01v8 L=2 W=4 nf=1
XM3 net1 net1 vdd vdd sky130_fd_pr__pfet_01v8 L=2 W=4 nf=1
XM4 stg1_out net1 vdd vdd sky130_fd_pr__pfet_01v8 L=2 W=4 nf=1
XM5 tail1 vbias vss vss sky130_fd_pr__nfet_01v8 L=8 W=0.42 nf=1

* Stage 2: output inverter (wide for rail-to-rail drive of 5+ loads)
XM6 rpeak_out stg1_out vdd vdd sky130_fd_pr__pfet_01v8 L=0.5 W=8 nf=1
XM7 rpeak_out stg1_out vss vss sky130_fd_pr__nfet_01v8 L=0.5 W=4 nf=1

.ends rpeak_detector
