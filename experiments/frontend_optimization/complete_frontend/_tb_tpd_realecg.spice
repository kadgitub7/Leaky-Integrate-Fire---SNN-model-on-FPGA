* ============================================================
* TESTBENCH: true_peak_detector with REAL ECG (Record 100, 8 beats)
* ============================================================
* Purpose: Characterize detection latency and jitter with real ECG morphology.
* ARM signal mimics rpeak_level_held (HIGH during each QRS window).
* Ground truth: MIT-BIH R-peak annotations.
* ============================================================

.lib "C:/Users/kadhi/OneDrive/Desktop/amux/verilogLearning/Leaky-Integrate-Fire---SNN-model-on-FPGA/experiments/frontend_optimization/ngspice_frontend/sky130_minimal.lib.spice" tt
.option scale=1.0u method=gear reltol=0.003 gmin=1e-15 itl4=200

Vdd vdd 0 0.9
Vss vss 0 0

Xbias vbias vref vdd vss bias_gen
.ic V(xbias.iref)=0.3

* === REAL ECG (Record 100, samples 190-2582) ===
Vecg ecg_in 0 PWL(
+ 0.5277778 0.586747
+ 0.5305556 0.586145
+ 0.5333333 0.589157
+ 0.5361111 0.590964
+ 0.5388889 0.590964
+ 0.5416667 0.592169
+ 0.5444444 0.591566
+ 0.5472222 0.592169
+ 0.5500000 0.592771
+ 0.5527778 0.593976
+ 0.5555556 0.596386
+ 0.5583333 0.596988
+ 0.5611111 0.596988
+ 0.5638889 0.595181
+ 0.5666667 0.596386
+ 0.5694444 0.597590
+ 0.5722222 0.599398
+ 0.5750000 0.597590
+ 0.5777778 0.597590
+ 0.5805556 0.596386
+ 0.5833333 0.596386
+ 0.5861111 0.598193
+ 0.5888889 0.596988
+ 0.5916667 0.596386
+ 0.5944444 0.597590
+ 0.5972222 0.596386
+ 0.6000000 0.596988
+ 0.6027778 0.596988
+ 0.6055556 0.595181
+ 0.6083333 0.595783
+ 0.6111111 0.595783
+ 0.6138889 0.595181
+ 0.6166667 0.594578
+ 0.6194444 0.595181
+ 0.6222222 0.595783
+ 0.6250000 0.593976
+ 0.6277778 0.593373
+ 0.6305556 0.592169
+ 0.6333333 0.593976
+ 0.6361111 0.594578
+ 0.6388889 0.595783
+ 0.6416667 0.593373
+ 0.6444444 0.593373
+ 0.6472222 0.592771
+ 0.6500000 0.593976
+ 0.6527778 0.593976
+ 0.6555556 0.595181
+ 0.6583333 0.594578
+ 0.6611111 0.592771
+ 0.6638889 0.592169
+ 0.6666667 0.593373
+ 0.6694444 0.593976
+ 0.6722222 0.592771
+ 0.6750000 0.593373
+ 0.6777778 0.590964
+ 0.6805556 0.590964
+ 0.6833333 0.590361
+ 0.6861111 0.591566
+ 0.6888889 0.590964
+ 0.6916667 0.589759
+ 0.6944444 0.589759
+ 0.6972222 0.590361
+ 0.7000000 0.591566
+ 0.7027778 0.592771
+ 0.7055556 0.592771
+ 0.7083333 0.592169
+ 0.7111111 0.591566
+ 0.7138889 0.589759
+ 0.7166667 0.592169
+ 0.7194444 0.591566
+ 0.7222222 0.590964
+ 0.7250000 0.590361
+ 0.7277778 0.589759
+ 0.7305556 0.587952
+ 0.7333333 0.589759
+ 0.7361111 0.590964
+ 0.7388889 0.592169
+ 0.7416667 0.589759
+ 0.7444444 0.587952
+ 0.7472222 0.587349
+ 0.7500000 0.589157
+ 0.7527778 0.590964
+ 0.7555556 0.590361
+ 0.7583333 0.589759
+ 0.7611111 0.588554
+ 0.7638889 0.587349
+ 0.7666667 0.587952
+ 0.7694444 0.589157
+ 0.7722222 0.589759
+ 0.7750000 0.590361
+ 0.7777778 0.590361
+ 0.7805556 0.589759
+ 0.7833333 0.590964
+ 0.7861111 0.590361
+ 0.7888889 0.592169
+ 0.7916667 0.590964
+ 0.7944444 0.590964
+ 0.7972222 0.590361
+ 0.8000000 0.590361
+ 0.8027778 0.592169
+ 0.8055556 0.593373
+ 0.8083333 0.591566
+ 0.8111111 0.590361
+ 0.8138889 0.589157
+ 0.8166667 0.590361
+ 0.8194444 0.591566
+ 0.8222222 0.592169
+ 0.8250000 0.593373
+ 0.8277778 0.594578
+ 0.8305556 0.593976
+ 0.8333333 0.593976
+ 0.8361111 0.594578
+ 0.8388889 0.596988
+ 0.8416667 0.596988
+ 0.8444444 0.596386
+ 0.8472222 0.600000
+ 0.8500000 0.600602
+ 0.8527778 0.602410
+ 0.8555556 0.603012
+ 0.8583333 0.602410
+ 0.8611111 0.601205
+ 0.8638889 0.599398
+ 0.8666667 0.600602
+ 0.8694444 0.600000
+ 0.8722222 0.600000
+ 0.8750000 0.600000
+ 0.8777778 0.599398
+ 0.8805556 0.598795
+ 0.8833333 0.598193
+ 0.8861111 0.598795
+ 0.8888889 0.600602
+ 0.8916667 0.601807
+ 0.8944444 0.602410
+ 0.8972222 0.597590
+ 0.9000000 0.592771
+ 0.9027778 0.592771
+ 0.9055556 0.590964
+ 0.9083333 0.589759
+ 0.9111111 0.587349
+ 0.9138889 0.587349
+ 0.9166667 0.587952
+ 0.9194444 0.589157
+ 0.9222222 0.588554
+ 0.9250000 0.589157
+ 0.9277778 0.587952
+ 0.9305556 0.586145
+ 0.9333333 0.585542
+ 0.9361111 0.586145
+ 0.9388889 0.586145
+ 0.9416667 0.584940
+ 0.9444444 0.585542
+ 0.9472222 0.584337
+ 0.9500000 0.587349
+ 0.9527778 0.586747
+ 0.9555556 0.587349
+ 0.9583333 0.588554
+ 0.9611111 0.585542
+ 0.9638889 0.584337
+ 0.9666667 0.586145
+ 0.9694444 0.587349
+ 0.9722222 0.587952
+ 0.9750000 0.587349
+ 0.9777778 0.584940
+ 0.9805556 0.583133
+ 0.9833333 0.583735
+ 0.9861111 0.581325
+ 0.9888889 0.575904
+ 0.9916667 0.573494
+ 0.9944444 0.569880
+ 0.9972222 0.565663
+ 1.0000000 0.562651
+ 1.0027778 0.566265
+ 1.0055556 0.577108
+ 1.0083333 0.590964
+ 1.0111111 0.607831
+ 1.0138889 0.625301
+ 1.0166667 0.655422
+ 1.0194444 0.686145
+ 1.0222222 0.713855
+ 1.0250000 0.732530
+ 1.0277778 0.740361
+ 1.0305556 0.736145
+ 1.0333333 0.718072
+ 1.0361111 0.686145
+ 1.0388889 0.646988
+ 1.0416667 0.613855
+ 1.0444444 0.594578
+ 1.0472222 0.580120
+ 1.0500000 0.572892
+ 1.0527778 0.569880
+ 1.0555556 0.572289
+ 1.0583333 0.575904
+ 1.0611111 0.580120
+ 1.0638889 0.580120
+ 1.0666667 0.580723
+ 1.0694444 0.580120
+ 1.0722222 0.581325
+ 1.0750000 0.581325
+ 1.0777778 0.581325
+ 1.0805556 0.579518
+ 1.0833333 0.580723
+ 1.0861111 0.580723
+ 1.0888889 0.580723
+ 1.0916667 0.581928
+ 1.0944444 0.579518
+ 1.0972222 0.577711
+ 1.1000000 0.577711
+ 1.1027778 0.578916
+ 1.1055556 0.579518
+ 1.1083333 0.580120
+ 1.1111111 0.578313
+ 1.1138889 0.579518
+ 1.1166667 0.580723
+ 1.1194444 0.581928
+ 1.1222222 0.580120
+ 1.1250000 0.580120
+ 1.1277778 0.578313
+ 1.1305556 0.577711
+ 1.1333333 0.577711
+ 1.1361111 0.580120
+ 1.1388889 0.580120
+ 1.1416667 0.579518
+ 1.1444444 0.578313
+ 1.1472222 0.577108
+ 1.1500000 0.578916
+ 1.1527778 0.577711
+ 1.1555556 0.578313
+ 1.1583333 0.577711
+ 1.1611111 0.577108
+ 1.1638889 0.577711
+ 1.1666667 0.578916
+ 1.1694444 0.578916
+ 1.1722222 0.579518
+ 1.1750000 0.580120
+ 1.1777778 0.578313
+ 1.1805556 0.577711
+ 1.1833333 0.580120
+ 1.1861111 0.580120
+ 1.1888889 0.580723
+ 1.1916667 0.580723
+ 1.1944444 0.577711
+ 1.1972222 0.578313
+ 1.2000000 0.579518
+ 1.2027778 0.580120
+ 1.2055556 0.581928
+ 1.2083333 0.580120
+ 1.2111111 0.579518
+ 1.2138889 0.577711
+ 1.2166667 0.578916
+ 1.2194444 0.580120
+ 1.2222222 0.580120
+ 1.2250000 0.580723
+ 1.2277778 0.578313
+ 1.2305556 0.577108
+ 1.2333333 0.577108
+ 1.2361111 0.578916
+ 1.2388889 0.579518
+ 1.2416667 0.578313
+ 1.2444444 0.577108
+ 1.2472222 0.576506
+ 1.2500000 0.576506
+ 1.2527778 0.577711
+ 1.2555556 0.577108
+ 1.2583333 0.575904
+ 1.2611111 0.576506
+ 1.2638889 0.574699
+ 1.2666667 0.575301
+ 1.2694444 0.575301
+ 1.2722222 0.576506
+ 1.2750000 0.575301
+ 1.2777778 0.572892
+ 1.2805556 0.572289
+ 1.2833333 0.572892
+ 1.2861111 0.574699
+ 1.2888889 0.573494
+ 1.2916667 0.572892
+ 1.2944444 0.572289
+ 1.2972222 0.570482
+ 1.3000000 0.571687
+ 1.3027778 0.572289
+ 1.3055556 0.572892
+ 1.3083333 0.572289
+ 1.3111111 0.570482
+ 1.3138889 0.569880
+ 1.3166667 0.571687
+ 1.3194444 0.572892
+ 1.3222222 0.573494
+ 1.3250000 0.574096
+ 1.3277778 0.574699
+ 1.3305556 0.574096
+ 1.3333333 0.577711
+ 1.3361111 0.579518
+ 1.3388889 0.582530
+ 1.3416667 0.583133
+ 1.3444444 0.583735
+ 1.3472222 0.583133
+ 1.3500000 0.586145
+ 1.3527778 0.587952
+ 1.3555556 0.589157
+ 1.3583333 0.588554
+ 1.3611111 0.587349
+ 1.3638889 0.587349
+ 1.3666667 0.588554
+ 1.3694444 0.589759
+ 1.3722222 0.590964
+ 1.3750000 0.590964
+ 1.3777778 0.588554
+ 1.3805556 0.588554
+ 1.3833333 0.589157
+ 1.3861111 0.590361
+ 1.3888889 0.590361
+ 1.3916667 0.591566
+ 1.3944444 0.588554
+ 1.3972222 0.587349
+ 1.4000000 0.590361
+ 1.4027778 0.589759
+ 1.4055556 0.590964
+ 1.4083333 0.590964
+ 1.4111111 0.588554
+ 1.4138889 0.587952
+ 1.4166667 0.589759
+ 1.4194444 0.590361
+ 1.4222222 0.589157
+ 1.4250000 0.590361
+ 1.4277778 0.589157
+ 1.4305556 0.589157
+ 1.4333333 0.589759
+ 1.4361111 0.591566
+ 1.4388889 0.592169
+ 1.4416667 0.590361
+ 1.4444444 0.589759
+ 1.4472222 0.588554
+ 1.4500000 0.589157
+ 1.4527778 0.590964
+ 1.4555556 0.589157
+ 1.4583333 0.589157
+ 1.4611111 0.589157
+ 1.4638889 0.587349
+ 1.4666667 0.589157
+ 1.4694444 0.588554
+ 1.4722222 0.589157
+ 1.4750000 0.587952
+ 1.4777778 0.586747
+ 1.4805556 0.586145
+ 1.4833333 0.586747
+ 1.4861111 0.586747
+ 1.4888889 0.587349
+ 1.4916667 0.587952
+ 1.4944444 0.585542
+ 1.4972222 0.584940
+ 1.5000000 0.585542
+ 1.5027778 0.586747
+ 1.5055556 0.587349
+ 1.5083333 0.587349
+ 1.5111111 0.585542
+ 1.5138889 0.585542
+ 1.5166667 0.585542
+ 1.5194444 0.588554
+ 1.5222222 0.587349
+ 1.5250000 0.586747
+ 1.5277778 0.586145
+ 1.5305556 0.584337
+ 1.5333333 0.586747
+ 1.5361111 0.587349
+ 1.5388889 0.587349
+ 1.5416667 0.586747
+ 1.5444444 0.584337
+ 1.5472222 0.583735
+ 1.5500000 0.584337
+ 1.5527778 0.584940
+ 1.5555556 0.586145
+ 1.5583333 0.585542
+ 1.5611111 0.585542
+ 1.5638889 0.585542
+ 1.5666667 0.585542
+ 1.5694444 0.587349
+ 1.5722222 0.587349
+ 1.5750000 0.586747
+ 1.5777778 0.585542
+ 1.5805556 0.584940
+ 1.5833333 0.584940
+ 1.5861111 0.586145
+ 1.5888889 0.587349
+ 1.5916667 0.585542
+ 1.5944444 0.585542
+ 1.5972222 0.584337
+ 1.6000000 0.584940
+ 1.6027778 0.586145
+ 1.6055556 0.587349
+ 1.6083333 0.586145
+ 1.6111111 0.586145
+ 1.6138889 0.586145
+ 1.6166667 0.587349
+ 1.6194444 0.586747
+ 1.6222222 0.587349
+ 1.6250000 0.586747
+ 1.6277778 0.585542
+ 1.6305556 0.585542
+ 1.6333333 0.586145
+ 1.6361111 0.587349
+ 1.6388889 0.589157
+ 1.6416667 0.591566
+ 1.6444444 0.590964
+ 1.6472222 0.591566
+ 1.6500000 0.592771
+ 1.6527778 0.593976
+ 1.6555556 0.595181
+ 1.6583333 0.595181
+ 1.6611111 0.595181
+ 1.6638889 0.596386
+ 1.6666667 0.596988
+ 1.6694444 0.598193
+ 1.6722222 0.600000
+ 1.6750000 0.601205
+ 1.6777778 0.598193
+ 1.6805556 0.597590
+ 1.6833333 0.598193
+ 1.6861111 0.597590
+ 1.6888889 0.598795
+ 1.6916667 0.597590
+ 1.6944444 0.596988
+ 1.6972222 0.593976
+ 1.7000000 0.593976
+ 1.7027778 0.595181
+ 1.7055556 0.596988
+ 1.7083333 0.600000
+ 1.7111111 0.600602
+ 1.7138889 0.599398
+ 1.7166667 0.595181
+ 1.7194444 0.594578
+ 1.7222222 0.593373
+ 1.7250000 0.592771
+ 1.7277778 0.590361
+ 1.7305556 0.588554
+ 1.7333333 0.586145
+ 1.7361111 0.587349
+ 1.7388889 0.586747
+ 1.7416667 0.586747
+ 1.7444444 0.584337
+ 1.7472222 0.582530
+ 1.7500000 0.583735
+ 1.7527778 0.585542
+ 1.7555556 0.584940
+ 1.7583333 0.584337
+ 1.7611111 0.583133
+ 1.7638889 0.581928
+ 1.7666667 0.581325
+ 1.7694444 0.582530
+ 1.7722222 0.583133
+ 1.7750000 0.583133
+ 1.7777778 0.581325
+ 1.7805556 0.580723
+ 1.7833333 0.581325
+ 1.7861111 0.581928
+ 1.7888889 0.584337
+ 1.7916667 0.582530
+ 1.7944444 0.580120
+ 1.7972222 0.578313
+ 1.8000000 0.577711
+ 1.8027778 0.574699
+ 1.8055556 0.571084
+ 1.8083333 0.568072
+ 1.8111111 0.564458
+ 1.8138889 0.560241
+ 1.8166667 0.558434
+ 1.8194444 0.563855
+ 1.8222222 0.578313
+ 1.8250000 0.596988
+ 1.8277778 0.616265
+ 1.8305556 0.641566
+ 1.8333333 0.676506
+ 1.8361111 0.710241
+ 1.8388889 0.733735
+ 1.8416667 0.742771
+ 1.8444444 0.729518
+ 1.8472222 0.689759
+ 1.8500000 0.633133
+ 1.8527778 0.588554
+ 1.8555556 0.566867
+ 1.8583333 0.566265
+ 1.8611111 0.573494
+ 1.8638889 0.577108
+ 1.8666667 0.579518
+ 1.8694444 0.580120
+ 1.8722222 0.579518
+ 1.8750000 0.580120
+ 1.8777778 0.579518
+ 1.8805556 0.578313
+ 1.8833333 0.579518
+ 1.8861111 0.578313
+ 1.8888889 0.580120
+ 1.8916667 0.579518
+ 1.8944444 0.579518
+ 1.8972222 0.577711
+ 1.9000000 0.578313
+ 1.9027778 0.578916
+ 1.9055556 0.578916
+ 1.9083333 0.577108
+ 1.9111111 0.578313
+ 1.9138889 0.576506
+ 1.9166667 0.577108
+ 1.9194444 0.578313
+ 1.9222222 0.578313
+ 1.9250000 0.576506
+ 1.9277778 0.576506
+ 1.9305556 0.574699
+ 1.9333333 0.576506
+ 1.9361111 0.577711
+ 1.9388889 0.577711
+ 1.9416667 0.578313
+ 1.9444444 0.575904
+ 1.9472222 0.575301
+ 1.9500000 0.576506
+ 1.9527778 0.577108
+ 1.9555556 0.577711
+ 1.9583333 0.577711
+ 1.9611111 0.575904
+ 1.9638889 0.576506
+ 1.9666667 0.578916
+ 1.9694444 0.579518
+ 1.9722222 0.578916
+ 1.9750000 0.578916
+ 1.9777778 0.579518
+ 1.9805556 0.577108
+ 1.9833333 0.578313
+ 1.9861111 0.580120
+ 1.9888889 0.578916
+ 1.9916667 0.578916
+ 1.9944444 0.577108
+ 1.9972222 0.575904
+ 2.0000000 0.575904
+ 2.0027778 0.577108
+ 2.0055556 0.577108
+ 2.0083333 0.577711
+ 2.0111111 0.575904
+ 2.0138889 0.575904
+ 2.0166667 0.576506
+ 2.0194444 0.577108
+ 2.0222222 0.578916
+ 2.0250000 0.578916
+ 2.0277778 0.577711
+ 2.0305556 0.575904
+ 2.0333333 0.577711
+ 2.0361111 0.578313
+ 2.0388889 0.579518
+ 2.0416667 0.578916
+ 2.0444444 0.578916
+ 2.0472222 0.578313
+ 2.0500000 0.580723
+ 2.0527778 0.578916
+ 2.0555556 0.580120
+ 2.0583333 0.580120
+ 2.0611111 0.578916
+ 2.0638889 0.577108
+ 2.0666667 0.578313
+ 2.0694444 0.578313
+ 2.0722222 0.577711
+ 2.0750000 0.577108
+ 2.0777778 0.576506
+ 2.0805556 0.576506
+ 2.0833333 0.575904
+ 2.0861111 0.577108
+ 2.0888889 0.577108
+ 2.0916667 0.577711
+ 2.0944444 0.574699
+ 2.0972222 0.575301
+ 2.1000000 0.574699
+ 2.1027778 0.576506
+ 2.1055556 0.576506
+ 2.1083333 0.576506
+ 2.1111111 0.576506
+ 2.1138889 0.575904
+ 2.1166667 0.575904
+ 2.1194444 0.577108
+ 2.1222222 0.579518
+ 2.1250000 0.579518
+ 2.1277778 0.580120
+ 2.1305556 0.581928
+ 2.1333333 0.583735
+ 2.1361111 0.586145
+ 2.1388889 0.586747
+ 2.1416667 0.587349
+ 2.1444444 0.586747
+ 2.1472222 0.586747
+ 2.1500000 0.587952
+ 2.1527778 0.588554
+ 2.1555556 0.590361
+ 2.1583333 0.590361
+ 2.1611111 0.589157
+ 2.1638889 0.589759
+ 2.1666667 0.590361
+ 2.1694444 0.590964
+ 2.1722222 0.590964
+ 2.1750000 0.590964
+ 2.1777778 0.589759
+ 2.1805556 0.589759
+ 2.1833333 0.589759
+ 2.1861111 0.589157
+ 2.1888889 0.590964
+ 2.1916667 0.590361
+ 2.1944444 0.589157
+ 2.1972222 0.588554
+ 2.2000000 0.587952
+ 2.2027778 0.589759
+ 2.2055556 0.590361
+ 2.2083333 0.590361
+ 2.2111111 0.588554
+ 2.2138889 0.587952
+ 2.2166667 0.590361
+ 2.2194444 0.589759
+ 2.2222222 0.591566
+ 2.2250000 0.589759
+ 2.2277778 0.587952
+ 2.2305556 0.587349
+ 2.2333333 0.588554
+ 2.2361111 0.588554
+ 2.2388889 0.588554
+ 2.2416667 0.587952
+ 2.2444444 0.584940
+ 2.2472222 0.584940
+ 2.2500000 0.586145
+ 2.2527778 0.586747
+ 2.2555556 0.587349
+ 2.2583333 0.586747
+ 2.2611111 0.586145
+ 2.2638889 0.583735
+ 2.2666667 0.584940
+ 2.2694444 0.584940
+ 2.2722222 0.584337
+ 2.2750000 0.583735
+ 2.2777778 0.584337
+ 2.2805556 0.583133
+ 2.2833333 0.584337
+ 2.2861111 0.584940
+ 2.2888889 0.586145
+ 2.2916667 0.584337
+ 2.2944444 0.584940
+ 2.2972222 0.583133
+ 2.3000000 0.583133
+ 2.3027778 0.584940
+ 2.3055556 0.584337
+ 2.3083333 0.584940
+ 2.3111111 0.582530
+ 2.3138889 0.581325
+ 2.3166667 0.582530
+ 2.3194444 0.583735
+ 2.3222222 0.583133
+ 2.3250000 0.583735
+ 2.3277778 0.583133
+ 2.3305556 0.581325
+ 2.3333333 0.582530
+ 2.3361111 0.583133
+ 2.3388889 0.584940
+ 2.3416667 0.584940
+ 2.3444444 0.584940
+ 2.3472222 0.582530
+ 2.3500000 0.583133
+ 2.3527778 0.585542
+ 2.3555556 0.585542
+ 2.3583333 0.586145
+ 2.3611111 0.584337
+ 2.3638889 0.583133
+ 2.3666667 0.583735
+ 2.3694444 0.584337
+ 2.3722222 0.584337
+ 2.3750000 0.584337
+ 2.3777778 0.581928
+ 2.3805556 0.580723
+ 2.3833333 0.584337
+ 2.3861111 0.583735
+ 2.3888889 0.584337
+ 2.3916667 0.583735
+ 2.3944444 0.583735
+ 2.3972222 0.582530
+ 2.4000000 0.583735
+ 2.4027778 0.585542
+ 2.4055556 0.584337
+ 2.4083333 0.585542
+ 2.4111111 0.585542
+ 2.4138889 0.585542
+ 2.4166667 0.586145
+ 2.4194444 0.589759
+ 2.4222222 0.590361
+ 2.4250000 0.590361
+ 2.4277778 0.589759
+ 2.4305556 0.590361
+ 2.4333333 0.592169
+ 2.4361111 0.592771
+ 2.4388889 0.593976
+ 2.4416667 0.593373
+ 2.4444444 0.593373
+ 2.4472222 0.593976
+ 2.4500000 0.595181
+ 2.4527778 0.596386
+ 2.4555556 0.597590
+ 2.4583333 0.595783
+ 2.4611111 0.595181
+ 2.4638889 0.593976
+ 2.4666667 0.593373
+ 2.4694444 0.595181
+ 2.4722222 0.594578
+ 2.4750000 0.593976
+ 2.4777778 0.593373
+ 2.4805556 0.593976
+ 2.4833333 0.593373
+ 2.4861111 0.593976
+ 2.4888889 0.595181
+ 2.4916667 0.596386
+ 2.4944444 0.598193
+ 2.4972222 0.595783
+ 2.5000000 0.593373
+ 2.5027778 0.589759
+ 2.5055556 0.589759
+ 2.5083333 0.585542
+ 2.5111111 0.583735
+ 2.5138889 0.581325
+ 2.5166667 0.580723
+ 2.5194444 0.581325
+ 2.5222222 0.582530
+ 2.5250000 0.581928
+ 2.5277778 0.580723
+ 2.5305556 0.580120
+ 2.5333333 0.579518
+ 2.5361111 0.580723
+ 2.5388889 0.580723
+ 2.5416667 0.580723
+ 2.5444444 0.579518
+ 2.5472222 0.578313
+ 2.5500000 0.578916
+ 2.5527778 0.581928
+ 2.5555556 0.581928
+ 2.5583333 0.580120
+ 2.5611111 0.579518
+ 2.5638889 0.577108
+ 2.5666667 0.578313
+ 2.5694444 0.578916
+ 2.5722222 0.580120
+ 2.5750000 0.578313
+ 2.5777778 0.575904
+ 2.5805556 0.571687
+ 2.5833333 0.569880
+ 2.5861111 0.566265
+ 2.5888889 0.565663
+ 2.5916667 0.563855
+ 2.5944444 0.562048
+ 2.5972222 0.554819
+ 2.6000000 0.549398
+ 2.6027778 0.551205
+ 2.6055556 0.557831
+ 2.6083333 0.567470
+ 2.6111111 0.580723
+ 2.6138889 0.594578
+ 2.6166667 0.613253
+ 2.6194444 0.637952
+ 2.6222222 0.671687
+ 2.6250000 0.703614
+ 2.6277778 0.724699
+ 2.6305556 0.730723
+ 2.6333333 0.719880
+ 2.6361111 0.684337
+ 2.6388889 0.634940
+ 2.6416667 0.590361
+ 2.6444444 0.566867
+ 2.6472222 0.564458
+ 2.6500000 0.569880
+ 2.6527778 0.577711
+ 2.6555556 0.580120
+ 2.6583333 0.580120
+ 2.6611111 0.578916
+ 2.6638889 0.577711
+ 2.6666667 0.578313
+ 2.6694444 0.580723
+ 2.6722222 0.580120
+ 2.6750000 0.579518
+ 2.6777778 0.578313
+ 2.6805556 0.577711
+ 2.6833333 0.578313
+ 2.6861111 0.578916
+ 2.6888889 0.580120
+ 2.6916667 0.579518
+ 2.6944444 0.577711
+ 2.6972222 0.577108
+ 2.7000000 0.577711
+ 2.7027778 0.579518
+ 2.7055556 0.578313
+ 2.7083333 0.577711
+ 2.7111111 0.578313
+ 2.7138889 0.578313
+ 2.7166667 0.577711
+ 2.7194444 0.580120
+ 2.7222222 0.580723
+ 2.7250000 0.580120
+ 2.7277778 0.579518
+ 2.7305556 0.578916
+ 2.7333333 0.578916
+ 2.7361111 0.578916
+ 2.7388889 0.579518
+ 2.7416667 0.579518
+ 2.7444444 0.578313
+ 2.7472222 0.578313
+ 2.7500000 0.578916
+ 2.7527778 0.579518
+ 2.7555556 0.580723
+ 2.7583333 0.581928
+ 2.7611111 0.580723
+ 2.7638889 0.579518
+ 2.7666667 0.580120
+ 2.7694444 0.580723
+ 2.7722222 0.581928
+ 2.7750000 0.580723
+ 2.7777778 0.579518
+ 2.7805556 0.579518
+ 2.7833333 0.580723
+ 2.7861111 0.581928
+ 2.7888889 0.581928
+ 2.7916667 0.580723
+ 2.7944444 0.579518
+ 2.7972222 0.580120
+ 2.8000000 0.580120
+ 2.8027778 0.583133
+ 2.8055556 0.581928
+ 2.8083333 0.580723
+ 2.8111111 0.579518
+ 2.8138889 0.581325
+ 2.8166667 0.580723
+ 2.8194444 0.581928
+ 2.8222222 0.581325
+ 2.8250000 0.580120
+ 2.8277778 0.581325
+ 2.8305556 0.581928
+ 2.8333333 0.581928
+ 2.8361111 0.581928
+ 2.8388889 0.581928
+ 2.8416667 0.581325
+ 2.8444444 0.580120
+ 2.8472222 0.580120
+ 2.8500000 0.583133
+ 2.8527778 0.582530
+ 2.8555556 0.581928
+ 2.8583333 0.580723
+ 2.8611111 0.580120
+ 2.8638889 0.580120
+ 2.8666667 0.581928
+ 2.8694444 0.583133
+ 2.8722222 0.580723
+ 2.8750000 0.581325
+ 2.8777778 0.580120
+ 2.8805556 0.581928
+ 2.8833333 0.581928
+ 2.8861111 0.583133
+ 2.8888889 0.582530
+ 2.8916667 0.580723
+ 2.8944444 0.579518
+ 2.8972222 0.580723
+ 2.9000000 0.580723
+ 2.9027778 0.582530
+ 2.9055556 0.583133
+ 2.9083333 0.582530
+ 2.9111111 0.581928
+ 2.9138889 0.584940
+ 2.9166667 0.586747
+ 2.9194444 0.588554
+ 2.9222222 0.589157
+ 2.9250000 0.588554
+ 2.9277778 0.587952
+ 2.9305556 0.589157
+ 2.9333333 0.591566
+ 2.9361111 0.592771
+ 2.9388889 0.590964
+ 2.9416667 0.591566
+ 2.9444444 0.592771
+ 2.9472222 0.592771
+ 2.9500000 0.593373
+ 2.9527778 0.594578
+ 2.9555556 0.593373
+ 2.9583333 0.592169
+ 2.9611111 0.591566
+ 2.9638889 0.591566
+ 2.9666667 0.592169
+ 2.9694444 0.593373
+ 2.9722222 0.592169
+ 2.9750000 0.591566
+ 2.9777778 0.589759
+ 2.9805556 0.591566
+ 2.9833333 0.592771
+ 2.9861111 0.593373
+ 2.9888889 0.593976
+ 2.9916667 0.591566
+ 2.9944444 0.590361
+ 2.9972222 0.590964
+ 3.0000000 0.591566
+ 3.0027778 0.591566
+ 3.0055556 0.592771
+ 3.0083333 0.590964
+ 3.0111111 0.590361
+ 3.0138889 0.590964
+ 3.0166667 0.591566
+ 3.0194444 0.590964
+ 3.0222222 0.590361
+ 3.0250000 0.589157
+ 3.0277778 0.589759
+ 3.0305556 0.589157
+ 3.0333333 0.591566
+ 3.0361111 0.590964
+ 3.0388889 0.589759
+ 3.0416667 0.587349
+ 3.0444444 0.586145
+ 3.0472222 0.587349
+ 3.0500000 0.588554
+ 3.0527778 0.588554
+ 3.0555556 0.589157
+ 3.0583333 0.587952
+ 3.0611111 0.586747
+ 3.0638889 0.587349
+ 3.0666667 0.589157
+ 3.0694444 0.588554
+ 3.0722222 0.588554
+ 3.0750000 0.587349
+ 3.0777778 0.585542
+ 3.0805556 0.586145
+ 3.0833333 0.586747
+ 3.0861111 0.587349
+ 3.0888889 0.586747
+ 3.0916667 0.585542
+ 3.0944444 0.584940
+ 3.0972222 0.585542
+ 3.1000000 0.586145
+ 3.1027778 0.586747
+ 3.1055556 0.586747
+ 3.1083333 0.587349
+ 3.1111111 0.586747
+ 3.1138889 0.586145
+ 3.1166667 0.586747
+ 3.1194444 0.588554
+ 3.1222222 0.586145
+ 3.1250000 0.586145
+ 3.1277778 0.584940
+ 3.1305556 0.583133
+ 3.1333333 0.583735
+ 3.1361111 0.585542
+ 3.1388889 0.585542
+ 3.1416667 0.584940
+ 3.1444444 0.584940
+ 3.1472222 0.584940
+ 3.1500000 0.586145
+ 3.1527778 0.586145
+ 3.1555556 0.585542
+ 3.1583333 0.585542
+ 3.1611111 0.581325
+ 3.1638889 0.583735
+ 3.1666667 0.583735
+ 3.1694444 0.585542
+ 3.1722222 0.585542
+ 3.1750000 0.584940
+ 3.1777778 0.584337
+ 3.1805556 0.585542
+ 3.1833333 0.587349
+ 3.1861111 0.587349
+ 3.1888889 0.586747
+ 3.1916667 0.586747
+ 3.1944444 0.586145
+ 3.1972222 0.587349
+ 3.2000000 0.588554
+ 3.2027778 0.592169
+ 3.2055556 0.592169
+ 3.2083333 0.590964
+ 3.2111111 0.590361
+ 3.2138889 0.592771
+ 3.2166667 0.593373
+ 3.2194444 0.593976
+ 3.2222222 0.593373
+ 3.2250000 0.593976
+ 3.2277778 0.594578
+ 3.2305556 0.595181
+ 3.2333333 0.596988
+ 3.2361111 0.599398
+ 3.2388889 0.597590
+ 3.2416667 0.598193
+ 3.2444444 0.596386
+ 3.2472222 0.596386
+ 3.2500000 0.597590
+ 3.2527778 0.598795
+ 3.2555556 0.596386
+ 3.2583333 0.595181
+ 3.2611111 0.595783
+ 3.2638889 0.596386
+ 3.2666667 0.594578
+ 3.2694444 0.595181
+ 3.2722222 0.593373
+ 3.2750000 0.596386
+ 3.2777778 0.596988
+ 3.2805556 0.597590
+ 3.2833333 0.595181
+ 3.2861111 0.593373
+ 3.2888889 0.590964
+ 3.2916667 0.589157
+ 3.2944444 0.587952
+ 3.2972222 0.586747
+ 3.3000000 0.585542
+ 3.3027778 0.587349
+ 3.3055556 0.586747
+ 3.3083333 0.585542
+ 3.3111111 0.583735
+ 3.3138889 0.584940
+ 3.3166667 0.586145
+ 3.3194444 0.586747
+ 3.3222222 0.585542
+ 3.3250000 0.583735
+ 3.3277778 0.583133
+ 3.3305556 0.581928
+ 3.3333333 0.582530
+ 3.3361111 0.583133
+ 3.3388889 0.583133
+ 3.3416667 0.581325
+ 3.3444444 0.581928
+ 3.3472222 0.581928
+ 3.3500000 0.583133
+ 3.3527778 0.582530
+ 3.3555556 0.583735
+ 3.3583333 0.582530
+ 3.3611111 0.581325
+ 3.3638889 0.583133
+ 3.3666667 0.583735
+ 3.3694444 0.584940
+ 3.3722222 0.584337
+ 3.3750000 0.582530
+ 3.3777778 0.580723
+ 3.3805556 0.579518
+ 3.3833333 0.575301
+ 3.3861111 0.573494
+ 3.3888889 0.568675
+ 3.3916667 0.565060
+ 3.3944444 0.559036
+ 3.3972222 0.560241
+ 3.4000000 0.569880
+ 3.4027778 0.584337
+ 3.4055556 0.600602
+ 3.4083333 0.620482
+ 3.4111111 0.649398
+ 3.4138889 0.684337
+ 3.4166667 0.712048
+ 3.4194444 0.725904
+ 3.4222222 0.721084
+ 3.4250000 0.691566
+ 3.4277778 0.644578
+ 3.4305556 0.603012
+ 3.4333333 0.576506
+ 3.4361111 0.566867
+ 3.4388889 0.569277
+ 3.4416667 0.572892
+ 3.4444444 0.577711
+ 3.4472222 0.578916
+ 3.4500000 0.580120
+ 3.4527778 0.580120
+ 3.4555556 0.578916
+ 3.4583333 0.578313
+ 3.4611111 0.575904
+ 3.4638889 0.575904
+ 3.4666667 0.578313
+ 3.4694444 0.579518
+ 3.4722222 0.578313
+ 3.4750000 0.578313
+ 3.4777778 0.577108
+ 3.4805556 0.578313
+ 3.4833333 0.580723
+ 3.4861111 0.580120
+ 3.4888889 0.579518
+ 3.4916667 0.579518
+ 3.4944444 0.579518
+ 3.4972222 0.579518
+ 3.5000000 0.580723
+ 3.5027778 0.580120
+ 3.5055556 0.580120
+ 3.5083333 0.578916
+ 3.5111111 0.575904
+ 3.5138889 0.577711
+ 3.5166667 0.578916
+ 3.5194444 0.579518
+ 3.5222222 0.578916
+ 3.5250000 0.578313
+ 3.5277778 0.575904
+ 3.5305556 0.577108
+ 3.5333333 0.578313
+ 3.5361111 0.578313
+ 3.5388889 0.578313
+ 3.5416667 0.577711
+ 3.5444444 0.577108
+ 3.5472222 0.578313
+ 3.5500000 0.576506
+ 3.5527778 0.578313
+ 3.5555556 0.577711
+ 3.5583333 0.577711
+ 3.5611111 0.576506
+ 3.5638889 0.577108
+ 3.5666667 0.578313
+ 3.5694444 0.579518
+ 3.5722222 0.579518
+ 3.5750000 0.579518
+ 3.5777778 0.578916
+ 3.5805556 0.579518
+ 3.5833333 0.579518
+ 3.5861111 0.578313
+ 3.5888889 0.578313
+ 3.5916667 0.576506
+ 3.5944444 0.574699
+ 3.5972222 0.577108
+ 3.6000000 0.578313
+ 3.6027778 0.579518
+ 3.6055556 0.580120
+ 3.6083333 0.577108
+ 3.6111111 0.578313
+ 3.6138889 0.578313
+ 3.6166667 0.578916
+ 3.6194444 0.579518
+ 3.6222222 0.579518
+ 3.6250000 0.578313
+ 3.6277778 0.576506
+ 3.6305556 0.577108
+ 3.6333333 0.578916
+ 3.6361111 0.579518
+ 3.6388889 0.578916
+ 3.6416667 0.578313
+ 3.6444444 0.575904
+ 3.6472222 0.575904
+ 3.6500000 0.575904
+ 3.6527778 0.576506
+ 3.6555556 0.575904
+ 3.6583333 0.572892
+ 3.6611111 0.573494
+ 3.6638889 0.572892
+ 3.6666667 0.574699
+ 3.6694444 0.573494
+ 3.6722222 0.570482
+ 3.6750000 0.572289
+ 3.6777778 0.571687
+ 3.6805556 0.574096
+ 3.6833333 0.574699
+ 3.6861111 0.575904
+ 3.6888889 0.575301
+ 3.6916667 0.573494
+ 3.6944444 0.572892
+ 3.6972222 0.573494
+ 3.7000000 0.575301
+ 3.7027778 0.576506
+ 3.7055556 0.577711
+ 3.7083333 0.575904
+ 3.7111111 0.576506
+ 3.7138889 0.578313
+ 3.7166667 0.581325
+ 3.7194444 0.582530
+ 3.7222222 0.583133
+ 3.7250000 0.583133
+ 3.7277778 0.583133
+ 3.7305556 0.585542
+ 3.7333333 0.587349
+ 3.7361111 0.589157
+ 3.7388889 0.590361
+ 3.7416667 0.590361
+ 3.7444444 0.588554
+ 3.7472222 0.589759
+ 3.7500000 0.589759
+ 3.7527778 0.590361
+ 3.7555556 0.589759
+ 3.7583333 0.589157
+ 3.7611111 0.588554
+ 3.7638889 0.589157
+ 3.7666667 0.590361
+ 3.7694444 0.590361
+ 3.7722222 0.591566
+ 3.7750000 0.589759
+ 3.7777778 0.588554
+ 3.7805556 0.589759
+ 3.7833333 0.589157
+ 3.7861111 0.591566
+ 3.7888889 0.590964
+ 3.7916667 0.590361
+ 3.7944444 0.590964
+ 3.7972222 0.592771
+ 3.8000000 0.593373
+ 3.8027778 0.592169
+ 3.8055556 0.591566
+ 3.8083333 0.590361
+ 3.8111111 0.587952
+ 3.8138889 0.590361
+ 3.8166667 0.590964
+ 3.8194444 0.590964
+ 3.8222222 0.589157
+ 3.8250000 0.587952
+ 3.8277778 0.586747
+ 3.8305556 0.587952
+ 3.8333333 0.589157
+ 3.8361111 0.588554
+ 3.8388889 0.586747
+ 3.8416667 0.587349
+ 3.8444444 0.586145
+ 3.8472222 0.587952
+ 3.8500000 0.587952
+ 3.8527778 0.588554
+ 3.8555556 0.589157
+ 3.8583333 0.586747
+ 3.8611111 0.586747
+ 3.8638889 0.585542
+ 3.8666667 0.586747
+ 3.8694444 0.587952
+ 3.8722222 0.587349
+ 3.8750000 0.589157
+ 3.8777778 0.586747
+ 3.8805556 0.587349
+ 3.8833333 0.587349
+ 3.8861111 0.587349
+ 3.8888889 0.587349
+ 3.8916667 0.586747
+ 3.8944444 0.586145
+ 3.8972222 0.587349
+ 3.9000000 0.588554
+ 3.9027778 0.589157
+ 3.9055556 0.587952
+ 3.9083333 0.586747
+ 3.9111111 0.584337
+ 3.9138889 0.585542
+ 3.9166667 0.586145
+ 3.9194444 0.586747
+ 3.9222222 0.588554
+ 3.9250000 0.587952
+ 3.9277778 0.584940
+ 3.9305556 0.587349
+ 3.9333333 0.589157
+ 3.9361111 0.589157
+ 3.9388889 0.587349
+ 3.9416667 0.587349
+ 3.9444444 0.586747
+ 3.9472222 0.586747
+ 3.9500000 0.587349
+ 3.9527778 0.587349
+ 3.9555556 0.587349
+ 3.9583333 0.586145
+ 3.9611111 0.586145
+ 3.9638889 0.586145
+ 3.9666667 0.587952
+ 3.9694444 0.587952
+ 3.9722222 0.587952
+ 3.9750000 0.585542
+ 3.9777778 0.584940
+ 3.9805556 0.586145
+ 3.9833333 0.587349
+ 3.9861111 0.588554
+ 3.9888889 0.589759
+ 3.9916667 0.590361
+ 3.9944444 0.590361
+ 3.9972222 0.593976
+ 4.0000000 0.594578
+ 4.0027778 0.596386
+ 4.0055556 0.595783
+ 4.0083333 0.595181
+ 4.0111111 0.595783
+ 4.0138889 0.596988
+ 4.0166667 0.598795
+ 4.0194444 0.598795
+ 4.0222222 0.600602
+ 4.0250000 0.598795
+ 4.0277778 0.598795
+ 4.0305556 0.600602
+ 4.0333333 0.599398
+ 4.0361111 0.600000
+ 4.0388889 0.598795
+ 4.0416667 0.597590
+ 4.0444444 0.596386
+ 4.0472222 0.598193
+ 4.0500000 0.599398
+ 4.0527778 0.599398
+ 4.0555556 0.596988
+ 4.0583333 0.596386
+ 4.0611111 0.596988
+ 4.0638889 0.599398
+ 4.0666667 0.602410
+ 4.0694444 0.603614
+ 4.0722222 0.601807
+ 4.0750000 0.599398
+ 4.0777778 0.594578
+ 4.0805556 0.594578
+ 4.0833333 0.592771
+ 4.0861111 0.592771
+ 4.0888889 0.589759
+ 4.0916667 0.587349
+ 4.0944444 0.586145
+ 4.0972222 0.586145
+ 4.1000000 0.585542
+ 4.1027778 0.584940
+ 4.1055556 0.584940
+ 4.1083333 0.586145
+ 4.1111111 0.584337
+ 4.1138889 0.585542
+ 4.1166667 0.586145
+ 4.1194444 0.586145
+ 4.1222222 0.585542
+ 4.1250000 0.584337
+ 4.1277778 0.582530
+ 4.1305556 0.584337
+ 4.1333333 0.582530
+ 4.1361111 0.585542
+ 4.1388889 0.586145
+ 4.1416667 0.583735
+ 4.1444444 0.581325
+ 4.1472222 0.583735
+ 4.1500000 0.585542
+ 4.1527778 0.584940
+ 4.1555556 0.584940
+ 4.1583333 0.584337
+ 4.1611111 0.581325
+ 4.1638889 0.580120
+ 4.1666667 0.579518
+ 4.1694444 0.575904
+ 4.1722222 0.572289
+ 4.1750000 0.569880
+ 4.1777778 0.565663
+ 4.1805556 0.561446
+ 4.1833333 0.562048
+ 4.1861111 0.567470
+ 4.1888889 0.578313
+ 4.1916667 0.591566
+ 4.1944444 0.607831
+ 4.1972222 0.631928
+ 4.2000000 0.665060
+ 4.2027778 0.698795
+ 4.2055556 0.723494
+ 4.2083333 0.733735
+ 4.2111111 0.722892
+ 4.2138889 0.689759
+ 4.2166667 0.642771
+ 4.2194444 0.601205
+ 4.2222222 0.575904
+ 4.2250000 0.566867
+ 4.2277778 0.568072
+ 4.2305556 0.572892
+ 4.2333333 0.578916
+ 4.2361111 0.580120
+ 4.2388889 0.579518
+ 4.2416667 0.579518
+ 4.2444444 0.578916
+ 4.2472222 0.580120
+ 4.2500000 0.581325
+ 4.2527778 0.580723
+ 4.2555556 0.580723
+ 4.2583333 0.578916
+ 4.2611111 0.577711
+ 4.2638889 0.577711
+ 4.2666667 0.580120
+ 4.2694444 0.580120
+ 4.2722222 0.578313
+ 4.2750000 0.578313
+ 4.2777778 0.577108
+ 4.2805556 0.577711
+ 4.2833333 0.579518
+ 4.2861111 0.579518
+ 4.2888889 0.578916
+ 4.2916667 0.577108
+ 4.2944444 0.577108
+ 4.2972222 0.577108
+ 4.3000000 0.578916
+ 4.3027778 0.580120
+ 4.3055556 0.580120
+ 4.3083333 0.577711
+ 4.3111111 0.577108
+ 4.3138889 0.578313
+ 4.3166667 0.579518
+ 4.3194444 0.579518
+ 4.3222222 0.579518
+ 4.3250000 0.578313
+ 4.3277778 0.577711
+ 4.3305556 0.577711
+ 4.3333333 0.578916
+ 4.3361111 0.580120
+ 4.3388889 0.579518
+ 4.3416667 0.577711
+ 4.3444444 0.575904
+ 4.3472222 0.577108
+ 4.3500000 0.578313
+ 4.3527778 0.577711
+ 4.3555556 0.578313
+ 4.3583333 0.577108
+ 4.3611111 0.575904
+ 4.3638889 0.575904
+ 4.3666667 0.577711
+ 4.3694444 0.579518
+ 4.3722222 0.580120
+ 4.3750000 0.578916
+ 4.3777778 0.577711
+ 4.3805556 0.577711
+ 4.3833333 0.578916
+ 4.3861111 0.580120
+ 4.3888889 0.577711
+ 4.3916667 0.576506
+ 4.3944444 0.576506
+ 4.3972222 0.577108
+ 4.4000000 0.577108
+ 4.4027778 0.578313
+ 4.4055556 0.576506
+ 4.4083333 0.577108
+ 4.4111111 0.575904
+ 4.4138889 0.577711
+ 4.4166667 0.578916
+ 4.4194444 0.578313
+ 4.4222222 0.578916
+ 4.4250000 0.578916
+ 4.4277778 0.577711
+ 4.4305556 0.578916
+ 4.4333333 0.579518
+ 4.4361111 0.579518
+ 4.4388889 0.578313
+ 4.4416667 0.577711
+ 4.4444444 0.575904
+ 4.4472222 0.575904
+ 4.4500000 0.577711
+ 4.4527778 0.577711
+ 4.4555556 0.576506
+ 4.4583333 0.575301
+ 4.4611111 0.573494
+ 4.4638889 0.574096
+ 4.4666667 0.574699
+ 4.4694444 0.575301
+ 4.4722222 0.575301
+ 4.4750000 0.572892
+ 4.4777778 0.573494
+ 4.4805556 0.573494
+ 4.4833333 0.574699
+ 4.4861111 0.574699
+ 4.4888889 0.573494
+ 4.4916667 0.574096
+ 4.4944444 0.572892
+ 4.4972222 0.575301
+ 4.5000000 0.575301
+ 4.5027778 0.577108
+ 4.5055556 0.578916
+ 4.5083333 0.578916
+ 4.5111111 0.580723
+ 4.5138889 0.583133
+ 4.5166667 0.586747
+ 4.5194444 0.587349
+ 4.5222222 0.587952
+ 4.5250000 0.587349
+ 4.5277778 0.587349
+ 4.5305556 0.589759
+ 4.5333333 0.591566
+ 4.5361111 0.592771
+ 4.5388889 0.592169
+ 4.5416667 0.592169
+ 4.5444444 0.589759
+ 4.5472222 0.591566
+ 4.5500000 0.592771
+ 4.5527778 0.593373
+ 4.5555556 0.590964
+ 4.5583333 0.592169
+ 4.5611111 0.591566
+ 4.5638889 0.592169
+ 4.5666667 0.593373
+ 4.5694444 0.593976
+ 4.5722222 0.593976
+ 4.5750000 0.592169
+ 4.5777778 0.592169
+ 4.5805556 0.592771
+ 4.5833333 0.594578
+ 4.5861111 0.594578
+ 4.5888889 0.594578
+ 4.5916667 0.593976
+ 4.5944444 0.592169
+ 4.5972222 0.592771
+ 4.6000000 0.593976
+ 4.6027778 0.593976
+ 4.6055556 0.592169
+ 4.6083333 0.591566
+ 4.6111111 0.590361
+ 4.6138889 0.591566
+ 4.6166667 0.591566
+ 4.6194444 0.592771
+ 4.6222222 0.592169
+ 4.6250000 0.590964
+ 4.6277778 0.590361
+ 4.6305556 0.589759
+ 4.6333333 0.591566
+ 4.6361111 0.590964
+ 4.6388889 0.590361
+ 4.6416667 0.589759
+ 4.6444444 0.587952
+ 4.6472222 0.587952
+ 4.6500000 0.589157
+ 4.6527778 0.589759
+ 4.6555556 0.589157
+ 4.6583333 0.589157
+ 4.6611111 0.587952
+ 4.6638889 0.588554
+ 4.6666667 0.589759
+ 4.6694444 0.588554
+ 4.6722222 0.589157
+ 4.6750000 0.587349
+ 4.6777778 0.587349
+ 4.6805556 0.588554
+ 4.6833333 0.589759
+ 4.6861111 0.589759
+ 4.6888889 0.589759
+ 4.6916667 0.587349
+ 4.6944444 0.586747
+ 4.6972222 0.587349
+ 4.7000000 0.588554
+ 4.7027778 0.587952
+ 4.7055556 0.587952
+ 4.7083333 0.587349
+ 4.7111111 0.586747
+ 4.7138889 0.587349
+ 4.7166667 0.587952
+ 4.7194444 0.587952
+ 4.7222222 0.588554
+ 4.7250000 0.587952
+ 4.7277778 0.587349
+ 4.7305556 0.587952
+ 4.7333333 0.589157
+ 4.7361111 0.590361
+ 4.7388889 0.587952
+ 4.7416667 0.589157
+ 4.7444444 0.586747
+ 4.7472222 0.587349
+ 4.7500000 0.589759
+ 4.7527778 0.588554
+ 4.7555556 0.587349
+ 4.7583333 0.587349
+ 4.7611111 0.586747
+ 4.7638889 0.587349
+ 4.7666667 0.587349
+ 4.7694444 0.588554
+ 4.7722222 0.588554
+ 4.7750000 0.587349
+ 4.7777778 0.587349
+ 4.7805556 0.587952
+ 4.7833333 0.589157
+ 4.7861111 0.589157
+ 4.7888889 0.589157
+ 4.7916667 0.587349
+ 4.7944444 0.587349
+ 4.7972222 0.588554
+ 4.8000000 0.589157
+ 4.8027778 0.590361
+ 4.8055556 0.590361
+ 4.8083333 0.591566
+ 4.8111111 0.589157
+ 4.8138889 0.590964
+ 4.8166667 0.593976
+ 4.8194444 0.596386
+ 4.8222222 0.596386
+ 4.8250000 0.595783
+ 4.8277778 0.595181
+ 4.8305556 0.596386
+ 4.8333333 0.598795
+ 4.8361111 0.599398
+ 4.8388889 0.600000
+ 4.8416667 0.600602
+ 4.8444444 0.600602
+ 4.8472222 0.601205
+ 4.8500000 0.603012
+ 4.8527778 0.602410
+ 4.8555556 0.602410
+ 4.8583333 0.600000
+ 4.8611111 0.598795
+ 4.8638889 0.598193
+ 4.8666667 0.599398
+ 4.8694444 0.601205
+ 4.8722222 0.598193
+ 4.8750000 0.598193
+ 4.8777778 0.596988
+ 4.8805556 0.598795
+ 4.8833333 0.601807
+ 4.8861111 0.603012
+ 4.8888889 0.600602
+ 4.8916667 0.596386
+ 4.8944444 0.593976
+ 4.8972222 0.592771
+ 4.9000000 0.590964
+ 4.9027778 0.590361
+ 4.9055556 0.588554
+ 4.9083333 0.587349
+ 4.9111111 0.587952
+ 4.9138889 0.588554
+ 4.9166667 0.587349
+ 4.9194444 0.587349
+ 4.9222222 0.586747
+ 4.9250000 0.586145
+ 4.9277778 0.585542
+ 4.9305556 0.586145
+ 4.9333333 0.586747
+ 4.9361111 0.588554
+ 4.9388889 0.587952
+ 4.9416667 0.586747
+ 4.9444444 0.585542
+ 4.9472222 0.585542
+ 4.9500000 0.585542
+ 4.9527778 0.586747
+ 4.9555556 0.586145
+ 4.9583333 0.585542
+ 4.9611111 0.584337
+ 4.9638889 0.586145
+ 4.9666667 0.586145
+ 4.9694444 0.586145
+ 4.9722222 0.586145
+ 4.9750000 0.585542
+ 4.9777778 0.584337
+ 4.9805556 0.583133
+ 4.9833333 0.582530
+ 4.9861111 0.578313
+ 4.9888889 0.573494
+ 4.9916667 0.569277
+ 4.9944444 0.567470
+ 4.9972222 0.564458
+ 5.0000000 0.562651
+ 5.0027778 0.566265
+ 5.0055556 0.577108
+ 5.0083333 0.593373
+ 5.0111111 0.610843
+ 5.0138889 0.634940
+ 5.0166667 0.663253
+ 5.0194444 0.696988
+ 5.0222222 0.724699
+ 5.0250000 0.740964
+ 5.0277778 0.737952
+ 5.0305556 0.720482
+ 5.0333333 0.680723
+ 5.0361111 0.629518
+ 5.0388889 0.591566
+ 5.0416667 0.573494
+ 5.0444444 0.570482
+ 5.0472222 0.575904
+ 5.0500000 0.581325
+ 5.0527778 0.583735
+ 5.0555556 0.583735
+ 5.0583333 0.582530
+ 5.0611111 0.581325
+ 5.0638889 0.581325
+ 5.0666667 0.581928
+ 5.0694444 0.582530
+ 5.0722222 0.583133
+ 5.0750000 0.582530
+ 5.0777778 0.580723
+ 5.0805556 0.580723
+ 5.0833333 0.581928
+ 5.0861111 0.582530
+ 5.0888889 0.582530
+ 5.0916667 0.580723
+ 5.0944444 0.579518
+ 5.0972222 0.580723
+ 5.1000000 0.580723
+ 5.1027778 0.580120
+ 5.1055556 0.580723
+ 5.1083333 0.579518
+ 5.1111111 0.577711
+ 5.1138889 0.578916
+ 5.1166667 0.579518
+ 5.1194444 0.581325
+ 5.1222222 0.579518
+ 5.1250000 0.579518
+ 5.1277778 0.578916
+ 5.1305556 0.578916
+ 5.1333333 0.579518
+ 5.1361111 0.580120
+ 5.1388889 0.580120
+ 5.1416667 0.579518
+ 5.1444444 0.578313
+ 5.1472222 0.580120
+ 5.1500000 0.580723
+ 5.1527778 0.581928
+ 5.1555556 0.581928
+ 5.1583333 0.581325
+ 5.1611111 0.580120
+ 5.1638889 0.580723
+ 5.1666667 0.582530
+ 5.1694444 0.582530
+ 5.1722222 0.582530
+ 5.1750000 0.581928
+ 5.1777778 0.580723
+ 5.1805556 0.582530
+ 5.1833333 0.580120
+ 5.1861111 0.581928
+ 5.1888889 0.582530
+ 5.1916667 0.581325
+ 5.1944444 0.580120
+ 5.1972222 0.580120
+ 5.2000000 0.580723
+ 5.2027778 0.581928
+ 5.2055556 0.581928
+ 5.2083333 0.580723
+ 5.2111111 0.579518
+ 5.2138889 0.580120
+ 5.2166667 0.580723
+ 5.2194444 0.581928
+ 5.2222222 0.581325
+ 5.2250000 0.580723
+ 5.2277778 0.580120
+ 5.2305556 0.581325
+ 5.2333333 0.581325
+ 5.2361111 0.582530
+ 5.2388889 0.582530
+ 5.2416667 0.583133
+ 5.2444444 0.580120
+ 5.2472222 0.583133
+ 5.2500000 0.583133
+ 5.2527778 0.583735
+ 5.2555556 0.581928
+ 5.2583333 0.581325
+ 5.2611111 0.578916
+ 5.2638889 0.580120
+ 5.2666667 0.581928
+ 5.2694444 0.581928
+ 5.2722222 0.582530
+ 5.2750000 0.580723
+ 5.2777778 0.580120
+ 5.2805556 0.580120
+ 5.2833333 0.580120
+ 5.2861111 0.580120
+ 5.2888889 0.581928
+ 5.2916667 0.580723
+ 5.2944444 0.579518
+ 5.2972222 0.581325
+ 5.3000000 0.582530
+ 5.3027778 0.581928
+ 5.3055556 0.581928
+ 5.3083333 0.580120
+ 5.3111111 0.578313
+ 5.3138889 0.581928
+ 5.3166667 0.582530
+ 5.3194444 0.583735
+ 5.3222222 0.581928
+ 5.3250000 0.580723
+ 5.3277778 0.581325
+ 5.3305556 0.582530
+ 5.3333333 0.583735
+ 5.3361111 0.585542
+ 5.3388889 0.585542
+ 5.3416667 0.587349
+ 5.3444444 0.587349
+ 5.3472222 0.589157
+ 5.3500000 0.589759
+ 5.3527778 0.591566
+ 5.3555556 0.592771
+ 5.3583333 0.592771
+ 5.3611111 0.591566
+ 5.3638889 0.593373
+ 5.3666667 0.594578
+ 5.3694444 0.593373
+ 5.3722222 0.593373
+ 5.3750000 0.593373
+ 5.3777778 0.592169
+ 5.3805556 0.592169
+ 5.3833333 0.593373
+ 5.3861111 0.593976
+ 5.3888889 0.593373
+ 5.3916667 0.592771
+ 5.3944444 0.592169
+ 5.3972222 0.592169
+ 5.4000000 0.593373
+ 5.4027778 0.593373
+ 5.4055556 0.592771
+ 5.4083333 0.592169
+ 5.4111111 0.590964
+ 5.4138889 0.591566
+ 5.4166667 0.592771
+ 5.4194444 0.593373
+ 5.4222222 0.592771
+ 5.4250000 0.592771
+ 5.4277778 0.591566
+ 5.4305556 0.592771
+ 5.4333333 0.593373
+ 5.4361111 0.593976
+ 5.4388889 0.593373
+ 5.4416667 0.592169
+ 5.4444444 0.589759
+ 5.4472222 0.590361
+ 5.4500000 0.592771
+ 5.4527778 0.594578
+ 5.4555556 0.594578
+ 5.4583333 0.593976
+ 5.4611111 0.592771
+ 5.4638889 0.592771
+ 5.4666667 0.594578
+ 5.4694444 0.595181
+ 5.4722222 0.595181
+ 5.4750000 0.595181
+ 5.4777778 0.593373
+ 5.4805556 0.595181
+ 5.4833333 0.597590
+ 5.4861111 0.598795
+ 5.4888889 0.598795
+ 5.4916667 0.596988
+ 5.4944444 0.596988
+ 5.4972222 0.597590
+ 5.5000000 0.601205
+ 5.5027778 0.600602
+ 5.5055556 0.597590
+ 5.5083333 0.596386
+ 5.5111111 0.599398
+ 5.5138889 0.602410
+ 5.5166667 0.601807
+ 5.5194444 0.600602
+ 5.5222222 0.599398
+ 5.5250000 0.598193
+ 5.5277778 0.598193
+ 5.5305556 0.597590
+ 5.5333333 0.596988
+ 5.5361111 0.594578
+ 5.5388889 0.592771
+ 5.5416667 0.589157
+ 5.5444444 0.588554
+ 5.5472222 0.588554
+ 5.5500000 0.589759
+ 5.5527778 0.587349
+ 5.5555556 0.586145
+ 5.5583333 0.585542
+ 5.5611111 0.583735
+ 5.5638889 0.583133
+ 5.5666667 0.583735
+ 5.5694444 0.584940
+ 5.5722222 0.584337
+ 5.5750000 0.581928
+ 5.5777778 0.580723
+ 5.5805556 0.581928
+ 5.5833333 0.582530
+ 5.5861111 0.583133
+ 5.5888889 0.583133
+ 5.5916667 0.582530
+ 5.5944444 0.581325
+ 5.5972222 0.583735
+ 5.6000000 0.584940
+ 5.6027778 0.584337
+ 5.6055556 0.584337
+ 5.6083333 0.584940
+ 5.6111111 0.583133
+ 5.6138889 0.584940
+ 5.6166667 0.584940
+ 5.6194444 0.586145
+ 5.6222222 0.584337
+ 5.6250000 0.584940
+ 5.6277778 0.581928
+ 5.6305556 0.583133
+ 5.6333333 0.581928
+ 5.6361111 0.578916
+ 5.6388889 0.575301
+ 5.6416667 0.569880
+ 5.6444444 0.564458
+ 5.6472222 0.564458
+ 5.6500000 0.560843
+ 5.6527778 0.558434
+ 5.6555556 0.562048
+ 5.6583333 0.573494
+ 5.6611111 0.590361
+ 5.6638889 0.610241
+ 5.6666667 0.630120
+ 5.6694444 0.658434
+ 5.6722222 0.688554
+ 5.6750000 0.715663
+ 5.6777778 0.728916
+ 5.6805556 0.732530
+ 5.6833333 0.715663
+ 5.6861111 0.675301
+ 5.6888889 0.624096
+ 5.6916667 0.586747
+ 5.6944444 0.569277
+ 5.6972222 0.570482
+ 5.7000000 0.577108
+ 5.7027778 0.581928
+ 5.7055556 0.583133
+ 5.7083333 0.580723
+ 5.7111111 0.578916
+ 5.7138889 0.581325
+ 5.7166667 0.580120
+ 5.7194444 0.581928
+ 5.7222222 0.580723
+ 5.7250000 0.579518
+ 5.7277778 0.578313
+ 5.7305556 0.580120
+ 5.7333333 0.581325
+ 5.7361111 0.580723
+ 5.7388889 0.580723
+ 5.7416667 0.579518
+ 5.7444444 0.578916
+ 5.7472222 0.578313
+ 5.7500000 0.578916
+ 5.7527778 0.580120
+ 5.7555556 0.580120
+ 5.7583333 0.579518
+ 5.7611111 0.578916
+ 5.7638889 0.580120
+ 5.7666667 0.580723
+ 5.7694444 0.580120
+ 5.7722222 0.580723
+ 5.7750000 0.577711
+ 5.7777778 0.576506
+ 5.7805556 0.578313
+ 5.7833333 0.577711
+ 5.7861111 0.580120
+ 5.7888889 0.580120
+ 5.7916667 0.580120
+ 5.7944444 0.578916
+ 5.7972222 0.578916
+ 5.8000000 0.580120
+ 5.8027778 0.581928
+ 5.8055556 0.581325
+ 5.8083333 0.579518
+ 5.8111111 0.578916
+ 5.8138889 0.580120
+ 5.8166667 0.578916
+ 5.8194444 0.580120
+ 5.8222222 0.579518
+ 5.8250000 0.577711
+ 5.8277778 0.577108
+ 5.8305556 0.578313
+ 5.8333333 0.580723
+ 5.8361111 0.580723
+ 5.8388889 0.581325
+ 5.8416667 0.578916
+ 5.8444444 0.578916
+ 5.8472222 0.579518
+ 5.8500000 0.580120
+ 5.8527778 0.581325
+ 5.8555556 0.581928
+ 5.8583333 0.579518
+ 5.8611111 0.579518
+ 5.8638889 0.580723
+ 5.8666667 0.581325
+ 5.8694444 0.581928
+ 5.8722222 0.580723
+ 5.8750000 0.580120
+ 5.8777778 0.578916
+ 5.8805556 0.578916
+ 5.8833333 0.580723
+ 5.8861111 0.581325
+ 5.8888889 0.579518
+ 5.8916667 0.580120
+ 5.8944444 0.578916
+ 5.8972222 0.579518
+ 5.9000000 0.580723
+ 5.9027778 0.581325
+ 5.9055556 0.580723
+ 5.9083333 0.579518
+ 5.9111111 0.578313
+ 5.9138889 0.578916
+ 5.9166667 0.580120
+ 5.9194444 0.581325
+ 5.9222222 0.581325
+ 5.9250000 0.580723
+ 5.9277778 0.578313
+ 5.9305556 0.579518
+ 5.9333333 0.578916
+ 5.9361111 0.580120
+ 5.9388889 0.578916
+ 5.9416667 0.578313
+ 5.9444444 0.575904
+ 5.9472222 0.576506
+ 5.9500000 0.578313
+ 5.9527778 0.578916
+ 5.9555556 0.578313
+ 5.9583333 0.578313
+ 5.9611111 0.577108
+ 5.9638889 0.578916
+ 5.9666667 0.580120
+ 5.9694444 0.581325
+ 5.9722222 0.580723
+ 5.9750000 0.579518
+ 5.9777778 0.578313
+ 5.9805556 0.580120
+ 5.9833333 0.582530
+ 5.9861111 0.582530
+ 5.9888889 0.582530
+ 5.9916667 0.580723
+ 5.9944444 0.582530
+ 5.9972222 0.584337
+ 6.0000000 0.585542
+ 6.0027778 0.586145
+ 6.0055556 0.586747
+ 6.0083333 0.586145
+ 6.0111111 0.584337
+ 6.0138889 0.586747
+ 6.0166667 0.587952
+ 6.0194444 0.589759
+ 6.0222222 0.590361
+ 6.0250000 0.590361
+ 6.0277778 0.588554
+ 6.0305556 0.589157
+ 6.0333333 0.589759
+ 6.0361111 0.590361
+ 6.0388889 0.590361
+ 6.0416667 0.587349
+ 6.0444444 0.587952
+ 6.0472222 0.585542
+ 6.0500000 0.587952
+ 6.0527778 0.589157
+ 6.0555556 0.589157
+ 6.0583333 0.590361
+ 6.0611111 0.589759
+ 6.0638889 0.589759
+ 6.0666667 0.590964
+ 6.0694444 0.590361
+ 6.0722222 0.590361
+ 6.0750000 0.589157
+ 6.0777778 0.588554
+ 6.0805556 0.587952
+ 6.0833333 0.589157
+ 6.0861111 0.590361
+ 6.0888889 0.589157
+ 6.0916667 0.587952
+ 6.0944444 0.587952
+ 6.0972222 0.587349
+ 6.1000000 0.589157
+ 6.1027778 0.589157
+ 6.1055556 0.589759
+ 6.1083333 0.587349
+ 6.1111111 0.586145
+ 6.1138889 0.586747
+ 6.1166667 0.587349
+ 6.1194444 0.585542
+ 6.1222222 0.584337
+ 6.1250000 0.583133
+ 6.1277778 0.582530
+ 6.1305556 0.585542
+ 6.1333333 0.586145
+ 6.1361111 0.586145
+ 6.1388889 0.585542
+ 6.1416667 0.583735
+ 6.1444444 0.583133
+ 6.1472222 0.583735
+ 6.1500000 0.583735
+ 6.1527778 0.585542
+ 6.1555556 0.584337
+ 6.1583333 0.583133
+ 6.1611111 0.584940
+ 6.1638889 0.583735
+ 6.1666667 0.584940
+ 6.1694444 0.586145
+ 6.1722222 0.585542
+ 6.1750000 0.584337
+ 6.1777778 0.582530
+ 6.1805556 0.584940
+ 6.1833333 0.584940
+ 6.1861111 0.584940
+ 6.1888889 0.585542
+ 6.1916667 0.584940
+ 6.1944444 0.584337
+ 6.1972222 0.583735
+ 6.2000000 0.585542
+ 6.2027778 0.584337
+ 6.2055556 0.584940
+ 6.2083333 0.583735
+ 6.2111111 0.582530
+ 6.2138889 0.584337
+ 6.2166667 0.584337
+ 6.2194444 0.584940
+ 6.2222222 0.584337
+ 6.2250000 0.583735
+ 6.2277778 0.580120
+ 6.2305556 0.580723
+ 6.2333333 0.583735
+ 6.2361111 0.583735
+ 6.2388889 0.582530
+ 6.2416667 0.582530
+ 6.2444444 0.580120
+ 6.2472222 0.581928
+ 6.2500000 0.582530
+ 6.2527778 0.584940
+ 6.2555556 0.586145
+ 6.2583333 0.585542
+ 6.2611111 0.583735
+ 6.2638889 0.583735
+ 6.2666667 0.584940
+ 6.2694444 0.584940
+ 6.2722222 0.586747
+ 6.2750000 0.583735
+ 6.2777778 0.583133
+ 6.2805556 0.583133
+ 6.2833333 0.583735
+ 6.2861111 0.583735
+ 6.2888889 0.583133
+ 6.2916667 0.581928
+ 6.2944444 0.580723
+ 6.2972222 0.580723
+ 6.3000000 0.583133
+ 6.3027778 0.582530
+ 6.3055556 0.581928
+ 6.3083333 0.582530
+ 6.3111111 0.581928
+ 6.3138889 0.583133
+ 6.3166667 0.584337
+ 6.3194444 0.584337
+ 6.3222222 0.583735
+ 6.3250000 0.583133
+ 6.3277778 0.582530
+ 6.3305556 0.583735
+ 6.3333333 0.584940
+ 6.3361111 0.586145
+ 6.3388889 0.585542
+ 6.3416667 0.586145
+ 6.3444444 0.584940
+ 6.3472222 0.585542
+ 6.3500000 0.584940
+ 6.3527778 0.583735
+ 6.3555556 0.584940
+ 6.3583333 0.583735
+ 6.3611111 0.582530
+ 6.3638889 0.583735
+ 6.3666667 0.583735
+ 6.3694444 0.584337
+ 6.3722222 0.583735
+ 6.3750000 0.581928
+ 6.3777778 0.581928
+ 6.3805556 0.582530
+ 6.3833333 0.584940
+ 6.3861111 0.584337
+ 6.3888889 0.583735
+ 6.3916667 0.583133
+ 6.3944444 0.581928
+ 6.3972222 0.582530
+ 6.4000000 0.583133
+ 6.4027778 0.583735
+ 6.4055556 0.584337
+ 6.4083333 0.583735
+ 6.4111111 0.583735
+ 6.4138889 0.584940
+ 6.4166667 0.586145
+ 6.4194444 0.585542
+ 6.4222222 0.585542
+ 6.4250000 0.584337
+ 6.4277778 0.583735
+ 6.4305556 0.583735
+ 6.4333333 0.583133
+ 6.4361111 0.585542
+ 6.4388889 0.584337
+ 6.4416667 0.584940
+ 6.4444444 0.583735
+ 6.4472222 0.584337
+ 6.4500000 0.583735
+ 6.4527778 0.585542
+ 6.4555556 0.586747
+ 6.4583333 0.587349
+ 6.4611111 0.587349
+ 6.4638889 0.589759
+ 6.4666667 0.590361
+ 6.4694444 0.590964
+ 6.4722222 0.590361
+ 6.4750000 0.591566
+ 6.4777778 0.590361
+ 6.4805556 0.592771
+ 6.4833333 0.593976
+ 6.4861111 0.595181
+ 6.4888889 0.596386
+ 6.4916667 0.596386
+ 6.4944444 0.595783
+ 6.4972222 0.595181
+ 6.5000000 0.596386
+ 6.5027778 0.596386
+ 6.5055556 0.595783
+ 6.5083333 0.593373
+ 6.5111111 0.592169
+ 6.5138889 0.593373
+ 6.5166667 0.594578
+ 6.5194444 0.596386
+ 6.5222222 0.593976
+ 6.5250000 0.592169
+ 6.5277778 0.588554
+ 6.5305556 0.590964
+ 6.5333333 0.591566
+ 6.5361111 0.594578
+ 6.5388889 0.595181
+ 6.5416667 0.594578
+ 6.5444444 0.592771
+ 6.5472222 0.590964
+ 6.5500000 0.589759
+ 6.5527778 0.589157
+ 6.5555556 0.588554
+ 6.5583333 0.584940
+ 6.5611111 0.582530
+ 6.5638889 0.583133
+ 6.5666667 0.583133
+ 6.5694444 0.583133
+ 6.5722222 0.582530
+ 6.5750000 0.582530
+ 6.5777778 0.582530
+ 6.5805556 0.581325
+ 6.5833333 0.583735
+ 6.5861111 0.581928
+ 6.5888889 0.581928
+ 6.5916667 0.578916
+ 6.5944444 0.576506
+ 6.5972222 0.578313
+ 6.6000000 0.578916
+ 6.6027778 0.580723
+ 6.6055556 0.581325
+ 6.6083333 0.578916
+ 6.6111111 0.577108
+ 6.6138889 0.578313
+ 6.6166667 0.579518
+ 6.6194444 0.579518
+ 6.6222222 0.579518
+ 6.6250000 0.577711
+ 6.6277778 0.575301
+ 6.6305556 0.574096
+ 6.6333333 0.572289
+ 6.6361111 0.568072
+ 6.6388889 0.568675
+ 6.6416667 0.564458
+ 6.6444444 0.558434
+ 6.6472222 0.557831
+ 6.6500000 0.563855
+ 6.6527778 0.576506
+ 6.6555556 0.590361
+ 6.6583333 0.604217
+ 6.6611111 0.624699
+ 6.6638889 0.653614
+ 6.6666667 0.685542
+ 6.6694444 0.713253
+ 6.6722222 0.728916
+ 6.6750000 0.733735
+ 6.6777778 0.722289
+ 6.6805556 0.694578
+ 6.6833333 0.654217
+ 6.6861111 0.618675
+ 6.6888889 0.592771
+ 6.6916667 0.575904
+ 6.6944444 0.566867
+ 6.6972222 0.560843
+ 6.7000000 0.562651
+ 6.7027778 0.566867
+ 6.7055556 0.571084
+ 6.7083333 0.572892
+ 6.7111111 0.572892
+ 6.7138889 0.574699
+ 6.7166667 0.576506
+ 6.7194444 0.577711
+ 6.7222222 0.577711
+ 6.7250000 0.577108
+ 6.7277778 0.576506
+ 6.7305556 0.575904
+ 6.7333333 0.576506
+ 6.7361111 0.575301
+ 6.7388889 0.575301
+ 6.7416667 0.574096
+ 6.7444444 0.572892
+ 6.7472222 0.572892
+ 6.7500000 0.575301
+ 6.7527778 0.575301
+ 6.7555556 0.575301
+ 6.7583333 0.573494
+ 6.7611111 0.573494
+ 6.7638889 0.574096
+ 6.7666667 0.575904
+ 6.7694444 0.575301
+ 6.7722222 0.575301
+ 6.7750000 0.575904
+ 6.7777778 0.573494
+ 6.7805556 0.573494
+ 6.7833333 0.575301
+ 6.7861111 0.574699
+ 6.7888889 0.574699
+ 6.7916667 0.573494
+ 6.7944444 0.573494
+ 6.7972222 0.574699
+ 6.8000000 0.575301
+ 6.8027778 0.575904
+ 6.8055556 0.575301
+ 6.8083333 0.575301
+ 6.8111111 0.574096
+ 6.8138889 0.576506
+ 6.8166667 0.575301
+ 6.8194444 0.575904
+ 6.8222222 0.575301
+ 6.8250000 0.574096
+ 6.8277778 0.574096
+ 6.8305556 0.575301
+ 6.8333333 0.575301
+ 6.8361111 0.577108
+ 6.8388889 0.575904
+ 6.8416667 0.575301
+ 6.8444444 0.572289
+ 6.8472222 0.573494
+ 6.8500000 0.573494
+ 6.8527778 0.575301
+ 6.8555556 0.575301
+ 6.8583333 0.574096
+ 6.8611111 0.574096
+ 6.8638889 0.574699
+ 6.8666667 0.575301
+ 6.8694444 0.577108
+ 6.8722222 0.577108
+ 6.8750000 0.575904
+ 6.8777778 0.575904
+ 6.8805556 0.576506
+ 6.8833333 0.578313
+ 6.8861111 0.578313
+ 6.8888889 0.577108
+ 6.8916667 0.577108
+ 6.8944444 0.575904
+ 6.8972222 0.575301
+ 6.9000000 0.578313
+ 6.9027778 0.578313
+ 6.9055556 0.578313
+ 6.9083333 0.578313
+ 6.9111111 0.575301
+ 6.9138889 0.577108
+ 6.9166667 0.577711
+ 6.9194444 0.577108
+ 6.9222222 0.575301
+ 6.9250000 0.573494
+ 6.9277778 0.571084
+ 6.9305556 0.571687
+ 6.9333333 0.572892
+ 6.9361111 0.572289
+ 6.9388889 0.571687
+ 6.9416667 0.571084
+ 6.9444444 0.568675
+ 6.9472222 0.567470
+ 6.9500000 0.569880
+ 6.9527778 0.568072
+ 6.9555556 0.566867
+ 6.9583333 0.567470
+ 6.9611111 0.565060
+ 6.9638889 0.566867
+ 6.9666667 0.568675
+ 6.9694444 0.568072
+ 6.9722222 0.568675
+ 6.9750000 0.566867
+ 6.9777778 0.566867
+ 6.9805556 0.568072
+ 6.9833333 0.569277
+ 6.9861111 0.571687
+ 6.9888889 0.571687
+ 6.9916667 0.570482
+ 6.9944444 0.571084
+ 6.9972222 0.574096
+ 7.0000000 0.575301
+ 7.0027778 0.575904
+ 7.0055556 0.577711
+ 7.0083333 0.577711
+ 7.0111111 0.578916
+ 7.0138889 0.580120
+ 7.0166667 0.581325
+ 7.0194444 0.584337
+ 7.0222222 0.584940
+ 7.0250000 0.584337
+ 7.0277778 0.584940
+ 7.0305556 0.586145
+ 7.0333333 0.587349
+ 7.0361111 0.587952
+ 7.0388889 0.590361
+ 7.0416667 0.588554
+ 7.0444444 0.589157
+ 7.0472222 0.590361
+ 7.0500000 0.590964
+ 7.0527778 0.590361
+ 7.0555556 0.590361
+ 7.0583333 0.589759
+ 7.0611111 0.587349
+ 7.0638889 0.589759
+ 7.0666667 0.589157
+ 7.0694444 0.589157
+ 7.0722222 0.588554
+ 7.0750000 0.587952
+ 7.0777778 0.587952
+ 7.0805556 0.587952
+ 7.0833333 0.589759
+ 7.0861111 0.589759
+ 7.0888889 0.589157
+ 7.0916667 0.587952
+ 7.0944444 0.587349
+ 7.0972222 0.587952
+ 7.1000000 0.587952
+ 7.1027778 0.589157
+ 7.1055556 0.588554
+ 7.1083333 0.587349
+ 7.1111111 0.586747
+ 7.1138889 0.587349
+ 7.1166667 0.589157
+ 7.1194444 0.588554
+ 7.1222222 0.588554
+ 7.1250000 0.586747
+ 7.1277778 0.586747
+ 7.1305556 0.587952
+ 7.1333333 0.587952
+ 7.1361111 0.588554
+ 7.1388889 0.588554
+ 7.1416667 0.587952
+ 7.1444444 0.584940
+ 7.1472222 0.585542
+ 7.1500000 0.585542
+ 7.1527778 0.586747
+ 7.1555556 0.585542
+ 7.1583333 0.584337
+ 7.1611111 0.584337
+ 7.1638889 0.584337
+ 7.1666667 0.585542
+ 7.1694444 0.586747
+ )

* === ARM SIGNAL (simulated rpeak_level_held) ===
Varm arm_signal 0 PWL(
+ 0 0
+ 1.0246778 0
+ 1.0247778 0.9
+ 1.1077778 0.9
+ 1.1078778 0
+ 1.8357889 0
+ 1.8358889 0.9
+ 1.9188889 0.9
+ 1.9189889 0
+ 2.6246778 0
+ 2.6247778 0.9
+ 2.7077778 0.9
+ 2.7078778 0
+ 3.4163444 0
+ 3.4164444 0.9
+ 3.4994444 0.9
+ 3.4995444 0
+ 4.2052333 0
+ 4.2053333 0.9
+ 4.2883333 0.9
+ 4.2884333 0
+ 5.0219000 0
+ 5.0220000 0.9
+ 5.1050000 0.9
+ 5.1051000 0
+ 5.6746778 0
+ 5.6747778 0.9
+ 5.7577778 0.9
+ 5.7578778 0
+ 6.6691222 0
+ 6.6692222 0.9
+ 6.7522222 0.9
+ 6.7523222 0
+ 7.1722222 0
+ )

* === DEVICE UNDER TEST ===
Xtpd ecg_in arm_signal peak_detected vdd vss vbias true_peak_detector
.ic V(xtpd.peak_hold)=0.58

* === MEASUREMENTS ===
.meas tran t_det_0 WHEN V(peak_detected)=0.45 RISE=1
.meas tran lat_0 PARAM='t_det_0 - 1.0277778'
.meas tran v_hold_0 FIND V(xtpd.peak_hold) AT=1.0277778
.meas tran v_ecg_0 FIND V(ecg_in) AT=1.0277778
.meas tran t_det_1 WHEN V(peak_detected)=0.45 RISE=2
.meas tran lat_1 PARAM='t_det_1 - 1.8388889'
.meas tran v_hold_1 FIND V(xtpd.peak_hold) AT=1.8388889
.meas tran v_ecg_1 FIND V(ecg_in) AT=1.8388889
.meas tran t_det_2 WHEN V(peak_detected)=0.45 RISE=3
.meas tran lat_2 PARAM='t_det_2 - 2.6277778'
.meas tran v_hold_2 FIND V(xtpd.peak_hold) AT=2.6277778
.meas tran v_ecg_2 FIND V(ecg_in) AT=2.6277778
.meas tran t_det_3 WHEN V(peak_detected)=0.45 RISE=4
.meas tran lat_3 PARAM='t_det_3 - 3.4194444'
.meas tran v_hold_3 FIND V(xtpd.peak_hold) AT=3.4194444
.meas tran v_ecg_3 FIND V(ecg_in) AT=3.4194444
.meas tran t_det_4 WHEN V(peak_detected)=0.45 RISE=5
.meas tran lat_4 PARAM='t_det_4 - 4.2083333'
.meas tran v_hold_4 FIND V(xtpd.peak_hold) AT=4.2083333
.meas tran v_ecg_4 FIND V(ecg_in) AT=4.2083333
.meas tran t_det_5 WHEN V(peak_detected)=0.45 RISE=6
.meas tran lat_5 PARAM='t_det_5 - 5.0250000'
.meas tran v_hold_5 FIND V(xtpd.peak_hold) AT=5.0250000
.meas tran v_ecg_5 FIND V(ecg_in) AT=5.0250000
.meas tran t_det_6 WHEN V(peak_detected)=0.45 RISE=7
.meas tran lat_6 PARAM='t_det_6 - 5.6777778'
.meas tran v_hold_6 FIND V(xtpd.peak_hold) AT=5.6777778
.meas tran v_ecg_6 FIND V(ecg_in) AT=5.6777778
.meas tran t_det_7 WHEN V(peak_detected)=0.45 RISE=8
.meas tran lat_7 PARAM='t_det_7 - 6.6722222'
.meas tran v_hold_7 FIND V(xtpd.peak_hold) AT=6.6722222
.meas tran v_ecg_7 FIND V(ecg_in) AT=6.6722222

.tran 10u 7.1722 UIC

.include "C:\Users\kadhi\OneDrive\Desktop\amux\verilogLearning\Leaky-Integrate-Fire---SNN-model-on-FPGA\experiments\frontend_optimization\complete_frontend/true_peak_detector.spice"
.include "C:\Users\kadhi\OneDrive\Desktop\amux\verilogLearning\Leaky-Integrate-Fire---SNN-model-on-FPGA\experiments\frontend_optimization\complete_frontend/bias_gen.spice"
.include "C:\Users\kadhi\OneDrive\Desktop\amux\verilogLearning\Leaky-Integrate-Fire---SNN-model-on-FPGA\experiments\frontend_optimization\complete_frontend/inverter.spice"

.control
run
wrdata _tb_tpd_results.txt V(ecg_in) V(xtpd.peak_hold) V(peak_detected) V(xtpd.track_level) V(xtpd.charge_en) V(arm_signal)
print t_det_0 lat_0 v_hold_0 v_ecg_0
print t_det_1 lat_1 v_hold_1 v_ecg_1
print t_det_2 lat_2 v_hold_2 v_ecg_2
print t_det_3 lat_3 v_hold_3 v_ecg_3
print t_det_4 lat_4 v_hold_4 v_ecg_4
print t_det_5 lat_5 v_hold_5 v_ecg_5
print t_det_6 lat_6 v_hold_6 v_ecg_6
print t_det_7 lat_7 v_hold_7 v_ecg_7
quit
.endc

.end
