.title delay_chain_test
.lib "C:/Users/kadhi/OneDrive/Desktop/amux/verilogLearning/Leaky-Integrate-Fire---SNN-model-on-FPGA/experiments/frontend_optimization/ngspice_frontend/sky130_minimal.lib.spice" tt
.option scale=1.0u method=gear reltol=0.01 gmin=1e-15
.temp 27

Vdd vdd 0 0.9
Vss vss 0 0
Vbias vbias 0 0.300

* rpeak_raw: simulates rpeak_detector output
* HIGH during QRS (100-110ms), LOW otherwise
Vrpk rpeak_raw 0 PWL(0 0 0.098 0 0.100 0.9 0.110 0.9 0.1105 0 0.6 0)

.include "C:/Users/kadhi/OneDrive/Desktop/amux/verilogLearning/Leaky-Integrate-Fire---SNN-model-on-FPGA/experiments/frontend_optimization/complete_frontend/inverter.spice"
.include "C:/Users/kadhi/OneDrive/Desktop/amux/verilogLearning/Leaky-Integrate-Fire---SNN-model-on-FPGA/experiments/frontend_optimization/complete_frontend/delay_timer.spice"
.include "C:/Users/kadhi/OneDrive/Desktop/amux/verilogLearning/Leaky-Integrate-Fire---SNN-model-on-FPGA/experiments/frontend_optimization/complete_frontend/pulse_gen.spice"

* === DELAY TIMER ===
* Thresholds calibrated from measured SF curves
Vth1 vth_14 0 0.482670
Vth2 vth_69 0 0.453987
Vth3 vth_28 0 0.475366
Vth4 vth_300 0 0.335569
Vth5 vth_10 0 0.478144

Xdelay rpeak_raw dt_s14_lev dt_s69_lev dt_wid_lev dt_bi_lev dt_rr_copy_lev vdd vss vbias vth_14 vth_69 vth_28 vth_300 vth_10 delay_timer

* === INVERTER BUFFERS (sharpen slow comparator edges) ===
Xinv_s14a dt_s14_lev dt_s14_buf1 vdd vss inverter_sub
Xinv_s14b dt_s14_buf1 dt_s14_buf vdd vss inverter_sub
Xinv_s69a dt_s69_lev dt_s69_buf1 vdd vss inverter_sub
Xinv_s69b dt_s69_buf1 dt_s69_buf vdd vss inverter_sub
Xinv_wida dt_wid_lev dt_wid_buf1 vdd vss inverter_sub
Xinv_widb dt_wid_buf1 dt_wid_buf vdd vss inverter_sub
Xinv_bia  dt_bi_lev  dt_bi_buf1 vdd vss inverter_sub
Xinv_bib  dt_bi_buf1 dt_bi_buf vdd vss inverter_sub
Xinv_rrca dt_rr_copy_lev dt_rrc_buf1 vdd vss inverter_sub
Xinv_rrcb dt_rrc_buf1 dt_rrc_buf vdd vss inverter_sub

* === PULSE GENERATORS (convert level transitions to 0.5ms pulses) ===
Xpg_s14 dt_s14_buf trig_s14 vdd vss vbias pulse_gen
Xpg_s69 dt_s69_buf trig_s69 vdd vss vbias pulse_gen
Xpg_wid dt_wid_buf trig_wid vdd vss vbias pulse_gen
Xpg_bi  dt_bi_buf  trig_bi_copy vdd vss vbias pulse_gen
Xpg_rrc dt_rrc_buf trig_rr_copy vdd vss vbias pulse_gen

.tran 0.05m 0.6

* === MEASUREMENTS ===

* 1. SF timer discharge curve (relative to rpk_drop at 110ms)
.meas tran sf_main_000ms FIND V(xdelay.sf_timer) AT=0.110000
.meas tran sf_main_001ms FIND V(xdelay.sf_timer) AT=0.111000
.meas tran sf_main_002ms FIND V(xdelay.sf_timer) AT=0.112000
.meas tran sf_main_005ms FIND V(xdelay.sf_timer) AT=0.115000
.meas tran sf_main_010ms FIND V(xdelay.sf_timer) AT=0.120000
.meas tran sf_main_015ms FIND V(xdelay.sf_timer) AT=0.125000
.meas tran sf_main_020ms FIND V(xdelay.sf_timer) AT=0.130000
.meas tran sf_main_030ms FIND V(xdelay.sf_timer) AT=0.140000
.meas tran sf_main_050ms FIND V(xdelay.sf_timer) AT=0.160000
.meas tran sf_main_070ms FIND V(xdelay.sf_timer) AT=0.180000
.meas tran sf_main_100ms FIND V(xdelay.sf_timer) AT=0.210000
.meas tran sf_main_150ms FIND V(xdelay.sf_timer) AT=0.260000
.meas tran sf_main_200ms FIND V(xdelay.sf_timer) AT=0.310000
.meas tran sf_main_300ms FIND V(xdelay.sf_timer) AT=0.410000
.meas tran sf_main_400ms FIND V(xdelay.sf_timer) AT=0.510000
.meas tran sf_fast_000ms FIND V(xdelay.sf_timer2) AT=0.110000
.meas tran sf_fast_001ms FIND V(xdelay.sf_timer2) AT=0.111000
.meas tran sf_fast_002ms FIND V(xdelay.sf_timer2) AT=0.112000
.meas tran sf_fast_003ms FIND V(xdelay.sf_timer2) AT=0.113000
.meas tran sf_fast_005ms FIND V(xdelay.sf_timer2) AT=0.115000
.meas tran sf_fast_008ms FIND V(xdelay.sf_timer2) AT=0.118000
.meas tran sf_fast_010ms FIND V(xdelay.sf_timer2) AT=0.120000
.meas tran sf_fast_015ms FIND V(xdelay.sf_timer2) AT=0.125000
.meas tran sf_fast_020ms FIND V(xdelay.sf_timer2) AT=0.130000

* 2. TRIGGER PULSE TIMING (0.5ms resolution)
.meas tran trig_rrc_000 FIND V(trig_rr_copy) AT=0.1100000
.meas tran trig_rrc_001 FIND V(trig_rr_copy) AT=0.1101000
.meas tran trig_rrc_002 FIND V(trig_rr_copy) AT=0.1102000
.meas tran trig_rrc_003 FIND V(trig_rr_copy) AT=0.1103000
.meas tran trig_rrc_004 FIND V(trig_rr_copy) AT=0.1104000
.meas tran trig_rrc_005 FIND V(trig_rr_copy) AT=0.1105000
.meas tran trig_rrc_006 FIND V(trig_rr_copy) AT=0.1106000
.meas tran trig_rrc_007 FIND V(trig_rr_copy) AT=0.1107000
.meas tran trig_rrc_008 FIND V(trig_rr_copy) AT=0.1108000
.meas tran trig_rrc_009 FIND V(trig_rr_copy) AT=0.1109000
.meas tran trig_rrc_010 FIND V(trig_rr_copy) AT=0.1110000
.meas tran trig_rrc_011 FIND V(trig_rr_copy) AT=0.1111000
.meas tran trig_rrc_012 FIND V(trig_rr_copy) AT=0.1112000
.meas tran trig_rrc_013 FIND V(trig_rr_copy) AT=0.1113000
.meas tran trig_rrc_014 FIND V(trig_rr_copy) AT=0.1114000
.meas tran trig_rrc_015 FIND V(trig_rr_copy) AT=0.1115000
.meas tran trig_rrc_016 FIND V(trig_rr_copy) AT=0.1116000
.meas tran trig_rrc_017 FIND V(trig_rr_copy) AT=0.1117000
.meas tran trig_rrc_018 FIND V(trig_rr_copy) AT=0.1118000
.meas tran trig_rrc_019 FIND V(trig_rr_copy) AT=0.1119000
.meas tran trig_rrc_020 FIND V(trig_rr_copy) AT=0.1120000
.meas tran trig_rrc_021 FIND V(trig_rr_copy) AT=0.1121000
.meas tran trig_rrc_022 FIND V(trig_rr_copy) AT=0.1122000
.meas tran trig_rrc_023 FIND V(trig_rr_copy) AT=0.1123000
.meas tran trig_rrc_024 FIND V(trig_rr_copy) AT=0.1124000
.meas tran trig_rrc_025 FIND V(trig_rr_copy) AT=0.1125000
.meas tran trig_rrc_026 FIND V(trig_rr_copy) AT=0.1126000
.meas tran trig_rrc_027 FIND V(trig_rr_copy) AT=0.1127000
.meas tran trig_rrc_028 FIND V(trig_rr_copy) AT=0.1128000
.meas tran trig_rrc_029 FIND V(trig_rr_copy) AT=0.1129000
.meas tran trig_rrc_030 FIND V(trig_rr_copy) AT=0.1130000
.meas tran trig_rrc_031 FIND V(trig_rr_copy) AT=0.1131000
.meas tran trig_rrc_032 FIND V(trig_rr_copy) AT=0.1132000
.meas tran trig_rrc_033 FIND V(trig_rr_copy) AT=0.1133000
.meas tran trig_rrc_034 FIND V(trig_rr_copy) AT=0.1134000
.meas tran trig_rrc_035 FIND V(trig_rr_copy) AT=0.1135000
.meas tran trig_rrc_036 FIND V(trig_rr_copy) AT=0.1136000
.meas tran trig_rrc_037 FIND V(trig_rr_copy) AT=0.1137000
.meas tran trig_rrc_038 FIND V(trig_rr_copy) AT=0.1138000
.meas tran trig_rrc_039 FIND V(trig_rr_copy) AT=0.1139000
.meas tran trig_s14_000 FIND V(trig_s14) AT=0.1100000
.meas tran trig_s14_001 FIND V(trig_s14) AT=0.1101000
.meas tran trig_s14_002 FIND V(trig_s14) AT=0.1102000
.meas tran trig_s14_003 FIND V(trig_s14) AT=0.1103000
.meas tran trig_s14_004 FIND V(trig_s14) AT=0.1104000
.meas tran trig_s14_005 FIND V(trig_s14) AT=0.1105000
.meas tran trig_s14_006 FIND V(trig_s14) AT=0.1106000
.meas tran trig_s14_007 FIND V(trig_s14) AT=0.1107000
.meas tran trig_s14_008 FIND V(trig_s14) AT=0.1108000
.meas tran trig_s14_009 FIND V(trig_s14) AT=0.1109000
.meas tran trig_s14_010 FIND V(trig_s14) AT=0.1110000
.meas tran trig_s14_011 FIND V(trig_s14) AT=0.1111000
.meas tran trig_s14_012 FIND V(trig_s14) AT=0.1112000
.meas tran trig_s14_013 FIND V(trig_s14) AT=0.1113000
.meas tran trig_s14_014 FIND V(trig_s14) AT=0.1114000
.meas tran trig_s14_015 FIND V(trig_s14) AT=0.1115000
.meas tran trig_s14_016 FIND V(trig_s14) AT=0.1116000
.meas tran trig_s14_017 FIND V(trig_s14) AT=0.1117000
.meas tran trig_s14_018 FIND V(trig_s14) AT=0.1118000
.meas tran trig_s14_019 FIND V(trig_s14) AT=0.1119000
.meas tran trig_s14_020 FIND V(trig_s14) AT=0.1120000
.meas tran trig_s14_021 FIND V(trig_s14) AT=0.1121000
.meas tran trig_s14_022 FIND V(trig_s14) AT=0.1122000
.meas tran trig_s14_023 FIND V(trig_s14) AT=0.1123000
.meas tran trig_s14_024 FIND V(trig_s14) AT=0.1124000
.meas tran trig_s14_025 FIND V(trig_s14) AT=0.1125000
.meas tran trig_s14_026 FIND V(trig_s14) AT=0.1126000
.meas tran trig_s14_027 FIND V(trig_s14) AT=0.1127000
.meas tran trig_s14_028 FIND V(trig_s14) AT=0.1128000
.meas tran trig_s14_029 FIND V(trig_s14) AT=0.1129000
.meas tran trig_s14_030 FIND V(trig_s14) AT=0.1130000
.meas tran trig_s14_031 FIND V(trig_s14) AT=0.1131000
.meas tran trig_s14_032 FIND V(trig_s14) AT=0.1132000
.meas tran trig_s14_033 FIND V(trig_s14) AT=0.1133000
.meas tran trig_s14_034 FIND V(trig_s14) AT=0.1134000
.meas tran trig_s14_035 FIND V(trig_s14) AT=0.1135000
.meas tran trig_s14_036 FIND V(trig_s14) AT=0.1136000
.meas tran trig_s14_037 FIND V(trig_s14) AT=0.1137000
.meas tran trig_s14_038 FIND V(trig_s14) AT=0.1138000
.meas tran trig_s14_039 FIND V(trig_s14) AT=0.1139000
.meas tran trig_s14_040 FIND V(trig_s14) AT=0.1140000
.meas tran trig_s14_041 FIND V(trig_s14) AT=0.1141000
.meas tran trig_s14_042 FIND V(trig_s14) AT=0.1142000
.meas tran trig_s14_043 FIND V(trig_s14) AT=0.1143000
.meas tran trig_s14_044 FIND V(trig_s14) AT=0.1144000
.meas tran trig_s14_045 FIND V(trig_s14) AT=0.1145000
.meas tran trig_s14_046 FIND V(trig_s14) AT=0.1146000
.meas tran trig_s14_047 FIND V(trig_s14) AT=0.1147000
.meas tran trig_s14_048 FIND V(trig_s14) AT=0.1148000
.meas tran trig_s14_049 FIND V(trig_s14) AT=0.1149000
.meas tran trig_s14_050 FIND V(trig_s14) AT=0.1150000
.meas tran trig_s14_051 FIND V(trig_s14) AT=0.1151000
.meas tran trig_s14_052 FIND V(trig_s14) AT=0.1152000
.meas tran trig_s14_053 FIND V(trig_s14) AT=0.1153000
.meas tran trig_s14_054 FIND V(trig_s14) AT=0.1154000
.meas tran trig_s14_055 FIND V(trig_s14) AT=0.1155000
.meas tran trig_s14_056 FIND V(trig_s14) AT=0.1156000
.meas tran trig_s14_057 FIND V(trig_s14) AT=0.1157000
.meas tran trig_s14_058 FIND V(trig_s14) AT=0.1158000
.meas tran trig_s14_059 FIND V(trig_s14) AT=0.1159000
.meas tran trig_s14_060 FIND V(trig_s14) AT=0.1160000
.meas tran trig_s14_061 FIND V(trig_s14) AT=0.1161000
.meas tran trig_s14_062 FIND V(trig_s14) AT=0.1162000
.meas tran trig_s14_063 FIND V(trig_s14) AT=0.1163000
.meas tran trig_s14_064 FIND V(trig_s14) AT=0.1164000
.meas tran trig_s14_065 FIND V(trig_s14) AT=0.1165000
.meas tran trig_s14_066 FIND V(trig_s14) AT=0.1166000
.meas tran trig_s14_067 FIND V(trig_s14) AT=0.1167000
.meas tran trig_s14_068 FIND V(trig_s14) AT=0.1168000
.meas tran trig_s14_069 FIND V(trig_s14) AT=0.1169000
.meas tran trig_s14_070 FIND V(trig_s14) AT=0.1170000
.meas tran trig_s14_071 FIND V(trig_s14) AT=0.1171000
.meas tran trig_s14_072 FIND V(trig_s14) AT=0.1172000
.meas tran trig_s14_073 FIND V(trig_s14) AT=0.1173000
.meas tran trig_s14_074 FIND V(trig_s14) AT=0.1174000
.meas tran trig_s14_075 FIND V(trig_s14) AT=0.1175000
.meas tran trig_s14_076 FIND V(trig_s14) AT=0.1176000
.meas tran trig_s14_077 FIND V(trig_s14) AT=0.1177000
.meas tran trig_s14_078 FIND V(trig_s14) AT=0.1178000
.meas tran trig_s14_079 FIND V(trig_s14) AT=0.1179000
.meas tran trig_s14_080 FIND V(trig_s14) AT=0.1180000
.meas tran trig_s14_081 FIND V(trig_s14) AT=0.1181000
.meas tran trig_s14_082 FIND V(trig_s14) AT=0.1182000
.meas tran trig_s14_083 FIND V(trig_s14) AT=0.1183000
.meas tran trig_s14_084 FIND V(trig_s14) AT=0.1184000
.meas tran trig_s14_085 FIND V(trig_s14) AT=0.1185000
.meas tran trig_s14_086 FIND V(trig_s14) AT=0.1186000
.meas tran trig_s14_087 FIND V(trig_s14) AT=0.1187000
.meas tran trig_s14_088 FIND V(trig_s14) AT=0.1188000
.meas tran trig_s14_089 FIND V(trig_s14) AT=0.1189000
.meas tran trig_s14_090 FIND V(trig_s14) AT=0.1190000
.meas tran trig_s14_091 FIND V(trig_s14) AT=0.1191000
.meas tran trig_s14_092 FIND V(trig_s14) AT=0.1192000
.meas tran trig_s14_093 FIND V(trig_s14) AT=0.1193000
.meas tran trig_s14_094 FIND V(trig_s14) AT=0.1194000
.meas tran trig_s14_095 FIND V(trig_s14) AT=0.1195000
.meas tran trig_s14_096 FIND V(trig_s14) AT=0.1196000
.meas tran trig_s14_097 FIND V(trig_s14) AT=0.1197000
.meas tran trig_s14_098 FIND V(trig_s14) AT=0.1198000
.meas tran trig_s14_099 FIND V(trig_s14) AT=0.1199000
.meas tran trig_s14_100 FIND V(trig_s14) AT=0.1200000
.meas tran trig_s14_101 FIND V(trig_s14) AT=0.1201000
.meas tran trig_s14_102 FIND V(trig_s14) AT=0.1202000
.meas tran trig_s14_103 FIND V(trig_s14) AT=0.1203000
.meas tran trig_s14_104 FIND V(trig_s14) AT=0.1204000
.meas tran trig_s14_105 FIND V(trig_s14) AT=0.1205000
.meas tran trig_s14_106 FIND V(trig_s14) AT=0.1206000
.meas tran trig_s14_107 FIND V(trig_s14) AT=0.1207000
.meas tran trig_s14_108 FIND V(trig_s14) AT=0.1208000
.meas tran trig_s14_109 FIND V(trig_s14) AT=0.1209000
.meas tran trig_s14_110 FIND V(trig_s14) AT=0.1210000
.meas tran trig_s14_111 FIND V(trig_s14) AT=0.1211000
.meas tran trig_s14_112 FIND V(trig_s14) AT=0.1212000
.meas tran trig_s14_113 FIND V(trig_s14) AT=0.1213000
.meas tran trig_s14_114 FIND V(trig_s14) AT=0.1214000
.meas tran trig_s14_115 FIND V(trig_s14) AT=0.1215000
.meas tran trig_s14_116 FIND V(trig_s14) AT=0.1216000
.meas tran trig_s14_117 FIND V(trig_s14) AT=0.1217000
.meas tran trig_s14_118 FIND V(trig_s14) AT=0.1218000
.meas tran trig_s14_119 FIND V(trig_s14) AT=0.1219000
.meas tran trig_wid_100 FIND V(trig_wid) AT=0.1200000
.meas tran trig_wid_101 FIND V(trig_wid) AT=0.1201000
.meas tran trig_wid_102 FIND V(trig_wid) AT=0.1202000
.meas tran trig_wid_103 FIND V(trig_wid) AT=0.1203000
.meas tran trig_wid_104 FIND V(trig_wid) AT=0.1204000
.meas tran trig_wid_105 FIND V(trig_wid) AT=0.1205000
.meas tran trig_wid_106 FIND V(trig_wid) AT=0.1206000
.meas tran trig_wid_107 FIND V(trig_wid) AT=0.1207000
.meas tran trig_wid_108 FIND V(trig_wid) AT=0.1208000
.meas tran trig_wid_109 FIND V(trig_wid) AT=0.1209000
.meas tran trig_wid_110 FIND V(trig_wid) AT=0.1210000
.meas tran trig_wid_111 FIND V(trig_wid) AT=0.1211000
.meas tran trig_wid_112 FIND V(trig_wid) AT=0.1212000
.meas tran trig_wid_113 FIND V(trig_wid) AT=0.1213000
.meas tran trig_wid_114 FIND V(trig_wid) AT=0.1214000
.meas tran trig_wid_115 FIND V(trig_wid) AT=0.1215000
.meas tran trig_wid_116 FIND V(trig_wid) AT=0.1216000
.meas tran trig_wid_117 FIND V(trig_wid) AT=0.1217000
.meas tran trig_wid_118 FIND V(trig_wid) AT=0.1218000
.meas tran trig_wid_119 FIND V(trig_wid) AT=0.1219000
.meas tran trig_wid_120 FIND V(trig_wid) AT=0.1220000
.meas tran trig_wid_121 FIND V(trig_wid) AT=0.1221000
.meas tran trig_wid_122 FIND V(trig_wid) AT=0.1222000
.meas tran trig_wid_123 FIND V(trig_wid) AT=0.1223000
.meas tran trig_wid_124 FIND V(trig_wid) AT=0.1224000
.meas tran trig_wid_125 FIND V(trig_wid) AT=0.1225000
.meas tran trig_wid_126 FIND V(trig_wid) AT=0.1226000
.meas tran trig_wid_127 FIND V(trig_wid) AT=0.1227000
.meas tran trig_wid_128 FIND V(trig_wid) AT=0.1228000
.meas tran trig_wid_129 FIND V(trig_wid) AT=0.1229000
.meas tran trig_wid_130 FIND V(trig_wid) AT=0.1230000
.meas tran trig_wid_131 FIND V(trig_wid) AT=0.1231000
.meas tran trig_wid_132 FIND V(trig_wid) AT=0.1232000
.meas tran trig_wid_133 FIND V(trig_wid) AT=0.1233000
.meas tran trig_wid_134 FIND V(trig_wid) AT=0.1234000
.meas tran trig_wid_135 FIND V(trig_wid) AT=0.1235000
.meas tran trig_wid_136 FIND V(trig_wid) AT=0.1236000
.meas tran trig_wid_137 FIND V(trig_wid) AT=0.1237000
.meas tran trig_wid_138 FIND V(trig_wid) AT=0.1238000
.meas tran trig_wid_139 FIND V(trig_wid) AT=0.1239000
.meas tran trig_wid_140 FIND V(trig_wid) AT=0.1240000
.meas tran trig_wid_141 FIND V(trig_wid) AT=0.1241000
.meas tran trig_wid_142 FIND V(trig_wid) AT=0.1242000
.meas tran trig_wid_143 FIND V(trig_wid) AT=0.1243000
.meas tran trig_wid_144 FIND V(trig_wid) AT=0.1244000
.meas tran trig_wid_145 FIND V(trig_wid) AT=0.1245000
.meas tran trig_wid_146 FIND V(trig_wid) AT=0.1246000
.meas tran trig_wid_147 FIND V(trig_wid) AT=0.1247000
.meas tran trig_wid_148 FIND V(trig_wid) AT=0.1248000
.meas tran trig_wid_149 FIND V(trig_wid) AT=0.1249000
.meas tran trig_wid_150 FIND V(trig_wid) AT=0.1250000
.meas tran trig_wid_151 FIND V(trig_wid) AT=0.1251000
.meas tran trig_wid_152 FIND V(trig_wid) AT=0.1252000
.meas tran trig_wid_153 FIND V(trig_wid) AT=0.1253000
.meas tran trig_wid_154 FIND V(trig_wid) AT=0.1254000
.meas tran trig_wid_155 FIND V(trig_wid) AT=0.1255000
.meas tran trig_wid_156 FIND V(trig_wid) AT=0.1256000
.meas tran trig_wid_157 FIND V(trig_wid) AT=0.1257000
.meas tran trig_wid_158 FIND V(trig_wid) AT=0.1258000
.meas tran trig_wid_159 FIND V(trig_wid) AT=0.1259000
.meas tran trig_wid_160 FIND V(trig_wid) AT=0.1260000
.meas tran trig_wid_161 FIND V(trig_wid) AT=0.1261000
.meas tran trig_wid_162 FIND V(trig_wid) AT=0.1262000
.meas tran trig_wid_163 FIND V(trig_wid) AT=0.1263000
.meas tran trig_wid_164 FIND V(trig_wid) AT=0.1264000
.meas tran trig_wid_165 FIND V(trig_wid) AT=0.1265000
.meas tran trig_wid_166 FIND V(trig_wid) AT=0.1266000
.meas tran trig_wid_167 FIND V(trig_wid) AT=0.1267000
.meas tran trig_wid_168 FIND V(trig_wid) AT=0.1268000
.meas tran trig_wid_169 FIND V(trig_wid) AT=0.1269000
.meas tran trig_wid_170 FIND V(trig_wid) AT=0.1270000
.meas tran trig_wid_171 FIND V(trig_wid) AT=0.1271000
.meas tran trig_wid_172 FIND V(trig_wid) AT=0.1272000
.meas tran trig_wid_173 FIND V(trig_wid) AT=0.1273000
.meas tran trig_wid_174 FIND V(trig_wid) AT=0.1274000
.meas tran trig_wid_175 FIND V(trig_wid) AT=0.1275000
.meas tran trig_wid_176 FIND V(trig_wid) AT=0.1276000
.meas tran trig_wid_177 FIND V(trig_wid) AT=0.1277000
.meas tran trig_wid_178 FIND V(trig_wid) AT=0.1278000
.meas tran trig_wid_179 FIND V(trig_wid) AT=0.1279000
.meas tran trig_wid_180 FIND V(trig_wid) AT=0.1280000
.meas tran trig_wid_181 FIND V(trig_wid) AT=0.1281000
.meas tran trig_wid_182 FIND V(trig_wid) AT=0.1282000
.meas tran trig_wid_183 FIND V(trig_wid) AT=0.1283000
.meas tran trig_wid_184 FIND V(trig_wid) AT=0.1284000
.meas tran trig_wid_185 FIND V(trig_wid) AT=0.1285000
.meas tran trig_wid_186 FIND V(trig_wid) AT=0.1286000
.meas tran trig_wid_187 FIND V(trig_wid) AT=0.1287000
.meas tran trig_wid_188 FIND V(trig_wid) AT=0.1288000
.meas tran trig_wid_189 FIND V(trig_wid) AT=0.1289000
.meas tran trig_wid_190 FIND V(trig_wid) AT=0.1290000
.meas tran trig_wid_191 FIND V(trig_wid) AT=0.1291000
.meas tran trig_wid_192 FIND V(trig_wid) AT=0.1292000
.meas tran trig_wid_193 FIND V(trig_wid) AT=0.1293000
.meas tran trig_wid_194 FIND V(trig_wid) AT=0.1294000
.meas tran trig_wid_195 FIND V(trig_wid) AT=0.1295000
.meas tran trig_wid_196 FIND V(trig_wid) AT=0.1296000
.meas tran trig_wid_197 FIND V(trig_wid) AT=0.1297000
.meas tran trig_wid_198 FIND V(trig_wid) AT=0.1298000
.meas tran trig_wid_199 FIND V(trig_wid) AT=0.1299000
.meas tran trig_wid_200 FIND V(trig_wid) AT=0.1300000
.meas tran trig_wid_201 FIND V(trig_wid) AT=0.1301000
.meas tran trig_wid_202 FIND V(trig_wid) AT=0.1302000
.meas tran trig_wid_203 FIND V(trig_wid) AT=0.1303000
.meas tran trig_wid_204 FIND V(trig_wid) AT=0.1304000
.meas tran trig_wid_205 FIND V(trig_wid) AT=0.1305000
.meas tran trig_wid_206 FIND V(trig_wid) AT=0.1306000
.meas tran trig_wid_207 FIND V(trig_wid) AT=0.1307000
.meas tran trig_wid_208 FIND V(trig_wid) AT=0.1308000
.meas tran trig_wid_209 FIND V(trig_wid) AT=0.1309000
.meas tran trig_wid_210 FIND V(trig_wid) AT=0.1310000
.meas tran trig_wid_211 FIND V(trig_wid) AT=0.1311000
.meas tran trig_wid_212 FIND V(trig_wid) AT=0.1312000
.meas tran trig_wid_213 FIND V(trig_wid) AT=0.1313000
.meas tran trig_wid_214 FIND V(trig_wid) AT=0.1314000
.meas tran trig_wid_215 FIND V(trig_wid) AT=0.1315000
.meas tran trig_wid_216 FIND V(trig_wid) AT=0.1316000
.meas tran trig_wid_217 FIND V(trig_wid) AT=0.1317000
.meas tran trig_wid_218 FIND V(trig_wid) AT=0.1318000
.meas tran trig_wid_219 FIND V(trig_wid) AT=0.1319000
.meas tran trig_wid_220 FIND V(trig_wid) AT=0.1320000
.meas tran trig_wid_221 FIND V(trig_wid) AT=0.1321000
.meas tran trig_wid_222 FIND V(trig_wid) AT=0.1322000
.meas tran trig_wid_223 FIND V(trig_wid) AT=0.1323000
.meas tran trig_wid_224 FIND V(trig_wid) AT=0.1324000
.meas tran trig_wid_225 FIND V(trig_wid) AT=0.1325000
.meas tran trig_wid_226 FIND V(trig_wid) AT=0.1326000
.meas tran trig_wid_227 FIND V(trig_wid) AT=0.1327000
.meas tran trig_wid_228 FIND V(trig_wid) AT=0.1328000
.meas tran trig_wid_229 FIND V(trig_wid) AT=0.1329000
.meas tran trig_wid_230 FIND V(trig_wid) AT=0.1330000
.meas tran trig_wid_231 FIND V(trig_wid) AT=0.1331000
.meas tran trig_wid_232 FIND V(trig_wid) AT=0.1332000
.meas tran trig_wid_233 FIND V(trig_wid) AT=0.1333000
.meas tran trig_wid_234 FIND V(trig_wid) AT=0.1334000
.meas tran trig_wid_235 FIND V(trig_wid) AT=0.1335000
.meas tran trig_wid_236 FIND V(trig_wid) AT=0.1336000
.meas tran trig_wid_237 FIND V(trig_wid) AT=0.1337000
.meas tran trig_wid_238 FIND V(trig_wid) AT=0.1338000
.meas tran trig_wid_239 FIND V(trig_wid) AT=0.1339000
.meas tran trig_wid_240 FIND V(trig_wid) AT=0.1340000
.meas tran trig_wid_241 FIND V(trig_wid) AT=0.1341000
.meas tran trig_wid_242 FIND V(trig_wid) AT=0.1342000
.meas tran trig_wid_243 FIND V(trig_wid) AT=0.1343000
.meas tran trig_wid_244 FIND V(trig_wid) AT=0.1344000
.meas tran trig_wid_245 FIND V(trig_wid) AT=0.1345000
.meas tran trig_wid_246 FIND V(trig_wid) AT=0.1346000
.meas tran trig_wid_247 FIND V(trig_wid) AT=0.1347000
.meas tran trig_wid_248 FIND V(trig_wid) AT=0.1348000
.meas tran trig_wid_249 FIND V(trig_wid) AT=0.1349000
.meas tran trig_wid_250 FIND V(trig_wid) AT=0.1350000
.meas tran trig_wid_251 FIND V(trig_wid) AT=0.1351000
.meas tran trig_wid_252 FIND V(trig_wid) AT=0.1352000
.meas tran trig_wid_253 FIND V(trig_wid) AT=0.1353000
.meas tran trig_wid_254 FIND V(trig_wid) AT=0.1354000
.meas tran trig_wid_255 FIND V(trig_wid) AT=0.1355000
.meas tran trig_wid_256 FIND V(trig_wid) AT=0.1356000
.meas tran trig_wid_257 FIND V(trig_wid) AT=0.1357000
.meas tran trig_wid_258 FIND V(trig_wid) AT=0.1358000
.meas tran trig_wid_259 FIND V(trig_wid) AT=0.1359000
.meas tran trig_wid_260 FIND V(trig_wid) AT=0.1360000
.meas tran trig_wid_261 FIND V(trig_wid) AT=0.1361000
.meas tran trig_wid_262 FIND V(trig_wid) AT=0.1362000
.meas tran trig_wid_263 FIND V(trig_wid) AT=0.1363000
.meas tran trig_wid_264 FIND V(trig_wid) AT=0.1364000
.meas tran trig_wid_265 FIND V(trig_wid) AT=0.1365000
.meas tran trig_wid_266 FIND V(trig_wid) AT=0.1366000
.meas tran trig_wid_267 FIND V(trig_wid) AT=0.1367000
.meas tran trig_wid_268 FIND V(trig_wid) AT=0.1368000
.meas tran trig_wid_269 FIND V(trig_wid) AT=0.1369000
.meas tran trig_wid_270 FIND V(trig_wid) AT=0.1370000
.meas tran trig_wid_271 FIND V(trig_wid) AT=0.1371000
.meas tran trig_wid_272 FIND V(trig_wid) AT=0.1372000
.meas tran trig_wid_273 FIND V(trig_wid) AT=0.1373000
.meas tran trig_wid_274 FIND V(trig_wid) AT=0.1374000
.meas tran trig_wid_275 FIND V(trig_wid) AT=0.1375000
.meas tran trig_wid_276 FIND V(trig_wid) AT=0.1376000
.meas tran trig_wid_277 FIND V(trig_wid) AT=0.1377000
.meas tran trig_wid_278 FIND V(trig_wid) AT=0.1378000
.meas tran trig_wid_279 FIND V(trig_wid) AT=0.1379000
.meas tran trig_wid_280 FIND V(trig_wid) AT=0.1380000
.meas tran trig_wid_281 FIND V(trig_wid) AT=0.1381000
.meas tran trig_wid_282 FIND V(trig_wid) AT=0.1382000
.meas tran trig_wid_283 FIND V(trig_wid) AT=0.1383000
.meas tran trig_wid_284 FIND V(trig_wid) AT=0.1384000
.meas tran trig_wid_285 FIND V(trig_wid) AT=0.1385000
.meas tran trig_wid_286 FIND V(trig_wid) AT=0.1386000
.meas tran trig_wid_287 FIND V(trig_wid) AT=0.1387000
.meas tran trig_wid_288 FIND V(trig_wid) AT=0.1388000
.meas tran trig_wid_289 FIND V(trig_wid) AT=0.1389000
.meas tran trig_wid_290 FIND V(trig_wid) AT=0.1390000
.meas tran trig_wid_291 FIND V(trig_wid) AT=0.1391000
.meas tran trig_wid_292 FIND V(trig_wid) AT=0.1392000
.meas tran trig_wid_293 FIND V(trig_wid) AT=0.1393000
.meas tran trig_wid_294 FIND V(trig_wid) AT=0.1394000
.meas tran trig_wid_295 FIND V(trig_wid) AT=0.1395000
.meas tran trig_wid_296 FIND V(trig_wid) AT=0.1396000
.meas tran trig_wid_297 FIND V(trig_wid) AT=0.1397000
.meas tran trig_wid_298 FIND V(trig_wid) AT=0.1398000
.meas tran trig_wid_299 FIND V(trig_wid) AT=0.1399000
.meas tran trig_s69_500 FIND V(trig_s69) AT=0.1600000
.meas tran trig_s69_501 FIND V(trig_s69) AT=0.1601000
.meas tran trig_s69_502 FIND V(trig_s69) AT=0.1602000
.meas tran trig_s69_503 FIND V(trig_s69) AT=0.1603000
.meas tran trig_s69_504 FIND V(trig_s69) AT=0.1604000
.meas tran trig_s69_505 FIND V(trig_s69) AT=0.1605000
.meas tran trig_s69_506 FIND V(trig_s69) AT=0.1606000
.meas tran trig_s69_507 FIND V(trig_s69) AT=0.1607000
.meas tran trig_s69_508 FIND V(trig_s69) AT=0.1608000
.meas tran trig_s69_509 FIND V(trig_s69) AT=0.1609000
.meas tran trig_s69_510 FIND V(trig_s69) AT=0.1610000
.meas tran trig_s69_511 FIND V(trig_s69) AT=0.1611000
.meas tran trig_s69_512 FIND V(trig_s69) AT=0.1612000
.meas tran trig_s69_513 FIND V(trig_s69) AT=0.1613000
.meas tran trig_s69_514 FIND V(trig_s69) AT=0.1614000
.meas tran trig_s69_515 FIND V(trig_s69) AT=0.1615000
.meas tran trig_s69_516 FIND V(trig_s69) AT=0.1616000
.meas tran trig_s69_517 FIND V(trig_s69) AT=0.1617000
.meas tran trig_s69_518 FIND V(trig_s69) AT=0.1618000
.meas tran trig_s69_519 FIND V(trig_s69) AT=0.1619000
.meas tran trig_s69_520 FIND V(trig_s69) AT=0.1620000
.meas tran trig_s69_521 FIND V(trig_s69) AT=0.1621000
.meas tran trig_s69_522 FIND V(trig_s69) AT=0.1622000
.meas tran trig_s69_523 FIND V(trig_s69) AT=0.1623000
.meas tran trig_s69_524 FIND V(trig_s69) AT=0.1624000
.meas tran trig_s69_525 FIND V(trig_s69) AT=0.1625000
.meas tran trig_s69_526 FIND V(trig_s69) AT=0.1626000
.meas tran trig_s69_527 FIND V(trig_s69) AT=0.1627000
.meas tran trig_s69_528 FIND V(trig_s69) AT=0.1628000
.meas tran trig_s69_529 FIND V(trig_s69) AT=0.1629000
.meas tran trig_s69_530 FIND V(trig_s69) AT=0.1630000
.meas tran trig_s69_531 FIND V(trig_s69) AT=0.1631000
.meas tran trig_s69_532 FIND V(trig_s69) AT=0.1632000
.meas tran trig_s69_533 FIND V(trig_s69) AT=0.1633000
.meas tran trig_s69_534 FIND V(trig_s69) AT=0.1634000
.meas tran trig_s69_535 FIND V(trig_s69) AT=0.1635000
.meas tran trig_s69_536 FIND V(trig_s69) AT=0.1636000
.meas tran trig_s69_537 FIND V(trig_s69) AT=0.1637000
.meas tran trig_s69_538 FIND V(trig_s69) AT=0.1638000
.meas tran trig_s69_539 FIND V(trig_s69) AT=0.1639000
.meas tran trig_s69_540 FIND V(trig_s69) AT=0.1640000
.meas tran trig_s69_541 FIND V(trig_s69) AT=0.1641000
.meas tran trig_s69_542 FIND V(trig_s69) AT=0.1642000
.meas tran trig_s69_543 FIND V(trig_s69) AT=0.1643000
.meas tran trig_s69_544 FIND V(trig_s69) AT=0.1644000
.meas tran trig_s69_545 FIND V(trig_s69) AT=0.1645000
.meas tran trig_s69_546 FIND V(trig_s69) AT=0.1646000
.meas tran trig_s69_547 FIND V(trig_s69) AT=0.1647000
.meas tran trig_s69_548 FIND V(trig_s69) AT=0.1648000
.meas tran trig_s69_549 FIND V(trig_s69) AT=0.1649000
.meas tran trig_s69_550 FIND V(trig_s69) AT=0.1650000
.meas tran trig_s69_551 FIND V(trig_s69) AT=0.1651000
.meas tran trig_s69_552 FIND V(trig_s69) AT=0.1652000
.meas tran trig_s69_553 FIND V(trig_s69) AT=0.1653000
.meas tran trig_s69_554 FIND V(trig_s69) AT=0.1654000
.meas tran trig_s69_555 FIND V(trig_s69) AT=0.1655000
.meas tran trig_s69_556 FIND V(trig_s69) AT=0.1656000
.meas tran trig_s69_557 FIND V(trig_s69) AT=0.1657000
.meas tran trig_s69_558 FIND V(trig_s69) AT=0.1658000
.meas tran trig_s69_559 FIND V(trig_s69) AT=0.1659000
.meas tran trig_s69_560 FIND V(trig_s69) AT=0.1660000
.meas tran trig_s69_561 FIND V(trig_s69) AT=0.1661000
.meas tran trig_s69_562 FIND V(trig_s69) AT=0.1662000
.meas tran trig_s69_563 FIND V(trig_s69) AT=0.1663000
.meas tran trig_s69_564 FIND V(trig_s69) AT=0.1664000
.meas tran trig_s69_565 FIND V(trig_s69) AT=0.1665000
.meas tran trig_s69_566 FIND V(trig_s69) AT=0.1666000
.meas tran trig_s69_567 FIND V(trig_s69) AT=0.1667000
.meas tran trig_s69_568 FIND V(trig_s69) AT=0.1668000
.meas tran trig_s69_569 FIND V(trig_s69) AT=0.1669000
.meas tran trig_s69_570 FIND V(trig_s69) AT=0.1670000
.meas tran trig_s69_571 FIND V(trig_s69) AT=0.1671000
.meas tran trig_s69_572 FIND V(trig_s69) AT=0.1672000
.meas tran trig_s69_573 FIND V(trig_s69) AT=0.1673000
.meas tran trig_s69_574 FIND V(trig_s69) AT=0.1674000
.meas tran trig_s69_575 FIND V(trig_s69) AT=0.1675000
.meas tran trig_s69_576 FIND V(trig_s69) AT=0.1676000
.meas tran trig_s69_577 FIND V(trig_s69) AT=0.1677000
.meas tran trig_s69_578 FIND V(trig_s69) AT=0.1678000
.meas tran trig_s69_579 FIND V(trig_s69) AT=0.1679000
.meas tran trig_s69_580 FIND V(trig_s69) AT=0.1680000
.meas tran trig_s69_581 FIND V(trig_s69) AT=0.1681000
.meas tran trig_s69_582 FIND V(trig_s69) AT=0.1682000
.meas tran trig_s69_583 FIND V(trig_s69) AT=0.1683000
.meas tran trig_s69_584 FIND V(trig_s69) AT=0.1684000
.meas tran trig_s69_585 FIND V(trig_s69) AT=0.1685000
.meas tran trig_s69_586 FIND V(trig_s69) AT=0.1686000
.meas tran trig_s69_587 FIND V(trig_s69) AT=0.1687000
.meas tran trig_s69_588 FIND V(trig_s69) AT=0.1688000
.meas tran trig_s69_589 FIND V(trig_s69) AT=0.1689000
.meas tran trig_s69_590 FIND V(trig_s69) AT=0.1690000
.meas tran trig_s69_591 FIND V(trig_s69) AT=0.1691000
.meas tran trig_s69_592 FIND V(trig_s69) AT=0.1692000
.meas tran trig_s69_593 FIND V(trig_s69) AT=0.1693000
.meas tran trig_s69_594 FIND V(trig_s69) AT=0.1694000
.meas tran trig_s69_595 FIND V(trig_s69) AT=0.1695000
.meas tran trig_s69_596 FIND V(trig_s69) AT=0.1696000
.meas tran trig_s69_597 FIND V(trig_s69) AT=0.1697000
.meas tran trig_s69_598 FIND V(trig_s69) AT=0.1698000
.meas tran trig_s69_599 FIND V(trig_s69) AT=0.1699000
.meas tran trig_s69_600 FIND V(trig_s69) AT=0.1700000
.meas tran trig_s69_601 FIND V(trig_s69) AT=0.1701000
.meas tran trig_s69_602 FIND V(trig_s69) AT=0.1702000
.meas tran trig_s69_603 FIND V(trig_s69) AT=0.1703000
.meas tran trig_s69_604 FIND V(trig_s69) AT=0.1704000
.meas tran trig_s69_605 FIND V(trig_s69) AT=0.1705000
.meas tran trig_s69_606 FIND V(trig_s69) AT=0.1706000
.meas tran trig_s69_607 FIND V(trig_s69) AT=0.1707000
.meas tran trig_s69_608 FIND V(trig_s69) AT=0.1708000
.meas tran trig_s69_609 FIND V(trig_s69) AT=0.1709000
.meas tran trig_s69_610 FIND V(trig_s69) AT=0.1710000
.meas tran trig_s69_611 FIND V(trig_s69) AT=0.1711000
.meas tran trig_s69_612 FIND V(trig_s69) AT=0.1712000
.meas tran trig_s69_613 FIND V(trig_s69) AT=0.1713000
.meas tran trig_s69_614 FIND V(trig_s69) AT=0.1714000
.meas tran trig_s69_615 FIND V(trig_s69) AT=0.1715000
.meas tran trig_s69_616 FIND V(trig_s69) AT=0.1716000
.meas tran trig_s69_617 FIND V(trig_s69) AT=0.1717000
.meas tran trig_s69_618 FIND V(trig_s69) AT=0.1718000
.meas tran trig_s69_619 FIND V(trig_s69) AT=0.1719000
.meas tran trig_s69_620 FIND V(trig_s69) AT=0.1720000
.meas tran trig_s69_621 FIND V(trig_s69) AT=0.1721000
.meas tran trig_s69_622 FIND V(trig_s69) AT=0.1722000
.meas tran trig_s69_623 FIND V(trig_s69) AT=0.1723000
.meas tran trig_s69_624 FIND V(trig_s69) AT=0.1724000
.meas tran trig_s69_625 FIND V(trig_s69) AT=0.1725000
.meas tran trig_s69_626 FIND V(trig_s69) AT=0.1726000
.meas tran trig_s69_627 FIND V(trig_s69) AT=0.1727000
.meas tran trig_s69_628 FIND V(trig_s69) AT=0.1728000
.meas tran trig_s69_629 FIND V(trig_s69) AT=0.1729000
.meas tran trig_s69_630 FIND V(trig_s69) AT=0.1730000
.meas tran trig_s69_631 FIND V(trig_s69) AT=0.1731000
.meas tran trig_s69_632 FIND V(trig_s69) AT=0.1732000
.meas tran trig_s69_633 FIND V(trig_s69) AT=0.1733000
.meas tran trig_s69_634 FIND V(trig_s69) AT=0.1734000
.meas tran trig_s69_635 FIND V(trig_s69) AT=0.1735000
.meas tran trig_s69_636 FIND V(trig_s69) AT=0.1736000
.meas tran trig_s69_637 FIND V(trig_s69) AT=0.1737000
.meas tran trig_s69_638 FIND V(trig_s69) AT=0.1738000
.meas tran trig_s69_639 FIND V(trig_s69) AT=0.1739000
.meas tran trig_s69_640 FIND V(trig_s69) AT=0.1740000
.meas tran trig_s69_641 FIND V(trig_s69) AT=0.1741000
.meas tran trig_s69_642 FIND V(trig_s69) AT=0.1742000
.meas tran trig_s69_643 FIND V(trig_s69) AT=0.1743000
.meas tran trig_s69_644 FIND V(trig_s69) AT=0.1744000
.meas tran trig_s69_645 FIND V(trig_s69) AT=0.1745000
.meas tran trig_s69_646 FIND V(trig_s69) AT=0.1746000
.meas tran trig_s69_647 FIND V(trig_s69) AT=0.1747000
.meas tran trig_s69_648 FIND V(trig_s69) AT=0.1748000
.meas tran trig_s69_649 FIND V(trig_s69) AT=0.1749000
.meas tran trig_s69_650 FIND V(trig_s69) AT=0.1750000
.meas tran trig_s69_651 FIND V(trig_s69) AT=0.1751000
.meas tran trig_s69_652 FIND V(trig_s69) AT=0.1752000
.meas tran trig_s69_653 FIND V(trig_s69) AT=0.1753000
.meas tran trig_s69_654 FIND V(trig_s69) AT=0.1754000
.meas tran trig_s69_655 FIND V(trig_s69) AT=0.1755000
.meas tran trig_s69_656 FIND V(trig_s69) AT=0.1756000
.meas tran trig_s69_657 FIND V(trig_s69) AT=0.1757000
.meas tran trig_s69_658 FIND V(trig_s69) AT=0.1758000
.meas tran trig_s69_659 FIND V(trig_s69) AT=0.1759000
.meas tran trig_s69_660 FIND V(trig_s69) AT=0.1760000
.meas tran trig_s69_661 FIND V(trig_s69) AT=0.1761000
.meas tran trig_s69_662 FIND V(trig_s69) AT=0.1762000
.meas tran trig_s69_663 FIND V(trig_s69) AT=0.1763000
.meas tran trig_s69_664 FIND V(trig_s69) AT=0.1764000
.meas tran trig_s69_665 FIND V(trig_s69) AT=0.1765000
.meas tran trig_s69_666 FIND V(trig_s69) AT=0.1766000
.meas tran trig_s69_667 FIND V(trig_s69) AT=0.1767000
.meas tran trig_s69_668 FIND V(trig_s69) AT=0.1768000
.meas tran trig_s69_669 FIND V(trig_s69) AT=0.1769000
.meas tran trig_s69_670 FIND V(trig_s69) AT=0.1770000
.meas tran trig_s69_671 FIND V(trig_s69) AT=0.1771000
.meas tran trig_s69_672 FIND V(trig_s69) AT=0.1772000
.meas tran trig_s69_673 FIND V(trig_s69) AT=0.1773000
.meas tran trig_s69_674 FIND V(trig_s69) AT=0.1774000
.meas tran trig_s69_675 FIND V(trig_s69) AT=0.1775000
.meas tran trig_s69_676 FIND V(trig_s69) AT=0.1776000
.meas tran trig_s69_677 FIND V(trig_s69) AT=0.1777000
.meas tran trig_s69_678 FIND V(trig_s69) AT=0.1778000
.meas tran trig_s69_679 FIND V(trig_s69) AT=0.1779000
.meas tran trig_s69_680 FIND V(trig_s69) AT=0.1780000
.meas tran trig_s69_681 FIND V(trig_s69) AT=0.1781000
.meas tran trig_s69_682 FIND V(trig_s69) AT=0.1782000
.meas tran trig_s69_683 FIND V(trig_s69) AT=0.1783000
.meas tran trig_s69_684 FIND V(trig_s69) AT=0.1784000
.meas tran trig_s69_685 FIND V(trig_s69) AT=0.1785000
.meas tran trig_s69_686 FIND V(trig_s69) AT=0.1786000
.meas tran trig_s69_687 FIND V(trig_s69) AT=0.1787000
.meas tran trig_s69_688 FIND V(trig_s69) AT=0.1788000
.meas tran trig_s69_689 FIND V(trig_s69) AT=0.1789000
.meas tran trig_s69_690 FIND V(trig_s69) AT=0.1790000
.meas tran trig_s69_691 FIND V(trig_s69) AT=0.1791000
.meas tran trig_s69_692 FIND V(trig_s69) AT=0.1792000
.meas tran trig_s69_693 FIND V(trig_s69) AT=0.1793000
.meas tran trig_s69_694 FIND V(trig_s69) AT=0.1794000
.meas tran trig_s69_695 FIND V(trig_s69) AT=0.1795000
.meas tran trig_s69_696 FIND V(trig_s69) AT=0.1796000
.meas tran trig_s69_697 FIND V(trig_s69) AT=0.1797000
.meas tran trig_s69_698 FIND V(trig_s69) AT=0.1798000
.meas tran trig_s69_699 FIND V(trig_s69) AT=0.1799000
.meas tran trig_bi_2800 FIND V(trig_bi_copy) AT=0.3900000
.meas tran trig_bi_2801 FIND V(trig_bi_copy) AT=0.3901000
.meas tran trig_bi_2802 FIND V(trig_bi_copy) AT=0.3902000
.meas tran trig_bi_2803 FIND V(trig_bi_copy) AT=0.3903000
.meas tran trig_bi_2804 FIND V(trig_bi_copy) AT=0.3904000
.meas tran trig_bi_2805 FIND V(trig_bi_copy) AT=0.3905000
.meas tran trig_bi_2806 FIND V(trig_bi_copy) AT=0.3906000
.meas tran trig_bi_2807 FIND V(trig_bi_copy) AT=0.3907000
.meas tran trig_bi_2808 FIND V(trig_bi_copy) AT=0.3908000
.meas tran trig_bi_2809 FIND V(trig_bi_copy) AT=0.3909000
.meas tran trig_bi_2810 FIND V(trig_bi_copy) AT=0.3910000
.meas tran trig_bi_2811 FIND V(trig_bi_copy) AT=0.3911000
.meas tran trig_bi_2812 FIND V(trig_bi_copy) AT=0.3912000
.meas tran trig_bi_2813 FIND V(trig_bi_copy) AT=0.3913000
.meas tran trig_bi_2814 FIND V(trig_bi_copy) AT=0.3914000
.meas tran trig_bi_2815 FIND V(trig_bi_copy) AT=0.3915000
.meas tran trig_bi_2816 FIND V(trig_bi_copy) AT=0.3916000
.meas tran trig_bi_2817 FIND V(trig_bi_copy) AT=0.3917000
.meas tran trig_bi_2818 FIND V(trig_bi_copy) AT=0.3918000
.meas tran trig_bi_2819 FIND V(trig_bi_copy) AT=0.3919000
.meas tran trig_bi_2820 FIND V(trig_bi_copy) AT=0.3920000
.meas tran trig_bi_2821 FIND V(trig_bi_copy) AT=0.3921000
.meas tran trig_bi_2822 FIND V(trig_bi_copy) AT=0.3922000
.meas tran trig_bi_2823 FIND V(trig_bi_copy) AT=0.3923000
.meas tran trig_bi_2824 FIND V(trig_bi_copy) AT=0.3924000
.meas tran trig_bi_2825 FIND V(trig_bi_copy) AT=0.3925000
.meas tran trig_bi_2826 FIND V(trig_bi_copy) AT=0.3926000
.meas tran trig_bi_2827 FIND V(trig_bi_copy) AT=0.3927000
.meas tran trig_bi_2828 FIND V(trig_bi_copy) AT=0.3928000
.meas tran trig_bi_2829 FIND V(trig_bi_copy) AT=0.3929000
.meas tran trig_bi_2830 FIND V(trig_bi_copy) AT=0.3930000
.meas tran trig_bi_2831 FIND V(trig_bi_copy) AT=0.3931000
.meas tran trig_bi_2832 FIND V(trig_bi_copy) AT=0.3932000
.meas tran trig_bi_2833 FIND V(trig_bi_copy) AT=0.3933000
.meas tran trig_bi_2834 FIND V(trig_bi_copy) AT=0.3934000
.meas tran trig_bi_2835 FIND V(trig_bi_copy) AT=0.3935000
.meas tran trig_bi_2836 FIND V(trig_bi_copy) AT=0.3936000
.meas tran trig_bi_2837 FIND V(trig_bi_copy) AT=0.3937000
.meas tran trig_bi_2838 FIND V(trig_bi_copy) AT=0.3938000
.meas tran trig_bi_2839 FIND V(trig_bi_copy) AT=0.3939000
.meas tran trig_bi_2840 FIND V(trig_bi_copy) AT=0.3940000
.meas tran trig_bi_2841 FIND V(trig_bi_copy) AT=0.3941000
.meas tran trig_bi_2842 FIND V(trig_bi_copy) AT=0.3942000
.meas tran trig_bi_2843 FIND V(trig_bi_copy) AT=0.3943000
.meas tran trig_bi_2844 FIND V(trig_bi_copy) AT=0.3944000
.meas tran trig_bi_2845 FIND V(trig_bi_copy) AT=0.3945000
.meas tran trig_bi_2846 FIND V(trig_bi_copy) AT=0.3946000
.meas tran trig_bi_2847 FIND V(trig_bi_copy) AT=0.3947000
.meas tran trig_bi_2848 FIND V(trig_bi_copy) AT=0.3948000
.meas tran trig_bi_2849 FIND V(trig_bi_copy) AT=0.3949000
.meas tran trig_bi_2850 FIND V(trig_bi_copy) AT=0.3950000
.meas tran trig_bi_2851 FIND V(trig_bi_copy) AT=0.3951000
.meas tran trig_bi_2852 FIND V(trig_bi_copy) AT=0.3952000
.meas tran trig_bi_2853 FIND V(trig_bi_copy) AT=0.3953000
.meas tran trig_bi_2854 FIND V(trig_bi_copy) AT=0.3954000
.meas tran trig_bi_2855 FIND V(trig_bi_copy) AT=0.3955000
.meas tran trig_bi_2856 FIND V(trig_bi_copy) AT=0.3956000
.meas tran trig_bi_2857 FIND V(trig_bi_copy) AT=0.3957000
.meas tran trig_bi_2858 FIND V(trig_bi_copy) AT=0.3958000
.meas tran trig_bi_2859 FIND V(trig_bi_copy) AT=0.3959000
.meas tran trig_bi_2860 FIND V(trig_bi_copy) AT=0.3960000
.meas tran trig_bi_2861 FIND V(trig_bi_copy) AT=0.3961000
.meas tran trig_bi_2862 FIND V(trig_bi_copy) AT=0.3962000
.meas tran trig_bi_2863 FIND V(trig_bi_copy) AT=0.3963000
.meas tran trig_bi_2864 FIND V(trig_bi_copy) AT=0.3964000
.meas tran trig_bi_2865 FIND V(trig_bi_copy) AT=0.3965000
.meas tran trig_bi_2866 FIND V(trig_bi_copy) AT=0.3966000
.meas tran trig_bi_2867 FIND V(trig_bi_copy) AT=0.3967000
.meas tran trig_bi_2868 FIND V(trig_bi_copy) AT=0.3968000
.meas tran trig_bi_2869 FIND V(trig_bi_copy) AT=0.3969000
.meas tran trig_bi_2870 FIND V(trig_bi_copy) AT=0.3970000
.meas tran trig_bi_2871 FIND V(trig_bi_copy) AT=0.3971000
.meas tran trig_bi_2872 FIND V(trig_bi_copy) AT=0.3972000
.meas tran trig_bi_2873 FIND V(trig_bi_copy) AT=0.3973000
.meas tran trig_bi_2874 FIND V(trig_bi_copy) AT=0.3974000
.meas tran trig_bi_2875 FIND V(trig_bi_copy) AT=0.3975000
.meas tran trig_bi_2876 FIND V(trig_bi_copy) AT=0.3976000
.meas tran trig_bi_2877 FIND V(trig_bi_copy) AT=0.3977000
.meas tran trig_bi_2878 FIND V(trig_bi_copy) AT=0.3978000
.meas tran trig_bi_2879 FIND V(trig_bi_copy) AT=0.3979000
.meas tran trig_bi_2880 FIND V(trig_bi_copy) AT=0.3980000
.meas tran trig_bi_2881 FIND V(trig_bi_copy) AT=0.3981000
.meas tran trig_bi_2882 FIND V(trig_bi_copy) AT=0.3982000
.meas tran trig_bi_2883 FIND V(trig_bi_copy) AT=0.3983000
.meas tran trig_bi_2884 FIND V(trig_bi_copy) AT=0.3984000
.meas tran trig_bi_2885 FIND V(trig_bi_copy) AT=0.3985000
.meas tran trig_bi_2886 FIND V(trig_bi_copy) AT=0.3986000
.meas tran trig_bi_2887 FIND V(trig_bi_copy) AT=0.3987000
.meas tran trig_bi_2888 FIND V(trig_bi_copy) AT=0.3988000
.meas tran trig_bi_2889 FIND V(trig_bi_copy) AT=0.3989000
.meas tran trig_bi_2890 FIND V(trig_bi_copy) AT=0.3990000
.meas tran trig_bi_2891 FIND V(trig_bi_copy) AT=0.3991000
.meas tran trig_bi_2892 FIND V(trig_bi_copy) AT=0.3992000
.meas tran trig_bi_2893 FIND V(trig_bi_copy) AT=0.3993000
.meas tran trig_bi_2894 FIND V(trig_bi_copy) AT=0.3994000
.meas tran trig_bi_2895 FIND V(trig_bi_copy) AT=0.3995000
.meas tran trig_bi_2896 FIND V(trig_bi_copy) AT=0.3996000
.meas tran trig_bi_2897 FIND V(trig_bi_copy) AT=0.3997000
.meas tran trig_bi_2898 FIND V(trig_bi_copy) AT=0.3998000
.meas tran trig_bi_2899 FIND V(trig_bi_copy) AT=0.3999000
.meas tran trig_bi_2900 FIND V(trig_bi_copy) AT=0.4000000
.meas tran trig_bi_2901 FIND V(trig_bi_copy) AT=0.4001000
.meas tran trig_bi_2902 FIND V(trig_bi_copy) AT=0.4002000
.meas tran trig_bi_2903 FIND V(trig_bi_copy) AT=0.4003000
.meas tran trig_bi_2904 FIND V(trig_bi_copy) AT=0.4004000
.meas tran trig_bi_2905 FIND V(trig_bi_copy) AT=0.4005000
.meas tran trig_bi_2906 FIND V(trig_bi_copy) AT=0.4006000
.meas tran trig_bi_2907 FIND V(trig_bi_copy) AT=0.4007000
.meas tran trig_bi_2908 FIND V(trig_bi_copy) AT=0.4008000
.meas tran trig_bi_2909 FIND V(trig_bi_copy) AT=0.4009000
.meas tran trig_bi_2910 FIND V(trig_bi_copy) AT=0.4010000
.meas tran trig_bi_2911 FIND V(trig_bi_copy) AT=0.4011000
.meas tran trig_bi_2912 FIND V(trig_bi_copy) AT=0.4012000
.meas tran trig_bi_2913 FIND V(trig_bi_copy) AT=0.4013000
.meas tran trig_bi_2914 FIND V(trig_bi_copy) AT=0.4014000
.meas tran trig_bi_2915 FIND V(trig_bi_copy) AT=0.4015000
.meas tran trig_bi_2916 FIND V(trig_bi_copy) AT=0.4016000
.meas tran trig_bi_2917 FIND V(trig_bi_copy) AT=0.4017000
.meas tran trig_bi_2918 FIND V(trig_bi_copy) AT=0.4018000
.meas tran trig_bi_2919 FIND V(trig_bi_copy) AT=0.4019000
.meas tran trig_bi_2920 FIND V(trig_bi_copy) AT=0.4020000
.meas tran trig_bi_2921 FIND V(trig_bi_copy) AT=0.4021000
.meas tran trig_bi_2922 FIND V(trig_bi_copy) AT=0.4022000
.meas tran trig_bi_2923 FIND V(trig_bi_copy) AT=0.4023000
.meas tran trig_bi_2924 FIND V(trig_bi_copy) AT=0.4024000
.meas tran trig_bi_2925 FIND V(trig_bi_copy) AT=0.4025000
.meas tran trig_bi_2926 FIND V(trig_bi_copy) AT=0.4026000
.meas tran trig_bi_2927 FIND V(trig_bi_copy) AT=0.4027000
.meas tran trig_bi_2928 FIND V(trig_bi_copy) AT=0.4028000
.meas tran trig_bi_2929 FIND V(trig_bi_copy) AT=0.4029000
.meas tran trig_bi_2930 FIND V(trig_bi_copy) AT=0.4030000
.meas tran trig_bi_2931 FIND V(trig_bi_copy) AT=0.4031000
.meas tran trig_bi_2932 FIND V(trig_bi_copy) AT=0.4032000
.meas tran trig_bi_2933 FIND V(trig_bi_copy) AT=0.4033000
.meas tran trig_bi_2934 FIND V(trig_bi_copy) AT=0.4034000
.meas tran trig_bi_2935 FIND V(trig_bi_copy) AT=0.4035000
.meas tran trig_bi_2936 FIND V(trig_bi_copy) AT=0.4036000
.meas tran trig_bi_2937 FIND V(trig_bi_copy) AT=0.4037000
.meas tran trig_bi_2938 FIND V(trig_bi_copy) AT=0.4038000
.meas tran trig_bi_2939 FIND V(trig_bi_copy) AT=0.4039000
.meas tran trig_bi_2940 FIND V(trig_bi_copy) AT=0.4040000
.meas tran trig_bi_2941 FIND V(trig_bi_copy) AT=0.4041000
.meas tran trig_bi_2942 FIND V(trig_bi_copy) AT=0.4042000
.meas tran trig_bi_2943 FIND V(trig_bi_copy) AT=0.4043000
.meas tran trig_bi_2944 FIND V(trig_bi_copy) AT=0.4044000
.meas tran trig_bi_2945 FIND V(trig_bi_copy) AT=0.4045000
.meas tran trig_bi_2946 FIND V(trig_bi_copy) AT=0.4046000
.meas tran trig_bi_2947 FIND V(trig_bi_copy) AT=0.4047000
.meas tran trig_bi_2948 FIND V(trig_bi_copy) AT=0.4048000
.meas tran trig_bi_2949 FIND V(trig_bi_copy) AT=0.4049000
.meas tran trig_bi_2950 FIND V(trig_bi_copy) AT=0.4050000
.meas tran trig_bi_2951 FIND V(trig_bi_copy) AT=0.4051000
.meas tran trig_bi_2952 FIND V(trig_bi_copy) AT=0.4052000
.meas tran trig_bi_2953 FIND V(trig_bi_copy) AT=0.4053000
.meas tran trig_bi_2954 FIND V(trig_bi_copy) AT=0.4054000
.meas tran trig_bi_2955 FIND V(trig_bi_copy) AT=0.4055000
.meas tran trig_bi_2956 FIND V(trig_bi_copy) AT=0.4056000
.meas tran trig_bi_2957 FIND V(trig_bi_copy) AT=0.4057000
.meas tran trig_bi_2958 FIND V(trig_bi_copy) AT=0.4058000
.meas tran trig_bi_2959 FIND V(trig_bi_copy) AT=0.4059000
.meas tran trig_bi_2960 FIND V(trig_bi_copy) AT=0.4060000
.meas tran trig_bi_2961 FIND V(trig_bi_copy) AT=0.4061000
.meas tran trig_bi_2962 FIND V(trig_bi_copy) AT=0.4062000
.meas tran trig_bi_2963 FIND V(trig_bi_copy) AT=0.4063000
.meas tran trig_bi_2964 FIND V(trig_bi_copy) AT=0.4064000
.meas tran trig_bi_2965 FIND V(trig_bi_copy) AT=0.4065000
.meas tran trig_bi_2966 FIND V(trig_bi_copy) AT=0.4066000
.meas tran trig_bi_2967 FIND V(trig_bi_copy) AT=0.4067000
.meas tran trig_bi_2968 FIND V(trig_bi_copy) AT=0.4068000
.meas tran trig_bi_2969 FIND V(trig_bi_copy) AT=0.4069000
.meas tran trig_bi_2970 FIND V(trig_bi_copy) AT=0.4070000
.meas tran trig_bi_2971 FIND V(trig_bi_copy) AT=0.4071000
.meas tran trig_bi_2972 FIND V(trig_bi_copy) AT=0.4072000
.meas tran trig_bi_2973 FIND V(trig_bi_copy) AT=0.4073000
.meas tran trig_bi_2974 FIND V(trig_bi_copy) AT=0.4074000
.meas tran trig_bi_2975 FIND V(trig_bi_copy) AT=0.4075000
.meas tran trig_bi_2976 FIND V(trig_bi_copy) AT=0.4076000
.meas tran trig_bi_2977 FIND V(trig_bi_copy) AT=0.4077000
.meas tran trig_bi_2978 FIND V(trig_bi_copy) AT=0.4078000
.meas tran trig_bi_2979 FIND V(trig_bi_copy) AT=0.4079000
.meas tran trig_bi_2980 FIND V(trig_bi_copy) AT=0.4080000
.meas tran trig_bi_2981 FIND V(trig_bi_copy) AT=0.4081000
.meas tran trig_bi_2982 FIND V(trig_bi_copy) AT=0.4082000
.meas tran trig_bi_2983 FIND V(trig_bi_copy) AT=0.4083000
.meas tran trig_bi_2984 FIND V(trig_bi_copy) AT=0.4084000
.meas tran trig_bi_2985 FIND V(trig_bi_copy) AT=0.4085000
.meas tran trig_bi_2986 FIND V(trig_bi_copy) AT=0.4086000
.meas tran trig_bi_2987 FIND V(trig_bi_copy) AT=0.4087000
.meas tran trig_bi_2988 FIND V(trig_bi_copy) AT=0.4088000
.meas tran trig_bi_2989 FIND V(trig_bi_copy) AT=0.4089000
.meas tran trig_bi_2990 FIND V(trig_bi_copy) AT=0.4090000
.meas tran trig_bi_2991 FIND V(trig_bi_copy) AT=0.4091000
.meas tran trig_bi_2992 FIND V(trig_bi_copy) AT=0.4092000
.meas tran trig_bi_2993 FIND V(trig_bi_copy) AT=0.4093000
.meas tran trig_bi_2994 FIND V(trig_bi_copy) AT=0.4094000
.meas tran trig_bi_2995 FIND V(trig_bi_copy) AT=0.4095000
.meas tran trig_bi_2996 FIND V(trig_bi_copy) AT=0.4096000
.meas tran trig_bi_2997 FIND V(trig_bi_copy) AT=0.4097000
.meas tran trig_bi_2998 FIND V(trig_bi_copy) AT=0.4098000
.meas tran trig_bi_2999 FIND V(trig_bi_copy) AT=0.4099000

.end
