Bias Generator Current Measurement
.lib "C:/Users/kadhi/OneDrive/Desktop/amux/verilogLearning/Leaky-Integrate-Fire---SNN-model-on-FPGA/experiments/frontend_optimization/ngspice_frontend/sky130_minimal.lib.spice" tt
.option scale=1.0u method=gear gmin=1e-15

.include "bias_gen.spice"

Vdd vdd 0 0.9
Vss vss 0 0

Xbias vbias vref vdd vss bias_gen

.ic v(xbias.iref) = 0.3

.tran 1m 200m uic

.control
run
set wr_singlescale
let vb = v(vbias)
let vr = v(vref)
let idd = -i(vdd)
wrdata C:/Users/kadhi/OneDrive/Desktop/amux/verilogLearning/Leaky-Integrate-Fire---SNN-model-on-FPGA/experiments/frontend_optimization/complete_frontend/_tb_bias_current_data.txt vb vr idd
.endc
.end
