.title qrs_symmetry_cf_test_100
.lib "C:\Users\kadhi\OneDrive\Desktop\amux\verilogLearning\Leaky-Integrate-Fire---SNN-model-on-FPGA\experiments\frontend_optimization\ngspice_frontend\sky130_minimal.lib.spice" tt
.option scale=1.0u method=gear reltol=0.01 gmin=1e-15
.temp 27
.include "qrs_symmetry.spice"

Vdd vdd 0 0.9
Vss vss 0 0
Vecg ecg_in 0 PWL(0.0000000 0.300000 1.9344444 0.300000 1.9444444 0.279374 1.9472222 0.279374 1.9500000 0.279079 1.9527778 0.277606 1.9555556 0.277017 1.9583333 0.276722 1.9611111 0.274954 1.9638889 0.273186 1.9666667 0.272007 1.9694444 0.269945 1.9722222 0.267882 1.9750000 0.268177 1.9777778 0.270829 1.9805556 0.276133 1.9833333 0.282615 1.9861111 0.290571 1.9888889 0.302357 1.9916667 0.318564 1.9944444 0.335064 1.9972222 0.347145 2.0000000 0.352155 2.0027778 0.346851 2.0055556 0.330645 2.0083333 0.307661 2.0111111 0.287330 2.0138889 0.274954 2.0166667 0.270534 2.0194444 0.271123 2.0222222 0.273481 2.0250000 0.276427 2.0277778 0.277017 2.0305556 0.276722 2.0333333 0.276722 2.0361111 0.276427 2.0388889 0.277017 2.0416667 0.277606 2.0444444 0.277311 2.0472222 0.277311 2.0500000 0.276427 2.0527778 0.275838 2.0555556 0.275838 2.0583333 0.277017 2.0611111 0.277017 2.0638889 0.276133 2.0666667 0.276133 2.0694444 0.275543 2.0722222 0.275838 2.0750000 0.276722 2.0777778 0.276722 2.0805556 0.276427 2.0833333 0.275543 2.0861111 0.275543 2.0888889 0.275543 2.0916667 0.276427 2.0944444 0.277017 2.0972222 0.277017 2.1000000 0.275838 2.1027778 0.275543 2.1055556 0.276133 2.1083333 0.276722 2.1211111 0.300000 2.7511111 0.300000 2.7611111 0.279963 2.7638889 0.279963 2.7666667 0.279669 2.7694444 0.279079 2.7722222 0.278490 2.7750000 0.278195 2.7777778 0.276133 2.7805556 0.273775 2.7833333 0.271713 2.7861111 0.270829 2.7888889 0.269355 2.7916667 0.268471 2.7944444 0.270239 2.7972222 0.275543 2.8000000 0.283499 2.8027778 0.292044 2.8055556 0.303831 2.8083333 0.317680 2.8111111 0.334180 2.8138889 0.347735 2.8166667 0.355691 2.8194444 0.354217 2.8222222 0.345672 2.8250000 0.326225 2.8277778 0.301179 2.8305556 0.282615 2.8333333 0.273775 2.8361111 0.272302 2.8388889 0.274954 2.8416667 0.277606 2.8444444 0.278785 2.8472222 0.278785 2.8500000 0.278195 2.8527778 0.277606 2.8555556 0.277606 2.8583333 0.277901 2.8611111 0.278195 2.8638889 0.278490 2.8666667 0.278195 2.8694444 0.277311 2.8722222 0.277311 2.8750000 0.277901 2.8777778 0.278195 2.8805556 0.278195 2.8833333 0.277311 2.8861111 0.276722 2.8888889 0.277311 2.8916667 0.277311 2.8944444 0.277017 2.8972222 0.277311 2.9000000 0.276722 2.9027778 0.275838 2.9055556 0.276427 2.9083333 0.276722 2.9111111 0.277606 2.9138889 0.276722 2.9166667 0.276722 2.9194444 0.276427 2.9222222 0.276427 2.9250000 0.276722 2.9377778 0.300000 3.4038889 0.300000 3.4138889 0.279079 3.4166667 0.279374 3.4194444 0.277901 3.4222222 0.278490 3.4250000 0.277901 3.4277778 0.276427 3.4305556 0.274659 3.4333333 0.272007 3.4361111 0.269355 3.4388889 0.269355 3.4416667 0.267587 3.4444444 0.266409 3.4472222 0.268177 3.4500000 0.273775 3.4527778 0.282026 3.4555556 0.291750 3.4583333 0.301473 3.4611111 0.315322 3.4638889 0.330055 3.4666667 0.343315 3.4694444 0.349797 3.4722222 0.351565 3.4750000 0.343315 3.4777778 0.323573 3.4805556 0.298527 3.4833333 0.280258 3.4861111 0.271713 3.4888889 0.272302 3.4916667 0.275543 3.4944444 0.277901 3.4972222 0.278490 3.5000000 0.277311 3.5027778 0.276427 3.5055556 0.277606 3.5083333 0.277017 3.5111111 0.277901 3.5138889 0.277311 3.5166667 0.276722 3.5194444 0.276133 3.5222222 0.277017 3.5250000 0.277606 3.5277778 0.277311 3.5305556 0.277311 3.5333333 0.276722 3.5361111 0.276427 3.5388889 0.276133 3.5416667 0.276427 3.5444444 0.277017 3.5472222 0.277017 3.5500000 0.276722 3.5527778 0.276427 3.5555556 0.277017 3.5583333 0.277311 3.5611111 0.277017 3.5638889 0.277311 3.5666667 0.275838 3.5694444 0.275249 3.5722222 0.276133 3.5750000 0.275838 3.5777778 0.277017 3.5905556 0.300000 4.3983333 0.300000 4.4083333 0.276722 4.4111111 0.276722 4.4138889 0.276722 4.4166667 0.275838 4.4194444 0.274659 4.4222222 0.274070 4.4250000 0.273186 4.4277778 0.271123 4.4305556 0.271418 4.4333333 0.269355 4.4361111 0.266409 4.4388889 0.266114 4.4416667 0.269061 4.4444444 0.275249 4.4472222 0.282026 4.4500000 0.288803 4.4527778 0.298821 4.4555556 0.312965 4.4583333 0.328582 4.4611111 0.342136 4.4638889 0.349797 4.4666667 0.352155 4.4694444 0.346556 4.4722222 0.333002 4.4750000 0.313260 4.4777778 0.295875 4.4805556 0.283204 4.4833333 0.274954 4.4861111 0.270534 4.4888889 0.267587 4.4916667 0.268471 4.4944444 0.270534 4.4972222 0.272597 4.5000000 0.273481 4.5027778 0.273481 4.5055556 0.274365 4.5083333 0.275249 4.5111111 0.275838 4.5138889 0.275838 4.5166667 0.275543 4.5194444 0.275249 4.5222222 0.274954 4.5250000 0.275249 4.5277778 0.274659 4.5305556 0.274659 4.5333333 0.274070 4.5361111 0.273481 4.5388889 0.273481 4.5416667 0.274659 4.5444444 0.274659 4.5472222 0.274659 4.5500000 0.273775 4.5527778 0.273775 4.5555556 0.274070 4.5583333 0.274954 4.5611111 0.274659 4.5638889 0.274659 4.5666667 0.274954 4.5694444 0.273775 4.5722222 0.273775 4.5850000 0.300000 5.2427778 0.300000 5.2527778 0.276722 5.2555556 0.276722 5.2583333 0.277311 5.2611111 0.277606 5.2638889 0.276722 5.2666667 0.274954 5.2694444 0.272597 5.2722222 0.270534 5.2750000 0.269650 5.2777778 0.268766 5.2805556 0.266998 5.2833333 0.265525 5.2861111 0.268766 5.2888889 0.275838 5.2916667 0.284972 5.2944444 0.293812 5.2972222 0.306188 5.3000000 0.320921 5.3027778 0.335359 5.3055556 0.347735 5.3083333 0.352449 5.3111111 0.348913 5.3138889 0.334180 5.3166667 0.310902 5.3194444 0.287919 5.3222222 0.273481 5.3250000 0.269061 5.3277778 0.270829 5.3305556 0.272597 5.3333333 0.274365 5.3361111 0.275543 5.3388889 0.275543 5.3416667 0.275543 5.3444444 0.276427 5.3472222 0.276722 5.3500000 0.276133 5.3527778 0.274954 5.3555556 0.274365 5.3583333 0.275543 5.3611111 0.275543 5.3638889 0.275543 5.3666667 0.275543 5.3694444 0.274659 5.3722222 0.275249 5.3750000 0.275838 5.3777778 0.276133 5.3805556 0.275249 5.3833333 0.275838 5.3861111 0.275249 5.3888889 0.276427 5.3916667 0.276722 5.3944444 0.277311 5.3972222 0.276427 5.4000000 0.276427 5.4027778 0.276427 5.4055556 0.276427 5.4083333 0.276722 5.4111111 0.276427 5.4138889 0.276427 5.4166667 0.276427 5.4294444 0.300000 6.0538889 0.300000 6.0638889 0.280258 6.0666667 0.280258 6.0694444 0.279079 6.0722222 0.279079 6.0750000 0.279669 6.0777778 0.279079 6.0805556 0.276722 6.0833333 0.273481 6.0861111 0.271713 6.0888889 0.270239 6.0916667 0.269061 6.0944444 0.267882 6.0972222 0.270534 6.1000000 0.276722 6.1027778 0.284972 6.1055556 0.295875 6.1083333 0.308545 6.1111111 0.325046 6.1138889 0.340368 6.1166667 0.351565 6.1194444 0.354512 6.1222222 0.346851 6.1250000 0.327698 6.1277778 0.301179 6.1305556 0.280847 6.1333333 0.272302 6.1361111 0.271418 6.1388889 0.275838 6.1416667 0.278490 6.1444444 0.279079 6.1472222 0.278490 6.1500000 0.277606 6.1527778 0.277311 6.1555556 0.277606 6.1583333 0.278195 6.1611111 0.278195 6.1638889 0.277901 6.1666667 0.277311 6.1694444 0.276722 6.1722222 0.277311 6.1750000 0.277606 6.1777778 0.277311 6.1805556 0.277901 6.1833333 0.277017 6.1861111 0.276133 6.1888889 0.276133 6.1916667 0.277017 6.1944444 0.277311 6.1972222 0.277311 6.2000000 0.277017 6.2027778 0.275838 6.2055556 0.276427 6.2083333 0.277017 6.2111111 0.277311 6.2138889 0.277311 6.2166667 0.276722 6.2194444 0.277017 6.2222222 0.276722 6.2250000 0.277606 6.2277778 0.277901 6.2405556 0.300000 6.8427778 0.300000 6.8527778 0.279963 6.8555556 0.280258 6.8583333 0.280847 6.8611111 0.281436 6.8638889 0.281142 6.8666667 0.279669 6.8694444 0.278195 6.8722222 0.276722 6.8750000 0.274954 6.8777778 0.273775 6.8805556 0.272597 6.8833333 0.269945 6.8861111 0.268766 6.8888889 0.271418 6.8916667 0.278195 6.8944444 0.286151 6.8972222 0.294696 6.9000000 0.306188 6.9027778 0.322099 6.9055556 0.338600 6.9083333 0.348324 6.9111111 0.350976 6.9138889 0.343315 6.9166667 0.326519 6.9194444 0.303536 6.9222222 0.284088 6.9250000 0.274659 6.9277778 0.272891 6.9305556 0.275543 6.9333333 0.277311 6.9361111 0.278490 6.9388889 0.279079 6.9416667 0.279079 6.9444444 0.279669 6.9472222 0.279374 6.9500000 0.279374 6.9527778 0.278785 6.9555556 0.279669 6.9583333 0.279963 6.9611111 0.279963 6.9638889 0.280258 6.9666667 0.280258 6.9694444 0.279079 6.9722222 0.279669 6.9750000 0.279963 6.9777778 0.280258 6.9805556 0.279963 6.9833333 0.279374 6.9861111 0.278490 6.9888889 0.278785 6.9916667 0.278490 6.9944444 0.279374 6.9972222 0.279669 7.0000000 0.278490 7.0027778 0.278785 7.0055556 0.279374 7.0083333 0.279079 7.0111111 0.279374 7.0138889 0.279079 7.0166667 0.279374 7.0294444 0.300000 7.6150000 0.300000 7.6250000 0.279079 7.6277778 0.279669 7.6305556 0.279669 7.6333333 0.279374 7.6361111 0.278490 7.6388889 0.277606 7.6416667 0.276133 7.6444444 0.274954 7.6472222 0.274070 7.6500000 0.272302 7.6527778 0.269355 7.6555556 0.268177 7.6583333 0.271123 7.6611111 0.277017 7.6638889 0.284678 7.6666667 0.293223 7.6694444 0.305009 7.6722222 0.321215 7.6750000 0.336243 7.6777778 0.345967 7.6805556 0.349208 7.6833333 0.342431 7.6861111 0.324162 7.6888889 0.301768 7.6916667 0.284972 7.6944444 0.275543 7.6972222 0.272302 7.7000000 0.272597 7.7027778 0.274365 7.7055556 0.276722 7.7083333 0.277901 7.7111111 0.278195 7.7138889 0.277901 7.7166667 0.277901 7.7194444 0.277017 7.7222222 0.276427 7.7250000 0.277606 7.7277778 0.277311 7.7305556 0.277311 7.7333333 0.277311 7.7361111 0.277311 7.7388889 0.278195 7.7416667 0.278195 7.7444444 0.278785 7.7472222 0.277606 7.7500000 0.277606 7.7527778 0.277311 7.7555556 0.278195 7.7583333 0.278195 7.7611111 0.278490 7.7638889 0.277901 7.7666667 0.277311 7.7694444 0.277017 7.7722222 0.277017 7.7750000 0.277311 7.7777778 0.277311 7.7805556 0.276722 7.7833333 0.277017 7.7861111 0.276427 7.7888889 0.276133 7.8016667 0.300000 8.4538889 0.300000 8.4638889 0.280847 8.4666667 0.280258 8.4694444 0.279374 8.4722222 0.279963 8.4750000 0.279669 8.4777778 0.279079 8.4805556 0.277311 8.4833333 0.274954 8.4861111 0.273481 8.4888889 0.272302 8.4916667 0.271418 8.4944444 0.269945 8.4972222 0.269650 8.5000000 0.273186 8.5027778 0.280847 8.5055556 0.290276 8.5083333 0.300589 8.5111111 0.314733 8.5138889 0.330350 8.5166667 0.343610 8.5194444 0.352155 8.5222222 0.355101 8.5250000 0.349208 8.5277778 0.330939 8.5305556 0.307072 8.5333333 0.286446 8.5361111 0.274954 8.5388889 0.273186 8.5416667 0.275249 8.5444444 0.277606 8.5472222 0.278785 8.5500000 0.278490 8.5527778 0.277901 8.5555556 0.277606 8.5583333 0.279079 8.5611111 0.279079 8.5638889 0.278195 8.5666667 0.277901 8.5694444 0.277311 8.5722222 0.277606 8.5750000 0.278490 8.5777778 0.278195 8.5805556 0.278195 8.5833333 0.278490 8.5861111 0.277606 8.5888889 0.278195 8.5916667 0.277901 8.5944444 0.278490 8.5972222 0.278195 8.6000000 0.277606 8.6027778 0.277901 8.6055556 0.278490 8.6083333 0.278785 8.6111111 0.278785 8.6138889 0.279079 8.6166667 0.279079 8.6194444 0.278195 8.6222222 0.278490 8.6250000 0.279079 8.6277778 0.279374 8.6405556 0.300000 9.3094444 0.300000 9.3194444 0.277901 9.3222222 0.276722 9.3250000 0.274659 9.3277778 0.274070 9.3305556 0.273481 9.3333333 0.273481 9.3361111 0.272007 9.3388889 0.271713 9.3416667 0.269945 9.3444444 0.267587 9.3472222 0.266114 9.3500000 0.267882 9.3527778 0.271123 9.3555556 0.277901 9.3583333 0.285267 9.3611111 0.292928 9.3638889 0.303536 9.3666667 0.316796 9.3694444 0.330939 9.3722222 0.343610 9.3750000 0.350681 9.3777778 0.352449 9.3805556 0.343020 9.3833333 0.325046 9.3861111 0.300884 9.3888889 0.283204 9.3916667 0.274365 9.3944444 0.273481 9.3972222 0.274365 9.4000000 0.277311 9.4027778 0.277606 9.4055556 0.278195 9.4083333 0.278195 9.4111111 0.278195 9.4138889 0.278785 9.4166667 0.278785 9.4194444 0.278195 9.4222222 0.277311 9.4250000 0.278490 9.4277778 0.278785 9.4305556 0.278490 9.4333333 0.278490 9.4361111 0.277901 9.4388889 0.277311 9.4416667 0.278785 9.4444444 0.278490 9.4472222 0.279079 9.4500000 0.277901 9.4527778 0.277606 9.4555556 0.277901 9.4583333 0.279079 9.4611111 0.279079 9.4638889 0.278785 9.4666667 0.278490 9.4694444 0.277606 9.4722222 0.278195 9.4750000 0.279079 9.4777778 0.279374 9.4805556 0.279079 9.4833333 0.278490 9.4961111 0.300000 10.1316667 0.300000 10.1416667 0.279079 10.1444444 0.279669 10.1472222 0.279374 10.1500000 0.278195 10.1527778 0.277311 10.1555556 0.275838 10.1583333 0.274070 10.1611111 0.272891 10.1638889 0.271123 10.1666667 0.268177 10.1694444 0.266703 10.1722222 0.267587 10.1750000 0.271418 10.1777778 0.278490 10.1805556 0.284972 10.1833333 0.292634 10.1861111 0.305304 10.1888889 0.321215 10.1916667 0.335359 10.1944444 0.344199 10.1972222 0.346851 10.2000000 0.341252 10.2027778 0.325930 10.2055556 0.305599 10.2083333 0.289098 10.2111111 0.278195 10.2138889 0.272302 10.2166667 0.271123 10.2194444 0.272302 10.2222222 0.274070 10.2250000 0.274954 10.2277778 0.275838 10.2305556 0.275838 10.2333333 0.275838 10.2361111 0.275249 10.2388889 0.276427 10.2416667 0.276722 10.2444444 0.276133 10.2472222 0.275838 10.2500000 0.276133 10.2527778 0.275249 10.2555556 0.276722 10.2583333 0.276722 10.2611111 0.277017 10.2638889 0.276722 10.2666667 0.276722 10.2694444 0.275838 10.2722222 0.276427 10.2750000 0.276427 10.2777778 0.275838 10.2805556 0.276427 10.2833333 0.276133 10.2861111 0.275838 10.2888889 0.275838 10.2916667 0.276427 10.2944444 0.277017 10.2972222 0.277017 10.3000000 0.276427 10.3027778 0.276427 10.3055556 0.276722 10.3183333 0.300000 10.9594444 0.300000 10.9694444 0.277311 10.9722222 0.277606 10.9750000 0.277901 10.9777778 0.278195 10.9805556 0.277606 10.9833333 0.276133 10.9861111 0.273775 10.9888889 0.272597 10.9916667 0.271713 10.9944444 0.271418 10.9972222 0.269061 11.0000000 0.267293 11.0027778 0.268471 11.0055556 0.273481 11.0083333 0.280847 11.0111111 0.289098 11.0138889 0.298527 11.0166667 0.310902 11.0194444 0.325341 11.0222222 0.338895 11.0250000 0.348029 11.0277778 0.350092 11.0305556 0.344199 11.0333333 0.328582 11.0361111 0.306483 11.0388889 0.287624 11.0416667 0.277017 11.0444444 0.272891 11.0472222 0.271418 11.0500000 0.272302 11.0527778 0.273481 11.0555556 0.274954 11.0583333 0.275543 11.0611111 0.276133 11.0638889 0.275543 11.0666667 0.275543 11.0694444 0.275249 11.0722222 0.276427 11.0750000 0.276722 11.0777778 0.277311 11.0805556 0.276722 11.0833333 0.276427 11.0861111 0.275249 11.0888889 0.275838 11.0916667 0.276427 11.0944444 0.276427 11.0972222 0.276133 11.1000000 0.276133 11.1027778 0.274365 11.1055556 0.275249 11.1083333 0.275838 11.1111111 0.276133 11.1138889 0.275543 11.1166667 0.274659 11.1194444 0.274070 11.1222222 0.274365 11.1250000 0.275543 11.1277778 0.275249 11.1305556 0.274659 11.1333333 0.275543 11.1461111 0.300000 11.7816667 0.300000 11.7916667 0.278195 11.7944444 0.279079 11.7972222 0.278195 11.8000000 0.277606 11.8027778 0.277311 11.8055556 0.277311 11.8083333 0.276427 11.8111111 0.274659 11.8138889 0.272597 11.8166667 0.271418 11.8194444 0.269355 11.8222222 0.267293 11.8250000 0.269061 11.8277778 0.274365 11.8305556 0.282026 11.8333333 0.290866 11.8361111 0.300589 11.8388889 0.315322 11.8416667 0.331529 11.8444444 0.344788 11.8472222 0.352449 11.8500000 0.353333 11.8527778 0.341547 11.8555556 0.321215 11.8583333 0.298232 11.8611111 0.281142 11.8638889 0.273186 11.8666667 0.272007 11.8694444 0.274070 11.8722222 0.276722 11.8750000 0.277606 11.8777778 0.277606 11.8805556 0.277311 11.8833333 0.276722 11.8861111 0.276427 11.8888889 0.276133 11.8916667 0.276722 11.8944444 0.275838 11.8972222 0.277017 11.9000000 0.276722 11.9027778 0.276133 11.9055556 0.276133 11.9083333 0.276722 11.9111111 0.277311 11.9138889 0.277311 11.9166667 0.276133 11.9194444 0.276133 11.9222222 0.276427 11.9250000 0.277311 11.9277778 0.277606 11.9305556 0.277311 11.9333333 0.276133 11.9361111 0.275838 11.9388889 0.276427 11.9416667 0.276722 11.9444444 0.277311 11.9472222 0.276722 11.9500000 0.275838 11.9527778 0.276133 11.9555556 0.276133 11.9683333 0.300000 12.5761111 0.300000 12.5861111 0.279079 12.5888889 0.279374 12.5916667 0.279963 12.5944444 0.279963 12.5972222 0.279963 12.6000000 0.279079 12.6027778 0.276427 12.6055556 0.274365 12.6083333 0.273186 12.6111111 0.272302 12.6138889 0.270534 12.6166667 0.268177 12.6194444 0.267882 12.6222222 0.272597 12.6250000 0.279079 12.6277778 0.287624 12.6305556 0.297937 12.6333333 0.310902 12.6361111 0.325635 12.6388889 0.339779 12.6416667 0.348324 12.6444444 0.348619 12.6472222 0.337716 12.6500000 0.318858 12.6527778 0.295875 12.6555556 0.279963 12.6583333 0.273775 12.6611111 0.273775 12.6638889 0.275838 12.6666667 0.277606 12.6694444 0.277901 12.6722222 0.277901 12.6750000 0.278195 12.6777778 0.278490 12.6805556 0.278785 12.6833333 0.278195 12.6861111 0.277901 12.6888889 0.278195 12.6916667 0.278785 12.6944444 0.279374 12.6972222 0.279079 12.7000000 0.278490 12.7027778 0.277606 12.7055556 0.277606 12.7083333 0.278195 12.7111111 0.278490 12.7138889 0.278490 12.7166667 0.277606 12.7194444 0.277311 12.7222222 0.277017 12.7250000 0.277606 12.7277778 0.277901 12.7305556 0.277901 12.7333333 0.277606 12.7361111 0.277017 12.7388889 0.277606 12.7416667 0.277901 12.7444444 0.278195 12.7472222 0.278490 12.7500000 0.277901 12.7627778 0.300000 13.3733333 0.300000 13.3833333 0.279079 13.3861111 0.278195 13.3888889 0.277901 13.3916667 0.277017 13.3944444 0.274954 13.3972222 0.273186 13.4000000 0.272007 13.4027778 0.270534 13.4055556 0.268177 13.4083333 0.266409 13.4111111 0.269945 13.4138889 0.275543 13.4166667 0.280258 13.4194444 0.284678 13.4222222 0.291160 13.4250000 0.299705 13.4277778 0.312081 13.4305556 0.327698 13.4333333 0.340074 13.4361111 0.348619 13.4388889 0.354512 13.4416667 0.357164 13.4444444 0.352155 13.4472222 0.340663 13.4500000 0.324457 13.4527778 0.306188 13.4555556 0.291160 13.4583333 0.279669 13.4611111 0.274365 13.4638889 0.272597 13.4666667 0.273186 13.4694444 0.274954 13.4722222 0.275543 13.4750000 0.276722 13.4777778 0.277901 13.4805556 0.278195 13.4833333 0.276722 13.4861111 0.276427 13.4888889 0.276427 13.4916667 0.275838 13.4944444 0.276427 13.4972222 0.276133 13.5000000 0.276427 13.5027778 0.276133 13.5055556 0.276722 13.5083333 0.277017 13.5111111 0.277606 13.5138889 0.277311 13.5166667 0.276133 13.5194444 0.275249 13.5222222 0.276133 13.5250000 0.276427 13.5277778 0.277017 13.5305556 0.277606 13.5333333 0.276722 13.5361111 0.276722 13.5388889 0.276427 13.5416667 0.277017 13.5444444 0.275838 13.5472222 0.276133 13.5600000 0.300000 14.1650000 0.300000 14.1750000 0.279079 14.1777778 0.279079 14.1805556 0.279079 14.1833333 0.278785 14.1861111 0.277901 14.1888889 0.278195 14.1916667 0.277017 14.1944444 0.274954 14.1972222 0.272597 14.2000000 0.271123 14.2027778 0.269061 14.2055556 0.266998 14.2083333 0.266998 14.2111111 0.270829 14.2138889 0.278785 14.2166667 0.287035 14.2194444 0.297348 14.2222222 0.311197 14.2250000 0.327993 14.2277778 0.342726 14.2305556 0.352744 14.2333333 0.352744 14.2361111 0.341842 14.2388889 0.320626 14.2416667 0.296759 14.2444444 0.279374 14.2472222 0.271713 14.2500000 0.271123 14.2527778 0.272597 14.2555556 0.275543 14.2583333 0.276133 14.2611111 0.276722 14.2638889 0.276133 14.2666667 0.275249 14.2694444 0.276722 14.2722222 0.275543 14.2750000 0.276427 14.2777778 0.277017 14.2805556 0.277311 14.2833333 0.276722 14.2861111 0.276133 14.2888889 0.276722 14.2916667 0.276427 14.2944444 0.277017 14.2972222 0.277017 14.3000000 0.276427 14.3027778 0.275543 14.3055556 0.276133 14.3083333 0.277017 14.3111111 0.277606 14.3138889 0.277606 14.3166667 0.276133 14.3194444 0.277017 14.3222222 0.276427 14.3250000 0.277017 14.3277778 0.277606 14.3305556 0.277606 14.3333333 0.276133 14.3361111 0.276427 14.3388889 0.275838 14.3516667 0.300000 14.9872222 0.300000 14.9972222 0.279374 15.0000000 0.279374 15.0027778 0.279079 15.0055556 0.279079 15.0083333 0.279079 15.0111111 0.278195 15.0138889 0.274954 15.0166667 0.272597 15.0194444 0.271713 15.0222222 0.270534 15.0250000 0.268766 15.0277778 0.268471 15.0305556 0.271418 15.0333333 0.276722 15.0361111 0.284972 15.0388889 0.294401 15.0416667 0.305599 15.0444444 0.320626 15.0472222 0.337127 15.0500000 0.349797 15.0527778 0.356280 15.0555556 0.357459 15.0583333 0.348619 15.0611111 0.328287 15.0638889 0.303241 15.0666667 0.284088 15.0694444 0.273186 15.0722222 0.271418 15.0750000 0.274070 15.0777778 0.276133 15.0805556 0.277901 15.0833333 0.277901 15.0861111 0.277017 15.0888889 0.277606 15.0916667 0.278785 15.0944444 0.279079 15.0972222 0.279669 15.1000000 0.278490 15.1027778 0.277901 15.1055556 0.278195 15.1083333 0.278195 15.1111111 0.279079 15.1138889 0.278195 15.1166667 0.277901 15.1194444 0.277606 15.1222222 0.277311 15.1250000 0.277606 15.1277778 0.277606 15.1305556 0.277606 15.1333333 0.277311 15.1361111 0.276722 15.1388889 0.276722 15.1416667 0.277017 15.1444444 0.277311 15.1472222 0.277606 15.1500000 0.277606 15.1527778 0.276722 15.1555556 0.277017 15.1583333 0.277606 15.1611111 0.278195 15.1738889 0.300000 15.8566667 0.300000 15.8666667 0.278785 15.8694444 0.278195 15.8722222 0.277901 15.8750000 0.278195 15.8777778 0.277606 15.8805556 0.275249 15.8833333 0.272597 15.8861111 0.271418 15.8888889 0.269650 15.8916667 0.267882 15.8944444 0.266114 15.8972222 0.267882 15.9000000 0.273481 15.9027778 0.280847 15.9055556 0.288508 15.9083333 0.297348 15.9111111 0.309724 15.9138889 0.325046 15.9166667 0.338600 15.9194444 0.347735 15.9222222 0.351565 15.9250000 0.348029 15.9277778 0.334770 15.9305556 0.312965 15.9333333 0.291160 15.9361111 0.277606 15.9388889 0.272302 15.9416667 0.272597 15.9444444 0.274954 15.9472222 0.277311 15.9500000 0.277901 15.9527778 0.276722 15.9555556 0.277311 15.9583333 0.277901 15.9611111 0.279079 15.9638889 0.278195 15.9666667 0.278785 15.9694444 0.278490 15.9722222 0.278195 15.9750000 0.278195 15.9777778 0.278785 15.9805556 0.278490 15.9833333 0.277901 15.9861111 0.277606 15.9888889 0.278195 15.9916667 0.278195 15.9944444 0.278195 15.9972222 0.277606 16.0000000 0.277311 16.0027778 0.276722 16.0055556 0.277017 16.0083333 0.277606 16.0111111 0.277901 16.0138889 0.277901 16.0166667 0.276722 16.0194444 0.276427 16.0222222 0.276722 16.0250000 0.278195 16.0277778 0.278195 16.0305556 0.278195 16.0433333 0.300000 16.6788889 0.300000 16.6888889 0.278195 16.6916667 0.278490 16.6944444 0.278785 16.6972222 0.277311 16.7000000 0.275543 16.7027778 0.273186 16.7055556 0.272597 16.7083333 0.272891 16.7111111 0.272007 16.7138889 0.270829 16.7166667 0.267293 16.7194444 0.265525 16.7222222 0.267587 16.7250000 0.272891 16.7277778 0.279669 16.7305556 0.287919 16.7333333 0.297643 16.7361111 0.311197 16.7388889 0.326814 16.7416667 0.340074 16.7444444 0.349503 16.7472222 0.351860 16.7500000 0.342726 16.7527778 0.323573 16.7555556 0.300000 16.7583333 0.283499 16.7611111 0.274365 16.7638889 0.269945 16.7666667 0.271418 16.7694444 0.272891 16.7722222 0.274659 16.7750000 0.276133 16.7777778 0.275838 16.7805556 0.275838 16.7833333 0.275543 16.7861111 0.276133 16.7888889 0.275543 16.7916667 0.276722 16.7944444 0.277017 16.7972222 0.276722 16.8000000 0.276133 16.8027778 0.275838 16.8055556 0.275838 16.8083333 0.276722 16.8111111 0.277017 16.8138889 0.276427 16.8166667 0.276427 16.8194444 0.276722 16.8222222 0.276427 16.8250000 0.277311 16.8277778 0.277311 16.8305556 0.276722 16.8333333 0.275838 16.8361111 0.275249 16.8388889 0.275838 16.8416667 0.276427 16.8444444 0.277017 16.8472222 0.275838 16.8500000 0.275543 16.8527778 0.274954 16.8655556 0.300000 17.4650000 0.300000 17.4750000 0.277311 17.4777778 0.278490 17.4805556 0.277901 17.4833333 0.277901 17.4861111 0.276427 17.4888889 0.276722 17.4916667 0.274659 17.4944444 0.272891 17.4972222 0.271713 17.5000000 0.269945 17.5027778 0.266409 17.5055556 0.265525 17.5083333 0.269650 17.5111111 0.277311 17.5138889 0.285856 17.5166667 0.294991 17.5194444 0.307366 17.5222222 0.323867 17.5250000 0.339779 17.5277778 0.350976 17.5305556 0.355101 17.5333333 0.349503 17.5361111 0.332707 17.5388889 0.308250 17.5416667 0.288214 17.5444444 0.276133 17.5472222 0.271418 17.5500000 0.271418 17.5527778 0.273481 17.5555556 0.277311 17.5583333 0.277311 17.5611111 0.277311 17.5638889 0.277017 17.5666667 0.277311 17.5694444 0.276722 17.5722222 0.277017 17.5750000 0.277311 17.5777778 0.277311 17.5805556 0.277017 17.5833333 0.276722 17.5861111 0.277017 17.5888889 0.277017 17.5916667 0.276722 17.5944444 0.277606 17.5972222 0.277311 17.6000000 0.277017 17.6027778 0.276133 17.6055556 0.276427 17.6083333 0.276722 17.6111111 0.277017 17.6138889 0.277017 17.6166667 0.277017 17.6194444 0.276133 17.6222222 0.277901 17.6250000 0.277017 17.6277778 0.277606 17.6305556 0.277017 17.6333333 0.277311 17.6361111 0.277017 17.6388889 0.277311 17.6516667 0.300000 18.2566667 0.300000 18.2666667 0.280258 18.2694444 0.279669 18.2722222 0.279374 18.2750000 0.276722 18.2777778 0.274659 18.2805556 0.272891 18.2833333 0.270239 18.2861111 0.267882 18.2888889 0.266114 18.2916667 0.266998 18.2944444 0.273186 18.2972222 0.280552 18.3000000 0.286151 18.3027778 0.292339 18.3055556 0.300000 18.3083333 0.309429 18.3111111 0.320626 18.3138889 0.332118 18.3166667 0.341252 18.3194444 0.348029 18.3222222 0.354807 18.3250000 0.360994 18.3277778 0.361878 18.3305556 0.354217 18.3333333 0.333591 18.3361111 0.306777 18.3388889 0.285562 18.3416667 0.275249 18.3444444 0.274954 18.3472222 0.277017 18.3500000 0.279079 18.3527778 0.278785 18.3555556 0.278490 18.3583333 0.279079 18.3611111 0.279374 18.3638889 0.278785 18.3666667 0.278490 18.3694444 0.277017 18.3722222 0.277311 18.3750000 0.277901 18.3777778 0.278195 18.3805556 0.278195 18.3833333 0.277606 18.3861111 0.276722 18.3888889 0.277311 18.3916667 0.277901 18.3944444 0.278490 18.3972222 0.278195 18.4000000 0.277311 18.4027778 0.276427 18.4055556 0.277311 18.4083333 0.277311 18.4111111 0.278195 18.4138889 0.277901 18.4166667 0.277311 18.4194444 0.276722 18.4222222 0.277017 18.4250000 0.278195 18.4277778 0.278785 18.4305556 0.278785 18.4433333 0.300000 19.0316667 0.300000 19.0416667 0.279669 19.0444444 0.279963 19.0472222 0.279374 19.0500000 0.278785 19.0527778 0.277017 19.0555556 0.276427 19.0583333 0.274365 19.0611111 0.272597 19.0638889 0.271713 19.0666667 0.269650 19.0694444 0.266409 19.0722222 0.265820 19.0750000 0.269355 19.0777778 0.276427 19.0805556 0.285267 19.0833333 0.294401 19.0861111 0.305893 19.0888889 0.323278 19.0916667 0.338895 19.0944444 0.348913 19.0972222 0.351860 19.1000000 0.344788 19.1027778 0.327109 19.1055556 0.304125 19.1083333 0.285856 19.1111111 0.274954 19.1138889 0.271418 19.1166667 0.271713 19.1194444 0.274659 19.1222222 0.276427 19.1250000 0.276722 19.1277778 0.276427 19.1305556 0.276427 19.1333333 0.276722 19.1361111 0.277017 19.1388889 0.277901 19.1416667 0.278490 19.1444444 0.278195 19.1472222 0.277311 19.1500000 0.276722 19.1527778 0.276133 19.1555556 0.277017 19.1583333 0.277017 19.1611111 0.277311 19.1638889 0.277606 19.1666667 0.276722 19.1694444 0.276427 19.1722222 0.277606 19.1750000 0.277606 19.1777778 0.277901 19.1805556 0.277311 19.1833333 0.276722 19.1861111 0.276133 19.1888889 0.276427 19.1916667 0.276722 19.1944444 0.276722 19.1972222 0.277606 19.2000000 0.276722 19.2027778 0.277017 19.2055556 0.276722 19.2183333 0.300000 19.8177778 0.300000 19.8277778 0.279669 19.8305556 0.278785 19.8333333 0.278490 19.8361111 0.277311 19.8388889 0.277017 19.8416667 0.276133 19.8444444 0.274659 19.8472222 0.273481 19.8500000 0.272302 19.8527778 0.269650 19.8555556 0.267587 19.8583333 0.266703 19.8611111 0.270239 19.8638889 0.275249 19.8666667 0.282615 19.8694444 0.292339 19.8722222 0.304715 19.8750000 0.321215 19.8777778 0.336538 19.8805556 0.349208 19.8833333 0.354217 19.8861111 0.348913 19.8888889 0.332118 19.8916667 0.309429 19.8944444 0.289392 19.8972222 0.276722 19.9000000 0.271123 19.9027778 0.269650 19.9055556 0.272302 19.9083333 0.274954 19.9111111 0.275838 19.9138889 0.275838 19.9166667 0.275543 19.9194444 0.275838 19.9222222 0.276133 19.9250000 0.276722 19.9277778 0.276722 19.9305556 0.276722 19.9333333 0.276133 19.9361111 0.275838 19.9388889 0.276427 19.9416667 0.276133 19.9444444 0.276722 19.9472222 0.276427 19.9500000 0.275838 19.9527778 0.275249 19.9555556 0.275543 19.9583333 0.275543 19.9611111 0.276133 19.9638889 0.275838 19.9666667 0.274659 19.9694444 0.273775 19.9722222 0.273775 19.9750000 0.274954 19.9777778 0.275543 19.9805556 0.275249 19.9833333 0.275249 19.9861111 0.274954 19.9888889 0.275249 19.9916667 0.274954 20.0044444 0.300000 20.6288889 0.300000 20.6388889 0.275543 20.6416667 0.276427 20.6444444 0.276133 20.6472222 0.274659 20.6500000 0.271713 20.6527778 0.269061 20.6555556 0.267587 20.6583333 0.266409 20.6611111 0.264936 20.6638889 0.261989 20.6666667 0.262284 20.6694444 0.266409 20.6722222 0.274070 20.6750000 0.280258 20.6777778 0.285267 20.6805556 0.291160 20.6833333 0.299116 20.6861111 0.309429 20.6888889 0.324162 20.6916667 0.339190 20.6944444 0.350387 20.6972222 0.356280 20.7000000 0.353628 20.7027778 0.338011 20.7055556 0.312670 20.7083333 0.288508 20.7111111 0.273775 20.7138889 0.268177 20.7166667 0.269945 20.7194444 0.271418 20.7222222 0.274365 20.7250000 0.273775 20.7277778 0.274070 20.7305556 0.274070 20.7333333 0.274070 20.7361111 0.273481 20.7388889 0.273186 20.7416667 0.273186 20.7444444 0.273481 20.7472222 0.273186 20.7500000 0.272891 20.7527778 0.272302 20.7555556 0.272597 20.7583333 0.273481 20.7611111 0.274070 20.7638889 0.273481 20.7666667 0.273775 20.7694444 0.272891 20.7722222 0.272891 20.7750000 0.274070 20.7777778 0.273775 20.7805556 0.273775 20.7833333 0.273481 20.7861111 0.273186 20.7888889 0.273481 20.7916667 0.273186 20.7944444 0.274365 20.7972222 0.273186 20.8000000 0.273481 20.8027778 0.273186 20.8155556 0.300000 21.4455556 0.300000 21.4555556 0.274070 21.4583333 0.273186 21.4611111 0.274659 21.4638889 0.274070 21.4666667 0.273186 21.4694444 0.271713 21.4722222 0.269945 21.4750000 0.267882 21.4777778 0.266703 21.4805556 0.265820 21.4833333 0.262578 21.4861111 0.260810 21.4888889 0.262873 21.4916667 0.269945 21.4944444 0.279079 21.4972222 0.288214 21.5000000 0.298527 21.5027778 0.314144 21.5055556 0.331823 21.5083333 0.344494 21.5111111 0.349797 21.5138889 0.346851 21.5166667 0.332413 21.5194444 0.307072 21.5222222 0.283204 21.5250000 0.269355 21.5277778 0.265525 21.5305556 0.266998 21.5333333 0.269355 21.5361111 0.270534 21.5388889 0.272302 21.5416667 0.272007 21.5444444 0.272302 21.5472222 0.272891 21.5500000 0.271713 21.5527778 0.271418 21.5555556 0.271418 21.5583333 0.272302 21.5611111 0.272597 21.5638889 0.272007 21.5666667 0.271713 21.5694444 0.271123 21.5722222 0.271418 21.5750000 0.272007 21.5777778 0.272302 21.5805556 0.272007 21.5833333 0.271123 21.5861111 0.270829 21.5888889 0.270829 21.5916667 0.270829 21.5944444 0.271713 21.5972222 0.271123 21.6000000 0.271418 21.6027778 0.270829 21.6055556 0.271123 21.6083333 0.271418 21.6111111 0.271713 21.6138889 0.272007 21.6166667 0.271418 21.6194444 0.271123 21.6322222 0.300000 22.2733333 0.300000 22.2833333 0.271418 22.2861111 0.270829 22.2888889 0.270829 22.2916667 0.271123 22.2944444 0.271123 22.2972222 0.269061 22.3000000 0.267293 22.3027778 0.264641 22.3055556 0.264052 22.3083333 0.263462 22.3111111 0.261400 22.3138889 0.259926 22.3166667 0.261400 22.3194444 0.266114 22.3222222 0.273775 22.3250000 0.281731 22.3277778 0.292339 22.3305556 0.307366 22.3333333 0.323278 22.3361111 0.335359 22.3388889 0.342726 22.3416667 0.342136 22.3444444 0.331234 22.3472222 0.310902 22.3500000 0.288508 22.3527778 0.273186 22.3555556 0.265230 22.3583333 0.263757 22.3611111 0.265525 22.3638889 0.267882 22.3666667 0.268471 22.3694444 0.268471 22.3722222 0.268471 22.3750000 0.269061 22.3777778 0.270239 22.3805556 0.269650 22.3833333 0.270239 22.3861111 0.269650 22.3888889 0.269650 22.3916667 0.271123 22.3944444 0.270829 22.3972222 0.270534 22.4000000 0.271123 22.4027778 0.269355 22.4055556 0.269945 22.4083333 0.269355 22.4111111 0.270239 22.4138889 0.270239 22.4166667 0.270239 22.4194444 0.269650 22.4222222 0.269650 22.4250000 0.270534 22.4277778 0.269945 22.4305556 0.269650 22.4333333 0.269061 22.4361111 0.268766 22.4388889 0.269061 22.4416667 0.268471 22.4444444 0.269355 22.4472222 0.269061 22.4600000 0.300000 23.1177778 0.300000 23.1277778 0.271713 23.1305556 0.272891 23.1333333 0.271713 23.1361111 0.271418 23.1388889 0.271418 23.1416667 0.270829 23.1444444 0.269061 23.1472222 0.268177 23.1500000 0.266409 23.1527778 0.264936 23.1555556 0.262578 23.1583333 0.260516 23.1611111 0.262873 23.1638889 0.268177 23.1666667 0.275543 23.1694444 0.283499 23.1722222 0.295285 23.1750000 0.309724 23.1777778 0.325635 23.1805556 0.339779 23.1833333 0.347145 23.1861111 0.348913 23.1888889 0.338895 23.1916667 0.320331 23.1944444 0.297643 23.1972222 0.279374 23.2000000 0.268766 23.2027778 0.264346 23.2055556 0.263168 23.2083333 0.265230 23.2111111 0.267882 23.2138889 0.269355 23.2166667 0.269945 23.2194444 0.268766 23.2222222 0.269650 23.2250000 0.270534 23.2277778 0.270829 23.2305556 0.270829 23.2333333 0.270239 23.2361111 0.270239 23.2388889 0.270239 23.2416667 0.270829 23.2444444 0.270534 23.2472222 0.270534 23.2500000 0.270534 23.2527778 0.269355 23.2555556 0.270239 23.2583333 0.270829 23.2611111 0.270829 23.2638889 0.270534 23.2666667 0.269945 23.2694444 0.269650 23.2722222 0.269945 23.2750000 0.270534 23.2777778 0.271713 23.2805556 0.270534 23.2833333 0.270239 23.2861111 0.269355 23.2888889 0.269650 23.2916667 0.270239 23.3044444 0.300000 23.9233333 0.300000 23.9333333 0.275249 23.9361111 0.274659 23.9388889 0.274954 23.9416667 0.275543 23.9444444 0.274659 23.9472222 0.273481 23.9500000 0.271123 23.9527778 0.268177 23.9555556 0.267587 23.9583333 0.266409 23.9611111 0.264936 23.9638889 0.264346 23.9666667 0.267293 23.9694444 0.274954 23.9722222 0.284972 23.9750000 0.295285 23.9777778 0.309429 23.9805556 0.326225 23.9833333 0.341547 23.9861111 0.352155 23.9888889 0.359227 23.9916667 0.361584 23.9944444 0.357459 23.9972222 0.343610 24.0000000 0.320626 24.0027778 0.295875 24.0055556 0.276133 24.0083333 0.267587 24.0111111 0.266998 24.0138889 0.268471 24.0166667 0.270534 24.0194444 0.273186 24.0222222 0.273186 24.0250000 0.273775 24.0277778 0.273775 24.0305556 0.274070 24.0333333 0.273186 24.0361111 0.272597 24.0388889 0.272597 24.0416667 0.272597 24.0444444 0.272597 24.0472222 0.272597 24.0500000 0.271713 24.0527778 0.271418 24.0555556 0.271713 24.0583333 0.272302 24.0611111 0.272302 24.0638889 0.272891 24.0666667 0.272891 24.0694444 0.272007 24.0722222 0.272007 24.0750000 0.272302 24.0777778 0.273186 24.0805556 0.273186 24.0833333 0.272891 24.0861111 0.272891 24.0888889 0.272891 24.0916667 0.273186 24.0944444 0.273481 24.0972222 0.273481 24.1100000 0.300000 24.6983333 0.300000 24.7083333 0.277017 24.7111111 0.277017 24.7138889 0.277017 24.7166667 0.276722 24.7194444 0.275543 24.7222222 0.274954 24.7250000 0.274365 24.7277778 0.272007 24.7305556 0.270534 24.7333333 0.269061 24.7361111 0.266409 24.7388889 0.264346 24.7416667 0.264936 24.7444444 0.270534 24.7472222 0.278785 24.7500000 0.286446 24.7527778 0.296759 24.7555556 0.311786 24.7583333 0.329466 24.7611111 0.343020 24.7638889 0.350387 24.7666667 0.349208 24.7694444 0.336538 24.7722222 0.313260 24.7750000 0.290571 24.7777778 0.275543 24.7805556 0.269061 24.7833333 0.269650 24.7861111 0.272302 24.7888889 0.274365 24.7916667 0.275543 24.7944444 0.275543 24.7972222 0.275838 24.8000000 0.276133 24.8027778 0.275543 24.8055556 0.275249 24.8083333 0.275543 24.8111111 0.276427 24.8138889 0.275543 24.8166667 0.275249 24.8194444 0.274659 24.8222222 0.275249 24.8250000 0.276133 24.8277778 0.275838 24.8305556 0.276427 24.8333333 0.275543 24.8361111 0.274659 24.8388889 0.275249 24.8416667 0.274954 24.8444444 0.276133 24.8472222 0.275838 24.8500000 0.275249 24.8527778 0.274365 24.8555556 0.274659 24.8583333 0.274954 24.8611111 0.275543 24.8638889 0.275249 24.8666667 0.274954 24.8694444 0.274365 24.8722222 0.274954 24.8850000 0.300000 25.4983333 0.300000 25.5083333 0.275838 25.5111111 0.275543 25.5138889 0.274954 25.5166667 0.273186 25.5194444 0.270534 25.5222222 0.269945 25.5250000 0.269355 25.5277778 0.269355 25.5305556 0.266409 25.5333333 0.263757 25.5361111 0.261400 25.5388889 0.262284 25.5416667 0.266409 25.5444444 0.272007 25.5472222 0.278785 25.5500000 0.286151 25.5527778 0.297643 25.5555556 0.314144 25.5583333 0.330350 25.5611111 0.341842 25.5638889 0.346851 25.5666667 0.342431 25.5694444 0.325635 25.5722222 0.303831 25.5750000 0.285267 25.5777778 0.273775 25.5805556 0.268471 25.5833333 0.267587 25.5861111 0.269945 25.5888889 0.271713 25.5916667 0.273481 25.5944444 0.273481 25.5972222 0.273775 25.6000000 0.274070 25.6027778 0.273186 25.6055556 0.273481 25.6083333 0.273481 25.6111111 0.274070 25.6138889 0.274070 25.6166667 0.273775 25.6194444 0.273481 25.6222222 0.273186 25.6250000 0.273775 25.6277778 0.274365 25.6305556 0.274659 25.6333333 0.274070 25.6361111 0.273186 25.6388889 0.273775 25.6416667 0.273775 25.6444444 0.274070 25.6472222 0.274365 25.6500000 0.272891 25.6527778 0.272891 25.6555556 0.273186 25.6583333 0.272597 25.6611111 0.273481 25.6638889 0.273775 25.6666667 0.272302 25.6694444 0.271418 25.6722222 0.272597 25.6850000 0.300000 27.5638889 0.300000)
Vsr sample_r_trig 0 PWL(0.0000000 0.000000 1.9995000 0.000000 2.0000000 0.900000 2.0010000 0.900000 2.0015000 0.000000 2.8161667 0.000000 2.8166667 0.900000 2.8176667 0.900000 2.8181667 0.000000 3.4689444 0.000000 3.4694444 0.900000 3.4704444 0.900000 3.4709444 0.000000 4.4633889 0.000000 4.4638889 0.900000 4.4648889 0.900000 4.4653889 0.000000 5.3078333 0.000000 5.3083333 0.900000 5.3093333 0.900000 5.3098333 0.000000 6.1189444 0.000000 6.1194444 0.900000 6.1204444 0.900000 6.1209444 0.000000 6.9078333 0.000000 6.9083333 0.900000 6.9093333 0.900000 6.9098333 0.000000 7.6800556 0.000000 7.6805556 0.900000 7.6815556 0.900000 7.6820556 0.000000 8.5189444 0.000000 8.5194444 0.900000 8.5204444 0.900000 8.5209444 0.000000 9.3745000 0.000000 9.3750000 0.900000 9.3760000 0.900000 9.3765000 0.000000 10.1967222 0.000000 10.1972222 0.900000 10.1982222 0.900000 10.1987222 0.000000 11.0245000 0.000000 11.0250000 0.900000 11.0260000 0.900000 11.0265000 0.000000 11.8467222 0.000000 11.8472222 0.900000 11.8482222 0.900000 11.8487222 0.000000 12.6411667 0.000000 12.6416667 0.900000 12.6426667 0.900000 12.6431667 0.000000 13.4383889 0.000000 13.4388889 0.900000 13.4398889 0.900000 13.4403889 0.000000 14.2300556 0.000000 14.2305556 0.900000 14.2315556 0.900000 14.2320556 0.000000 15.0522778 0.000000 15.0527778 0.900000 15.0537778 0.900000 15.0542778 0.000000 15.9217222 0.000000 15.9222222 0.900000 15.9232222 0.900000 15.9237222 0.000000 16.7439444 0.000000 16.7444444 0.900000 16.7454444 0.900000 16.7459444 0.000000 17.5300556 0.000000 17.5305556 0.900000 17.5315556 0.900000 17.5320556 0.000000 18.3217222 0.000000 18.3222222 0.900000 18.3232222 0.900000 18.3237222 0.000000 19.0967222 0.000000 19.0972222 0.900000 19.0982222 0.900000 19.0987222 0.000000 19.8828333 0.000000 19.8833333 0.900000 19.8843333 0.900000 19.8848333 0.000000 20.6939444 0.000000 20.6944444 0.900000 20.6954444 0.900000 20.6959444 0.000000 21.5106111 0.000000 21.5111111 0.900000 21.5121111 0.900000 21.5126111 0.000000 22.3383889 0.000000 22.3388889 0.900000 22.3398889 0.900000 22.3403889 0.000000 23.1828333 0.000000 23.1833333 0.900000 23.1843333 0.900000 23.1848333 0.000000 23.9883889 0.000000 23.9888889 0.900000 23.9898889 0.900000 23.9903889 0.000000 24.7633889 0.000000 24.7638889 0.900000 24.7648889 0.900000 24.7653889 0.000000 25.5633889 0.000000 25.5638889 0.900000 25.5648889 0.900000 25.5653889 0.000000 27.5638889 0.000000)

Xsym ecg_in sample_r_trig sym_out vdd vss qrs_symmetry

.tran 0.1m 27.5639

.meas tran sym_b0 FIND V(sym_out) AT=2.0060000
.meas tran sym_b1 FIND V(sym_out) AT=2.8226667
.meas tran sym_b2 FIND V(sym_out) AT=3.4754444
.meas tran sym_b3 FIND V(sym_out) AT=4.4698889
.meas tran sym_b4 FIND V(sym_out) AT=5.3143333
.meas tran sym_b5 FIND V(sym_out) AT=6.1254444
.meas tran sym_b6 FIND V(sym_out) AT=6.9143333
.meas tran sym_b7 FIND V(sym_out) AT=7.6865556
.meas tran sym_b8 FIND V(sym_out) AT=8.5254444
.meas tran sym_b9 FIND V(sym_out) AT=9.3810000
.meas tran sym_b10 FIND V(sym_out) AT=10.2032222
.meas tran sym_b11 FIND V(sym_out) AT=11.0310000
.meas tran sym_b12 FIND V(sym_out) AT=11.8532222
.meas tran sym_b13 FIND V(sym_out) AT=12.6476667
.meas tran sym_b14 FIND V(sym_out) AT=13.4448889
.meas tran sym_b15 FIND V(sym_out) AT=14.2365556
.meas tran sym_b16 FIND V(sym_out) AT=15.0587778
.meas tran sym_b17 FIND V(sym_out) AT=15.9282222
.meas tran sym_b18 FIND V(sym_out) AT=16.7504444
.meas tran sym_b19 FIND V(sym_out) AT=17.5365556
.meas tran sym_b20 FIND V(sym_out) AT=18.3282222
.meas tran sym_b21 FIND V(sym_out) AT=19.1032222
.meas tran sym_b22 FIND V(sym_out) AT=19.8893333
.meas tran sym_b23 FIND V(sym_out) AT=20.7004444
.meas tran sym_b24 FIND V(sym_out) AT=21.5171111
.meas tran sym_b25 FIND V(sym_out) AT=22.3448889
.meas tran sym_b26 FIND V(sym_out) AT=23.1893333
.meas tran sym_b27 FIND V(sym_out) AT=23.9948889
.meas tran sym_b28 FIND V(sym_out) AT=24.7698889
.meas tran sym_b29 FIND V(sym_out) AT=25.5698889

.end
