.title rpeak_chain_test
.lib "C:/Users/kadhi/OneDrive/Desktop/amux/verilogLearning/Leaky-Integrate-Fire---SNN-model-on-FPGA/experiments/frontend_optimization/ngspice_frontend/sky130_minimal.lib.spice" tt
.option scale=1.0u method=gear reltol=0.01 gmin=1e-15
.temp 27

Vdd vdd 0 0.9
Vss vss 0 0
Vbias vbias 0 0.300

Vecg ecg_l0 0 PWL(0.0000000 0.300000 1.7470000 0.300000 1.7500000 0.282026 1.7527778 0.281731 1.7555556 0.282320 1.7583333 0.282026 1.7611111 0.282910 1.7638889 0.282320 1.7666667 0.282320 1.7694444 0.282026 1.7722222 0.282026 1.7750000 0.282910 1.7777778 0.283499 1.7805556 0.282615 1.7833333 0.282026 1.7861111 0.281436 1.7888889 0.282026 1.7916667 0.282615 1.7944444 0.282910 1.7972222 0.283499 1.8000000 0.284088 1.8027778 0.283794 1.8055556 0.283794 1.8083333 0.284088 1.8111111 0.285267 1.8138889 0.285267 1.8166667 0.284972 1.8194444 0.286740 1.8222222 0.287035 1.8250000 0.287919 1.8277778 0.288214 1.8305556 0.287919 1.8333333 0.287330 1.8361111 0.286446 1.8388889 0.287035 1.8416667 0.286740 1.8444444 0.286740 1.8472222 0.286740 1.8500000 0.286446 1.8527778 0.286151 1.8555556 0.285856 1.8583333 0.286151 1.8611111 0.287035 1.8638889 0.287624 1.8666667 0.287919 1.8694444 0.285562 1.8722222 0.283204 1.8750000 0.283204 1.8777778 0.282320 1.8805556 0.281731 1.8833333 0.280552 1.8861111 0.280552 1.8888889 0.280847 1.8916667 0.281436 1.8944444 0.281142 1.8972222 0.281436 1.9000000 0.280847 1.9027778 0.279963 1.9055556 0.279669 1.9083333 0.279963 1.9111111 0.279963 1.9138889 0.279374 1.9166667 0.279669 1.9194444 0.279079 1.9222222 0.280552 1.9250000 0.280258 1.9277778 0.280552 1.9305556 0.281142 1.9333333 0.279669 1.9361111 0.279079 1.9388889 0.279963 1.9416667 0.280552 1.9444444 0.280847 1.9472222 0.280552 1.9500000 0.279374 1.9527778 0.278490 1.9555556 0.278785 1.9583333 0.277606 1.9611111 0.274954 1.9638889 0.273775 1.9666667 0.272007 1.9694444 0.269945 1.9722222 0.268471 1.9750000 0.270239 1.9777778 0.275543 1.9805556 0.282320 1.9833333 0.290571 1.9861111 0.299116 1.9888889 0.313849 1.9916667 0.328877 1.9944444 0.342431 1.9972222 0.351565 2.0000000 0.355396 2.0027778 0.353333 2.0055556 0.344494 2.0083333 0.328877 2.0111111 0.309724 2.0138889 0.293517 2.0166667 0.284088 2.0194444 0.277017 2.0222222 0.273481 2.0250000 0.272007 2.0277778 0.273186 2.0305556 0.274954 2.0333333 0.277017 2.0361111 0.277017 2.0388889 0.277311 2.0416667 0.277017 2.0444444 0.277606 2.0472222 0.277606 2.0500000 0.277606 2.0527778 0.276722 2.0555556 0.277311 2.0583333 0.277311 2.0611111 0.277311 2.0638889 0.277901 2.0666667 0.276722 2.0694444 0.275838 2.0722222 0.275838 2.0750000 0.276427 2.0777778 0.276722 2.0805556 0.277017 2.0833333 0.276133 2.0861111 0.276722 2.0888889 0.277311 2.0916667 0.277901 2.0944444 0.277017 2.0972222 0.277017 2.1000000 0.276133 2.1027778 0.275838 2.1055556 0.275838 2.1083333 0.277017 2.1111111 0.277017 2.1138889 0.276722 2.1166667 0.276133 2.1194444 0.275543 2.1222222 0.276427 2.1250000 0.275838 2.1277778 0.276133 2.1305556 0.275838 2.1333333 0.275543 2.1361111 0.275838 2.1388889 0.276427 2.1416667 0.276427 2.1444444 0.276722 2.1472222 0.277017 2.1500000 0.276133 2.1527778 0.275838 2.1555556 0.277017 2.1583333 0.277017 2.1611111 0.277311 2.1638889 0.277311 2.1666667 0.275838 2.1694444 0.276133 2.1722222 0.276722 2.1750000 0.277017 2.1777778 0.277901 2.1805556 0.277017 2.1833333 0.276722 2.1861111 0.275838 2.1888889 0.276427 2.1916667 0.277017 2.1944444 0.277017 2.1972222 0.277311 2.2000000 0.276133 2.2027778 0.275543 2.2055556 0.275543 2.2083333 0.276427 2.2111111 0.276722 2.2138889 0.276133 2.2166667 0.275543 2.2194444 0.275249 2.2222222 0.275249 2.2250000 0.275838 2.2277778 0.275543 2.2305556 0.274954 2.2333333 0.275249 2.2361111 0.274365 2.2388889 0.274659 2.2416667 0.274659 2.2444444 0.275249 2.2472222 0.274659 2.2500000 0.273481 2.2527778 0.273186 2.2555556 0.273481 2.2583333 0.274365 2.2611111 0.273775 2.2638889 0.273481 2.2666667 0.273186 2.2694444 0.272302 2.2722222 0.272891 2.2750000 0.273186 2.2777778 0.273481 2.2805556 0.273186 2.2833333 0.272302 2.2861111 0.272007 2.2888889 0.272891 2.2916667 0.273481 2.2944444 0.273775 2.2972222 0.274070 2.3030000 0.300000 2.5581111 0.300000 2.5611111 0.280552 2.5638889 0.279669 2.5666667 0.279669 2.5694444 0.279079 2.5722222 0.279374 2.5750000 0.279963 2.5777778 0.280552 2.5805556 0.279963 2.5833333 0.279963 2.5861111 0.279963 2.5888889 0.280552 2.5916667 0.280258 2.5944444 0.280552 2.5972222 0.280258 2.6000000 0.279669 2.6027778 0.279669 2.6055556 0.279963 2.6083333 0.280552 2.6111111 0.281436 2.6138889 0.282615 2.6166667 0.282320 2.6194444 0.282615 2.6222222 0.283204 2.6250000 0.283794 2.6277778 0.284383 2.6305556 0.284383 2.6333333 0.284383 2.6361111 0.284972 2.6388889 0.285267 2.6416667 0.285856 2.6444444 0.286740 2.6472222 0.287330 2.6500000 0.285856 2.6527778 0.285562 2.6555556 0.285856 2.6583333 0.285562 2.6611111 0.286151 2.6638889 0.285562 2.6666667 0.285267 2.6694444 0.283794 2.6722222 0.283794 2.6750000 0.284383 2.6777778 0.285267 2.6805556 0.286740 2.6833333 0.287035 2.6861111 0.286446 2.6888889 0.284383 2.6916667 0.284088 2.6944444 0.283499 2.6972222 0.283204 2.7000000 0.282026 2.7027778 0.281142 2.7055556 0.279963 2.7083333 0.280552 2.7111111 0.280258 2.7138889 0.280258 2.7166667 0.279079 2.7194444 0.278195 2.7222222 0.278785 2.7250000 0.279669 2.7277778 0.279374 2.7305556 0.279079 2.7333333 0.278490 2.7361111 0.277901 2.7388889 0.277606 2.7416667 0.278195 2.7444444 0.278490 2.7472222 0.278490 2.7500000 0.277606 2.7527778 0.277311 2.7555556 0.277606 2.7583333 0.277901 2.7611111 0.279079 2.7638889 0.278195 2.7666667 0.277017 2.7694444 0.276133 2.7722222 0.275838 2.7750000 0.274365 2.7777778 0.272597 2.7805556 0.271123 2.7833333 0.269355 2.7861111 0.267293 2.7888889 0.266409 2.7916667 0.269061 2.7944444 0.276133 2.7972222 0.285267 2.8000000 0.294696 2.8027778 0.307072 2.8055556 0.324162 2.8083333 0.340663 2.8111111 0.352155 2.8138889 0.356575 2.8166667 0.350092 2.8194444 0.330645 2.8222222 0.302947 2.8250000 0.281142 2.8277778 0.270534 2.8305556 0.270239 2.8333333 0.273775 2.8361111 0.275543 2.8388889 0.276722 2.8416667 0.277017 2.8444444 0.276722 2.8472222 0.277017 2.8500000 0.276722 2.8527778 0.276133 2.8555556 0.276722 2.8583333 0.276133 2.8611111 0.277017 2.8638889 0.276722 2.8666667 0.276722 2.8694444 0.275838 2.8722222 0.276133 2.8750000 0.276427 2.8777778 0.276427 2.8805556 0.275543 2.8833333 0.276133 2.8861111 0.275249 2.8888889 0.275543 2.8916667 0.276133 2.8944444 0.276133 2.8972222 0.275249 2.9000000 0.275249 2.9027778 0.274365 2.9055556 0.275249 2.9083333 0.275838 2.9111111 0.275838 2.9138889 0.276133 2.9166667 0.274954 2.9194444 0.274659 2.9222222 0.275249 2.9250000 0.275543 2.9277778 0.275838 2.9305556 0.275838 2.9333333 0.274954 2.9361111 0.275249 2.9388889 0.276427 2.9416667 0.276722 2.9444444 0.276427 2.9472222 0.276427 2.9500000 0.276722 2.9527778 0.275543 2.9555556 0.276133 2.9583333 0.277017 2.9611111 0.276427 2.9638889 0.276427 2.9666667 0.275543 2.9694444 0.274954 2.9722222 0.274954 2.9750000 0.275543 2.9777778 0.275543 2.9805556 0.275838 2.9833333 0.274954 2.9861111 0.274954 2.9888889 0.275249 2.9916667 0.275543 2.9944444 0.276427 2.9972222 0.276427 3.0000000 0.275838 3.0027778 0.274954 3.0055556 0.275838 3.0083333 0.276133 3.0111111 0.276722 3.0138889 0.276427 3.0166667 0.276427 3.0194444 0.276133 3.0222222 0.277311 3.0250000 0.276427 3.0277778 0.277017 3.0305556 0.277017 3.0333333 0.276427 3.0361111 0.275543 3.0388889 0.276133 3.0416667 0.276133 3.0444444 0.275838 3.0472222 0.275543 3.0500000 0.275249 3.0527778 0.275249 3.0555556 0.274954 3.0583333 0.275543 3.0611111 0.275543 3.0638889 0.275838 3.0666667 0.274365 3.0694444 0.274659 3.0722222 0.274365 3.0750000 0.275249 3.0777778 0.275249 3.0805556 0.275249 3.0833333 0.275249 3.0861111 0.274954 3.0888889 0.274954 3.0916667 0.275543 3.0944444 0.276722 3.0972222 0.276722 3.1000000 0.277017 3.1027778 0.277901 3.1055556 0.278785 3.1083333 0.279963 3.1141111 0.300000 3.3470000 0.300000 3.3500000 0.277901 3.3527778 0.277311 3.3555556 0.279079 3.3583333 0.278785 3.3611111 0.279079 3.3638889 0.278785 3.3666667 0.278785 3.3694444 0.278195 3.3722222 0.278785 3.3750000 0.279669 3.3777778 0.279079 3.3805556 0.279669 3.3833333 0.279669 3.3861111 0.279669 3.3888889 0.279963 3.3916667 0.281731 3.3944444 0.282026 3.3972222 0.282026 3.4000000 0.281731 3.4027778 0.282026 3.4055556 0.282910 3.4083333 0.283204 3.4111111 0.283794 3.4138889 0.283499 3.4166667 0.283499 3.4194444 0.283794 3.4222222 0.284383 3.4250000 0.284972 3.4277778 0.285562 3.4305556 0.284678 3.4333333 0.284383 3.4361111 0.283794 3.4388889 0.283499 3.4416667 0.284383 3.4444444 0.284088 3.4472222 0.283794 3.4500000 0.283499 3.4527778 0.283794 3.4555556 0.283499 3.4583333 0.283794 3.4611111 0.284383 3.4638889 0.284972 3.4666667 0.285856 3.4694444 0.284678 3.4722222 0.283499 3.4750000 0.281731 3.4777778 0.281731 3.4805556 0.279669 3.4833333 0.278785 3.4861111 0.277606 3.4888889 0.277311 3.4916667 0.277606 3.4944444 0.278195 3.4972222 0.277901 3.5000000 0.277311 3.5027778 0.277017 3.5055556 0.276722 3.5083333 0.277311 3.5111111 0.277311 3.5138889 0.277311 3.5166667 0.276722 3.5194444 0.276133 3.5222222 0.276427 3.5250000 0.277901 3.5277778 0.277901 3.5305556 0.277017 3.5333333 0.276722 3.5361111 0.275543 3.5388889 0.276133 3.5416667 0.276427 3.5444444 0.277017 3.5472222 0.276133 3.5500000 0.274954 3.5527778 0.272891 3.5555556 0.272007 3.5583333 0.270239 3.5611111 0.269945 3.5638889 0.269061 3.5666667 0.268177 3.5694444 0.264641 3.5722222 0.261989 3.5750000 0.262873 3.5777778 0.266114 3.5805556 0.270829 3.5833333 0.277311 3.5861111 0.284088 3.5888889 0.293223 3.5916667 0.305304 3.5944444 0.321805 3.5972222 0.337422 3.6000000 0.347735 3.6027778 0.350681 3.6055556 0.345378 3.6083333 0.327993 3.6111111 0.303831 3.6138889 0.282026 3.6166667 0.270534 3.6194444 0.269355 3.6222222 0.272007 3.6250000 0.275838 3.6277778 0.277017 3.6305556 0.277017 3.6333333 0.276427 3.6361111 0.275838 3.6388889 0.276133 3.6416667 0.277311 3.6444444 0.277017 3.6472222 0.276722 3.6500000 0.276133 3.6527778 0.275838 3.6555556 0.276133 3.6583333 0.276427 3.6611111 0.277017 3.6638889 0.276722 3.6666667 0.275838 3.6694444 0.275543 3.6722222 0.275838 3.6750000 0.276722 3.6777778 0.276133 3.6805556 0.275838 3.6833333 0.276133 3.6861111 0.276133 3.6888889 0.275838 3.6916667 0.277017 3.6944444 0.277311 3.6972222 0.277017 3.7000000 0.276722 3.7027778 0.276427 3.7055556 0.276427 3.7083333 0.276427 3.7111111 0.276722 3.7138889 0.276722 3.7166667 0.276133 3.7194444 0.276133 3.7222222 0.276427 3.7250000 0.276722 3.7277778 0.277311 3.7305556 0.277901 3.7333333 0.277311 3.7361111 0.276722 3.7388889 0.277017 3.7416667 0.277311 3.7444444 0.277901 3.7472222 0.277311 3.7500000 0.276722 3.7527778 0.276722 3.7555556 0.277311 3.7583333 0.277901 3.7611111 0.277901 3.7638889 0.277311 3.7666667 0.276722 3.7694444 0.277017 3.7722222 0.277017 3.7750000 0.278490 3.7777778 0.277901 3.7805556 0.277311 3.7833333 0.276722 3.7861111 0.277606 3.7888889 0.277311 3.7916667 0.277901 3.7944444 0.277606 3.7972222 0.277017 3.8000000 0.277606 3.8027778 0.277901 3.8055556 0.277901 3.8083333 0.277901 3.8111111 0.277901 3.8138889 0.277606 3.8166667 0.277017 3.8194444 0.277017 3.8222222 0.278490 3.8250000 0.278195 3.8277778 0.277901 3.8305556 0.277311 3.8333333 0.277017 3.8361111 0.277017 3.8388889 0.277901 3.8416667 0.278490 3.8444444 0.277311 3.8472222 0.277606 3.8500000 0.277017 3.8527778 0.277901 3.8555556 0.277901 3.8583333 0.278490 3.8611111 0.278195 3.8638889 0.277311 3.8666667 0.276722 3.8694444 0.277311 3.8722222 0.277311 3.8750000 0.278195 3.8777778 0.278490 3.8805556 0.278195 3.8833333 0.277901 3.8861111 0.279374 3.8888889 0.280258 3.8916667 0.281142 3.8944444 0.281436 3.8972222 0.281142 3.9030000 0.300000 4.1386667 0.300000 4.1416667 0.279669 4.1444444 0.279669 4.1472222 0.279374 4.1500000 0.279079 4.1527778 0.279669 4.1555556 0.280552 4.1583333 0.280552 4.1611111 0.280258 4.1638889 0.280258 4.1666667 0.279963 4.1694444 0.280552 4.1722222 0.281142 4.1750000 0.282910 4.1777778 0.282910 4.1805556 0.282320 4.1833333 0.282026 4.1861111 0.283204 4.1888889 0.283499 4.1916667 0.283794 4.1944444 0.283499 4.1972222 0.283794 4.2000000 0.284088 4.2027778 0.284383 4.2055556 0.285267 4.2083333 0.286446 4.2111111 0.285562 4.2138889 0.285856 4.2166667 0.284972 4.2194444 0.284972 4.2222222 0.285562 4.2250000 0.286151 4.2277778 0.284972 4.2305556 0.284383 4.2333333 0.284678 4.2361111 0.284972 4.2388889 0.284088 4.2416667 0.284383 4.2444444 0.283499 4.2472222 0.284972 4.2500000 0.285267 4.2527778 0.285562 4.2555556 0.284383 4.2583333 0.283499 4.2611111 0.282320 4.2638889 0.281436 4.2666667 0.280847 4.2694444 0.280258 4.2722222 0.279669 4.2750000 0.280552 4.2777778 0.280258 4.2805556 0.279669 4.2833333 0.278785 4.2861111 0.279374 4.2888889 0.279963 4.2916667 0.280258 4.2944444 0.279669 4.2972222 0.278785 4.3000000 0.278490 4.3027778 0.277901 4.3055556 0.278195 4.3083333 0.278490 4.3111111 0.278490 4.3138889 0.277606 4.3166667 0.277901 4.3194444 0.277901 4.3222222 0.278490 4.3250000 0.278195 4.3277778 0.278785 4.3305556 0.278195 4.3333333 0.277606 4.3361111 0.278490 4.3388889 0.278785 4.3416667 0.279374 4.3444444 0.279079 4.3472222 0.278195 4.3500000 0.277311 4.3527778 0.276722 4.3555556 0.274659 4.3583333 0.273775 4.3611111 0.271418 4.3638889 0.269650 4.3666667 0.266703 4.3694444 0.267293 4.3722222 0.272007 4.3750000 0.279079 4.3777778 0.287035 4.3805556 0.296759 4.3833333 0.310902 4.3861111 0.327993 4.3888889 0.341547 4.3916667 0.348324 4.3944444 0.345967 4.3972222 0.331529 4.4000000 0.308545 4.4027778 0.288214 4.4055556 0.275249 4.4083333 0.270534 4.4111111 0.271713 4.4138889 0.273481 4.4166667 0.275838 4.4194444 0.276427 4.4222222 0.277017 4.4250000 0.277017 4.4277778 0.276427 4.4305556 0.276133 4.4333333 0.274954 4.4361111 0.274954 4.4388889 0.276133 4.4416667 0.276722 4.4444444 0.276133 4.4472222 0.276133 4.4500000 0.275543 4.4527778 0.276133 4.4555556 0.277311 4.4583333 0.277017 4.4611111 0.276722 4.4638889 0.276722 4.4666667 0.276722 4.4694444 0.276722 4.4722222 0.277311 4.4750000 0.277017 4.4777778 0.277017 4.4805556 0.276427 4.4833333 0.274954 4.4861111 0.275838 4.4888889 0.276427 4.4916667 0.276722 4.4944444 0.276427 4.4972222 0.276133 4.5000000 0.274954 4.5027778 0.275543 4.5055556 0.276133 4.5083333 0.276133 4.5111111 0.276133 4.5138889 0.275838 4.5166667 0.275543 4.5194444 0.276133 4.5222222 0.275249 4.5250000 0.276133 4.5277778 0.275838 4.5305556 0.275838 4.5333333 0.275249 4.5361111 0.275543 4.5388889 0.276133 4.5416667 0.276722 4.5444444 0.276722 4.5472222 0.276722 4.5500000 0.276427 4.5527778 0.276722 4.5555556 0.276722 4.5583333 0.276133 4.5611111 0.276133 4.5638889 0.275249 4.5666667 0.274365 4.5694444 0.275543 4.5722222 0.276133 4.5750000 0.276722 4.5777778 0.277017 4.5805556 0.275543 4.5833333 0.276133 4.5861111 0.276133 4.5888889 0.276427 4.5916667 0.276722 4.5944444 0.276722 4.5972222 0.276133 4.6000000 0.275249 4.6027778 0.275543 4.6055556 0.276427 4.6083333 0.276722 4.6111111 0.276427 4.6138889 0.276133 4.6166667 0.274954 4.6194444 0.274954 4.6222222 0.274954 4.6250000 0.275249 4.6277778 0.274954 4.6305556 0.273481 4.6333333 0.273775 4.6361111 0.273481 4.6388889 0.274365 4.6416667 0.273775 4.6444444 0.272302 4.6472222 0.273186 4.6500000 0.272891 4.6527778 0.274070 4.6555556 0.274365 4.6583333 0.274954 4.6611111 0.274659 4.6638889 0.273775 4.6666667 0.273481 4.6694444 0.273775 4.6722222 0.274659 4.6750000 0.275249 4.6777778 0.275838 4.6805556 0.274954 4.6833333 0.275249 4.6861111 0.276133 4.6888889 0.277606 4.6946667 0.300000 4.9275556 0.300000 4.9305556 0.279963 4.9333333 0.279963 4.9361111 0.279963 4.9388889 0.280847 4.9416667 0.280847 4.9444444 0.280847 4.9472222 0.279669 4.9500000 0.279374 4.9527778 0.279963 4.9555556 0.280552 4.9583333 0.281142 4.9611111 0.281731 4.9638889 0.282026 4.9666667 0.282026 4.9694444 0.283794 4.9722222 0.284088 4.9750000 0.284972 4.9777778 0.284678 4.9805556 0.284383 4.9833333 0.284678 4.9861111 0.285267 4.9888889 0.286151 4.9916667 0.286151 4.9944444 0.287035 4.9972222 0.286151 5.0000000 0.286151 5.0027778 0.287035 5.0055556 0.286446 5.0083333 0.286740 5.0111111 0.286151 5.0138889 0.285562 5.0166667 0.284972 5.0194444 0.285856 5.0222222 0.286446 5.0250000 0.286446 5.0277778 0.285267 5.0305556 0.284972 5.0333333 0.285267 5.0361111 0.286446 5.0388889 0.287919 5.0416667 0.288508 5.0444444 0.287624 5.0472222 0.286446 5.0500000 0.284088 5.0527778 0.284088 5.0555556 0.283204 5.0583333 0.283204 5.0611111 0.281731 5.0638889 0.280552 5.0666667 0.279963 5.0694444 0.279963 5.0722222 0.279669 5.0750000 0.279374 5.0777778 0.279374 5.0805556 0.279963 5.0833333 0.279079 5.0861111 0.279669 5.0888889 0.279963 5.0916667 0.279963 5.0944444 0.279669 5.0972222 0.279079 5.1000000 0.278195 5.1027778 0.279079 5.1055556 0.278195 5.1083333 0.279669 5.1111111 0.279963 5.1138889 0.278785 5.1166667 0.277606 5.1194444 0.278785 5.1222222 0.279669 5.1250000 0.279374 5.1277778 0.279374 5.1305556 0.279079 5.1333333 0.277606 5.1361111 0.277017 5.1388889 0.276722 5.1416667 0.274954 5.1444444 0.273186 5.1472222 0.272007 5.1500000 0.269945 5.1527778 0.267882 5.1555556 0.268177 5.1583333 0.270829 5.1611111 0.276133 5.1638889 0.282615 5.1666667 0.290571 5.1694444 0.302357 5.1722222 0.318564 5.1750000 0.335064 5.1777778 0.347145 5.1805556 0.352155 5.1833333 0.346851 5.1861111 0.330645 5.1888889 0.307661 5.1916667 0.287330 5.1944444 0.274954 5.1972222 0.270534 5.2000000 0.271123 5.2027778 0.273481 5.2055556 0.276427 5.2083333 0.277017 5.2111111 0.276722 5.2138889 0.276722 5.2166667 0.276427 5.2194444 0.277017 5.2222222 0.277606 5.2250000 0.277311 5.2277778 0.277311 5.2305556 0.276427 5.2333333 0.275838 5.2361111 0.275838 5.2388889 0.277017 5.2416667 0.277017 5.2444444 0.276133 5.2472222 0.276133 5.2500000 0.275543 5.2527778 0.275838 5.2555556 0.276722 5.2583333 0.276722 5.2611111 0.276427 5.2638889 0.275543 5.2666667 0.275543 5.2694444 0.275543 5.2722222 0.276427 5.2750000 0.277017 5.2777778 0.277017 5.2805556 0.275838 5.2833333 0.275543 5.2861111 0.276133 5.2888889 0.276722 5.2916667 0.276722 5.2944444 0.276722 5.2972222 0.276133 5.3000000 0.275838 5.3027778 0.275838 5.3055556 0.276427 5.3083333 0.277017 5.3111111 0.276722 5.3138889 0.275838 5.3166667 0.274954 5.3194444 0.275543 5.3222222 0.276133 5.3250000 0.275838 5.3277778 0.276133 5.3305556 0.275543 5.3333333 0.274954 5.3361111 0.274954 5.3388889 0.275838 5.3416667 0.276722 5.3444444 0.277017 5.3472222 0.276427 5.3500000 0.275838 5.3527778 0.275838 5.3555556 0.276427 5.3583333 0.277017 5.3611111 0.275838 5.3638889 0.275249 5.3666667 0.275249 5.3694444 0.275543 5.3722222 0.275543 5.3750000 0.276133 5.3777778 0.275249 5.3805556 0.275543 5.3833333 0.274954 5.3861111 0.275838 5.3888889 0.276427 5.3916667 0.276133 5.3944444 0.276427 5.3972222 0.276427 5.4000000 0.275838 5.4027778 0.276427 5.4055556 0.276722 5.4083333 0.276722 5.4111111 0.276133 5.4138889 0.275838 5.4166667 0.274954 5.4194444 0.274954 5.4222222 0.275838 5.4250000 0.275838 5.4277778 0.275249 5.4305556 0.274659 5.4333333 0.273775 5.4361111 0.274070 5.4388889 0.274365 5.4416667 0.274659 5.4444444 0.274659 5.4472222 0.273481 5.4500000 0.273775 5.4527778 0.273775 5.4555556 0.274365 5.4583333 0.274365 5.4611111 0.273775 5.4638889 0.274070 5.4666667 0.273481 5.4694444 0.274659 5.4722222 0.274659 5.4750000 0.275543 5.4777778 0.276427 5.4835556 0.300000 5.7442222 0.300000 5.7472222 0.280552 5.7500000 0.280552 5.7527778 0.280847 5.7555556 0.281436 5.7583333 0.281436 5.7611111 0.281436 5.7638889 0.280552 5.7666667 0.280552 5.7694444 0.281142 5.7722222 0.281436 5.7750000 0.282026 5.7777778 0.282026 5.7805556 0.282615 5.7833333 0.281436 5.7861111 0.282320 5.7888889 0.283794 5.7916667 0.284972 5.7944444 0.284972 5.7972222 0.284678 5.8000000 0.284383 5.8027778 0.284972 5.8055556 0.286151 5.8083333 0.286446 5.8111111 0.286740 5.8138889 0.287035 5.8166667 0.287035 5.8194444 0.287330 5.8222222 0.288214 5.8250000 0.287919 5.8277778 0.287919 5.8305556 0.286740 5.8333333 0.286151 5.8361111 0.285856 5.8388889 0.286446 5.8416667 0.287330 5.8444444 0.285856 5.8472222 0.285856 5.8500000 0.285267 5.8527778 0.286151 5.8555556 0.287624 5.8583333 0.288214 5.8611111 0.287035 5.8638889 0.284972 5.8666667 0.283794 5.8694444 0.283204 5.8722222 0.282320 5.8750000 0.282026 5.8777778 0.281142 5.8805556 0.280552 5.8833333 0.280847 5.8861111 0.281142 5.8888889 0.280552 5.8916667 0.280552 5.8944444 0.280258 5.8972222 0.279963 5.9000000 0.279669 5.9027778 0.279963 5.9055556 0.280258 5.9083333 0.281142 5.9111111 0.280847 5.9138889 0.280258 5.9166667 0.279669 5.9194444 0.279669 5.9222222 0.279669 5.9250000 0.280258 5.9277778 0.279963 5.9305556 0.279669 5.9333333 0.279079 5.9361111 0.279963 5.9388889 0.279963 5.9416667 0.279963 5.9444444 0.279963 5.9472222 0.279669 5.9500000 0.279079 5.9527778 0.278490 5.9555556 0.278195 5.9583333 0.276133 5.9611111 0.273775 5.9638889 0.271713 5.9666667 0.270829 5.9694444 0.269355 5.9722222 0.268471 5.9750000 0.270239 5.9777778 0.275543 5.9805556 0.283499 5.9833333 0.292044 5.9861111 0.303831 5.9888889 0.317680 5.9916667 0.334180 5.9944444 0.347735 5.9972222 0.355691 6.0000000 0.354217 6.0027778 0.345672 6.0055556 0.326225 6.0083333 0.301179 6.0111111 0.282615 6.0138889 0.273775 6.0166667 0.272302 6.0194444 0.274954 6.0222222 0.277606 6.0250000 0.278785 6.0277778 0.278785 6.0305556 0.278195 6.0333333 0.277606 6.0361111 0.277606 6.0388889 0.277901 6.0416667 0.278195 6.0444444 0.278490 6.0472222 0.278195 6.0500000 0.277311 6.0527778 0.277311 6.0555556 0.277901 6.0583333 0.278195 6.0611111 0.278195 6.0638889 0.277311 6.0666667 0.276722 6.0694444 0.277311 6.0722222 0.277311 6.0750000 0.277017 6.0777778 0.277311 6.0805556 0.276722 6.0833333 0.275838 6.0861111 0.276427 6.0888889 0.276722 6.0916667 0.277606 6.0944444 0.276722 6.0972222 0.276722 6.1000000 0.276427 6.1027778 0.276427 6.1055556 0.276722 6.1083333 0.277017 6.1111111 0.277017 6.1138889 0.276722 6.1166667 0.276133 6.1194444 0.277017 6.1222222 0.277311 6.1250000 0.277901 6.1277778 0.277901 6.1305556 0.277606 6.1333333 0.277017 6.1361111 0.277311 6.1388889 0.278195 6.1416667 0.278195 6.1444444 0.278195 6.1472222 0.277901 6.1500000 0.277311 6.1527778 0.278195 6.1555556 0.277017 6.1583333 0.277901 6.1611111 0.278195 6.1638889 0.277606 6.1666667 0.277017 6.1694444 0.277017 6.1722222 0.277311 6.1750000 0.277901 6.1777778 0.277901 6.1805556 0.277311 6.1833333 0.276722 6.1861111 0.277017 6.1888889 0.277311 6.1916667 0.277901 6.1944444 0.277606 6.1972222 0.277311 6.2000000 0.277017 6.2027778 0.277606 6.2055556 0.277606 6.2083333 0.278195 6.2111111 0.278195 6.2138889 0.278490 6.2166667 0.277017 6.2194444 0.278490 6.2222222 0.278490 6.2250000 0.278785 6.2277778 0.277901 6.2305556 0.277606 6.2333333 0.276427 6.2361111 0.277017 6.2388889 0.277901 6.2416667 0.277901 6.2444444 0.278195 6.2472222 0.277311 6.2500000 0.277017 6.2527778 0.277017 6.2555556 0.277017 6.2583333 0.277017 6.2611111 0.277901 6.2638889 0.277311 6.2666667 0.276722 6.2694444 0.277606 6.2722222 0.278195 6.2750000 0.277901 6.2777778 0.277901 6.2805556 0.277017 6.2833333 0.276133 6.2861111 0.277901 6.2888889 0.278195 6.2916667 0.278785 6.2944444 0.277901 6.3002222 0.300000 6.3970000 0.300000 6.4000000 0.282615 6.4027778 0.283204 6.4055556 0.283499 6.4083333 0.283794 6.4111111 0.283499 6.4138889 0.282910 6.4166667 0.281731 6.4194444 0.282026 6.4222222 0.283204 6.4250000 0.284088 6.4277778 0.284088 6.4305556 0.283794 6.4333333 0.283204 6.4361111 0.283204 6.4388889 0.284088 6.4416667 0.284383 6.4444444 0.284383 6.4472222 0.284383 6.4500000 0.283499 6.4527778 0.284383 6.4555556 0.285562 6.4583333 0.286151 6.4611111 0.286151 6.4638889 0.285267 6.4666667 0.285267 6.4694444 0.285562 6.4722222 0.287330 6.4750000 0.287035 6.4777778 0.285562 6.4805556 0.284972 6.4833333 0.286446 6.4861111 0.287919 6.4888889 0.287624 6.4916667 0.287035 6.4944444 0.286446 6.4972222 0.285856 6.5000000 0.285856 6.5027778 0.285562 6.5055556 0.285267 6.5083333 0.284088 6.5111111 0.283204 6.5138889 0.281436 6.5166667 0.281142 6.5194444 0.281142 6.5222222 0.281731 6.5250000 0.280552 6.5277778 0.279963 6.5305556 0.279669 6.5333333 0.278785 6.5361111 0.278490 6.5388889 0.278785 6.5416667 0.279374 6.5444444 0.279079 6.5472222 0.277901 6.5500000 0.277311 6.5527778 0.277901 6.5555556 0.278195 6.5583333 0.278490 6.5611111 0.278490 6.5638889 0.278195 6.5666667 0.277606 6.5694444 0.278785 6.5722222 0.279374 6.5750000 0.279079 6.5777778 0.279079 6.5805556 0.279374 6.5833333 0.278490 6.5861111 0.279374 6.5888889 0.279374 6.5916667 0.279963 6.5944444 0.279079 6.5972222 0.279374 6.6000000 0.277901 6.6027778 0.278490 6.6055556 0.277901 6.6083333 0.276427 6.6111111 0.274659 6.6138889 0.272007 6.6166667 0.269355 6.6194444 0.269355 6.6222222 0.267587 6.6250000 0.266409 6.6277778 0.268177 6.6305556 0.273775 6.6333333 0.282026 6.6361111 0.291750 6.6388889 0.301473 6.6416667 0.315322 6.6444444 0.330055 6.6472222 0.343315 6.6500000 0.349797 6.6527778 0.351565 6.6555556 0.343315 6.6583333 0.323573 6.6611111 0.298527 6.6638889 0.280258 6.6666667 0.271713 6.6694444 0.272302 6.6722222 0.275543 6.6750000 0.277901 6.6777778 0.278490 6.6805556 0.277311 6.6833333 0.276427 6.6861111 0.277606 6.6888889 0.277017 6.6916667 0.277901 6.6944444 0.277311 6.6972222 0.276722 6.7000000 0.276133 6.7027778 0.277017 6.7055556 0.277606 6.7083333 0.277311 6.7111111 0.277311 6.7138889 0.276722 6.7166667 0.276427 6.7194444 0.276133 6.7222222 0.276427 6.7250000 0.277017 6.7277778 0.277017 6.7305556 0.276722 6.7333333 0.276427 6.7361111 0.277017 6.7388889 0.277311 6.7416667 0.277017 6.7444444 0.277311 6.7472222 0.275838 6.7500000 0.275249 6.7527778 0.276133 6.7555556 0.275838 6.7583333 0.277017 6.7611111 0.277017 6.7638889 0.277017 6.7666667 0.276427 6.7694444 0.276427 6.7722222 0.277017 6.7750000 0.277901 6.7777778 0.277606 6.7805556 0.276722 6.7833333 0.276427 6.7861111 0.277017 6.7888889 0.276427 6.7916667 0.277017 6.7944444 0.276722 6.7972222 0.275838 6.8000000 0.275543 6.8027778 0.276133 6.8055556 0.277311 6.8083333 0.277311 6.8111111 0.277606 6.8138889 0.276427 6.8166667 0.276427 6.8194444 0.276722 6.8222222 0.277017 6.8250000 0.277606 6.8277778 0.277901 6.8305556 0.276722 6.8333333 0.276722 6.8361111 0.277311 6.8388889 0.277606 6.8416667 0.277901 6.8444444 0.277311 6.8472222 0.277017 6.8500000 0.276427 6.8527778 0.276427 6.8555556 0.277311 6.8583333 0.277606 6.8611111 0.276722 6.8638889 0.277017 6.8666667 0.276427 6.8694444 0.276722 6.8722222 0.277311 6.8750000 0.277606 6.8777778 0.277311 6.8805556 0.276722 6.8833333 0.276133 6.8861111 0.276427 6.8888889 0.277017 6.8916667 0.277606 6.8944444 0.277606 6.8972222 0.277311 6.9000000 0.276133 6.9027778 0.276722 6.9055556 0.276427 6.9083333 0.277017 6.9111111 0.276427 6.9138889 0.276133 6.9166667 0.274954 6.9194444 0.275249 6.9222222 0.276133 6.9250000 0.276427 6.9277778 0.276133 6.9305556 0.276133 6.9333333 0.275543 6.9361111 0.276427 6.9388889 0.277017 6.9416667 0.277606 6.9444444 0.277311 6.9472222 0.276722 6.9530000 0.300000 7.3914444 0.300000 7.3944444 0.279669 7.3972222 0.279079 7.4000000 0.278785 7.4027778 0.278785 7.4055556 0.278490 7.4083333 0.279669 7.4111111 0.279079 7.4138889 0.279374 7.4166667 0.278785 7.4194444 0.279079 7.4222222 0.278785 7.4250000 0.279669 7.4277778 0.280258 7.4305556 0.280552 7.4333333 0.280552 7.4361111 0.281731 7.4388889 0.282026 7.4416667 0.282320 7.4444444 0.282026 7.4472222 0.282615 7.4500000 0.282026 7.4527778 0.283204 7.4555556 0.283794 7.4583333 0.284383 7.4611111 0.284972 7.4638889 0.284972 7.4666667 0.284678 7.4694444 0.284383 7.4722222 0.284972 7.4750000 0.284972 7.4777778 0.284678 7.4805556 0.283499 7.4833333 0.282910 7.4861111 0.283499 7.4888889 0.284088 7.4916667 0.284972 7.4944444 0.283794 7.4972222 0.282910 7.5000000 0.281142 7.5027778 0.282320 7.5055556 0.282615 7.5083333 0.284088 7.5111111 0.284383 7.5138889 0.284088 7.5166667 0.283204 7.5194444 0.282320 7.5222222 0.281731 7.5250000 0.281436 7.5277778 0.281142 7.5305556 0.279374 7.5333333 0.278195 7.5361111 0.278490 7.5388889 0.278490 7.5416667 0.278490 7.5444444 0.278195 7.5472222 0.278195 7.5500000 0.278195 7.5527778 0.277606 7.5555556 0.278785 7.5583333 0.277901 7.5611111 0.277901 7.5638889 0.276427 7.5666667 0.275249 7.5694444 0.276133 7.5722222 0.276427 7.5750000 0.277311 7.5777778 0.277606 7.5805556 0.276427 7.5833333 0.275543 7.5861111 0.276133 7.5888889 0.276722 7.5916667 0.276722 7.5944444 0.276722 7.5972222 0.275838 7.6000000 0.274659 7.6027778 0.274070 7.6055556 0.273186 7.6083333 0.271123 7.6111111 0.271418 7.6138889 0.269355 7.6166667 0.266409 7.6194444 0.266114 7.6222222 0.269061 7.6250000 0.275249 7.6277778 0.282026 7.6305556 0.288803 7.6333333 0.298821 7.6361111 0.312965 7.6388889 0.328582 7.6416667 0.342136 7.6444444 0.349797 7.6472222 0.352155 7.6500000 0.346556 7.6527778 0.333002 7.6555556 0.313260 7.6583333 0.295875 7.6611111 0.283204 7.6638889 0.274954 7.6666667 0.270534 7.6694444 0.267587 7.6722222 0.268471 7.6750000 0.270534 7.6777778 0.272597 7.6805556 0.273481 7.6833333 0.273481 7.6861111 0.274365 7.6888889 0.275249 7.6916667 0.275838 7.6944444 0.275838 7.6972222 0.275543 7.7000000 0.275249 7.7027778 0.274954 7.7055556 0.275249 7.7083333 0.274659 7.7111111 0.274659 7.7138889 0.274070 7.7166667 0.273481 7.7194444 0.273481 7.7222222 0.274659 7.7250000 0.274659 7.7277778 0.274659 7.7305556 0.273775 7.7333333 0.273775 7.7361111 0.274070 7.7388889 0.274954 7.7416667 0.274659 7.7444444 0.274659 7.7472222 0.274954 7.7500000 0.273775 7.7527778 0.273775 7.7555556 0.274659 7.7583333 0.274365 7.7611111 0.274365 7.7638889 0.273775 7.7666667 0.273775 7.7694444 0.274365 7.7722222 0.274659 7.7750000 0.274954 7.7777778 0.274659 7.7805556 0.274659 7.7833333 0.274070 7.7861111 0.275249 7.7888889 0.274659 7.7916667 0.274954 7.7944444 0.274659 7.7972222 0.274070 7.8000000 0.274070 7.8027778 0.274659 7.8055556 0.274659 7.8083333 0.275543 7.8111111 0.274954 7.8138889 0.274659 7.8166667 0.273186 7.8194444 0.273775 7.8222222 0.273775 7.8250000 0.274659 7.8277778 0.274659 7.8305556 0.274070 7.8333333 0.274070 7.8361111 0.274365 7.8388889 0.274659 7.8416667 0.275543 7.8444444 0.275543 7.8472222 0.274954 7.8500000 0.274954 7.8527778 0.275249 7.8555556 0.276133 7.8583333 0.276133 7.8611111 0.275543 7.8638889 0.275543 7.8666667 0.274954 7.8694444 0.274659 7.8722222 0.276133 7.8750000 0.276133 7.8777778 0.276133 7.8805556 0.276133 7.8833333 0.274659 7.8861111 0.275543 7.8888889 0.275838 7.8916667 0.275543 7.8944444 0.274659 7.8972222 0.273775 7.9000000 0.272597 7.9027778 0.272891 7.9055556 0.273481 7.9083333 0.273186 7.9111111 0.272891 7.9138889 0.272597 7.9166667 0.271418 7.9194444 0.270829 7.9222222 0.272007 7.9250000 0.271123 7.9277778 0.270534 7.9305556 0.270829 7.9333333 0.269650 7.9361111 0.270534 7.9388889 0.271418 7.9416667 0.271123 7.9474444 0.300000 8.2358889 0.300000 8.2388889 0.279079 8.2416667 0.279963 8.2444444 0.279669 8.2472222 0.279079 8.2500000 0.279079 8.2527778 0.279079 8.2555556 0.279963 8.2583333 0.279963 8.2611111 0.279669 8.2638889 0.278490 8.2666667 0.278195 8.2694444 0.279374 8.2722222 0.280552 8.2750000 0.281142 8.2777778 0.281436 8.2805556 0.282615 8.2833333 0.282026 8.2861111 0.282615 8.2888889 0.282320 8.2916667 0.283204 8.2944444 0.283794 8.2972222 0.284678 8.3000000 0.283794 8.3027778 0.284383 8.3055556 0.284678 8.3083333 0.285267 8.3111111 0.285562 8.3138889 0.284972 8.3166667 0.284383 8.3194444 0.284678 8.3222222 0.284678 8.3250000 0.285267 8.3277778 0.284678 8.3305556 0.283499 8.3333333 0.283499 8.3361111 0.283794 8.3388889 0.283204 8.3416667 0.283499 8.3444444 0.284972 8.3472222 0.285562 8.3500000 0.285562 8.3527778 0.284678 8.3555556 0.283204 8.3583333 0.282910 8.3611111 0.282320 8.3638889 0.281142 8.3666667 0.280258 8.3694444 0.279079 8.3722222 0.279374 8.3750000 0.279079 8.3777778 0.279079 8.3805556 0.277901 8.3833333 0.277311 8.3861111 0.277606 8.3888889 0.278785 8.3916667 0.279374 8.3944444 0.278785 8.3972222 0.278490 8.4000000 0.278195 8.4027778 0.278195 8.4055556 0.278490 8.4083333 0.278785 8.4111111 0.278490 8.4138889 0.278195 8.4166667 0.277311 8.4194444 0.277311 8.4222222 0.278490 8.4250000 0.278785 8.4277778 0.277606 8.4305556 0.277311 8.4333333 0.276722 8.4361111 0.276722 8.4388889 0.277311 8.4416667 0.277606 8.4444444 0.276722 8.4472222 0.274954 8.4500000 0.272597 8.4527778 0.270534 8.4555556 0.269650 8.4583333 0.268766 8.4611111 0.266998 8.4638889 0.265525 8.4666667 0.268766 8.4694444 0.275838 8.4722222 0.284972 8.4750000 0.293812 8.4777778 0.306188 8.4805556 0.320921 8.4833333 0.335359 8.4861111 0.347735 8.4888889 0.352449 8.4916667 0.348913 8.4944444 0.334180 8.4972222 0.310902 8.5000000 0.287919 8.5027778 0.273481 8.5055556 0.269061 8.5083333 0.270829 8.5111111 0.272597 8.5138889 0.274365 8.5166667 0.275543 8.5194444 0.275543 8.5222222 0.275543 8.5250000 0.276427 8.5277778 0.276722 8.5305556 0.276133 8.5333333 0.274954 8.5361111 0.274365 8.5388889 0.275543 8.5416667 0.275543 8.5444444 0.275543 8.5472222 0.275543 8.5500000 0.274659 8.5527778 0.275249 8.5555556 0.275838 8.5583333 0.276133 8.5611111 0.275249 8.5638889 0.275838 8.5666667 0.275249 8.5694444 0.276427 8.5722222 0.276722 8.5750000 0.277311 8.5777778 0.276427 8.5805556 0.276427 8.5833333 0.276427 8.5861111 0.276427 8.5888889 0.276722 8.5916667 0.276427 8.5944444 0.276427 8.5972222 0.276427 8.6000000 0.275838 8.6027778 0.276722 8.6055556 0.275838 8.6083333 0.276427 8.6111111 0.276722 8.6138889 0.276133 8.6166667 0.275838 8.6194444 0.275543 8.6222222 0.276133 8.6250000 0.276427 8.6277778 0.276722 8.6305556 0.276133 8.6333333 0.275543 8.6361111 0.276133 8.6388889 0.275543 8.6416667 0.275838 8.6444444 0.276133 8.6472222 0.276133 8.6500000 0.275838 8.6527778 0.276133 8.6555556 0.276427 8.6583333 0.276722 8.6611111 0.276133 8.6638889 0.276133 8.6666667 0.276427 8.6694444 0.276722 8.6722222 0.277017 8.6750000 0.276722 8.6777778 0.277017 8.6805556 0.276722 8.6833333 0.275249 8.6861111 0.275543 8.6888889 0.276133 8.6916667 0.276427 8.6944444 0.276427 8.6972222 0.275543 8.7000000 0.275249 8.7027778 0.275838 8.7055556 0.276722 8.7083333 0.276427 8.7111111 0.276133 8.7138889 0.275543 8.7166667 0.274365 8.7194444 0.275543 8.7222222 0.275543 8.7250000 0.276427 8.7277778 0.276133 8.7305556 0.275249 8.7333333 0.274659 8.7361111 0.274954 8.7388889 0.275838 8.7416667 0.275838 8.7444444 0.276133 8.7472222 0.275543 8.7500000 0.274954 8.7527778 0.274954 8.7555556 0.275249 8.7583333 0.275838 8.7611111 0.275838 8.7638889 0.275249 8.7666667 0.274659 8.7694444 0.274954 8.7722222 0.275249 8.7750000 0.276133 8.7777778 0.275543 8.7805556 0.275838 8.7833333 0.275838 8.7861111 0.277311 8.7918889 0.300000 9.0470000 0.300000 9.0500000 0.280258 9.0527778 0.281142 9.0555556 0.280847 9.0583333 0.281436 9.0611111 0.281142 9.0638889 0.281142 9.0666667 0.279669 9.0694444 0.280258 9.0722222 0.281142 9.0750000 0.281731 9.0777778 0.281142 9.0805556 0.281142 9.0833333 0.279963 9.0861111 0.280552 9.0888889 0.281142 9.0916667 0.281731 9.0944444 0.281731 9.0972222 0.281731 9.1000000 0.282615 9.1027778 0.283499 9.1055556 0.284972 9.1083333 0.285267 9.1111111 0.285267 9.1138889 0.284972 9.1166667 0.284678 9.1194444 0.285856 9.1222222 0.287035 9.1250000 0.286446 9.1277778 0.286446 9.1305556 0.287330 9.1333333 0.287035 9.1361111 0.286740 9.1388889 0.286446 9.1416667 0.286446 9.1444444 0.286151 9.1472222 0.285562 9.1500000 0.284972 9.1527778 0.285856 9.1555556 0.286151 9.1583333 0.285562 9.1611111 0.286151 9.1638889 0.286446 9.1666667 0.287035 9.1694444 0.288508 9.1722222 0.287035 9.1750000 0.285562 9.1777778 0.284678 9.1805556 0.284088 9.1833333 0.282910 9.1861111 0.282320 9.1888889 0.282026 9.1916667 0.282026 9.1944444 0.281142 9.1972222 0.280552 9.2000000 0.279374 9.2027778 0.279374 9.2055556 0.280258 9.2083333 0.280258 9.2111111 0.280258 9.2138889 0.279963 9.2166667 0.279374 9.2194444 0.279374 9.2222222 0.279669 9.2250000 0.280258 9.2277778 0.279669 9.2305556 0.279079 9.2333333 0.278195 9.2361111 0.279374 9.2388889 0.279669 9.2416667 0.280258 9.2444444 0.280258 9.2472222 0.280258 9.2500000 0.279079 9.2527778 0.279079 9.2555556 0.279669 9.2583333 0.279079 9.2611111 0.276722 9.2638889 0.273481 9.2666667 0.271713 9.2694444 0.270239 9.2722222 0.269061 9.2750000 0.267882 9.2777778 0.270534 9.2805556 0.276722 9.2833333 0.284972 9.2861111 0.295875 9.2888889 0.308545 9.2916667 0.325046 9.2944444 0.340368 9.2972222 0.351565 9.3000000 0.354512 9.3027778 0.346851 9.3055556 0.327698 9.3083333 0.301179 9.3111111 0.280847 9.3138889 0.272302 9.3166667 0.271418 9.3194444 0.275838 9.3222222 0.278490 9.3250000 0.279079 9.3277778 0.278490 9.3305556 0.277606 9.3333333 0.277311 9.3361111 0.277606 9.3388889 0.278195 9.3416667 0.278195 9.3444444 0.277901 9.3472222 0.277311 9.3500000 0.276722 9.3527778 0.277311 9.3555556 0.277606 9.3583333 0.277311 9.3611111 0.277901 9.3638889 0.277017 9.3666667 0.276133 9.3694444 0.276133 9.3722222 0.277017 9.3750000 0.277311 9.3777778 0.277311 9.3805556 0.277017 9.3833333 0.275838 9.3861111 0.276427 9.3888889 0.277017 9.3916667 0.277311 9.3944444 0.277311 9.3972222 0.276722 9.4000000 0.277017 9.4027778 0.276722 9.4055556 0.277606 9.4083333 0.277901 9.4111111 0.277606 9.4138889 0.277311 9.4166667 0.276427 9.4194444 0.277311 9.4222222 0.277606 9.4250000 0.277901 9.4277778 0.277606 9.4305556 0.276722 9.4333333 0.276722 9.4361111 0.277311 9.4388889 0.277901 9.4416667 0.278195 9.4444444 0.278490 9.4472222 0.277311 9.4500000 0.276722 9.4527778 0.277311 9.4555556 0.277311 9.4583333 0.278195 9.4611111 0.277901 9.4638889 0.278195 9.4666667 0.277901 9.4694444 0.277901 9.4722222 0.278195 9.4750000 0.279079 9.4777778 0.278490 9.4805556 0.277606 9.4833333 0.277901 9.4861111 0.278195 9.4888889 0.277606 9.4916667 0.278490 9.4944444 0.278195 9.4972222 0.277901 9.5000000 0.277017 9.5027778 0.277606 9.5055556 0.277901 9.5083333 0.277606 9.5111111 0.278195 9.5138889 0.277901 9.5166667 0.277606 9.5194444 0.277311 9.5222222 0.277311 9.5250000 0.278195 9.5277778 0.277901 9.5305556 0.277901 9.5333333 0.277606 9.5361111 0.277606 9.5388889 0.277606 9.5416667 0.277606 9.5444444 0.277901 9.5472222 0.277017 9.5500000 0.276722 9.5527778 0.277311 9.5555556 0.277311 9.5583333 0.277901 9.5611111 0.277901 9.5638889 0.277311 9.5666667 0.277311 9.5694444 0.277017 9.5722222 0.278195 9.5750000 0.278490 9.5777778 0.278490 9.5805556 0.277901 9.5833333 0.277311 9.5861111 0.279374 9.5888889 0.279669 9.5916667 0.280847 9.5944444 0.280847 9.5972222 0.280552 9.6030000 0.300000 9.8000000 0.300000)
Vth rpeak_threshold 0 0.3278

.include "C:/Users/kadhi/OneDrive/Desktop/amux/verilogLearning/Leaky-Integrate-Fire---SNN-model-on-FPGA/experiments/frontend_optimization/complete_frontend/inverter.spice"
.include "C:/Users/kadhi/OneDrive/Desktop/amux/verilogLearning/Leaky-Integrate-Fire---SNN-model-on-FPGA/experiments/frontend_optimization/complete_frontend/bias_gen.spice"
.include "C:/Users/kadhi/OneDrive/Desktop/amux/verilogLearning/Leaky-Integrate-Fire---SNN-model-on-FPGA/experiments/frontend_optimization/complete_frontend/rpeak_detector.spice"
.include "C:/Users/kadhi/OneDrive/Desktop/amux/verilogLearning/Leaky-Integrate-Fire---SNN-model-on-FPGA/experiments/frontend_optimization/complete_frontend/pulse_gen.spice"

Xbias vbias_gen vref vdd vss bias_gen
Xrpeak ecg_l0 rpeak_threshold rpeak_raw vdd vss vbias rpeak_detector
Xpg_rpk rpeak_raw rpeak_pulse vdd vss vbias pulse_gen

.ic V(xbias.iref)=0.3

.tran 0.05m 9.8000

.meas tran raw_0_00 FIND V(rpeak_raw) AT=1.9900000
.meas tran pls_0_00 FIND V(rpeak_pulse) AT=1.9900000
.meas tran ecg_0_00 FIND V(ecg_l0) AT=1.9900000
.meas tran raw_0_01 FIND V(rpeak_raw) AT=1.9910000
.meas tran pls_0_01 FIND V(rpeak_pulse) AT=1.9910000
.meas tran ecg_0_01 FIND V(ecg_l0) AT=1.9910000
.meas tran raw_0_02 FIND V(rpeak_raw) AT=1.9920000
.meas tran pls_0_02 FIND V(rpeak_pulse) AT=1.9920000
.meas tran ecg_0_02 FIND V(ecg_l0) AT=1.9920000
.meas tran raw_0_03 FIND V(rpeak_raw) AT=1.9930000
.meas tran pls_0_03 FIND V(rpeak_pulse) AT=1.9930000
.meas tran ecg_0_03 FIND V(ecg_l0) AT=1.9930000
.meas tran raw_0_04 FIND V(rpeak_raw) AT=1.9940000
.meas tran pls_0_04 FIND V(rpeak_pulse) AT=1.9940000
.meas tran ecg_0_04 FIND V(ecg_l0) AT=1.9940000
.meas tran raw_0_05 FIND V(rpeak_raw) AT=1.9950000
.meas tran pls_0_05 FIND V(rpeak_pulse) AT=1.9950000
.meas tran ecg_0_05 FIND V(ecg_l0) AT=1.9950000
.meas tran raw_0_06 FIND V(rpeak_raw) AT=1.9960000
.meas tran pls_0_06 FIND V(rpeak_pulse) AT=1.9960000
.meas tran ecg_0_06 FIND V(ecg_l0) AT=1.9960000
.meas tran raw_0_07 FIND V(rpeak_raw) AT=1.9970000
.meas tran pls_0_07 FIND V(rpeak_pulse) AT=1.9970000
.meas tran ecg_0_07 FIND V(ecg_l0) AT=1.9970000
.meas tran raw_0_08 FIND V(rpeak_raw) AT=1.9980000
.meas tran pls_0_08 FIND V(rpeak_pulse) AT=1.9980000
.meas tran ecg_0_08 FIND V(ecg_l0) AT=1.9980000
.meas tran raw_0_09 FIND V(rpeak_raw) AT=1.9990000
.meas tran pls_0_09 FIND V(rpeak_pulse) AT=1.9990000
.meas tran ecg_0_09 FIND V(ecg_l0) AT=1.9990000
.meas tran raw_0_10 FIND V(rpeak_raw) AT=2.0000000
.meas tran pls_0_10 FIND V(rpeak_pulse) AT=2.0000000
.meas tran ecg_0_10 FIND V(ecg_l0) AT=2.0000000
.meas tran raw_0_11 FIND V(rpeak_raw) AT=2.0010000
.meas tran pls_0_11 FIND V(rpeak_pulse) AT=2.0010000
.meas tran ecg_0_11 FIND V(ecg_l0) AT=2.0010000
.meas tran raw_0_12 FIND V(rpeak_raw) AT=2.0020000
.meas tran pls_0_12 FIND V(rpeak_pulse) AT=2.0020000
.meas tran ecg_0_12 FIND V(ecg_l0) AT=2.0020000
.meas tran raw_0_13 FIND V(rpeak_raw) AT=2.0030000
.meas tran pls_0_13 FIND V(rpeak_pulse) AT=2.0030000
.meas tran ecg_0_13 FIND V(ecg_l0) AT=2.0030000
.meas tran raw_0_14 FIND V(rpeak_raw) AT=2.0040000
.meas tran pls_0_14 FIND V(rpeak_pulse) AT=2.0040000
.meas tran ecg_0_14 FIND V(ecg_l0) AT=2.0040000
.meas tran raw_0_15 FIND V(rpeak_raw) AT=2.0050000
.meas tran pls_0_15 FIND V(rpeak_pulse) AT=2.0050000
.meas tran ecg_0_15 FIND V(ecg_l0) AT=2.0050000
.meas tran raw_0_16 FIND V(rpeak_raw) AT=2.0060000
.meas tran pls_0_16 FIND V(rpeak_pulse) AT=2.0060000
.meas tran ecg_0_16 FIND V(ecg_l0) AT=2.0060000
.meas tran raw_0_17 FIND V(rpeak_raw) AT=2.0070000
.meas tran pls_0_17 FIND V(rpeak_pulse) AT=2.0070000
.meas tran ecg_0_17 FIND V(ecg_l0) AT=2.0070000
.meas tran raw_0_18 FIND V(rpeak_raw) AT=2.0080000
.meas tran pls_0_18 FIND V(rpeak_pulse) AT=2.0080000
.meas tran ecg_0_18 FIND V(ecg_l0) AT=2.0080000
.meas tran raw_0_19 FIND V(rpeak_raw) AT=2.0090000
.meas tran pls_0_19 FIND V(rpeak_pulse) AT=2.0090000
.meas tran ecg_0_19 FIND V(ecg_l0) AT=2.0090000
.meas tran raw_0_20 FIND V(rpeak_raw) AT=2.0100000
.meas tran pls_0_20 FIND V(rpeak_pulse) AT=2.0100000
.meas tran ecg_0_20 FIND V(ecg_l0) AT=2.0100000
.meas tran raw_0_21 FIND V(rpeak_raw) AT=2.0110000
.meas tran pls_0_21 FIND V(rpeak_pulse) AT=2.0110000
.meas tran ecg_0_21 FIND V(ecg_l0) AT=2.0110000
.meas tran raw_0_22 FIND V(rpeak_raw) AT=2.0120000
.meas tran pls_0_22 FIND V(rpeak_pulse) AT=2.0120000
.meas tran ecg_0_22 FIND V(ecg_l0) AT=2.0120000
.meas tran raw_0_23 FIND V(rpeak_raw) AT=2.0130000
.meas tran pls_0_23 FIND V(rpeak_pulse) AT=2.0130000
.meas tran ecg_0_23 FIND V(ecg_l0) AT=2.0130000
.meas tran raw_0_24 FIND V(rpeak_raw) AT=2.0140000
.meas tran pls_0_24 FIND V(rpeak_pulse) AT=2.0140000
.meas tran ecg_0_24 FIND V(ecg_l0) AT=2.0140000
.meas tran raw_0_25 FIND V(rpeak_raw) AT=2.0150000
.meas tran pls_0_25 FIND V(rpeak_pulse) AT=2.0150000
.meas tran ecg_0_25 FIND V(ecg_l0) AT=2.0150000
.meas tran raw_0_26 FIND V(rpeak_raw) AT=2.0160000
.meas tran pls_0_26 FIND V(rpeak_pulse) AT=2.0160000
.meas tran ecg_0_26 FIND V(ecg_l0) AT=2.0160000
.meas tran raw_0_27 FIND V(rpeak_raw) AT=2.0170000
.meas tran pls_0_27 FIND V(rpeak_pulse) AT=2.0170000
.meas tran ecg_0_27 FIND V(ecg_l0) AT=2.0170000
.meas tran raw_0_28 FIND V(rpeak_raw) AT=2.0180000
.meas tran pls_0_28 FIND V(rpeak_pulse) AT=2.0180000
.meas tran ecg_0_28 FIND V(ecg_l0) AT=2.0180000
.meas tran raw_0_29 FIND V(rpeak_raw) AT=2.0190000
.meas tran pls_0_29 FIND V(rpeak_pulse) AT=2.0190000
.meas tran ecg_0_29 FIND V(ecg_l0) AT=2.0190000
.meas tran raw_0_30 FIND V(rpeak_raw) AT=2.0200000
.meas tran pls_0_30 FIND V(rpeak_pulse) AT=2.0200000
.meas tran ecg_0_30 FIND V(ecg_l0) AT=2.0200000
.meas tran raw_0_31 FIND V(rpeak_raw) AT=2.0210000
.meas tran pls_0_31 FIND V(rpeak_pulse) AT=2.0210000
.meas tran ecg_0_31 FIND V(ecg_l0) AT=2.0210000
.meas tran raw_0_32 FIND V(rpeak_raw) AT=2.0220000
.meas tran pls_0_32 FIND V(rpeak_pulse) AT=2.0220000
.meas tran ecg_0_32 FIND V(ecg_l0) AT=2.0220000
.meas tran raw_0_33 FIND V(rpeak_raw) AT=2.0230000
.meas tran pls_0_33 FIND V(rpeak_pulse) AT=2.0230000
.meas tran ecg_0_33 FIND V(ecg_l0) AT=2.0230000
.meas tran raw_0_34 FIND V(rpeak_raw) AT=2.0240000
.meas tran pls_0_34 FIND V(rpeak_pulse) AT=2.0240000
.meas tran ecg_0_34 FIND V(ecg_l0) AT=2.0240000
.meas tran raw_0_35 FIND V(rpeak_raw) AT=2.0250000
.meas tran pls_0_35 FIND V(rpeak_pulse) AT=2.0250000
.meas tran ecg_0_35 FIND V(ecg_l0) AT=2.0250000
.meas tran raw_0_36 FIND V(rpeak_raw) AT=2.0260000
.meas tran pls_0_36 FIND V(rpeak_pulse) AT=2.0260000
.meas tran ecg_0_36 FIND V(ecg_l0) AT=2.0260000
.meas tran raw_0_37 FIND V(rpeak_raw) AT=2.0270000
.meas tran pls_0_37 FIND V(rpeak_pulse) AT=2.0270000
.meas tran ecg_0_37 FIND V(ecg_l0) AT=2.0270000
.meas tran raw_0_38 FIND V(rpeak_raw) AT=2.0280000
.meas tran pls_0_38 FIND V(rpeak_pulse) AT=2.0280000
.meas tran ecg_0_38 FIND V(ecg_l0) AT=2.0280000
.meas tran raw_0_39 FIND V(rpeak_raw) AT=2.0290000
.meas tran pls_0_39 FIND V(rpeak_pulse) AT=2.0290000
.meas tran ecg_0_39 FIND V(ecg_l0) AT=2.0290000
.meas tran raw_0_40 FIND V(rpeak_raw) AT=2.0300000
.meas tran pls_0_40 FIND V(rpeak_pulse) AT=2.0300000
.meas tran ecg_0_40 FIND V(ecg_l0) AT=2.0300000
.meas tran raw_1_00 FIND V(rpeak_raw) AT=2.8011111
.meas tran pls_1_00 FIND V(rpeak_pulse) AT=2.8011111
.meas tran ecg_1_00 FIND V(ecg_l0) AT=2.8011111
.meas tran raw_1_01 FIND V(rpeak_raw) AT=2.8021111
.meas tran pls_1_01 FIND V(rpeak_pulse) AT=2.8021111
.meas tran ecg_1_01 FIND V(ecg_l0) AT=2.8021111
.meas tran raw_1_02 FIND V(rpeak_raw) AT=2.8031111
.meas tran pls_1_02 FIND V(rpeak_pulse) AT=2.8031111
.meas tran ecg_1_02 FIND V(ecg_l0) AT=2.8031111
.meas tran raw_1_03 FIND V(rpeak_raw) AT=2.8041111
.meas tran pls_1_03 FIND V(rpeak_pulse) AT=2.8041111
.meas tran ecg_1_03 FIND V(ecg_l0) AT=2.8041111
.meas tran raw_1_04 FIND V(rpeak_raw) AT=2.8051111
.meas tran pls_1_04 FIND V(rpeak_pulse) AT=2.8051111
.meas tran ecg_1_04 FIND V(ecg_l0) AT=2.8051111
.meas tran raw_1_05 FIND V(rpeak_raw) AT=2.8061111
.meas tran pls_1_05 FIND V(rpeak_pulse) AT=2.8061111
.meas tran ecg_1_05 FIND V(ecg_l0) AT=2.8061111
.meas tran raw_1_06 FIND V(rpeak_raw) AT=2.8071111
.meas tran pls_1_06 FIND V(rpeak_pulse) AT=2.8071111
.meas tran ecg_1_06 FIND V(ecg_l0) AT=2.8071111
.meas tran raw_1_07 FIND V(rpeak_raw) AT=2.8081111
.meas tran pls_1_07 FIND V(rpeak_pulse) AT=2.8081111
.meas tran ecg_1_07 FIND V(ecg_l0) AT=2.8081111
.meas tran raw_1_08 FIND V(rpeak_raw) AT=2.8091111
.meas tran pls_1_08 FIND V(rpeak_pulse) AT=2.8091111
.meas tran ecg_1_08 FIND V(ecg_l0) AT=2.8091111
.meas tran raw_1_09 FIND V(rpeak_raw) AT=2.8101111
.meas tran pls_1_09 FIND V(rpeak_pulse) AT=2.8101111
.meas tran ecg_1_09 FIND V(ecg_l0) AT=2.8101111
.meas tran raw_1_10 FIND V(rpeak_raw) AT=2.8111111
.meas tran pls_1_10 FIND V(rpeak_pulse) AT=2.8111111
.meas tran ecg_1_10 FIND V(ecg_l0) AT=2.8111111
.meas tran raw_1_11 FIND V(rpeak_raw) AT=2.8121111
.meas tran pls_1_11 FIND V(rpeak_pulse) AT=2.8121111
.meas tran ecg_1_11 FIND V(ecg_l0) AT=2.8121111
.meas tran raw_1_12 FIND V(rpeak_raw) AT=2.8131111
.meas tran pls_1_12 FIND V(rpeak_pulse) AT=2.8131111
.meas tran ecg_1_12 FIND V(ecg_l0) AT=2.8131111
.meas tran raw_1_13 FIND V(rpeak_raw) AT=2.8141111
.meas tran pls_1_13 FIND V(rpeak_pulse) AT=2.8141111
.meas tran ecg_1_13 FIND V(ecg_l0) AT=2.8141111
.meas tran raw_1_14 FIND V(rpeak_raw) AT=2.8151111
.meas tran pls_1_14 FIND V(rpeak_pulse) AT=2.8151111
.meas tran ecg_1_14 FIND V(ecg_l0) AT=2.8151111
.meas tran raw_1_15 FIND V(rpeak_raw) AT=2.8161111
.meas tran pls_1_15 FIND V(rpeak_pulse) AT=2.8161111
.meas tran ecg_1_15 FIND V(ecg_l0) AT=2.8161111
.meas tran raw_1_16 FIND V(rpeak_raw) AT=2.8171111
.meas tran pls_1_16 FIND V(rpeak_pulse) AT=2.8171111
.meas tran ecg_1_16 FIND V(ecg_l0) AT=2.8171111
.meas tran raw_1_17 FIND V(rpeak_raw) AT=2.8181111
.meas tran pls_1_17 FIND V(rpeak_pulse) AT=2.8181111
.meas tran ecg_1_17 FIND V(ecg_l0) AT=2.8181111
.meas tran raw_1_18 FIND V(rpeak_raw) AT=2.8191111
.meas tran pls_1_18 FIND V(rpeak_pulse) AT=2.8191111
.meas tran ecg_1_18 FIND V(ecg_l0) AT=2.8191111
.meas tran raw_1_19 FIND V(rpeak_raw) AT=2.8201111
.meas tran pls_1_19 FIND V(rpeak_pulse) AT=2.8201111
.meas tran ecg_1_19 FIND V(ecg_l0) AT=2.8201111
.meas tran raw_1_20 FIND V(rpeak_raw) AT=2.8211111
.meas tran pls_1_20 FIND V(rpeak_pulse) AT=2.8211111
.meas tran ecg_1_20 FIND V(ecg_l0) AT=2.8211111
.meas tran raw_1_21 FIND V(rpeak_raw) AT=2.8221111
.meas tran pls_1_21 FIND V(rpeak_pulse) AT=2.8221111
.meas tran ecg_1_21 FIND V(ecg_l0) AT=2.8221111
.meas tran raw_1_22 FIND V(rpeak_raw) AT=2.8231111
.meas tran pls_1_22 FIND V(rpeak_pulse) AT=2.8231111
.meas tran ecg_1_22 FIND V(ecg_l0) AT=2.8231111
.meas tran raw_1_23 FIND V(rpeak_raw) AT=2.8241111
.meas tran pls_1_23 FIND V(rpeak_pulse) AT=2.8241111
.meas tran ecg_1_23 FIND V(ecg_l0) AT=2.8241111
.meas tran raw_1_24 FIND V(rpeak_raw) AT=2.8251111
.meas tran pls_1_24 FIND V(rpeak_pulse) AT=2.8251111
.meas tran ecg_1_24 FIND V(ecg_l0) AT=2.8251111
.meas tran raw_1_25 FIND V(rpeak_raw) AT=2.8261111
.meas tran pls_1_25 FIND V(rpeak_pulse) AT=2.8261111
.meas tran ecg_1_25 FIND V(ecg_l0) AT=2.8261111
.meas tran raw_1_26 FIND V(rpeak_raw) AT=2.8271111
.meas tran pls_1_26 FIND V(rpeak_pulse) AT=2.8271111
.meas tran ecg_1_26 FIND V(ecg_l0) AT=2.8271111
.meas tran raw_1_27 FIND V(rpeak_raw) AT=2.8281111
.meas tran pls_1_27 FIND V(rpeak_pulse) AT=2.8281111
.meas tran ecg_1_27 FIND V(ecg_l0) AT=2.8281111
.meas tran raw_1_28 FIND V(rpeak_raw) AT=2.8291111
.meas tran pls_1_28 FIND V(rpeak_pulse) AT=2.8291111
.meas tran ecg_1_28 FIND V(ecg_l0) AT=2.8291111
.meas tran raw_1_29 FIND V(rpeak_raw) AT=2.8301111
.meas tran pls_1_29 FIND V(rpeak_pulse) AT=2.8301111
.meas tran ecg_1_29 FIND V(ecg_l0) AT=2.8301111
.meas tran raw_1_30 FIND V(rpeak_raw) AT=2.8311111
.meas tran pls_1_30 FIND V(rpeak_pulse) AT=2.8311111
.meas tran ecg_1_30 FIND V(ecg_l0) AT=2.8311111
.meas tran raw_1_31 FIND V(rpeak_raw) AT=2.8321111
.meas tran pls_1_31 FIND V(rpeak_pulse) AT=2.8321111
.meas tran ecg_1_31 FIND V(ecg_l0) AT=2.8321111
.meas tran raw_1_32 FIND V(rpeak_raw) AT=2.8331111
.meas tran pls_1_32 FIND V(rpeak_pulse) AT=2.8331111
.meas tran ecg_1_32 FIND V(ecg_l0) AT=2.8331111
.meas tran raw_1_33 FIND V(rpeak_raw) AT=2.8341111
.meas tran pls_1_33 FIND V(rpeak_pulse) AT=2.8341111
.meas tran ecg_1_33 FIND V(ecg_l0) AT=2.8341111
.meas tran raw_1_34 FIND V(rpeak_raw) AT=2.8351111
.meas tran pls_1_34 FIND V(rpeak_pulse) AT=2.8351111
.meas tran ecg_1_34 FIND V(ecg_l0) AT=2.8351111
.meas tran raw_1_35 FIND V(rpeak_raw) AT=2.8361111
.meas tran pls_1_35 FIND V(rpeak_pulse) AT=2.8361111
.meas tran ecg_1_35 FIND V(ecg_l0) AT=2.8361111
.meas tran raw_1_36 FIND V(rpeak_raw) AT=2.8371111
.meas tran pls_1_36 FIND V(rpeak_pulse) AT=2.8371111
.meas tran ecg_1_36 FIND V(ecg_l0) AT=2.8371111
.meas tran raw_1_37 FIND V(rpeak_raw) AT=2.8381111
.meas tran pls_1_37 FIND V(rpeak_pulse) AT=2.8381111
.meas tran ecg_1_37 FIND V(ecg_l0) AT=2.8381111
.meas tran raw_1_38 FIND V(rpeak_raw) AT=2.8391111
.meas tran pls_1_38 FIND V(rpeak_pulse) AT=2.8391111
.meas tran ecg_1_38 FIND V(ecg_l0) AT=2.8391111
.meas tran raw_1_39 FIND V(rpeak_raw) AT=2.8401111
.meas tran pls_1_39 FIND V(rpeak_pulse) AT=2.8401111
.meas tran ecg_1_39 FIND V(ecg_l0) AT=2.8401111
.meas tran raw_1_40 FIND V(rpeak_raw) AT=2.8411111
.meas tran pls_1_40 FIND V(rpeak_pulse) AT=2.8411111
.meas tran ecg_1_40 FIND V(ecg_l0) AT=2.8411111
.meas tran raw_2_00 FIND V(rpeak_raw) AT=3.5900000
.meas tran pls_2_00 FIND V(rpeak_pulse) AT=3.5900000
.meas tran ecg_2_00 FIND V(ecg_l0) AT=3.5900000
.meas tran raw_2_01 FIND V(rpeak_raw) AT=3.5910000
.meas tran pls_2_01 FIND V(rpeak_pulse) AT=3.5910000
.meas tran ecg_2_01 FIND V(ecg_l0) AT=3.5910000
.meas tran raw_2_02 FIND V(rpeak_raw) AT=3.5920000
.meas tran pls_2_02 FIND V(rpeak_pulse) AT=3.5920000
.meas tran ecg_2_02 FIND V(ecg_l0) AT=3.5920000
.meas tran raw_2_03 FIND V(rpeak_raw) AT=3.5930000
.meas tran pls_2_03 FIND V(rpeak_pulse) AT=3.5930000
.meas tran ecg_2_03 FIND V(ecg_l0) AT=3.5930000
.meas tran raw_2_04 FIND V(rpeak_raw) AT=3.5940000
.meas tran pls_2_04 FIND V(rpeak_pulse) AT=3.5940000
.meas tran ecg_2_04 FIND V(ecg_l0) AT=3.5940000
.meas tran raw_2_05 FIND V(rpeak_raw) AT=3.5950000
.meas tran pls_2_05 FIND V(rpeak_pulse) AT=3.5950000
.meas tran ecg_2_05 FIND V(ecg_l0) AT=3.5950000
.meas tran raw_2_06 FIND V(rpeak_raw) AT=3.5960000
.meas tran pls_2_06 FIND V(rpeak_pulse) AT=3.5960000
.meas tran ecg_2_06 FIND V(ecg_l0) AT=3.5960000
.meas tran raw_2_07 FIND V(rpeak_raw) AT=3.5970000
.meas tran pls_2_07 FIND V(rpeak_pulse) AT=3.5970000
.meas tran ecg_2_07 FIND V(ecg_l0) AT=3.5970000
.meas tran raw_2_08 FIND V(rpeak_raw) AT=3.5980000
.meas tran pls_2_08 FIND V(rpeak_pulse) AT=3.5980000
.meas tran ecg_2_08 FIND V(ecg_l0) AT=3.5980000
.meas tran raw_2_09 FIND V(rpeak_raw) AT=3.5990000
.meas tran pls_2_09 FIND V(rpeak_pulse) AT=3.5990000
.meas tran ecg_2_09 FIND V(ecg_l0) AT=3.5990000
.meas tran raw_2_10 FIND V(rpeak_raw) AT=3.6000000
.meas tran pls_2_10 FIND V(rpeak_pulse) AT=3.6000000
.meas tran ecg_2_10 FIND V(ecg_l0) AT=3.6000000
.meas tran raw_2_11 FIND V(rpeak_raw) AT=3.6010000
.meas tran pls_2_11 FIND V(rpeak_pulse) AT=3.6010000
.meas tran ecg_2_11 FIND V(ecg_l0) AT=3.6010000
.meas tran raw_2_12 FIND V(rpeak_raw) AT=3.6020000
.meas tran pls_2_12 FIND V(rpeak_pulse) AT=3.6020000
.meas tran ecg_2_12 FIND V(ecg_l0) AT=3.6020000
.meas tran raw_2_13 FIND V(rpeak_raw) AT=3.6030000
.meas tran pls_2_13 FIND V(rpeak_pulse) AT=3.6030000
.meas tran ecg_2_13 FIND V(ecg_l0) AT=3.6030000
.meas tran raw_2_14 FIND V(rpeak_raw) AT=3.6040000
.meas tran pls_2_14 FIND V(rpeak_pulse) AT=3.6040000
.meas tran ecg_2_14 FIND V(ecg_l0) AT=3.6040000
.meas tran raw_2_15 FIND V(rpeak_raw) AT=3.6050000
.meas tran pls_2_15 FIND V(rpeak_pulse) AT=3.6050000
.meas tran ecg_2_15 FIND V(ecg_l0) AT=3.6050000
.meas tran raw_2_16 FIND V(rpeak_raw) AT=3.6060000
.meas tran pls_2_16 FIND V(rpeak_pulse) AT=3.6060000
.meas tran ecg_2_16 FIND V(ecg_l0) AT=3.6060000
.meas tran raw_2_17 FIND V(rpeak_raw) AT=3.6070000
.meas tran pls_2_17 FIND V(rpeak_pulse) AT=3.6070000
.meas tran ecg_2_17 FIND V(ecg_l0) AT=3.6070000
.meas tran raw_2_18 FIND V(rpeak_raw) AT=3.6080000
.meas tran pls_2_18 FIND V(rpeak_pulse) AT=3.6080000
.meas tran ecg_2_18 FIND V(ecg_l0) AT=3.6080000
.meas tran raw_2_19 FIND V(rpeak_raw) AT=3.6090000
.meas tran pls_2_19 FIND V(rpeak_pulse) AT=3.6090000
.meas tran ecg_2_19 FIND V(ecg_l0) AT=3.6090000
.meas tran raw_2_20 FIND V(rpeak_raw) AT=3.6100000
.meas tran pls_2_20 FIND V(rpeak_pulse) AT=3.6100000
.meas tran ecg_2_20 FIND V(ecg_l0) AT=3.6100000
.meas tran raw_2_21 FIND V(rpeak_raw) AT=3.6110000
.meas tran pls_2_21 FIND V(rpeak_pulse) AT=3.6110000
.meas tran ecg_2_21 FIND V(ecg_l0) AT=3.6110000
.meas tran raw_2_22 FIND V(rpeak_raw) AT=3.6120000
.meas tran pls_2_22 FIND V(rpeak_pulse) AT=3.6120000
.meas tran ecg_2_22 FIND V(ecg_l0) AT=3.6120000
.meas tran raw_2_23 FIND V(rpeak_raw) AT=3.6130000
.meas tran pls_2_23 FIND V(rpeak_pulse) AT=3.6130000
.meas tran ecg_2_23 FIND V(ecg_l0) AT=3.6130000
.meas tran raw_2_24 FIND V(rpeak_raw) AT=3.6140000
.meas tran pls_2_24 FIND V(rpeak_pulse) AT=3.6140000
.meas tran ecg_2_24 FIND V(ecg_l0) AT=3.6140000
.meas tran raw_2_25 FIND V(rpeak_raw) AT=3.6150000
.meas tran pls_2_25 FIND V(rpeak_pulse) AT=3.6150000
.meas tran ecg_2_25 FIND V(ecg_l0) AT=3.6150000
.meas tran raw_2_26 FIND V(rpeak_raw) AT=3.6160000
.meas tran pls_2_26 FIND V(rpeak_pulse) AT=3.6160000
.meas tran ecg_2_26 FIND V(ecg_l0) AT=3.6160000
.meas tran raw_2_27 FIND V(rpeak_raw) AT=3.6170000
.meas tran pls_2_27 FIND V(rpeak_pulse) AT=3.6170000
.meas tran ecg_2_27 FIND V(ecg_l0) AT=3.6170000
.meas tran raw_2_28 FIND V(rpeak_raw) AT=3.6180000
.meas tran pls_2_28 FIND V(rpeak_pulse) AT=3.6180000
.meas tran ecg_2_28 FIND V(ecg_l0) AT=3.6180000
.meas tran raw_2_29 FIND V(rpeak_raw) AT=3.6190000
.meas tran pls_2_29 FIND V(rpeak_pulse) AT=3.6190000
.meas tran ecg_2_29 FIND V(ecg_l0) AT=3.6190000
.meas tran raw_2_30 FIND V(rpeak_raw) AT=3.6200000
.meas tran pls_2_30 FIND V(rpeak_pulse) AT=3.6200000
.meas tran ecg_2_30 FIND V(ecg_l0) AT=3.6200000
.meas tran raw_2_31 FIND V(rpeak_raw) AT=3.6210000
.meas tran pls_2_31 FIND V(rpeak_pulse) AT=3.6210000
.meas tran ecg_2_31 FIND V(ecg_l0) AT=3.6210000
.meas tran raw_2_32 FIND V(rpeak_raw) AT=3.6220000
.meas tran pls_2_32 FIND V(rpeak_pulse) AT=3.6220000
.meas tran ecg_2_32 FIND V(ecg_l0) AT=3.6220000
.meas tran raw_2_33 FIND V(rpeak_raw) AT=3.6230000
.meas tran pls_2_33 FIND V(rpeak_pulse) AT=3.6230000
.meas tran ecg_2_33 FIND V(ecg_l0) AT=3.6230000
.meas tran raw_2_34 FIND V(rpeak_raw) AT=3.6240000
.meas tran pls_2_34 FIND V(rpeak_pulse) AT=3.6240000
.meas tran ecg_2_34 FIND V(ecg_l0) AT=3.6240000
.meas tran raw_2_35 FIND V(rpeak_raw) AT=3.6250000
.meas tran pls_2_35 FIND V(rpeak_pulse) AT=3.6250000
.meas tran ecg_2_35 FIND V(ecg_l0) AT=3.6250000
.meas tran raw_2_36 FIND V(rpeak_raw) AT=3.6260000
.meas tran pls_2_36 FIND V(rpeak_pulse) AT=3.6260000
.meas tran ecg_2_36 FIND V(ecg_l0) AT=3.6260000
.meas tran raw_2_37 FIND V(rpeak_raw) AT=3.6270000
.meas tran pls_2_37 FIND V(rpeak_pulse) AT=3.6270000
.meas tran ecg_2_37 FIND V(ecg_l0) AT=3.6270000
.meas tran raw_2_38 FIND V(rpeak_raw) AT=3.6280000
.meas tran pls_2_38 FIND V(rpeak_pulse) AT=3.6280000
.meas tran ecg_2_38 FIND V(ecg_l0) AT=3.6280000
.meas tran raw_2_39 FIND V(rpeak_raw) AT=3.6290000
.meas tran pls_2_39 FIND V(rpeak_pulse) AT=3.6290000
.meas tran ecg_2_39 FIND V(ecg_l0) AT=3.6290000
.meas tran raw_2_40 FIND V(rpeak_raw) AT=3.6300000
.meas tran pls_2_40 FIND V(rpeak_pulse) AT=3.6300000
.meas tran ecg_2_40 FIND V(ecg_l0) AT=3.6300000
.meas tran raw_3_00 FIND V(rpeak_raw) AT=4.3816667
.meas tran pls_3_00 FIND V(rpeak_pulse) AT=4.3816667
.meas tran ecg_3_00 FIND V(ecg_l0) AT=4.3816667
.meas tran raw_3_01 FIND V(rpeak_raw) AT=4.3826667
.meas tran pls_3_01 FIND V(rpeak_pulse) AT=4.3826667
.meas tran ecg_3_01 FIND V(ecg_l0) AT=4.3826667
.meas tran raw_3_02 FIND V(rpeak_raw) AT=4.3836667
.meas tran pls_3_02 FIND V(rpeak_pulse) AT=4.3836667
.meas tran ecg_3_02 FIND V(ecg_l0) AT=4.3836667
.meas tran raw_3_03 FIND V(rpeak_raw) AT=4.3846667
.meas tran pls_3_03 FIND V(rpeak_pulse) AT=4.3846667
.meas tran ecg_3_03 FIND V(ecg_l0) AT=4.3846667
.meas tran raw_3_04 FIND V(rpeak_raw) AT=4.3856667
.meas tran pls_3_04 FIND V(rpeak_pulse) AT=4.3856667
.meas tran ecg_3_04 FIND V(ecg_l0) AT=4.3856667
.meas tran raw_3_05 FIND V(rpeak_raw) AT=4.3866667
.meas tran pls_3_05 FIND V(rpeak_pulse) AT=4.3866667
.meas tran ecg_3_05 FIND V(ecg_l0) AT=4.3866667
.meas tran raw_3_06 FIND V(rpeak_raw) AT=4.3876667
.meas tran pls_3_06 FIND V(rpeak_pulse) AT=4.3876667
.meas tran ecg_3_06 FIND V(ecg_l0) AT=4.3876667
.meas tran raw_3_07 FIND V(rpeak_raw) AT=4.3886667
.meas tran pls_3_07 FIND V(rpeak_pulse) AT=4.3886667
.meas tran ecg_3_07 FIND V(ecg_l0) AT=4.3886667
.meas tran raw_3_08 FIND V(rpeak_raw) AT=4.3896667
.meas tran pls_3_08 FIND V(rpeak_pulse) AT=4.3896667
.meas tran ecg_3_08 FIND V(ecg_l0) AT=4.3896667
.meas tran raw_3_09 FIND V(rpeak_raw) AT=4.3906667
.meas tran pls_3_09 FIND V(rpeak_pulse) AT=4.3906667
.meas tran ecg_3_09 FIND V(ecg_l0) AT=4.3906667
.meas tran raw_3_10 FIND V(rpeak_raw) AT=4.3916667
.meas tran pls_3_10 FIND V(rpeak_pulse) AT=4.3916667
.meas tran ecg_3_10 FIND V(ecg_l0) AT=4.3916667
.meas tran raw_3_11 FIND V(rpeak_raw) AT=4.3926667
.meas tran pls_3_11 FIND V(rpeak_pulse) AT=4.3926667
.meas tran ecg_3_11 FIND V(ecg_l0) AT=4.3926667
.meas tran raw_3_12 FIND V(rpeak_raw) AT=4.3936667
.meas tran pls_3_12 FIND V(rpeak_pulse) AT=4.3936667
.meas tran ecg_3_12 FIND V(ecg_l0) AT=4.3936667
.meas tran raw_3_13 FIND V(rpeak_raw) AT=4.3946667
.meas tran pls_3_13 FIND V(rpeak_pulse) AT=4.3946667
.meas tran ecg_3_13 FIND V(ecg_l0) AT=4.3946667
.meas tran raw_3_14 FIND V(rpeak_raw) AT=4.3956667
.meas tran pls_3_14 FIND V(rpeak_pulse) AT=4.3956667
.meas tran ecg_3_14 FIND V(ecg_l0) AT=4.3956667
.meas tran raw_3_15 FIND V(rpeak_raw) AT=4.3966667
.meas tran pls_3_15 FIND V(rpeak_pulse) AT=4.3966667
.meas tran ecg_3_15 FIND V(ecg_l0) AT=4.3966667
.meas tran raw_3_16 FIND V(rpeak_raw) AT=4.3976667
.meas tran pls_3_16 FIND V(rpeak_pulse) AT=4.3976667
.meas tran ecg_3_16 FIND V(ecg_l0) AT=4.3976667
.meas tran raw_3_17 FIND V(rpeak_raw) AT=4.3986667
.meas tran pls_3_17 FIND V(rpeak_pulse) AT=4.3986667
.meas tran ecg_3_17 FIND V(ecg_l0) AT=4.3986667
.meas tran raw_3_18 FIND V(rpeak_raw) AT=4.3996667
.meas tran pls_3_18 FIND V(rpeak_pulse) AT=4.3996667
.meas tran ecg_3_18 FIND V(ecg_l0) AT=4.3996667
.meas tran raw_3_19 FIND V(rpeak_raw) AT=4.4006667
.meas tran pls_3_19 FIND V(rpeak_pulse) AT=4.4006667
.meas tran ecg_3_19 FIND V(ecg_l0) AT=4.4006667
.meas tran raw_3_20 FIND V(rpeak_raw) AT=4.4016667
.meas tran pls_3_20 FIND V(rpeak_pulse) AT=4.4016667
.meas tran ecg_3_20 FIND V(ecg_l0) AT=4.4016667
.meas tran raw_3_21 FIND V(rpeak_raw) AT=4.4026667
.meas tran pls_3_21 FIND V(rpeak_pulse) AT=4.4026667
.meas tran ecg_3_21 FIND V(ecg_l0) AT=4.4026667
.meas tran raw_3_22 FIND V(rpeak_raw) AT=4.4036667
.meas tran pls_3_22 FIND V(rpeak_pulse) AT=4.4036667
.meas tran ecg_3_22 FIND V(ecg_l0) AT=4.4036667
.meas tran raw_3_23 FIND V(rpeak_raw) AT=4.4046667
.meas tran pls_3_23 FIND V(rpeak_pulse) AT=4.4046667
.meas tran ecg_3_23 FIND V(ecg_l0) AT=4.4046667
.meas tran raw_3_24 FIND V(rpeak_raw) AT=4.4056667
.meas tran pls_3_24 FIND V(rpeak_pulse) AT=4.4056667
.meas tran ecg_3_24 FIND V(ecg_l0) AT=4.4056667
.meas tran raw_3_25 FIND V(rpeak_raw) AT=4.4066667
.meas tran pls_3_25 FIND V(rpeak_pulse) AT=4.4066667
.meas tran ecg_3_25 FIND V(ecg_l0) AT=4.4066667
.meas tran raw_3_26 FIND V(rpeak_raw) AT=4.4076667
.meas tran pls_3_26 FIND V(rpeak_pulse) AT=4.4076667
.meas tran ecg_3_26 FIND V(ecg_l0) AT=4.4076667
.meas tran raw_3_27 FIND V(rpeak_raw) AT=4.4086667
.meas tran pls_3_27 FIND V(rpeak_pulse) AT=4.4086667
.meas tran ecg_3_27 FIND V(ecg_l0) AT=4.4086667
.meas tran raw_3_28 FIND V(rpeak_raw) AT=4.4096667
.meas tran pls_3_28 FIND V(rpeak_pulse) AT=4.4096667
.meas tran ecg_3_28 FIND V(ecg_l0) AT=4.4096667
.meas tran raw_3_29 FIND V(rpeak_raw) AT=4.4106667
.meas tran pls_3_29 FIND V(rpeak_pulse) AT=4.4106667
.meas tran ecg_3_29 FIND V(ecg_l0) AT=4.4106667
.meas tran raw_3_30 FIND V(rpeak_raw) AT=4.4116667
.meas tran pls_3_30 FIND V(rpeak_pulse) AT=4.4116667
.meas tran ecg_3_30 FIND V(ecg_l0) AT=4.4116667
.meas tran raw_3_31 FIND V(rpeak_raw) AT=4.4126667
.meas tran pls_3_31 FIND V(rpeak_pulse) AT=4.4126667
.meas tran ecg_3_31 FIND V(ecg_l0) AT=4.4126667
.meas tran raw_3_32 FIND V(rpeak_raw) AT=4.4136667
.meas tran pls_3_32 FIND V(rpeak_pulse) AT=4.4136667
.meas tran ecg_3_32 FIND V(ecg_l0) AT=4.4136667
.meas tran raw_3_33 FIND V(rpeak_raw) AT=4.4146667
.meas tran pls_3_33 FIND V(rpeak_pulse) AT=4.4146667
.meas tran ecg_3_33 FIND V(ecg_l0) AT=4.4146667
.meas tran raw_3_34 FIND V(rpeak_raw) AT=4.4156667
.meas tran pls_3_34 FIND V(rpeak_pulse) AT=4.4156667
.meas tran ecg_3_34 FIND V(ecg_l0) AT=4.4156667
.meas tran raw_3_35 FIND V(rpeak_raw) AT=4.4166667
.meas tran pls_3_35 FIND V(rpeak_pulse) AT=4.4166667
.meas tran ecg_3_35 FIND V(ecg_l0) AT=4.4166667
.meas tran raw_3_36 FIND V(rpeak_raw) AT=4.4176667
.meas tran pls_3_36 FIND V(rpeak_pulse) AT=4.4176667
.meas tran ecg_3_36 FIND V(ecg_l0) AT=4.4176667
.meas tran raw_3_37 FIND V(rpeak_raw) AT=4.4186667
.meas tran pls_3_37 FIND V(rpeak_pulse) AT=4.4186667
.meas tran ecg_3_37 FIND V(ecg_l0) AT=4.4186667
.meas tran raw_3_38 FIND V(rpeak_raw) AT=4.4196667
.meas tran pls_3_38 FIND V(rpeak_pulse) AT=4.4196667
.meas tran ecg_3_38 FIND V(ecg_l0) AT=4.4196667
.meas tran raw_3_39 FIND V(rpeak_raw) AT=4.4206667
.meas tran pls_3_39 FIND V(rpeak_pulse) AT=4.4206667
.meas tran ecg_3_39 FIND V(ecg_l0) AT=4.4206667
.meas tran raw_3_40 FIND V(rpeak_raw) AT=4.4216667
.meas tran pls_3_40 FIND V(rpeak_pulse) AT=4.4216667
.meas tran ecg_3_40 FIND V(ecg_l0) AT=4.4216667
.meas tran raw_4_00 FIND V(rpeak_raw) AT=5.1705556
.meas tran pls_4_00 FIND V(rpeak_pulse) AT=5.1705556
.meas tran ecg_4_00 FIND V(ecg_l0) AT=5.1705556
.meas tran raw_4_01 FIND V(rpeak_raw) AT=5.1715556
.meas tran pls_4_01 FIND V(rpeak_pulse) AT=5.1715556
.meas tran ecg_4_01 FIND V(ecg_l0) AT=5.1715556
.meas tran raw_4_02 FIND V(rpeak_raw) AT=5.1725556
.meas tran pls_4_02 FIND V(rpeak_pulse) AT=5.1725556
.meas tran ecg_4_02 FIND V(ecg_l0) AT=5.1725556
.meas tran raw_4_03 FIND V(rpeak_raw) AT=5.1735556
.meas tran pls_4_03 FIND V(rpeak_pulse) AT=5.1735556
.meas tran ecg_4_03 FIND V(ecg_l0) AT=5.1735556
.meas tran raw_4_04 FIND V(rpeak_raw) AT=5.1745556
.meas tran pls_4_04 FIND V(rpeak_pulse) AT=5.1745556
.meas tran ecg_4_04 FIND V(ecg_l0) AT=5.1745556
.meas tran raw_4_05 FIND V(rpeak_raw) AT=5.1755556
.meas tran pls_4_05 FIND V(rpeak_pulse) AT=5.1755556
.meas tran ecg_4_05 FIND V(ecg_l0) AT=5.1755556
.meas tran raw_4_06 FIND V(rpeak_raw) AT=5.1765556
.meas tran pls_4_06 FIND V(rpeak_pulse) AT=5.1765556
.meas tran ecg_4_06 FIND V(ecg_l0) AT=5.1765556
.meas tran raw_4_07 FIND V(rpeak_raw) AT=5.1775556
.meas tran pls_4_07 FIND V(rpeak_pulse) AT=5.1775556
.meas tran ecg_4_07 FIND V(ecg_l0) AT=5.1775556
.meas tran raw_4_08 FIND V(rpeak_raw) AT=5.1785556
.meas tran pls_4_08 FIND V(rpeak_pulse) AT=5.1785556
.meas tran ecg_4_08 FIND V(ecg_l0) AT=5.1785556
.meas tran raw_4_09 FIND V(rpeak_raw) AT=5.1795556
.meas tran pls_4_09 FIND V(rpeak_pulse) AT=5.1795556
.meas tran ecg_4_09 FIND V(ecg_l0) AT=5.1795556
.meas tran raw_4_10 FIND V(rpeak_raw) AT=5.1805556
.meas tran pls_4_10 FIND V(rpeak_pulse) AT=5.1805556
.meas tran ecg_4_10 FIND V(ecg_l0) AT=5.1805556
.meas tran raw_4_11 FIND V(rpeak_raw) AT=5.1815556
.meas tran pls_4_11 FIND V(rpeak_pulse) AT=5.1815556
.meas tran ecg_4_11 FIND V(ecg_l0) AT=5.1815556
.meas tran raw_4_12 FIND V(rpeak_raw) AT=5.1825556
.meas tran pls_4_12 FIND V(rpeak_pulse) AT=5.1825556
.meas tran ecg_4_12 FIND V(ecg_l0) AT=5.1825556
.meas tran raw_4_13 FIND V(rpeak_raw) AT=5.1835556
.meas tran pls_4_13 FIND V(rpeak_pulse) AT=5.1835556
.meas tran ecg_4_13 FIND V(ecg_l0) AT=5.1835556
.meas tran raw_4_14 FIND V(rpeak_raw) AT=5.1845556
.meas tran pls_4_14 FIND V(rpeak_pulse) AT=5.1845556
.meas tran ecg_4_14 FIND V(ecg_l0) AT=5.1845556
.meas tran raw_4_15 FIND V(rpeak_raw) AT=5.1855556
.meas tran pls_4_15 FIND V(rpeak_pulse) AT=5.1855556
.meas tran ecg_4_15 FIND V(ecg_l0) AT=5.1855556
.meas tran raw_4_16 FIND V(rpeak_raw) AT=5.1865556
.meas tran pls_4_16 FIND V(rpeak_pulse) AT=5.1865556
.meas tran ecg_4_16 FIND V(ecg_l0) AT=5.1865556
.meas tran raw_4_17 FIND V(rpeak_raw) AT=5.1875556
.meas tran pls_4_17 FIND V(rpeak_pulse) AT=5.1875556
.meas tran ecg_4_17 FIND V(ecg_l0) AT=5.1875556
.meas tran raw_4_18 FIND V(rpeak_raw) AT=5.1885556
.meas tran pls_4_18 FIND V(rpeak_pulse) AT=5.1885556
.meas tran ecg_4_18 FIND V(ecg_l0) AT=5.1885556
.meas tran raw_4_19 FIND V(rpeak_raw) AT=5.1895556
.meas tran pls_4_19 FIND V(rpeak_pulse) AT=5.1895556
.meas tran ecg_4_19 FIND V(ecg_l0) AT=5.1895556
.meas tran raw_4_20 FIND V(rpeak_raw) AT=5.1905556
.meas tran pls_4_20 FIND V(rpeak_pulse) AT=5.1905556
.meas tran ecg_4_20 FIND V(ecg_l0) AT=5.1905556
.meas tran raw_4_21 FIND V(rpeak_raw) AT=5.1915556
.meas tran pls_4_21 FIND V(rpeak_pulse) AT=5.1915556
.meas tran ecg_4_21 FIND V(ecg_l0) AT=5.1915556
.meas tran raw_4_22 FIND V(rpeak_raw) AT=5.1925556
.meas tran pls_4_22 FIND V(rpeak_pulse) AT=5.1925556
.meas tran ecg_4_22 FIND V(ecg_l0) AT=5.1925556
.meas tran raw_4_23 FIND V(rpeak_raw) AT=5.1935556
.meas tran pls_4_23 FIND V(rpeak_pulse) AT=5.1935556
.meas tran ecg_4_23 FIND V(ecg_l0) AT=5.1935556
.meas tran raw_4_24 FIND V(rpeak_raw) AT=5.1945556
.meas tran pls_4_24 FIND V(rpeak_pulse) AT=5.1945556
.meas tran ecg_4_24 FIND V(ecg_l0) AT=5.1945556
.meas tran raw_4_25 FIND V(rpeak_raw) AT=5.1955556
.meas tran pls_4_25 FIND V(rpeak_pulse) AT=5.1955556
.meas tran ecg_4_25 FIND V(ecg_l0) AT=5.1955556
.meas tran raw_4_26 FIND V(rpeak_raw) AT=5.1965556
.meas tran pls_4_26 FIND V(rpeak_pulse) AT=5.1965556
.meas tran ecg_4_26 FIND V(ecg_l0) AT=5.1965556
.meas tran raw_4_27 FIND V(rpeak_raw) AT=5.1975556
.meas tran pls_4_27 FIND V(rpeak_pulse) AT=5.1975556
.meas tran ecg_4_27 FIND V(ecg_l0) AT=5.1975556
.meas tran raw_4_28 FIND V(rpeak_raw) AT=5.1985556
.meas tran pls_4_28 FIND V(rpeak_pulse) AT=5.1985556
.meas tran ecg_4_28 FIND V(ecg_l0) AT=5.1985556
.meas tran raw_4_29 FIND V(rpeak_raw) AT=5.1995556
.meas tran pls_4_29 FIND V(rpeak_pulse) AT=5.1995556
.meas tran ecg_4_29 FIND V(ecg_l0) AT=5.1995556
.meas tran raw_4_30 FIND V(rpeak_raw) AT=5.2005556
.meas tran pls_4_30 FIND V(rpeak_pulse) AT=5.2005556
.meas tran ecg_4_30 FIND V(ecg_l0) AT=5.2005556
.meas tran raw_4_31 FIND V(rpeak_raw) AT=5.2015556
.meas tran pls_4_31 FIND V(rpeak_pulse) AT=5.2015556
.meas tran ecg_4_31 FIND V(ecg_l0) AT=5.2015556
.meas tran raw_4_32 FIND V(rpeak_raw) AT=5.2025556
.meas tran pls_4_32 FIND V(rpeak_pulse) AT=5.2025556
.meas tran ecg_4_32 FIND V(ecg_l0) AT=5.2025556
.meas tran raw_4_33 FIND V(rpeak_raw) AT=5.2035556
.meas tran pls_4_33 FIND V(rpeak_pulse) AT=5.2035556
.meas tran ecg_4_33 FIND V(ecg_l0) AT=5.2035556
.meas tran raw_4_34 FIND V(rpeak_raw) AT=5.2045556
.meas tran pls_4_34 FIND V(rpeak_pulse) AT=5.2045556
.meas tran ecg_4_34 FIND V(ecg_l0) AT=5.2045556
.meas tran raw_4_35 FIND V(rpeak_raw) AT=5.2055556
.meas tran pls_4_35 FIND V(rpeak_pulse) AT=5.2055556
.meas tran ecg_4_35 FIND V(ecg_l0) AT=5.2055556
.meas tran raw_4_36 FIND V(rpeak_raw) AT=5.2065556
.meas tran pls_4_36 FIND V(rpeak_pulse) AT=5.2065556
.meas tran ecg_4_36 FIND V(ecg_l0) AT=5.2065556
.meas tran raw_4_37 FIND V(rpeak_raw) AT=5.2075556
.meas tran pls_4_37 FIND V(rpeak_pulse) AT=5.2075556
.meas tran ecg_4_37 FIND V(ecg_l0) AT=5.2075556
.meas tran raw_4_38 FIND V(rpeak_raw) AT=5.2085556
.meas tran pls_4_38 FIND V(rpeak_pulse) AT=5.2085556
.meas tran ecg_4_38 FIND V(ecg_l0) AT=5.2085556
.meas tran raw_4_39 FIND V(rpeak_raw) AT=5.2095556
.meas tran pls_4_39 FIND V(rpeak_pulse) AT=5.2095556
.meas tran ecg_4_39 FIND V(ecg_l0) AT=5.2095556
.meas tran raw_4_40 FIND V(rpeak_raw) AT=5.2105556
.meas tran pls_4_40 FIND V(rpeak_pulse) AT=5.2105556
.meas tran ecg_4_40 FIND V(ecg_l0) AT=5.2105556
.meas tran raw_5_00 FIND V(rpeak_raw) AT=5.9872222
.meas tran pls_5_00 FIND V(rpeak_pulse) AT=5.9872222
.meas tran ecg_5_00 FIND V(ecg_l0) AT=5.9872222
.meas tran raw_5_01 FIND V(rpeak_raw) AT=5.9882222
.meas tran pls_5_01 FIND V(rpeak_pulse) AT=5.9882222
.meas tran ecg_5_01 FIND V(ecg_l0) AT=5.9882222
.meas tran raw_5_02 FIND V(rpeak_raw) AT=5.9892222
.meas tran pls_5_02 FIND V(rpeak_pulse) AT=5.9892222
.meas tran ecg_5_02 FIND V(ecg_l0) AT=5.9892222
.meas tran raw_5_03 FIND V(rpeak_raw) AT=5.9902222
.meas tran pls_5_03 FIND V(rpeak_pulse) AT=5.9902222
.meas tran ecg_5_03 FIND V(ecg_l0) AT=5.9902222
.meas tran raw_5_04 FIND V(rpeak_raw) AT=5.9912222
.meas tran pls_5_04 FIND V(rpeak_pulse) AT=5.9912222
.meas tran ecg_5_04 FIND V(ecg_l0) AT=5.9912222
.meas tran raw_5_05 FIND V(rpeak_raw) AT=5.9922222
.meas tran pls_5_05 FIND V(rpeak_pulse) AT=5.9922222
.meas tran ecg_5_05 FIND V(ecg_l0) AT=5.9922222
.meas tran raw_5_06 FIND V(rpeak_raw) AT=5.9932222
.meas tran pls_5_06 FIND V(rpeak_pulse) AT=5.9932222
.meas tran ecg_5_06 FIND V(ecg_l0) AT=5.9932222
.meas tran raw_5_07 FIND V(rpeak_raw) AT=5.9942222
.meas tran pls_5_07 FIND V(rpeak_pulse) AT=5.9942222
.meas tran ecg_5_07 FIND V(ecg_l0) AT=5.9942222
.meas tran raw_5_08 FIND V(rpeak_raw) AT=5.9952222
.meas tran pls_5_08 FIND V(rpeak_pulse) AT=5.9952222
.meas tran ecg_5_08 FIND V(ecg_l0) AT=5.9952222
.meas tran raw_5_09 FIND V(rpeak_raw) AT=5.9962222
.meas tran pls_5_09 FIND V(rpeak_pulse) AT=5.9962222
.meas tran ecg_5_09 FIND V(ecg_l0) AT=5.9962222
.meas tran raw_5_10 FIND V(rpeak_raw) AT=5.9972222
.meas tran pls_5_10 FIND V(rpeak_pulse) AT=5.9972222
.meas tran ecg_5_10 FIND V(ecg_l0) AT=5.9972222
.meas tran raw_5_11 FIND V(rpeak_raw) AT=5.9982222
.meas tran pls_5_11 FIND V(rpeak_pulse) AT=5.9982222
.meas tran ecg_5_11 FIND V(ecg_l0) AT=5.9982222
.meas tran raw_5_12 FIND V(rpeak_raw) AT=5.9992222
.meas tran pls_5_12 FIND V(rpeak_pulse) AT=5.9992222
.meas tran ecg_5_12 FIND V(ecg_l0) AT=5.9992222
.meas tran raw_5_13 FIND V(rpeak_raw) AT=6.0002222
.meas tran pls_5_13 FIND V(rpeak_pulse) AT=6.0002222
.meas tran ecg_5_13 FIND V(ecg_l0) AT=6.0002222
.meas tran raw_5_14 FIND V(rpeak_raw) AT=6.0012222
.meas tran pls_5_14 FIND V(rpeak_pulse) AT=6.0012222
.meas tran ecg_5_14 FIND V(ecg_l0) AT=6.0012222
.meas tran raw_5_15 FIND V(rpeak_raw) AT=6.0022222
.meas tran pls_5_15 FIND V(rpeak_pulse) AT=6.0022222
.meas tran ecg_5_15 FIND V(ecg_l0) AT=6.0022222
.meas tran raw_5_16 FIND V(rpeak_raw) AT=6.0032222
.meas tran pls_5_16 FIND V(rpeak_pulse) AT=6.0032222
.meas tran ecg_5_16 FIND V(ecg_l0) AT=6.0032222
.meas tran raw_5_17 FIND V(rpeak_raw) AT=6.0042222
.meas tran pls_5_17 FIND V(rpeak_pulse) AT=6.0042222
.meas tran ecg_5_17 FIND V(ecg_l0) AT=6.0042222
.meas tran raw_5_18 FIND V(rpeak_raw) AT=6.0052222
.meas tran pls_5_18 FIND V(rpeak_pulse) AT=6.0052222
.meas tran ecg_5_18 FIND V(ecg_l0) AT=6.0052222
.meas tran raw_5_19 FIND V(rpeak_raw) AT=6.0062222
.meas tran pls_5_19 FIND V(rpeak_pulse) AT=6.0062222
.meas tran ecg_5_19 FIND V(ecg_l0) AT=6.0062222
.meas tran raw_5_20 FIND V(rpeak_raw) AT=6.0072222
.meas tran pls_5_20 FIND V(rpeak_pulse) AT=6.0072222
.meas tran ecg_5_20 FIND V(ecg_l0) AT=6.0072222
.meas tran raw_5_21 FIND V(rpeak_raw) AT=6.0082222
.meas tran pls_5_21 FIND V(rpeak_pulse) AT=6.0082222
.meas tran ecg_5_21 FIND V(ecg_l0) AT=6.0082222
.meas tran raw_5_22 FIND V(rpeak_raw) AT=6.0092222
.meas tran pls_5_22 FIND V(rpeak_pulse) AT=6.0092222
.meas tran ecg_5_22 FIND V(ecg_l0) AT=6.0092222
.meas tran raw_5_23 FIND V(rpeak_raw) AT=6.0102222
.meas tran pls_5_23 FIND V(rpeak_pulse) AT=6.0102222
.meas tran ecg_5_23 FIND V(ecg_l0) AT=6.0102222
.meas tran raw_5_24 FIND V(rpeak_raw) AT=6.0112222
.meas tran pls_5_24 FIND V(rpeak_pulse) AT=6.0112222
.meas tran ecg_5_24 FIND V(ecg_l0) AT=6.0112222
.meas tran raw_5_25 FIND V(rpeak_raw) AT=6.0122222
.meas tran pls_5_25 FIND V(rpeak_pulse) AT=6.0122222
.meas tran ecg_5_25 FIND V(ecg_l0) AT=6.0122222
.meas tran raw_5_26 FIND V(rpeak_raw) AT=6.0132222
.meas tran pls_5_26 FIND V(rpeak_pulse) AT=6.0132222
.meas tran ecg_5_26 FIND V(ecg_l0) AT=6.0132222
.meas tran raw_5_27 FIND V(rpeak_raw) AT=6.0142222
.meas tran pls_5_27 FIND V(rpeak_pulse) AT=6.0142222
.meas tran ecg_5_27 FIND V(ecg_l0) AT=6.0142222
.meas tran raw_5_28 FIND V(rpeak_raw) AT=6.0152222
.meas tran pls_5_28 FIND V(rpeak_pulse) AT=6.0152222
.meas tran ecg_5_28 FIND V(ecg_l0) AT=6.0152222
.meas tran raw_5_29 FIND V(rpeak_raw) AT=6.0162222
.meas tran pls_5_29 FIND V(rpeak_pulse) AT=6.0162222
.meas tran ecg_5_29 FIND V(ecg_l0) AT=6.0162222
.meas tran raw_5_30 FIND V(rpeak_raw) AT=6.0172222
.meas tran pls_5_30 FIND V(rpeak_pulse) AT=6.0172222
.meas tran ecg_5_30 FIND V(ecg_l0) AT=6.0172222
.meas tran raw_5_31 FIND V(rpeak_raw) AT=6.0182222
.meas tran pls_5_31 FIND V(rpeak_pulse) AT=6.0182222
.meas tran ecg_5_31 FIND V(ecg_l0) AT=6.0182222
.meas tran raw_5_32 FIND V(rpeak_raw) AT=6.0192222
.meas tran pls_5_32 FIND V(rpeak_pulse) AT=6.0192222
.meas tran ecg_5_32 FIND V(ecg_l0) AT=6.0192222
.meas tran raw_5_33 FIND V(rpeak_raw) AT=6.0202222
.meas tran pls_5_33 FIND V(rpeak_pulse) AT=6.0202222
.meas tran ecg_5_33 FIND V(ecg_l0) AT=6.0202222
.meas tran raw_5_34 FIND V(rpeak_raw) AT=6.0212222
.meas tran pls_5_34 FIND V(rpeak_pulse) AT=6.0212222
.meas tran ecg_5_34 FIND V(ecg_l0) AT=6.0212222
.meas tran raw_5_35 FIND V(rpeak_raw) AT=6.0222222
.meas tran pls_5_35 FIND V(rpeak_pulse) AT=6.0222222
.meas tran ecg_5_35 FIND V(ecg_l0) AT=6.0222222
.meas tran raw_5_36 FIND V(rpeak_raw) AT=6.0232222
.meas tran pls_5_36 FIND V(rpeak_pulse) AT=6.0232222
.meas tran ecg_5_36 FIND V(ecg_l0) AT=6.0232222
.meas tran raw_5_37 FIND V(rpeak_raw) AT=6.0242222
.meas tran pls_5_37 FIND V(rpeak_pulse) AT=6.0242222
.meas tran ecg_5_37 FIND V(ecg_l0) AT=6.0242222
.meas tran raw_5_38 FIND V(rpeak_raw) AT=6.0252222
.meas tran pls_5_38 FIND V(rpeak_pulse) AT=6.0252222
.meas tran ecg_5_38 FIND V(ecg_l0) AT=6.0252222
.meas tran raw_5_39 FIND V(rpeak_raw) AT=6.0262222
.meas tran pls_5_39 FIND V(rpeak_pulse) AT=6.0262222
.meas tran ecg_5_39 FIND V(ecg_l0) AT=6.0262222
.meas tran raw_5_40 FIND V(rpeak_raw) AT=6.0272222
.meas tran pls_5_40 FIND V(rpeak_pulse) AT=6.0272222
.meas tran ecg_5_40 FIND V(ecg_l0) AT=6.0272222
.meas tran raw_6_00 FIND V(rpeak_raw) AT=6.6400000
.meas tran pls_6_00 FIND V(rpeak_pulse) AT=6.6400000
.meas tran ecg_6_00 FIND V(ecg_l0) AT=6.6400000
.meas tran raw_6_01 FIND V(rpeak_raw) AT=6.6410000
.meas tran pls_6_01 FIND V(rpeak_pulse) AT=6.6410000
.meas tran ecg_6_01 FIND V(ecg_l0) AT=6.6410000
.meas tran raw_6_02 FIND V(rpeak_raw) AT=6.6420000
.meas tran pls_6_02 FIND V(rpeak_pulse) AT=6.6420000
.meas tran ecg_6_02 FIND V(ecg_l0) AT=6.6420000
.meas tran raw_6_03 FIND V(rpeak_raw) AT=6.6430000
.meas tran pls_6_03 FIND V(rpeak_pulse) AT=6.6430000
.meas tran ecg_6_03 FIND V(ecg_l0) AT=6.6430000
.meas tran raw_6_04 FIND V(rpeak_raw) AT=6.6440000
.meas tran pls_6_04 FIND V(rpeak_pulse) AT=6.6440000
.meas tran ecg_6_04 FIND V(ecg_l0) AT=6.6440000
.meas tran raw_6_05 FIND V(rpeak_raw) AT=6.6450000
.meas tran pls_6_05 FIND V(rpeak_pulse) AT=6.6450000
.meas tran ecg_6_05 FIND V(ecg_l0) AT=6.6450000
.meas tran raw_6_06 FIND V(rpeak_raw) AT=6.6460000
.meas tran pls_6_06 FIND V(rpeak_pulse) AT=6.6460000
.meas tran ecg_6_06 FIND V(ecg_l0) AT=6.6460000
.meas tran raw_6_07 FIND V(rpeak_raw) AT=6.6470000
.meas tran pls_6_07 FIND V(rpeak_pulse) AT=6.6470000
.meas tran ecg_6_07 FIND V(ecg_l0) AT=6.6470000
.meas tran raw_6_08 FIND V(rpeak_raw) AT=6.6480000
.meas tran pls_6_08 FIND V(rpeak_pulse) AT=6.6480000
.meas tran ecg_6_08 FIND V(ecg_l0) AT=6.6480000
.meas tran raw_6_09 FIND V(rpeak_raw) AT=6.6490000
.meas tran pls_6_09 FIND V(rpeak_pulse) AT=6.6490000
.meas tran ecg_6_09 FIND V(ecg_l0) AT=6.6490000
.meas tran raw_6_10 FIND V(rpeak_raw) AT=6.6500000
.meas tran pls_6_10 FIND V(rpeak_pulse) AT=6.6500000
.meas tran ecg_6_10 FIND V(ecg_l0) AT=6.6500000
.meas tran raw_6_11 FIND V(rpeak_raw) AT=6.6510000
.meas tran pls_6_11 FIND V(rpeak_pulse) AT=6.6510000
.meas tran ecg_6_11 FIND V(ecg_l0) AT=6.6510000
.meas tran raw_6_12 FIND V(rpeak_raw) AT=6.6520000
.meas tran pls_6_12 FIND V(rpeak_pulse) AT=6.6520000
.meas tran ecg_6_12 FIND V(ecg_l0) AT=6.6520000
.meas tran raw_6_13 FIND V(rpeak_raw) AT=6.6530000
.meas tran pls_6_13 FIND V(rpeak_pulse) AT=6.6530000
.meas tran ecg_6_13 FIND V(ecg_l0) AT=6.6530000
.meas tran raw_6_14 FIND V(rpeak_raw) AT=6.6540000
.meas tran pls_6_14 FIND V(rpeak_pulse) AT=6.6540000
.meas tran ecg_6_14 FIND V(ecg_l0) AT=6.6540000
.meas tran raw_6_15 FIND V(rpeak_raw) AT=6.6550000
.meas tran pls_6_15 FIND V(rpeak_pulse) AT=6.6550000
.meas tran ecg_6_15 FIND V(ecg_l0) AT=6.6550000
.meas tran raw_6_16 FIND V(rpeak_raw) AT=6.6560000
.meas tran pls_6_16 FIND V(rpeak_pulse) AT=6.6560000
.meas tran ecg_6_16 FIND V(ecg_l0) AT=6.6560000
.meas tran raw_6_17 FIND V(rpeak_raw) AT=6.6570000
.meas tran pls_6_17 FIND V(rpeak_pulse) AT=6.6570000
.meas tran ecg_6_17 FIND V(ecg_l0) AT=6.6570000
.meas tran raw_6_18 FIND V(rpeak_raw) AT=6.6580000
.meas tran pls_6_18 FIND V(rpeak_pulse) AT=6.6580000
.meas tran ecg_6_18 FIND V(ecg_l0) AT=6.6580000
.meas tran raw_6_19 FIND V(rpeak_raw) AT=6.6590000
.meas tran pls_6_19 FIND V(rpeak_pulse) AT=6.6590000
.meas tran ecg_6_19 FIND V(ecg_l0) AT=6.6590000
.meas tran raw_6_20 FIND V(rpeak_raw) AT=6.6600000
.meas tran pls_6_20 FIND V(rpeak_pulse) AT=6.6600000
.meas tran ecg_6_20 FIND V(ecg_l0) AT=6.6600000
.meas tran raw_6_21 FIND V(rpeak_raw) AT=6.6610000
.meas tran pls_6_21 FIND V(rpeak_pulse) AT=6.6610000
.meas tran ecg_6_21 FIND V(ecg_l0) AT=6.6610000
.meas tran raw_6_22 FIND V(rpeak_raw) AT=6.6620000
.meas tran pls_6_22 FIND V(rpeak_pulse) AT=6.6620000
.meas tran ecg_6_22 FIND V(ecg_l0) AT=6.6620000
.meas tran raw_6_23 FIND V(rpeak_raw) AT=6.6630000
.meas tran pls_6_23 FIND V(rpeak_pulse) AT=6.6630000
.meas tran ecg_6_23 FIND V(ecg_l0) AT=6.6630000
.meas tran raw_6_24 FIND V(rpeak_raw) AT=6.6640000
.meas tran pls_6_24 FIND V(rpeak_pulse) AT=6.6640000
.meas tran ecg_6_24 FIND V(ecg_l0) AT=6.6640000
.meas tran raw_6_25 FIND V(rpeak_raw) AT=6.6650000
.meas tran pls_6_25 FIND V(rpeak_pulse) AT=6.6650000
.meas tran ecg_6_25 FIND V(ecg_l0) AT=6.6650000
.meas tran raw_6_26 FIND V(rpeak_raw) AT=6.6660000
.meas tran pls_6_26 FIND V(rpeak_pulse) AT=6.6660000
.meas tran ecg_6_26 FIND V(ecg_l0) AT=6.6660000
.meas tran raw_6_27 FIND V(rpeak_raw) AT=6.6670000
.meas tran pls_6_27 FIND V(rpeak_pulse) AT=6.6670000
.meas tran ecg_6_27 FIND V(ecg_l0) AT=6.6670000
.meas tran raw_6_28 FIND V(rpeak_raw) AT=6.6680000
.meas tran pls_6_28 FIND V(rpeak_pulse) AT=6.6680000
.meas tran ecg_6_28 FIND V(ecg_l0) AT=6.6680000
.meas tran raw_6_29 FIND V(rpeak_raw) AT=6.6690000
.meas tran pls_6_29 FIND V(rpeak_pulse) AT=6.6690000
.meas tran ecg_6_29 FIND V(ecg_l0) AT=6.6690000
.meas tran raw_6_30 FIND V(rpeak_raw) AT=6.6700000
.meas tran pls_6_30 FIND V(rpeak_pulse) AT=6.6700000
.meas tran ecg_6_30 FIND V(ecg_l0) AT=6.6700000
.meas tran raw_6_31 FIND V(rpeak_raw) AT=6.6710000
.meas tran pls_6_31 FIND V(rpeak_pulse) AT=6.6710000
.meas tran ecg_6_31 FIND V(ecg_l0) AT=6.6710000
.meas tran raw_6_32 FIND V(rpeak_raw) AT=6.6720000
.meas tran pls_6_32 FIND V(rpeak_pulse) AT=6.6720000
.meas tran ecg_6_32 FIND V(ecg_l0) AT=6.6720000
.meas tran raw_6_33 FIND V(rpeak_raw) AT=6.6730000
.meas tran pls_6_33 FIND V(rpeak_pulse) AT=6.6730000
.meas tran ecg_6_33 FIND V(ecg_l0) AT=6.6730000
.meas tran raw_6_34 FIND V(rpeak_raw) AT=6.6740000
.meas tran pls_6_34 FIND V(rpeak_pulse) AT=6.6740000
.meas tran ecg_6_34 FIND V(ecg_l0) AT=6.6740000
.meas tran raw_6_35 FIND V(rpeak_raw) AT=6.6750000
.meas tran pls_6_35 FIND V(rpeak_pulse) AT=6.6750000
.meas tran ecg_6_35 FIND V(ecg_l0) AT=6.6750000
.meas tran raw_6_36 FIND V(rpeak_raw) AT=6.6760000
.meas tran pls_6_36 FIND V(rpeak_pulse) AT=6.6760000
.meas tran ecg_6_36 FIND V(ecg_l0) AT=6.6760000
.meas tran raw_6_37 FIND V(rpeak_raw) AT=6.6770000
.meas tran pls_6_37 FIND V(rpeak_pulse) AT=6.6770000
.meas tran ecg_6_37 FIND V(ecg_l0) AT=6.6770000
.meas tran raw_6_38 FIND V(rpeak_raw) AT=6.6780000
.meas tran pls_6_38 FIND V(rpeak_pulse) AT=6.6780000
.meas tran ecg_6_38 FIND V(ecg_l0) AT=6.6780000
.meas tran raw_6_39 FIND V(rpeak_raw) AT=6.6790000
.meas tran pls_6_39 FIND V(rpeak_pulse) AT=6.6790000
.meas tran ecg_6_39 FIND V(ecg_l0) AT=6.6790000
.meas tran raw_6_40 FIND V(rpeak_raw) AT=6.6800000
.meas tran pls_6_40 FIND V(rpeak_pulse) AT=6.6800000
.meas tran ecg_6_40 FIND V(ecg_l0) AT=6.6800000
.meas tran raw_7_00 FIND V(rpeak_raw) AT=7.6344444
.meas tran pls_7_00 FIND V(rpeak_pulse) AT=7.6344444
.meas tran ecg_7_00 FIND V(ecg_l0) AT=7.6344444
.meas tran raw_7_01 FIND V(rpeak_raw) AT=7.6354444
.meas tran pls_7_01 FIND V(rpeak_pulse) AT=7.6354444
.meas tran ecg_7_01 FIND V(ecg_l0) AT=7.6354444
.meas tran raw_7_02 FIND V(rpeak_raw) AT=7.6364444
.meas tran pls_7_02 FIND V(rpeak_pulse) AT=7.6364444
.meas tran ecg_7_02 FIND V(ecg_l0) AT=7.6364444
.meas tran raw_7_03 FIND V(rpeak_raw) AT=7.6374444
.meas tran pls_7_03 FIND V(rpeak_pulse) AT=7.6374444
.meas tran ecg_7_03 FIND V(ecg_l0) AT=7.6374444
.meas tran raw_7_04 FIND V(rpeak_raw) AT=7.6384444
.meas tran pls_7_04 FIND V(rpeak_pulse) AT=7.6384444
.meas tran ecg_7_04 FIND V(ecg_l0) AT=7.6384444
.meas tran raw_7_05 FIND V(rpeak_raw) AT=7.6394444
.meas tran pls_7_05 FIND V(rpeak_pulse) AT=7.6394444
.meas tran ecg_7_05 FIND V(ecg_l0) AT=7.6394444
.meas tran raw_7_06 FIND V(rpeak_raw) AT=7.6404444
.meas tran pls_7_06 FIND V(rpeak_pulse) AT=7.6404444
.meas tran ecg_7_06 FIND V(ecg_l0) AT=7.6404444
.meas tran raw_7_07 FIND V(rpeak_raw) AT=7.6414444
.meas tran pls_7_07 FIND V(rpeak_pulse) AT=7.6414444
.meas tran ecg_7_07 FIND V(ecg_l0) AT=7.6414444
.meas tran raw_7_08 FIND V(rpeak_raw) AT=7.6424444
.meas tran pls_7_08 FIND V(rpeak_pulse) AT=7.6424444
.meas tran ecg_7_08 FIND V(ecg_l0) AT=7.6424444
.meas tran raw_7_09 FIND V(rpeak_raw) AT=7.6434444
.meas tran pls_7_09 FIND V(rpeak_pulse) AT=7.6434444
.meas tran ecg_7_09 FIND V(ecg_l0) AT=7.6434444
.meas tran raw_7_10 FIND V(rpeak_raw) AT=7.6444444
.meas tran pls_7_10 FIND V(rpeak_pulse) AT=7.6444444
.meas tran ecg_7_10 FIND V(ecg_l0) AT=7.6444444
.meas tran raw_7_11 FIND V(rpeak_raw) AT=7.6454444
.meas tran pls_7_11 FIND V(rpeak_pulse) AT=7.6454444
.meas tran ecg_7_11 FIND V(ecg_l0) AT=7.6454444
.meas tran raw_7_12 FIND V(rpeak_raw) AT=7.6464444
.meas tran pls_7_12 FIND V(rpeak_pulse) AT=7.6464444
.meas tran ecg_7_12 FIND V(ecg_l0) AT=7.6464444
.meas tran raw_7_13 FIND V(rpeak_raw) AT=7.6474444
.meas tran pls_7_13 FIND V(rpeak_pulse) AT=7.6474444
.meas tran ecg_7_13 FIND V(ecg_l0) AT=7.6474444
.meas tran raw_7_14 FIND V(rpeak_raw) AT=7.6484444
.meas tran pls_7_14 FIND V(rpeak_pulse) AT=7.6484444
.meas tran ecg_7_14 FIND V(ecg_l0) AT=7.6484444
.meas tran raw_7_15 FIND V(rpeak_raw) AT=7.6494444
.meas tran pls_7_15 FIND V(rpeak_pulse) AT=7.6494444
.meas tran ecg_7_15 FIND V(ecg_l0) AT=7.6494444
.meas tran raw_7_16 FIND V(rpeak_raw) AT=7.6504444
.meas tran pls_7_16 FIND V(rpeak_pulse) AT=7.6504444
.meas tran ecg_7_16 FIND V(ecg_l0) AT=7.6504444
.meas tran raw_7_17 FIND V(rpeak_raw) AT=7.6514444
.meas tran pls_7_17 FIND V(rpeak_pulse) AT=7.6514444
.meas tran ecg_7_17 FIND V(ecg_l0) AT=7.6514444
.meas tran raw_7_18 FIND V(rpeak_raw) AT=7.6524444
.meas tran pls_7_18 FIND V(rpeak_pulse) AT=7.6524444
.meas tran ecg_7_18 FIND V(ecg_l0) AT=7.6524444
.meas tran raw_7_19 FIND V(rpeak_raw) AT=7.6534444
.meas tran pls_7_19 FIND V(rpeak_pulse) AT=7.6534444
.meas tran ecg_7_19 FIND V(ecg_l0) AT=7.6534444
.meas tran raw_7_20 FIND V(rpeak_raw) AT=7.6544444
.meas tran pls_7_20 FIND V(rpeak_pulse) AT=7.6544444
.meas tran ecg_7_20 FIND V(ecg_l0) AT=7.6544444
.meas tran raw_7_21 FIND V(rpeak_raw) AT=7.6554444
.meas tran pls_7_21 FIND V(rpeak_pulse) AT=7.6554444
.meas tran ecg_7_21 FIND V(ecg_l0) AT=7.6554444
.meas tran raw_7_22 FIND V(rpeak_raw) AT=7.6564444
.meas tran pls_7_22 FIND V(rpeak_pulse) AT=7.6564444
.meas tran ecg_7_22 FIND V(ecg_l0) AT=7.6564444
.meas tran raw_7_23 FIND V(rpeak_raw) AT=7.6574444
.meas tran pls_7_23 FIND V(rpeak_pulse) AT=7.6574444
.meas tran ecg_7_23 FIND V(ecg_l0) AT=7.6574444
.meas tran raw_7_24 FIND V(rpeak_raw) AT=7.6584444
.meas tran pls_7_24 FIND V(rpeak_pulse) AT=7.6584444
.meas tran ecg_7_24 FIND V(ecg_l0) AT=7.6584444
.meas tran raw_7_25 FIND V(rpeak_raw) AT=7.6594444
.meas tran pls_7_25 FIND V(rpeak_pulse) AT=7.6594444
.meas tran ecg_7_25 FIND V(ecg_l0) AT=7.6594444
.meas tran raw_7_26 FIND V(rpeak_raw) AT=7.6604444
.meas tran pls_7_26 FIND V(rpeak_pulse) AT=7.6604444
.meas tran ecg_7_26 FIND V(ecg_l0) AT=7.6604444
.meas tran raw_7_27 FIND V(rpeak_raw) AT=7.6614444
.meas tran pls_7_27 FIND V(rpeak_pulse) AT=7.6614444
.meas tran ecg_7_27 FIND V(ecg_l0) AT=7.6614444
.meas tran raw_7_28 FIND V(rpeak_raw) AT=7.6624444
.meas tran pls_7_28 FIND V(rpeak_pulse) AT=7.6624444
.meas tran ecg_7_28 FIND V(ecg_l0) AT=7.6624444
.meas tran raw_7_29 FIND V(rpeak_raw) AT=7.6634444
.meas tran pls_7_29 FIND V(rpeak_pulse) AT=7.6634444
.meas tran ecg_7_29 FIND V(ecg_l0) AT=7.6634444
.meas tran raw_7_30 FIND V(rpeak_raw) AT=7.6644444
.meas tran pls_7_30 FIND V(rpeak_pulse) AT=7.6644444
.meas tran ecg_7_30 FIND V(ecg_l0) AT=7.6644444
.meas tran raw_7_31 FIND V(rpeak_raw) AT=7.6654444
.meas tran pls_7_31 FIND V(rpeak_pulse) AT=7.6654444
.meas tran ecg_7_31 FIND V(ecg_l0) AT=7.6654444
.meas tran raw_7_32 FIND V(rpeak_raw) AT=7.6664444
.meas tran pls_7_32 FIND V(rpeak_pulse) AT=7.6664444
.meas tran ecg_7_32 FIND V(ecg_l0) AT=7.6664444
.meas tran raw_7_33 FIND V(rpeak_raw) AT=7.6674444
.meas tran pls_7_33 FIND V(rpeak_pulse) AT=7.6674444
.meas tran ecg_7_33 FIND V(ecg_l0) AT=7.6674444
.meas tran raw_7_34 FIND V(rpeak_raw) AT=7.6684444
.meas tran pls_7_34 FIND V(rpeak_pulse) AT=7.6684444
.meas tran ecg_7_34 FIND V(ecg_l0) AT=7.6684444
.meas tran raw_7_35 FIND V(rpeak_raw) AT=7.6694444
.meas tran pls_7_35 FIND V(rpeak_pulse) AT=7.6694444
.meas tran ecg_7_35 FIND V(ecg_l0) AT=7.6694444
.meas tran raw_7_36 FIND V(rpeak_raw) AT=7.6704444
.meas tran pls_7_36 FIND V(rpeak_pulse) AT=7.6704444
.meas tran ecg_7_36 FIND V(ecg_l0) AT=7.6704444
.meas tran raw_7_37 FIND V(rpeak_raw) AT=7.6714444
.meas tran pls_7_37 FIND V(rpeak_pulse) AT=7.6714444
.meas tran ecg_7_37 FIND V(ecg_l0) AT=7.6714444
.meas tran raw_7_38 FIND V(rpeak_raw) AT=7.6724444
.meas tran pls_7_38 FIND V(rpeak_pulse) AT=7.6724444
.meas tran ecg_7_38 FIND V(ecg_l0) AT=7.6724444
.meas tran raw_7_39 FIND V(rpeak_raw) AT=7.6734444
.meas tran pls_7_39 FIND V(rpeak_pulse) AT=7.6734444
.meas tran ecg_7_39 FIND V(ecg_l0) AT=7.6734444
.meas tran raw_7_40 FIND V(rpeak_raw) AT=7.6744444
.meas tran pls_7_40 FIND V(rpeak_pulse) AT=7.6744444
.meas tran ecg_7_40 FIND V(ecg_l0) AT=7.6744444
.meas tran raw_8_00 FIND V(rpeak_raw) AT=8.4788889
.meas tran pls_8_00 FIND V(rpeak_pulse) AT=8.4788889
.meas tran ecg_8_00 FIND V(ecg_l0) AT=8.4788889
.meas tran raw_8_01 FIND V(rpeak_raw) AT=8.4798889
.meas tran pls_8_01 FIND V(rpeak_pulse) AT=8.4798889
.meas tran ecg_8_01 FIND V(ecg_l0) AT=8.4798889
.meas tran raw_8_02 FIND V(rpeak_raw) AT=8.4808889
.meas tran pls_8_02 FIND V(rpeak_pulse) AT=8.4808889
.meas tran ecg_8_02 FIND V(ecg_l0) AT=8.4808889
.meas tran raw_8_03 FIND V(rpeak_raw) AT=8.4818889
.meas tran pls_8_03 FIND V(rpeak_pulse) AT=8.4818889
.meas tran ecg_8_03 FIND V(ecg_l0) AT=8.4818889
.meas tran raw_8_04 FIND V(rpeak_raw) AT=8.4828889
.meas tran pls_8_04 FIND V(rpeak_pulse) AT=8.4828889
.meas tran ecg_8_04 FIND V(ecg_l0) AT=8.4828889
.meas tran raw_8_05 FIND V(rpeak_raw) AT=8.4838889
.meas tran pls_8_05 FIND V(rpeak_pulse) AT=8.4838889
.meas tran ecg_8_05 FIND V(ecg_l0) AT=8.4838889
.meas tran raw_8_06 FIND V(rpeak_raw) AT=8.4848889
.meas tran pls_8_06 FIND V(rpeak_pulse) AT=8.4848889
.meas tran ecg_8_06 FIND V(ecg_l0) AT=8.4848889
.meas tran raw_8_07 FIND V(rpeak_raw) AT=8.4858889
.meas tran pls_8_07 FIND V(rpeak_pulse) AT=8.4858889
.meas tran ecg_8_07 FIND V(ecg_l0) AT=8.4858889
.meas tran raw_8_08 FIND V(rpeak_raw) AT=8.4868889
.meas tran pls_8_08 FIND V(rpeak_pulse) AT=8.4868889
.meas tran ecg_8_08 FIND V(ecg_l0) AT=8.4868889
.meas tran raw_8_09 FIND V(rpeak_raw) AT=8.4878889
.meas tran pls_8_09 FIND V(rpeak_pulse) AT=8.4878889
.meas tran ecg_8_09 FIND V(ecg_l0) AT=8.4878889
.meas tran raw_8_10 FIND V(rpeak_raw) AT=8.4888889
.meas tran pls_8_10 FIND V(rpeak_pulse) AT=8.4888889
.meas tran ecg_8_10 FIND V(ecg_l0) AT=8.4888889
.meas tran raw_8_11 FIND V(rpeak_raw) AT=8.4898889
.meas tran pls_8_11 FIND V(rpeak_pulse) AT=8.4898889
.meas tran ecg_8_11 FIND V(ecg_l0) AT=8.4898889
.meas tran raw_8_12 FIND V(rpeak_raw) AT=8.4908889
.meas tran pls_8_12 FIND V(rpeak_pulse) AT=8.4908889
.meas tran ecg_8_12 FIND V(ecg_l0) AT=8.4908889
.meas tran raw_8_13 FIND V(rpeak_raw) AT=8.4918889
.meas tran pls_8_13 FIND V(rpeak_pulse) AT=8.4918889
.meas tran ecg_8_13 FIND V(ecg_l0) AT=8.4918889
.meas tran raw_8_14 FIND V(rpeak_raw) AT=8.4928889
.meas tran pls_8_14 FIND V(rpeak_pulse) AT=8.4928889
.meas tran ecg_8_14 FIND V(ecg_l0) AT=8.4928889
.meas tran raw_8_15 FIND V(rpeak_raw) AT=8.4938889
.meas tran pls_8_15 FIND V(rpeak_pulse) AT=8.4938889
.meas tran ecg_8_15 FIND V(ecg_l0) AT=8.4938889
.meas tran raw_8_16 FIND V(rpeak_raw) AT=8.4948889
.meas tran pls_8_16 FIND V(rpeak_pulse) AT=8.4948889
.meas tran ecg_8_16 FIND V(ecg_l0) AT=8.4948889
.meas tran raw_8_17 FIND V(rpeak_raw) AT=8.4958889
.meas tran pls_8_17 FIND V(rpeak_pulse) AT=8.4958889
.meas tran ecg_8_17 FIND V(ecg_l0) AT=8.4958889
.meas tran raw_8_18 FIND V(rpeak_raw) AT=8.4968889
.meas tran pls_8_18 FIND V(rpeak_pulse) AT=8.4968889
.meas tran ecg_8_18 FIND V(ecg_l0) AT=8.4968889
.meas tran raw_8_19 FIND V(rpeak_raw) AT=8.4978889
.meas tran pls_8_19 FIND V(rpeak_pulse) AT=8.4978889
.meas tran ecg_8_19 FIND V(ecg_l0) AT=8.4978889
.meas tran raw_8_20 FIND V(rpeak_raw) AT=8.4988889
.meas tran pls_8_20 FIND V(rpeak_pulse) AT=8.4988889
.meas tran ecg_8_20 FIND V(ecg_l0) AT=8.4988889
.meas tran raw_8_21 FIND V(rpeak_raw) AT=8.4998889
.meas tran pls_8_21 FIND V(rpeak_pulse) AT=8.4998889
.meas tran ecg_8_21 FIND V(ecg_l0) AT=8.4998889
.meas tran raw_8_22 FIND V(rpeak_raw) AT=8.5008889
.meas tran pls_8_22 FIND V(rpeak_pulse) AT=8.5008889
.meas tran ecg_8_22 FIND V(ecg_l0) AT=8.5008889
.meas tran raw_8_23 FIND V(rpeak_raw) AT=8.5018889
.meas tran pls_8_23 FIND V(rpeak_pulse) AT=8.5018889
.meas tran ecg_8_23 FIND V(ecg_l0) AT=8.5018889
.meas tran raw_8_24 FIND V(rpeak_raw) AT=8.5028889
.meas tran pls_8_24 FIND V(rpeak_pulse) AT=8.5028889
.meas tran ecg_8_24 FIND V(ecg_l0) AT=8.5028889
.meas tran raw_8_25 FIND V(rpeak_raw) AT=8.5038889
.meas tran pls_8_25 FIND V(rpeak_pulse) AT=8.5038889
.meas tran ecg_8_25 FIND V(ecg_l0) AT=8.5038889
.meas tran raw_8_26 FIND V(rpeak_raw) AT=8.5048889
.meas tran pls_8_26 FIND V(rpeak_pulse) AT=8.5048889
.meas tran ecg_8_26 FIND V(ecg_l0) AT=8.5048889
.meas tran raw_8_27 FIND V(rpeak_raw) AT=8.5058889
.meas tran pls_8_27 FIND V(rpeak_pulse) AT=8.5058889
.meas tran ecg_8_27 FIND V(ecg_l0) AT=8.5058889
.meas tran raw_8_28 FIND V(rpeak_raw) AT=8.5068889
.meas tran pls_8_28 FIND V(rpeak_pulse) AT=8.5068889
.meas tran ecg_8_28 FIND V(ecg_l0) AT=8.5068889
.meas tran raw_8_29 FIND V(rpeak_raw) AT=8.5078889
.meas tran pls_8_29 FIND V(rpeak_pulse) AT=8.5078889
.meas tran ecg_8_29 FIND V(ecg_l0) AT=8.5078889
.meas tran raw_8_30 FIND V(rpeak_raw) AT=8.5088889
.meas tran pls_8_30 FIND V(rpeak_pulse) AT=8.5088889
.meas tran ecg_8_30 FIND V(ecg_l0) AT=8.5088889
.meas tran raw_8_31 FIND V(rpeak_raw) AT=8.5098889
.meas tran pls_8_31 FIND V(rpeak_pulse) AT=8.5098889
.meas tran ecg_8_31 FIND V(ecg_l0) AT=8.5098889
.meas tran raw_8_32 FIND V(rpeak_raw) AT=8.5108889
.meas tran pls_8_32 FIND V(rpeak_pulse) AT=8.5108889
.meas tran ecg_8_32 FIND V(ecg_l0) AT=8.5108889
.meas tran raw_8_33 FIND V(rpeak_raw) AT=8.5118889
.meas tran pls_8_33 FIND V(rpeak_pulse) AT=8.5118889
.meas tran ecg_8_33 FIND V(ecg_l0) AT=8.5118889
.meas tran raw_8_34 FIND V(rpeak_raw) AT=8.5128889
.meas tran pls_8_34 FIND V(rpeak_pulse) AT=8.5128889
.meas tran ecg_8_34 FIND V(ecg_l0) AT=8.5128889
.meas tran raw_8_35 FIND V(rpeak_raw) AT=8.5138889
.meas tran pls_8_35 FIND V(rpeak_pulse) AT=8.5138889
.meas tran ecg_8_35 FIND V(ecg_l0) AT=8.5138889
.meas tran raw_8_36 FIND V(rpeak_raw) AT=8.5148889
.meas tran pls_8_36 FIND V(rpeak_pulse) AT=8.5148889
.meas tran ecg_8_36 FIND V(ecg_l0) AT=8.5148889
.meas tran raw_8_37 FIND V(rpeak_raw) AT=8.5158889
.meas tran pls_8_37 FIND V(rpeak_pulse) AT=8.5158889
.meas tran ecg_8_37 FIND V(ecg_l0) AT=8.5158889
.meas tran raw_8_38 FIND V(rpeak_raw) AT=8.5168889
.meas tran pls_8_38 FIND V(rpeak_pulse) AT=8.5168889
.meas tran ecg_8_38 FIND V(ecg_l0) AT=8.5168889
.meas tran raw_8_39 FIND V(rpeak_raw) AT=8.5178889
.meas tran pls_8_39 FIND V(rpeak_pulse) AT=8.5178889
.meas tran ecg_8_39 FIND V(ecg_l0) AT=8.5178889
.meas tran raw_8_40 FIND V(rpeak_raw) AT=8.5188889
.meas tran pls_8_40 FIND V(rpeak_pulse) AT=8.5188889
.meas tran ecg_8_40 FIND V(ecg_l0) AT=8.5188889
.meas tran raw_9_00 FIND V(rpeak_raw) AT=9.2900000
.meas tran pls_9_00 FIND V(rpeak_pulse) AT=9.2900000
.meas tran ecg_9_00 FIND V(ecg_l0) AT=9.2900000
.meas tran raw_9_01 FIND V(rpeak_raw) AT=9.2910000
.meas tran pls_9_01 FIND V(rpeak_pulse) AT=9.2910000
.meas tran ecg_9_01 FIND V(ecg_l0) AT=9.2910000
.meas tran raw_9_02 FIND V(rpeak_raw) AT=9.2920000
.meas tran pls_9_02 FIND V(rpeak_pulse) AT=9.2920000
.meas tran ecg_9_02 FIND V(ecg_l0) AT=9.2920000
.meas tran raw_9_03 FIND V(rpeak_raw) AT=9.2930000
.meas tran pls_9_03 FIND V(rpeak_pulse) AT=9.2930000
.meas tran ecg_9_03 FIND V(ecg_l0) AT=9.2930000
.meas tran raw_9_04 FIND V(rpeak_raw) AT=9.2940000
.meas tran pls_9_04 FIND V(rpeak_pulse) AT=9.2940000
.meas tran ecg_9_04 FIND V(ecg_l0) AT=9.2940000
.meas tran raw_9_05 FIND V(rpeak_raw) AT=9.2950000
.meas tran pls_9_05 FIND V(rpeak_pulse) AT=9.2950000
.meas tran ecg_9_05 FIND V(ecg_l0) AT=9.2950000
.meas tran raw_9_06 FIND V(rpeak_raw) AT=9.2960000
.meas tran pls_9_06 FIND V(rpeak_pulse) AT=9.2960000
.meas tran ecg_9_06 FIND V(ecg_l0) AT=9.2960000
.meas tran raw_9_07 FIND V(rpeak_raw) AT=9.2970000
.meas tran pls_9_07 FIND V(rpeak_pulse) AT=9.2970000
.meas tran ecg_9_07 FIND V(ecg_l0) AT=9.2970000
.meas tran raw_9_08 FIND V(rpeak_raw) AT=9.2980000
.meas tran pls_9_08 FIND V(rpeak_pulse) AT=9.2980000
.meas tran ecg_9_08 FIND V(ecg_l0) AT=9.2980000
.meas tran raw_9_09 FIND V(rpeak_raw) AT=9.2990000
.meas tran pls_9_09 FIND V(rpeak_pulse) AT=9.2990000
.meas tran ecg_9_09 FIND V(ecg_l0) AT=9.2990000
.meas tran raw_9_10 FIND V(rpeak_raw) AT=9.3000000
.meas tran pls_9_10 FIND V(rpeak_pulse) AT=9.3000000
.meas tran ecg_9_10 FIND V(ecg_l0) AT=9.3000000
.meas tran raw_9_11 FIND V(rpeak_raw) AT=9.3010000
.meas tran pls_9_11 FIND V(rpeak_pulse) AT=9.3010000
.meas tran ecg_9_11 FIND V(ecg_l0) AT=9.3010000
.meas tran raw_9_12 FIND V(rpeak_raw) AT=9.3020000
.meas tran pls_9_12 FIND V(rpeak_pulse) AT=9.3020000
.meas tran ecg_9_12 FIND V(ecg_l0) AT=9.3020000
.meas tran raw_9_13 FIND V(rpeak_raw) AT=9.3030000
.meas tran pls_9_13 FIND V(rpeak_pulse) AT=9.3030000
.meas tran ecg_9_13 FIND V(ecg_l0) AT=9.3030000
.meas tran raw_9_14 FIND V(rpeak_raw) AT=9.3040000
.meas tran pls_9_14 FIND V(rpeak_pulse) AT=9.3040000
.meas tran ecg_9_14 FIND V(ecg_l0) AT=9.3040000
.meas tran raw_9_15 FIND V(rpeak_raw) AT=9.3050000
.meas tran pls_9_15 FIND V(rpeak_pulse) AT=9.3050000
.meas tran ecg_9_15 FIND V(ecg_l0) AT=9.3050000
.meas tran raw_9_16 FIND V(rpeak_raw) AT=9.3060000
.meas tran pls_9_16 FIND V(rpeak_pulse) AT=9.3060000
.meas tran ecg_9_16 FIND V(ecg_l0) AT=9.3060000
.meas tran raw_9_17 FIND V(rpeak_raw) AT=9.3070000
.meas tran pls_9_17 FIND V(rpeak_pulse) AT=9.3070000
.meas tran ecg_9_17 FIND V(ecg_l0) AT=9.3070000
.meas tran raw_9_18 FIND V(rpeak_raw) AT=9.3080000
.meas tran pls_9_18 FIND V(rpeak_pulse) AT=9.3080000
.meas tran ecg_9_18 FIND V(ecg_l0) AT=9.3080000
.meas tran raw_9_19 FIND V(rpeak_raw) AT=9.3090000
.meas tran pls_9_19 FIND V(rpeak_pulse) AT=9.3090000
.meas tran ecg_9_19 FIND V(ecg_l0) AT=9.3090000
.meas tran raw_9_20 FIND V(rpeak_raw) AT=9.3100000
.meas tran pls_9_20 FIND V(rpeak_pulse) AT=9.3100000
.meas tran ecg_9_20 FIND V(ecg_l0) AT=9.3100000
.meas tran raw_9_21 FIND V(rpeak_raw) AT=9.3110000
.meas tran pls_9_21 FIND V(rpeak_pulse) AT=9.3110000
.meas tran ecg_9_21 FIND V(ecg_l0) AT=9.3110000
.meas tran raw_9_22 FIND V(rpeak_raw) AT=9.3120000
.meas tran pls_9_22 FIND V(rpeak_pulse) AT=9.3120000
.meas tran ecg_9_22 FIND V(ecg_l0) AT=9.3120000
.meas tran raw_9_23 FIND V(rpeak_raw) AT=9.3130000
.meas tran pls_9_23 FIND V(rpeak_pulse) AT=9.3130000
.meas tran ecg_9_23 FIND V(ecg_l0) AT=9.3130000
.meas tran raw_9_24 FIND V(rpeak_raw) AT=9.3140000
.meas tran pls_9_24 FIND V(rpeak_pulse) AT=9.3140000
.meas tran ecg_9_24 FIND V(ecg_l0) AT=9.3140000
.meas tran raw_9_25 FIND V(rpeak_raw) AT=9.3150000
.meas tran pls_9_25 FIND V(rpeak_pulse) AT=9.3150000
.meas tran ecg_9_25 FIND V(ecg_l0) AT=9.3150000
.meas tran raw_9_26 FIND V(rpeak_raw) AT=9.3160000
.meas tran pls_9_26 FIND V(rpeak_pulse) AT=9.3160000
.meas tran ecg_9_26 FIND V(ecg_l0) AT=9.3160000
.meas tran raw_9_27 FIND V(rpeak_raw) AT=9.3170000
.meas tran pls_9_27 FIND V(rpeak_pulse) AT=9.3170000
.meas tran ecg_9_27 FIND V(ecg_l0) AT=9.3170000
.meas tran raw_9_28 FIND V(rpeak_raw) AT=9.3180000
.meas tran pls_9_28 FIND V(rpeak_pulse) AT=9.3180000
.meas tran ecg_9_28 FIND V(ecg_l0) AT=9.3180000
.meas tran raw_9_29 FIND V(rpeak_raw) AT=9.3190000
.meas tran pls_9_29 FIND V(rpeak_pulse) AT=9.3190000
.meas tran ecg_9_29 FIND V(ecg_l0) AT=9.3190000
.meas tran raw_9_30 FIND V(rpeak_raw) AT=9.3200000
.meas tran pls_9_30 FIND V(rpeak_pulse) AT=9.3200000
.meas tran ecg_9_30 FIND V(ecg_l0) AT=9.3200000
.meas tran raw_9_31 FIND V(rpeak_raw) AT=9.3210000
.meas tran pls_9_31 FIND V(rpeak_pulse) AT=9.3210000
.meas tran ecg_9_31 FIND V(ecg_l0) AT=9.3210000
.meas tran raw_9_32 FIND V(rpeak_raw) AT=9.3220000
.meas tran pls_9_32 FIND V(rpeak_pulse) AT=9.3220000
.meas tran ecg_9_32 FIND V(ecg_l0) AT=9.3220000
.meas tran raw_9_33 FIND V(rpeak_raw) AT=9.3230000
.meas tran pls_9_33 FIND V(rpeak_pulse) AT=9.3230000
.meas tran ecg_9_33 FIND V(ecg_l0) AT=9.3230000
.meas tran raw_9_34 FIND V(rpeak_raw) AT=9.3240000
.meas tran pls_9_34 FIND V(rpeak_pulse) AT=9.3240000
.meas tran ecg_9_34 FIND V(ecg_l0) AT=9.3240000
.meas tran raw_9_35 FIND V(rpeak_raw) AT=9.3250000
.meas tran pls_9_35 FIND V(rpeak_pulse) AT=9.3250000
.meas tran ecg_9_35 FIND V(ecg_l0) AT=9.3250000
.meas tran raw_9_36 FIND V(rpeak_raw) AT=9.3260000
.meas tran pls_9_36 FIND V(rpeak_pulse) AT=9.3260000
.meas tran ecg_9_36 FIND V(ecg_l0) AT=9.3260000
.meas tran raw_9_37 FIND V(rpeak_raw) AT=9.3270000
.meas tran pls_9_37 FIND V(rpeak_pulse) AT=9.3270000
.meas tran ecg_9_37 FIND V(ecg_l0) AT=9.3270000
.meas tran raw_9_38 FIND V(rpeak_raw) AT=9.3280000
.meas tran pls_9_38 FIND V(rpeak_pulse) AT=9.3280000
.meas tran ecg_9_38 FIND V(ecg_l0) AT=9.3280000
.meas tran raw_9_39 FIND V(rpeak_raw) AT=9.3290000
.meas tran pls_9_39 FIND V(rpeak_pulse) AT=9.3290000
.meas tran ecg_9_39 FIND V(ecg_l0) AT=9.3290000
.meas tran raw_9_40 FIND V(rpeak_raw) AT=9.3300000
.meas tran pls_9_40 FIND V(rpeak_pulse) AT=9.3300000
.meas tran ecg_9_40 FIND V(ecg_l0) AT=9.3300000

.end
