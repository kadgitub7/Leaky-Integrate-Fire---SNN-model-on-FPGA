Full self-contained frontend integration test
.lib "C:\Users\kadhi\OneDrive\Desktop\amux\verilogLearning\Leaky-Integrate-Fire---SNN-model-on-FPGA\experiments\frontend_optimization\ngspice_frontend\sky130_minimal.lib.spice" tt
.option scale=1.0u method=gear gmin=1e-15
.temp 27

.include "inverter.spice"
.include "rpeak_detector.spice"
.include "bias_gen.spice"
.include "delay_timer.spice"
.include "rr_timing.spice"
.include "pwave_predictor.spice"
.include "beat_instability.spice"
.include "pwave_diff.spice"
.include "qrs_width.spice"
.include "qrs_slope.spice"
.include "qrs_symmetry.spice"

Vdd vdd 0 0.9
Vss vss 0 0

* === SELF-CONTAINED BIAS ===
Xbias vbias vref vdd vss bias_gen
.ic v(xbias.iref) = 0.3

* === ECG INPUTS (IA bypassed — validated separately, needs 100s settle) ===
Vecg_l0 ecg_amp_l0 0 PWL(
+ 0.0000000 0.166778
+ 0.0002778 0.081973
+ 0.0005556 0.050000
+ 0.0008333 0.050000
+ 0.0011111 0.050000
+ 0.0013889 0.050000
+ 0.0016667 0.050000
+ 0.0019444 0.050000
+ 0.0022222 0.050000
+ 0.0025000 0.050000
+ 0.0027778 0.055208
+ 0.0030556 0.101629
+ 0.0033333 0.151442
+ 0.0036111 0.202877
+ 0.0038889 0.254166
+ 0.0041667 0.303538
+ 0.0044444 0.349226
+ 0.0047222 0.389459
+ 0.0050000 0.422468
+ 0.0052778 0.446484
+ 0.0055556 0.459738
+ 0.0058333 0.461017
+ 0.0061111 0.451328
+ 0.0063889 0.432238
+ 0.0066667 0.405310
+ 0.0069444 0.372109
+ 0.0072222 0.334201
+ 0.0075000 0.293148
+ 0.0077778 0.250517
+ 0.0080556 0.207872
+ 0.0083333 0.166778
+ 0.0086111 0.128663
+ 0.0088889 0.094416
+ 0.0091667 0.064790
+ 0.0094444 0.050000
+ 0.0097222 0.050000
+ 0.0100000 0.050000
+ 0.0102778 0.050000
+ 0.0105556 0.050000
+ 0.0108333 0.050000
+ 0.0111111 0.050000
+ 0.0113889 0.083895
+ 0.0116667 0.125957
+ 0.0119444 0.173715
+ 0.0122222 0.224695
+ 0.0125000 0.276423
+ 0.0127778 0.326426
+ 0.0130556 0.372231
+ 0.0133333 0.411365
+ 0.0136111 0.441354
+ 0.0138889 0.459725
+ 0.0141667 0.464712
+ 0.0144444 0.457373
+ 0.0147222 0.439474
+ 0.0150000 0.412779
+ 0.0152778 0.379055
+ 0.0155556 0.340067
+ 0.0158333 0.297579
+ 0.0161111 0.253358
+ 0.0163889 0.209170
+ 0.0166667 0.166778
+ 0.0169444 0.127769
+ 0.0172222 0.093007
+ 0.0175000 0.063177
+ 0.0177778 0.050000
+ 0.0180556 0.050000
+ 0.0183333 0.050000
+ 0.0186111 0.050000
+ 0.0188889 0.050000
+ 0.0191667 0.050000
+ 0.0194444 0.050000
+ 0.0197222 0.083768
+ 0.0200000 0.125543
+ 0.0202778 0.172924
+ 0.0205556 0.223505
+ 0.0208333 0.274885
+ 0.0211111 0.324660
+ 0.0213889 0.370427
+ 0.0216667 0.409782
+ 0.0219444 0.440323
+ 0.0222222 0.459647
+ 0.0225000 0.466026
+ 0.0227778 0.460439
+ 0.0230556 0.444541
+ 0.0233333 0.419985
+ 0.0236111 0.388427
+ 0.0238889 0.351522
+ 0.0241667 0.310923
+ 0.0244444 0.268286
+ 0.0247222 0.225265
+ 0.0250000 0.183514
+ 0.0252778 0.144544
+ 0.0255556 0.109286
+ 0.0258333 0.078527
+ 0.0261111 0.053053
+ 0.0263889 0.050000
+ 0.0266667 0.050000
+ 0.0269444 0.050000
+ 0.0272222 0.050000
+ 0.0275000 0.050000
+ 0.0277778 0.055273
+ 0.0280556 0.088284
+ 0.0283333 0.129595
+ 0.0286111 0.176715
+ 0.0288889 0.227149
+ 0.0291667 0.278406
+ 0.0294444 0.327992
+ 0.0297222 0.373415
+ 0.0300000 0.412182
+ 0.0302778 0.441801
+ 0.0305556 0.459778
+ 0.0308333 0.464333
+ 0.0311111 0.456537
+ 0.0313889 0.438171
+ 0.0316667 0.411020
+ 0.0319444 0.376865
+ 0.0322222 0.337489
+ 0.0325000 0.294675
+ 0.0327778 0.250205
+ 0.0330556 0.205863
+ 0.0333333 0.163431
+ 0.0336111 0.124504
+ 0.0338889 0.089936
+ 0.0341667 0.060388
+ 0.0344444 0.050000
+ 0.0347222 0.050000
+ 0.0350000 0.050000
+ 0.0352778 0.050000
+ 0.0355556 0.050000
+ 0.0358333 0.050000
+ 0.0361111 0.050000
+ 0.0363889 0.084044
+ 0.0366667 0.126027
+ 0.0369444 0.173550
+ 0.0372222 0.224212
+ 0.0375000 0.275615
+ 0.0377778 0.325360
+ 0.0380556 0.371045
+ 0.0383333 0.410272
+ 0.0386111 0.440640
+ 0.0388889 0.459752
+ 0.0391667 0.465882
+ 0.0394444 0.460014
+ 0.0397222 0.443806
+ 0.0400000 0.418916
+ 0.0402778 0.387005
+ 0.0405556 0.349730
+ 0.0408333 0.308750
+ 0.0411111 0.265723
+ 0.0413889 0.222309
+ 0.0416667 0.180167
+ 0.0419444 0.140810
+ 0.0422222 0.105181
+ 0.0425000 0.074077
+ 0.0427778 0.050000
+ 0.0430556 0.050000
+ 0.0433333 0.050000
+ 0.0436111 0.050000
+ 0.0438889 0.050000
+ 0.0441667 0.050000
+ 0.0444444 0.050000
+ 0.0447222 0.083243
+ 0.0450000 0.124883
+ 0.0452778 0.172416
+ 0.0455556 0.223336
+ 0.0458333 0.275139
+ 0.0461111 0.325319
+ 0.0463889 0.371371
+ 0.0466667 0.410791
+ 0.0469444 0.441073
+ 0.0472222 0.459712
+ 0.0475000 0.464916
+ 0.0477778 0.457739
+ 0.0480556 0.439950
+ 0.0483333 0.413317
+ 0.0486111 0.379607
+ 0.0488889 0.340587
+ 0.0491667 0.298027
+ 0.0494444 0.253694
+ 0.0497222 0.209355
+ 0.0500000 0.166778
+ 0.0502778 0.127554
+ 0.0505556 0.092567
+ 0.0508333 0.062524
+ 0.0511111 0.050000
+ 0.0513889 0.050000
+ 0.0516667 0.050000
+ 0.0519444 0.050000
+ 0.0522222 0.050000
+ 0.0525000 0.050000
+ 0.0527778 0.050000
+ 0.0530556 0.084412
+ 0.0533333 0.126929
+ 0.0536111 0.175058
+ 0.0538889 0.226306
+ 0.0541667 0.278180
+ 0.0544444 0.328189
+ 0.0547222 0.373839
+ 0.0550000 0.412638
+ 0.0552778 0.442093
+ 0.0555556 0.459712
+ 0.0558333 0.463723
+ 0.0561111 0.455233
+ 0.0563889 0.436071
+ 0.0566667 0.408066
+ 0.0569444 0.373047
+ 0.0572222 0.332842
+ 0.0575000 0.289280
+ 0.0577778 0.244189
+ 0.0580556 0.199398
+ 0.0583333 0.156736
+ 0.0586111 0.117832
+ 0.0588889 0.083516
+ 0.0591667 0.054422
+ 0.0594444 0.050000
+ 0.0597222 0.050000
+ 0.0600000 0.050000
+ 0.0602778 0.050000
+ 0.0605556 0.050000
+ 0.0608333 0.050000
+ 0.0611111 0.050000
+ 0.0613889 0.084901
+ 0.0616667 0.127642
+ 0.0619444 0.175789
+ 0.0622222 0.226908
+ 0.0625000 0.278564
+ 0.0627778 0.328324
+ 0.0630556 0.373753
+ 0.0633333 0.412416
+ 0.0636111 0.441881
+ 0.0638889 0.459712
+ 0.0641667 0.464177
+ 0.0644444 0.456344
+ 0.0647222 0.437985
+ 0.0650000 0.410869
+ 0.0652778 0.376767
+ 0.0655556 0.337449
+ 0.0658333 0.294687
+ 0.0661111 0.250249
+ 0.0663889 0.205907
+ 0.0666667 0.163431
+ 0.0669444 0.124410
+ 0.0672222 0.089711
+ 0.0675000 0.060020
+ 0.0677778 0.050000
+ 0.0680556 0.050000
+ 0.0683333 0.050000
+ 0.0686111 0.050000
+ 0.0688889 0.050000
+ 0.0691667 0.050000
+ 0.0694444 0.050000
+ 0.0697222 0.084530
+ 0.0700000 0.127083
+ 0.0702778 0.175185
+ 0.0705556 0.226366
+ 0.0708333 0.278153
+ 0.0711111 0.328076
+ 0.0713889 0.373663
+ 0.0716667 0.412441
+ 0.0719444 0.441939
+ 0.0722222 0.459686
+ 0.0725000 0.463923
+ 0.0727778 0.455743
+ 0.0730556 0.436954
+ 0.0733333 0.409360
+ 0.0736111 0.374769
+ 0.0738889 0.334988
+ 0.0741667 0.291822
+ 0.0744444 0.247078
+ 0.0747222 0.202563
+ 0.0750000 0.160083
+ 0.0752778 0.121252
+ 0.0755556 0.086912
+ 0.0758333 0.057713
+ 0.0761111 0.050000
+ 0.0763889 0.050000
+ 0.0766667 0.050000
+ 0.0769444 0.050000
+ 0.0772222 0.050000
+ 0.0775000 0.050000
+ 0.0777778 0.051835
+ 0.0780556 0.086632
+ 0.0783333 0.129312
+ 0.0786111 0.177416
+ 0.0788889 0.228490
+ 0.0791667 0.280076
+ 0.0794444 0.329719
+ 0.0797222 0.374962
+ 0.0800000 0.413348
+ 0.0802778 0.442421
+ 0.0805556 0.459725
+ 0.0808333 0.463516
+ 0.0811111 0.454894
+ 0.0813889 0.435675
+ 0.0816667 0.407671
+ 0.0819444 0.372696
+ 0.0822222 0.332563
+ 0.0825000 0.289088
+ 0.0827778 0.244082
+ 0.0830556 0.199360
+ 0.0833333 0.156736
+ 0.0836111 0.117828
+ 0.0838889 0.083476
+ 0.0841667 0.054324
+ 0.0844444 0.050000
+ 0.0847222 0.050000
+ 0.0850000 0.050000
+ 0.0852778 0.050000
+ 0.0855556 0.050000
+ 0.0858333 0.050000
+ 0.0861111 0.050000
+ 0.0863889 0.085132
+ 0.0866667 0.128149
+ 0.0869444 0.176583
+ 0.0872222 0.227961
+ 0.0875000 0.279815
+ 0.0877778 0.329674
+ 0.0880556 0.375067
+ 0.0883333 0.413524
+ 0.0886111 0.442576
+ 0.0888889 0.459752
+ 0.0891667 0.463303
+ 0.0894444 0.454368
+ 0.0897222 0.434809
+ 0.0900000 0.406487
+ 0.0902778 0.371262
+ 0.0905556 0.330996
+ 0.0908333 0.287549
+ 0.0911111 0.242783
+ 0.0913889 0.198558
+ 0.0916667 0.156736
+ 0.0919444 0.118959
+ 0.0922222 0.085998
+ 0.0925000 0.058404
+ 0.0927778 0.050000
+ 0.0930556 0.050000
+ 0.0933333 0.050000
+ 0.0936111 0.050000
+ 0.0938889 0.050000
+ 0.0941667 0.050000
+ 0.0944444 0.061876
+ 0.0947222 0.096599
+ 0.0950000 0.138743
+ 0.0952778 0.185946
+ 0.0955556 0.235849
+ 0.0958333 0.286091
+ 0.0961111 0.334310
+ 0.0963889 0.378147
+ 0.0966667 0.415240
+ 0.0969444 0.443228
+ 0.0972222 0.459752
+ 0.0975000 0.463134
+ 0.0977778 0.454440
+ 0.0980556 0.435419
+ 0.0983333 0.407821
+ 0.0986111 0.373395
+ 0.0988889 0.333891
+ 0.0991667 0.291058
+ 0.0994444 0.246646
+ 0.0997222 0.202405
+ 0.1000000 0.160083
+ 0.1002778 0.121254
+ 0.1005556 0.086779
+ 0.1008333 0.057345
+ 0.1011111 0.050000
+ 0.1013889 0.050000
+ 0.1016667 0.050000
+ 0.1019444 0.050000
+ 0.1022222 0.050000
+ 0.1025000 0.050000
+ 0.1027778 0.050000
+ 0.1030556 0.085028
+ 0.1033333 0.128069
+ 0.1036111 0.176615
+ 0.1038889 0.228155
+ 0.1041667 0.280180
+ 0.1044444 0.330181
+ 0.1047222 0.375648
+ 0.1050000 0.414072
+ 0.1052778 0.442943
+ 0.1055556 0.459752
+ 0.1058333 0.462723
+ 0.1061111 0.453019
+ 0.1063889 0.432537
+ 0.1066667 0.403173
+ 0.1069444 0.366824
+ 0.1072222 0.325388
+ 0.1075000 0.280760
+ 0.1077778 0.234837
+ 0.1080556 0.189516
+ 0.1083333 0.146694
+ 0.1086111 0.108045
+ 0.1088889 0.074349
+ 0.1091667 0.050000
+ 0.1094444 0.050000
+ 0.1097222 0.050000
+ 0.1100000 0.050000
+ 0.1102778 0.050000
+ 0.1105556 0.050000
+ 0.1108333 0.050000
+ 0.1111111 0.050000
+ 0.1113889 0.085482
+ 0.1116667 0.128548
+ 0.1119444 0.176813
+ 0.1122222 0.227889
+ 0.1125000 0.279389
+ 0.1127778 0.328927
+ 0.1130556 0.374117
+ 0.1133333 0.412571
+ 0.1136111 0.441902
+ 0.1138889 0.459725
+ 0.1141667 0.464340
+ 0.1144444 0.456793
+ 0.1147222 0.438821
+ 0.1150000 0.412156
+ 0.1152778 0.378534
+ 0.1155556 0.339690
+ 0.1158333 0.297358
+ 0.1161111 0.253272
+ 0.1163889 0.209167
+ 0.1166667 0.166778
+ 0.1169444 0.127670
+ 0.1172222 0.092734
+ 0.1175000 0.062691
+ 0.1177778 0.050000
+ 0.1180556 0.050000
+ 0.1183333 0.050000
+ 0.1186111 0.050000
+ 0.1188889 0.050000
+ 0.1191667 0.050000
+ 0.1194444 0.050000
+ 0.1197222 0.084535
+ 0.1200000 0.127215
+ 0.1202778 0.175524
+ 0.1205556 0.226941
+ 0.1208333 0.278948
+ 0.1211111 0.329027
+ 0.1213889 0.374659
+ 0.1216667 0.413326
+ 0.1219444 0.442507
+ 0.1222222 0.459686
+ 0.1225000 0.463076
+ 0.1227778 0.453823
+ 0.1230556 0.433804
+ 0.1233333 0.404900
+ 0.1236111 0.368986
+ 0.1238889 0.327944
+ 0.1241667 0.283649
+ 0.1244444 0.237982
+ 0.1247222 0.192820
+ 0.1250000 0.150042
+ 0.1252778 0.111311
+ 0.1255556 0.077431
+ 0.1258333 0.050000
+ 0.1261111 0.050000
+ 0.1263889 0.050000
+ 0.1266667 0.050000
+ 0.1269444 0.050000
+ 0.1272222 0.050000
+ 0.1275000 0.050000
+ 0.1277778 0.051795
+ 0.1280556 0.087599
+ 0.1283333 0.131092
+ 0.1286111 0.179807
+ 0.1288889 0.231276
+ 0.1291667 0.283031
+ 0.1294444 0.332604
+ 0.1297222 0.377528
+ 0.1300000 0.415335
+ 0.1302778 0.443556
+ 0.1305556 0.459725
+ 0.1308333 0.462102
+ 0.1311111 0.451856
+ 0.1313889 0.430887
+ 0.1316667 0.401094
+ 0.1319444 0.364375
+ 0.1322222 0.322629
+ 0.1325000 0.277754
+ 0.1327778 0.231650
+ 0.1330556 0.186215
+ 0.1333333 0.143347
+ 0.1336111 0.104722
+ 0.1338889 0.071121
+ 0.1341667 0.050000
+ 0.1344444 0.050000
+ 0.1347222 0.050000
+ 0.1350000 0.050000
+ 0.1352778 0.050000
+ 0.1355556 0.050000
+ 0.1358333 0.050000
+ 0.1361111 0.050000
+ 0.1363889 0.086177
+ 0.1366667 0.129943
+ 0.1369444 0.178854
+ 0.1372222 0.230461
+ 0.1375000 0.282317
+ 0.1377778 0.331977
+ 0.1380556 0.376993
+ 0.1383333 0.414919
+ 0.1386111 0.443308
+ 0.1388889 0.459712
+ 0.1391667 0.462406
+ 0.1394444 0.452545
+ 0.1397222 0.432003
+ 0.1400000 0.402657
+ 0.1402778 0.366381
+ 0.1405556 0.325051
+ 0.1408333 0.280542
+ 0.1411111 0.234729
+ 0.1413889 0.189488
+ 0.1416667 0.146694
+ 0.1419444 0.108007
+ 0.1422222 0.074222
+ 0.1425000 0.050000
+ 0.1427778 0.050000
+ 0.1430556 0.050000
+ 0.1433333 0.050000
+ 0.1436111 0.050000
+ 0.1438889 0.050000
+ 0.1441667 0.050000
+ 0.1444444 0.050000
+ 0.1447222 0.085922
+ 0.1450000 0.129510
+ 0.1452778 0.178311
+ 0.1455556 0.229870
+ 0.1458333 0.281734
+ 0.1461111 0.331448
+ 0.1463889 0.376558
+ 0.1466667 0.414611
+ 0.1469444 0.443151
+ 0.1472222 0.459725
+ 0.1475000 0.462602
+ 0.1477778 0.452940
+ 0.1480556 0.432621
+ 0.1483333 0.403527
+ 0.1486111 0.367538
+ 0.1488889 0.326537
+ 0.1491667 0.282406
+ 0.1494444 0.237025
+ 0.1497222 0.192276
+ 0.1500000 0.150042
+ 0.1502778 0.111981
+ 0.1505556 0.078869
+ 0.1508333 0.051258
+ 0.1511111 0.050000
+ 0.1513889 0.050000
+ 0.1516667 0.050000
+ 0.1519444 0.050000
+ 0.1522222 0.050000
+ 0.1525000 0.050000
+ 0.1527778 0.058477
+ 0.1530556 0.094286
+ 0.1533333 0.137576
+ 0.1536111 0.185901
+ 0.1538889 0.236816
+ 0.1541667 0.287876
+ 0.1544444 0.336635
+ 0.1547222 0.380649
+ 0.1550000 0.417472
+ 0.1552778 0.444659
+ 0.1555556 0.459765
+ 0.1558333 0.461072
+ 0.1561111 0.449778
+ 0.1563889 0.427805
+ 0.1566667 0.397079
+ 0.1569444 0.359523
+ 0.1572222 0.317063
+ 0.1575000 0.271621
+ 0.1577778 0.225123
+ 0.1580556 0.179492
+ 0.1583333 0.136653
+ 0.1586111 0.098295
+ 0.1588889 0.065166
+ 0.1591667 0.050000
+ 0.1594444 0.050000
+ 0.1597222 0.050000
+ 0.1600000 0.050000
+ 0.1602778 0.050000
+ 0.1605556 0.050000
+ 0.1608333 0.050000
+ 0.1611111 0.050000
+ 0.1613889 0.086549
+ 0.1616667 0.130529
+ 0.1619444 0.179523
+ 0.1622222 0.231111
+ 0.1625000 0.282876
+ 0.1627778 0.332400
+ 0.1630556 0.377263
+ 0.1633333 0.415049
+ 0.1636111 0.443338
+ 0.1638889 0.459712
+ 0.1641667 0.462468
+ 0.1644444 0.452755
+ 0.1647222 0.432440
+ 0.1650000 0.403388
+ 0.1652778 0.367464
+ 0.1655556 0.326532
+ 0.1658333 0.282459
+ 0.1661111 0.237110
+ 0.1663889 0.192349
+ 0.1666667 0.150042
+ 0.1669444 0.111836
+ 0.1672222 0.078513
+ 0.1675000 0.050632
+ 0.1677778 0.050000
+ 0.1680556 0.050000
+ 0.1683333 0.050000
+ 0.1686111 0.050000
+ 0.1688889 0.050000
+ 0.1691667 0.050000
+ 0.1694444 0.055116
+ 0.1697222 0.090530
+ 0.1700000 0.133480
+ 0.1702778 0.181560
+ 0.1705556 0.232366
+ 0.1708333 0.283491
+ 0.1711111 0.332531
+ 0.1713889 0.377080
+ 0.1716667 0.414732
+ 0.1719444 0.443082
+ 0.1722222 0.459725
+ 0.1725000 0.462960
+ 0.1727778 0.453898
+ 0.1730556 0.434356
+ 0.1733333 0.406152
+ 0.1736111 0.371101
+ 0.1738889 0.331021
+ 0.1741667 0.287728
+ 0.1744444 0.243038
+ 0.1747222 0.198769
+ 0.1750000 0.156736
+ 0.1752778 0.118556
+ 0.1755556 0.085043
+ 0.1758333 0.056809
+ 0.1761111 0.050000
+ 0.1763889 0.050000
+ 0.1766667 0.050000
+ 0.1769444 0.050000
+ 0.1772222 0.050000
+ 0.1775000 0.050000
+ 0.1777778 0.058490
+ 0.1780556 0.094041
+ 0.1783333 0.137277
+ 0.1786111 0.185696
+ 0.1788889 0.236799
+ 0.1791667 0.288086
+ 0.1794444 0.337058
+ 0.1797222 0.381214
+ 0.1800000 0.418055
+ 0.1802778 0.445080
+ 0.1805556 0.459791
+ 0.1808333 0.460443
+ 0.1811111 0.448323
+ 0.1813889 0.425473
+ 0.1816667 0.393935
+ 0.1819444 0.355753
+ 0.1822222 0.312968
+ 0.1825000 0.267623
+ 0.1827778 0.221760
+ 0.1830556 0.177423
+ 0.1833333 0.136653
+ 0.1836111 0.101200
+ 0.1838889 0.071644
+ 0.1841667 0.050000
+ 0.1844444 0.050000
+ 0.1847222 0.050000
+ 0.1850000 0.050000
+ 0.1852778 0.050000
+ 0.1855556 0.050000
+ 0.1858333 0.053914
+ 0.1861111 0.081842
+ 0.1863889 0.117830
+ 0.1866667 0.160091
+ 0.1869444 0.206424
+ 0.1872222 0.254628
+ 0.1875000 0.302501
+ 0.1877778 0.347843
+ 0.1880556 0.388452
+ 0.1883333 0.422127
+ 0.1886111 0.446666
+ 0.1888889 0.459869
+ 0.1891667 0.460207
+ 0.1894444 0.448841
+ 0.1897222 0.427607
+ 0.1900000 0.398338
+ 0.1902778 0.362869
+ 0.1905556 0.323035
+ 0.1908333 0.280670
+ 0.1911111 0.237609
+ 0.1913889 0.195686
+ 0.1916667 0.156736
+ 0.1919444 0.122351
+ 0.1922222 0.093153
+ 0.1925000 0.069524
+ 0.1927778 0.051843
+ 0.1930556 0.050000
+ 0.1933333 0.050000
+ 0.1936111 0.050000
+ 0.1938889 0.050000
+ 0.1941667 0.065977
+ 0.1944444 0.091975
+ 0.1947222 0.126156
+ 0.1950000 0.166757
+ 0.1952778 0.211589
+ 0.1955556 0.258461
+ 0.1958333 0.305182
+ 0.1961111 0.349563
+ 0.1963889 0.389412
+ 0.1966667 0.422540
+ 0.1969444 0.446756
+ 0.1972222 0.459869
+ 0.1975000 0.460358
+ 0.1977778 0.449373
+ 0.1980556 0.428735
+ 0.1983333 0.400261
+ 0.1986111 0.365773
+ 0.1988889 0.327088
+ 0.1991667 0.286027
+ 0.1994444 0.244409
+ 0.1997222 0.204052
+ 0.2000000 0.166778
+ 0.2002778 0.134153
+ 0.2005556 0.106738
+ 0.2008333 0.084843
+ 0.2011111 0.068777
+ 0.2013889 0.058850
+ 0.2016667 0.055371
+ 0.2019444 0.058649
+ 0.2022222 0.068994
+ 0.2025000 0.086716
+ 0.2027778 0.112124
+ 0.2030556 0.145130
+ 0.2033333 0.184058
+ 0.2036111 0.226837
+ 0.2038889 0.271393
+ 0.2041667 0.315655
+ 0.2044444 0.357549
+ 0.2047222 0.395003
+ 0.2050000 0.425945
+ 0.2052778 0.448301
+ 0.2055556 0.460000
+ 0.2058333 0.459604
+ 0.2061111 0.448217
+ 0.2063889 0.427578
+ 0.2066667 0.399426
+ 0.2069444 0.365500
+ 0.2072222 0.327539
+ 0.2075000 0.287282
+ 0.2077778 0.246468
+ 0.2080556 0.206836
+ 0.2083333 0.170125
+ 0.2086111 0.137840
+ 0.2088889 0.110550
+ 0.2091667 0.088587
+ 0.2094444 0.072287
+ 0.2097222 0.061984
+ 0.2100000 0.058012
+ 0.2102778 0.060704
+ 0.2105556 0.070395
+ 0.2108333 0.087419
+ 0.2111111 0.112111
+ 0.2113889 0.144409
+ 0.2116667 0.182678
+ 0.2119444 0.224885
+ 0.2122222 0.269000
+ 0.2125000 0.312991
+ 0.2127778 0.354827
+ 0.2130556 0.392478
+ 0.2133333 0.423911
+ 0.2136111 0.447095
+ 0.2138889 0.460000
+ 0.2141667 0.461200
+ 0.2144444 0.451699
+ 0.2147222 0.433105
+ 0.2150000 0.407027
+ 0.2152778 0.375075
+ 0.2155556 0.338857
+ 0.2158333 0.299983
+ 0.2161111 0.260062
+ 0.2163889 0.220702
+ 0.2166667 0.183514
+ 0.2169444 0.149923
+ 0.2172222 0.120623
+ 0.2175000 0.096126
+ 0.2177778 0.076944
+ 0.2180556 0.063587
+ 0.2183333 0.056566
+ 0.2186111 0.056395
+ 0.2188889 0.063582
+ 0.2191667 0.078641
+ 0.2194444 0.102082
+ 0.2197222 0.133967
+ 0.2200000 0.172556
+ 0.2202778 0.215660
+ 0.2205556 0.261090
+ 0.2208333 0.306657
+ 0.2211111 0.350170
+ 0.2213889 0.389441
+ 0.2216667 0.422281
+ 0.2219444 0.446500
+ 0.2222222 0.459908
+ 0.2225000 0.460977
+ 0.2227778 0.450810
+ 0.2230556 0.431174
+ 0.2233333 0.403833
+ 0.2236111 0.370552
+ 0.2238889 0.333096
+ 0.2241667 0.293230
+ 0.2244444 0.252718
+ 0.2247222 0.213327
+ 0.2250000 0.176819
+ 0.2252778 0.144722
+ 0.2255556 0.117600
+ 0.2258333 0.095779
+ 0.2261111 0.079585
+ 0.2263889 0.069344
+ 0.2266667 0.065382
+ 0.2269444 0.068026
+ 0.2272222 0.077600
+ 0.2275000 0.094431
+ 0.2277778 0.118844
+ 0.2280556 0.150775
+ 0.2283333 0.188589
+ 0.2286111 0.230263
+ 0.2288889 0.273771
+ 0.2291667 0.317088
+ 0.2294444 0.358190
+ 0.2297222 0.395051
+ 0.2300000 0.425648
+ 0.2302778 0.447955
+ 0.2305556 0.459948
+ 0.2308333 0.460207
+ 0.2311111 0.449741
+ 0.2313889 0.430162
+ 0.2316667 0.403084
+ 0.2319444 0.370119
+ 0.2322222 0.332882
+ 0.2325000 0.292985
+ 0.2327778 0.252043
+ 0.2330556 0.211667
+ 0.2333333 0.173472
+ 0.2336111 0.138893
+ 0.2338889 0.108656
+ 0.2341667 0.083306
+ 0.2344444 0.063392
+ 0.2347222 0.050000
+ 0.2350000 0.050000
+ 0.2352778 0.050000
+ 0.2355556 0.050000
+ 0.2358333 0.064504
+ 0.2361111 0.088693
+ 0.2363889 0.121678
+ 0.2366667 0.161652
+ 0.2369444 0.206339
+ 0.2372222 0.253462
+ 0.2375000 0.300746
+ 0.2377778 0.345914
+ 0.2380556 0.386689
+ 0.2383333 0.420795
+ 0.2386111 0.445956
+ 0.2388889 0.459895
+ 0.2391667 0.461022
+ 0.2394444 0.450488
+ 0.2397222 0.430128
+ 0.2400000 0.401780
+ 0.2402778 0.367280
+ 0.2405556 0.328464
+ 0.2408333 0.287170
+ 0.2411111 0.245233
+ 0.2413889 0.204490
+ 0.2416667 0.166778
+ 0.2419444 0.133681
+ 0.2422222 0.105778
+ 0.2425000 0.083395
+ 0.2427778 0.066859
+ 0.2430556 0.056497
+ 0.2433333 0.052634
+ 0.2436111 0.055597
+ 0.2438889 0.065714
+ 0.2441667 0.083309
+ 0.2444444 0.108711
+ 0.2447222 0.141842
+ 0.2450000 0.181007
+ 0.2452778 0.224111
+ 0.2455556 0.269055
+ 0.2458333 0.313742
+ 0.2461111 0.356075
+ 0.2463889 0.393957
+ 0.2466667 0.425290
+ 0.2469444 0.447978
+ 0.2472222 0.459922
+ 0.2475000 0.459658
+ 0.2477778 0.448254
+ 0.2480556 0.427412
+ 0.2483333 0.398831
+ 0.2486111 0.364212
+ 0.2488889 0.325257
+ 0.2491667 0.283665
+ 0.2494444 0.241139
+ 0.2497222 0.199378
+ 0.2500000 0.160083
+ 0.2502778 0.124758
+ 0.2505556 0.094110
+ 0.2508333 0.068651
+ 0.2511111 0.050000
+ 0.2513889 0.050000
+ 0.2516667 0.050000
+ 0.2519444 0.050000
+ 0.2522222 0.050000
+ 0.2525000 0.053471
+ 0.2527778 0.078639
+ 0.2530556 0.112617
+ 0.2533333 0.153592
+ 0.2536111 0.199285
+ 0.2538889 0.247418
+ 0.2541667 0.295712
+ 0.2544444 0.341887
+ 0.2547222 0.383665
+ 0.2550000 0.418768
+ 0.2552778 0.444916
+ 0.2555556 0.459830
+ 0.2558333 0.461899
+ 0.2561111 0.452179
+ 0.2563889 0.432392
+ 0.2566667 0.404262
+ 0.2569444 0.369510
+ 0.2572222 0.329860
+ 0.2575000 0.287035
+ 0.2577778 0.242758
+ 0.2580556 0.198750
+ 0.2583333 0.156736
+ 0.2586111 0.118263
+ 0.2588889 0.084176
+ 0.2591667 0.055149
+ 0.2594444 0.050000
+ 0.2597222 0.050000
+ 0.2600000 0.050000
+ 0.2602778 0.050000
+ 0.2605556 0.050000
+ 0.2608333 0.050000
+ 0.2611111 0.050000
+ 0.2613889 0.085087
+ 0.2616667 0.128115
+ 0.2619444 0.176598
+ 0.2622222 0.228048
+ 0.2625000 0.279975
+ 0.2627778 0.329894
+ 0.2630556 0.375314
+ 0.2633333 0.413749
+ 0.2636111 0.442712
+ 0.2638889 0.459712
+ 0.2641667 0.462990
+ 0.2644444 0.453683
+ 0.2647222 0.433658
+ 0.2650000 0.404779
+ 0.2652778 0.368913
+ 0.2655556 0.327923
+ 0.2658333 0.283676
+ 0.2661111 0.238037
+ 0.2663889 0.192870
+ 0.2666667 0.150042
+ 0.2669444 0.111206
+ 0.2672222 0.077175
+ 0.2675000 0.050000
+ 0.2677778 0.050000
+ 0.2680556 0.050000
+ 0.2683333 0.050000
+ 0.2686111 0.050000
+ 0.2688889 0.050000
+ 0.2691667 0.050000
+ 0.2694444 0.050000
+ 0.2697222 0.085741
+ 0.2700000 0.129227
+ 0.2702778 0.177989
+ 0.2705556 0.229558
+ 0.2708333 0.281467
+ 0.2711111 0.331246
+ 0.2713889 0.376428
+ 0.2716667 0.414543
+ 0.2719444 0.443123
+ 0.2722222 0.459699
+ 0.2725000 0.462528
+ 0.2727778 0.452764
+ 0.2730556 0.432284
+ 0.2733333 0.402968
+ 0.2736111 0.366693
+ 0.2738889 0.325339
+ 0.2741667 0.280784
+ 0.2744444 0.234906
+ 0.2747222 0.189583
+ 0.2750000 0.146694
+ 0.2752778 0.107904
+ 0.2755556 0.074014
+ 0.2758333 0.050000
+ 0.2761111 0.050000
+ 0.2763889 0.050000
+ 0.2766667 0.050000
+ 0.2769444 0.050000
+ 0.2772222 0.050000
+ 0.2775000 0.050000
+ 0.2777778 0.050000
+ 0.2780556 0.086204
+ 0.2783333 0.130115
+ 0.2786111 0.179240
+ 0.2788889 0.231086
+ 0.2791667 0.283160
+ 0.2794444 0.332969
+ 0.2797222 0.378019
+ 0.2800000 0.415817
+ 0.2802778 0.443871
+ 0.2805556 0.459686
+ 0.2808333 0.461511
+ 0.2811111 0.450554
+ 0.2813889 0.428764
+ 0.2816667 0.398091
+ 0.2819444 0.360483
+ 0.2822222 0.317891
+ 0.2825000 0.272262
+ 0.2827778 0.225547
+ 0.2830556 0.179694
+ 0.2833333 0.136653
+ 0.2836111 0.098133
+ 0.2838889 0.064885
+ 0.2841667 0.050000
+ 0.2844444 0.050000
+ 0.2847222 0.050000
+ 0.2850000 0.050000
+ 0.2852778 0.050000
+ 0.2855556 0.050000
+ 0.2858333 0.050000
+ 0.2861111 0.050000
+ 0.2863889 0.086700
+ 0.2866667 0.130837
+ 0.2869444 0.179977
+ 0.2872222 0.231687
+ 0.2875000 0.283533
+ 0.2877778 0.333080
+ 0.2880556 0.377897
+ 0.2883333 0.415548
+ 0.2886111 0.443600
+ 0.2888889 0.459621
+ 0.2891667 0.461896
+ 0.2894444 0.451596
+ 0.2897222 0.430611
+ 0.2900000 0.400832
+ 0.2902778 0.364149
+ 0.2905556 0.322452
+ 0.2908333 0.277634
+ 0.2911111 0.231583
+ 0.2913889 0.186191
+ 0.2916667 0.143347
+ 0.2919444 0.104722
+ 0.2922222 0.071102
+ 0.2925000 0.050000
+ 0.2927778 0.050000
+ 0.2930556 0.050000
+ 0.2933333 0.050000
+ 0.2936111 0.050000
+ 0.2938889 0.050000
+ 0.2941667 0.050000
+ 0.2944444 0.050000
+ 0.2947222 0.086306
+ 0.2950000 0.130226
+ 0.2952778 0.179294
+ 0.2955556 0.231041
+ 0.2958333 0.283000
+ 0.2961111 0.332702
+ 0.2963889 0.377679
+ 0.2966667 0.415463
+ 0.2969444 0.443587
+ 0.2972222 0.459582
+ 0.2975000 0.461710
+ 0.2977778 0.451158
+ 0.2980556 0.429838
+ 0.2983333 0.399667
+ 0.2986111 0.362559
+ 0.2988889 0.320430
+ 0.2991667 0.275195
+ 0.2994444 0.228768
+ 0.2997222 0.183065
+ 0.3000000 0.140000
+ 0.3002778 0.101263
+ 0.3005556 0.067640
+ 0.3008333 0.050000
+ 0.3011111 0.050000
+ 0.3013889 0.050000
+ 0.3016667 0.050000
+ 0.3019444 0.050000
+ 0.3022222 0.050000
+ 0.3025000 0.050000
+ 0.3027778 0.050000
+ 0.3030556 0.087101
+ 0.3033333 0.131823
+ 0.3036111 0.181630
+ 0.3038889 0.233986
+ 0.3041667 0.286355
+ 0.3044444 0.336201
+ 0.3047222 0.380988
+ 0.3050000 0.418179
+ 0.3052778 0.445240
+ 0.3055556 0.459634
+ 0.3058333 0.459592
+ 0.3061111 0.446418
+ 0.3063889 0.422179
+ 0.3066667 0.388946
+ 0.3069444 0.348789
+ 0.3072222 0.303777
+ 0.3075000 0.255979
+ 0.3077778 0.207466
+ 0.3080556 0.160306
+ 0.3083333 0.116569
+ 0.3086111 0.078053
+ 0.3088889 0.050000
+ 0.3091667 0.050000
+ 0.3094444 0.050000
+ 0.3097222 0.050000
+ 0.3100000 0.050000
+ 0.3102778 0.050000
+ 0.3105556 0.050000
+ 0.3108333 0.050000
+ 0.3111111 0.050000
+ 0.3113889 0.089711
+ 0.3116667 0.136639
+ 0.3119444 0.188181
+ 0.3122222 0.241734
+ 0.3125000 0.294694
+ 0.3127778 0.344457
+ 0.3130556 0.388421
+ 0.3133333 0.423981
+ 0.3136111 0.448534
+ 0.3138889 0.459477
+ 0.3141667 0.455035
+ 0.3144444 0.436749
+ 0.3147222 0.406988
+ 0.3150000 0.368121
+ 0.3152778 0.322519
+ 0.3155556 0.272551
+ 0.3158333 0.220585
+ 0.3161111 0.168993
+ 0.3163889 0.120142
+ 0.3166667 0.076403
+ 0.3169444 0.050000
+ 0.3172222 0.050000
+ 0.3175000 0.050000
+ 0.3177778 0.050000
+ 0.3180556 0.050000
+ 0.3183333 0.050000
+ 0.3186111 0.050000
+ 0.3188889 0.050000
+ 0.3191667 0.050000
+ 0.3194444 0.050000
+ 0.3197222 0.088976
+ 0.3200000 0.133662
+ 0.3202778 0.182079
+ 0.3205556 0.232248
+ 0.3208333 0.282187
+ 0.3211111 0.329919
+ 0.3213889 0.373464
+ 0.3216667 0.410841
+ 0.3219444 0.440072
+ 0.3222222 0.459176
+ 0.3225000 0.466728
+ 0.3227778 0.463509
+ 0.3230556 0.450855
+ 0.3233333 0.430102
+ 0.3236111 0.402586
+ 0.3238889 0.369641
+ 0.3241667 0.332604
+ 0.3244444 0.292809
+ 0.3247222 0.251594
+ 0.3250000 0.210292
+ 0.3252778 0.170203
+ 0.3255556 0.132481
+ 0.3258333 0.098244
+ 0.3261111 0.068608
+ 0.3263889 0.050000
+ 0.3266667 0.050000
+ 0.3269444 0.050000
+ 0.3272222 0.050000
+ 0.3275000 0.050000
+ 0.3277778 0.050000
+ 0.3280556 0.083244
+ 0.3283333 0.126316
+ 0.3286111 0.176624
+ 0.3288889 0.231571
+ 0.3291667 0.288565
+ 0.3294444 0.345011
+ 0.3297222 0.398314
+ 0.3300000 0.445880
+ 0.3302778 0.485115
+ 0.3305556 0.513425
+ 0.3308333 0.528981
+ 0.3311111 0.533022
+ 0.3313889 0.527550
+ 0.3316667 0.514571
+ 0.3319444 0.496088
+ 0.3322222 0.474105
+ 0.3325000 0.450626
+ 0.3327778 0.427654
+ 0.3330556 0.407195
+ 0.3333333 0.391251
+ 0.3336111 0.381341
+ 0.3338889 0.377035
+ 0.3341667 0.377420
+ 0.3344444 0.381580
+ 0.3347222 0.388599
+ 0.3350000 0.397565
+ 0.3352778 0.407561
+ 0.3355556 0.417672
+ 0.3358333 0.426984
+ 0.3361111 0.434582
+ 0.3363889 0.439851
+ 0.3366667 0.443380
+ 0.3369444 0.446055
+ 0.3372222 0.448766
+ 0.3375000 0.452399
+ 0.3377778 0.457843
+ 0.3380556 0.465987
+ 0.3383333 0.477717
+ 0.3386111 0.493922
+ 0.3388889 0.515491
+ 0.3391667 0.542741
+ 0.3394444 0.573715
+ 0.3397222 0.605887
+ 0.3400000 0.636728
+ 0.3402778 0.663714
+ 0.3405556 0.684315
+ 0.3408333 0.696006
+ 0.3411111 0.696260
+ 0.3413889 0.682550
+ 0.3416667 0.652348
+ 0.3419444 0.604291
+ 0.3422222 0.541664
+ 0.3425000 0.468917
+ 0.3427778 0.390498
+ 0.3430556 0.310855
+ 0.3433333 0.234438
+ 0.3436111 0.165696
+ 0.3438889 0.109076
+ 0.3441667 0.069028
+ 0.3444444 0.050000
+ 0.3447222 0.054910
+ 0.3450000 0.080546
+ 0.3452778 0.122167
+ 0.3455556 0.175030
+ 0.3458333 0.234393
+ 0.3461111 0.295515
+ 0.3463889 0.353651
+ 0.3466667 0.404062
+ 0.3469444 0.442003
+ 0.3472222 0.462733
+ 0.3475000 0.462899
+ 0.3477778 0.444707
+ 0.3480556 0.411752
+ 0.3483333 0.367630
+ 0.3486111 0.315936
+ 0.3488889 0.260265
+ 0.3491667 0.204213
+ 0.3494444 0.151375
+ 0.3497222 0.105346
+ 0.3500000 0.069721
+ 0.3502778 0.050000
+ 0.3505556 0.050000
+ 0.3508333 0.050000
+ 0.3511111 0.050000
+ 0.3513889 0.069177
+ 0.3516667 0.095532
+ 0.3519444 0.127411
+ 0.3522222 0.163404
+ 0.3525000 0.202096
+ 0.3527778 0.242077
+ 0.3530556 0.281992
+ 0.3533333 0.320717
+ 0.3536111 0.357187
+ 0.3538889 0.390339
+ 0.3541667 0.419107
+ 0.3544444 0.442427
+ 0.3547222 0.459233
+ 0.3550000 0.468460
+ 0.3552778 0.469045
+ 0.3555556 0.459922
+ 0.3558333 0.440488
+ 0.3561111 0.411992
+ 0.3563889 0.376144
+ 0.3566667 0.334654
+ 0.3569444 0.289232
+ 0.3572222 0.241590
+ 0.3575000 0.193436
+ 0.3577778 0.146482
+ 0.3580556 0.102438
+ 0.3583333 0.063014
+ 0.3586111 0.050000
+ 0.3588889 0.050000
+ 0.3591667 0.050000
+ 0.3594444 0.050000
+ 0.3597222 0.050000
+ 0.3600000 0.050000
+ 0.3602778 0.050000
+ 0.3605556 0.050000
+ 0.3608333 0.050000
+ 0.3611111 0.050000
+ 0.3613889 0.091384
+ 0.3616667 0.138910
+ 0.3619444 0.190238
+ 0.3622222 0.243025
+ 0.3625000 0.294931
+ 0.3627778 0.343612
+ 0.3630556 0.386729
+ 0.3633333 0.421938
+ 0.3636111 0.446898
+ 0.3638889 0.459268
+ 0.3641667 0.457440
+ 0.3644444 0.442746
+ 0.3647222 0.417251
+ 0.3650000 0.383020
+ 0.3652778 0.342121
+ 0.3655556 0.296617
+ 0.3658333 0.248575
+ 0.3661111 0.200060
+ 0.3663889 0.153138
+ 0.3666667 0.109875
+ 0.3669444 0.072053
+ 0.3672222 0.050000
+ 0.3675000 0.050000
+ 0.3677778 0.050000
+ 0.3680556 0.050000
+ 0.3683333 0.050000
+ 0.3686111 0.050000
+ 0.3688889 0.050000
+ 0.3691667 0.050000
+ 0.3694444 0.050000
+ 0.3697222 0.089200
+ 0.3700000 0.135347
+ 0.3702778 0.185981
+ 0.3705556 0.238644
+ 0.3708333 0.290875
+ 0.3711111 0.340216
+ 0.3713889 0.384207
+ 0.3716667 0.420390
+ 0.3719444 0.446304
+ 0.3722222 0.459490
+ 0.3725000 0.458249
+ 0.3727778 0.443919
+ 0.3730556 0.418599
+ 0.3733333 0.384387
+ 0.3736111 0.343380
+ 0.3738889 0.297678
+ 0.3741667 0.249378
+ 0.3744444 0.200579
+ 0.3747222 0.153378
+ 0.3750000 0.109875
+ 0.3752778 0.071877
+ 0.3755556 0.050000
+ 0.3758333 0.050000
+ 0.3761111 0.050000
+ 0.3763889 0.050000
+ 0.3766667 0.050000
+ 0.3769444 0.050000
+ 0.3772222 0.050000
+ 0.3775000 0.050000
+ 0.3777778 0.050000
+ 0.3780556 0.089258
+ 0.3783333 0.135448
+ 0.3786111 0.186112
+ 0.3788889 0.238794
+ 0.3791667 0.291034
+ 0.3794444 0.340375
+ 0.3797222 0.384360
+ 0.3800000 0.420530
+ 0.3802778 0.446427
+ 0.3805556 0.459595
+ 0.3808333 0.458333
+ 0.3811111 0.443983
+ 0.3813889 0.418643
+ 0.3816667 0.384412
+ 0.3819444 0.343389
+ 0.3822222 0.297675
+ 0.3825000 0.249367
+ 0.3827778 0.200565
+ 0.3830556 0.153368
+ 0.3833333 0.109875
+ 0.3836111 0.071895
+ 0.3838889 0.050000
+ 0.3841667 0.050000
+ 0.3844444 0.050000
+ 0.3847222 0.050000
+ 0.3850000 0.050000
+ 0.3852778 0.050000
+ 0.3855556 0.050000
+ 0.3858333 0.050000
+ 0.3861111 0.050000
+ 0.3863889 0.089177
+ 0.3866667 0.135273
+ 0.3869444 0.185841
+ 0.3872222 0.238436
+ 0.3875000 0.290611
+ 0.3877778 0.339920
+ 0.3880556 0.383916
+ 0.3883333 0.420154
+ 0.3886111 0.446187
+ 0.3888889 0.459569
+ 0.3891667 0.458606
+ 0.3894444 0.444624
+ 0.3897222 0.419697
+ 0.3900000 0.385903
+ 0.3902778 0.345318
+ 0.3905556 0.300019
+ 0.3908333 0.252084
+ 0.3911111 0.203588
+ 0.3913889 0.156609
+ 0.3916667 0.113222
+ 0.3919444 0.075222
+ 0.3922222 0.050000
+ 0.3925000 0.050000
+ 0.3927778 0.050000
+ 0.3930556 0.050000
+ 0.3933333 0.050000
+ 0.3936111 0.050000
+ 0.3938889 0.050000
+ 0.3941667 0.050000
+ 0.3944444 0.050000
+ 0.3947222 0.088776
+ 0.3950000 0.134524
+ 0.3952778 0.184811
+ 0.3955556 0.237203
+ 0.3958333 0.289266
+ 0.3961111 0.338568
+ 0.3963889 0.382675
+ 0.3966667 0.419153
+ 0.3969444 0.445569
+ 0.3972222 0.459490
+ 0.3975000 0.459226
+ 0.3977778 0.446062
+ 0.3980556 0.422029
+ 0.3983333 0.389155
+ 0.3986111 0.349471
+ 0.3988889 0.305005
+ 0.3991667 0.257787
+ 0.3994444 0.209846
+ 0.3997222 0.163213
+ 0.4000000 0.119917
+ 0.4002778 0.081719
+ 0.4005556 0.050000
+ 0.4008333 0.050000
+ 0.4011111 0.050000
+ 0.4013889 0.050000
+ 0.4016667 0.050000
+ 0.4019444 0.050000
+ 0.4022222 0.050000
+ 0.4025000 0.050000
+ 0.4027778 0.050000
+ 0.4030556 0.088507
+ 0.4033333 0.134175
+ 0.4036111 0.184525
+ 0.4038889 0.237072
+ 0.4041667 0.289336
+ 0.4044444 0.338835
+ 0.4047222 0.383087
+ 0.4050000 0.419610
+ 0.4052778 0.445923
+ 0.4055556 0.459542
+ 0.4058333 0.458749
+ 0.4061111 0.444870
+ 0.4063889 0.419991
+ 0.4066667 0.386200
+ 0.4069444 0.345586
+ 0.4072222 0.300235
+ 0.4075000 0.252236
+ 0.4077778 0.203676
+ 0.4080556 0.156642
+ 0.4083333 0.113222
+ 0.4086111 0.075217
+ 0.4088889 0.050000
+ 0.4091667 0.050000
+ 0.4094444 0.050000
+ 0.4097222 0.050000
+ 0.4100000 0.050000
+ 0.4102778 0.050000
+ 0.4105556 0.050000
+ 0.4108333 0.050000
+ 0.4111111 0.050000
+ 0.4113889 0.088633
+ 0.4116667 0.134209
+ 0.4119444 0.184317
+ 0.4122222 0.236549
+ 0.4125000 0.288494
+ 0.4127778 0.337741
+ 0.4130556 0.381881
+ 0.4133333 0.418503
+ 0.4136111 0.445198
+ 0.4138889 0.459555
+ 0.4141667 0.459897
+ 0.4144444 0.447475
+ 0.4147222 0.424272
+ 0.4150000 0.392273
+ 0.4152778 0.353459
+ 0.4155556 0.309815
+ 0.4158333 0.263325
+ 0.4161111 0.215972
+ 0.4163889 0.169740
+ 0.4166667 0.126611
+ 0.4169444 0.088318
+ 0.4172222 0.055581
+ 0.4175000 0.050000
+ 0.4177778 0.050000
+ 0.4180556 0.050000
+ 0.4183333 0.050000
+ 0.4186111 0.050000
+ 0.4188889 0.050000
+ 0.4191667 0.050000
+ 0.4194444 0.050000
+ 0.4197222 0.087885
+ 0.4200000 0.133067
+ 0.4202778 0.183064
+ 0.4205556 0.235397
+ 0.4208333 0.287584
+ 0.4211111 0.337144
+ 0.4213889 0.381597
+ 0.4216667 0.418462
+ 0.4219444 0.445257
+ 0.4222222 0.459503
+ 0.4225000 0.459472
+ 0.4227778 0.446454
+ 0.4230556 0.422491
+ 0.4233333 0.389626
+ 0.4236111 0.349903
+ 0.4238889 0.305365
+ 0.4241667 0.258054
+ 0.4244444 0.210013
+ 0.4247222 0.163287
+ 0.4250000 0.119917
+ 0.4252778 0.081676
+ 0.4255556 0.050000
+ 0.4258333 0.050000
+ 0.4261111 0.050000
+ 0.4263889 0.050000
+ 0.4266667 0.050000
+ 0.4269444 0.050000
+ 0.4272222 0.050000
+ 0.4275000 0.050000
+ 0.4277778 0.050000
+ 0.4280556 0.088442
+ 0.4283333 0.134026
+ 0.4286111 0.184284
+ 0.4288889 0.236746
+ 0.4291667 0.288943
+ 0.4294444 0.338406
+ 0.4297222 0.382665
+ 0.4300000 0.419252
+ 0.4302778 0.445696
+ 0.4305556 0.459529
+ 0.4308333 0.459038
+ 0.4311111 0.445530
+ 0.4313889 0.421069
+ 0.4316667 0.387721
+ 0.4319444 0.347549
+ 0.4322222 0.302616
+ 0.4325000 0.254988
+ 0.4327778 0.206728
+ 0.4330556 0.159901
+ 0.4333333 0.116569
+ 0.4336111 0.078519
+ 0.4338889 0.050000
+ 0.4341667 0.050000
+ 0.4344444 0.050000
+ 0.4347222 0.050000
+ 0.4350000 0.050000
+ 0.4352778 0.050000
+ 0.4355556 0.050000
+ 0.4358333 0.050000
+ 0.4361111 0.050000
+ 0.4363889 0.088325
+ 0.4366667 0.133662
+ 0.4369444 0.183600
+ 0.4372222 0.235729
+ 0.4375000 0.287639
+ 0.4377778 0.336920
+ 0.4380556 0.381160
+ 0.4383333 0.417951
+ 0.4386111 0.444882
+ 0.4388889 0.459542
+ 0.4391667 0.460251
+ 0.4394444 0.448243
+ 0.4397222 0.425480
+ 0.4400000 0.393927
+ 0.4402778 0.355547
+ 0.4405556 0.312304
+ 0.4408333 0.266159
+ 0.4411111 0.219078
+ 0.4413889 0.173023
+ 0.4416667 0.129958
+ 0.4419444 0.091601
+ 0.4422222 0.058685
+ 0.4425000 0.050000
+ 0.4427778 0.050000
+ 0.4430556 0.050000
+ 0.4433333 0.050000
+ 0.4436111 0.050000
+ 0.4438889 0.050000
+ 0.4441667 0.050000
+ 0.4444444 0.050000
+ 0.4447222 0.087588
+ 0.4450000 0.132541
+ 0.4452778 0.182376
+ 0.4455556 0.234614
+ 0.4458333 0.286771
+ 0.4461111 0.336368
+ 0.4463889 0.380922
+ 0.4466667 0.417952
+ 0.4469444 0.444978
+ 0.4472222 0.459516
+ 0.4475000 0.459838
+ 0.4477778 0.447217
+ 0.4480556 0.423677
+ 0.4483333 0.391243
+ 0.4486111 0.351941
+ 0.4488889 0.307795
+ 0.4491667 0.260829
+ 0.4494444 0.213069
+ 0.4497222 0.166539
+ 0.4500000 0.123264
+ 0.4502778 0.085004
+ 0.4505556 0.052458
+ 0.4508333 0.050000
+ 0.4511111 0.050000
+ 0.4513889 0.050000
+ 0.4516667 0.050000
+ 0.4519444 0.050000
+ 0.4522222 0.050000
+ 0.4525000 0.050000
+ 0.4527778 0.050000
+ 0.4530556 0.087974
+ 0.4533333 0.133130
+ 0.4536111 0.183025
+ 0.4538889 0.235212
+ 0.4541667 0.287246
+ 0.4544444 0.336682
+ 0.4547222 0.381075
+ 0.4550000 0.417980
+ 0.4552778 0.444950
+ 0.4555556 0.459542
+ 0.4558333 0.460050
+ 0.4561111 0.447728
+ 0.4563889 0.424571
+ 0.4566667 0.392573
+ 0.4569444 0.353728
+ 0.4572222 0.310031
+ 0.4575000 0.263477
+ 0.4577778 0.216059
+ 0.4580556 0.169772
+ 0.4583333 0.126611
+ 0.4586111 0.088314
+ 0.4588889 0.055598
+ 0.4591667 0.050000
+ 0.4594444 0.050000
+ 0.4597222 0.050000
+ 0.4600000 0.050000
+ 0.4602778 0.050000
+ 0.4605556 0.050000
+ 0.4608333 0.050000
+ 0.4611111 0.050000
+ 0.4613889 0.087736
+ 0.4616667 0.132739
+ 0.4619444 0.182552
+ 0.4622222 0.234718
+ 0.4625000 0.286780
+ 0.4627778 0.336281
+ 0.4630556 0.380765
+ 0.4633333 0.417774
+ 0.4636111 0.444852
+ 0.4638889 0.459542
+ 0.4641667 0.460130
+ 0.4644444 0.447867
+ 0.4647222 0.424751
+ 0.4650000 0.392775
+ 0.4652778 0.353935
+ 0.4655556 0.310226
+ 0.4658333 0.263645
+ 0.4661111 0.216185
+ 0.4663889 0.169842
+ 0.4666667 0.126611
+ 0.4669444 0.088234
+ 0.4672222 0.055432
+ 0.4675000 0.050000
+ 0.4677778 0.050000
+ 0.4680556 0.050000
+ 0.4683333 0.050000
+ 0.4686111 0.050000
+ 0.4688889 0.050000
+ 0.4691667 0.050000
+ 0.4694444 0.050000
+ 0.4697222 0.087979
+ 0.4700000 0.133261
+ 0.4702778 0.183355
+ 0.4705556 0.235768
+ 0.4708333 0.288012
+ 0.4711111 0.337593
+ 0.4713889 0.382021
+ 0.4716667 0.418805
+ 0.4719444 0.445454
+ 0.4722222 0.459477
+ 0.4725000 0.459142
+ 0.4727778 0.445754
+ 0.4730556 0.421378
+ 0.4733333 0.388081
+ 0.4736111 0.347926
+ 0.4738889 0.302979
+ 0.4741667 0.255304
+ 0.4744444 0.206968
+ 0.4747222 0.160035
+ 0.4750000 0.116569
+ 0.4752778 0.078360
+ 0.4755556 0.050000
+ 0.4758333 0.050000
+ 0.4761111 0.050000
+ 0.4763889 0.050000
+ 0.4766667 0.050000
+ 0.4769444 0.050000
+ 0.4772222 0.050000
+ 0.4775000 0.050000
+ 0.4777778 0.050000
+ 0.4780556 0.088819
+ 0.4783333 0.134725
+ 0.4786111 0.185237
+ 0.4788889 0.237877
+ 0.4791667 0.290164
+ 0.4794444 0.339620
+ 0.4797222 0.383765
+ 0.4800000 0.420120
+ 0.4802778 0.446206
+ 0.4805556 0.459542
+ 0.4808333 0.458414
+ 0.4811111 0.444160
+ 0.4813889 0.418882
+ 0.4816667 0.384683
+ 0.4819444 0.343665
+ 0.4822222 0.297930
+ 0.4825000 0.249582
+ 0.4827778 0.200721
+ 0.4830556 0.153452
+ 0.4833333 0.109875
+ 0.4836111 0.071804
+ 0.4838889 0.050000
+ 0.4841667 0.050000
+ 0.4844444 0.050000
+ 0.4847222 0.050000
+ 0.4850000 0.050000
+ 0.4852778 0.050000
+ 0.4855556 0.050000
+ 0.4858333 0.050000
+ 0.4861111 0.050000
+ 0.4863889 0.089423
+ 0.4866667 0.135801
+ 0.4869444 0.186652
+ 0.4872222 0.239497
+ 0.4875000 0.291856
+ 0.4877778 0.341247
+ 0.4880556 0.385192
+ 0.4883333 0.421210
+ 0.4886111 0.446820
+ 0.4888889 0.459542
+ 0.4891667 0.457668
+ 0.4894444 0.442570
+ 0.4897222 0.416395
+ 0.4900000 0.381287
+ 0.4902778 0.339392
+ 0.4905556 0.292854
+ 0.4908333 0.243819
+ 0.4911111 0.194432
+ 0.4913889 0.146837
+ 0.4916667 0.103181
+ 0.4919444 0.065302
+ 0.4922222 0.050000
+ 0.4925000 0.050000
+ 0.4927778 0.050000
+ 0.4930556 0.050000
+ 0.4933333 0.050000
+ 0.4936111 0.050000
+ 0.4938889 0.050000
+ 0.4941667 0.050000
+ 0.4944444 0.050000
+ 0.4947222 0.089782
+ 0.4950000 0.136346
+ 0.4952778 0.187246
+ 0.4955556 0.240037
+ 0.4958333 0.292273
+ 0.4961111 0.341510
+ 0.4963889 0.385302
+ 0.4966667 0.421204
+ 0.4969444 0.446770
+ 0.4972222 0.459555
+ 0.4975000 0.457875
+ 0.4977778 0.443083
+ 0.4980556 0.417295
+ 0.4983333 0.382625
+ 0.4986111 0.341188
+ 0.4988889 0.295100
+ 0.4991667 0.246475
+ 0.4994444 0.197428
+ 0.4997222 0.150074
+ 0.5000000 0.106528
+ 0.5002778 0.068608
+ 0.5005556 0.050000
+ 0.5008333 0.050000
+ 0.5011111 0.050000
+ 0.5013889 0.050000
+ 0.5016667 0.050000
+ 0.5019444 0.050000
+ 0.5022222 0.050000
+ 0.5025000 0.050000
+ 0.5027778 0.050000
+ 0.5030556 0.089557
+ 0.5033333 0.135981
+ 0.5036111 0.186814
+ 0.5038889 0.239597
+ 0.5041667 0.291873
+ 0.5044444 0.341181
+ 0.5047222 0.385065
+ 0.5050000 0.421065
+ 0.5052778 0.446724
+ 0.5055556 0.459582
+ 0.5058333 0.457944
+ 0.5061111 0.443169
+ 0.5063889 0.417377
+ 0.5066667 0.382689
+ 0.5069444 0.341226
+ 0.5072222 0.295110
+ 0.5075000 0.246461
+ 0.5077778 0.197400
+ 0.5080556 0.150049
+ 0.5083333 0.106528
+ 0.5086111 0.068659
+ 0.5088889 0.050000
+ 0.5091667 0.050000
+ 0.5094444 0.050000
+ 0.5097222 0.050000
+ 0.5100000 0.050000
+ 0.5102778 0.050000
+ 0.5105556 0.050000
+ 0.5108333 0.050000
+ 0.5111111 0.050000
+ 0.5113889 0.089302
+ 0.5116667 0.135429
+ 0.5119444 0.185959
+ 0.5122222 0.238472
+ 0.5125000 0.290546
+ 0.5127778 0.339761
+ 0.5130556 0.383695
+ 0.5133333 0.419928
+ 0.5136111 0.446040
+ 0.5138889 0.459608
+ 0.5141667 0.458956
+ 0.5144444 0.445381
+ 0.5147222 0.420926
+ 0.5150000 0.387632
+ 0.5152778 0.347540
+ 0.5155556 0.302692
+ 0.5158333 0.255129
+ 0.5161111 0.206893
+ 0.5163889 0.160026
+ 0.5166667 0.116569
+ 0.5169444 0.078295
+ 0.5172222 0.050000
+ 0.5175000 0.050000
+ 0.5177778 0.050000
+ 0.5180556 0.050000
+ 0.5183333 0.050000
+ 0.5186111 0.050000
+ 0.5188889 0.050000
+ 0.5191667 0.050000
+ 0.5194444 0.050000
+ 0.5197222 0.089359
+ 0.5200000 0.135902
+ 0.5202778 0.187069
+ 0.5205556 0.240297
+ 0.5208333 0.293026
+ 0.5211111 0.342694
+ 0.5213889 0.386741
+ 0.5216667 0.422606
+ 0.5219444 0.447727
+ 0.5222222 0.459542
+ 0.5225000 0.456296
+ 0.5227778 0.439447
+ 0.5230556 0.411256
+ 0.5233333 0.373988
+ 0.5236111 0.329904
+ 0.5238889 0.281267
+ 0.5241667 0.230340
+ 0.5244444 0.179386
+ 0.5247222 0.130666
+ 0.5250000 0.086444
+ 0.5252778 0.050000
+ 0.5255556 0.050000
+ 0.5258333 0.050000
+ 0.5261111 0.050000
+ 0.5263889 0.050000
+ 0.5266667 0.050000
+ 0.5269444 0.050000
+ 0.5272222 0.050000
+ 0.5275000 0.050000
+ 0.5277778 0.050000
+ 0.5280556 0.091796
+ 0.5283333 0.140104
+ 0.5286111 0.192412
+ 0.5288889 0.246207
+ 0.5291667 0.298978
+ 0.5294444 0.348213
+ 0.5297222 0.391398
+ 0.5300000 0.426023
+ 0.5302778 0.449575
+ 0.5305556 0.459542
+ 0.5308333 0.454223
+ 0.5311111 0.435156
+ 0.5313889 0.404692
+ 0.5316667 0.365180
+ 0.5319444 0.318971
+ 0.5322222 0.268414
+ 0.5325000 0.215859
+ 0.5327778 0.163657
+ 0.5330556 0.114157
+ 0.5333333 0.069708
+ 0.5336111 0.050000
+ 0.5338889 0.050000
+ 0.5341667 0.050000
+ 0.5344444 0.050000
+ 0.5347222 0.050000
+ 0.5350000 0.050000
+ 0.5352778 0.050000
+ 0.5355556 0.050000
+ 0.5358333 0.050000
+ 0.5361111 0.050000
+ 0.5363889 0.093286
+ 0.5366667 0.142756
+ 0.5369444 0.195896
+ 0.5372222 0.250192
+ 0.5375000 0.303131
+ 0.5377778 0.352199
+ 0.5380556 0.394882
+ 0.5383333 0.428668
+ 0.5386111 0.451042
+ 0.5388889 0.459490
+ 0.5391667 0.452328
+ 0.5394444 0.431180
+ 0.5397222 0.398501
+ 0.5400000 0.356743
+ 0.5402778 0.308362
+ 0.5405556 0.255810
+ 0.5408333 0.201542
+ 0.5411111 0.148010
+ 0.5413889 0.097669
+ 0.5416667 0.052972
+ 0.5419444 0.050000
+ 0.5422222 0.050000
+ 0.5425000 0.050000
+ 0.5427778 0.050000
+ 0.5430556 0.050000
+ 0.5433333 0.050000
+ 0.5436111 0.050000
+ 0.5438889 0.050000
+ 0.5441667 0.050000
+ 0.5444444 0.050000
+ 0.5447222 0.094451
+ 0.5450000 0.144697
+ 0.5452778 0.198272
+ 0.5455556 0.252710
+ 0.5458333 0.305545
+ 0.5461111 0.354314
+ 0.5463889 0.396548
+ 0.5466667 0.429785
+ 0.5469444 0.451556
+ 0.5472222 0.459399
+ 0.5475000 0.451666
+ 0.5477778 0.429997
+ 0.5480556 0.396851
+ 0.5483333 0.354686
+ 0.5486111 0.305961
+ 0.5488889 0.253135
+ 0.5491667 0.198667
+ 0.5494444 0.145016
+ 0.5497222 0.094641
+ 0.5500000 0.050000
+ 0.5502778 0.050000
+ 0.5505556 0.050000
+ 0.5508333 0.050000
+ 0.5511111 0.050000
+ 0.5513889 0.050000
+ 0.5516667 0.050000
+ 0.5519444 0.050000
+ 0.5522222 0.050000
+ 0.5525000 0.050000
+ 0.5527778 0.050000
+ 0.5530556 0.094624
+ 0.5533333 0.144978
+ 0.5536111 0.198605
+ 0.5538889 0.253050
+ 0.5541667 0.305857
+ 0.5544444 0.354569
+ 0.5547222 0.396732
+ 0.5550000 0.429888
+ 0.5552778 0.451583
+ 0.5555556 0.459359
+ 0.5558333 0.451581
+ 0.5561111 0.429884
+ 0.5563889 0.396726
+ 0.5566667 0.354562
+ 0.5569444 0.305849
+ 0.5572222 0.253042
+ 0.5575000 0.198597
+ 0.5577778 0.144972
+ 0.5580556 0.094620
+ 0.5583333 0.050000
+ 0.5586111 0.050000
+ 0.5588889 0.050000
+ 0.5591667 0.050000
+ 0.5594444 0.050000
+ 0.5597222 0.050000
+ 0.5600000 0.050000
+ 0.5602778 0.050000
+ 0.5605556 0.050000
+ 0.5608333 0.050000
+ 0.5611111 0.050000
+ 0.5613889 0.094624
+ 0.5616667 0.144979
+ 0.5619444 0.198610
+ 0.5622222 0.253060
+ 0.5625000 0.305873
+ 0.5627778 0.354591
+ 0.5630556 0.396760
+ 0.5633333 0.429921
+ 0.5636111 0.451620
+ 0.5638889 0.459399
+ 0.5641667 0.451620
+ 0.5644444 0.429922
+ 0.5647222 0.396761
+ 0.5650000 0.354593
+ 0.5652778 0.305874
+ 0.5655556 0.253062
+ 0.5658333 0.198611
+ 0.5661111 0.144980
+ 0.5663889 0.094624
+ 0.5666667 0.050000
+ 0.5669444 0.050000
+ 0.5672222 0.050000
+ 0.5675000 0.050000
+ 0.5677778 0.050000
+ 0.5680556 0.050000
+ 0.5683333 0.050000
+ 0.5686111 0.050000
+ 0.5688889 0.050000
+ 0.5691667 0.050000
+ 0.5694444 0.050000
+ 0.5697222 0.094623
+ 0.5700000 0.144978
+ 0.5702778 0.198607
+ 0.5705556 0.253054
+ 0.5708333 0.305863
+ 0.5711111 0.354578
+ 0.5713889 0.396741
+ 0.5716667 0.429897
+ 0.5719444 0.451588
+ 0.5722222 0.459359
+ 0.5725000 0.451572
+ 0.5727778 0.429866
+ 0.5730556 0.396697
+ 0.5733333 0.354524
+ 0.5736111 0.305803
+ 0.5738889 0.252993
+ 0.5741667 0.198550
+ 0.5744444 0.144932
+ 0.5747222 0.094596
+ 0.5750000 0.050000
+ 0.5752778 0.050000
+ 0.5755556 0.050000
+ 0.5758333 0.050000
+ 0.5761111 0.050000
+ 0.5763889 0.050000
+ 0.5766667 0.050000
+ 0.5769444 0.050000
+ 0.5772222 0.050000
+ 0.5775000 0.050000
+ 0.5777778 0.050000
+ 0.5780556 0.094497
+ 0.5783333 0.144705
+ 0.5786111 0.198188
+ 0.5788889 0.252507
+ 0.5791667 0.305224
+ 0.5794444 0.353902
+ 0.5797222 0.396103
+ 0.5800000 0.429389
+ 0.5802778 0.451322
+ 0.5805556 0.459464
+ 0.5808333 0.452188
+ 0.5811111 0.431107
+ 0.5813889 0.398645
+ 0.5816667 0.357225
+ 0.5819444 0.309271
+ 0.5822222 0.257207
+ 0.5825000 0.203456
+ 0.5827778 0.150442
+ 0.5830556 0.100589
+ 0.5833333 0.056319
+ 0.5836111 0.050000
+ 0.5838889 0.050000
+ 0.5841667 0.050000
+ 0.5844444 0.050000
+ 0.5847222 0.050000
+ 0.5850000 0.050000
+ 0.5852778 0.050000
+ 0.5855556 0.050000
+ 0.5858333 0.050000
+ 0.5861111 0.050000
+ 0.5863889 0.093022
+ 0.5866667 0.141742
+ 0.5869444 0.193850
+ 0.5872222 0.247038
+ 0.5875000 0.298997
+ 0.5877778 0.347418
+ 0.5880556 0.389992
+ 0.5883333 0.424410
+ 0.5886111 0.448363
+ 0.5888889 0.459542
+ 0.5891667 0.456378
+ 0.5894444 0.440255
+ 0.5897222 0.413300
+ 0.5900000 0.377638
+ 0.5902778 0.335395
+ 0.5905556 0.288694
+ 0.5908333 0.239663
+ 0.5911111 0.190425
+ 0.5913889 0.143107
+ 0.5916667 0.099833
+ 0.5919444 0.062422
+ 0.5922222 0.050000
+ 0.5925000 0.050000
+ 0.5927778 0.050000
+ 0.5930556 0.050000
+ 0.5933333 0.050000
+ 0.5936111 0.050000
+ 0.5938889 0.050000
+ 0.5941667 0.050000
+ 0.5944444 0.050000
+ 0.5947222 0.089392
+ 0.5950000 0.135422
+ 0.5952778 0.185732
+ 0.5955556 0.237963
+ 0.5958333 0.289756
+ 0.5961111 0.338754
+ 0.5963889 0.382598
+ 0.5966667 0.418929
+ 0.5969444 0.445390
+ 0.5972222 0.459621
+ 0.5975000 0.459984
+ 0.5977778 0.447718
+ 0.5980556 0.424781
+ 0.5983333 0.393132
+ 0.5986111 0.354729
+ 0.5988889 0.311532
+ 0.5991667 0.265497
+ 0.5994444 0.218584
+ 0.5997222 0.172752
+ 0.6000000 0.129958
+ 0.6002778 0.091914
+ 0.6005556 0.059335
+ 0.6008333 0.050000
+ 0.6011111 0.050000
+ 0.6013889 0.050000
+ 0.6016667 0.050000
+ 0.6019444 0.050000
+ 0.6022222 0.050000
+ 0.6025000 0.050000
+ 0.6027778 0.051756
+ 0.6030556 0.088991
+ 0.6033333 0.133487
+ 0.6036111 0.182817
+ 0.6038889 0.234557
+ 0.6041667 0.286280
+ 0.6044444 0.335561
+ 0.6047222 0.379975
+ 0.6050000 0.417095
+ 0.6052778 0.444496
+ 0.6055556 0.459752
+ 0.6058333 0.461166
+ 0.6061111 0.449961
+ 0.6063889 0.428085
+ 0.6066667 0.397490
+ 0.6069444 0.360124
+ 0.6072222 0.317938
+ 0.6075000 0.272883
+ 0.6077778 0.226908
+ 0.6080556 0.181964
+ 0.6083333 0.140000
+ 0.6086111 0.102716
+ 0.6088889 0.070803
+ 0.6091667 0.050000
+ 0.6094444 0.050000
+ 0.6097222 0.050000
+ 0.6100000 0.050000
+ 0.6102778 0.050000
+ 0.6105556 0.050000
+ 0.6108333 0.050000
+ 0.6111111 0.061785
+ 0.6113889 0.097598
+ 0.6116667 0.140446
+ 0.6119444 0.188022
+ 0.6122222 0.238022
+ 0.6125000 0.288139
+ 0.6127778 0.336069
+ 0.6130556 0.379505
+ 0.6133333 0.416144
+ 0.6136111 0.443678
+ 0.6138889 0.459804
+ 0.6141667 0.462895
+ 0.6144444 0.454049
+ 0.6147222 0.435042
+ 0.6150000 0.407652
+ 0.6152778 0.373656
+ 0.6155556 0.334830
+ 0.6158333 0.292953
+ 0.6161111 0.249800
+ 0.6163889 0.207149
+ 0.6166667 0.166778
+ 0.6169444 0.130258
+ 0.6172222 0.098347
+ 0.6175000 0.071597
+ 0.6177778 0.050560
+ 0.6180556 0.050000
+ 0.6183333 0.050000
+ 0.6186111 0.050000
+ 0.6188889 0.050000
+ 0.6191667 0.050409
+ 0.6194444 0.075252
+ 0.6197222 0.109193
+ 0.6200000 0.150375
+ 0.6202778 0.196459
+ 0.6205556 0.245107
+ 0.6208333 0.293978
+ 0.6211111 0.340736
+ 0.6213889 0.383040
+ 0.6216667 0.418552
+ 0.6219444 0.444932
+ 0.6222222 0.459843
+ 0.6225000 0.461642
+ 0.6227778 0.451471
+ 0.6230556 0.431173
+ 0.6233333 0.402587
+ 0.6236111 0.367553
+ 0.6238889 0.327912
+ 0.6241667 0.285505
+ 0.6244444 0.242170
+ 0.6247222 0.199750
+ 0.6250000 0.160083
+ 0.6252778 0.124777
+ 0.6255556 0.094499
+ 0.6258333 0.069682
+ 0.6261111 0.050762
+ 0.6263889 0.050000
+ 0.6266667 0.050000
+ 0.6269444 0.050000
+ 0.6272222 0.050000
+ 0.6275000 0.059772
+ 0.6277778 0.085333
+ 0.6280556 0.119382
+ 0.6283333 0.160132
+ 0.6286111 0.205356
+ 0.6288889 0.252822
+ 0.6291667 0.300302
+ 0.6294444 0.345565
+ 0.6297222 0.386383
+ 0.6300000 0.420526
+ 0.6302778 0.445765
+ 0.6305556 0.459869
+ 0.6308333 0.461275
+ 0.6311111 0.451080
+ 0.6313889 0.431048
+ 0.6316667 0.402940
+ 0.6319444 0.368519
+ 0.6322222 0.329549
+ 0.6325000 0.287793
+ 0.6327778 0.245012
+ 0.6330556 0.202970
+ 0.6333333 0.163431
+ 0.6336111 0.127944
+ 0.6338889 0.097215
+ 0.6341667 0.071739
+ 0.6344444 0.052009
+ 0.6347222 0.050000
+ 0.6350000 0.050000
+ 0.6352778 0.050000
+ 0.6355556 0.050000
+ 0.6358333 0.056831
+ 0.6361111 0.081947
+ 0.6363889 0.115804
+ 0.6366667 0.156593
+ 0.6369444 0.202041
+ 0.6372222 0.249877
+ 0.6375000 0.297830
+ 0.6377778 0.343629
+ 0.6380556 0.385001
+ 0.6383333 0.419675
+ 0.6386111 0.445379
+ 0.6388889 0.459843
+ 0.6391667 0.461468
+ 0.6394444 0.451351
+ 0.6397222 0.431261
+ 0.6400000 0.402969
+ 0.6402778 0.368244
+ 0.6405556 0.328857
+ 0.6408333 0.286578
+ 0.6411111 0.243175
+ 0.6413889 0.200421
+ 0.6416667 0.160083
+ 0.6419444 0.123726
+ 0.6422222 0.092084
+ 0.6425000 0.065682
+ 0.6427778 0.050000
+ 0.6430556 0.050000
+ 0.6433333 0.050000
+ 0.6436111 0.050000
+ 0.6438889 0.050000
+ 0.6441667 0.050000
+ 0.6444444 0.071918
+ 0.6447222 0.105956
+ 0.6450000 0.147161
+ 0.6452778 0.193242
+ 0.6455556 0.241906
+ 0.6458333 0.290862
+ 0.6461111 0.337819
+ 0.6463889 0.380484
+ 0.6466667 0.416567
+ 0.6469444 0.443775
+ 0.6472222 0.459817
+ 0.6475000 0.463073
+ 0.6477778 0.454608
+ 0.6480556 0.436161
+ 0.6483333 0.409469
+ 0.6486111 0.376270
+ 0.6488889 0.338300
+ 0.6491667 0.297298
+ 0.6494444 0.255001
+ 0.6497222 0.213146
+ 0.6500000 0.173472
+ 0.6502778 0.137519
+ 0.6505556 0.106039
+ 0.6508333 0.079589
+ 0.6511111 0.058726
+ 0.6513889 0.050000
+ 0.6516667 0.050000
+ 0.6519444 0.050000
+ 0.6522222 0.050000
+ 0.6525000 0.057657
+ 0.6527778 0.081986
+ 0.6530556 0.115314
+ 0.6533333 0.155807
+ 0.6536111 0.201147
+ 0.6538889 0.249022
+ 0.6541667 0.297115
+ 0.6544444 0.343112
+ 0.6547222 0.384698
+ 0.6550000 0.419559
+ 0.6552778 0.445379
+ 0.6555556 0.459843
+ 0.6558333 0.461323
+ 0.6561111 0.450934
+ 0.6563889 0.430478
+ 0.6566667 0.401757
+ 0.6569444 0.366571
+ 0.6572222 0.326723
+ 0.6575000 0.284014
+ 0.6577778 0.240245
+ 0.6580556 0.197219
+ 0.6583333 0.156736
+ 0.6586111 0.120383
+ 0.6588889 0.088878
+ 0.6591667 0.062727
+ 0.6594444 0.050000
+ 0.6597222 0.050000
+ 0.6600000 0.050000
+ 0.6602778 0.050000
+ 0.6605556 0.050000
+ 0.6608333 0.050000
+ 0.6611111 0.071892
+ 0.6613889 0.106243
+ 0.6616667 0.147688
+ 0.6619444 0.193938
+ 0.6622222 0.242701
+ 0.6625000 0.291689
+ 0.6627778 0.338609
+ 0.6630556 0.381172
+ 0.6633333 0.417088
+ 0.6636111 0.444067
+ 0.6638889 0.459817
+ 0.6641667 0.462720
+ 0.6644444 0.453840
+ 0.6647222 0.434911
+ 0.6650000 0.407668
+ 0.6652778 0.373847
+ 0.6655556 0.335182
+ 0.6658333 0.293407
+ 0.6661111 0.250259
+ 0.6663889 0.207471
+ 0.6666667 0.166778
+ 0.6669444 0.129727
+ 0.6672222 0.097112
+ 0.6675000 0.069539
+ 0.6677778 0.050000
+ 0.6680556 0.050000
+ 0.6683333 0.050000
+ 0.6686111 0.050000
+ 0.6688889 0.050000
+ 0.6691667 0.050000
+ 0.6694444 0.068558
+ 0.6697222 0.102619
+ 0.6700000 0.144176
+ 0.6702778 0.190841
+ 0.6705556 0.240224
+ 0.6708333 0.289936
+ 0.6711111 0.337587
+ 0.6713889 0.380787
+ 0.6716667 0.417147
+ 0.6719444 0.444278
+ 0.6722222 0.459791
+ 0.6725000 0.462002
+ 0.6727778 0.452054
+ 0.6730556 0.431798
+ 0.6733333 0.403082
+ 0.6736111 0.367758
+ 0.6738889 0.327674
+ 0.6741667 0.284680
+ 0.6744444 0.240626
+ 0.6747222 0.197361
+ 0.6750000 0.156736
+ 0.6752778 0.120373
+ 0.6755556 0.088984
+ 0.6758333 0.063056
+ 0.6761111 0.050000
+ 0.6763889 0.050000
+ 0.6766667 0.050000
+ 0.6769444 0.050000
+ 0.6772222 0.050000
+ 0.6775000 0.050000
+ 0.6777778 0.075252
+ 0.6780556 0.110025
+ 0.6783333 0.151818
+ 0.6786111 0.198307
+ 0.6788889 0.247164
+ 0.6791667 0.296066
+ 0.6794444 0.342685
+ 0.6797222 0.384697
+ 0.6800000 0.419775
+ 0.6802778 0.445595
+ 0.6805556 0.459830
+ 0.6808333 0.460852
+ 0.6811111 0.449817
+ 0.6813889 0.428581
+ 0.6816667 0.398998
+ 0.6819444 0.362922
+ 0.6822222 0.322206
+ 0.6825000 0.278706
+ 0.6827778 0.234276
+ 0.6830556 0.190770
+ 0.6833333 0.150042
+ 0.6836111 0.113714
+ 0.6838889 0.082484
+ 0.6841667 0.056815
+ 0.6844444 0.050000
+ 0.6847222 0.050000
+ 0.6850000 0.050000
+ 0.6852778 0.050000
+ 0.6855556 0.050000
+ 0.6858333 0.050000
+ 0.6861111 0.071853
+ 0.6863889 0.106930
+ 0.6866667 0.148978
+ 0.6869444 0.195695
+ 0.6872222 0.244774
+ 0.6875000 0.293911
+ 0.6877778 0.340803
+ 0.6880556 0.383143
+ 0.6883333 0.418629
+ 0.6886111 0.444955
+ 0.6888889 0.459817
+ 0.6891667 0.461596
+ 0.6894444 0.451417
+ 0.6897222 0.431090
+ 0.6900000 0.402426
+ 0.6902778 0.367235
+ 0.6905556 0.327327
+ 0.6908333 0.284513
+ 0.6911111 0.240603
+ 0.6913889 0.197407
+ 0.6916667 0.156736
+ 0.6919444 0.120185
+ 0.6922222 0.088488
+ 0.6925000 0.062163
+ 0.6927778 0.050000
+ 0.6930556 0.050000
+ 0.6933333 0.050000
+ 0.6936111 0.050000
+ 0.6938889 0.050000
+ 0.6941667 0.050000
+ 0.6944444 0.071853
+ 0.6947222 0.106688
+ 0.6950000 0.148687
+ 0.6952778 0.195492
+ 0.6955556 0.244747
+ 0.6958333 0.294095
+ 0.6961111 0.341179
+ 0.6963889 0.383644
+ 0.6966667 0.419132
+ 0.6969444 0.445287
+ 0.6972222 0.459752
+ 0.6975000 0.460874
+ 0.6977778 0.449815
+ 0.6980556 0.428442
+ 0.6983333 0.398618
+ 0.6986111 0.362210
+ 0.6988889 0.321083
+ 0.6991667 0.277102
+ 0.6994444 0.232134
+ 0.6997222 0.188042
+ 0.7000000 0.146694
+ 0.7002778 0.109726
+ 0.7005556 0.077855
+ 0.7008333 0.051572
+ 0.7011111 0.050000
+ 0.7013889 0.050000
+ 0.7016667 0.050000
+ 0.7019444 0.050000
+ 0.7022222 0.050000
+ 0.7025000 0.050000
+ 0.7027778 0.065171
+ 0.7030556 0.100741
+ 0.7033333 0.143459
+ 0.7036111 0.190968
+ 0.7038889 0.240913
+ 0.7041667 0.290936
+ 0.7044444 0.338683
+ 0.7047222 0.381795
+ 0.7050000 0.417917
+ 0.7052778 0.444692
+ 0.7055556 0.459765
+ 0.7058333 0.461476
+ 0.7061111 0.450961
+ 0.7063889 0.430053
+ 0.7066667 0.400586
+ 0.7069444 0.364392
+ 0.7072222 0.323305
+ 0.7075000 0.279159
+ 0.7077778 0.233786
+ 0.7080556 0.189020
+ 0.7083333 0.146694
+ 0.7086111 0.108433
+ 0.7088889 0.075023
+ 0.7091667 0.050000
+ 0.7094444 0.050000
+ 0.7097222 0.050000
+ 0.7100000 0.050000
+ 0.7102778 0.050000
+ 0.7105556 0.050000
+ 0.7108333 0.050000
+ 0.7111111 0.051717
+ 0.7113889 0.087465
+ 0.7116667 0.130830
+ 0.7119444 0.179376
+ 0.7122222 0.230669
+ 0.7125000 0.282274
+ 0.7127778 0.331756
+ 0.7130556 0.376681
+ 0.7133333 0.414614
+ 0.7136111 0.443120
+ 0.7138889 0.459765
+ 0.7141667 0.462828
+ 0.7144444 0.453451
+ 0.7147222 0.433491
+ 0.7150000 0.404804
+ 0.7152778 0.369247
+ 0.7155556 0.328677
+ 0.7158333 0.284949
+ 0.7161111 0.239921
+ 0.7163889 0.195449
+ 0.7166667 0.153389
+ 0.7169444 0.115383
+ 0.7172222 0.082210
+ 0.7175000 0.054433
+ 0.7177778 0.050000
+ 0.7180556 0.050000
+ 0.7183333 0.050000
+ 0.7186111 0.050000
+ 0.7188889 0.050000
+ 0.7191667 0.050000
+ 0.7194444 0.058464
+ 0.7197222 0.093663
+ 0.7200000 0.136365
+ 0.7202778 0.184169
+ 0.7205556 0.234669
+ 0.7208333 0.285464
+ 0.7211111 0.334150
+ 0.7213889 0.378324
+ 0.7216667 0.415582
+ 0.7219444 0.443521
+ 0.7222222 0.459738
+ 0.7225000 0.462539
+ 0.7227778 0.453061
+ 0.7230556 0.433150
+ 0.7233333 0.404652
+ 0.7236111 0.369414
+ 0.7238889 0.329282
+ 0.7241667 0.286102
+ 0.7244444 0.241721
+ 0.7247222 0.197983
+ 0.7250000 0.156736
+ 0.7252778 0.119607
+ 0.7255556 0.087348
+ 0.7258333 0.060492
+ 0.7261111 0.050000
+ 0.7263889 0.050000
+ 0.7266667 0.050000
+ 0.7269444 0.050000
+ 0.7272222 0.050000
+ 0.7275000 0.050000
+ 0.7277778 0.068558
+ 0.7280556 0.103628
+ 0.7283333 0.145975
+ 0.7286111 0.193208
+ 0.7288889 0.242935
+ 0.7291667 0.292766
+ 0.7294444 0.340310
+ 0.7297222 0.383175
+ 0.7300000 0.418971
+ 0.7302778 0.445306
+ 0.7305556 0.459791
+ 0.7308333 0.460746
+ 0.7311111 0.449347
+ 0.7313889 0.427483
+ 0.7316667 0.397041
+ 0.7319444 0.359909
+ 0.7322222 0.317977
+ 0.7325000 0.273131
+ 0.7327778 0.227261
+ 0.7330556 0.182255
+ 0.7333333 0.140000
+ 0.7336111 0.102156
+ 0.7338889 0.069466
+ 0.7341667 0.050000
+ 0.7344444 0.050000
+ 0.7347222 0.050000
+ 0.7350000 0.050000
+ 0.7352778 0.050000
+ 0.7355556 0.050000
+ 0.7358333 0.050000
+ 0.7361111 0.055090
+ 0.7363889 0.091401
+ 0.7366667 0.135073
+ 0.7369444 0.183693
+ 0.7372222 0.234845
+ 0.7375000 0.286117
+ 0.7377778 0.335094
+ 0.7380556 0.379362
+ 0.7383333 0.416509
+ 0.7386111 0.444118
+ 0.7388889 0.459778
+ 0.7391667 0.461788
+ 0.7394444 0.451312
+ 0.7397222 0.430228
+ 0.7400000 0.400413
+ 0.7402778 0.363746
+ 0.7405556 0.322104
+ 0.7408333 0.277365
+ 0.7411111 0.231407
+ 0.7413889 0.186109
+ 0.7416667 0.143347
+ 0.7419444 0.104782
+ 0.7422222 0.071199
+ 0.7425000 0.050000
+ 0.7427778 0.050000
+ 0.7430556 0.050000
+ 0.7433333 0.050000
+ 0.7436111 0.050000
+ 0.7438889 0.050000
+ 0.7441667 0.050000
+ 0.7444444 0.050000
+ 0.7447222 0.086289
+ 0.7450000 0.130201
+ 0.7452778 0.179266
+ 0.7455556 0.231018
+ 0.7458333 0.282988
+ 0.7461111 0.332708
+ 0.7463889 0.377711
+ 0.7466667 0.415529
+ 0.7469444 0.443694
+ 0.7472222 0.459738
+ 0.7475000 0.461927
+ 0.7477778 0.451455
+ 0.7480556 0.430251
+ 0.7483333 0.400245
+ 0.7486111 0.363364
+ 0.7488889 0.321538
+ 0.7491667 0.276694
+ 0.7494444 0.230762
+ 0.7497222 0.185670
+ 0.7500000 0.143347
+ 0.7502778 0.105483
+ 0.7505556 0.072815
+ 0.7508333 0.050000
+ 0.7511111 0.050000
+ 0.7513889 0.050000
+ 0.7516667 0.050000
+ 0.7519444 0.050000
+ 0.7522222 0.050000
+ 0.7525000 0.050000
+ 0.7527778 0.058477
+ 0.7530556 0.094567
+ 0.7533333 0.137950
+ 0.7536111 0.186227
+ 0.7538889 0.237000
+ 0.7541667 0.287871
+ 0.7544444 0.336442
+ 0.7547222 0.380313
+ 0.7550000 0.417088
+ 0.7552778 0.444366
+ 0.7555556 0.459752
+ 0.7558333 0.461556
+ 0.7561111 0.450940
+ 0.7563889 0.429773
+ 0.7566667 0.399926
+ 0.7569444 0.363272
+ 0.7572222 0.321679
+ 0.7575000 0.277019
+ 0.7577778 0.231163
+ 0.7580556 0.185983
+ 0.7583333 0.143347
+ 0.7586111 0.104910
+ 0.7588889 0.071448
+ 0.7591667 0.050000
+ 0.7594444 0.050000
+ 0.7597222 0.050000
+ 0.7600000 0.050000
+ 0.7602778 0.050000
+ 0.7605556 0.050000
+ 0.7608333 0.050000
+ 0.7611111 0.050000
+ 0.7613889 0.085991
+ 0.7616667 0.129564
+ 0.7619444 0.178291
+ 0.7622222 0.229745
+ 0.7625000 0.281497
+ 0.7627778 0.331119
+ 0.7630556 0.376185
+ 0.7633333 0.414267
+ 0.7636111 0.442936
+ 0.7638889 0.459765
+ 0.7641667 0.463036
+ 0.7644444 0.453876
+ 0.7647222 0.434121
+ 0.7650000 0.405606
+ 0.7652778 0.370168
+ 0.7655556 0.329642
+ 0.7658333 0.285865
+ 0.7661111 0.240673
+ 0.7663889 0.195903
+ 0.7666667 0.153389
+ 0.7669444 0.114764
+ 0.7672222 0.080841
+ 0.7675000 0.052228
+ 0.7677778 0.050000
+ 0.7680556 0.050000
+ 0.7683333 0.050000
+ 0.7686111 0.050000
+ 0.7688889 0.050000
+ 0.7691667 0.050000
+ 0.7694444 0.051756
+ 0.7697222 0.087029
+ 0.7700000 0.130039
+ 0.7702778 0.178346
+ 0.7705556 0.229508
+ 0.7708333 0.281083
+ 0.7711111 0.330630
+ 0.7713889 0.375708
+ 0.7716667 0.413876
+ 0.7719444 0.442691
+ 0.7722222 0.459712
+ 0.7725000 0.463211
+ 0.7727778 0.454309
+ 0.7730556 0.434840
+ 0.7733333 0.406638
+ 0.7736111 0.371537
+ 0.7738889 0.331371
+ 0.7741667 0.287974
+ 0.7744444 0.243179
+ 0.7747222 0.198822
+ 0.7750000 0.156736
+ 0.7752778 0.118549
+ 0.7755556 0.085067
+ 0.7758333 0.056888
+ 0.7761111 0.050000
+ 0.7763889 0.050000
+ 0.7766667 0.050000
+ 0.7769444 0.050000
+ 0.7772222 0.050000
+ 0.7775000 0.050000
+ 0.7777778 0.058477
+ 0.7780556 0.093791
+ 0.7783333 0.136740
+ 0.7786111 0.184864
+ 0.7788889 0.235698
+ 0.7791667 0.286781
+ 0.7794444 0.335651
+ 0.7797222 0.379845
+ 0.7800000 0.416901
+ 0.7802778 0.444358
+ 0.7805556 0.459752
+ 0.7808333 0.461352
+ 0.7811111 0.450355
+ 0.7813889 0.428686
+ 0.7816667 0.398271
+ 0.7819444 0.361037
+ 0.7822222 0.318910
+ 0.7825000 0.273816
+ 0.7827778 0.227683
+ 0.7830556 0.182435
+ 0.7833333 0.140000
+ 0.7836111 0.102065
+ 0.7838889 0.069360
+ 0.7841667 0.050000
+ 0.7844444 0.050000
+ 0.7847222 0.050000
+ 0.7850000 0.050000
+ 0.7852778 0.050000
+ 0.7855556 0.050000
+ 0.7858333 0.050000
+ 0.7861111 0.055090
+ 0.7863889 0.091132
+ 0.7866667 0.134467
+ 0.7869444 0.182729
+ 0.7872222 0.233551
+ 0.7875000 0.284568
+ 0.7877778 0.333412
+ 0.7880556 0.377718
+ 0.7883333 0.415118
+ 0.7886111 0.443247
+ 0.7888889 0.459738
+ 0.7891667 0.462918
+ 0.7894444 0.453883
+ 0.7897222 0.434425
+ 0.7900000 0.406333
+ 0.7902778 0.371399
+ 0.7905556 0.331411
+ 0.7908333 0.288160
+ 0.7911111 0.243437
+ 0.7913889 0.199033
+ 0.7916667 0.156736
+ 0.7919444 0.118146
+ 0.7922222 0.084094
+ 0.7925000 0.055220
+ 0.7927778 0.050000
+ 0.7930556 0.050000
+ 0.7933333 0.050000
+ 0.7936111 0.050000
+ 0.7938889 0.050000
+ 0.7941667 0.050000
+ 0.7944444 0.051782
+ 0.7947222 0.086832
+ 0.7950000 0.129715
+ 0.7952778 0.177973
+ 0.7955556 0.229148
+ 0.7958333 0.280781
+ 0.7961111 0.330411
+ 0.7963889 0.375581
+ 0.7966667 0.413832
+ 0.7969444 0.442704
+ 0.7972222 0.459738
+ 0.7975000 0.463196
+ 0.7977778 0.454209
+ 0.7980556 0.434633
+ 0.7983333 0.406320
+ 0.7986111 0.371123
+ 0.7988889 0.330895
+ 0.7991667 0.287489
+ 0.7994444 0.242758
+ 0.7997222 0.198557
+ 0.8000000 0.156736
+ 0.8002778 0.118935
+ 0.8005556 0.085930
+ 0.8008333 0.058281
+ 0.8011111 0.050000
+ 0.8013889 0.050000
+ 0.8016667 0.050000
+ 0.8019444 0.050000
+ 0.8022222 0.050000
+ 0.8025000 0.050000
+ 0.8027778 0.061863
+ 0.8030556 0.096776
+ 0.8033333 0.139145
+ 0.8036111 0.186581
+ 0.8038889 0.236693
+ 0.8041667 0.287093
+ 0.8044444 0.335390
+ 0.8047222 0.379195
+ 0.8050000 0.416119
+ 0.8052778 0.443772
+ 0.8055556 0.459765
+ 0.8058333 0.462408
+ 0.8061111 0.452816
+ 0.8063889 0.432803
+ 0.8066667 0.404185
+ 0.8069444 0.368777
+ 0.8072222 0.328392
+ 0.8075000 0.284846
+ 0.8077778 0.239953
+ 0.8080556 0.195530
+ 0.8083333 0.153389
+ 0.8086111 0.115145
+ 0.8088889 0.081603
+ 0.8091667 0.053369
+ 0.8094444 0.050000
+ 0.8097222 0.050000
+ 0.8100000 0.050000
+ 0.8102778 0.050000
+ 0.8105556 0.050000
+ 0.8108333 0.050000
+ 0.8111111 0.055130
+ 0.8113889 0.090611
+ 0.8116667 0.133772
+ 0.8119444 0.182150
+ 0.8122222 0.233278
+ 0.8125000 0.284692
+ 0.8127778 0.333929
+ 0.8130556 0.378523
+ 0.8133333 0.416010
+ 0.8136111 0.443925
+ 0.8138889 0.459804
+ 0.8141667 0.461921
+ 0.8144444 0.451507
+ 0.8147222 0.430530
+ 0.8150000 0.400961
+ 0.8152778 0.364769
+ 0.8155556 0.323923
+ 0.8158333 0.280393
+ 0.8161111 0.236147
+ 0.8163889 0.193156
+ 0.8166667 0.153389
+ 0.8169444 0.118540
+ 0.8172222 0.089208
+ 0.8175000 0.065717
+ 0.8177778 0.050000
+ 0.8180556 0.050000
+ 0.8183333 0.050000
+ 0.8186111 0.050000
+ 0.8188889 0.050000
+ 0.8191667 0.065527
+ 0.8194444 0.091975
+ 0.8197222 0.126438
+ 0.8200000 0.167172
+ 0.8202778 0.212018
+ 0.8205556 0.258820
+ 0.8208333 0.305420
+ 0.8211111 0.349660
+ 0.8213889 0.389383
+ 0.8216667 0.422430
+ 0.8219444 0.446645
+ 0.8222222 0.459869
+ 0.8225000 0.460599
+ 0.8227778 0.449947
+ 0.8230556 0.429677
+ 0.8233333 0.401554
+ 0.8236111 0.367345
+ 0.8238889 0.328814
+ 0.8241667 0.287727
+ 0.8244444 0.245848
+ 0.8247222 0.204943
+ 0.8250000 0.166778
+ 0.8252778 0.132892
+ 0.8255556 0.103923
+ 0.8258333 0.080284
+ 0.8261111 0.062389
+ 0.8263889 0.050650
+ 0.8266667 0.050000
+ 0.8269444 0.050000
+ 0.8272222 0.056499
+ 0.8275000 0.073513
+ 0.8277778 0.098748
+ 0.8280556 0.132182
+ 0.8283333 0.172059
+ 0.8286111 0.216184
+ 0.8288889 0.262368
+ 0.8291667 0.308418
+ 0.8294444 0.352143
+ 0.8297222 0.391350
+ 0.8300000 0.423848
+ 0.8302778 0.447444
+ 0.8305556 0.459948
+ 0.8308333 0.459837
+ 0.8311111 0.448275
+ 0.8313889 0.427093
+ 0.8316667 0.398125
+ 0.8319444 0.363202
+ 0.8322222 0.324159
+ 0.8325000 0.282828
+ 0.8327778 0.241041
+ 0.8330556 0.200631
+ 0.8333333 0.163431
+ 0.8336111 0.131014
+ 0.8338889 0.103919
+ 0.8341667 0.082422
+ 0.8344444 0.066803
+ 0.8347222 0.057339
+ 0.8350000 0.054308
+ 0.8352778 0.057989
+ 0.8355556 0.068660
+ 0.8358333 0.086599
+ 0.8361111 0.112085
+ 0.8363889 0.145011
+ 0.8366667 0.183741
+ 0.8369444 0.226253
+ 0.8372222 0.270527
+ 0.8375000 0.314541
+ 0.8377778 0.356275
+ 0.8380556 0.393708
+ 0.8383333 0.424818
+ 0.8386111 0.447584
+ 0.8388889 0.459987
+ 0.8391667 0.460618
+ 0.8394444 0.450528
+ 0.8397222 0.431381
+ 0.8400000 0.404840
+ 0.8402778 0.372570
+ 0.8405556 0.336234
+ 0.8408333 0.297497
+ 0.8411111 0.258022
+ 0.8413889 0.219473
+ 0.8416667 0.183514
+ 0.8419444 0.151596
+ 0.8422222 0.124313
+ 0.8425000 0.102050
+ 0.8427778 0.085186
+ 0.8430556 0.074105
+ 0.8433333 0.069188
+ 0.8436111 0.070817
+ 0.8438889 0.079375
+ 0.8441667 0.095244
+ 0.8444444 0.118805
+ 0.8447222 0.150040
+ 0.8450000 0.187321
+ 0.8452778 0.228622
+ 0.8455556 0.271916
+ 0.8458333 0.315174
+ 0.8461111 0.356370
+ 0.8463889 0.393475
+ 0.8466667 0.424462
+ 0.8469444 0.447304
+ 0.8472222 0.459974
+ 0.8475000 0.461052
+ 0.8477778 0.451557
+ 0.8480556 0.433116
+ 0.8483333 0.407356
+ 0.8486111 0.375904
+ 0.8488889 0.340387
+ 0.8491667 0.302432
+ 0.8494444 0.263665
+ 0.8497222 0.225715
+ 0.8500000 0.190208
+ 0.8502778 0.158566
+ 0.8505556 0.131390
+ 0.8508333 0.109076
+ 0.8511111 0.092020
+ 0.8513889 0.080617
+ 0.8516667 0.075263
+ 0.8519444 0.076354
+ 0.8522222 0.084286
+ 0.8525000 0.099455
+ 0.8527778 0.122257
+ 0.8530556 0.152690
+ 0.8533333 0.189164
+ 0.8536111 0.229692
+ 0.8538889 0.272288
+ 0.8541667 0.314963
+ 0.8544444 0.355731
+ 0.8547222 0.392604
+ 0.8550000 0.423596
+ 0.8552778 0.446719
+ 0.8555556 0.459987
+ 0.8558333 0.461995
+ 0.8561111 0.453674
+ 0.8563889 0.436537
+ 0.8566667 0.412099
+ 0.8569444 0.381872
+ 0.8572222 0.347372
+ 0.8575000 0.310111
+ 0.8577778 0.271603
+ 0.8580556 0.233363
+ 0.8583333 0.196903
+ 0.8586111 0.163580
+ 0.8588889 0.134118
+ 0.8591667 0.109086
+ 0.8594444 0.089049
+ 0.8597222 0.074575
+ 0.8600000 0.066231
+ 0.8602778 0.064584
+ 0.8605556 0.070200
+ 0.8608333 0.083649
+ 0.8611111 0.105495
+ 0.8613889 0.135856
+ 0.8616667 0.173045
+ 0.8619444 0.214925
+ 0.8622222 0.259359
+ 0.8625000 0.304210
+ 0.8627778 0.347341
+ 0.8630556 0.386615
+ 0.8633333 0.419894
+ 0.8636111 0.445042
+ 0.8638889 0.459922
+ 0.8641667 0.463022
+ 0.8644444 0.455338
+ 0.8647222 0.438492
+ 0.8650000 0.414105
+ 0.8652778 0.383800
+ 0.8655556 0.349198
+ 0.8658333 0.311920
+ 0.8661111 0.273588
+ 0.8663889 0.235824
+ 0.8666667 0.200250
+ 0.8669444 0.168291
+ 0.8672222 0.140588
+ 0.8675000 0.117586
+ 0.8677778 0.099730
+ 0.8680556 0.087464
+ 0.8683333 0.081232
+ 0.8686111 0.081481
+ 0.8688889 0.088654
+ 0.8691667 0.103196
+ 0.8694444 0.125552
+ 0.8697222 0.155750
+ 0.8700000 0.192151
+ 0.8702778 0.232700
+ 0.8705556 0.275342
+ 0.8708333 0.318020
+ 0.8711111 0.358680
+ 0.8713889 0.395266
+ 0.8716667 0.425722
+ 0.8719444 0.447994
+ 0.8722222 0.460026
+ 0.8725000 0.460374
+ 0.8727778 0.450043
+ 0.8730556 0.430647
+ 0.8733333 0.403804
+ 0.8736111 0.371128
+ 0.8738889 0.334236
+ 0.8741667 0.294743
+ 0.8744444 0.254265
+ 0.8747222 0.214419
+ 0.8750000 0.176819
+ 0.8752778 0.142898
+ 0.8755556 0.113349
+ 0.8758333 0.088680
+ 0.8761111 0.069401
+ 0.8763889 0.056021
+ 0.8766667 0.050000
+ 0.8769444 0.050000
+ 0.8772222 0.056362
+ 0.8775000 0.071666
+ 0.8777778 0.095414
+ 0.8780556 0.127665
+ 0.8783333 0.166681
+ 0.8786111 0.210275
+ 0.8788889 0.256259
+ 0.8791667 0.302447
+ 0.8794444 0.346651
+ 0.8797222 0.386684
+ 0.8800000 0.420358
+ 0.8802778 0.445487
+ 0.8805556 0.459882
+ 0.8808333 0.461992
+ 0.8811111 0.452800
+ 0.8813889 0.433928
+ 0.8816667 0.406993
+ 0.8819444 0.373616
+ 0.8822222 0.335416
+ 0.8825000 0.294013
+ 0.8827778 0.251026
+ 0.8830556 0.208074
+ 0.8833333 0.166778
+ 0.8836111 0.128607
+ 0.8838889 0.094434
+ 0.8841667 0.064982
+ 0.8844444 0.050000
+ 0.8847222 0.050000
+ 0.8850000 0.050000
+ 0.8852778 0.050000
+ 0.8855556 0.050000
+ 0.8858333 0.050000
+ 0.8861111 0.051795
+ 0.8863889 0.085632
+ 0.8866667 0.127534
+ 0.8869444 0.175056
+ 0.8872222 0.225754
+ 0.8875000 0.277184
+ 0.8877778 0.326900
+ 0.8880556 0.372460
+ 0.8883333 0.411418
+ 0.8886111 0.441330
+ 0.8888889 0.459752
+ 0.8891667 0.464934
+ 0.8894444 0.457913
+ 0.8897222 0.440420
+ 0.8900000 0.414184
+ 0.8902778 0.380937
+ 0.8905556 0.342411
+ 0.8908333 0.300335
+ 0.8911111 0.256442
+ 0.8913889 0.212462
+ 0.8916667 0.170125
+ 0.8919444 0.130995
+ 0.8922222 0.095964
+ 0.8925000 0.065753
+ 0.8927778 0.050000
+ 0.8930556 0.050000
+ 0.8933333 0.050000
+ 0.8936111 0.050000
+ 0.8938889 0.050000
+ 0.8941667 0.050000
+ 0.8944444 0.050000
+ 0.8947222 0.083856
+ 0.8950000 0.125855
+ 0.8952778 0.173537
+ 0.8955556 0.224440
+ 0.8958333 0.276103
+ 0.8961111 0.326064
+ 0.8963889 0.371861
+ 0.8966667 0.411034
+ 0.8969444 0.441121
+ 0.8972222 0.459660
+ 0.8975000 0.464892
+ 0.8977778 0.457864
+ 0.8980556 0.440325
+ 0.8983333 0.414022
+ 0.8986111 0.380706
+ 0.8988889 0.342125
+ 0.8991667 0.300028
+ 0.8994444 0.256163
+ 0.8997222 0.212279
+ 0.9000000 0.170125
+ 0.9002778 0.131277
+ 0.9005556 0.096616
+ 0.9008333 0.066852
+ 0.9011111 0.050000
+ 0.9013889 0.050000
+ 0.9016667 0.050000
+ 0.9019444 0.050000
+ 0.9022222 0.050000
+ 0.9025000 0.050000
+ 0.9027778 0.055169
+ 0.9030556 0.089566
+ 0.9033333 0.132016
+ 0.9036111 0.180005
+ 0.9038889 0.231017
+ 0.9041667 0.282537
+ 0.9044444 0.332050
+ 0.9047222 0.377040
+ 0.9050000 0.414993
+ 0.9052778 0.443393
+ 0.9055556 0.459725
+ 0.9058333 0.462212
+ 0.9061111 0.452024
+ 0.9063889 0.431071
+ 0.9066667 0.401263
+ 0.9069444 0.364508
+ 0.9072222 0.322714
+ 0.9075000 0.277793
+ 0.9077778 0.231652
+ 0.9080556 0.186200
+ 0.9083333 0.143347
+ 0.9086111 0.104774
+ 0.9088889 0.071252
+ 0.9091667 0.050000
+ 0.9094444 0.050000
+ 0.9097222 0.050000
+ 0.9100000 0.050000
+ 0.9102778 0.050000
+ 0.9105556 0.050000
+ 0.9108333 0.050000
+ 0.9111111 0.050000
+ 0.9113889 0.085858
+ 0.9116667 0.129251
+ 0.9119444 0.177779
+ 0.9122222 0.229043
+ 0.9125000 0.280643
+ 0.9127778 0.330181
+ 0.9130556 0.375256
+ 0.9133333 0.413469
+ 0.9136111 0.442421
+ 0.9138889 0.459712
+ 0.9141667 0.463641
+ 0.9144444 0.455289
+ 0.9147222 0.436439
+ 0.9150000 0.408871
+ 0.9152778 0.374365
+ 0.9155556 0.334701
+ 0.9158333 0.291661
+ 0.9161111 0.247024
+ 0.9163889 0.202571
+ 0.9166667 0.160083
+ 0.9169444 0.121156
+ 0.9172222 0.086644
+ 0.9175000 0.057218
+ 0.9177778 0.050000
+ 0.9180556 0.050000
+ 0.9183333 0.050000
+ 0.9186111 0.050000
+ 0.9188889 0.050000
+ 0.9191667 0.050000
+ 0.9194444 0.050000
+ 0.9197222 0.084886
+ 0.9200000 0.127741
+ 0.9202778 0.176085
+ 0.9205556 0.227434
+ 0.9208333 0.279307
+ 0.9211111 0.329222
+ 0.9213889 0.374697
+ 0.9216667 0.413250
+ 0.9219444 0.442398
+ 0.9222222 0.459660
+ 0.9225000 0.463275
+ 0.9227778 0.454364
+ 0.9230556 0.434772
+ 0.9233333 0.406342
+ 0.9236111 0.370917
+ 0.9238889 0.330341
+ 0.9241667 0.286457
+ 0.9244444 0.241108
+ 0.9247222 0.196137
+ 0.9250000 0.153389
+ 0.9252778 0.114502
+ 0.9255556 0.080303
+ 0.9258333 0.051411
+ 0.9261111 0.050000
+ 0.9263889 0.050000
+ 0.9266667 0.050000
+ 0.9269444 0.050000
+ 0.9272222 0.050000
+ 0.9275000 0.050000
+ 0.9277778 0.050000
+ 0.9280556 0.085430
+ 0.9283333 0.128672
+ 0.9286111 0.177258
+ 0.9288889 0.228719
+ 0.9291667 0.280588
+ 0.9294444 0.330397
+ 0.9297222 0.375678
+ 0.9300000 0.413963
+ 0.9302778 0.442784
+ 0.9305556 0.459673
+ 0.9308333 0.462883
+ 0.9311111 0.453550
+ 0.9313889 0.433529
+ 0.9316667 0.404676
+ 0.9319444 0.368848
+ 0.9322222 0.327901
+ 0.9325000 0.283691
+ 0.9327778 0.238073
+ 0.9330556 0.192905
+ 0.9333333 0.150042
+ 0.9336111 0.111133
+ 0.9338889 0.077002
+ 0.9341667 0.050000
+ 0.9344444 0.050000
+ 0.9347222 0.050000
+ 0.9350000 0.050000
+ 0.9352778 0.050000
+ 0.9355556 0.050000
+ 0.9358333 0.050000
+ 0.9361111 0.050000
+ 0.9363889 0.086110
+ 0.9366667 0.130028
+ 0.9369444 0.179230
+ 0.9372222 0.231193
+ 0.9375000 0.283394
+ 0.9377778 0.333310
+ 0.9380556 0.378418
+ 0.9383333 0.416194
+ 0.9386111 0.444116
+ 0.9388889 0.459660
+ 0.9391667 0.461054
+ 0.9394444 0.449529
+ 0.9397222 0.427065
+ 0.9400000 0.395644
+ 0.9402778 0.357247
+ 0.9405556 0.313855
+ 0.9408333 0.267449
+ 0.9411111 0.220010
+ 0.9413889 0.173519
+ 0.9416667 0.129958
+ 0.9419444 0.091066
+ 0.9422222 0.057618
+ 0.9425000 0.050000
+ 0.9427778 0.050000
+ 0.9430556 0.050000
+ 0.9433333 0.050000
+ 0.9436111 0.050000
+ 0.9438889 0.050000
+ 0.9441667 0.050000
+ 0.9444444 0.050000
+ 0.9447222 0.089007
+ 0.9450000 0.135581
+ 0.9452778 0.187046
+ 0.9455556 0.240725
+ 0.9458333 0.293944
+ 0.9461111 0.344024
+ 0.9463889 0.388291
+ 0.9466667 0.424069
+ 0.9469444 0.448681
+ 0.9472222 0.459451
+ 0.9475000 0.454556
+ 0.9477778 0.435582
+ 0.9480556 0.404969
+ 0.9483333 0.365158
+ 0.9486111 0.318586
+ 0.9488889 0.267693
+ 0.9491667 0.214920
+ 0.9494444 0.162705
+ 0.9497222 0.113488
+ 0.9500000 0.069708
+ 0.9502778 0.050000
+ 0.9505556 0.050000
+ 0.9508333 0.050000
+ 0.9511111 0.050000
+ 0.9513889 0.050000
+ 0.9516667 0.050000
+ 0.9519444 0.050000
+ 0.9522222 0.050000
+ 0.9525000 0.050000
+ 0.9527778 0.050000
+ 0.9530556 0.088501
+ 0.9533333 0.132394
+ 0.9536111 0.179859
+ 0.9538889 0.229075
+ 0.9541667 0.278222
+ 0.9544444 0.325479
+ 0.9547222 0.369026
+ 0.9550000 0.407042
+ 0.9552778 0.437708
+ 0.9555556 0.459202
+ 0.9558333 0.470186
+ 0.9561111 0.471246
+ 0.9563889 0.463447
+ 0.9566667 0.447858
+ 0.9569444 0.425544
+ 0.9572222 0.397573
+ 0.9575000 0.365013
+ 0.9577778 0.328929
+ 0.9580556 0.290388
+ 0.9583333 0.250458
+ 0.9586111 0.210247
+ 0.9588889 0.171023
+ 0.9591667 0.134096
+ 0.9594444 0.100778
+ 0.9597222 0.072377
+ 0.9600000 0.050205
+ 0.9602778 0.050000
+ 0.9605556 0.050000
+ 0.9608333 0.050000
+ 0.9611111 0.050000
+ 0.9613889 0.078007
+ 0.9616667 0.116419
+ 0.9619444 0.162864
+ 0.9622222 0.214969
+ 0.9625000 0.270360
+ 0.9627778 0.326665
+ 0.9630556 0.381510
+ 0.9633333 0.432522
+ 0.9636111 0.477328
+ 0.9638889 0.513556
+ 0.9641667 0.539467
+ 0.9644444 0.555873
+ 0.9647222 0.564219
+ 0.9650000 0.565952
+ 0.9652778 0.562517
+ 0.9655556 0.555361
+ 0.9658333 0.545929
+ 0.9661111 0.535669
+ 0.9663889 0.526026
+ 0.9666667 0.518446
+ 0.9669444 0.514026
+ 0.9672222 0.512469
+ 0.9675000 0.513128
+ 0.9677778 0.515355
+ 0.9680556 0.518504
+ 0.9683333 0.521927
+ 0.9686111 0.524978
+ 0.9688889 0.527010
+ 0.9691667 0.527375
+ 0.9694444 0.525428
+ 0.9697222 0.520799
+ 0.9700000 0.514240
+ 0.9702778 0.506780
+ 0.9705556 0.499447
+ 0.9708333 0.493273
+ 0.9711111 0.489285
+ 0.9713889 0.488513
+ 0.9716667 0.491988
+ 0.9719444 0.500737
+ 0.9722222 0.515791
+ 0.9725000 0.537576
+ 0.9727778 0.564100
+ 0.9730556 0.592770
+ 0.9733333 0.620991
+ 0.9736111 0.646169
+ 0.9738889 0.665709
+ 0.9741667 0.677018
+ 0.9744444 0.677501
+ 0.9747222 0.664564
+ 0.9750000 0.635612
+ 0.9752778 0.589206
+ 0.9755556 0.528531
+ 0.9758333 0.457923
+ 0.9761111 0.381722
+ 0.9763889 0.304265
+ 0.9766667 0.229892
+ 0.9769444 0.162941
+ 0.9772222 0.107749
+ 0.9775000 0.068656
+ 0.9777778 0.050000
+ 0.9780556 0.054639
+ 0.9783333 0.079514
+ 0.9786111 0.120084
+ 0.9788889 0.171809
+ 0.9791667 0.230150
+ 0.9794444 0.290566
+ 0.9797222 0.348517
+ 0.9800000 0.399464
+ 0.9802778 0.438866
+ 0.9805556 0.462184
+ 0.9808333 0.466128
+ 0.9811111 0.452414
+ 0.9813889 0.424009
+ 0.9816667 0.383880
+ 0.9819444 0.334992
+ 0.9822222 0.280314
+ 0.9825000 0.222812
+ 0.9827778 0.165452
+ 0.9830556 0.111202
+ 0.9833333 0.063027
+ 0.9836111 0.050000
+ 0.9838889 0.050000
+ 0.9841667 0.050000
+ 0.9844444 0.050000
+ 0.9847222 0.050000
+ 0.9850000 0.050000
+ 0.9852778 0.050000
+ 0.9855556 0.050000
+ 0.9858333 0.050000
+ 0.9861111 0.050000
+ 0.9863889 0.092622
+ 0.9866667 0.140685
+ 0.9869444 0.192007
+ 0.9872222 0.244407
+ 0.9875000 0.295703
+ 0.9877778 0.343716
+ 0.9880556 0.386262
+ 0.9883333 0.421162
+ 0.9886111 0.446233
+ 0.9888889 0.459294
+ 0.9891667 0.458845
+ 0.9894444 0.446106
+ 0.9897222 0.422980
+ 0.9900000 0.391367
+ 0.9902778 0.353169
+ 0.9905556 0.310288
+ 0.9908333 0.264625
+ 0.9911111 0.218081
+ 0.9913889 0.172558
+ 0.9916667 0.129958
+ 0.9919444 0.091949
+ 0.9922222 0.059267
+ 0.9925000 0.050000
+ 0.9927778 0.050000
+ 0.9930556 0.050000
+ 0.9933333 0.050000
+ 0.9936111 0.050000
+ 0.9938889 0.050000
+ 0.9941667 0.050000
+ 0.9944444 0.050000
+ 0.9947222 0.087419
+ 0.9950000 0.132222
+ 0.9952778 0.181934
+ 0.9955556 0.234082
+ 0.9958333 0.286192
+ 0.9961111 0.335790
+ 0.9963889 0.380402
+ 0.9966667 0.417553
+ 0.9969444 0.444771
+ 0.9972222 0.459582
+ 0.9975000 0.460256
+ 0.9977778 0.448048
+ 0.9980556 0.424958
+ 0.9983333 0.392986
+ 0.9986111 0.354131
+ 0.9988889 0.310393
+ 0.9991667 0.263773
+ 0.9994444 0.216269
+ 0.9997222 0.169882
+ 1.0000000 0.126611
+ 1.0002778 0.088201
+ 1.0005556 0.055376
+ 1.0008333 0.050000
+ 1.0011111 0.050000
+ 1.0013889 0.050000
+ 1.0016667 0.050000
+ 1.0019444 0.050000
+ 1.0022222 0.050000
+ 1.0025000 0.050000
+ 1.0027778 0.050000
+ 1.0030556 0.088011
+ 1.0033333 0.133328
+ 1.0036111 0.183456
+ 1.0038889 0.235903
+ 1.0041667 0.288174
+ 1.0044444 0.337777
+ 1.0047222 0.382218
+ 1.0050000 0.419003
+ 1.0052778 0.445640
+ 1.0055556 0.459634
+ 1.0058333 0.459253
+ 1.0061111 0.445808
+ 1.0063889 0.421371
+ 1.0066667 0.388014
+ 1.0069444 0.347809
+ 1.0072222 0.302827
+ 1.0075000 0.255140
+ 1.0077778 0.206820
+ 1.0080556 0.159939
+ 1.0083333 0.116569
+ 1.0086111 0.078500
+ 1.0088889 0.050000
+ 1.0091667 0.050000
+ 1.0094444 0.050000
+ 1.0097222 0.050000
+ 1.0100000 0.050000
+ 1.0102778 0.050000
+ 1.0105556 0.050000
+ 1.0108333 0.050000
+ 1.0111111 0.050000
+ 1.0113889 0.088261
+ 1.0116667 0.133519
+ 1.0119444 0.183374
+ 1.0122222 0.235427
+ 1.0125000 0.287280
+ 1.0127778 0.336534
+ 1.0130556 0.380790
+ 1.0133333 0.417649
+ 1.0136111 0.444712
+ 1.0138889 0.459582
+ 1.0141667 0.460581
+ 1.0144444 0.448929
+ 1.0147222 0.426568
+ 1.0150000 0.395439
+ 1.0152778 0.357486
+ 1.0155556 0.314648
+ 1.0158333 0.268870
+ 1.0161111 0.222092
+ 1.0163889 0.176256
+ 1.0166667 0.133306
+ 1.0169444 0.094941
+ 1.0172222 0.061908
+ 1.0175000 0.050000
+ 1.0177778 0.050000
+ 1.0180556 0.050000
+ 1.0183333 0.050000
+ 1.0186111 0.050000
+ 1.0188889 0.050000
+ 1.0191667 0.050000
+ 1.0194444 0.050000
+ 1.0197222 0.087122
+ 1.0200000 0.131651
+ 1.0202778 0.181129
+ 1.0205556 0.233097
+ 1.0208333 0.285097
+ 1.0211111 0.334672
+ 1.0213889 0.379362
+ 1.0216667 0.416709
+ 1.0219444 0.444256
+ 1.0222222 0.459542
+ 1.0225000 0.460847
+ 1.0227778 0.449392
+ 1.0230556 0.427135
+ 1.0233333 0.396033
+ 1.0236111 0.358043
+ 1.0238889 0.315124
+ 1.0241667 0.269233
+ 1.0244444 0.222328
+ 1.0247222 0.176366
+ 1.0250000 0.133306
+ 1.0252778 0.094861
+ 1.0255556 0.061774
+ 1.0258333 0.050000
+ 1.0261111 0.050000
+ 1.0263889 0.050000
+ 1.0266667 0.050000
+ 1.0269444 0.050000
+ 1.0272222 0.050000
+ 1.0275000 0.050000
+ 1.0277778 0.050000
+ 1.0280556 0.087150
+ 1.0283333 0.131701
+ 1.0286111 0.181195
+ 1.0288889 0.233173
+ 1.0291667 0.285178
+ 1.0294444 0.334751
+ 1.0297222 0.379435
+ 1.0300000 0.416771
+ 1.0302778 0.444302
+ 1.0305556 0.459569
+ 1.0308333 0.460850
+ 1.0311111 0.449369
+ 1.0313889 0.427087
+ 1.0316667 0.395963
+ 1.0319444 0.357957
+ 1.0322222 0.315030
+ 1.0325000 0.269141
+ 1.0327778 0.222251
+ 1.0330556 0.176319
+ 1.0333333 0.133306
+ 1.0336111 0.094926
+ 1.0338889 0.061916
+ 1.0341667 0.050000
+ 1.0344444 0.050000
+ 1.0347222 0.050000
+ 1.0350000 0.050000
+ 1.0352778 0.050000
+ 1.0355556 0.050000
+ 1.0358333 0.050000
+ 1.0361111 0.050000
+ 1.0363889 0.086905
+ 1.0366667 0.131173
+ 1.0369444 0.180380
+ 1.0372222 0.232103
+ 1.0375000 0.283922
+ 1.0377778 0.333411
+ 1.0380556 0.378150
+ 1.0383333 0.415715
+ 1.0386111 0.443684
+ 1.0388889 0.459634
+ 1.0391667 0.461860
+ 1.0394444 0.451532
+ 1.0397222 0.430536
+ 1.0400000 0.400758
+ 1.0402778 0.364086
+ 1.0405556 0.322407
+ 1.0408333 0.277606
+ 1.0411111 0.231572
+ 1.0413889 0.186190
+ 1.0416667 0.143347
+ 1.0419444 0.104711
+ 1.0422222 0.071070
+ 1.0425000 0.050000
+ 1.0427778 0.050000
+ 1.0430556 0.050000
+ 1.0433333 0.050000
+ 1.0436111 0.050000
+ 1.0438889 0.050000
+ 1.0441667 0.050000
+ 1.0444444 0.050000
+ 1.0447222 0.086395
+ 1.0450000 0.130423
+ 1.0452778 0.179600
+ 1.0455556 0.231447
+ 1.0458333 0.283481
+ 1.0461111 0.333222
+ 1.0463889 0.378187
+ 1.0466667 0.415897
+ 1.0469444 0.443868
+ 1.0472222 0.459621
+ 1.0475000 0.461411
+ 1.0477778 0.450443
+ 1.0480556 0.428662
+ 1.0483333 0.398011
+ 1.0486111 0.360433
+ 1.0488889 0.317871
+ 1.0491667 0.272268
+ 1.0494444 0.225569
+ 1.0497222 0.179716
+ 1.0500000 0.136653
+ 1.0502778 0.098085
+ 1.0505556 0.064773
+ 1.0508333 0.050000
+ 1.0511111 0.050000
+ 1.0513889 0.050000
+ 1.0516667 0.050000
+ 1.0519444 0.050000
+ 1.0522222 0.050000
+ 1.0525000 0.050000
+ 1.0527778 0.050000
+ 1.0530556 0.086943
+ 1.0533333 0.131364
+ 1.0536111 0.180793
+ 1.0538889 0.232762
+ 1.0541667 0.284801
+ 1.0544444 0.334441
+ 1.0547222 0.379212
+ 1.0550000 0.416645
+ 1.0552778 0.444271
+ 1.0555556 0.459621
+ 1.0558333 0.460963
+ 1.0561111 0.449523
+ 1.0563889 0.427261
+ 1.0566667 0.396142
+ 1.0569444 0.358126
+ 1.0572222 0.315178
+ 1.0575000 0.269259
+ 1.0577778 0.222333
+ 1.0580556 0.176361
+ 1.0583333 0.133306
+ 1.0586111 0.094885
+ 1.0588889 0.061838
+ 1.0591667 0.050000
+ 1.0594444 0.050000
+ 1.0597222 0.050000
+ 1.0600000 0.050000
+ 1.0602778 0.050000
+ 1.0605556 0.050000
+ 1.0608333 0.050000
+ 1.0611111 0.050000
+ 1.0613889 0.086992
+ 1.0616667 0.131358
+ 1.0619444 0.180663
+ 1.0622222 0.232472
+ 1.0625000 0.284351
+ 1.0627778 0.333866
+ 1.0630556 0.378582
+ 1.0633333 0.416065
+ 1.0636111 0.443881
+ 1.0638889 0.459595
+ 1.0641667 0.461497
+ 1.0644444 0.450775
+ 1.0647222 0.429342
+ 1.0650000 0.399108
+ 1.0652778 0.361988
+ 1.0655556 0.319892
+ 1.0658333 0.274733
+ 1.0661111 0.228423
+ 1.0663889 0.182875
+ 1.0666667 0.140000
+ 1.0669444 0.101482
+ 1.0672222 0.068088
+ 1.0675000 0.050000
+ 1.0677778 0.050000
+ 1.0680556 0.050000
+ 1.0683333 0.050000
+ 1.0686111 0.050000
+ 1.0688889 0.050000
+ 1.0691667 0.050000
+ 1.0694444 0.050000
+ 1.0697222 0.086450
+ 1.0700000 0.130423
+ 1.0702778 0.179475
+ 1.0705556 0.231158
+ 1.0708333 0.283029
+ 1.0711111 0.332641
+ 1.0713889 0.377550
+ 1.0716667 0.415308
+ 1.0719444 0.443472
+ 1.0722222 0.459595
+ 1.0725000 0.461954
+ 1.0727778 0.451719
+ 1.0730556 0.430780
+ 1.0733333 0.401027
+ 1.0736111 0.364354
+ 1.0738889 0.322649
+ 1.0741667 0.277805
+ 1.0744444 0.231713
+ 1.0747222 0.186263
+ 1.0750000 0.143347
+ 1.0752778 0.104637
+ 1.0755556 0.070924
+ 1.0758333 0.050000
+ 1.0761111 0.050000
+ 1.0763889 0.050000
+ 1.0766667 0.050000
+ 1.0769444 0.050000
+ 1.0772222 0.050000
+ 1.0775000 0.050000
+ 1.0777778 0.050000
+ 1.0780556 0.086572
+ 1.0783333 0.130799
+ 1.0786111 0.180177
+ 1.0788889 0.232201
+ 1.0791667 0.284366
+ 1.0794444 0.334167
+ 1.0797222 0.379099
+ 1.0800000 0.416658
+ 1.0802778 0.444338
+ 1.0805556 0.459634
+ 1.0808333 0.460791
+ 1.0811111 0.449052
+ 1.0813889 0.426410
+ 1.0816667 0.394856
+ 1.0819444 0.356382
+ 1.0822222 0.312982
+ 1.0825000 0.266647
+ 1.0827778 0.219370
+ 1.0830556 0.173143
+ 1.0833333 0.129958
+ 1.0836111 0.091554
+ 1.0838889 0.058655
+ 1.0841667 0.050000
+ 1.0844444 0.050000
+ 1.0847222 0.050000
+ 1.0850000 0.050000
+ 1.0852778 0.050000
+ 1.0855556 0.050000
+ 1.0858333 0.050000
+ 1.0861111 0.050000
+ 1.0863889 0.087299
+ 1.0866667 0.131899
+ 1.0869444 0.181366
+ 1.0872222 0.233268
+ 1.0875000 0.285172
+ 1.0877778 0.334645
+ 1.0880556 0.379256
+ 1.0883333 0.416570
+ 1.0886111 0.444157
+ 1.0888889 0.459582
+ 1.0891667 0.461140
+ 1.0894444 0.450032
+ 1.0897222 0.428189
+ 1.0900000 0.397536
+ 1.0902778 0.360005
+ 1.0905556 0.317522
+ 1.0908333 0.272017
+ 1.0911111 0.225418
+ 1.0913889 0.179654
+ 1.0916667 0.136653
+ 1.0919444 0.098111
+ 1.0922222 0.064791
+ 1.0925000 0.050000
+ 1.0927778 0.050000
+ 1.0930556 0.050000
+ 1.0933333 0.050000
+ 1.0936111 0.050000
+ 1.0938889 0.050000
+ 1.0941667 0.050000
+ 1.0944444 0.050000
+ 1.0947222 0.087084
+ 1.0950000 0.131679
+ 1.0952778 0.181289
+ 1.0955556 0.233423
+ 1.0958333 0.285588
+ 1.0961111 0.335289
+ 1.0963889 0.380033
+ 1.0966667 0.417328
+ 1.0969444 0.444679
+ 1.0972222 0.459595
+ 1.0975000 0.460331
+ 1.0977778 0.448146
+ 1.0980556 0.425050
+ 1.0983333 0.393051
+ 1.0986111 0.354159
+ 1.0988889 0.310383
+ 1.0991667 0.263730
+ 1.0994444 0.216212
+ 1.0997222 0.169836
+ 1.1000000 0.126611
+ 1.1002778 0.088287
+ 1.1005556 0.055575
+ 1.1008333 0.050000
+ 1.1011111 0.050000
+ 1.1013889 0.050000
+ 1.1016667 0.050000
+ 1.1019444 0.050000
+ 1.1022222 0.050000
+ 1.1025000 0.050000
+ 1.1027778 0.050000
+ 1.1030556 0.087601
+ 1.1033333 0.132438
+ 1.1036111 0.182078
+ 1.1038889 0.234087
+ 1.1041667 0.286031
+ 1.1044444 0.335477
+ 1.1047222 0.379991
+ 1.1050000 0.417140
+ 1.1052778 0.444490
+ 1.1055556 0.459608
+ 1.1058333 0.460790
+ 1.1061111 0.449257
+ 1.1063889 0.426959
+ 1.1066667 0.395847
+ 1.1069444 0.357871
+ 1.1072222 0.314982
+ 1.1075000 0.269130
+ 1.1077778 0.222267
+ 1.1080556 0.176342
+ 1.1083333 0.133306
+ 1.1086111 0.094868
+ 1.1088889 0.061775
+ 1.1091667 0.050000
+ 1.1094444 0.050000
+ 1.1097222 0.050000
+ 1.1100000 0.050000
+ 1.1102778 0.050000
+ 1.1105556 0.050000
+ 1.1108333 0.050000
+ 1.1111111 0.050000
+ 1.1113889 0.087224
+ 1.1116667 0.131866
+ 1.1119444 0.181455
+ 1.1122222 0.233522
+ 1.1125000 0.285597
+ 1.1127778 0.335210
+ 1.1130556 0.379891
+ 1.1133333 0.417171
+ 1.1136111 0.444580
+ 1.1138889 0.459647
+ 1.1141667 0.460645
+ 1.1144444 0.448813
+ 1.1147222 0.426132
+ 1.1150000 0.394582
+ 1.1152778 0.356144
+ 1.1155556 0.312799
+ 1.1158333 0.266527
+ 1.1161111 0.219309
+ 1.1163889 0.173126
+ 1.1166667 0.129958
+ 1.1169444 0.091537
+ 1.1172222 0.058593
+ 1.1175000 0.050000
+ 1.1177778 0.050000
+ 1.1180556 0.050000
+ 1.1183333 0.050000
+ 1.1186111 0.050000
+ 1.1188889 0.050000
+ 1.1191667 0.050000
+ 1.1194444 0.050000
+ 1.1197222 0.087524
+ 1.1200000 0.132391
+ 1.1202778 0.182133
+ 1.1205556 0.234282
+ 1.1208333 0.286372
+ 1.1211111 0.335934
+ 1.1213889 0.380503
+ 1.1216667 0.417610
+ 1.1219444 0.444787
+ 1.1222222 0.459569
+ 1.1225000 0.460230
+ 1.1227778 0.448023
+ 1.1230556 0.424944
+ 1.1233333 0.392989
+ 1.1236111 0.354152
+ 1.1238889 0.310431
+ 1.1241667 0.263821
+ 1.1244444 0.216317
+ 1.1247222 0.169915
+ 1.1250000 0.126611
+ 1.1252778 0.088148
+ 1.1255556 0.055257
+ 1.1258333 0.050000
+ 1.1261111 0.050000
+ 1.1263889 0.050000
+ 1.1266667 0.050000
+ 1.1269444 0.050000
+ 1.1272222 0.050000
+ 1.1275000 0.050000
+ 1.1277778 0.050000
+ 1.1280556 0.088240
+ 1.1283333 0.133823
+ 1.1286111 0.184222
+ 1.1288889 0.236910
+ 1.1291667 0.289361
+ 1.1294444 0.339048
+ 1.1297222 0.383444
+ 1.1300000 0.420023
+ 1.1302778 0.446257
+ 1.1305556 0.459621
+ 1.1308333 0.458364
+ 1.1311111 0.443845
+ 1.1313889 0.418199
+ 1.1316667 0.383563
+ 1.1319444 0.342071
+ 1.1322222 0.295860
+ 1.1325000 0.247064
+ 1.1327778 0.197820
+ 1.1330556 0.150262
+ 1.1333333 0.106528
+ 1.1336111 0.068452
+ 1.1338889 0.050000
+ 1.1341667 0.050000
+ 1.1344444 0.050000
+ 1.1347222 0.050000
+ 1.1350000 0.050000
+ 1.1352778 0.050000
+ 1.1355556 0.050000
+ 1.1358333 0.050000
+ 1.1361111 0.050000
+ 1.1363889 0.089741
+ 1.1366667 0.136362
+ 1.1369444 0.187386
+ 1.1372222 0.240334
+ 1.1375000 0.292727
+ 1.1377778 0.342088
+ 1.1380556 0.385937
+ 1.1383333 0.421797
+ 1.1386111 0.447188
+ 1.1388889 0.459634
+ 1.1391667 0.457428
+ 1.1394444 0.441957
+ 1.1397222 0.415381
+ 1.1400000 0.379859
+ 1.1402778 0.337553
+ 1.1405556 0.290621
+ 1.1408333 0.241223
+ 1.1411111 0.191519
+ 1.1413889 0.143669
+ 1.1416667 0.099833
+ 1.1419444 0.061863
+ 1.1422222 0.050000
+ 1.1425000 0.050000
+ 1.1427778 0.050000
+ 1.1430556 0.050000
+ 1.1433333 0.050000
+ 1.1436111 0.050000
+ 1.1438889 0.050000
+ 1.1441667 0.050000
+ 1.1444444 0.050000
+ 1.1447222 0.090644
+ 1.1450000 0.138090
+ 1.1452778 0.189814
+ 1.1455556 0.243291
+ 1.1458333 0.295994
+ 1.1461111 0.345399
+ 1.1463889 0.388981
+ 1.1466667 0.424213
+ 1.1469444 0.448571
+ 1.1472222 0.459529
+ 1.1475000 0.455366
+ 1.1477778 0.437571
+ 1.1480556 0.408439
+ 1.1483333 0.370263
+ 1.1486111 0.325338
+ 1.1488889 0.275956
+ 1.1491667 0.224413
+ 1.1494444 0.173002
+ 1.1497222 0.124016
+ 1.1500000 0.079750
+ 1.1502778 0.050000
+ 1.1505556 0.050000
+ 1.1508333 0.050000
+ 1.1511111 0.050000
+ 1.1513889 0.050000
+ 1.1516667 0.050000
+ 1.1519444 0.050000
+ 1.1522222 0.050000
+ 1.1525000 0.050000
+ 1.1527778 0.050000
+ 1.1530556 0.092312
+ 1.1533333 0.140995
+ 1.1536111 0.193548
+ 1.1538889 0.247468
+ 1.1541667 0.300254
+ 1.1544444 0.349405
+ 1.1547222 0.392417
+ 1.1550000 0.426790
+ 1.1552778 0.450020
+ 1.1555556 0.459608
+ 1.1558333 0.453861
+ 1.1561111 0.434338
+ 1.1563889 0.403405
+ 1.1566667 0.363432
+ 1.1569444 0.316786
+ 1.1572222 0.265836
+ 1.1575000 0.212951
+ 1.1577778 0.160497
+ 1.1580556 0.110845
+ 1.1583333 0.066361
+ 1.1586111 0.050000
+ 1.1588889 0.050000
+ 1.1591667 0.050000
+ 1.1594444 0.050000
+ 1.1597222 0.050000
+ 1.1600000 0.050000
+ 1.1602778 0.050000
+ 1.1605556 0.050000
+ 1.1608333 0.050000
+ 1.1611111 0.050000
+ 1.1613889 0.093513
+ 1.1616667 0.143133
+ 1.1619444 0.196357
+ 1.1622222 0.250682
+ 1.1625000 0.303605
+ 1.1627778 0.352624
+ 1.1630556 0.395235
+ 1.1633333 0.428936
+ 1.1636111 0.451223
+ 1.1638889 0.459595
+ 1.1641667 0.452373
+ 1.1644444 0.431183
+ 1.1647222 0.398477
+ 1.1650000 0.356705
+ 1.1652778 0.308319
+ 1.1655556 0.255771
+ 1.1658333 0.201511
+ 1.1661111 0.147990
+ 1.1663889 0.097660
+ 1.1666667 0.052972
+ 1.1669444 0.050000
+ 1.1672222 0.050000
+ 1.1675000 0.050000
+ 1.1677778 0.050000
+ 1.1680556 0.050000
+ 1.1683333 0.050000
+ 1.1686111 0.050000
+ 1.1688889 0.050000
+ 1.1691667 0.050000
+ 1.1694444 0.050000
+ 1.1697222 0.094463
+ 1.1700000 0.144724
+ 1.1702778 0.198317
+ 1.1705556 0.252776
+ 1.1708333 0.305632
+ 1.1711111 0.354420
+ 1.1713889 0.396673
+ 1.1716667 0.429924
+ 1.1719444 0.451707
+ 1.1722222 0.459555
+ 1.1725000 0.451823
+ 1.1727778 0.430148
+ 1.1730556 0.396991
+ 1.1733333 0.354811
+ 1.1736111 0.306069
+ 1.1738889 0.253223
+ 1.1741667 0.198733
+ 1.1744444 0.145060
+ 1.1747222 0.094662
+ 1.1750000 0.050000
+ 1.1752778 0.050000
+ 1.1755556 0.050000
+ 1.1758333 0.050000
+ 1.1761111 0.050000
+ 1.1763889 0.050000
+ 1.1766667 0.050000
+ 1.1769444 0.050000
+ 1.1772222 0.050000
+ 1.1775000 0.050000
+ 1.1777778 0.050000
+ 1.1780556 0.094661
+ 1.1783333 0.145057
+ 1.1786111 0.198729
+ 1.1788889 0.253217
+ 1.1791667 0.306064
+ 1.1794444 0.354810
+ 1.1797222 0.396995
+ 1.1800000 0.430160
+ 1.1802778 0.451846
+ 1.1805556 0.459595
+ 1.1808333 0.451767
+ 1.1811111 0.430005
+ 1.1813889 0.396775
+ 1.1816667 0.354539
+ 1.1819444 0.305763
+ 1.1822222 0.252909
+ 1.1825000 0.198441
+ 1.1827778 0.144825
+ 1.1830556 0.094523
+ 1.1833333 0.050000
+ 1.1836111 0.050000
+ 1.1838889 0.050000
+ 1.1841667 0.050000
+ 1.1844444 0.050000
+ 1.1847222 0.050000
+ 1.1850000 0.050000
+ 1.1852778 0.050000
+ 1.1855556 0.050000
+ 1.1858333 0.050000
+ 1.1861111 0.050000
+ 1.1863889 0.094018
+ 1.1866667 0.143670
+ 1.1869444 0.196588
+ 1.1872222 0.250405
+ 1.1875000 0.302752
+ 1.1877778 0.351261
+ 1.1880556 0.393566
+ 1.1883333 0.427297
+ 1.1886111 0.450087
+ 1.1888889 0.459569
+ 1.1891667 0.454148
+ 1.1894444 0.435332
+ 1.1897222 0.405403
+ 1.1900000 0.366643
+ 1.1902778 0.321333
+ 1.1905556 0.271755
+ 1.1908333 0.220191
+ 1.1911111 0.168924
+ 1.1913889 0.120233
+ 1.1916667 0.076403
+ 1.1919444 0.050000
+ 1.1922222 0.050000
+ 1.1925000 0.050000
+ 1.1927778 0.050000
+ 1.1930556 0.050000
+ 1.1933333 0.050000
+ 1.1936111 0.050000
+ 1.1938889 0.050000
+ 1.1941667 0.050000
+ 1.1944444 0.050000
+ 1.1947222 0.091519
+ 1.1950000 0.139199
+ 1.1952778 0.190683
+ 1.1955556 0.243614
+ 1.1958333 0.295634
+ 1.1961111 0.344388
+ 1.1963889 0.387517
+ 1.1966667 0.422666
+ 1.1969444 0.447478
+ 1.1972222 0.459595
+ 1.1975000 0.457403
+ 1.1977778 0.442257
+ 1.1980556 0.416256
+ 1.1983333 0.381498
+ 1.1986111 0.340080
+ 1.1988889 0.294101
+ 1.1991667 0.245658
+ 1.1994444 0.196849
+ 1.1997222 0.149773
+ 1.2000000 0.106528
+ 1.2002778 0.068914
+ 1.2005556 0.050000
+ 1.2008333 0.050000
+ 1.2011111 0.050000
+ 1.2013889 0.050000
+ 1.2016667 0.050000
+ 1.2019444 0.050000
+ 1.2022222 0.050000
+ 1.2025000 0.050000
+ 1.2027778 0.050000
+ 1.2030556 0.088834
+ 1.2033333 0.134438
+ 1.2036111 0.184451
+ 1.2038889 0.236514
+ 1.2041667 0.288266
+ 1.2044444 0.337346
+ 1.2047222 0.381396
+ 1.2050000 0.418053
+ 1.2052778 0.444958
+ 1.2055556 0.459752
+ 1.2058333 0.460790
+ 1.2061111 0.449302
+ 1.2063889 0.427233
+ 1.2066667 0.396531
+ 1.2069444 0.359142
+ 1.2072222 0.317011
+ 1.2075000 0.272085
+ 1.2077778 0.226310
+ 1.2080556 0.181633
+ 1.2083333 0.140000
+ 1.2086111 0.103103
+ 1.2088889 0.071617
+ 1.2091667 0.050000
+ 1.2094444 0.050000
+ 1.2097222 0.050000
+ 1.2100000 0.050000
+ 1.2102778 0.050000
+ 1.2105556 0.050000
+ 1.2108333 0.050000
+ 1.2111111 0.065171
+ 1.2113889 0.100920
+ 1.2116667 0.143591
+ 1.2119444 0.190897
+ 1.2122222 0.240554
+ 1.2125000 0.290274
+ 1.2127778 0.337773
+ 1.2130556 0.380763
+ 1.2133333 0.416961
+ 1.2136111 0.444078
+ 1.2138889 0.459830
+ 1.2141667 0.462608
+ 1.2144444 0.453513
+ 1.2147222 0.434325
+ 1.2150000 0.406820
+ 1.2152778 0.372780
+ 1.2155556 0.333981
+ 1.2158333 0.292202
+ 1.2161111 0.249223
+ 1.2163889 0.206822
+ 1.2166667 0.166778
+ 1.2169444 0.130660
+ 1.2172222 0.099204
+ 1.2175000 0.072937
+ 1.2177778 0.052386
+ 1.2180556 0.050000
+ 1.2183333 0.050000
+ 1.2186111 0.050000
+ 1.2188889 0.050000
+ 1.2191667 0.053796
+ 1.2194444 0.078599
+ 1.2197222 0.112334
+ 1.2200000 0.153173
+ 1.2202778 0.198817
+ 1.2205556 0.246970
+ 1.2208333 0.295331
+ 1.2211111 0.341603
+ 1.2213889 0.383487
+ 1.2216667 0.418685
+ 1.2219444 0.444899
+ 1.2222222 0.459830
+ 1.2225000 0.461864
+ 1.2227778 0.452121
+ 1.2230556 0.432406
+ 1.2233333 0.404524
+ 1.2236111 0.370279
+ 1.2238889 0.331476
+ 1.2241667 0.289920
+ 1.2244444 0.247415
+ 1.2247222 0.205766
+ 1.2250000 0.166778
+ 1.2252778 0.132027
+ 1.2255556 0.102176
+ 1.2258333 0.077661
+ 1.2261111 0.058916
+ 1.2263889 0.050000
+ 1.2266667 0.050000
+ 1.2269444 0.050000
+ 1.2272222 0.050354
+ 1.2275000 0.066993
+ 1.2277778 0.092014
+ 1.2280556 0.125414
+ 1.2283333 0.165432
+ 1.2286111 0.209869
+ 1.2288889 0.256526
+ 1.2291667 0.303202
+ 1.2294444 0.347699
+ 1.2297222 0.387818
+ 1.2300000 0.421359
+ 1.2302778 0.446122
+ 1.2305556 0.459908
+ 1.2308333 0.461179
+ 1.2311111 0.451033
+ 1.2313889 0.431232
+ 1.2316667 0.403536
+ 1.2319444 0.369704
+ 1.2322222 0.331497
+ 1.2325000 0.290676
+ 1.2327778 0.249000
+ 1.2330556 0.208229
+ 1.2333333 0.170125
+ 1.2336111 0.136223
+ 1.2338889 0.107161
+ 1.2341667 0.083356
+ 1.2344444 0.065221
+ 1.2347222 0.053171
+ 1.2350000 0.050000
+ 1.2352778 0.050000
+ 1.2355556 0.057682
+ 1.2358333 0.074122
+ 1.2361111 0.098722
+ 1.2363889 0.131471
+ 1.2366667 0.170660
+ 1.2369444 0.214155
+ 1.2372222 0.259822
+ 1.2375000 0.305526
+ 1.2377778 0.349134
+ 1.2380556 0.388512
+ 1.2383333 0.421525
+ 1.2386111 0.446040
+ 1.2388889 0.459922
+ 1.2391667 0.461672
+ 1.2394444 0.452336
+ 1.2397222 0.433593
+ 1.2400000 0.407125
+ 1.2402778 0.374611
+ 1.2405556 0.337731
+ 1.2408333 0.298167
+ 1.2411111 0.257598
+ 1.2413889 0.217704
+ 1.2416667 0.180167
+ 1.2419444 0.146464
+ 1.2422222 0.117265
+ 1.2425000 0.093041
+ 1.2427778 0.074258
+ 1.2430556 0.061387
+ 1.2433333 0.054895
+ 1.2436111 0.055251
+ 1.2438889 0.062924
+ 1.2441667 0.078383
+ 1.2444444 0.102095
+ 1.2447222 0.134094
+ 1.2450000 0.172666
+ 1.2452778 0.215661
+ 1.2455556 0.260930
+ 1.2458333 0.306322
+ 1.2461111 0.349688
+ 1.2463889 0.388878
+ 1.2466667 0.421743
+ 1.2469444 0.446132
+ 1.2472222 0.459895
+ 1.2475000 0.461524
+ 1.2477778 0.452068
+ 1.2480556 0.433217
+ 1.2483333 0.406661
+ 1.2486111 0.374090
+ 1.2488889 0.337194
+ 1.2491667 0.297664
+ 1.2494444 0.257190
+ 1.2497222 0.217460
+ 1.2500000 0.180167
+ 1.2502778 0.146791
+ 1.2505556 0.117986
+ 1.2508333 0.094197
+ 1.2511111 0.075867
+ 1.2513889 0.063444
+ 1.2516667 0.057371
+ 1.2519444 0.058093
+ 1.2522222 0.066056
+ 1.2525000 0.081704
+ 1.2527778 0.105482
+ 1.2530556 0.137407
+ 1.2533333 0.175782
+ 1.2536111 0.218481
+ 1.2538889 0.263379
+ 1.2541667 0.308351
+ 1.2544444 0.351271
+ 1.2547222 0.390013
+ 1.2550000 0.422453
+ 1.2552778 0.446464
+ 1.2555556 0.459922
+ 1.2558333 0.461330
+ 1.2561111 0.451717
+ 1.2563889 0.432738
+ 1.2566667 0.406050
+ 1.2569444 0.373310
+ 1.2572222 0.336175
+ 1.2575000 0.296302
+ 1.2577778 0.255347
+ 1.2580556 0.214967
+ 1.2583333 0.176819
+ 1.2586111 0.142370
+ 1.2588889 0.112322
+ 1.2591667 0.087190
+ 1.2594444 0.067487
+ 1.2597222 0.053725
+ 1.2600000 0.050000
+ 1.2602778 0.050000
+ 1.2605556 0.053226
+ 1.2608333 0.068366
+ 1.2611111 0.092014
+ 1.2613889 0.124235
+ 1.2616667 0.163294
+ 1.2619444 0.207008
+ 1.2622222 0.253193
+ 1.2625000 0.299666
+ 1.2627778 0.344243
+ 1.2630556 0.384741
+ 1.2633333 0.418975
+ 1.2636111 0.444764
+ 1.2638889 0.459922
+ 1.2641667 0.462903
+ 1.2644444 0.454709
+ 1.2647222 0.436980
+ 1.2650000 0.411353
+ 1.2652778 0.379467
+ 1.2655556 0.342961
+ 1.2658333 0.303474
+ 1.2661111 0.262645
+ 1.2663889 0.222112
+ 1.2666667 0.183514
+ 1.2669444 0.148314
+ 1.2672222 0.117272
+ 1.2675000 0.090971
+ 1.2677778 0.069997
+ 1.2680556 0.054933
+ 1.2683333 0.050000
+ 1.2686111 0.050000
+ 1.2688889 0.051042
+ 1.2691667 0.065459
+ 1.2694444 0.088706
+ 1.2697222 0.120893
+ 1.2700000 0.160225
+ 1.2702778 0.204434
+ 1.2705556 0.251251
+ 1.2708333 0.298407
+ 1.2711111 0.343632
+ 1.2713889 0.384659
+ 1.2716667 0.419218
+ 1.2719444 0.445040
+ 1.2722222 0.459856
+ 1.2725000 0.462068
+ 1.2727778 0.452755
+ 1.2730556 0.433670
+ 1.2733333 0.406561
+ 1.2736111 0.373181
+ 1.2738889 0.335279
+ 1.2741667 0.294607
+ 1.2744444 0.252915
+ 1.2747222 0.211953
+ 1.2750000 0.173472
+ 1.2752778 0.139009
+ 1.2755556 0.109239
+ 1.2758333 0.084623
+ 1.2761111 0.065624
+ 1.2763889 0.052702
+ 1.2766667 0.050000
+ 1.2769444 0.050000
+ 1.2772222 0.055014
+ 1.2775000 0.071015
+ 1.2777778 0.095401
+ 1.2780556 0.128190
+ 1.2783333 0.167635
+ 1.2786111 0.211544
+ 1.2788889 0.257727
+ 1.2791667 0.303994
+ 1.2794444 0.348155
+ 1.2797222 0.388018
+ 1.2800000 0.421394
+ 1.2802778 0.446092
+ 1.2805556 0.459922
+ 1.2808333 0.461344
+ 1.2811111 0.451426
+ 1.2813889 0.431887
+ 1.2816667 0.404446
+ 1.2819444 0.370823
+ 1.2822222 0.332735
+ 1.2825000 0.291902
+ 1.2827778 0.250044
+ 1.2830556 0.208878
+ 1.2833333 0.170125
+ 1.2836111 0.135298
+ 1.2838889 0.105092
+ 1.2841667 0.079998
+ 1.2844444 0.060506
+ 1.2847222 0.050000
+ 1.2850000 0.050000
+ 1.2852778 0.050000
+ 1.2855556 0.050000
+ 1.2858333 0.064237
+ 1.2861111 0.088654
+ 1.2863889 0.121654
+ 1.2866667 0.161475
+ 1.2869444 0.205902
+ 1.2872222 0.252721
+ 1.2875000 0.299719
+ 1.2877778 0.344681
+ 1.2880556 0.385394
+ 1.2883333 0.419643
+ 1.2886111 0.445215
+ 1.2888889 0.459895
+ 1.2891667 0.462123
+ 1.2894444 0.452949
+ 1.2897222 0.434077
+ 1.2900000 0.407208
+ 1.2902778 0.374047
+ 1.2905556 0.336298
+ 1.2908333 0.295662
+ 1.2911111 0.253844
+ 1.2913889 0.212546
+ 1.2916667 0.173472
+ 1.2919444 0.138131
+ 1.2922222 0.107254
+ 1.2925000 0.081376
+ 1.2927778 0.061035
+ 1.2930556 0.050000
+ 1.2933333 0.050000
+ 1.2936111 0.050000
+ 1.2938889 0.050000
+ 1.2941667 0.061151
+ 1.2944444 0.085294
+ 1.2947222 0.118261
+ 1.2950000 0.158258
+ 1.2952778 0.203022
+ 1.2955556 0.250291
+ 1.2958333 0.297803
+ 1.2961111 0.343296
+ 1.2963889 0.384507
+ 1.2966667 0.419174
+ 1.2969444 0.445036
+ 1.2972222 0.459830
+ 1.2975000 0.461963
+ 1.2977778 0.452516
+ 1.2980556 0.433240
+ 1.2983333 0.405885
+ 1.2986111 0.372201
+ 1.2988889 0.333940
+ 1.2991667 0.292852
+ 1.2994444 0.250686
+ 1.2997222 0.209194
+ 1.3000000 0.170125
+ 1.3002778 0.135022
+ 1.3005556 0.104588
+ 1.3008333 0.079319
+ 1.3011111 0.059711
+ 1.3013889 0.050000
+ 1.3016667 0.050000
+ 1.3019444 0.050000
+ 1.3022222 0.050000
+ 1.3025000 0.063920
+ 1.3027778 0.088680
+ 1.3030556 0.122109
+ 1.3033333 0.162400
+ 1.3036111 0.207288
+ 1.3038889 0.254507
+ 1.3041667 0.301790
+ 1.3044444 0.346871
+ 1.3047222 0.387484
+ 1.3050000 0.421364
+ 1.3052778 0.446243
+ 1.3055556 0.459856
+ 1.3058333 0.460613
+ 1.3061111 0.449624
+ 1.3063889 0.428678
+ 1.3066667 0.399562
+ 1.3069444 0.364064
+ 1.3072222 0.323970
+ 1.3075000 0.281068
+ 1.3077778 0.237146
+ 1.3080556 0.193990
+ 1.3083333 0.153389
+ 1.3086111 0.116917
+ 1.3088889 0.085299
+ 1.3091667 0.059046
+ 1.3094444 0.050000
+ 1.3097222 0.050000
+ 1.3100000 0.050000
+ 1.3102778 0.050000
+ 1.3105556 0.050000
+ 1.3108333 0.050000
+ 1.3111111 0.068532
+ 1.3113889 0.103169
+ 1.3116667 0.144960
+ 1.3119444 0.191597
+ 1.3122222 0.240772
+ 1.3125000 0.290176
+ 1.3127778 0.337502
+ 1.3130556 0.380441
+ 1.3133333 0.416685
+ 1.3136111 0.443926
+ 1.3138889 0.459856
+ 1.3141667 0.462844
+ 1.3144444 0.453970
+ 1.3147222 0.434991
+ 1.3150000 0.407664
+ 1.3152778 0.373745
+ 1.3155556 0.334992
+ 1.3158333 0.293162
+ 1.3161111 0.250011
+ 1.3163889 0.207298
+ 1.3166667 0.166778
+ 1.3169444 0.130012
+ 1.3172222 0.097772
+ 1.3175000 0.070635
+ 1.3177778 0.050000
+ 1.3180556 0.050000
+ 1.3183333 0.050000
+ 1.3186111 0.050000
+ 1.3188889 0.050000
+ 1.3191667 0.050000
+ 1.3194444 0.071905
+ 1.3197222 0.105826
+ 1.3200000 0.147102
+ 1.3202778 0.193381
+ 1.3205556 0.242310
+ 1.3208333 0.291535
+ 1.3211111 0.338705
+ 1.3213889 0.381466
+ 1.3216667 0.417464
+ 1.3219444 0.444348
+ 1.3222222 0.459765
+ 1.3225000 0.462055
+ 1.3227778 0.452339
+ 1.3230556 0.432431
+ 1.3233333 0.404145
+ 1.3236111 0.369295
+ 1.3238889 0.329695
+ 1.3241667 0.287160
+ 1.3244444 0.243503
+ 1.3247222 0.200540
+ 1.3250000 0.160083
+ 1.3252778 0.123731
+ 1.3255556 0.092210
+ 1.3258333 0.066032
+ 1.3261111 0.050000
+ 1.3263889 0.050000
+ 1.3266667 0.050000
+ 1.3269444 0.050000
+ 1.3272222 0.050000
+ 1.3275000 0.050000
+ 1.3277778 0.075252
+ 1.3280556 0.109718
+ 1.3283333 0.151281
+ 1.3286111 0.197612
+ 1.3288889 0.246383
+ 1.3291667 0.295263
+ 1.3294444 0.341924
+ 1.3297222 0.384036
+ 1.3300000 0.419271
+ 1.3302778 0.445299
+ 1.3305556 0.459791
+ 1.3308333 0.461110
+ 1.3311111 0.450388
+ 1.3313889 0.429449
+ 1.3316667 0.400118
+ 1.3319444 0.364219
+ 1.3322222 0.323575
+ 1.3325000 0.280011
+ 1.3327778 0.235351
+ 1.3330556 0.191420
+ 1.3333333 0.150042
+ 1.3336111 0.112824
+ 1.3338889 0.080509
+ 1.3341667 0.053626
+ 1.3344444 0.050000
+ 1.3347222 0.050000
+ 1.3350000 0.050000
+ 1.3352778 0.050000
+ 1.3355556 0.050000
+ 1.3358333 0.050000
+ 1.3361111 0.061785
+ 1.3363889 0.096846
+ 1.3366667 0.139210
+ 1.3369444 0.186535
+ 1.3372222 0.236477
+ 1.3375000 0.286691
+ 1.3377778 0.334835
+ 1.3380556 0.378565
+ 1.3383333 0.415536
+ 1.3386111 0.443406
+ 1.3388889 0.459830
+ 1.3391667 0.463150
+ 1.3394444 0.454443
+ 1.3397222 0.435474
+ 1.3400000 0.408005
+ 1.3402778 0.373800
+ 1.3405556 0.334621
+ 1.3408333 0.292231
+ 1.3411111 0.248394
+ 1.3413889 0.204873
+ 1.3416667 0.163431
+ 1.3419444 0.125641
+ 1.3422222 0.092319
+ 1.3425000 0.064094
+ 1.3427778 0.050000
+ 1.3430556 0.050000
+ 1.3433333 0.050000
+ 1.3436111 0.050000
+ 1.3438889 0.050000
+ 1.3441667 0.050000
+ 1.3444444 0.061824
+ 1.3447222 0.096410
+ 1.3450000 0.138665
+ 1.3452778 0.186145
+ 1.3455556 0.236411
+ 1.3458333 0.287020
+ 1.3461111 0.335532
+ 1.3463889 0.379505
+ 1.3466667 0.416497
+ 1.3469444 0.444069
+ 1.3472222 0.459778
+ 1.3475000 0.461905
+ 1.3477778 0.451624
+ 1.3480556 0.430828
+ 1.3483333 0.401414
+ 1.3486111 0.365275
+ 1.3488889 0.324307
+ 1.3491667 0.280405
+ 1.3494444 0.235463
+ 1.3497222 0.191377
+ 1.3500000 0.150042
+ 1.3502778 0.113115
+ 1.3505556 0.081312
+ 1.3508333 0.055108
+ 1.3511111 0.050000
+ 1.3513889 0.050000
+ 1.3516667 0.050000
+ 1.3519444 0.050000
+ 1.3522222 0.050000
+ 1.3525000 0.050000
+ 1.3527778 0.068545
+ 1.3530556 0.103844
+ 1.3533333 0.146223
+ 1.3536111 0.193345
+ 1.3538889 0.242876
+ 1.3541667 0.292477
+ 1.3544444 0.339813
+ 1.3547222 0.382547
+ 1.3550000 0.418343
+ 1.3552778 0.444866
+ 1.3555556 0.459778
+ 1.3558333 0.461437
+ 1.3561111 0.450975
+ 1.3563889 0.430218
+ 1.3566667 0.400992
+ 1.3569444 0.365123
+ 1.3572222 0.324437
+ 1.3575000 0.280760
+ 1.3577778 0.235918
+ 1.3580556 0.191736
+ 1.3583333 0.150042
+ 1.3586111 0.112446
+ 1.3588889 0.079711
+ 1.3591667 0.052383
+ 1.3594444 0.050000
+ 1.3597222 0.050000
+ 1.3600000 0.050000
+ 1.3602778 0.050000
+ 1.3605556 0.050000
+ 1.3608333 0.050000
+ 1.3611111 0.058477
+ 1.3613889 0.093629
+ 1.3616667 0.136200
+ 1.3619444 0.183823
+ 1.3622222 0.234131
+ 1.3625000 0.284756
+ 1.3627778 0.333332
+ 1.3630556 0.377490
+ 1.3633333 0.414865
+ 1.3636111 0.443087
+ 1.3638889 0.459791
+ 1.3641667 0.463299
+ 1.3644444 0.454700
+ 1.3647222 0.435771
+ 1.3650000 0.408291
+ 1.3652778 0.374039
+ 1.3655556 0.334792
+ 1.3658333 0.292329
+ 1.3661111 0.248429
+ 1.3663889 0.204870
+ 1.3666667 0.163431
+ 1.3669444 0.125694
+ 1.3672222 0.092463
+ 1.3675000 0.064347
+ 1.3677778 0.050000
+ 1.3680556 0.050000
+ 1.3683333 0.050000
+ 1.3686111 0.050000
+ 1.3688889 0.050000
+ 1.3691667 0.050000
+ 1.3694444 0.061863
+ 1.3697222 0.096073
+ 1.3700000 0.137881
+ 1.3702778 0.184903
+ 1.3705556 0.234755
+ 1.3708333 0.285052
+ 1.3711111 0.333411
+ 1.3713889 0.377445
+ 1.3716667 0.414772
+ 1.3719444 0.443007
+ 1.3722222 0.459765
+ 1.3725000 0.463357
+ 1.3727778 0.454875
+ 1.3730556 0.436106
+ 1.3733333 0.408836
+ 1.3736111 0.374853
+ 1.3738889 0.335944
+ 1.3741667 0.293895
+ 1.3744444 0.250493
+ 1.3747222 0.207525
+ 1.3750000 0.166778
+ 1.3752778 0.129836
+ 1.3755556 0.097473
+ 1.3758333 0.070260
+ 1.3761111 0.050000
+ 1.3763889 0.050000
+ 1.3766667 0.050000
+ 1.3769444 0.050000
+ 1.3772222 0.050000
+ 1.3775000 0.050000
+ 1.3777778 0.071918
+ 1.3780556 0.105967
+ 1.3783333 0.147370
+ 1.3786111 0.193765
+ 1.3788889 0.242789
+ 1.3791667 0.292078
+ 1.3794444 0.339271
+ 1.3797222 0.382004
+ 1.3800000 0.417914
+ 1.3802778 0.444640
+ 1.3805556 0.459817
+ 1.3808333 0.461780
+ 1.3811111 0.451650
+ 1.3813889 0.431245
+ 1.3816667 0.402382
+ 1.3819444 0.366879
+ 1.3822222 0.326554
+ 1.3825000 0.283225
+ 1.3827778 0.238709
+ 1.3830556 0.194825
+ 1.3833333 0.153389
+ 1.3836111 0.116008
+ 1.3838889 0.083441
+ 1.3841667 0.056235
+ 1.3844444 0.050000
+ 1.3847222 0.050000
+ 1.3850000 0.050000
+ 1.3852778 0.050000
+ 1.3855556 0.050000
+ 1.3858333 0.050000
+ 1.3861111 0.061837
+ 1.3863889 0.096724
+ 1.3866667 0.138990
+ 1.3869444 0.186277
+ 1.3872222 0.236227
+ 1.3875000 0.286483
+ 1.3877778 0.334688
+ 1.3880556 0.378482
+ 1.3883333 0.415509
+ 1.3886111 0.443411
+ 1.3888889 0.459830
+ 1.3891667 0.463098
+ 1.3894444 0.454306
+ 1.3897222 0.435233
+ 1.3900000 0.407661
+ 1.3902778 0.373369
+ 1.3905556 0.334139
+ 1.3908333 0.291749
+ 1.3911111 0.247981
+ 1.3913889 0.204615
+ 1.3916667 0.163431
+ 1.3919444 0.126011
+ 1.3922222 0.093145
+ 1.3925000 0.065426
+ 1.3927778 0.050000
+ 1.3930556 0.050000
+ 1.3933333 0.050000
+ 1.3936111 0.050000
+ 1.3938889 0.050000
+ 1.3941667 0.050000
+ 1.3944444 0.065197
+ 1.3947222 0.099459
+ 1.3950000 0.141221
+ 1.3952778 0.188106
+ 1.3955556 0.237731
+ 1.3958333 0.287719
+ 1.3961111 0.335689
+ 1.3963889 0.379260
+ 1.3966667 0.416055
+ 1.3969444 0.443691
+ 1.3972222 0.459791
+ 1.3975000 0.462674
+ 1.3977778 0.453465
+ 1.3980556 0.433988
+ 1.3983333 0.406068
+ 1.3986111 0.371530
+ 1.3988889 0.332199
+ 1.3991667 0.289898
+ 1.3994444 0.246454
+ 1.3997222 0.203690
+ 1.4000000 0.163431
+ 1.4002778 0.127280
+ 1.4005556 0.095956
+ 1.4008333 0.069954
+ 1.4011111 0.050000
+ 1.4013889 0.050000
+ 1.4016667 0.050000
+ 1.4019444 0.050000
+ 1.4022222 0.050000
+ 1.4025000 0.053512
+ 1.4027778 0.078665
+ 1.4030556 0.112648
+ 1.4033333 0.153639
+ 1.4036111 0.199357
+ 1.4038889 0.247515
+ 1.4041667 0.295831
+ 1.4044444 0.342020
+ 1.4047222 0.383798
+ 1.4050000 0.418882
+ 1.4052778 0.444987
+ 1.4055556 0.459830
+ 1.4058333 0.461800
+ 1.4061111 0.451982
+ 1.4063889 0.432135
+ 1.4066667 0.404016
+ 1.4069444 0.369385
+ 1.4072222 0.329999
+ 1.4075000 0.287618
+ 1.4077778 0.243999
+ 1.4080556 0.200901
+ 1.4083333 0.160083
+ 1.4086111 0.123104
+ 1.4088889 0.090728
+ 1.4091667 0.063519
+ 1.4094444 0.050000
+ 1.4097222 0.050000
+ 1.4100000 0.050000
+ 1.4102778 0.050000
+ 1.4105556 0.050000
+ 1.4108333 0.050000
+ 1.4111111 0.065197
+ 1.4113889 0.099184
+ 1.4116667 0.140548
+ 1.4119444 0.186978
+ 1.4122222 0.236165
+ 1.4125000 0.285799
+ 1.4127778 0.333570
+ 1.4130556 0.377168
+ 1.4133333 0.414284
+ 1.4136111 0.442608
+ 1.4138889 0.459830
+ 1.4141667 0.464307
+ 1.4144444 0.457064
+ 1.4147222 0.439791
+ 1.4150000 0.414182
+ 1.4152778 0.381927
+ 1.4155556 0.344717
+ 1.4158333 0.304245
+ 1.4161111 0.262201
+ 1.4163889 0.220278
+ 1.4166667 0.180167
+ 1.4169444 0.143383
+ 1.4172222 0.110741
+ 1.4175000 0.082878
+ 1.4177778 0.060434
+ 1.4180556 0.050000
+ 1.4183333 0.050000
+ 1.4186111 0.050000
+ 1.4188889 0.050000
+ 1.4191667 0.051823
+ 1.4194444 0.075291
+ 1.4197222 0.108146
+ 1.4200000 0.148530
+ 1.4202778 0.194085
+ 1.4205556 0.242455
+ 1.4208333 0.291282
+ 1.4211111 0.338209
+ 1.4213889 0.380880
+ 1.4216667 0.416936
+ 1.4219444 0.444021
+ 1.4222222 0.459778
+ 1.4225000 0.462540
+ 1.4227778 0.453405
+ 1.4230556 0.434164
+ 1.4233333 0.406605
+ 1.4236111 0.372518
+ 1.4238889 0.333691
+ 1.4241667 0.291914
+ 1.4244444 0.248977
+ 1.4247222 0.206668
+ 1.4250000 0.166778
+ 1.4252778 0.130882
+ 1.4255556 0.099707
+ 1.4258333 0.073768
+ 1.4261111 0.053579
+ 1.4263889 0.050000
+ 1.4266667 0.050000
+ 1.4269444 0.050000
+ 1.4272222 0.050000
+ 1.4275000 0.056869
+ 1.4277778 0.081973
+ 1.4280556 0.115953
+ 1.4283333 0.156963
+ 1.4286111 0.202684
+ 1.4288889 0.250797
+ 1.4291667 0.298983
+ 1.4294444 0.344923
+ 1.4297222 0.386300
+ 1.4300000 0.420793
+ 1.4302778 0.446085
+ 1.4305556 0.459856
+ 1.4308333 0.460491
+ 1.4311111 0.449186
+ 1.4313889 0.427838
+ 1.4316667 0.398348
+ 1.4319444 0.362614
+ 1.4322222 0.322534
+ 1.4325000 0.280008
+ 1.4327778 0.236933
+ 1.4330556 0.195210
+ 1.4333333 0.156736
+ 1.4336111 0.123144
+ 1.4338889 0.095001
+ 1.4341667 0.072605
+ 1.4344444 0.056259
+ 1.4347222 0.050000
+ 1.4350000 0.050000
+ 1.4352778 0.050000
+ 1.4355556 0.057354
+ 1.4358333 0.075748
+ 1.4361111 0.101991
+ 1.4363889 0.135979
+ 1.4366667 0.176004
+ 1.4369444 0.219952
+ 1.4372222 0.265710
+ 1.4375000 0.311168
+ 1.4377778 0.354211
+ 1.4380556 0.392729
+ 1.4383333 0.424608
+ 1.4386111 0.447736
+ 1.4388889 0.460000
+ 1.4391667 0.459938
+ 1.4394444 0.448687
+ 1.4397222 0.428031
+ 1.4400000 0.399757
+ 1.4402778 0.365650
+ 1.4405556 0.327496
+ 1.4408333 0.287080
+ 1.4411111 0.246190
+ 1.4413889 0.206609
+ 1.4416667 0.170125
+ 1.4419444 0.138273
+ 1.4422222 0.111590
+ 1.4425000 0.090365
+ 1.4427778 0.074886
+ 1.4430556 0.065439
+ 1.4433333 0.062314
+ 1.4436111 0.065797
+ 1.4438889 0.076177
+ 1.4441667 0.093742
+ 1.4444444 0.118779
+ 1.4447222 0.151193
+ 1.4450000 0.189354
+ 1.4452778 0.231250
+ 1.4455556 0.274866
+ 1.4458333 0.318191
+ 1.4461111 0.359212
+ 1.4463889 0.395914
+ 1.4466667 0.426286
+ 1.4469444 0.448315
+ 1.4472222 0.459987
+ 1.4475000 0.459909
+ 1.4477778 0.449163
+ 1.4480556 0.429454
+ 1.4483333 0.402483
+ 1.4486111 0.369953
+ 1.4488889 0.333567
+ 1.4491667 0.295027
+ 1.4494444 0.256037
+ 1.4497222 0.218298
+ 1.4500000 0.183514
+ 1.4502778 0.153150
+ 1.4505556 0.127723
+ 1.4508333 0.107512
+ 1.4511111 0.092799
+ 1.4513889 0.083863
+ 1.4516667 0.080984
+ 1.4519444 0.084441
+ 1.4522222 0.094515
+ 1.4525000 0.111486
+ 1.4527778 0.135633
+ 1.4530556 0.166863
+ 1.4533333 0.203590
+ 1.4536111 0.243854
+ 1.4538889 0.285693
+ 1.4541667 0.327149
+ 1.4544444 0.366260
+ 1.4547222 0.401068
+ 1.4550000 0.429611
+ 1.4552778 0.449931
+ 1.4555556 0.460065
+ 1.4558333 0.458666
+ 1.4561111 0.446823
+ 1.4563889 0.426236
+ 1.4566667 0.398607
+ 1.4569444 0.365635
+ 1.4572222 0.329022
+ 1.4575000 0.290468
+ 1.4577778 0.251674
+ 1.4580556 0.214340
+ 1.4583333 0.180167
+ 1.4586111 0.150607
+ 1.4588889 0.126125
+ 1.4591667 0.106935
+ 1.4594444 0.093253
+ 1.4597222 0.085296
+ 1.4600000 0.083278
+ 1.4602778 0.087415
+ 1.4605556 0.097923
+ 1.4608333 0.115018
+ 1.4611111 0.138915
+ 1.4613889 0.169490
+ 1.4616667 0.205263
+ 1.4619444 0.244412
+ 1.4622222 0.285116
+ 1.4625000 0.325557
+ 1.4627778 0.363912
+ 1.4630556 0.398361
+ 1.4633333 0.427083
+ 1.4636111 0.448258
+ 1.4638889 0.460065
+ 1.4641667 0.461229
+ 1.4644444 0.452650
+ 1.4647222 0.435777
+ 1.4650000 0.412056
+ 1.4652778 0.382934
+ 1.4655556 0.349857
+ 1.4658333 0.314273
+ 1.4661111 0.277629
+ 1.4663889 0.241370
+ 1.4666667 0.206945
+ 1.4669444 0.175643
+ 1.4672222 0.148130
+ 1.4675000 0.124917
+ 1.4677778 0.106512
+ 1.4680556 0.093426
+ 1.4683333 0.086167
+ 1.4686111 0.085246
+ 1.4688889 0.091172
+ 1.4691667 0.104455
+ 1.4694444 0.125604
+ 1.4697222 0.154708
+ 1.4700000 0.190165
+ 1.4702778 0.229956
+ 1.4705556 0.272058
+ 1.4708333 0.314449
+ 1.4711111 0.355109
+ 1.4713889 0.392016
+ 1.4716667 0.423147
+ 1.4719444 0.446483
+ 1.4722222 0.460000
+ 1.4725000 0.462271
+ 1.4727778 0.454240
+ 1.4730556 0.437444
+ 1.4733333 0.413421
+ 1.4736111 0.383708
+ 1.4738889 0.349842
+ 1.4741667 0.313360
+ 1.4744444 0.275801
+ 1.4747222 0.238701
+ 1.4750000 0.203597
+ 1.4752778 0.171853
+ 1.4755556 0.144130
+ 1.4758333 0.120917
+ 1.4761111 0.102700
+ 1.4763889 0.089968
+ 1.4766667 0.083208
+ 1.4769444 0.082908
+ 1.4772222 0.089556
+ 1.4775000 0.103638
+ 1.4777778 0.125644
+ 1.4780556 0.155631
+ 1.4783333 0.191944
+ 1.4786111 0.232498
+ 1.4788889 0.275210
+ 1.4791667 0.317994
+ 1.4794444 0.358767
+ 1.4797222 0.395443
+ 1.4800000 0.425939
+ 1.4802778 0.448171
+ 1.4805556 0.460052
+ 1.4808333 0.460139
+ 1.4811111 0.449543
+ 1.4813889 0.430014
+ 1.4816667 0.403302
+ 1.4819444 0.371157
+ 1.4822222 0.335330
+ 1.4825000 0.297572
+ 1.4827778 0.259632
+ 1.4830556 0.223260
+ 1.4833333 0.190208
+ 1.4836111 0.161958
+ 1.4838889 0.138917
+ 1.4841667 0.121227
+ 1.4844444 0.109027
+ 1.4847222 0.102460
+ 1.4850000 0.101664
+ 1.4852778 0.106781
+ 1.4855556 0.117951
+ 1.4858333 0.135314
+ 1.4861111 0.159011
+ 1.4863889 0.188868
+ 1.4866667 0.223449
+ 1.4869444 0.261003
+ 1.4872222 0.299780
+ 1.4875000 0.338029
+ 1.4877778 0.374000
+ 1.4880556 0.405942
+ 1.4883333 0.432105
+ 1.4886111 0.450739
+ 1.4888889 0.460092
+ 1.4891667 0.458946
+ 1.4894444 0.448211
+ 1.4897222 0.429330
+ 1.4900000 0.403745
+ 1.4902778 0.372897
+ 1.4905556 0.338230
+ 1.4908333 0.301186
+ 1.4911111 0.263206
+ 1.4913889 0.225732
+ 1.4916667 0.190208
+ 1.4919444 0.157925
+ 1.4922222 0.129571
+ 1.4925000 0.105686
+ 1.4927778 0.086807
+ 1.4930556 0.073472
+ 1.4933333 0.066221
+ 1.4936111 0.065592
+ 1.4938889 0.072122
+ 1.4941667 0.086351
+ 1.4944444 0.108816
+ 1.4947222 0.139611
+ 1.4950000 0.177050
+ 1.4952778 0.219000
+ 1.4955556 0.263330
+ 1.4958333 0.307908
+ 1.4961111 0.350603
+ 1.4963889 0.389282
+ 1.4966667 0.421813
+ 1.4969444 0.446066
+ 1.4972222 0.459908
+ 1.4975000 0.461832
+ 1.4977778 0.452821
+ 1.4980556 0.434486
+ 1.4983333 0.408434
+ 1.4986111 0.376274
+ 1.4988889 0.339616
+ 1.4991667 0.300067
+ 1.4994444 0.259237
+ 1.4997222 0.218734
+ 1.5000000 0.180167
+ 1.5002778 0.144975
+ 1.5005556 0.113919
+ 1.5008333 0.087591
+ 1.5011111 0.066583
+ 1.5013889 0.051487
+ 1.5016667 0.050000
+ 1.5019444 0.050000
+ 1.5022222 0.050000
+ 1.5025000 0.062049
+ 1.5027778 0.085385
+ 1.5030556 0.117706
+ 1.5033333 0.157219
+ 1.5036111 0.201654
+ 1.5038889 0.248741
+ 1.5041667 0.296209
+ 1.5044444 0.341789
+ 1.5047222 0.383211
+ 1.5050000 0.418206
+ 1.5052778 0.444502
+ 1.5055556 0.459830
+ 1.5058333 0.462577
+ 1.5061111 0.453753
+ 1.5063889 0.435027
+ 1.5066667 0.408067
+ 1.5069444 0.374540
+ 1.5072222 0.336114
+ 1.5075000 0.294457
+ 1.5077778 0.251237
+ 1.5080556 0.208121
+ 1.5083333 0.166778
+ 1.5086111 0.128712
+ 1.5088889 0.094779
+ 1.5091667 0.065671
+ 1.5094444 0.050000
+ 1.5097222 0.050000
+ 1.5100000 0.050000
+ 1.5102778 0.050000
+ 1.5105556 0.050000
+ 1.5108333 0.050000
+ 1.5111111 0.055169
+ 1.5113889 0.089065
+ 1.5116667 0.130896
+ 1.5119444 0.178234
+ 1.5122222 0.228651
+ 1.5125000 0.279717
+ 1.5127778 0.329004
+ 1.5130556 0.374083
+ 1.5133333 0.412526
+ 1.5136111 0.441905
+ 1.5138889 0.459791
+ 1.5141667 0.464452
+ 1.5144444 0.456951
+ 1.5147222 0.439046
+ 1.5150000 0.412495
+ 1.5152778 0.379057
+ 1.5155556 0.340491
+ 1.5158333 0.298556
+ 1.5161111 0.255011
+ 1.5163889 0.211615
+ 1.5166667 0.170125
+ 1.5169444 0.132116
+ 1.5172222 0.098421
+ 1.5175000 0.069687
+ 1.5177778 0.050000
+ 1.5180556 0.050000
+ 1.5183333 0.050000
+ 1.5186111 0.050000
+ 1.5188889 0.050000
+ 1.5191667 0.050000
+ 1.5194444 0.061850
+ 1.5197222 0.095608
+ 1.5200000 0.137107
+ 1.5202778 0.183947
+ 1.5205556 0.233728
+ 1.5208333 0.284049
+ 1.5211111 0.332511
+ 1.5213889 0.376712
+ 1.5216667 0.414253
+ 1.5219444 0.442733
+ 1.5222222 0.459752
+ 1.5225000 0.463605
+ 1.5227778 0.455368
+ 1.5230556 0.436812
+ 1.5233333 0.409708
+ 1.5236111 0.375829
+ 1.5238889 0.336944
+ 1.5241667 0.294825
+ 1.5244444 0.251244
+ 1.5247222 0.207971
+ 1.5250000 0.166778
+ 1.5252778 0.129242
+ 1.5255556 0.096166
+ 1.5258333 0.068160
+ 1.5261111 0.050000
+ 1.5263889 0.050000
+ 1.5266667 0.050000
+ 1.5269444 0.050000
+ 1.5272222 0.050000
+ 1.5275000 0.050000
+ 1.5277778 0.065237
+ 1.5280556 0.099220
+ 1.5283333 0.140766
+ 1.5286111 0.187495
+ 1.5288889 0.237026
+ 1.5291667 0.286979
+ 1.5294444 0.334974
+ 1.5297222 0.378630
+ 1.5300000 0.415568
+ 1.5302778 0.443406
+ 1.5305556 0.459765
+ 1.5308333 0.462955
+ 1.5311111 0.454056
+ 1.5313889 0.434839
+ 1.5316667 0.407072
+ 1.5319444 0.372526
+ 1.5322222 0.332973
+ 1.5325000 0.290181
+ 1.5327778 0.245923
+ 1.5330556 0.201966
+ 1.5333333 0.160083
+ 1.5336111 0.121854
+ 1.5338889 0.088102
+ 1.5341667 0.059459
+ 1.5344444 0.050000
+ 1.5347222 0.050000
+ 1.5350000 0.050000
+ 1.5352778 0.050000
+ 1.5355556 0.050000
+ 1.5358333 0.050000
+ 1.5361111 0.055208
+ 1.5363889 0.089726
+ 1.5366667 0.132003
+ 1.5369444 0.179625
+ 1.5372222 0.230176
+ 1.5375000 0.281242
+ 1.5377778 0.330407
+ 1.5380556 0.375257
+ 1.5383333 0.413376
+ 1.5386111 0.442351
+ 1.5388889 0.459765
+ 1.5391667 0.463903
+ 1.5394444 0.455852
+ 1.5397222 0.437395
+ 1.5400000 0.410317
+ 1.5402778 0.376404
+ 1.5405556 0.337440
+ 1.5408333 0.295211
+ 1.5411111 0.251501
+ 1.5413889 0.208095
+ 1.5416667 0.166778
+ 1.5419444 0.129139
+ 1.5422222 0.095983
+ 1.5425000 0.067920
+ 1.5427778 0.050000
+ 1.5430556 0.050000
+ 1.5433333 0.050000
+ 1.5436111 0.050000
+ 1.5438889 0.050000
+ 1.5441667 0.050000
+ 1.5444444 0.065210
+ 1.5447222 0.099308
+ 1.5450000 0.140976
+ 1.5452778 0.187824
+ 1.5455556 0.237456
+ 1.5458333 0.287481
+ 1.5461111 0.335505
+ 1.5463889 0.379136
+ 1.5466667 0.415980
+ 1.5469444 0.443646
+ 1.5472222 0.459738
+ 1.5475000 0.462562
+ 1.5477778 0.453201
+ 1.5480556 0.433436
+ 1.5483333 0.405050
+ 1.5486111 0.369821
+ 1.5488889 0.329532
+ 1.5491667 0.285964
+ 1.5494444 0.240896
+ 1.5497222 0.196111
+ 1.5500000 0.153389
+ 1.5502778 0.114331
+ 1.5505556 0.079820
+ 1.5508333 0.050558
+ 1.5511111 0.050000
+ 1.5513889 0.050000
+ 1.5516667 0.050000
+ 1.5519444 0.050000
+ 1.5522222 0.050000
+ 1.5525000 0.050000
+ 1.5527778 0.051717
+ 1.5530556 0.089163
+ 1.5533333 0.134718
+ 1.5536111 0.185619
+ 1.5538889 0.239104
+ 1.5541667 0.292412
+ 1.5544444 0.342781
+ 1.5547222 0.387450
+ 1.5550000 0.423656
+ 1.5552778 0.448638
+ 1.5555556 0.459634
+ 1.5558333 0.454756
+ 1.5561111 0.435610
+ 1.5563889 0.404676
+ 1.5566667 0.364434
+ 1.5569444 0.317362
+ 1.5572222 0.265942
+ 1.5575000 0.212652
+ 1.5577778 0.159972
+ 1.5580556 0.110382
+ 1.5583333 0.066361
+ 1.5586111 0.050000
+ 1.5588889 0.050000
+ 1.5591667 0.050000
+ 1.5594444 0.050000
+ 1.5597222 0.050000
+ 1.5600000 0.050000
+ 1.5602778 0.050000
+ 1.5605556 0.050000
+ 1.5608333 0.050000
+ 1.5611111 0.050000
+ 1.5613889 0.088942
+ 1.5616667 0.133215
+ 1.5619444 0.180987
+ 1.5622222 0.230423
+ 1.5625000 0.279689
+ 1.5627778 0.326952
+ 1.5630556 0.370377
+ 1.5633333 0.408132
+ 1.5636111 0.438382
+ 1.5638889 0.459294
+ 1.5641667 0.469526
+ 1.5644444 0.469706
+ 1.5647222 0.460955
+ 1.5650000 0.444393
+ 1.5652778 0.421142
+ 1.5655556 0.392322
+ 1.5658333 0.359053
+ 1.5661111 0.322457
+ 1.5663889 0.283654
+ 1.5666667 0.243764
+ 1.5669444 0.203927
+ 1.5672222 0.165354
+ 1.5675000 0.129278
+ 1.5677778 0.096927
+ 1.5680556 0.069534
+ 1.5683333 0.050000
+ 1.5686111 0.050000
+ 1.5688889 0.050000
+ 1.5691667 0.050000
+ 1.5694444 0.050000
+ 1.5697222 0.077618
+ 1.5700000 0.115347
+ 1.5702778 0.160957
+ 1.5705556 0.212217
+ 1.5708333 0.266899
+ 1.5711111 0.322770
+ 1.5713889 0.377602
+ 1.5716667 0.429164
+ 1.5719444 0.475225
+ 1.5722222 0.513556
+ 1.5725000 0.542510
+ 1.5727778 0.562779
+ 1.5730556 0.575637
+ 1.5733333 0.582362
+ 1.5736111 0.584227
+ 1.5738889 0.582509
+ 1.5741667 0.578482
+ 1.5744444 0.573422
+ 1.5747222 0.568606
+ 1.5750000 0.565307
+ 1.5752778 0.564478
+ 1.5755556 0.565775
+ 1.5758333 0.568530
+ 1.5761111 0.572076
+ 1.5763889 0.575745
+ 1.5766667 0.578870
+ 1.5769444 0.580783
+ 1.5772222 0.580817
+ 1.5775000 0.578304
+ 1.5777778 0.572577
+ 1.5780556 0.563292
+ 1.5783333 0.551403
+ 1.5786111 0.538190
+ 1.5788889 0.524931
+ 1.5791667 0.512904
+ 1.5794444 0.503389
+ 1.5797222 0.497664
+ 1.5800000 0.497007
+ 1.5802778 0.502697
+ 1.5805556 0.516014
+ 1.5808333 0.537544
+ 1.5811111 0.565112
+ 1.5813889 0.595851
+ 1.5816667 0.626896
+ 1.5819444 0.655379
+ 1.5822222 0.678434
+ 1.5825000 0.693194
+ 1.5827778 0.696793
+ 1.5830556 0.686365
+ 1.5833333 0.659042
+ 1.5836111 0.613183
+ 1.5838889 0.552040
+ 1.5841667 0.480092
+ 1.5844444 0.401816
+ 1.5847222 0.321688
+ 1.5850000 0.244187
+ 1.5852778 0.173791
+ 1.5855556 0.114976
+ 1.5858333 0.072220
+ 1.5861111 0.050000
+ 1.5863889 0.051314
+ 1.5866667 0.073236
+ 1.5869444 0.111362
+ 1.5872222 0.161286
+ 1.5875000 0.218603
+ 1.5877778 0.278908
+ 1.5880556 0.337795
+ 1.5883333 0.390858
+ 1.5886111 0.433694
+ 1.5888889 0.461896
+ 1.5891667 0.472216
+ 1.5894444 0.466032
+ 1.5897222 0.445879
+ 1.5900000 0.414293
+ 1.5902778 0.373808
+ 1.5905556 0.326959
+ 1.5908333 0.276281
+ 1.5911111 0.224309
+ 1.5913889 0.173579
+ 1.5916667 0.126624
+ 1.5919444 0.085609
+ 1.5922222 0.051204
+ 1.5925000 0.050000
+ 1.5927778 0.050000
+ 1.5930556 0.050000
+ 1.5933333 0.050000
+ 1.5936111 0.050000
+ 1.5938889 0.050000
+ 1.5941667 0.050000
+ 1.5944444 0.050000
+ 1.5947222 0.088161
+ 1.5950000 0.133263
+ 1.5952778 0.182935
+ 1.5955556 0.234806
+ 1.5958333 0.286504
+ 1.5961111 0.335657
+ 1.5963889 0.379895
+ 1.5966667 0.416845
+ 1.5969444 0.444137
+ 1.5972222 0.459399
+ 1.5975000 0.460970
+ 1.5977778 0.450036
+ 1.5980556 0.428494
+ 1.5983333 0.398241
+ 1.5986111 0.361173
+ 1.5988889 0.319188
+ 1.5991667 0.274181
+ 1.5994444 0.228049
+ 1.5997222 0.182690
+ 1.6000000 0.140000
+ 1.6002778 0.101650
+ 1.6005556 0.068410
+ 1.6008333 0.050000
+ 1.6011111 0.050000
+ 1.6013889 0.050000
+ 1.6016667 0.050000
+ 1.6019444 0.050000
+ 1.6022222 0.050000
+ 1.6025000 0.050000
+ 1.6027778 0.051756
+ 1.6030556 0.088491
+ 1.6033333 0.132750
+ 1.6036111 0.182051
+ 1.6038889 0.233909
+ 1.6041667 0.285843
+ 1.6044444 0.335367
+ 1.6047222 0.380000
+ 1.6050000 0.417257
+ 1.6052778 0.444656
+ 1.6055556 0.459712
+ 1.6058333 0.460689
+ 1.6061111 0.448825
+ 1.6063889 0.426108
+ 1.6066667 0.394522
+ 1.6069444 0.356053
+ 1.6072222 0.312687
+ 1.6075000 0.266409
+ 1.6077778 0.219204
+ 1.6080556 0.173059
+ 1.6083333 0.129958
+ 1.6086111 0.091635
+ 1.6088889 0.058808
+ 1.6091667 0.050000
+ 1.6094444 0.050000
+ 1.6097222 0.050000
+ 1.6100000 0.050000
+ 1.6102778 0.050000
+ 1.6105556 0.050000
+ 1.6108333 0.050000
+ 1.6111111 0.050000
+ 1.6113889 0.087137
+ 1.6116667 0.131556
+ 1.6119444 0.180844
+ 1.6122222 0.232591
+ 1.6125000 0.284385
+ 1.6127778 0.333818
+ 1.6130556 0.378476
+ 1.6133333 0.415950
+ 1.6136111 0.443828
+ 1.6138889 0.459699
+ 1.6141667 0.461869
+ 1.6144444 0.451505
+ 1.6147222 0.430490
+ 1.6150000 0.400707
+ 1.6152778 0.364040
+ 1.6155556 0.322371
+ 1.6158333 0.277584
+ 1.6161111 0.231562
+ 1.6163889 0.186189
+ 1.6166667 0.143347
+ 1.6169444 0.104702
+ 1.6172222 0.071043
+ 1.6175000 0.050000
+ 1.6177778 0.050000
+ 1.6180556 0.050000
+ 1.6183333 0.050000
+ 1.6186111 0.050000
+ 1.6188889 0.050000
+ 1.6191667 0.050000
+ 1.6194444 0.050000
+ 1.6197222 0.086473
+ 1.6200000 0.130591
+ 1.6202778 0.179863
+ 1.6205556 0.231794
+ 1.6208333 0.283893
+ 1.6211111 0.333665
+ 1.6213889 0.378618
+ 1.6216667 0.416259
+ 1.6219444 0.444095
+ 1.6222222 0.459634
+ 1.6225000 0.461125
+ 1.6227778 0.449790
+ 1.6230556 0.427597
+ 1.6233333 0.396509
+ 1.6236111 0.358495
+ 1.6238889 0.315518
+ 1.6241667 0.269545
+ 1.6244444 0.222541
+ 1.6247222 0.176473
+ 1.6250000 0.133306
+ 1.6252778 0.094762
+ 1.6255556 0.061588
+ 1.6258333 0.050000
+ 1.6261111 0.050000
+ 1.6263889 0.050000
+ 1.6266667 0.050000
+ 1.6269444 0.050000
+ 1.6272222 0.050000
+ 1.6275000 0.050000
+ 1.6277778 0.050000
+ 1.6280556 0.087336
+ 1.6283333 0.132095
+ 1.6286111 0.181797
+ 1.6288889 0.233960
+ 1.6291667 0.286103
+ 1.6294444 0.335746
+ 1.6297222 0.380407
+ 1.6300000 0.417604
+ 1.6302778 0.444858
+ 1.6305556 0.459686
+ 1.6308333 0.460356
+ 1.6311111 0.448125
+ 1.6313889 0.425001
+ 1.6316667 0.392988
+ 1.6319444 0.354094
+ 1.6322222 0.310324
+ 1.6325000 0.263684
+ 1.6327778 0.216182
+ 1.6330556 0.169822
+ 1.6333333 0.126611
+ 1.6336111 0.088296
+ 1.6338889 0.055589
+ 1.6341667 0.050000
+ 1.6344444 0.050000
+ 1.6347222 0.050000
+ 1.6350000 0.050000
+ 1.6352778 0.050000
+ 1.6355556 0.050000
+ 1.6358333 0.050000
+ 1.6361111 0.050000
+ 1.6363889 0.087607
+ 1.6366667 0.132452
+ 1.6369444 0.182102
+ 1.6372222 0.234121
+ 1.6375000 0.286074
+ 1.6377778 0.335528
+ 1.6380556 0.380046
+ 1.6383333 0.417196
+ 1.6386111 0.444541
+ 1.6388889 0.459647
+ 1.6391667 0.460811
+ 1.6394444 0.449255
+ 1.6397222 0.426932
+ 1.6400000 0.395797
+ 1.6402778 0.357802
+ 1.6405556 0.314901
+ 1.6408333 0.269047
+ 1.6411111 0.222194
+ 1.6413889 0.176296
+ 1.6416667 0.133306
+ 1.6419444 0.094934
+ 1.6422222 0.061918
+ 1.6425000 0.050000
+ 1.6427778 0.050000
+ 1.6430556 0.050000
+ 1.6433333 0.050000
+ 1.6436111 0.050000
+ 1.6438889 0.050000
+ 1.6441667 0.050000
+ 1.6444444 0.050000
+ 1.6447222 0.086970
+ 1.6450000 0.131317
+ 1.6452778 0.180606
+ 1.6455556 0.232404
+ 1.6458333 0.284277
+ 1.6461111 0.333792
+ 1.6463889 0.378514
+ 1.6466667 0.416012
+ 1.6469444 0.443850
+ 1.6472222 0.459595
+ 1.6475000 0.461537
+ 1.6477778 0.450859
+ 1.6480556 0.429470
+ 1.6483333 0.399275
+ 1.6486111 0.362183
+ 1.6488889 0.320099
+ 1.6491667 0.274932
+ 1.6494444 0.228589
+ 1.6497222 0.182975
+ 1.6500000 0.140000
+ 1.6502778 0.101344
+ 1.6505556 0.067791
+ 1.6508333 0.050000
+ 1.6511111 0.050000
+ 1.6513889 0.050000
+ 1.6516667 0.050000
+ 1.6519444 0.050000
+ 1.6522222 0.050000
+ 1.6525000 0.050000
+ 1.6527778 0.050000
+ 1.6530556 0.086960
+ 1.6533333 0.131524
+ 1.6536111 0.181176
+ 1.6538889 0.233397
+ 1.6541667 0.285668
+ 1.6544444 0.335473
+ 1.6547222 0.380292
+ 1.6550000 0.417609
+ 1.6552778 0.444904
+ 1.6555556 0.459660
+ 1.6558333 0.460119
+ 1.6561111 0.447560
+ 1.6563889 0.424025
+ 1.6566667 0.391552
+ 1.6569444 0.352181
+ 1.6572222 0.307953
+ 1.6575000 0.260908
+ 1.6577778 0.213084
+ 1.6580556 0.166523
+ 1.6583333 0.123264
+ 1.6586111 0.085076
+ 1.6588889 0.052643
+ 1.6591667 0.050000
+ 1.6594444 0.050000
+ 1.6597222 0.050000
+ 1.6600000 0.050000
+ 1.6602778 0.050000
+ 1.6605556 0.050000
+ 1.6608333 0.050000
+ 1.6611111 0.050000
+ 1.6613889 0.087510
+ 1.6616667 0.132122
+ 1.6619444 0.181460
+ 1.6622222 0.233150
+ 1.6625000 0.284817
+ 1.6627778 0.334086
+ 1.6630556 0.378581
+ 1.6633333 0.415927
+ 1.6636111 0.443750
+ 1.6638889 0.459673
+ 1.6641667 0.462027
+ 1.6644444 0.451961
+ 1.6647222 0.431328
+ 1.6650000 0.401980
+ 1.6652778 0.365773
+ 1.6655556 0.324558
+ 1.6658333 0.280189
+ 1.6661111 0.234520
+ 1.6663889 0.189404
+ 1.6666667 0.146694
+ 1.6669444 0.108035
+ 1.6672222 0.074231
+ 1.6675000 0.050000
+ 1.6677778 0.050000
+ 1.6680556 0.050000
+ 1.6683333 0.050000
+ 1.6686111 0.050000
+ 1.6688889 0.050000
+ 1.6691667 0.050000
+ 1.6694444 0.050000
+ 1.6697222 0.086160
+ 1.6700000 0.130038
+ 1.6702778 0.179140
+ 1.6705556 0.230971
+ 1.6708333 0.283038
+ 1.6711111 0.332848
+ 1.6713889 0.377904
+ 1.6716667 0.415715
+ 1.6719444 0.443785
+ 1.6722222 0.459621
+ 1.6725000 0.461469
+ 1.6727778 0.450535
+ 1.6730556 0.428769
+ 1.6733333 0.398116
+ 1.6736111 0.360525
+ 1.6738889 0.317943
+ 1.6741667 0.272317
+ 1.6744444 0.225595
+ 1.6747222 0.179725
+ 1.6750000 0.136653
+ 1.6752778 0.098089
+ 1.6755556 0.064789
+ 1.6758333 0.050000
+ 1.6761111 0.050000
+ 1.6763889 0.050000
+ 1.6766667 0.050000
+ 1.6769444 0.050000
+ 1.6772222 0.050000
+ 1.6775000 0.050000
+ 1.6777778 0.050000
+ 1.6780556 0.086871
+ 1.6783333 0.131207
+ 1.6786111 0.180549
+ 1.6788889 0.232440
+ 1.6791667 0.284423
+ 1.6794444 0.334038
+ 1.6797222 0.378828
+ 1.6800000 0.416336
+ 1.6802778 0.444104
+ 1.6805556 0.459673
+ 1.6808333 0.461319
+ 1.6811111 0.450249
+ 1.6813889 0.428402
+ 1.6816667 0.397717
+ 1.6819444 0.360136
+ 1.6822222 0.317596
+ 1.6825000 0.272038
+ 1.6827778 0.225402
+ 1.6830556 0.179627
+ 1.6833333 0.136653
+ 1.6836111 0.098181
+ 1.6838889 0.064964
+ 1.6841667 0.050000
+ 1.6844444 0.050000
+ 1.6847222 0.050000
+ 1.6850000 0.050000
+ 1.6852778 0.050000
+ 1.6855556 0.050000
+ 1.6858333 0.050000
+ 1.6861111 0.050000
+ 1.6863889 0.086688
+ 1.6866667 0.130819
+ 1.6869444 0.179957
+ 1.6872222 0.231670
+ 1.6875000 0.283522
+ 1.6877778 0.333079
+ 1.6880556 0.377909
+ 1.6883333 0.415576
+ 1.6886111 0.443646
+ 1.6888889 0.459686
+ 1.6891667 0.461982
+ 1.6894444 0.451701
+ 1.6897222 0.430733
+ 1.6900000 0.400966
+ 1.6902778 0.364289
+ 1.6905556 0.322590
+ 1.6908333 0.277758
+ 1.6911111 0.231681
+ 1.6913889 0.186248
+ 1.6916667 0.143347
+ 1.6919444 0.104649
+ 1.6922222 0.070945
+ 1.6925000 0.050000
+ 1.6927778 0.050000
+ 1.6930556 0.050000
+ 1.6933333 0.050000
+ 1.6936111 0.050000
+ 1.6938889 0.050000
+ 1.6941667 0.050000
+ 1.6944444 0.050000
+ 1.6947222 0.086562
+ 1.6950000 0.130780
+ 1.6952778 0.180149
+ 1.6955556 0.232166
+ 1.6958333 0.284326
+ 1.6961111 0.334126
+ 1.6963889 0.379060
+ 1.6966667 0.416626
+ 1.6969444 0.444318
+ 1.6972222 0.459634
+ 1.6975000 0.460817
+ 1.6977778 0.449107
+ 1.6980556 0.426494
+ 1.6983333 0.394966
+ 1.6986111 0.356512
+ 1.6988889 0.313121
+ 1.6991667 0.266781
+ 1.6994444 0.219481
+ 1.6997222 0.173211
+ 1.7000000 0.129958
+ 1.7002778 0.091461
+ 1.7005556 0.058454
+ 1.7008333 0.050000
+ 1.7011111 0.050000
+ 1.7013889 0.050000
+ 1.7016667 0.050000
+ 1.7019444 0.050000
+ 1.7022222 0.050000
+ 1.7025000 0.050000
+ 1.7027778 0.050000
+ 1.7030556 0.087646
+ 1.7033333 0.132648
+ 1.7036111 0.182524
+ 1.7038889 0.234793
+ 1.7041667 0.286973
+ 1.7044444 0.336583
+ 1.7047222 0.381141
+ 1.7050000 0.418165
+ 1.7052778 0.445174
+ 1.7055556 0.459686
+ 1.7058333 0.459972
+ 1.7061111 0.447308
+ 1.7063889 0.423723
+ 1.7066667 0.391246
+ 1.7069444 0.351906
+ 1.7072222 0.307731
+ 1.7075000 0.260751
+ 1.7077778 0.212994
+ 1.7080556 0.166489
+ 1.7083333 0.123264
+ 1.7086111 0.085081
+ 1.7088889 0.052629
+ 1.7091667 0.050000
+ 1.7094444 0.050000
+ 1.7097222 0.050000
+ 1.7100000 0.050000
+ 1.7102778 0.050000
+ 1.7105556 0.050000
+ 1.7108333 0.050000
+ 1.7111111 0.050000
+ 1.7113889 0.087655
+ 1.7116667 0.132443
+ 1.7119444 0.181964
+ 1.7122222 0.233820
+ 1.7125000 0.285614
+ 1.7127778 0.334946
+ 1.7130556 0.379419
+ 1.7133333 0.416634
+ 1.7136111 0.444194
+ 1.7138889 0.459699
+ 1.7141667 0.461468
+ 1.7144444 0.450681
+ 1.7147222 0.429236
+ 1.7150000 0.399028
+ 1.7152778 0.361955
+ 1.7155556 0.319914
+ 1.7158333 0.274801
+ 1.7161111 0.228513
+ 1.7163889 0.182947
+ 1.7166667 0.140000
+ 1.7169444 0.101347
+ 1.7172222 0.067774
+ 1.7175000 0.050000
+ 1.7177778 0.050000
+ 1.7180556 0.050000
+ 1.7183333 0.050000
+ 1.7186111 0.050000
+ 1.7188889 0.050000
+ 1.7191667 0.050000
+ 1.7194444 0.050000
+ 1.7197222 0.087096
+ 1.7200000 0.131824
+ 1.7202778 0.181646
+ 1.7205556 0.234021
+ 1.7208333 0.286411
+ 1.7211111 0.336275
+ 1.7213889 0.381074
+ 1.7216667 0.418268
+ 1.7219444 0.445319
+ 1.7222222 0.459686
+ 1.7225000 0.459600
+ 1.7227778 0.446368
+ 1.7230556 0.422068
+ 1.7233333 0.388778
+ 1.7236111 0.348574
+ 1.7238889 0.303535
+ 1.7241667 0.255737
+ 1.7244444 0.207259
+ 1.7247222 0.160177
+ 1.7250000 0.116569
+ 1.7252778 0.078235
+ 1.7255556 0.050000
+ 1.7258333 0.050000
+ 1.7261111 0.050000
+ 1.7263889 0.050000
+ 1.7266667 0.050000
+ 1.7269444 0.050000
+ 1.7272222 0.050000
+ 1.7275000 0.050000
+ 1.7277778 0.050000
+ 1.7280556 0.089015
+ 1.7283333 0.135138
+ 1.7286111 0.185866
+ 1.7288889 0.238696
+ 1.7291667 0.291127
+ 1.7294444 0.340655
+ 1.7297222 0.384779
+ 1.7300000 0.420995
+ 1.7302778 0.446803
+ 1.7305556 0.459699
+ 1.7308333 0.457957
+ 1.7311111 0.442949
+ 1.7313889 0.416824
+ 1.7316667 0.381732
+ 1.7319444 0.339821
+ 1.7322222 0.293239
+ 1.7325000 0.244135
+ 1.7327778 0.194658
+ 1.7330556 0.146957
+ 1.7333333 0.103181
+ 1.7336111 0.065173
+ 1.7338889 0.050000
+ 1.7341667 0.050000
+ 1.7344444 0.050000
+ 1.7347222 0.050000
+ 1.7350000 0.050000
+ 1.7352778 0.050000
+ 1.7355556 0.050000
+ 1.7358333 0.050000
+ 1.7361111 0.050000
+ 1.7363889 0.090123
+ 1.7366667 0.137078
+ 1.7369444 0.188372
+ 1.7372222 0.241514
+ 1.7375000 0.294015
+ 1.7377778 0.343381
+ 1.7380556 0.387123
+ 1.7383333 0.422748
+ 1.7386111 0.447766
+ 1.7388889 0.459686
+ 1.7391667 0.456799
+ 1.7394444 0.440528
+ 1.7397222 0.413077
+ 1.7400000 0.376652
+ 1.7402778 0.333459
+ 1.7405556 0.285701
+ 1.7408333 0.235586
+ 1.7411111 0.185316
+ 1.7413889 0.137099
+ 1.7416667 0.093139
+ 1.7419444 0.055318
+ 1.7422222 0.050000
+ 1.7425000 0.050000
+ 1.7427778 0.050000
+ 1.7430556 0.050000
+ 1.7433333 0.050000
+ 1.7436111 0.050000
+ 1.7438889 0.050000
+ 1.7441667 0.050000
+ 1.7444444 0.050000
+ 1.7447222 0.091096
+ 1.7450000 0.138836
+ 1.7452778 0.190716
+ 1.7455556 0.244237
+ 1.7458333 0.296894
+ 1.7461111 0.346187
+ 1.7463889 0.389613
+ 1.7466667 0.424671
+ 1.7469444 0.448858
+ 1.7472222 0.459673
+ 1.7475000 0.455411
+ 1.7477778 0.437560
+ 1.7480556 0.408405
+ 1.7483333 0.370231
+ 1.7486111 0.325322
+ 1.7488889 0.275965
+ 1.7491667 0.224444
+ 1.7494444 0.173044
+ 1.7497222 0.124051
+ 1.7500000 0.079750
+ 1.7502778 0.050000
+ 1.7505556 0.050000
+ 1.7508333 0.050000
+ 1.7511111 0.050000
+ 1.7513889 0.050000
+ 1.7516667 0.050000
+ 1.7519444 0.050000
+ 1.7522222 0.050000
+ 1.7525000 0.050000
+ 1.7527778 0.050000
+ 1.7530556 0.092643
+ 1.7533333 0.141714
+ 1.7536111 0.194663
+ 1.7538889 0.248940
+ 1.7541667 0.301995
+ 1.7544444 0.351278
+ 1.7547222 0.394238
+ 1.7550000 0.428326
+ 1.7552778 0.450992
+ 1.7555556 0.459686
+ 1.7558333 0.452694
+ 1.7561111 0.431644
+ 1.7563889 0.399001
+ 1.7566667 0.357231
+ 1.7569444 0.308799
+ 1.7572222 0.256169
+ 1.7575000 0.201807
+ 1.7577778 0.148176
+ 1.7580556 0.097743
+ 1.7583333 0.052972
+ 1.7586111 0.050000
+ 1.7588889 0.050000
+ 1.7591667 0.050000
+ 1.7594444 0.050000
+ 1.7597222 0.050000
+ 1.7600000 0.050000
+ 1.7602778 0.050000
+ 1.7605556 0.050000
+ 1.7608333 0.050000
+ 1.7611111 0.050000
+ 1.7613889 0.094419
+ 1.7616667 0.144621
+ 1.7619444 0.198149
+ 1.7622222 0.252548
+ 1.7625000 0.305360
+ 1.7627778 0.354131
+ 1.7630556 0.396403
+ 1.7633333 0.429722
+ 1.7636111 0.451631
+ 1.7638889 0.459673
+ 1.7641667 0.452209
+ 1.7644444 0.430862
+ 1.7647222 0.398071
+ 1.7650000 0.356274
+ 1.7652778 0.307911
+ 1.7655556 0.255422
+ 1.7658333 0.201244
+ 1.7661111 0.147817
+ 1.7663889 0.097580
+ 1.7666667 0.052972
+ 1.7669444 0.050000
+ 1.7672222 0.050000
+ 1.7675000 0.050000
+ 1.7677778 0.050000
+ 1.7680556 0.050000
+ 1.7683333 0.050000
+ 1.7686111 0.050000
+ 1.7688889 0.050000
+ 1.7691667 0.050000
+ 1.7694444 0.050000
+ 1.7697222 0.094454
+ 1.7700000 0.144714
+ 1.7702778 0.198312
+ 1.7705556 0.252779
+ 1.7708333 0.305648
+ 1.7711111 0.354450
+ 1.7713889 0.396718
+ 1.7716667 0.429983
+ 1.7719444 0.451778
+ 1.7722222 0.459634
+ 1.7725000 0.451905
+ 1.7727778 0.430229
+ 1.7730556 0.397068
+ 1.7733333 0.354881
+ 1.7736111 0.306129
+ 1.7738889 0.253271
+ 1.7741667 0.198770
+ 1.7744444 0.145084
+ 1.7747222 0.094674
+ 1.7750000 0.050000
+ 1.7752778 0.050000
+ 1.7755556 0.050000
+ 1.7758333 0.050000
+ 1.7761111 0.050000
+ 1.7763889 0.050000
+ 1.7766667 0.050000
+ 1.7769444 0.050000
+ 1.7772222 0.050000
+ 1.7775000 0.050000
+ 1.7777778 0.050000
+ 1.7780556 0.094675
+ 1.7783333 0.145088
+ 1.7786111 0.198778
+ 1.7788889 0.253284
+ 1.7791667 0.306146
+ 1.7794444 0.354904
+ 1.7797222 0.397097
+ 1.7800000 0.430266
+ 1.7802778 0.451949
+ 1.7805556 0.459686
+ 1.7808333 0.451839
+ 1.7811111 0.430052
+ 1.7813889 0.396794
+ 1.7816667 0.354530
+ 1.7819444 0.305729
+ 1.7822222 0.252857
+ 1.7825000 0.198381
+ 1.7827778 0.144768
+ 1.7830556 0.094485
+ 1.7833333 0.050000
+ 1.7836111 0.050000
+ 1.7838889 0.050000
+ 1.7841667 0.050000
+ 1.7844444 0.050000
+ 1.7847222 0.050000
+ 1.7850000 0.050000
+ 1.7852778 0.050000
+ 1.7855556 0.050000
+ 1.7858333 0.050000
+ 1.7861111 0.050000
+ 1.7863889 0.093783
+ 1.7866667 0.143162
+ 1.7869444 0.195805
+ 1.7872222 0.249378
+ 1.7875000 0.301548
+ 1.7877778 0.349983
+ 1.7880556 0.392348
+ 1.7883333 0.426311
+ 1.7886111 0.449540
+ 1.7888889 0.459699
+ 1.7891667 0.455215
+ 1.7894444 0.437539
+ 1.7897222 0.408881
+ 1.7900000 0.371452
+ 1.7902778 0.327462
+ 1.7905556 0.279121
+ 1.7908333 0.228638
+ 1.7911111 0.178225
+ 1.7913889 0.130090
+ 1.7916667 0.086444
+ 1.7919444 0.050000
+ 1.7922222 0.050000
+ 1.7925000 0.050000
+ 1.7927778 0.050000
+ 1.7930556 0.050000
+ 1.7933333 0.050000
+ 1.7936111 0.050000
+ 1.7938889 0.050000
+ 1.7941667 0.050000
+ 1.7944444 0.050000
+ 1.7947222 0.090907
+ 1.7950000 0.138228
+ 1.7952778 0.189562
+ 1.7955556 0.242510
+ 1.7958333 0.294670
+ 1.7961111 0.343643
+ 1.7963889 0.387029
+ 1.7966667 0.422427
+ 1.7969444 0.447438
+ 1.7972222 0.459660
+ 1.7975000 0.457454
+ 1.7977778 0.442215
+ 1.7980556 0.416100
+ 1.7983333 0.381265
+ 1.7986111 0.339866
+ 1.7988889 0.294059
+ 1.7991667 0.246001
+ 1.7994444 0.197847
+ 1.7997222 0.151753
+ 1.8000000 0.109875
+ 1.8002778 0.074044
+ 1.8005556 0.050000
+ 1.8008333 0.050000
+ 1.8011111 0.050000
+ 1.8013889 0.050000
+ 1.8016667 0.050000
+ 1.8019444 0.050000
+ 1.8022222 0.050000
+ 1.8025000 0.050000
+ 1.8027778 0.071787
+ 1.8030556 0.110420
+ 1.8033333 0.155172
+ 1.8036111 0.203763
+ 1.8038889 0.253913
+ 1.8041667 0.303340
+ 1.8044444 0.349764
+ 1.8047222 0.390904
+ 1.8050000 0.424480
+ 1.8052778 0.448211
+ 1.8055556 0.459817
+ 1.8058333 0.457732
+ 1.8061111 0.443257
+ 1.8063889 0.418407
+ 1.8066667 0.385197
+ 1.8069444 0.345644
+ 1.8072222 0.301762
+ 1.8075000 0.255568
+ 1.8077778 0.209076
+ 1.8080556 0.164303
+ 1.8083333 0.123264
+ 1.8086111 0.087685
+ 1.8088889 0.058131
+ 1.8091667 0.050000
+ 1.8094444 0.050000
+ 1.8097222 0.050000
+ 1.8100000 0.050000
+ 1.8102778 0.050000
+ 1.8105556 0.050000
+ 1.8108333 0.050000
+ 1.8111111 0.071800
+ 1.8113889 0.108504
+ 1.8116667 0.151526
+ 1.8119444 0.198672
+ 1.8122222 0.247748
+ 1.8125000 0.296559
+ 1.8127778 0.342912
+ 1.8130556 0.384611
+ 1.8133333 0.419462
+ 1.8136111 0.445271
+ 1.8138889 0.459843
+ 1.8141667 0.461647
+ 1.8144444 0.451797
+ 1.8147222 0.432071
+ 1.8150000 0.404247
+ 1.8152778 0.370102
+ 1.8155556 0.331413
+ 1.8158333 0.289959
+ 1.8161111 0.247517
+ 1.8163889 0.205864
+ 1.8166667 0.166778
+ 1.8169444 0.131816
+ 1.8172222 0.101660
+ 1.8175000 0.076769
+ 1.8177778 0.057604
+ 1.8180556 0.050000
+ 1.8183333 0.050000
+ 1.8186111 0.050000
+ 1.8188889 0.050000
+ 1.8191667 0.063791
+ 1.8194444 0.088654
+ 1.8197222 0.122022
+ 1.8200000 0.162126
+ 1.8202778 0.206754
+ 1.8205556 0.253692
+ 1.8208333 0.300727
+ 1.8211111 0.345644
+ 1.8213889 0.386232
+ 1.8216667 0.420277
+ 1.8219444 0.445565
+ 1.8222222 0.459882
+ 1.8225000 0.461681
+ 1.8227778 0.452067
+ 1.8230556 0.432811
+ 1.8233333 0.405685
+ 1.8236111 0.372460
+ 1.8238889 0.334905
+ 1.8241667 0.294793
+ 1.8244444 0.253894
+ 1.8247222 0.213979
+ 1.8250000 0.176819
+ 1.8252778 0.143952
+ 1.8255556 0.115976
+ 1.8258333 0.093257
+ 1.8261111 0.076163
+ 1.8263889 0.065058
+ 1.8266667 0.060309
+ 1.8269444 0.062282
+ 1.8272222 0.071342
+ 1.8275000 0.087856
+ 1.8277778 0.112189
+ 1.8280556 0.144302
+ 1.8283333 0.182529
+ 1.8286111 0.224800
+ 1.8288889 0.269044
+ 1.8291667 0.313191
+ 1.8294444 0.355169
+ 1.8297222 0.392909
+ 1.8300000 0.424339
+ 1.8302778 0.447388
+ 1.8305556 0.459987
+ 1.8308333 0.460688
+ 1.8311111 0.450545
+ 1.8313889 0.431232
+ 1.8316667 0.404428
+ 1.8319444 0.371809
+ 1.8322222 0.335051
+ 1.8325000 0.295831
+ 1.8327778 0.255826
+ 1.8330556 0.216713
+ 1.8333333 0.180167
+ 1.8336111 0.147653
+ 1.8338889 0.119784
+ 1.8341667 0.096962
+ 1.8344444 0.079586
+ 1.8347222 0.068057
+ 1.8350000 0.062777
+ 1.8352778 0.064145
+ 1.8355556 0.072563
+ 1.8358333 0.088431
+ 1.8361111 0.112150
+ 1.8363889 0.143711
+ 1.8366667 0.181469
+ 1.8369444 0.223368
+ 1.8372222 0.267354
+ 1.8375000 0.311371
+ 1.8377778 0.353364
+ 1.8380556 0.391279
+ 1.8383333 0.423060
+ 1.8386111 0.446652
+ 1.8388889 0.460000
+ 1.8391667 0.461658
+ 1.8394444 0.452616
+ 1.8397222 0.434471
+ 1.8400000 0.408823
+ 1.8402778 0.377269
+ 1.8405556 0.341408
+ 1.8408333 0.302839
+ 1.8411111 0.263159
+ 1.8413889 0.223967
+ 1.8416667 0.186861
+ 1.8419444 0.153260
+ 1.8422222 0.123862
+ 1.8425000 0.099183
+ 1.8427778 0.079742
+ 1.8430556 0.066057
+ 1.8433333 0.058645
+ 1.8436111 0.058024
+ 1.8438889 0.064711
+ 1.8441667 0.079225
+ 1.8444444 0.102082
+ 1.8447222 0.133358
+ 1.8450000 0.171351
+ 1.8452778 0.213919
+ 1.8455556 0.258918
+ 1.8458333 0.304204
+ 1.8461111 0.347634
+ 1.8463889 0.387064
+ 1.8466667 0.420351
+ 1.8469444 0.445352
+ 1.8472222 0.459922
+ 1.8475000 0.462547
+ 1.8477778 0.454235
+ 1.8480556 0.436619
+ 1.8483333 0.411336
+ 1.8486111 0.380021
+ 1.8488889 0.344309
+ 1.8491667 0.305837
+ 1.8494444 0.266239
+ 1.8497222 0.227151
+ 1.8500000 0.190208
+ 1.8502778 0.156857
+ 1.8505556 0.127784
+ 1.8508333 0.103485
+ 1.8511111 0.084458
+ 1.8513889 0.071199
+ 1.8516667 0.064207
+ 1.8519444 0.063976
+ 1.8522222 0.071005
+ 1.8525000 0.085790
+ 1.8527778 0.108829
+ 1.8530556 0.140175
+ 1.8533333 0.178113
+ 1.8536111 0.220485
+ 1.8538889 0.265133
+ 1.8541667 0.309899
+ 1.8544444 0.352624
+ 1.8547222 0.391151
+ 1.8550000 0.423322
+ 1.8552778 0.446978
+ 1.8555556 0.459961
+ 1.8558333 0.460759
+ 1.8561111 0.450440
+ 1.8563889 0.430720
+ 1.8566667 0.403314
+ 1.8569444 0.369935
+ 1.8572222 0.332299
+ 1.8575000 0.292120
+ 1.8577778 0.251112
+ 1.8580556 0.210992
+ 1.8583333 0.173472
+ 1.8586111 0.140052
+ 1.8588889 0.111364
+ 1.8591667 0.087822
+ 1.8594444 0.069844
+ 1.8597222 0.057844
+ 1.8600000 0.052238
+ 1.8602778 0.053442
+ 1.8605556 0.061871
+ 1.8608333 0.077942
+ 1.8611111 0.102069
+ 1.8613889 0.134251
+ 1.8616667 0.172813
+ 1.8619444 0.215664
+ 1.8622222 0.260711
+ 1.8625000 0.305861
+ 1.8627778 0.349023
+ 1.8630556 0.388105
+ 1.8633333 0.421015
+ 1.8636111 0.445660
+ 1.8638889 0.459948
+ 1.8641667 0.462404
+ 1.8644444 0.454023
+ 1.8647222 0.436416
+ 1.8650000 0.411195
+ 1.8652778 0.379970
+ 1.8655556 0.344355
+ 1.8658333 0.305959
+ 1.8661111 0.266395
+ 1.8663889 0.227275
+ 1.8666667 0.190208
+ 1.8669444 0.156627
+ 1.8672222 0.127233
+ 1.8675000 0.102549
+ 1.8677778 0.083096
+ 1.8680556 0.069396
+ 1.8683333 0.061972
+ 1.8686111 0.061343
+ 1.8688889 0.068033
+ 1.8691667 0.082564
+ 1.8694444 0.105456
+ 1.8697222 0.136782
+ 1.8700000 0.174819
+ 1.8702778 0.217393
+ 1.8705556 0.262331
+ 1.8708333 0.307460
+ 1.8711111 0.350607
+ 1.8713889 0.389598
+ 1.8716667 0.422261
+ 1.8719444 0.446422
+ 1.8722222 0.459908
+ 1.8725000 0.461194
+ 1.8727778 0.451342
+ 1.8730556 0.432063
+ 1.8733333 0.405067
+ 1.8736111 0.372064
+ 1.8738889 0.334766
+ 1.8741667 0.294882
+ 1.8744444 0.254122
+ 1.8747222 0.214198
+ 1.8750000 0.176819
+ 1.8752778 0.143483
+ 1.8755556 0.114829
+ 1.8758333 0.091287
+ 1.8761111 0.073281
+ 1.8763889 0.061241
+ 1.8766667 0.055593
+ 1.8769444 0.056765
+ 1.8772222 0.065183
+ 1.8775000 0.081275
+ 1.8777778 0.105469
+ 1.8780556 0.137764
+ 1.8783333 0.176453
+ 1.8786111 0.219400
+ 1.8788889 0.264472
+ 1.8791667 0.309533
+ 1.8794444 0.352449
+ 1.8797222 0.391085
+ 1.8800000 0.423305
+ 1.8802778 0.446975
+ 1.8805556 0.459961
+ 1.8808333 0.460768
+ 1.8811111 0.450466
+ 1.8813889 0.430767
+ 1.8816667 0.403382
+ 1.8819444 0.370021
+ 1.8822222 0.332396
+ 1.8825000 0.292218
+ 1.8827778 0.251197
+ 1.8830556 0.211045
+ 1.8833333 0.173472
+ 1.8836111 0.139977
+ 1.8838889 0.111199
+ 1.8841667 0.087566
+ 1.8844444 0.069505
+ 1.8847222 0.057442
+ 1.8850000 0.051805
+ 1.8852778 0.053021
+ 1.8855556 0.061517
+ 1.8858333 0.077720
+ 1.8861111 0.102056
+ 1.8863889 0.134526
+ 1.8866667 0.173424
+ 1.8869444 0.216615
+ 1.8872222 0.261967
+ 1.8875000 0.307345
+ 1.8877778 0.350616
+ 1.8880556 0.389647
+ 1.8883333 0.422303
+ 1.8886111 0.446453
+ 1.8888889 0.459961
+ 1.8891667 0.461331
+ 1.8894444 0.451611
+ 1.8897222 0.432487
+ 1.8900000 0.405643
+ 1.8902778 0.372764
+ 1.8905556 0.335535
+ 1.8908333 0.295641
+ 1.8911111 0.254768
+ 1.8913889 0.214599
+ 1.8916667 0.176819
+ 1.8919444 0.142913
+ 1.8922222 0.113551
+ 1.8925000 0.089204
+ 1.8927778 0.070343
+ 1.8930556 0.057438
+ 1.8933333 0.050959
+ 1.8936111 0.051376
+ 1.8938889 0.059160
+ 1.8941667 0.074781
+ 1.8944444 0.098709
+ 1.8947222 0.130976
+ 1.8950000 0.169859
+ 1.8952778 0.213200
+ 1.8955556 0.258836
+ 1.8958333 0.304608
+ 1.8961111 0.348354
+ 1.8963889 0.387916
+ 1.8966667 0.421131
+ 1.8969444 0.445840
+ 1.8972222 0.459882
+ 1.8975000 0.461736
+ 1.8977778 0.452432
+ 1.8980556 0.433642
+ 1.8983333 0.407037
+ 1.8986111 0.374286
+ 1.8988889 0.337060
+ 1.8991667 0.297030
+ 1.8994444 0.255866
+ 1.8997222 0.215239
+ 1.9000000 0.176819
+ 1.9002778 0.142088
+ 1.9005556 0.111768
+ 1.9008333 0.086393
+ 1.9011111 0.066497
+ 1.9013889 0.052613
+ 1.9016667 0.050000
+ 1.9019444 0.050000
+ 1.9022222 0.052371
+ 1.9025000 0.067872
+ 1.9027778 0.092054
+ 1.9030556 0.124980
+ 1.9033333 0.164842
+ 1.9036111 0.209359
+ 1.9038889 0.256252
+ 1.9041667 0.303243
+ 1.9044444 0.348052
+ 1.9047222 0.388399
+ 1.9050000 0.422006
+ 1.9052778 0.446594
+ 1.9055556 0.459882
+ 1.9058333 0.460280
+ 1.9061111 0.448941
+ 1.9063889 0.427708
+ 1.9066667 0.398422
+ 1.9069444 0.362925
+ 1.9072222 0.323059
+ 1.9075000 0.280665
+ 1.9077778 0.237586
+ 1.9080556 0.195662
+ 1.9083333 0.156736
+ 1.9086111 0.122404
+ 1.9088889 0.093280
+ 1.9091667 0.069732
+ 1.9094444 0.052130
+ 1.9097222 0.050000
+ 1.9100000 0.050000
+ 1.9102778 0.050000
+ 1.9105556 0.050000
+ 1.9108333 0.066184
+ 1.9111111 0.091988
+ 1.9113889 0.125897
+ 1.9116667 0.166179
+ 1.9119444 0.210686
+ 1.9122222 0.257266
+ 1.9125000 0.303771
+ 1.9127778 0.348050
+ 1.9130556 0.387953
+ 1.9133333 0.421331
+ 1.9136111 0.446033
+ 1.9138889 0.459908
+ 1.9141667 0.461449
+ 1.9144444 0.451702
+ 1.9147222 0.432359
+ 1.9150000 0.405107
+ 1.9152778 0.371636
+ 1.9155556 0.333636
+ 1.9158333 0.292796
+ 1.9161111 0.250804
+ 1.9163889 0.209351
+ 1.9166667 0.170125
+ 1.9169444 0.134626
+ 1.9172222 0.103592
+ 1.9175000 0.077573
+ 1.9177778 0.057118
+ 1.9180556 0.050000
+ 1.9183333 0.050000
+ 1.9186111 0.050000
+ 1.9188889 0.050000
+ 1.9191667 0.057524
+ 1.9194444 0.081986
+ 1.9197222 0.115380
+ 1.9200000 0.155883
+ 1.9202778 0.201195
+ 1.9205556 0.249015
+ 1.9208333 0.297044
+ 1.9211111 0.342982
+ 1.9213889 0.384529
+ 1.9216667 0.419386
+ 1.9219444 0.445253
+ 1.9222222 0.459830
+ 1.9225000 0.461502
+ 1.9227778 0.451393
+ 1.9230556 0.431311
+ 1.9233333 0.403065
+ 1.9236111 0.368464
+ 1.9238889 0.329316
+ 1.9241667 0.287430
+ 1.9244444 0.244615
+ 1.9247222 0.202679
+ 1.9250000 0.163431
+ 1.9252778 0.128451
+ 1.9255556 0.098408
+ 1.9258333 0.073742
+ 1.9261111 0.054894
+ 1.9263889 0.050000
+ 1.9266667 0.050000
+ 1.9269444 0.050000
+ 1.9272222 0.050000
+ 1.9275000 0.063343
+ 1.9277778 0.088654
+ 1.9280556 0.122422
+ 1.9283333 0.162868
+ 1.9286111 0.207766
+ 1.9288889 0.254892
+ 1.9291667 0.302022
+ 1.9294444 0.346931
+ 1.9297222 0.387395
+ 1.9300000 0.421189
+ 1.9302778 0.446088
+ 1.9305556 0.459869
+ 1.9308333 0.460970
+ 1.9311111 0.450483
+ 1.9313889 0.430164
+ 1.9316667 0.401768
+ 1.9319444 0.367050
+ 1.9322222 0.327767
+ 1.9325000 0.285673
+ 1.9327778 0.242524
+ 1.9330556 0.200076
+ 1.9333333 0.160083
+ 1.9336111 0.124096
+ 1.9338889 0.092839
+ 1.9341667 0.066830
+ 1.9344444 0.050000
+ 1.9347222 0.050000
+ 1.9350000 0.050000
+ 1.9352778 0.050000
+ 1.9355556 0.050000
+ 1.9358333 0.050012
+ 1.9361111 0.075252
+ 1.9363889 0.109417
+ 1.9366667 0.150675
+ 1.9369444 0.196724
+ 1.9372222 0.245262
+ 1.9375000 0.293988
+ 1.9377778 0.340599
+ 1.9380556 0.382795
+ 1.9383333 0.418273
+ 1.9386111 0.444732
+ 1.9388889 0.459869
+ 1.9391667 0.462065
+ 1.9394444 0.452424
+ 1.9397222 0.432731
+ 1.9400000 0.404772
+ 1.9402778 0.370333
+ 1.9405556 0.331199
+ 1.9408333 0.289156
+ 1.9411111 0.245990
+ 1.9413889 0.203486
+ 1.9416667 0.163431
+ 1.9419444 0.127397
+ 1.9422222 0.096111
+ 1.9425000 0.070090
+ 1.9427778 0.050000
+ 1.9430556 0.050000
+ 1.9433333 0.050000
+ 1.9436111 0.050000
+ 1.9438889 0.050000
+ 1.9441667 0.053350
+ 1.9444444 0.078599
+ 1.9447222 0.112761
+ 1.9450000 0.153988
+ 1.9452778 0.199961
+ 1.9455556 0.248361
+ 1.9458333 0.296867
+ 1.9461111 0.343160
+ 1.9463889 0.384922
+ 1.9466667 0.419831
+ 1.9469444 0.445569
+ 1.9472222 0.459817
+ 1.9475000 0.460951
+ 1.9477778 0.450135
+ 1.9480556 0.429231
+ 1.9483333 0.400099
+ 1.9486111 0.364601
+ 1.9488889 0.324596
+ 1.9491667 0.281947
+ 1.9494444 0.238513
+ 1.9497222 0.196156
+ 1.9500000 0.156736
+ 1.9502778 0.121870
+ 1.9505556 0.092195
+ 1.9508333 0.068102
+ 1.9511111 0.050000
+ 1.9513889 0.050000
+ 1.9516667 0.050000
+ 1.9519444 0.050000
+ 1.9522222 0.050000
+ 1.9525000 0.062731
+ 1.9527778 0.088693
+ 1.9530556 0.122941
+ 1.9533333 0.163705
+ 1.9536111 0.208779
+ 1.9538889 0.255960
+ 1.9541667 0.303044
+ 1.9544444 0.347827
+ 1.9547222 0.388105
+ 1.9550000 0.421674
+ 1.9552778 0.446330
+ 1.9555556 0.459869
+ 1.9558333 0.460749
+ 1.9561111 0.450070
+ 1.9563889 0.429596
+ 1.9566667 0.401090
+ 1.9569444 0.366314
+ 1.9572222 0.327031
+ 1.9575000 0.285003
+ 1.9577778 0.241994
+ 1.9580556 0.199767
+ 1.9583333 0.160083
+ 1.9586111 0.124494
+ 1.9588889 0.093700
+ 1.9591667 0.068190
+ 1.9594444 0.050000
+ 1.9597222 0.050000
+ 1.9600000 0.050000
+ 1.9602778 0.050000
+ 1.9605556 0.050000
+ 1.9608333 0.053426
+ 1.9611111 0.078573
+ 1.9613889 0.112454
+ 1.9616667 0.153275
+ 1.9619444 0.198789
+ 1.9622222 0.246745
+ 1.9625000 0.294896
+ 1.9627778 0.340991
+ 1.9630556 0.382783
+ 1.9633333 0.418021
+ 1.9636111 0.444458
+ 1.9638889 0.459843
+ 1.9641667 0.462587
+ 1.9644444 0.453737
+ 1.9647222 0.434996
+ 1.9650000 0.408071
+ 1.9652778 0.374666
+ 1.9655556 0.336487
+ 1.9658333 0.295238
+ 1.9661111 0.252624
+ 1.9663889 0.210352
+ 1.9666667 0.170125
+ 1.9669444 0.133466
+ 1.9672222 0.101161
+ 1.9675000 0.073815
+ 1.9677778 0.052031
+ 1.9680556 0.050000
+ 1.9683333 0.050000
+ 1.9686111 0.050000
+ 1.9688889 0.050000
+ 1.9691667 0.050000
+ 1.9694444 0.071957
+ 1.9697222 0.105526
+ 1.9700000 0.146531
+ 1.9702778 0.192618
+ 1.9705556 0.241433
+ 1.9708333 0.290624
+ 1.9711111 0.337836
+ 1.9713889 0.380717
+ 1.9716667 0.416912
+ 1.9719444 0.444067
+ 1.9722222 0.459830
+ 1.9725000 0.462540
+ 1.9727778 0.453313
+ 1.9730556 0.433956
+ 1.9733333 0.406279
+ 1.9736111 0.372091
+ 1.9738889 0.333200
+ 1.9741667 0.291414
+ 1.9744444 0.248543
+ 1.9747222 0.206394
+ 1.9750000 0.166778
+ 1.9752778 0.131279
+ 1.9755556 0.100596
+ 1.9758333 0.075201
+ 1.9761111 0.055569
+ 1.9763889 0.050000
+ 1.9766667 0.050000
+ 1.9769444 0.050000
+ 1.9772222 0.050000
+ 1.9775000 0.060463
+ 1.9777778 0.085372
+ 1.9780556 0.118912
+ 1.9783333 0.159295
+ 1.9786111 0.204281
+ 1.9788889 0.251627
+ 1.9791667 0.299095
+ 1.9794444 0.344444
+ 1.9797222 0.385432
+ 1.9800000 0.419820
+ 1.9802778 0.445366
+ 1.9805556 0.459830
+ 1.9808333 0.461636
+ 1.9811111 0.451868
+ 1.9813889 0.432273
+ 1.9816667 0.404599
+ 1.9819444 0.370593
+ 1.9822222 0.332005
+ 1.9825000 0.290581
+ 1.9827778 0.248070
+ 1.9830556 0.206220
+ 1.9833333 0.166778
+ 1.9836111 0.131285
+ 1.9838889 0.100451
+ 1.9841667 0.074781
+ 1.9844444 0.054777
+ 1.9847222 0.050000
+ 1.9850000 0.050000
+ 1.9852778 0.050000
+ 1.9855556 0.050000
+ 1.9858333 0.057378
+ 1.9861111 0.081947
+ 1.9863889 0.115249
+ 1.9866667 0.155509
+ 1.9869444 0.200489
+ 1.9872222 0.247958
+ 1.9875000 0.295679
+ 1.9877778 0.341418
+ 1.9880556 0.382941
+ 1.9883333 0.418014
+ 1.9886111 0.444401
+ 1.9888889 0.459869
+ 1.9891667 0.462841
+ 1.9894444 0.454370
+ 1.9897222 0.436170
+ 1.9900000 0.409953
+ 1.9902778 0.377430
+ 1.9905556 0.340315
+ 1.9908333 0.300318
+ 1.9911111 0.259153
+ 1.9913889 0.218532
+ 1.9916667 0.180167
+ 1.9919444 0.145568
+ 1.9922222 0.115438
+ 1.9925000 0.090277
+ 1.9927778 0.070588
+ 1.9930556 0.056870
+ 1.9933333 0.050000
+ 1.9936111 0.050000
+ 1.9938889 0.056556
+ 1.9941667 0.071734
+ 1.9944444 0.095388
+ 1.9947222 0.127570
+ 1.9950000 0.166540
+ 1.9952778 0.210107
+ 1.9955556 0.256081
+ 1.9958333 0.302274
+ 1.9961111 0.346495
+ 1.9963889 0.386555
+ 1.9966667 0.420264
+ 1.9969444 0.445432
+ 1.9972222 0.459869
+ 1.9975000 0.462031
+ 1.9977778 0.452949
+ 1.9980556 0.434302
+ 1.9983333 0.407766
+ 1.9986111 0.375020
+ 1.9988889 0.337739
+ 1.9991667 0.297601
+ 1.9994444 0.256284
+ 1.9997222 0.215464
+ 2.0000000 0.176819
+ 2.0002778 0.141837
+ 2.0005556 0.111242
+ 2.0008333 0.085571
+ 2.0011111 0.065360
+ 2.0013889 0.051143
+ 2.0016667 0.050000
+ 2.0019444 0.050000
+ 2.0022222 0.050000
+ 2.0025000 0.064939
+ 2.0027778 0.088733
+ 2.0030556 0.121273
+ 2.0033333 0.160789
+ 2.0036111 0.205044
+ 2.0038889 0.251805
+ 2.0041667 0.298837
+ 2.0044444 0.343906
+ 2.0047222 0.384776
+ 2.0050000 0.419215
+ 2.0052778 0.444986
+ 2.0055556 0.459856
+ 2.0058333 0.462246
+ 2.0061111 0.453203
+ 2.0063889 0.434427
+ 2.0066667 0.407622
+ 2.0069444 0.374488
+ 2.0072222 0.336729
+ 2.0075000 0.296046
+ 2.0077778 0.254140
+ 2.0080556 0.212715
+ 2.0083333 0.173472
+ 2.0086111 0.137920
+ 2.0088889 0.106792
+ 2.0091667 0.080630
+ 2.0094444 0.059975
+ 2.0097222 0.050000
+ 2.0100000 0.050000
+ 2.0102778 0.050000
+ 2.0105556 0.050000
+ 2.0108333 0.058230
+ 2.0111111 0.081973
+ 2.0113889 0.114549
+ 2.0116667 0.154199
+ 2.0119444 0.198706
+ 2.0122222 0.245851
+ 2.0125000 0.293415
+ 2.0127778 0.339181
+ 2.0130556 0.380930
+ 2.0133333 0.416445
+ 2.0136111 0.443506
+ 2.0138889 0.459895
+ 2.0141667 0.464033
+ 2.0144444 0.456891
+ 2.0147222 0.440079
+ 2.0150000 0.415207
+ 2.0152778 0.383884
+ 2.0155556 0.347721
+ 2.0158333 0.308328
+ 2.0161111 0.267313
+ 2.0163889 0.226288
+ 2.0166667 0.186861
+ 2.0169444 0.150487
+ 2.0172222 0.117996
+ 2.0175000 0.090061
+ 2.0177778 0.067355
+ 2.0180556 0.050554
+ 2.0183333 0.050000
+ 2.0186111 0.050000
+ 2.0188889 0.050000
+ 2.0191667 0.055856
+ 2.0194444 0.078678
+ 2.0197222 0.110940
+ 2.0200000 0.150790
+ 2.0202778 0.195871
+ 2.0205556 0.243825
+ 2.0208333 0.292294
+ 2.0211111 0.338922
+ 2.0213889 0.381349
+ 2.0216667 0.417219
+ 2.0219444 0.444174
+ 2.0222222 0.459856
+ 2.0225000 0.462611
+ 2.0227778 0.453590
+ 2.0230556 0.434650
+ 2.0233333 0.407646
+ 2.0236111 0.374432
+ 2.0238889 0.336865
+ 2.0241667 0.296800
+ 2.0244444 0.256092
+ 2.0247222 0.216595
+ 2.0250000 0.180167
+ 2.0252778 0.148397
+ 2.0255556 0.121822
+ 2.0258333 0.100714
+ 2.0261111 0.085345
+ 2.0263889 0.075986
+ 2.0266667 0.072910
+ 2.0269444 0.076389
+ 2.0272222 0.086694
+ 2.0275000 0.104098
+ 2.0277778 0.128873
+ 2.0280556 0.160908
+ 2.0283333 0.198567
+ 2.0286111 0.239831
+ 2.0288889 0.282680
+ 2.0291667 0.325095
+ 2.0294444 0.365057
+ 2.0297222 0.400548
+ 2.0300000 0.429548
+ 2.0302778 0.450039
+ 2.0305556 0.460000
+ 2.0308333 0.458047
+ 2.0311111 0.445330
+ 2.0313889 0.423633
+ 2.0316667 0.394739
+ 2.0319444 0.360431
+ 2.0322222 0.322494
+ 2.0325000 0.282711
+ 2.0327778 0.242867
+ 2.0330556 0.204743
+ 2.0333333 0.170125
+ 2.0336111 0.140526
+ 2.0338889 0.116377
+ 2.0341667 0.097843
+ 2.0344444 0.085084
+ 2.0347222 0.078263
+ 2.0350000 0.077543
+ 2.0352778 0.083086
+ 2.0355556 0.095054
+ 2.0358333 0.113609
+ 2.0361111 0.138915
+ 2.0363889 0.170793
+ 2.0366667 0.207713
+ 2.0369444 0.247804
+ 2.0372222 0.289195
+ 2.0375000 0.330015
+ 2.0377778 0.368393
+ 2.0380556 0.402460
+ 2.0383333 0.430343
+ 2.0386111 0.450173
+ 2.0388889 0.460078
+ 2.0391667 0.458777
+ 2.0394444 0.447342
+ 2.0397222 0.427431
+ 2.0400000 0.400705
+ 2.0402778 0.368825
+ 2.0405556 0.333450
+ 2.0408333 0.296241
+ 2.0411111 0.258858
+ 2.0413889 0.222960
+ 2.0416667 0.190208
+ 2.0419444 0.162017
+ 2.0422222 0.138821
+ 2.0425000 0.120808
+ 2.0427778 0.108167
+ 2.0430556 0.101087
+ 2.0433333 0.099756
+ 2.0436111 0.104364
+ 2.0438889 0.115098
+ 2.0441667 0.132149
+ 2.0444444 0.155703
+ 2.0447222 0.185621
+ 2.0450000 0.220438
+ 2.0452778 0.258361
+ 2.0455556 0.297597
+ 2.0458333 0.336353
+ 2.0461111 0.372835
+ 2.0463889 0.405250
+ 2.0466667 0.431804
+ 2.0469444 0.450704
+ 2.0472222 0.460157
+ 2.0475000 0.458932
+ 2.0477778 0.448052
+ 2.0480556 0.429100
+ 2.0483333 0.403663
+ 2.0486111 0.373325
+ 2.0488889 0.339671
+ 2.0491667 0.304287
+ 2.0494444 0.268756
+ 2.0497222 0.234665
+ 2.0500000 0.203597
+ 2.0502778 0.176903
+ 2.0505556 0.154991
+ 2.0508333 0.138032
+ 2.0511111 0.126200
+ 2.0513889 0.119666
+ 2.0516667 0.118603
+ 2.0519444 0.123182
+ 2.0522222 0.133578
+ 2.0525000 0.149961
+ 2.0527778 0.172505
+ 2.0530556 0.201066
+ 2.0533333 0.234246
+ 2.0536111 0.270329
+ 2.0538889 0.307602
+ 2.0541667 0.344349
+ 2.0544444 0.378856
+ 2.0547222 0.409409
+ 2.0550000 0.434293
+ 2.0552778 0.451793
+ 2.0555556 0.460196
+ 2.0558333 0.458320
+ 2.0561111 0.447119
+ 2.0563889 0.428079
+ 2.0566667 0.402689
+ 2.0569444 0.372434
+ 2.0572222 0.338803
+ 2.0575000 0.303282
+ 2.0577778 0.267358
+ 2.0580556 0.232518
+ 2.0583333 0.200250
+ 2.0586111 0.171843
+ 2.0588889 0.147800
+ 2.0591667 0.128425
+ 2.0594444 0.114022
+ 2.0597222 0.104897
+ 2.0600000 0.101355
+ 2.0602778 0.103699
+ 2.0605556 0.112235
+ 2.0608333 0.127267
+ 2.0611111 0.149100
+ 2.0613889 0.177691
+ 2.0616667 0.211602
+ 2.0619444 0.249047
+ 2.0622222 0.288241
+ 2.0625000 0.327397
+ 2.0627778 0.364731
+ 2.0630556 0.398455
+ 2.0633333 0.426785
+ 2.0636111 0.447934
+ 2.0638889 0.460118
+ 2.0641667 0.462077
+ 2.0644444 0.454664
+ 2.0647222 0.439261
+ 2.0650000 0.417249
+ 2.0652778 0.390006
+ 2.0655556 0.358916
+ 2.0658333 0.325357
+ 2.0661111 0.290711
+ 2.0663889 0.256359
+ 2.0666667 0.223681
+ 2.0669444 0.193910
+ 2.0672222 0.167694
+ 2.0675000 0.145530
+ 2.0677778 0.127918
+ 2.0680556 0.115357
+ 2.0683333 0.108346
+ 2.0686111 0.107383
+ 2.0688889 0.112969
+ 2.0691667 0.125601
+ 2.0694444 0.145779
+ 2.0697222 0.173590
+ 2.0700000 0.207471
+ 2.0702778 0.245447
+ 2.0705556 0.285544
+ 2.0708333 0.325787
+ 2.0711111 0.364201
+ 2.0713889 0.398812
+ 2.0716667 0.427645
+ 2.0719444 0.448726
+ 2.0722222 0.460078
+ 2.0725000 0.460332
+ 2.0727778 0.450525
+ 2.0730556 0.432301
+ 2.0733333 0.407300
+ 2.0736111 0.377165
+ 2.0738889 0.343537
+ 2.0741667 0.308059
+ 2.0744444 0.272373
+ 2.0747222 0.238121
+ 2.0750000 0.206945
+ 2.0752778 0.180236
+ 2.0755556 0.158388
+ 2.0758333 0.141545
+ 2.0761111 0.129851
+ 2.0763889 0.123448
+ 2.0766667 0.122481
+ 2.0769444 0.127093
+ 2.0772222 0.137428
+ 2.0775000 0.153628
+ 2.0777778 0.175839
+ 2.0780556 0.203903
+ 2.0783333 0.236464
+ 2.0786111 0.271868
+ 2.0788889 0.308457
+ 2.0791667 0.344577
+ 2.0794444 0.378572
+ 2.0797222 0.408786
+ 2.0800000 0.433563
+ 2.0802778 0.451247
+ 2.0805556 0.460183
+ 2.0808333 0.459215
+ 2.0811111 0.449183
+ 2.0813889 0.431430
+ 2.0816667 0.407296
+ 2.0819444 0.378123
+ 2.0822222 0.345251
+ 2.0825000 0.310021
+ 2.0827778 0.273775
+ 2.0830556 0.237853
+ 2.0833333 0.203597
+ 2.0836111 0.172219
+ 2.0838889 0.144416
+ 2.0841667 0.120757
+ 2.0844444 0.101808
+ 2.0847222 0.088140
+ 2.0850000 0.080320
+ 2.0852778 0.078916
+ 2.0855556 0.084496
+ 2.0858333 0.097629
+ 2.0861111 0.118884
+ 2.0863889 0.148384
+ 2.0866667 0.184484
+ 2.0869444 0.225091
+ 2.0872222 0.268116
+ 2.0875000 0.311468
+ 2.0877778 0.353056
+ 2.0880556 0.390790
+ 2.0883333 0.422580
+ 2.0886111 0.446333
+ 2.0888889 0.459961
+ 2.0891667 0.461979
+ 2.0894444 0.453335
+ 2.0897222 0.435583
+ 2.0900000 0.410277
+ 2.0902778 0.378973
+ 2.0905556 0.343223
+ 2.0908333 0.304582
+ 2.0911111 0.264606
+ 2.0913889 0.224847
+ 2.0916667 0.186861
+ 2.0919444 0.152044
+ 2.0922222 0.121162
+ 2.0925000 0.094823
+ 2.0927778 0.073635
+ 2.0930556 0.058207
+ 2.0933333 0.050000
+ 2.0936111 0.050000
+ 2.0938889 0.052556
+ 2.0941667 0.066244
+ 2.0944444 0.088733
+ 2.0947222 0.120157
+ 2.0950000 0.158768
+ 2.0952778 0.202345
+ 2.0955556 0.248667
+ 2.0958333 0.295513
+ 2.0961111 0.340663
+ 2.0963889 0.381896
+ 2.0966667 0.416991
+ 2.0969444 0.443726
+ 2.0972222 0.459882
+ 2.0975000 0.463877
+ 2.0977778 0.456686
+ 2.0980556 0.439923
+ 2.0983333 0.415203
+ 2.0986111 0.384141
+ 2.0988889 0.348352
+ 2.0991667 0.309449
+ 2.0994444 0.269048
+ 2.0997222 0.228763
+ 2.1000000 0.190208
+ 2.1002778 0.154833
+ 2.1005556 0.123419
+ 2.1008333 0.096584
+ 2.1011111 0.074945
+ 2.1013889 0.059118
+ 2.1016667 0.050000
+ 2.1019444 0.050000
+ 2.1022222 0.052680
+ 2.1025000 0.066271
+ 2.1027778 0.088759
+ 2.1030556 0.120280
+ 2.1033333 0.159060
+ 2.1036111 0.202841
+ 2.1038889 0.249369
+ 2.1041667 0.296388
+ 2.1044444 0.341641
+ 2.1047222 0.382875
+ 2.1050000 0.417832
+ 2.1052778 0.444257
+ 2.1055556 0.459895
+ 2.1058333 0.463144
+ 2.1061111 0.455015
+ 2.1063889 0.437172
+ 2.1066667 0.411282
+ 2.1069444 0.379008
+ 2.1072222 0.342016
+ 2.1075000 0.301971
+ 2.1077778 0.260538
+ 2.1080556 0.219382
+ 2.1083333 0.180167
+ 2.1086111 0.144379
+ 2.1088889 0.112789
+ 2.1091667 0.085986
+ 2.1094444 0.064560
+ 2.1097222 0.050000
+ 2.1100000 0.050000
+ 2.1102778 0.050000
+ 2.1105556 0.050000
+ 2.1108333 0.058761
+ 2.1111111 0.081999
+ 2.1113889 0.114272
+ 2.1116667 0.153796
+ 2.1119444 0.198311
+ 2.1122222 0.245558
+ 2.1125000 0.293276
+ 2.1127778 0.339206
+ 2.1130556 0.381089
+ 2.1133333 0.416665
+ 2.1136111 0.443674
+ 2.1138889 0.459856
+ 2.1141667 0.463607
+ 2.1144444 0.455939
+ 2.1147222 0.438518
+ 2.1150000 0.413012
+ 2.1152778 0.381087
+ 2.1155556 0.344410
+ 2.1158333 0.304647
+ 2.1161111 0.263466
+ 2.1163889 0.222532
+ 2.1166667 0.183514
+ 2.1169444 0.147897
+ 2.1172222 0.116449
+ 2.1175000 0.089757
+ 2.1177778 0.068407
+ 2.1180556 0.052987
+ 2.1183333 0.050000
+ 2.1186111 0.050000
+ 2.1188889 0.050000
+ 2.1191667 0.062340
+ 2.1194444 0.085372
+ 2.1197222 0.117383
+ 2.1200000 0.156597
+ 2.1202778 0.200766
+ 2.1205556 0.247642
+ 2.1208333 0.294977
+ 2.1211111 0.340522
+ 2.1213889 0.382029
+ 2.1216667 0.417251
+ 2.1219444 0.443938
+ 2.1222222 0.459843
+ 2.1225000 0.463367
+ 2.1227778 0.455505
+ 2.1230556 0.437903
+ 2.1233333 0.412206
+ 2.1236111 0.380060
+ 2.1238889 0.343109
+ 2.1241667 0.303000
+ 2.1244444 0.261376
+ 2.1247222 0.219883
+ 2.1250000 0.180167
+ 2.1252778 0.143705
+ 2.1255556 0.111306
+ 2.1258333 0.083611
+ 2.1261111 0.061261
+ 2.1263889 0.050000
+ 2.1266667 0.050000
+ 2.1269444 0.050000
+ 2.1272222 0.050000
+ 2.1275000 0.052141
+ 2.1277778 0.075331
+ 2.1280556 0.107861
+ 2.1283333 0.147902
+ 2.1286111 0.193131
+ 2.1288889 0.241224
+ 2.1291667 0.289859
+ 2.1294444 0.336711
+ 2.1297222 0.379457
+ 2.1300000 0.415775
+ 2.1302778 0.443340
+ 2.1305556 0.459830
+ 2.1308333 0.463590
+ 2.1311111 0.455642
+ 2.1313889 0.437677
+ 2.1316667 0.411385
+ 2.1319444 0.378458
+ 2.1322222 0.340587
+ 2.1325000 0.299461
+ 2.1327778 0.256773
+ 2.1330556 0.214213
+ 2.1333333 0.173472
+ 2.1336111 0.136068
+ 2.1338889 0.102828
+ 2.1341667 0.074405
+ 2.1344444 0.051453
+ 2.1347222 0.050000
+ 2.1350000 0.050000
+ 2.1352778 0.050000
+ 2.1355556 0.050000
+ 2.1358333 0.050000
+ 2.1361111 0.065263
+ 2.1363889 0.098418
+ 2.1366667 0.139263
+ 2.1369444 0.185440
+ 2.1372222 0.234589
+ 2.1375000 0.284351
+ 2.1377778 0.332369
+ 2.1380556 0.376283
+ 2.1383333 0.413735
+ 2.1386111 0.442366
+ 2.1388889 0.459817
+ 2.1391667 0.464402
+ 2.1394444 0.457128
+ 2.1397222 0.439674
+ 2.1400000 0.413718
+ 2.1402778 0.380939
+ 2.1405556 0.343017
+ 2.1408333 0.301630
+ 2.1411111 0.258458
+ 2.1413889 0.215179
+ 2.1416667 0.173472
+ 2.1419444 0.134863
+ 2.1422222 0.100262
+ 2.1425000 0.070425
+ 2.1427778 0.050000
+ 2.1430556 0.050000
+ 2.1433333 0.050000
+ 2.1436111 0.050000
+ 2.1438889 0.050000
+ 2.1441667 0.050000
+ 2.1444444 0.058503
+ 2.1447222 0.093445
+ 2.1450000 0.136567
+ 2.1452778 0.185233
+ 2.1455556 0.236806
+ 2.1458333 0.288652
+ 2.1461111 0.338133
+ 2.1463889 0.382614
+ 2.1466667 0.419460
+ 2.1469444 0.446033
+ 2.1472222 0.459699
+ 2.1475000 0.458622
+ 2.1477778 0.444164
+ 2.1480556 0.418491
+ 2.1483333 0.383767
+ 2.1486111 0.342155
+ 2.1488889 0.295820
+ 2.1491667 0.246926
+ 2.1494444 0.197636
+ 2.1497222 0.150116
+ 2.1500000 0.106528
+ 2.1502778 0.068724
+ 2.1505556 0.050000
+ 2.1508333 0.050000
+ 2.1511111 0.050000
+ 2.1513889 0.050000
+ 2.1516667 0.050000
+ 2.1519444 0.050000
+ 2.1522222 0.050000
+ 2.1525000 0.050000
+ 2.1527778 0.050000
+ 2.1530556 0.088452
+ 2.1533333 0.133567
+ 2.1536111 0.183055
+ 2.1538889 0.234624
+ 2.1541667 0.285984
+ 2.1544444 0.334842
+ 2.1547222 0.378909
+ 2.1550000 0.415894
+ 2.1552778 0.443505
+ 2.1555556 0.459451
+ 2.1558333 0.462121
+ 2.1561111 0.452626
+ 2.1563889 0.432753
+ 2.1566667 0.404292
+ 2.1569444 0.369034
+ 2.1572222 0.328766
+ 2.1575000 0.285278
+ 2.1577778 0.240360
+ 2.1580556 0.195800
+ 2.1583333 0.153389
+ 2.1586111 0.114724
+ 2.1588889 0.080640
+ 2.1591667 0.051778
+ 2.1594444 0.050000
+ 2.1597222 0.050000
+ 2.1600000 0.050000
+ 2.1602778 0.050000
+ 2.1605556 0.050000
+ 2.1608333 0.050000
+ 2.1611111 0.050000
+ 2.1613889 0.085598
+ 2.1616667 0.129385
+ 2.1619444 0.179184
+ 2.1622222 0.232818
+ 2.1625000 0.288111
+ 2.1627778 0.342885
+ 2.1630556 0.394964
+ 2.1633333 0.442169
+ 2.1636111 0.482325
+ 2.1638889 0.513255
+ 2.1641667 0.533376
+ 2.1644444 0.543488
+ 2.1647222 0.544986
+ 2.1650000 0.539264
+ 2.1652778 0.527717
+ 2.1655556 0.511740
+ 2.1658333 0.492727
+ 2.1661111 0.472072
+ 2.1663889 0.451171
+ 2.1666667 0.431418
+ 2.1669444 0.413961
+ 2.1672222 0.398965
+ 2.1675000 0.386348
+ 2.1677778 0.376027
+ 2.1680556 0.367921
+ 2.1683333 0.361947
+ 2.1686111 0.358024
+ 2.1688889 0.356070
+ 2.1691667 0.356003
+ 2.1694444 0.357740
+ 2.1697222 0.361258
+ 2.1700000 0.366771
+ 2.1702778 0.374548
+ 2.1705556 0.384863
+ 2.1708333 0.397984
+ 2.1711111 0.414185
+ 2.1713889 0.433736
+ 2.1716667 0.456909
+ 2.1719444 0.483974
+ 2.1722222 0.515203
+ 2.1725000 0.550427
+ 2.1727778 0.587715
+ 2.1730556 0.624696
+ 2.1733333 0.658998
+ 2.1736111 0.688251
+ 2.1738889 0.710083
+ 2.1741667 0.722123
+ 2.1744444 0.722000
+ 2.1747222 0.707342
+ 2.1750000 0.675778
+ 2.1752778 0.626079
+ 2.1755556 0.561580
+ 2.1758333 0.486758
+ 2.1761111 0.406089
+ 2.1763889 0.324050
+ 2.1766667 0.245119
+ 2.1769444 0.173771
+ 2.1772222 0.114484
+ 2.1775000 0.071735
+ 2.1777778 0.050000
+ 2.1780556 0.052246
+ 2.1783333 0.075395
+ 2.1786111 0.114859
+ 2.1788889 0.166052
+ 2.1791667 0.224386
+ 2.1794444 0.285272
+ 2.1797222 0.344123
+ 2.1800000 0.396351
+ 2.1802778 0.437369
+ 2.1805556 0.462589
+ 2.1808333 0.468683
+ 2.1811111 0.457363
+ 2.1813889 0.431601
+ 2.1816667 0.394368
+ 2.1819444 0.348635
+ 2.1822222 0.297376
+ 2.1825000 0.243561
+ 2.1827778 0.190162
+ 2.1830556 0.140151
+ 2.1833333 0.096499
+ 2.1836111 0.061624
+ 2.1838889 0.050000
+ 2.1841667 0.050000
+ 2.1844444 0.050000
+ 2.1847222 0.050000
+ 2.1850000 0.050000
+ 2.1852778 0.050000
+ 2.1855556 0.050000
+ 2.1858333 0.075565
+ 2.1861111 0.108554
+ 2.1863889 0.147058
+ 2.1866667 0.189536
+ 2.1869444 0.234216
+ 2.1872222 0.279322
+ 2.1875000 0.323080
+ 2.1877778 0.363715
+ 2.1880556 0.399454
+ 2.1883333 0.428521
+ 2.1886111 0.449142
+ 2.1888889 0.459542
+ 2.1891667 0.458497
+ 2.1894444 0.446976
+ 2.1897222 0.426500
+ 2.1900000 0.398588
+ 2.1902778 0.364761
+ 2.1905556 0.326538
+ 2.1908333 0.285439
+ 2.1911111 0.242983
+ 2.1913889 0.200692
+ 2.1916667 0.160083
+ 2.1919444 0.122547
+ 2.1922222 0.088949
+ 2.1925000 0.060022
+ 2.1927778 0.050000
+ 2.1930556 0.050000
+ 2.1933333 0.050000
+ 2.1936111 0.050000
+ 2.1938889 0.050000
+ 2.1941667 0.050000
+ 2.1944444 0.050000
+ 2.1947222 0.084338
+ 2.1950000 0.126747
+ 2.1952778 0.174753
+ 2.1955556 0.225882
+ 2.1958333 0.277660
+ 2.1961111 0.327615
+ 2.1963889 0.373270
+ 2.1966667 0.412155
+ 2.1969444 0.441793
+ 2.1972222 0.459712
+ 2.1975000 0.464152
+ 2.1977778 0.456204
+ 2.1980556 0.437676
+ 2.1983333 0.410373
+ 2.1986111 0.376102
+ 2.1988889 0.336668
+ 2.1991667 0.293878
+ 2.1994444 0.249537
+ 2.1997222 0.205453
+ 2.2000000 0.163431
+ 2.2002778 0.125081
+ 2.2005556 0.091233
+ 2.2008333 0.062521
+ 2.2011111 0.050000
+ 2.2013889 0.050000
+ 2.2016667 0.050000
+ 2.2019444 0.050000
+ 2.2022222 0.050000
+ 2.2025000 0.050000
+ 2.2027778 0.058542
+ 2.2030556 0.093206
+ 2.2033333 0.135621
+ 2.2036111 0.183336
+ 2.2038889 0.233899
+ 2.2041667 0.284856
+ 2.2044444 0.333757
+ 2.2047222 0.378149
+ 2.2050000 0.415580
+ 2.2052778 0.443599
+ 2.2055556 0.459752
+ 2.2058333 0.462308
+ 2.2061111 0.452420
+ 2.2063889 0.431961
+ 2.2066667 0.402802
+ 2.2069444 0.366817
+ 2.2072222 0.325878
+ 2.2075000 0.281859
+ 2.2077778 0.236631
+ 2.2080556 0.192068
+ 2.2083333 0.150042
+ 2.2086111 0.112203
+ 2.2088889 0.079309
+ 2.2091667 0.051897
+ 2.2094444 0.050000
+ 2.2097222 0.050000
+ 2.2100000 0.050000
+ 2.2102778 0.050000
+ 2.2105556 0.050000
+ 2.2108333 0.050000
+ 2.2111111 0.058464
+ 2.2113889 0.093695
+ 2.2116667 0.136325
+ 2.2119444 0.183989
+ 2.2122222 0.234318
+ 2.2125000 0.284948
+ 2.2127778 0.333511
+ 2.2130556 0.377642
+ 2.2133333 0.414975
+ 2.2136111 0.443142
+ 2.2138889 0.459778
+ 2.2141667 0.463208
+ 2.2144444 0.454527
+ 2.2147222 0.435521
+ 2.2150000 0.407977
+ 2.2152778 0.373680
+ 2.2155556 0.334417
+ 2.2158333 0.291974
+ 2.2161111 0.248138
+ 2.2163889 0.204695
+ 2.2166667 0.163431
+ 2.2169444 0.125934
+ 2.2172222 0.092998
+ 2.2175000 0.065219
+ 2.2177778 0.050000
+ 2.2180556 0.050000
+ 2.2183333 0.050000
+ 2.2186111 0.050000
+ 2.2188889 0.050000
+ 2.2191667 0.050000
+ 2.2194444 0.065197
+ 2.2197222 0.099618
+ 2.2200000 0.141561
+ 2.2202778 0.188623
+ 2.2205556 0.238404
+ 2.2208333 0.288504
+ 2.2211111 0.336521
+ 2.2213889 0.380054
+ 2.2216667 0.416702
+ 2.2219444 0.444064
+ 2.2222222 0.459738
+ 2.2225000 0.462033
+ 2.2227778 0.452086
+ 2.2230556 0.431745
+ 2.2233333 0.402854
+ 2.2236111 0.367261
+ 2.2238889 0.326812
+ 2.2241667 0.283354
+ 2.2244444 0.238734
+ 2.2247222 0.194796
+ 2.2250000 0.153389
+ 2.2252778 0.116139
+ 2.2255556 0.083794
+ 2.2258333 0.056885
+ 2.2261111 0.050000
+ 2.2263889 0.050000
+ 2.2266667 0.050000
+ 2.2269444 0.050000
+ 2.2272222 0.050000
+ 2.2275000 0.050000
+ 2.2277778 0.065197
+ 2.2280556 0.100351
+ 2.2283333 0.142799
+ 2.2286111 0.190166
+ 2.2288889 0.240073
+ 2.2291667 0.290145
+ 2.2294444 0.338004
+ 2.2297222 0.381274
+ 2.2300000 0.417578
+ 2.2302778 0.444538
+ 2.2305556 0.459778
+ 2.2308333 0.461623
+ 2.2311111 0.451206
+ 2.2313889 0.430364
+ 2.2316667 0.400930
+ 2.2319444 0.364741
+ 2.2322222 0.323631
+ 2.2325000 0.279436
+ 2.2327778 0.233991
+ 2.2330556 0.189132
+ 2.2333333 0.146694
+ 2.2336111 0.108303
+ 2.2338889 0.074748
+ 2.2341667 0.050000
+ 2.2344444 0.050000
+ 2.2347222 0.050000
+ 2.2350000 0.050000
+ 2.2352778 0.050000
+ 2.2355556 0.050000
+ 2.2358333 0.050000
+ 2.2361111 0.050000
+ 2.2363889 0.085567
+ 2.2366667 0.128775
+ 2.2369444 0.177209
+ 2.2372222 0.228453
+ 2.2375000 0.280093
+ 2.2377778 0.329714
+ 2.2380556 0.374902
+ 2.2383333 0.413241
+ 2.2386111 0.442316
+ 2.2388889 0.459712
+ 2.2391667 0.463716
+ 2.2394444 0.455411
+ 2.2397222 0.436583
+ 2.2400000 0.409017
+ 2.2402778 0.374497
+ 2.2405556 0.334810
+ 2.2408333 0.291740
+ 2.2411111 0.247072
+ 2.2413889 0.202592
+ 2.2416667 0.160083
+ 2.2419444 0.121146
+ 2.2422222 0.086634
+ 2.2425000 0.057216
+ 2.2427778 0.050000
+ 2.2430556 0.050000
+ 2.2433333 0.050000
+ 2.2436111 0.050000
+ 2.2438889 0.050000
+ 2.2441667 0.050000
+ 2.2444444 0.050000
+ 2.2447222 0.084848
+ 2.2450000 0.127658
+ 2.2452778 0.175954
+ 2.2455556 0.227261
+ 2.2458333 0.279104
+ 2.2461111 0.329007
+ 2.2463889 0.374496
+ 2.2466667 0.413096
+ 2.2469444 0.442331
+ 2.2472222 0.459725
+ 2.2475000 0.463524
+ 2.2477778 0.454845
+ 2.2480556 0.435526
+ 2.2483333 0.407405
+ 2.2486111 0.372319
+ 2.2488889 0.332106
+ 2.2491667 0.288604
+ 2.2494444 0.243650
+ 2.2497222 0.199081
+ 2.2500000 0.156736
+ 2.2502778 0.118247
+ 2.2505556 0.084429
+ 2.2508333 0.055890
+ 2.2511111 0.050000
+ 2.2513889 0.050000
+ 2.2516667 0.050000
+ 2.2519444 0.050000
+ 2.2522222 0.050000
+ 2.2525000 0.050000
+ 2.2527778 0.055169
+ 2.2530556 0.090306
+ 2.2533333 0.133153
+ 2.2536111 0.181261
+ 2.2538889 0.232183
+ 2.2541667 0.283471
+ 2.2544444 0.332678
+ 2.2547222 0.377355
+ 2.2550000 0.415056
+ 2.2552778 0.443333
+ 2.2555556 0.459738
+ 2.2558333 0.462545
+ 2.2561111 0.452911
+ 2.2563889 0.432714
+ 2.2566667 0.403834
+ 2.2569444 0.368148
+ 2.2572222 0.327536
+ 2.2575000 0.283875
+ 2.2577778 0.239045
+ 2.2580556 0.194923
+ 2.2583333 0.153389
+ 2.2586111 0.116092
+ 2.2588889 0.083769
+ 2.2591667 0.056928
+ 2.2594444 0.050000
+ 2.2597222 0.050000
+ 2.2600000 0.050000
+ 2.2602778 0.050000
+ 2.2605556 0.050000
+ 2.2608333 0.050000
+ 2.2611111 0.065158
+ 2.2613889 0.099972
+ 2.2616667 0.142008
+ 2.2619444 0.188946
+ 2.2622222 0.238463
+ 2.2625000 0.288241
+ 2.2627778 0.335957
+ 2.2630556 0.379290
+ 2.2633333 0.415921
+ 2.2636111 0.443528
+ 2.2638889 0.459791
+ 2.2641667 0.463063
+ 2.2644444 0.454403
+ 2.2647222 0.435542
+ 2.2650000 0.408214
+ 2.2652778 0.374149
+ 2.2655556 0.335082
+ 2.2658333 0.292744
+ 2.2661111 0.248868
+ 2.2663889 0.205186
+ 2.2666667 0.163431
+ 2.2669444 0.125157
+ 2.2672222 0.091207
+ 2.2675000 0.062248
+ 2.2677778 0.050000
+ 2.2680556 0.050000
+ 2.2683333 0.050000
+ 2.2686111 0.050000
+ 2.2688889 0.050000
+ 2.2691667 0.050000
+ 2.2694444 0.055143
+ 2.2697222 0.089538
+ 2.2700000 0.131801
+ 2.2702778 0.179487
+ 2.2705556 0.230151
+ 2.2708333 0.281348
+ 2.2711111 0.330633
+ 2.2713889 0.375561
+ 2.2716667 0.413686
+ 2.2719444 0.442565
+ 2.2722222 0.459752
+ 2.2725000 0.463510
+ 2.2727778 0.454944
+ 2.2730556 0.435863
+ 2.2733333 0.408081
+ 2.2736111 0.373407
+ 2.2738889 0.333654
+ 2.2741667 0.290634
+ 2.2744444 0.246158
+ 2.2747222 0.202037
+ 2.2750000 0.160083
+ 2.2752778 0.121909
+ 2.2755556 0.088326
+ 2.2758333 0.059947
+ 2.2761111 0.050000
+ 2.2763889 0.050000
+ 2.2766667 0.050000
+ 2.2769444 0.050000
+ 2.2772222 0.050000
+ 2.2775000 0.050000
+ 2.2777778 0.058516
+ 2.2780556 0.093333
+ 2.2783333 0.135822
+ 2.2786111 0.183549
+ 2.2788889 0.234079
+ 2.2791667 0.284976
+ 2.2794444 0.333806
+ 2.2797222 0.378132
+ 2.2800000 0.415519
+ 2.2802778 0.443533
+ 2.2805556 0.459738
+ 2.2808333 0.462413
+ 2.2811111 0.452690
+ 2.2813889 0.432413
+ 2.2816667 0.403430
+ 2.2819444 0.367585
+ 2.2822222 0.326725
+ 2.2825000 0.282695
+ 2.2827778 0.237340
+ 2.2830556 0.192508
+ 2.2833333 0.150042
+ 2.2836111 0.111579
+ 2.2838889 0.077915
+ 2.2841667 0.050000
+ 2.2844444 0.050000
+ 2.2847222 0.050000
+ 2.2850000 0.050000
+ 2.2852778 0.050000
+ 2.2855556 0.050000
+ 2.2858333 0.050000
+ 2.2861111 0.051782
+ 2.2863889 0.087210
+ 2.2866667 0.130294
+ 2.2869444 0.178609
+ 2.2872222 0.229734
+ 2.2875000 0.281244
+ 2.2877778 0.330715
+ 2.2880556 0.375725
+ 2.2883333 0.413850
+ 2.2886111 0.442667
+ 2.2888889 0.459752
+ 2.2891667 0.463385
+ 2.2894444 0.454668
+ 2.2897222 0.435403
+ 2.2900000 0.407393
+ 2.2902778 0.372445
+ 2.2905556 0.332360
+ 2.2908333 0.288942
+ 2.2911111 0.243997
+ 2.2913889 0.199327
+ 2.2916667 0.156736
+ 2.2919444 0.117837
+ 2.2922222 0.083472
+ 2.2925000 0.054294
+ 2.2927778 0.050000
+ 2.2930556 0.050000
+ 2.2933333 0.050000
+ 2.2936111 0.050000
+ 2.2938889 0.050000
+ 2.2941667 0.050000
+ 2.2944444 0.050000
+ 2.2947222 0.085247
+ 2.2950000 0.128404
+ 2.2952778 0.176981
+ 2.2955556 0.228490
+ 2.2958333 0.280441
+ 2.2961111 0.330344
+ 2.2963889 0.375711
+ 2.2966667 0.414052
+ 2.2969444 0.442878
+ 2.2972222 0.459699
+ 2.2975000 0.462757
+ 2.2977778 0.453212
+ 2.2980556 0.432954
+ 2.2983333 0.403875
+ 2.2986111 0.367866
+ 2.2988889 0.326817
+ 2.2991667 0.282620
+ 2.2994444 0.237164
+ 2.2997222 0.192341
+ 2.3000000 0.150042
+ 2.3002778 0.111934
+ 2.3005556 0.078791
+ 2.3008333 0.051164
+ 2.3011111 0.050000
+ 2.3013889 0.050000
+ 2.3016667 0.050000
+ 2.3019444 0.050000
+ 2.3022222 0.050000
+ 2.3025000 0.050000
+ 2.3027778 0.058503
+ 2.3030556 0.094337
+ 2.3033333 0.137648
+ 2.3036111 0.185990
+ 2.3038889 0.236917
+ 2.3041667 0.287981
+ 2.3044444 0.336738
+ 2.3047222 0.380741
+ 2.3050000 0.417544
+ 2.3052778 0.444701
+ 2.3055556 0.459765
+ 2.3058333 0.461023
+ 2.3061111 0.449693
+ 2.3063889 0.427727
+ 2.3066667 0.397074
+ 2.3069444 0.359686
+ 2.3072222 0.317514
+ 2.3075000 0.272508
+ 2.3077778 0.226620
+ 2.3080556 0.181801
+ 2.3083333 0.140000
+ 2.3086111 0.102917
+ 2.3088889 0.071243
+ 2.3091667 0.050000
+ 2.3094444 0.050000
+ 2.3097222 0.050000
+ 2.3100000 0.050000
+ 2.3102778 0.050000
+ 2.3105556 0.050000
+ 2.3108333 0.050000
+ 2.3111111 0.065132
+ 2.3113889 0.101386
+ 2.3116667 0.144636
+ 2.3119444 0.192527
+ 2.3122222 0.242703
+ 2.3125000 0.292808
+ 2.3127778 0.340486
+ 2.3130556 0.383382
+ 2.3133333 0.419139
+ 2.3136111 0.445403
+ 2.3138889 0.459817
+ 2.3141667 0.460732
+ 2.3144444 0.449321
+ 2.3147222 0.427466
+ 2.3150000 0.397048
+ 2.3152778 0.359946
+ 2.3155556 0.318040
+ 2.3158333 0.273213
+ 2.3161111 0.227343
+ 2.3163889 0.182312
+ 2.3166667 0.140000
+ 2.3169444 0.102062
+ 2.3172222 0.069254
+ 2.3175000 0.050000
+ 2.3177778 0.050000
+ 2.3180556 0.050000
+ 2.3183333 0.050000
+ 2.3186111 0.050000
+ 2.3188889 0.050000
+ 2.3191667 0.050000
+ 2.3194444 0.055051
+ 2.3197222 0.091758
+ 2.3200000 0.135893
+ 2.3202778 0.184983
+ 2.3205556 0.236558
+ 2.3208333 0.288145
+ 2.3211111 0.337273
+ 2.3213889 0.381469
+ 2.3216667 0.418262
+ 2.3219444 0.445180
+ 2.3222222 0.459752
+ 2.3225000 0.460249
+ 2.3227778 0.447919
+ 2.3230556 0.424756
+ 2.3233333 0.392751
+ 2.3236111 0.353897
+ 2.3238889 0.310185
+ 2.3241667 0.263608
+ 2.3244444 0.216159
+ 2.3247222 0.169829
+ 2.3250000 0.126611
+ 2.3252778 0.088243
+ 2.3255556 0.055448
+ 2.3258333 0.050000
+ 2.3261111 0.050000
+ 2.3263889 0.050000
+ 2.3266667 0.050000
+ 2.3269444 0.050000
+ 2.3272222 0.050000
+ 2.3275000 0.050000
+ 2.3277778 0.050000
+ 2.3280556 0.087975
+ 2.3283333 0.133255
+ 2.3286111 0.183350
+ 2.3288889 0.235772
+ 2.3291667 0.288031
+ 2.3294444 0.337637
+ 2.3297222 0.382101
+ 2.3300000 0.418935
+ 2.3302778 0.445648
+ 2.3305556 0.459752
+ 2.3308333 0.459516
+ 2.3311111 0.446255
+ 2.3313889 0.422039
+ 2.3316667 0.388943
+ 2.3319444 0.349037
+ 2.3322222 0.304395
+ 2.3325000 0.257090
+ 2.3327778 0.209193
+ 2.3330556 0.162778
+ 2.3333333 0.119917
+ 2.3336111 0.082397
+ 2.3338889 0.050871
+ 2.3341667 0.050000
+ 2.3344444 0.050000
+ 2.3347222 0.050000
+ 2.3350000 0.050000
+ 2.3352778 0.050000
+ 2.3355556 0.050000
+ 2.3358333 0.050000
+ 2.3361111 0.058320
+ 2.3363889 0.096735
+ 2.3366667 0.142008
+ 2.3369444 0.191714
+ 2.3372222 0.243422
+ 2.3375000 0.294705
+ 2.3377778 0.343136
+ 2.3380556 0.386285
+ 2.3383333 0.421725
+ 2.3386111 0.447027
+ 2.3388889 0.459765
+ 2.3391667 0.458260
+ 2.3394444 0.443842
+ 2.3397222 0.418590
+ 2.3400000 0.384586
+ 2.3402778 0.343908
+ 2.3405556 0.298637
+ 2.3408333 0.250852
+ 2.3411111 0.202635
+ 2.3413889 0.156065
+ 2.3416667 0.113222
+ 2.3419444 0.075897
+ 2.3422222 0.050000
+ 2.3425000 0.050000
+ 2.3427778 0.050000
+ 2.3430556 0.050000
+ 2.3433333 0.050000
+ 2.3436111 0.050000
+ 2.3438889 0.050000
+ 2.3441667 0.050000
+ 2.3444444 0.058254
+ 2.3447222 0.097518
+ 2.3450000 0.143569
+ 2.3452778 0.193937
+ 2.3455556 0.246148
+ 2.3458333 0.297732
+ 2.3461111 0.346218
+ 2.3463889 0.389133
+ 2.3466667 0.424006
+ 2.3469444 0.448365
+ 2.3472222 0.459738
+ 2.3475000 0.456436
+ 2.3477778 0.439891
+ 2.3480556 0.412317
+ 2.3483333 0.375929
+ 2.3486111 0.332940
+ 2.3488889 0.285565
+ 2.3491667 0.236018
+ 2.3494444 0.186513
+ 2.3497222 0.139264
+ 2.3500000 0.096486
+ 2.3502778 0.060055
+ 2.3505556 0.050000
+ 2.3508333 0.050000
+ 2.3511111 0.050000
+ 2.3513889 0.050000
+ 2.3516667 0.050000
+ 2.3519444 0.050000
+ 2.3522222 0.050000
+ 2.3525000 0.050000
+ 2.3527778 0.064962
+ 2.3530556 0.105600
+ 2.3533333 0.152439
+ 2.3536111 0.203057
+ 2.3538889 0.255032
+ 2.3541667 0.305942
+ 2.3544444 0.353365
+ 2.3547222 0.394880
+ 2.3550000 0.428063
+ 2.3552778 0.450495
+ 2.3555556 0.459752
+ 2.3558333 0.454194
+ 2.3561111 0.435307
+ 2.3563889 0.405357
+ 2.3566667 0.366613
+ 2.3569444 0.321340
+ 2.3572222 0.271807
+ 2.3575000 0.220279
+ 2.3577778 0.169024
+ 2.3580556 0.120310
+ 2.3583333 0.076403
+ 2.3586111 0.050000
+ 2.3588889 0.050000
+ 2.3591667 0.050000
+ 2.3594444 0.050000
+ 2.3597222 0.050000
+ 2.3600000 0.050000
+ 2.3602778 0.050000
+ 2.3605556 0.050000
+ 2.3608333 0.050000
+ 2.3611111 0.050000
+ 2.3613889 0.092154
+ 2.3616667 0.140576
+ 2.3619444 0.192817
+ 2.3622222 0.246428
+ 2.3625000 0.298960
+ 2.3627778 0.347965
+ 2.3630556 0.390995
+ 2.3633333 0.425599
+ 2.3636111 0.449330
+ 2.3638889 0.459738
+ 2.3641667 0.455164
+ 2.3644444 0.437094
+ 2.3647222 0.407803
+ 2.3650000 0.369569
+ 2.3652778 0.324665
+ 2.3655556 0.275367
+ 2.3658333 0.223952
+ 2.3661111 0.172693
+ 2.3663889 0.123868
+ 2.3666667 0.079750
+ 2.3669444 0.050000
+ 2.3672222 0.050000
+ 2.3675000 0.050000
+ 2.3677778 0.050000
+ 2.3680556 0.050000
+ 2.3683333 0.050000
+ 2.3686111 0.050000
+ 2.3688889 0.050000
+ 2.3691667 0.050000
+ 2.3694444 0.050000
+ 2.3697222 0.092178
+ 2.3700000 0.140720
+ 2.3702778 0.193138
+ 2.3705556 0.246945
+ 2.3708333 0.299653
+ 2.3711111 0.348776
+ 2.3713889 0.391825
+ 2.3716667 0.426314
+ 2.3719444 0.449755
+ 2.3722222 0.459660
+ 2.3725000 0.454349
+ 2.3727778 0.435364
+ 2.3730556 0.405053
+ 2.3733333 0.365766
+ 2.3736111 0.319850
+ 2.3738889 0.269656
+ 2.3741667 0.217530
+ 2.3744444 0.165822
+ 2.3747222 0.116881
+ 2.3750000 0.073055
+ 2.3752778 0.050000
+ 2.3755556 0.050000
+ 2.3758333 0.050000
+ 2.3761111 0.050000
+ 2.3763889 0.050000
+ 2.3766667 0.050000
+ 2.3769444 0.050000
+ 2.3772222 0.050000
+ 2.3775000 0.050000
+ 2.3777778 0.054868
+ 2.3780556 0.096809
+ 2.3783333 0.144678
+ 2.3786111 0.196131
+ 2.3788889 0.248824
+ 2.3791667 0.300414
+ 2.3794444 0.348555
+ 2.3797222 0.390905
+ 2.3800000 0.425120
+ 2.3802778 0.448854
+ 2.3805556 0.459765
+ 2.3808333 0.456256
+ 2.3811111 0.439727
+ 2.3813889 0.412326
+ 2.3816667 0.376200
+ 2.3819444 0.333496
+ 2.3822222 0.286363
+ 2.3825000 0.236948
+ 2.3827778 0.187398
+ 2.3830556 0.139862
+ 2.3833333 0.096486
+ 2.3836111 0.059105
+ 2.3838889 0.050000
+ 2.3841667 0.050000
+ 2.3844444 0.050000
+ 2.3847222 0.050000
+ 2.3850000 0.050000
+ 2.3852778 0.050000
+ 2.3855556 0.050000
+ 2.3858333 0.050000
+ 2.3861111 0.050000
+ 2.3863889 0.089747
+ 2.3866667 0.136071
+ 2.3869444 0.186608
+ 2.3872222 0.238995
+ 2.3875000 0.290867
+ 2.3877778 0.339860
+ 2.3880556 0.383611
+ 2.3883333 0.419754
+ 2.3886111 0.445927
+ 2.3888889 0.459765
+ 2.3891667 0.459634
+ 2.3894444 0.446822
+ 2.3897222 0.423347
+ 2.3900000 0.391226
+ 2.3902778 0.352479
+ 2.3905556 0.309122
+ 2.3908333 0.263173
+ 2.3911111 0.216651
+ 2.3913889 0.171574
+ 2.3916667 0.129958
+ 2.3919444 0.093544
+ 2.3922222 0.062949
+ 2.3925000 0.050000
+ 2.3927778 0.050000
+ 2.3930556 0.050000
+ 2.3933333 0.050000
+ 2.3936111 0.050000
+ 2.3938889 0.050000
+ 2.3941667 0.050000
+ 2.3944444 0.068453
+ 2.3947222 0.105083
+ 2.3950000 0.148320
+ 2.3952778 0.195896
+ 2.3955556 0.245540
+ 2.3958333 0.294984
+ 2.3961111 0.341960
+ 2.3963889 0.384197
+ 2.3966667 0.419427
+ 2.3969444 0.445382
+ 2.3972222 0.459791
+ 2.3975000 0.461076
+ 2.3977778 0.450421
+ 2.3980556 0.429697
+ 2.3983333 0.400780
+ 2.3986111 0.365540
+ 2.3988889 0.325853
+ 2.3991667 0.283590
+ 2.3994444 0.240626
+ 2.3997222 0.198832
+ 2.4000000 0.160083
+ 2.4002778 0.125999
+ 2.4005556 0.097184
+ 2.4008333 0.073992
+ 2.4011111 0.056775
+ 2.4013889 0.050000
+ 2.4016667 0.050000
+ 2.4019444 0.050000
+ 2.4022222 0.054711
+ 2.4025000 0.072658
+ 2.4027778 0.098696
+ 2.4030556 0.132755
+ 2.4033333 0.173079
+ 2.4036111 0.217490
+ 2.4038889 0.263812
+ 2.4041667 0.309866
+ 2.4044444 0.353476
+ 2.4047222 0.392462
+ 2.4050000 0.424648
+ 2.4052778 0.447856
+ 2.4055556 0.459908
+ 2.4058333 0.459297
+ 2.4061111 0.447188
+ 2.4063889 0.425417
+ 2.4066667 0.395822
+ 2.4069444 0.360237
+ 2.4072222 0.320499
+ 2.4075000 0.278444
+ 2.4077778 0.235908
+ 2.4080556 0.194727
+ 2.4083333 0.156736
+ 2.4086111 0.123518
+ 2.4088889 0.095638
+ 2.4091667 0.073406
+ 2.4094444 0.057133
+ 2.4097222 0.050000
+ 2.4100000 0.050000
+ 2.4102778 0.050000
+ 2.4105556 0.057849
+ 2.4108333 0.076034
+ 2.4111111 0.102043
+ 2.4113889 0.135786
+ 2.4116667 0.175569
+ 2.4119444 0.219298
+ 2.4122222 0.264878
+ 2.4125000 0.310215
+ 2.4127778 0.353215
+ 2.4130556 0.391782
+ 2.4133333 0.423823
+ 2.4136111 0.447243
+ 2.4138889 0.459948
+ 2.4141667 0.460479
+ 2.4144444 0.449925
+ 2.4147222 0.430012
+ 2.4150000 0.402464
+ 2.4152778 0.369008
+ 2.4155556 0.331367
+ 2.4158333 0.291268
+ 2.4161111 0.250436
+ 2.4163889 0.210596
+ 2.4166667 0.173472
+ 2.4169444 0.140569
+ 2.4172222 0.112498
+ 2.4175000 0.089651
+ 2.4177778 0.072417
+ 2.4180556 0.061187
+ 2.4183333 0.056352
+ 2.4186111 0.058301
+ 2.4188889 0.067426
+ 2.4191667 0.084117
+ 2.4194444 0.108764
+ 2.4197222 0.141338
+ 2.4200000 0.180138
+ 2.4202778 0.223040
+ 2.4205556 0.267922
+ 2.4208333 0.312663
+ 2.4211111 0.355140
+ 2.4213889 0.393232
+ 2.4216667 0.424816
+ 2.4219444 0.447771
+ 2.4222222 0.459974
+ 2.4225000 0.459953
+ 2.4227778 0.448834
+ 2.4230556 0.428393
+ 2.4233333 0.400406
+ 2.4236111 0.366650
+ 2.4238889 0.328899
+ 2.4241667 0.288930
+ 2.4244444 0.248518
+ 2.4247222 0.209440
+ 2.4250000 0.173472
+ 2.4252778 0.142139
+ 2.4255556 0.115968
+ 2.4258333 0.095235
+ 2.4261111 0.080214
+ 2.4263889 0.071184
+ 2.4266667 0.068419
+ 2.4269444 0.072196
+ 2.4272222 0.082791
+ 2.4275000 0.100480
+ 2.4277778 0.125539
+ 2.4280556 0.157862
+ 2.4283333 0.195813
+ 2.4286111 0.237377
+ 2.4288889 0.280535
+ 2.4291667 0.323271
+ 2.4294444 0.363569
+ 2.4297222 0.399410
+ 2.4300000 0.428778
+ 2.4302778 0.449656
+ 2.4305556 0.460026
+ 2.4308333 0.458497
+ 2.4311111 0.446175
+ 2.4313889 0.424791
+ 2.4316667 0.396076
+ 2.4319444 0.361761
+ 2.4322222 0.323577
+ 2.4325000 0.283256
+ 2.4327778 0.242528
+ 2.4330556 0.203125
+ 2.4333333 0.166778
+ 2.4336111 0.134980
+ 2.4338889 0.108280
+ 2.4341667 0.086988
+ 2.4344444 0.071414
+ 2.4347222 0.061869
+ 2.4350000 0.058663
+ 2.4352778 0.062108
+ 2.4355556 0.072512
+ 2.4358333 0.090188
+ 2.4361111 0.115445
+ 2.4363889 0.148201
+ 2.4366667 0.186799
+ 2.4369444 0.229191
+ 2.4372222 0.273326
+ 2.4375000 0.317157
+ 2.4377778 0.358632
+ 2.4380556 0.395704
+ 2.4383333 0.426322
+ 2.4386111 0.448437
+ 2.4388889 0.460000
+ 2.4391667 0.459591
+ 2.4394444 0.448305
+ 2.4397222 0.427868
+ 2.4400000 0.400005
+ 2.4402778 0.366440
+ 2.4405556 0.328899
+ 2.4408333 0.289107
+ 2.4411111 0.248788
+ 2.4413889 0.209668
+ 2.4416667 0.173472
+ 2.4419444 0.141692
+ 2.4422222 0.114887
+ 2.4425000 0.093385
+ 2.4427778 0.077512
+ 2.4430556 0.067595
+ 2.4433333 0.063961
+ 2.4436111 0.066937
+ 2.4438889 0.076850
+ 2.4441667 0.094026
+ 2.4444444 0.118792
+ 2.4447222 0.151080
+ 2.4450000 0.189236
+ 2.4452778 0.231213
+ 2.4455556 0.274961
+ 2.4458333 0.318433
+ 2.4461111 0.359579
+ 2.4463889 0.396353
+ 2.4466667 0.426704
+ 2.4469444 0.448585
+ 2.4472222 0.459948
+ 2.4475000 0.459369
+ 2.4477778 0.447928
+ 2.4480556 0.427333
+ 2.4483333 0.399288
+ 2.4486111 0.365501
+ 2.4488889 0.327676
+ 2.4491667 0.287520
+ 2.4494444 0.246739
+ 2.4497222 0.207038
+ 2.4500000 0.170125
+ 2.4502778 0.137484
+ 2.4505556 0.109716
+ 2.4508333 0.087204
+ 2.4511111 0.070328
+ 2.4513889 0.059470
+ 2.4516667 0.055009
+ 2.4519444 0.057329
+ 2.4522222 0.066809
+ 2.4525000 0.083831
+ 2.4527778 0.108777
+ 2.4530556 0.141608
+ 2.4533333 0.180617
+ 2.4536111 0.223678
+ 2.4538889 0.268665
+ 2.4541667 0.313450
+ 2.4544444 0.355909
+ 2.4547222 0.393914
+ 2.4550000 0.425340
+ 2.4552778 0.448060
+ 2.4555556 0.459948
+ 2.4558333 0.459525
+ 2.4561111 0.447908
+ 2.4563889 0.426856
+ 2.4566667 0.398135
+ 2.4569444 0.363506
+ 2.4572222 0.324731
+ 2.4575000 0.283573
+ 2.4577778 0.241796
+ 2.4580556 0.201161
+ 2.4583333 0.163431
+ 2.4586111 0.130137
+ 2.4588889 0.101883
+ 2.4591667 0.079042
+ 2.4594444 0.061987
+ 2.4597222 0.051091
+ 2.4600000 0.050000
+ 2.4602778 0.050000
+ 2.4605556 0.059079
+ 2.4608333 0.076544
+ 2.4611111 0.102030
+ 2.4613889 0.135491
+ 2.4616667 0.175198
+ 2.4619444 0.219004
+ 2.4622222 0.264760
+ 2.4625000 0.310317
+ 2.4627778 0.353529
+ 2.4630556 0.392246
+ 2.4633333 0.424320
+ 2.4636111 0.447603
+ 2.4638889 0.459948
+ 2.4641667 0.459859
+ 2.4644444 0.448461
+ 2.4647222 0.427530
+ 2.4650000 0.398845
+ 2.4652778 0.364183
+ 2.4655556 0.325321
+ 2.4658333 0.284038
+ 2.4661111 0.242110
+ 2.4663889 0.201315
+ 2.4666667 0.163431
+ 2.4669444 0.130001
+ 2.4672222 0.101635
+ 2.4675000 0.078707
+ 2.4677778 0.061594
+ 2.4680556 0.050670
+ 2.4683333 0.050000
+ 2.4686111 0.050000
+ 2.4688889 0.058789
+ 2.4691667 0.076376
+ 2.4694444 0.102030
+ 2.4697222 0.135700
+ 2.4700000 0.175637
+ 2.4702778 0.219669
+ 2.4705556 0.265620
+ 2.4708333 0.311317
+ 2.4711111 0.354586
+ 2.4713889 0.393254
+ 2.4716667 0.425146
+ 2.4719444 0.448089
+ 2.4722222 0.459908
+ 2.4725000 0.459100
+ 2.4727778 0.446832
+ 2.4730556 0.424944
+ 2.4733333 0.395273
+ 2.4736111 0.359657
+ 2.4738889 0.319934
+ 2.4741667 0.277942
+ 2.4744444 0.235520
+ 2.4747222 0.194506
+ 2.4750000 0.156736
+ 2.4752778 0.123794
+ 2.4755556 0.096234
+ 2.4758333 0.074356
+ 2.4761111 0.058458
+ 2.4763889 0.050000
+ 2.4766667 0.050000
+ 2.4769444 0.050000
+ 2.4772222 0.060657
+ 2.4775000 0.079149
+ 2.4777778 0.105416
+ 2.4780556 0.139357
+ 2.4783333 0.179260
+ 2.4786111 0.223017
+ 2.4788889 0.268517
+ 2.4791667 0.313648
+ 2.4794444 0.356300
+ 2.4797222 0.394363
+ 2.4800000 0.425726
+ 2.4802778 0.448278
+ 2.4805556 0.459908
+ 2.4808333 0.459156
+ 2.4811111 0.447155
+ 2.4813889 0.425686
+ 2.4816667 0.396534
+ 2.4819444 0.361481
+ 2.4822222 0.322308
+ 2.4825000 0.280800
+ 2.4827778 0.238738
+ 2.4830556 0.197905
+ 2.4833333 0.160083
+ 2.4836111 0.126819
+ 2.4838889 0.098705
+ 2.4841667 0.076098
+ 2.4844444 0.059355
+ 2.4847222 0.050000
+ 2.4850000 0.050000
+ 2.4852778 0.050000
+ 2.4855556 0.058147
+ 2.4858333 0.076068
+ 2.4861111 0.101991
+ 2.4863889 0.135852
+ 2.4866667 0.175909
+ 2.4869444 0.220000
+ 2.4872222 0.265962
+ 2.4875000 0.311632
+ 2.4877778 0.354848
+ 2.4880556 0.393447
+ 2.4883333 0.425267
+ 2.4886111 0.448146
+ 2.4888889 0.459922
+ 2.4891667 0.459092
+ 2.4894444 0.446807
+ 2.4897222 0.424877
+ 2.4900000 0.395112
+ 2.4902778 0.359323
+ 2.4905556 0.319321
+ 2.4908333 0.276916
+ 2.4911111 0.233918
+ 2.4913889 0.192139
+ 2.4916667 0.153389
+ 2.4919444 0.119239
+ 2.4922222 0.090307
+ 2.4925000 0.066969
+ 2.4927778 0.050000
+ 2.4930556 0.050000
+ 2.4933333 0.050000
+ 2.4936111 0.050000
+ 2.4938889 0.050000
+ 2.4941667 0.065549
+ 2.4944444 0.091936
+ 2.4947222 0.126504
+ 2.4950000 0.167471
+ 2.4952778 0.212622
+ 2.4955556 0.259744
+ 2.4958333 0.306623
+ 2.4961111 0.351044
+ 2.4963889 0.390793
+ 2.4966667 0.423657
+ 2.4969444 0.447420
+ 2.4972222 0.459869
+ 2.4975000 0.459465
+ 2.4977778 0.447369
+ 2.4980556 0.425418
+ 2.4983333 0.395447
+ 2.4986111 0.359292
+ 2.4988889 0.318791
+ 2.4991667 0.275779
+ 2.4994444 0.232093
+ 2.4997222 0.189568
+ 2.5000000 0.150042
+ 2.5002778 0.115111
+ 2.5005556 0.085421
+ 2.5008333 0.061377
+ 2.5011111 0.050000
+ 2.5013889 0.050000
+ 2.5016667 0.050000
+ 2.5019444 0.050000
+ 2.5022222 0.050000
+ 2.5025000 0.058401
+ 2.5027778 0.085241
+ 2.5030556 0.120524
+ 2.5033333 0.162406
+ 2.5036111 0.208594
+ 2.5038889 0.256795
+ 2.5041667 0.304715
+ 2.5044444 0.350061
+ 2.5047222 0.390540
+ 2.5050000 0.423859
+ 2.5052778 0.447724
+ 2.5055556 0.459843
+ 2.5058333 0.458628
+ 2.5061111 0.445317
+ 2.5063889 0.421854
+ 2.5066667 0.390182
+ 2.5069444 0.352247
+ 2.5072222 0.309992
+ 2.5075000 0.265361
+ 2.5077778 0.220298
+ 2.5080556 0.176747
+ 2.5083333 0.136653
+ 2.5086111 0.101687
+ 2.5088889 0.072435
+ 2.5091667 0.050000
+ 2.5094444 0.050000
+ 2.5097222 0.050000
+ 2.5100000 0.050000
+ 2.5102778 0.050000
+ 2.5105556 0.050000
+ 2.5108333 0.054086
+ 2.5111111 0.081868
+ 2.5113889 0.117772
+ 2.5116667 0.160005
+ 2.5119444 0.206351
+ 2.5122222 0.254595
+ 2.5125000 0.302523
+ 2.5127778 0.347919
+ 2.5130556 0.388568
+ 2.5133333 0.422255
+ 2.5136111 0.446765
+ 2.5138889 0.459882
+ 2.5141667 0.460065
+ 2.5144444 0.448463
+ 2.5147222 0.426897
+ 2.5150000 0.397191
+ 2.5152778 0.361166
+ 2.5155556 0.320645
+ 2.5158333 0.277450
+ 2.5161111 0.233403
+ 2.5163889 0.190326
+ 2.5166667 0.150042
+ 2.5169444 0.114146
+ 2.5172222 0.083328
+ 2.5175000 0.058051
+ 2.5177778 0.050000
+ 2.5180556 0.050000
+ 2.5183333 0.050000
+ 2.5186111 0.050000
+ 2.5188889 0.050000
+ 2.5191667 0.050000
+ 2.5194444 0.075174
+ 2.5197222 0.110436
+ 2.5200000 0.152617
+ 2.5202778 0.199390
+ 2.5205556 0.248426
+ 2.5208333 0.297397
+ 2.5211111 0.343977
+ 2.5213889 0.385836
+ 2.5216667 0.420648
+ 2.5219444 0.446084
+ 2.5222222 0.459817
+ 2.5225000 0.460224
+ 2.5227778 0.448504
+ 2.5230556 0.426562
+ 2.5233333 0.396302
+ 2.5236111 0.359627
+ 2.5238889 0.318443
+ 2.5241667 0.274653
+ 2.5244444 0.230162
+ 2.5247222 0.186875
+ 2.5250000 0.146694
+ 2.5252778 0.111273
+ 2.5255556 0.081251
+ 2.5258333 0.057014
+ 2.5261111 0.050000
+ 2.5263889 0.050000
+ 2.5266667 0.050000
+ 2.5269444 0.050000
+ 2.5272222 0.050000
+ 2.5275000 0.054796
+ 2.5277778 0.081907
+ 2.5280556 0.117457
+ 2.5283333 0.159605
+ 2.5286111 0.206063
+ 2.5288889 0.254545
+ 2.5291667 0.302763
+ 2.5294444 0.348431
+ 2.5297222 0.389261
+ 2.5300000 0.422967
+ 2.5302778 0.447261
+ 2.5305556 0.459856
+ 2.5308333 0.459167
+ 2.5311111 0.446410
+ 2.5313889 0.423502
+ 2.5316667 0.392361
+ 2.5319444 0.354905
+ 2.5322222 0.313050
+ 2.5325000 0.268715
+ 2.5327778 0.223816
+ 2.5330556 0.180272
+ 2.5333333 0.140000
+ 2.5336111 0.104656
+ 2.5338889 0.074856
+ 2.5341667 0.050953
+ 2.5344444 0.050000
+ 2.5347222 0.050000
+ 2.5350000 0.050000
+ 2.5352778 0.050000
+ 2.5355556 0.050000
+ 2.5358333 0.051204
+ 2.5361111 0.078495
+ 2.5363889 0.114085
+ 2.5366667 0.156178
+ 2.5369444 0.202548
+ 2.5372222 0.250968
+ 2.5375000 0.299212
+ 2.5377778 0.345054
+ 2.5380556 0.386267
+ 2.5383333 0.420625
+ 2.5386111 0.445901
+ 2.5388889 0.459869
+ 2.5391667 0.460972
+ 2.5394444 0.450328
+ 2.5397222 0.429724
+ 2.5400000 0.400946
+ 2.5402778 0.365784
+ 2.5405556 0.326022
+ 2.5408333 0.283450
+ 2.5411111 0.239853
+ 2.5413889 0.197020
+ 2.5416667 0.156736
+ 2.5419444 0.120578
+ 2.5422222 0.089271
+ 2.5425000 0.063330
+ 2.5427778 0.050000
+ 2.5430556 0.050000
+ 2.5433333 0.050000
+ 2.5436111 0.050000
+ 2.5438889 0.050000
+ 2.5441667 0.050000
+ 2.5444444 0.075174
+ 2.5447222 0.110187
+ 2.5450000 0.152303
+ 2.5452778 0.199147
+ 2.5455556 0.248341
+ 2.5458333 0.297510
+ 2.5461111 0.344278
+ 2.5463889 0.386269
+ 2.5466667 0.421106
+ 2.5469444 0.446414
+ 2.5472222 0.459817
+ 2.5475000 0.459662
+ 2.5477778 0.447191
+ 2.5480556 0.424371
+ 2.5483333 0.393167
+ 2.5486111 0.355547
+ 2.5488889 0.313475
+ 2.5491667 0.268918
+ 2.5494444 0.223843
+ 2.5497222 0.180215
+ 2.5500000 0.140000
+ 2.5502778 0.104892
+ 2.5505556 0.075492
+ 2.5508333 0.052129
+ 2.5511111 0.050000
+ 2.5513889 0.050000
+ 2.5516667 0.050000
+ 2.5519444 0.050000
+ 2.5522222 0.050000
+ 2.5525000 0.057139
+ 2.5527778 0.085241
+ 2.5530556 0.121573
+ 2.5533333 0.164277
+ 2.5536111 0.211058
+ 2.5538889 0.259620
+ 2.5541667 0.307669
+ 2.5544444 0.352908
+ 2.5547222 0.393043
+ 2.5550000 0.425778
+ 2.5552778 0.448819
+ 2.5555556 0.459869
+ 2.5558333 0.457355
+ 2.5561111 0.442584
+ 2.5563889 0.417584
+ 2.5566667 0.384385
+ 2.5569444 0.345016
+ 2.5572222 0.301504
+ 2.5575000 0.255880
+ 2.5577778 0.210170
+ 2.5580556 0.166404
+ 2.5583333 0.126611
+ 2.5586111 0.092514
+ 2.5588889 0.064618
+ 2.5591667 0.050000
+ 2.5594444 0.050000
+ 2.5597222 0.050000
+ 2.5600000 0.050000
+ 2.5602778 0.050000
+ 2.5605556 0.050000
+ 2.5608333 0.059648
+ 2.5611111 0.088510
+ 2.5613889 0.124973
+ 2.5616667 0.167287
+ 2.5619444 0.213314
+ 2.5622222 0.260916
+ 2.5625000 0.307955
+ 2.5627778 0.352292
+ 2.5630556 0.391788
+ 2.5633333 0.424307
+ 2.5636111 0.447709
+ 2.5638889 0.459856
+ 2.5641667 0.459268
+ 2.5644444 0.447098
+ 2.5647222 0.425156
+ 2.5650000 0.395253
+ 2.5652778 0.359199
+ 2.5655556 0.318805
+ 2.5658333 0.275881
+ 2.5661111 0.232239
+ 2.5663889 0.189689
+ 2.5666667 0.150042
+ 2.5669444 0.114878
+ 2.5672222 0.084859
+ 2.5675000 0.060420
+ 2.5677778 0.050000
+ 2.5680556 0.050000
+ 2.5683333 0.050000
+ 2.5686111 0.050000
+ 2.5688889 0.050000
+ 2.5691667 0.055167
+ 2.5694444 0.081894
+ 2.5697222 0.117204
+ 2.5700000 0.159239
+ 2.5702778 0.205685
+ 2.5705556 0.254226
+ 2.5708333 0.302547
+ 2.5711111 0.348334
+ 2.5713889 0.389270
+ 2.5716667 0.423042
+ 2.5719444 0.447333
+ 2.5722222 0.459830
+ 2.5725000 0.458930
+ 2.5727778 0.445884
+ 2.5730556 0.422657
+ 2.5733333 0.391213
+ 2.5736111 0.353516
+ 2.5738889 0.311531
+ 2.5741667 0.267223
+ 2.5744444 0.222555
+ 2.5747222 0.179493
+ 2.5750000 0.140000
+ 2.5752778 0.105759
+ 2.5755556 0.077327
+ 2.5758333 0.054978
+ 2.5761111 0.050000
+ 2.5763889 0.050000
+ 2.5766667 0.050000
+ 2.5769444 0.050000
+ 2.5772222 0.050000
+ 2.5775000 0.064012
+ 2.5777778 0.091936
+ 2.5780556 0.127728
+ 2.5783333 0.169603
+ 2.5786111 0.215363
+ 2.5788889 0.262811
+ 2.5791667 0.309749
+ 2.5794444 0.353981
+ 2.5797222 0.393307
+ 2.5800000 0.425531
+ 2.5802778 0.448455
+ 2.5805556 0.459882
+ 2.5808333 0.458293
+ 2.5811111 0.444881
+ 2.5813889 0.421519
+ 2.5816667 0.390078
+ 2.5819444 0.352433
+ 2.5822222 0.310454
+ 2.5825000 0.266014
+ 2.5827778 0.220986
+ 2.5830556 0.177241
+ 2.5833333 0.136653
+ 2.5836111 0.100848
+ 2.5838889 0.070478
+ 2.5841667 0.050000
+ 2.5844444 0.050000
+ 2.5847222 0.050000
+ 2.5850000 0.050000
+ 2.5852778 0.050000
+ 2.5855556 0.050000
+ 2.5858333 0.050000
+ 2.5861111 0.071800
+ 2.5863889 0.108129
+ 2.5866667 0.151215
+ 2.5869444 0.198730
+ 2.5872222 0.248347
+ 2.5875000 0.297739
+ 2.5877778 0.344579
+ 2.5880556 0.386539
+ 2.5883333 0.421292
+ 2.5886111 0.446511
+ 2.5888889 0.459869
+ 2.5891667 0.459750
+ 2.5894444 0.447380
+ 2.5897222 0.424698
+ 2.5900000 0.393642
+ 2.5902778 0.356150
+ 2.5905556 0.314162
+ 2.5908333 0.269614
+ 2.5911111 0.224446
+ 2.5913889 0.180595
+ 2.5916667 0.140000
+ 2.5919444 0.104338
+ 2.5922222 0.074242
+ 2.5925000 0.050083
+ 2.5927778 0.050000
+ 2.5930556 0.050000
+ 2.5933333 0.050000
+ 2.5936111 0.050000
+ 2.5938889 0.050000
+ 2.5941667 0.050660
+ 2.5944444 0.078482
+ 2.5947222 0.114769
+ 2.5950000 0.157650
+ 2.5952778 0.204807
+ 2.5955556 0.253921
+ 2.5958333 0.302671
+ 2.5961111 0.348740
+ 2.5963889 0.389809
+ 2.5966667 0.423557
+ 2.5969444 0.447666
+ 2.5972222 0.459817
+ 2.5975000 0.458414
+ 2.5977778 0.444754
+ 2.5980556 0.420858
+ 2.5983333 0.388745
+ 2.5986111 0.350436
+ 2.5988889 0.307950
+ 2.5991667 0.263309
+ 2.5994444 0.218532
+ 2.5997222 0.175640
+ 2.6000000 0.136653
+ 2.6002778 0.103286
+ 2.6005556 0.076041
+ 2.6008333 0.055113
+ 2.6011111 0.050000
+ 2.6013889 0.050000
+ 2.6016667 0.050000
+ 2.6019444 0.050000
+ 2.6022222 0.052091
+ 2.6025000 0.073183
+ 2.6027778 0.101965
+ 2.6030556 0.138236
+ 2.6033333 0.180214
+ 2.6036111 0.225720
+ 2.6038889 0.272574
+ 2.6041667 0.318598
+ 2.6044444 0.361611
+ 2.6047222 0.399436
+ 2.6050000 0.429893
+ 2.6052778 0.450803
+ 2.6055556 0.459987
+ 2.6058333 0.455968
+ 2.6061111 0.440080
+ 2.6063889 0.414357
+ 2.6066667 0.380837
+ 2.6069444 0.341555
+ 2.6072222 0.298546
+ 2.6075000 0.253846
+ 2.6077778 0.209491
+ 2.6080556 0.167516
+ 2.6083333 0.129958
+ 2.6086111 0.098522
+ 2.6088889 0.073595
+ 2.6091667 0.055233
+ 2.6094444 0.050000
+ 2.6097222 0.050000
+ 2.6100000 0.050000
+ 2.6102778 0.050000
+ 2.6105556 0.063880
+ 2.6108333 0.086097
+ 2.6111111 0.115275
+ 2.6113889 0.151128
+ 2.6116667 0.192001
+ 2.6119444 0.235897
+ 2.6122222 0.280818
+ 2.6125000 0.324767
+ 2.6127778 0.365746
+ 2.6130556 0.401758
+ 2.6133333 0.430804
+ 2.6136111 0.450889
+ 2.6138889 0.460013
+ 2.6141667 0.456828
+ 2.6144444 0.442574
+ 2.6147222 0.419141
+ 2.6150000 0.388417
+ 2.6152778 0.352290
+ 2.6155556 0.312651
+ 2.6158333 0.271387
+ 2.6161111 0.230387
+ 2.6163889 0.191541
+ 2.6166667 0.156736
+ 2.6169444 0.127558
+ 2.6172222 0.104373
+ 2.6175000 0.087245
+ 2.6177778 0.076235
+ 2.6180556 0.071407
+ 2.6183333 0.072823
+ 2.6186111 0.080546
+ 2.6188889 0.094639
+ 2.6191667 0.115164
+ 2.6194444 0.142184
+ 2.6197222 0.175438
+ 2.6200000 0.213372
+ 2.6202778 0.254109
+ 2.6205556 0.295772
+ 2.6208333 0.336483
+ 2.6211111 0.374365
+ 2.6213889 0.407540
+ 2.6216667 0.434131
+ 2.6219444 0.452261
+ 2.6222222 0.460052
+ 2.6225000 0.456238
+ 2.6227778 0.441993
+ 2.6230556 0.419103
+ 2.6233333 0.389353
+ 2.6236111 0.354528
+ 2.6238889 0.316415
+ 2.6241667 0.276798
+ 2.6244444 0.237462
+ 2.6247222 0.200194
+ 2.6250000 0.166778
+ 2.6252778 0.138715
+ 2.6255556 0.116365
+ 2.6258333 0.099803
+ 2.6261111 0.089104
+ 2.6263889 0.084344
+ 2.6266667 0.085598
+ 2.6269444 0.092940
+ 2.6272222 0.106446
+ 2.6275000 0.126192
+ 2.6277778 0.152251
+ 2.6280556 0.184384
+ 2.6283333 0.221082
+ 2.6286111 0.260520
+ 2.6288889 0.300876
+ 2.6291667 0.340325
+ 2.6294444 0.377043
+ 2.6297222 0.409205
+ 2.6300000 0.434987
+ 2.6302778 0.452566
+ 2.6305556 0.460118
+ 2.6308333 0.456401
+ 2.6311111 0.442512
+ 2.6313889 0.420131
+ 2.6316667 0.390938
+ 2.6319444 0.356611
+ 2.6322222 0.318831
+ 2.6325000 0.279279
+ 2.6327778 0.239632
+ 2.6330556 0.201572
+ 2.6333333 0.166778
+ 2.6336111 0.136690
+ 2.6338889 0.111793
+ 2.6341667 0.092330
+ 2.6344444 0.078547
+ 2.6347222 0.070688
+ 2.6350000 0.068997
+ 2.6352778 0.073719
+ 2.6355556 0.085098
+ 2.6358333 0.103380
+ 2.6361111 0.128808
+ 2.6363889 0.161257
+ 2.6366667 0.199122
+ 2.6369444 0.240429
+ 2.6372222 0.283203
+ 2.6375000 0.325469
+ 2.6377778 0.365252
+ 2.6380556 0.400578
+ 2.6383333 0.429472
+ 2.6386111 0.449960
+ 2.6388889 0.460065
+ 2.6391667 0.458429
+ 2.6394444 0.446149
+ 2.6397222 0.424936
+ 2.6400000 0.396502
+ 2.6402778 0.362560
+ 2.6405556 0.324820
+ 2.6408333 0.284995
+ 2.6411111 0.244796
+ 2.6413889 0.205935
+ 2.6416667 0.170125
+ 2.6419444 0.138842
+ 2.6422222 0.112628
+ 2.6425000 0.091787
+ 2.6427778 0.076628
+ 2.6430556 0.067455
+ 2.6433333 0.064575
+ 2.6436111 0.068295
+ 2.6438889 0.078921
+ 2.6441667 0.096758
+ 2.6444444 0.122113
+ 2.6447222 0.154897
+ 2.6450000 0.193431
+ 2.6452778 0.235644
+ 2.6455556 0.279461
+ 2.6458333 0.322810
+ 2.6461111 0.363618
+ 2.6463889 0.399812
+ 2.6466667 0.429318
+ 2.6469444 0.450063
+ 2.6472222 0.459974
+ 2.6475000 0.457634
+ 2.6477778 0.444252
+ 2.6480556 0.421692
+ 2.6483333 0.391819
+ 2.6486111 0.356498
+ 2.6488889 0.317593
+ 2.6491667 0.276969
+ 2.6494444 0.236491
+ 2.6497222 0.198023
+ 2.6500000 0.163431
+ 2.6502778 0.134282
+ 2.6505556 0.110967
+ 2.6508333 0.093577
+ 2.6511111 0.082205
+ 2.6513889 0.076944
+ 2.6516667 0.077887
+ 2.6519444 0.085128
+ 2.6522222 0.098757
+ 2.6525000 0.118869
+ 2.6527778 0.145557
+ 2.6530556 0.178578
+ 2.6533333 0.216354
+ 2.6536111 0.256971
+ 2.6538889 0.298516
+ 2.6541667 0.339074
+ 2.6544444 0.376733
+ 2.6547222 0.409580
+ 2.6550000 0.435699
+ 2.6552778 0.453179
+ 2.6555556 0.460105
+ 2.6558333 0.455179
+ 2.6561111 0.439565
+ 2.6563889 0.415042
+ 2.6566667 0.383388
+ 2.6569444 0.346383
+ 2.6572222 0.305805
+ 2.6575000 0.263434
+ 2.6577778 0.221048
+ 2.6580556 0.180426
+ 2.6583333 0.143347
+ 2.6586111 0.111337
+ 2.6588889 0.084907
+ 2.6591667 0.064315
+ 2.6594444 0.050000
+ 2.6597222 0.050000
+ 2.6600000 0.050000
+ 2.6602778 0.050000
+ 2.6605556 0.057970
+ 2.6608333 0.077831
+ 2.6611111 0.105338
+ 2.6613889 0.140351
+ 2.6616667 0.181140
+ 2.6619444 0.225575
+ 2.6622222 0.271529
+ 2.6625000 0.316873
+ 2.6627778 0.359479
+ 2.6630556 0.397218
+ 2.6633333 0.427961
+ 2.6636111 0.449581
+ 2.6638889 0.459948
+ 2.6641667 0.457594
+ 2.6644444 0.443692
+ 2.6647222 0.420074
+ 2.6650000 0.388574
+ 2.6652778 0.351022
+ 2.6655556 0.309254
+ 2.6658333 0.265100
+ 2.6661111 0.220393
+ 2.6663889 0.176967
+ 2.6666667 0.136653
+ 2.6669444 0.101048
+ 2.6672222 0.070805
+ 2.6675000 0.050000
+ 2.6677778 0.050000
+ 2.6680556 0.050000
+ 2.6683333 0.050000
+ 2.6686111 0.050000
+ 2.6688889 0.050000
+ 2.6691667 0.050000
+ 2.6694444 0.071774
+ 2.6697222 0.108041
+ 2.6700000 0.151082
+ 2.6702778 0.198570
+ 2.6705556 0.248173
+ 2.6708333 0.297563
+ 2.6711111 0.344409
+ 2.6713889 0.386384
+ 2.6716667 0.421156
+ 2.6719444 0.446397
+ 2.6722222 0.459778
+ 2.6725000 0.459679
+ 2.6727778 0.447328
+ 2.6730556 0.424662
+ 2.6733333 0.393620
+ 2.6736111 0.356141
+ 2.6738889 0.314161
+ 2.6741667 0.269618
+ 2.6744444 0.224452
+ 2.6747222 0.180600
+ 2.6750000 0.140000
+ 2.6752778 0.104329
+ 2.6755556 0.074222
+ 2.6758333 0.050052
+ 2.6761111 0.050000
+ 2.6763889 0.050000
+ 2.6766667 0.050000
+ 2.6769444 0.050000
+ 2.6772222 0.050000
+ 2.6775000 0.050632
+ 2.6777778 0.078482
+ 2.6780556 0.114807
+ 2.6783333 0.157734
+ 2.6786111 0.204938
+ 2.6788889 0.254093
+ 2.6791667 0.302877
+ 2.6794444 0.348964
+ 2.6797222 0.390030
+ 2.6800000 0.423750
+ 2.6802778 0.447800
+ 2.6805556 0.459856
+ 2.6808333 0.458310
+ 2.6811111 0.444425
+ 2.6813889 0.420179
+ 2.6816667 0.387551
+ 2.6819444 0.348522
+ 2.6822222 0.305069
+ 2.6825000 0.259172
+ 2.6827778 0.212811
+ 2.6830556 0.167964
+ 2.6833333 0.126611
+ 2.6836111 0.090458
+ 2.6838889 0.060125
+ 2.6841667 0.050000
+ 2.6844444 0.050000
+ 2.6847222 0.050000
+ 2.6850000 0.050000
+ 2.6852778 0.050000
+ 2.6855556 0.050000
+ 2.6858333 0.050000
+ 2.6861111 0.068453
+ 2.6863889 0.105615
+ 2.6866667 0.149394
+ 2.6869444 0.197472
+ 2.6872222 0.247534
+ 2.6875000 0.297262
+ 2.6877778 0.344339
+ 2.6880556 0.386450
+ 2.6883333 0.421278
+ 2.6886111 0.446506
+ 2.6888889 0.459817
+ 2.6891667 0.459600
+ 2.6894444 0.447067
+ 2.6897222 0.424132
+ 2.6900000 0.392712
+ 2.6902778 0.354723
+ 2.6905556 0.312081
+ 2.6908333 0.266703
+ 2.6911111 0.220503
+ 2.6913889 0.175399
+ 2.6916667 0.133306
+ 2.6919444 0.095899
+ 2.6922222 0.063888
+ 2.6925000 0.050000
+ 2.6927778 0.050000
+ 2.6930556 0.050000
+ 2.6933333 0.050000
+ 2.6936111 0.050000
+ 2.6938889 0.050000
+ 2.6941667 0.050000
+ 2.6944444 0.058398
+ 2.6947222 0.095590
+ 2.6950000 0.139957
+ 2.6952778 0.189053
+ 2.6955556 0.240434
+ 2.6958333 0.291654
+ 2.6961111 0.340268
+ 2.6963889 0.383829
+ 2.6966667 0.419894
+ 2.6969444 0.446017
+ 2.6972222 0.459752
+ 2.6975000 0.459399
+ 2.6977778 0.446240
+ 2.6980556 0.422304
+ 2.6983333 0.389617
+ 2.6986111 0.350206
+ 2.6988889 0.306100
+ 2.6991667 0.259325
+ 2.6994444 0.211909
+ 2.6997222 0.165879
+ 2.7000000 0.123264
+ 2.7002778 0.085817
+ 2.7005556 0.054204
+ 2.7008333 0.050000
+ 2.7011111 0.050000
+ 2.7013889 0.050000
+ 2.7016667 0.050000
+ 2.7019444 0.050000
+ 2.7022222 0.050000
+ 2.7025000 0.050000
+ 2.7027778 0.058372
+ 2.7030556 0.096441
+ 2.7033333 0.141445
+ 2.7036111 0.190957
+ 2.7038889 0.242547
+ 2.7041667 0.293787
+ 2.7044444 0.342249
+ 2.7047222 0.385505
+ 2.7050000 0.421126
+ 2.7052778 0.446685
+ 2.7055556 0.459752
+ 2.7058333 0.458646
+ 2.7061111 0.444677
+ 2.7063889 0.419901
+ 2.7066667 0.386373
+ 2.7069444 0.346150
+ 2.7072222 0.301288
+ 2.7075000 0.253842
+ 2.7077778 0.205870
+ 2.7080556 0.159427
+ 2.7083333 0.116569
+ 2.7086111 0.079071
+ 2.7088889 0.050000
+ 2.7091667 0.050000
+ 2.7094444 0.050000
+ 2.7097222 0.050000
+ 2.7100000 0.050000
+ 2.7102778 0.050000
+ 2.7105556 0.050000
+ 2.7108333 0.050000
+ 2.7111111 0.054986
+ 2.7113889 0.093290
+ 2.7116667 0.138452
+ 2.7119444 0.188083
+ 2.7122222 0.239790
+ 2.7125000 0.291183
+ 2.7127778 0.339870
+ 2.7130556 0.383460
+ 2.7133333 0.419562
+ 2.7136111 0.445786
+ 2.7138889 0.459738
+ 2.7141667 0.459758
+ 2.7144444 0.447095
+ 2.7147222 0.423728
+ 2.7150000 0.391634
+ 2.7152778 0.352792
+ 2.7155556 0.309181
+ 2.7158333 0.262779
+ 2.7161111 0.215565
+ 2.7163889 0.169516
+ 2.7166667 0.126611
+ 2.7169444 0.088578
+ 2.7172222 0.056142
+ 2.7175000 0.050000
+ 2.7177778 0.050000
+ 2.7180556 0.050000
+ 2.7183333 0.050000
+ 2.7186111 0.050000
+ 2.7188889 0.050000
+ 2.7191667 0.050000
+ 2.7194444 0.054999
+ 2.7197222 0.093749
+ 2.7200000 0.139775
+ 2.7202778 0.190493
+ 2.7205556 0.243317
+ 2.7208333 0.295662
+ 2.7211111 0.344942
+ 2.7213889 0.388573
+ 2.7216667 0.423968
+ 2.7219444 0.448543
+ 2.7222222 0.459712
+ 2.7225000 0.455705
+ 2.7227778 0.438008
+ 2.7230556 0.408922
+ 2.7233333 0.370750
+ 2.7236111 0.325791
+ 2.7238889 0.276347
+ 2.7241667 0.224720
+ 2.7244444 0.173211
+ 2.7247222 0.124120
+ 2.7250000 0.079750
+ 2.7252778 0.050000
+ 2.7255556 0.050000
+ 2.7258333 0.050000
+ 2.7261111 0.050000
+ 2.7263889 0.050000
+ 2.7266667 0.050000
+ 2.7269444 0.050000
+ 2.7272222 0.050000
+ 2.7275000 0.050000
+ 2.7277778 0.050000
+ 2.7280556 0.092492
+ 2.7283333 0.141376
+ 2.7286111 0.194127
+ 2.7288889 0.248219
+ 2.7291667 0.301128
+ 2.7294444 0.350326
+ 2.7297222 0.393290
+ 2.7300000 0.427493
+ 2.7302778 0.450411
+ 2.7305556 0.459516
+ 2.7308333 0.453113
+ 2.7311111 0.432812
+ 2.7313889 0.401057
+ 2.7316667 0.360286
+ 2.7319444 0.312940
+ 2.7322222 0.261460
+ 2.7325000 0.208287
+ 2.7327778 0.155861
+ 2.7330556 0.106623
+ 2.7333333 0.063014
+ 2.7336111 0.050000
+ 2.7338889 0.050000
+ 2.7341667 0.050000
+ 2.7344444 0.050000
+ 2.7347222 0.050000
+ 2.7350000 0.050000
+ 2.7352778 0.050000
+ 2.7355556 0.050000
+ 2.7358333 0.050000
+ 2.7361111 0.050000
+ 2.7363889 0.088948
+ 2.7366667 0.133159
+ 2.7369444 0.180825
+ 2.7372222 0.230138
+ 2.7375000 0.279291
+ 2.7377778 0.326476
+ 2.7380556 0.369885
+ 2.7383333 0.407712
+ 2.7386111 0.438148
+ 2.7388889 0.459385
+ 2.7391667 0.470143
+ 2.7394444 0.471244
+ 2.7397222 0.464035
+ 2.7400000 0.449866
+ 2.7402778 0.430084
+ 2.7405556 0.406038
+ 2.7408333 0.379076
+ 2.7411111 0.350548
+ 2.7413889 0.321800
+ 2.7416667 0.294182
+ 2.7419444 0.268874
+ 2.7422222 0.246391
+ 2.7425000 0.227079
+ 2.7427778 0.211285
+ 2.7430556 0.199354
+ 2.7433333 0.191635
+ 2.7436111 0.188472
+ 2.7438889 0.190214
+ 2.7441667 0.197206
+ 2.7444444 0.209795
+ 2.7447222 0.228122
+ 2.7450000 0.251508
+ 2.7452778 0.279066
+ 2.7455556 0.309912
+ 2.7458333 0.343160
+ 2.7461111 0.377925
+ 2.7463889 0.413321
+ 2.7466667 0.448463
+ 2.7469444 0.482466
+ 2.7472222 0.514445
+ 2.7475000 0.543510
+ 2.7477778 0.568763
+ 2.7480556 0.589299
+ 2.7483333 0.604216
+ 2.7486111 0.612612
+ 2.7488889 0.613582
+ 2.7491667 0.606224
+ 2.7494444 0.589636
+ 2.7497222 0.562913
+ 2.7500000 0.525153
+ 2.7502778 0.476162
+ 2.7505556 0.418576
+ 2.7508333 0.355742
+ 2.7511111 0.291005
+ 2.7513889 0.227712
+ 2.7516667 0.169208
+ 2.7519444 0.118839
+ 2.7522222 0.079950
+ 2.7525000 0.055889
+ 2.7527778 0.050000
+ 2.7530556 0.064366
+ 2.7533333 0.096012
+ 2.7536111 0.140703
+ 2.7538889 0.194201
+ 2.7541667 0.252269
+ 2.7544444 0.310669
+ 2.7547222 0.365164
+ 2.7550000 0.411518
+ 2.7552778 0.445492
+ 2.7555556 0.462850
+ 2.7558333 0.460655
+ 2.7561111 0.441165
+ 2.7563889 0.407941
+ 2.7566667 0.364543
+ 2.7569444 0.314528
+ 2.7572222 0.261458
+ 2.7575000 0.208891
+ 2.7577778 0.160387
+ 2.7580556 0.119505
+ 2.7583333 0.089805
+ 2.7586111 0.073964
+ 2.7588889 0.071133
+ 2.7591667 0.079578
+ 2.7594444 0.097570
+ 2.7597222 0.123375
+ 2.7600000 0.155261
+ 2.7602778 0.191497
+ 2.7605556 0.230350
+ 2.7608333 0.270090
+ 2.7611111 0.308983
+ 2.7613889 0.345487
+ 2.7616667 0.378819
+ 2.7619444 0.408385
+ 2.7622222 0.433591
+ 2.7625000 0.453843
+ 2.7627778 0.468547
+ 2.7630556 0.477108
+ 2.7633333 0.478934
+ 2.7636111 0.473429
+ 2.7638889 0.460000
+ 2.7641667 0.438377
+ 2.7644444 0.409585
+ 2.7647222 0.374974
+ 2.7650000 0.335892
+ 2.7652778 0.293690
+ 2.7655556 0.249717
+ 2.7658333 0.205321
+ 2.7661111 0.161854
+ 2.7663889 0.120662
+ 2.7666667 0.083097
+ 2.7669444 0.050354
+ 2.7672222 0.050000
+ 2.7675000 0.050000
+ 2.7677778 0.050000
+ 2.7680556 0.050000
+ 2.7683333 0.050000
+ 2.7686111 0.050000
+ 2.7688889 0.050000
+ 2.7691667 0.050000
+ 2.7694444 0.050000
+ 2.7697222 0.090010
+ 2.7700000 0.136800
+ 2.7702778 0.187907
+ 2.7705556 0.240866
+ 2.7708333 0.293213
+ 2.7711111 0.342484
+ 2.7713889 0.386216
+ 2.7716667 0.421943
+ 2.7719444 0.447202
+ 2.7722222 0.459529
+ 2.7725000 0.457230
+ 2.7727778 0.441694
+ 2.7730556 0.415077
+ 2.7733333 0.379539
+ 2.7736111 0.337239
+ 2.7738889 0.290333
+ 2.7741667 0.240982
+ 2.7744444 0.191342
+ 2.7747222 0.143573
+ 2.7750000 0.099833
+ 2.7752778 0.061971
+ 2.7755556 0.050000
+ 2.7758333 0.050000
+ 2.7761111 0.050000
+ 2.7763889 0.050000
+ 2.7766667 0.050000
+ 2.7769444 0.050000
+ 2.7772222 0.050000
+ 2.7775000 0.050000
+ 2.7777778 0.050000
+ 2.7780556 0.090333
+ 2.7783333 0.137424
+ 2.7786111 0.188792
+ 2.7788889 0.241955
+ 2.7791667 0.294432
+ 2.7794444 0.343742
+ 2.7797222 0.387404
+ 2.7800000 0.422936
+ 2.7802778 0.447858
+ 2.7805556 0.459686
+ 2.7808333 0.456722
+ 2.7811111 0.440390
+ 2.7813889 0.412896
+ 2.7816667 0.376444
+ 2.7819444 0.333240
+ 2.7822222 0.285490
+ 2.7825000 0.235400
+ 2.7827778 0.185174
+ 2.7830556 0.137019
+ 2.7833333 0.093139
+ 2.7836111 0.055416
+ 2.7838889 0.050000
+ 2.7841667 0.050000
+ 2.7844444 0.050000
+ 2.7847222 0.050000
+ 2.7850000 0.050000
+ 2.7852778 0.050000
+ 2.7855556 0.050000
+ 2.7858333 0.050000
+ 2.7861111 0.050000
+ 2.7863889 0.090782
+ 2.7866667 0.138160
+ 2.7869444 0.189675
+ 2.7872222 0.242869
+ 2.7875000 0.295286
+ 2.7877778 0.344466
+ 2.7880556 0.387953
+ 2.7883333 0.423288
+ 2.7886111 0.448014
+ 2.7888889 0.459673
+ 2.7891667 0.456583
+ 2.7894444 0.440168
+ 2.7897222 0.412628
+ 2.7900000 0.376163
+ 2.7902778 0.332973
+ 2.7905556 0.285257
+ 2.7908333 0.235216
+ 2.7911111 0.185049
+ 2.7913889 0.136957
+ 2.7916667 0.093139
+ 2.7919444 0.055471
+ 2.7922222 0.050000
+ 2.7925000 0.050000
+ 2.7927778 0.050000
+ 2.7930556 0.050000
+ 2.7933333 0.050000
+ 2.7936111 0.050000
+ 2.7938889 0.050000
+ 2.7941667 0.050000
+ 2.7944444 0.050000
+ 2.7947222 0.090689
+ 2.7950000 0.137964
+ 2.7952778 0.189377
+ 2.7955556 0.242483
+ 2.7958333 0.294834
+ 2.7961111 0.343985
+ 2.7963889 0.387490
+ 2.7966667 0.422901
+ 2.7969444 0.447774
+ 2.7972222 0.459660
+ 2.7975000 0.456885
+ 2.7977778 0.440853
+ 2.7980556 0.413742
+ 2.7983333 0.377725
+ 2.7986111 0.334981
+ 2.7988889 0.287683
+ 2.7991667 0.238009
+ 2.7994444 0.188135
+ 2.7997222 0.140235
+ 2.8000000 0.096486
+ 2.8002778 0.058748
+ 2.8005556 0.050000
+ 2.8008333 0.050000
+ 2.8011111 0.050000
+ 2.8013889 0.050000
+ 2.8016667 0.050000
+ 2.8019444 0.050000
+ 2.8022222 0.050000
+ 2.8025000 0.050000
+ 2.8027778 0.050000
+ 2.8030556 0.090469
+ 2.8033333 0.137606
+ 2.8036111 0.188951
+ 2.8038889 0.242046
+ 2.8041667 0.294432
+ 2.8044444 0.343650
+ 2.8047222 0.387242
+ 2.8050000 0.422749
+ 2.8052778 0.447712
+ 2.8055556 0.459673
+ 2.8058333 0.456946
+ 2.8061111 0.440938
+ 2.8063889 0.413831
+ 2.8066667 0.377806
+ 2.8069444 0.335042
+ 2.8072222 0.287721
+ 2.8075000 0.238025
+ 2.8077778 0.188133
+ 2.8080556 0.140226
+ 2.8083333 0.096486
+ 2.8086111 0.058775
+ 2.8088889 0.050000
+ 2.8091667 0.050000
+ 2.8094444 0.050000
+ 2.8097222 0.050000
+ 2.8100000 0.050000
+ 2.8102778 0.050000
+ 2.8105556 0.050000
+ 2.8108333 0.050000
+ 2.8111111 0.050000
+ 2.8113889 0.090310
+ 2.8116667 0.137259
+ 2.8119444 0.188413
+ 2.8122222 0.241337
+ 2.8125000 0.293596
+ 2.8127778 0.342755
+ 2.8130556 0.386380
+ 2.8133333 0.422036
+ 2.8136111 0.447287
+ 2.8138889 0.459699
+ 2.8141667 0.457599
+ 2.8144444 0.442357
+ 2.8147222 0.416105
+ 2.8150000 0.380976
+ 2.8152778 0.339102
+ 2.8155556 0.292615
+ 2.8158333 0.243647
+ 2.8161111 0.194331
+ 2.8163889 0.146798
+ 2.8166667 0.103181
+ 2.8169444 0.065310
+ 2.8172222 0.050000
+ 2.8175000 0.050000
+ 2.8177778 0.050000
+ 2.8180556 0.050000
+ 2.8183333 0.050000
+ 2.8186111 0.050000
+ 2.8188889 0.050000
+ 2.8191667 0.050000
+ 2.8194444 0.050000
+ 2.8197222 0.089934
+ 2.8200000 0.136681
+ 2.8202778 0.187773
+ 2.8205556 0.240740
+ 2.8208333 0.293113
+ 2.8211111 0.342423
+ 2.8213889 0.386201
+ 2.8216667 0.421977
+ 2.8219444 0.447282
+ 2.8222222 0.459647
+ 2.8225000 0.457375
+ 2.8227778 0.441853
+ 2.8230556 0.415241
+ 2.8233333 0.379698
+ 2.8236111 0.337384
+ 2.8238889 0.290459
+ 2.8241667 0.241082
+ 2.8244444 0.191412
+ 2.8247222 0.143609
+ 2.8250000 0.099833
+ 2.8252778 0.061935
+ 2.8255556 0.050000
+ 2.8258333 0.050000
+ 2.8261111 0.050000
+ 2.8263889 0.050000
+ 2.8266667 0.050000
+ 2.8269444 0.050000
+ 2.8272222 0.050000
+ 2.8275000 0.050000
+ 2.8277778 0.050000
+ 2.8280556 0.090422
+ 2.8283333 0.137615
+ 2.8286111 0.189084
+ 2.8288889 0.242335
+ 2.8291667 0.294876
+ 2.8294444 0.344211
+ 2.8297222 0.387849
+ 2.8300000 0.423294
+ 2.8302778 0.448054
+ 2.8305556 0.459634
+ 2.8308333 0.456329
+ 2.8311111 0.439584
+ 2.8313889 0.411632
+ 2.8316667 0.374707
+ 2.8319444 0.331043
+ 2.8322222 0.282872
+ 2.8325000 0.232428
+ 2.8327778 0.181944
+ 2.8330556 0.133655
+ 2.8333333 0.089792
+ 2.8336111 0.052253
+ 2.8338889 0.050000
+ 2.8341667 0.050000
+ 2.8344444 0.050000
+ 2.8347222 0.050000
+ 2.8350000 0.050000
+ 2.8352778 0.050000
+ 2.8355556 0.050000
+ 2.8358333 0.050000
+ 2.8361111 0.050000
+ 2.8363889 0.090590
+ 2.8366667 0.137628
+ 2.8369444 0.188728
+ 2.8372222 0.241502
+ 2.8375000 0.293563
+ 2.8377778 0.342525
+ 2.8380556 0.386001
+ 2.8383333 0.421605
+ 2.8386111 0.446949
+ 2.8388889 0.459647
+ 2.8391667 0.458056
+ 2.8394444 0.443508
+ 2.8397222 0.418080
+ 2.8400000 0.383849
+ 2.8402778 0.342890
+ 2.8405556 0.297282
+ 2.8408333 0.249100
+ 2.8411111 0.200420
+ 2.8413889 0.153320
+ 2.8416667 0.109875
+ 2.8419444 0.071879
+ 2.8422222 0.050000
+ 2.8425000 0.050000
+ 2.8427778 0.050000
+ 2.8430556 0.050000
+ 2.8433333 0.050000
+ 2.8436111 0.050000
+ 2.8438889 0.050000
+ 2.8441667 0.050000
+ 2.8444444 0.050000
+ 2.8447222 0.089556
+ 2.8450000 0.136105
+ 2.8452778 0.187140
+ 2.8455556 0.240158
+ 2.8458333 0.292654
+ 2.8461111 0.342121
+ 2.8463889 0.386055
+ 2.8466667 0.421951
+ 2.8469444 0.447303
+ 2.8472222 0.459608
+ 2.8475000 0.457141
+ 2.8477778 0.441312
+ 2.8480556 0.414310
+ 2.8483333 0.378327
+ 2.8486111 0.335552
+ 2.8488889 0.288178
+ 2.8491667 0.238393
+ 2.8494444 0.188389
+ 2.8497222 0.140357
+ 2.8500000 0.096486
+ 2.8502778 0.058650
+ 2.8505556 0.050000
+ 2.8508333 0.050000
+ 2.8511111 0.050000
+ 2.8513889 0.050000
+ 2.8516667 0.050000
+ 2.8519444 0.050000
+ 2.8522222 0.050000
+ 2.8525000 0.050000
+ 2.8527778 0.050000
+ 2.8530556 0.090569
+ 2.8533333 0.137810
+ 2.8536111 0.189254
+ 2.8538889 0.242432
+ 2.8541667 0.294875
+ 2.8544444 0.344113
+ 2.8547222 0.387679
+ 2.8550000 0.423103
+ 2.8552778 0.447915
+ 2.8555556 0.459647
+ 2.8558333 0.456608
+ 2.8561111 0.440224
+ 2.8563889 0.412698
+ 2.8566667 0.376233
+ 2.8569444 0.333033
+ 2.8572222 0.285302
+ 2.8575000 0.235243
+ 2.8577778 0.185061
+ 2.8580556 0.136958
+ 2.8583333 0.093139
+ 2.8586111 0.055481
+ 2.8588889 0.050000
+ 2.8591667 0.050000
+ 2.8594444 0.050000
+ 2.8597222 0.050000
+ 2.8600000 0.050000
+ 2.8602778 0.050000
+ 2.8605556 0.050000
+ 2.8608333 0.050000
+ 2.8611111 0.050000
+ 2.8613889 0.090606
+ 2.8616667 0.137782
+ 2.8619444 0.189094
+ 2.8622222 0.242109
+ 2.8625000 0.294391
+ 2.8627778 0.343509
+ 2.8630556 0.387027
+ 2.8633333 0.422512
+ 2.8636111 0.447530
+ 2.8638889 0.459647
+ 2.8641667 0.457194
+ 2.8644444 0.441556
+ 2.8647222 0.414884
+ 2.8650000 0.379328
+ 2.8652778 0.337038
+ 2.8655556 0.290164
+ 2.8658333 0.240856
+ 2.8661111 0.191265
+ 2.8663889 0.143541
+ 2.8666667 0.099833
+ 2.8669444 0.061986
+ 2.8672222 0.050000
+ 2.8675000 0.050000
+ 2.8677778 0.050000
+ 2.8680556 0.050000
+ 2.8683333 0.050000
+ 2.8686111 0.050000
+ 2.8688889 0.050000
+ 2.8691667 0.050000
+ 2.8694444 0.050000
+ 2.8697222 0.090397
+ 2.8700000 0.137568
+ 2.8702778 0.189018
+ 2.8705556 0.242255
+ 2.8708333 0.294786
+ 2.8711111 0.344119
+ 2.8713889 0.387761
+ 2.8716667 0.423218
+ 2.8719444 0.447998
+ 2.8722222 0.459608
+ 2.8725000 0.456342
+ 2.8727778 0.439641
+ 2.8730556 0.411735
+ 2.8733333 0.374850
+ 2.8736111 0.331216
+ 2.8738889 0.283061
+ 2.8741667 0.232612
+ 2.8744444 0.182099
+ 2.8747222 0.133749
+ 2.8750000 0.089792
+ 2.8752778 0.052122
+ 2.8755556 0.050000
+ 2.8758333 0.050000
+ 2.8761111 0.050000
+ 2.8763889 0.050000
+ 2.8766667 0.050000
+ 2.8769444 0.050000
+ 2.8772222 0.050000
+ 2.8775000 0.050000
+ 2.8777778 0.050000
+ 2.8780556 0.091082
+ 2.8783333 0.138691
+ 2.8786111 0.190370
+ 2.8788889 0.243660
+ 2.8791667 0.296105
+ 2.8794444 0.345247
+ 2.8797222 0.388630
+ 2.8800000 0.423796
+ 2.8802778 0.448287
+ 2.8805556 0.459647
+ 2.8808333 0.456197
+ 2.8811111 0.439378
+ 2.8813889 0.411408
+ 2.8816667 0.374506
+ 2.8819444 0.330892
+ 2.8822222 0.282783
+ 2.8825000 0.232400
+ 2.8827778 0.181961
+ 2.8830556 0.133685
+ 2.8833333 0.089792
+ 2.8836111 0.052169
+ 2.8838889 0.050000
+ 2.8841667 0.050000
+ 2.8844444 0.050000
+ 2.8847222 0.050000
+ 2.8850000 0.050000
+ 2.8852778 0.050000
+ 2.8855556 0.050000
+ 2.8858333 0.050000
+ 2.8861111 0.050000
+ 2.8863889 0.091067
+ 2.8866667 0.138665
+ 2.8869444 0.190335
+ 2.8872222 0.243621
+ 2.8875000 0.296066
+ 2.8877778 0.345211
+ 2.8880556 0.388599
+ 2.8883333 0.423772
+ 2.8886111 0.448274
+ 2.8888889 0.459647
+ 2.8891667 0.456212
+ 2.8894444 0.439408
+ 2.8897222 0.411453
+ 2.8900000 0.374563
+ 2.8902778 0.330957
+ 2.8905556 0.282851
+ 2.8908333 0.232465
+ 2.8911111 0.182014
+ 2.8913889 0.133717
+ 2.8916667 0.089792
+ 2.8919444 0.052126
+ 2.8922222 0.050000
+ 2.8925000 0.050000
+ 2.8927778 0.050000
+ 2.8930556 0.050000
+ 2.8933333 0.050000
+ 2.8936111 0.050000
+ 2.8938889 0.050000
+ 2.8941667 0.050000
+ 2.8944444 0.050000
+ 2.8947222 0.091225
+ 2.8950000 0.139006
+ 2.8952778 0.190862
+ 2.8955556 0.244312
+ 2.8958333 0.296878
+ 2.8961111 0.346078
+ 2.8963889 0.389433
+ 2.8966667 0.424462
+ 2.8969444 0.448684
+ 2.8972222 0.459621
+ 2.8975000 0.455581
+ 2.8977778 0.438038
+ 2.8980556 0.409254
+ 2.8983333 0.371492
+ 2.8986111 0.327015
+ 2.8988889 0.278085
+ 2.8991667 0.226966
+ 2.8994444 0.175920
+ 2.8997222 0.127209
+ 2.9000000 0.083097
+ 2.9002778 0.050000
+ 2.9005556 0.050000
+ 2.9008333 0.050000
+ 2.9011111 0.050000
+ 2.9013889 0.050000
+ 2.9016667 0.050000
+ 2.9019444 0.050000
+ 2.9022222 0.050000
+ 2.9025000 0.050000
+ 2.9027778 0.050000
+ 2.9030556 0.091928
+ 2.9033333 0.140290
+ 2.9036111 0.192592
+ 2.9038889 0.246343
+ 2.9041667 0.299050
+ 2.9044444 0.348219
+ 2.9047222 0.391359
+ 2.9050000 0.425976
+ 2.9052778 0.449579
+ 2.9055556 0.459673
+ 2.9058333 0.454571
+ 2.9061111 0.435798
+ 2.9063889 0.405685
+ 2.9066667 0.366560
+ 2.9069444 0.320755
+ 2.9072222 0.270598
+ 2.9075000 0.218420
+ 2.9077778 0.166550
+ 2.9080556 0.117319
+ 2.9083333 0.073055
+ 2.9086111 0.050000
+ 2.9088889 0.050000
+ 2.9091667 0.050000
+ 2.9094444 0.050000
+ 2.9097222 0.050000
+ 2.9100000 0.050000
+ 2.9102778 0.050000
+ 2.9105556 0.050000
+ 2.9108333 0.050000
+ 2.9111111 0.050000
+ 2.9113889 0.092503
+ 2.9116667 0.141184
+ 2.9119444 0.193599
+ 2.9122222 0.247301
+ 2.9125000 0.299848
+ 2.9127778 0.348793
+ 2.9130556 0.391693
+ 2.9133333 0.426103
+ 2.9136111 0.449578
+ 2.9138889 0.459673
+ 2.9141667 0.454733
+ 2.9144444 0.436262
+ 2.9147222 0.406550
+ 2.9150000 0.367891
+ 2.9152778 0.322577
+ 2.9155556 0.272899
+ 2.9158333 0.221151
+ 2.9161111 0.169624
+ 2.9163889 0.120610
+ 2.9166667 0.076403
+ 2.9169444 0.050000
+ 2.9172222 0.050000
+ 2.9175000 0.050000
+ 2.9177778 0.050000
+ 2.9180556 0.050000
+ 2.9183333 0.050000
+ 2.9186111 0.050000
+ 2.9188889 0.050000
+ 2.9191667 0.050000
+ 2.9194444 0.050000
+ 2.9197222 0.092672
+ 2.9200000 0.141673
+ 2.9202778 0.194486
+ 2.9205556 0.248597
+ 2.9208333 0.301490
+ 2.9211111 0.350650
+ 2.9213889 0.393561
+ 2.9216667 0.427708
+ 2.9219444 0.450575
+ 2.9222222 0.459647
+ 2.9225000 0.453230
+ 2.9227778 0.432915
+ 2.9230556 0.401116
+ 2.9233333 0.360246
+ 2.9236111 0.312718
+ 2.9238889 0.260945
+ 2.9241667 0.207340
+ 2.9244444 0.154317
+ 2.9247222 0.104288
+ 2.9250000 0.059667
+ 2.9252778 0.050000
+ 2.9255556 0.050000
+ 2.9258333 0.050000
+ 2.9261111 0.050000
+ 2.9263889 0.050000
+ 2.9266667 0.050000
+ 2.9269444 0.050000
+ 2.9272222 0.050000
+ 2.9275000 0.050000
+ 2.9277778 0.050000
+ 2.9280556 0.094031
+ 2.9283333 0.144018
+ 2.9286111 0.197473
+ 2.9288889 0.251904
+ 2.9291667 0.304823
+ 2.9294444 0.353739
+ 2.9297222 0.396163
+ 2.9300000 0.429604
+ 2.9302778 0.451574
+ 2.9305556 0.459582
+ 2.9308333 0.451964
+ 2.9311111 0.430361
+ 2.9313889 0.397238
+ 2.9316667 0.355063
+ 2.9319444 0.306300
+ 2.9322222 0.253417
+ 2.9325000 0.198879
+ 2.9327778 0.145153
+ 2.9330556 0.094704
+ 2.9333333 0.050000
+ 2.9336111 0.050000
+ 2.9338889 0.050000
+ 2.9341667 0.050000
+ 2.9344444 0.050000
+ 2.9347222 0.050000
+ 2.9350000 0.050000
+ 2.9352778 0.050000
+ 2.9355556 0.050000
+ 2.9358333 0.050000
+ 2.9361111 0.050000
+ 2.9363889 0.094654
+ 2.9366667 0.145037
+ 2.9369444 0.198693
+ 2.9372222 0.253165
+ 2.9375000 0.305996
+ 2.9377778 0.354730
+ 2.9380556 0.396910
+ 2.9383333 0.430078
+ 2.9386111 0.451779
+ 2.9388889 0.459555
+ 2.9391667 0.451770
+ 2.9394444 0.430061
+ 2.9397222 0.396885
+ 2.9400000 0.354700
+ 2.9402778 0.305962
+ 2.9405556 0.253130
+ 2.9408333 0.198661
+ 2.9411111 0.145011
+ 2.9413889 0.094638
+ 2.9416667 0.050000
+ 2.9419444 0.050000
+ 2.9422222 0.050000
+ 2.9425000 0.050000
+ 2.9427778 0.050000
+ 2.9430556 0.050000
+ 2.9433333 0.050000
+ 2.9436111 0.050000
+ 2.9438889 0.050000
+ 2.9441667 0.050000
+ 2.9444444 0.050000
+ 2.9447222 0.094632
+ 2.9450000 0.144995
+ 2.9452778 0.198633
+ 2.9455556 0.253090
+ 2.9458333 0.305909
+ 2.9461111 0.354633
+ 2.9463889 0.396806
+ 2.9466667 0.429971
+ 2.9469444 0.451672
+ 2.9472222 0.459451
+ 2.9475000 0.451671
+ 2.9477778 0.429971
+ 2.9480556 0.396806
+ 2.9483333 0.354633
+ 2.9486111 0.305909
+ 2.9488889 0.253090
+ 2.9491667 0.198633
+ 2.9494444 0.144994
+ 2.9497222 0.094631
+ 2.9500000 0.050000
+ 2.9502778 0.050000
+ 2.9505556 0.050000
+ 2.9508333 0.050000
+ 2.9511111 0.050000
+ 2.9513889 0.050000
+ 2.9516667 0.050000
+ 2.9519444 0.050000
+ 2.9522222 0.050000
+ 2.9525000 0.050000
+ 2.9527778 0.050000
+ 2.9530556 0.094637
+ 2.9533333 0.145008
+ 2.9536111 0.198656
+ 2.9538889 0.253123
+ 2.9541667 0.305953
+ 2.9544444 0.354687
+ 2.9547222 0.396869
+ 2.9550000 0.430042
+ 2.9552778 0.451748
+ 2.9555556 0.459529
+ 2.9558333 0.451749
+ 2.9561111 0.430044
+ 2.9563889 0.396873
+ 2.9566667 0.354692
+ 2.9569444 0.305958
+ 2.9572222 0.253129
+ 2.9575000 0.198661
+ 2.9577778 0.145012
+ 2.9580556 0.094640
+ 2.9583333 0.050000
+ 2.9586111 0.050000
+ 2.9588889 0.050000
+ 2.9591667 0.050000
+ 2.9594444 0.050000
+ 2.9597222 0.050000
+ 2.9600000 0.050000
+ 2.9602778 0.050000
+ 2.9605556 0.050000
+ 2.9608333 0.050000
+ 2.9611111 0.050000
+ 2.9613889 0.094642
+ 2.9616667 0.145019
+ 2.9619444 0.198672
+ 2.9622222 0.253144
+ 2.9625000 0.305977
+ 2.9627778 0.354715
+ 2.9630556 0.396899
+ 2.9633333 0.430072
+ 2.9636111 0.451777
+ 2.9638889 0.459555
+ 2.9641667 0.451770
+ 2.9644444 0.430058
+ 2.9647222 0.396879
+ 2.9650000 0.354691
+ 2.9652778 0.305950
+ 2.9655556 0.253116
+ 2.9658333 0.198646
+ 2.9661111 0.144998
+ 2.9663889 0.094630
+ 2.9666667 0.050000
+ 2.9669444 0.050000
+ 2.9672222 0.050000
+ 2.9675000 0.050000
+ 2.9677778 0.050000
+ 2.9680556 0.050000
+ 2.9683333 0.050000
+ 2.9686111 0.050000
+ 2.9688889 0.050000
+ 2.9691667 0.050000
+ 2.9694444 0.050000
+ 2.9697222 0.094582
+ 2.9700000 0.144888
+ 2.9702778 0.198469
+ 2.9705556 0.252877
+ 2.9708333 0.305662
+ 2.9711111 0.354376
+ 2.9713889 0.396570
+ 2.9716667 0.429795
+ 2.9719444 0.451602
+ 2.9722222 0.459542
+ 2.9725000 0.451983
+ 2.9727778 0.430551
+ 2.9730556 0.397691
+ 2.9733333 0.355847
+ 2.9736111 0.307463
+ 2.9738889 0.254983
+ 2.9741667 0.200850
+ 2.9744444 0.147508
+ 2.9747222 0.097400
+ 2.9750000 0.052972
+ 2.9752778 0.050000
+ 2.9755556 0.050000
+ 2.9758333 0.050000
+ 2.9761111 0.050000
+ 2.9763889 0.050000
+ 2.9766667 0.050000
+ 2.9769444 0.050000
+ 2.9772222 0.050000
+ 2.9775000 0.050000
+ 2.9777778 0.050000
+ 2.9780556 0.093672
+ 2.9783333 0.143027
+ 2.9786111 0.195710
+ 2.9788889 0.249364
+ 2.9791667 0.301632
+ 2.9794444 0.350156
+ 2.9797222 0.392580
+ 2.9800000 0.426548
+ 2.9802778 0.449702
+ 2.9805556 0.459686
+ 2.9808333 0.454909
+ 2.9811111 0.436847
+ 2.9813889 0.407741
+ 2.9816667 0.369834
+ 2.9819444 0.325367
+ 2.9822222 0.276582
+ 2.9825000 0.225720
+ 2.9827778 0.175024
+ 2.9830556 0.126736
+ 2.9833333 0.083097
+ 2.9836111 0.050000
+ 2.9838889 0.050000
+ 2.9841667 0.050000
+ 2.9844444 0.050000
+ 2.9847222 0.050000
+ 2.9850000 0.050000
+ 2.9852778 0.050000
+ 2.9855556 0.050000
+ 2.9858333 0.050000
+ 2.9861111 0.050000
+ 2.9863889 0.090649
+ 2.9866667 0.137552
+ 2.9869444 0.188391
+ 2.9872222 0.240847
+ 2.9875000 0.292604
+ 2.9877778 0.341342
+ 2.9880556 0.384744
+ 2.9883333 0.420492
+ 2.9886111 0.446267
+ 2.9888889 0.459752
+ 2.9891667 0.459349
+ 2.9894444 0.446348
+ 2.9897222 0.422757
+ 2.9900000 0.390588
+ 2.9902778 0.351849
+ 2.9905556 0.308551
+ 2.9908333 0.262703
+ 2.9911111 0.216315
+ 2.9913889 0.171397
+ 2.9916667 0.129958
+ 2.9919444 0.093732
+ 2.9922222 0.063341
+ 2.9925000 0.050000
+ 2.9927778 0.050000
+ 2.9930556 0.050000
+ 2.9933333 0.050000
+ 2.9936111 0.050000
+ 2.9938889 0.050000
+ 2.9941667 0.050000
+ 2.9944444 0.071774
+ 2.9947222 0.109012
+ 2.9950000 0.152852
+ 2.9952778 0.200948
+ 2.9955556 0.250957
+ 2.9958333 0.300532
+ 2.9961111 0.347329
+ 2.9963889 0.389002
+ 2.9966667 0.423207
+ 2.9969444 0.447598
+ 2.9972222 0.459830
+ 2.9975000 0.458290
+ 2.9977778 0.444296
+ 2.9980556 0.419898
+ 2.9983333 0.387145
+ 2.9986111 0.348086
+ 2.9988889 0.304772
+ 2.9991667 0.259253
+ 2.9994444 0.213578
+ 2.9997222 0.169796
+ 3.0000000 0.129958
+ 3.0002778 0.095806
+ 3.0005556 0.067852
+ 3.0008333 0.050000
+ 3.0011111 0.050000
+ 3.0013889 0.050000
+ 3.0016667 0.050000
+ 3.0019444 0.050000
+ 3.0022222 0.050000
+ 3.0025000 0.062912
+ 3.0027778 0.091910
+ 3.0030556 0.128550
+ 3.0033333 0.171047
+ 3.0036111 0.217218
+ 3.0038889 0.264878
+ 3.0041667 0.311847
+ 3.0044444 0.355939
+ 3.0047222 0.394971
+ 3.0050000 0.426762
+ 3.0052778 0.449126
+ 3.0055556 0.459882
+ 3.0058333 0.457534
+ 3.0061111 0.443339
+ 3.0063889 0.419241
+ 3.0066667 0.387185
+ 3.0069444 0.349117
+ 3.0072222 0.306981
+ 3.0075000 0.262721
+ 3.0077778 0.218284
+ 3.0080556 0.175613
+ 3.0083333 0.136653
+ 3.0086111 0.103065
+ 3.0088889 0.075376
+ 3.0091667 0.053827
+ 3.0094444 0.050000
+ 3.0097222 0.050000
+ 3.0100000 0.050000
+ 3.0102778 0.050000
+ 3.0105556 0.050000
+ 3.0108333 0.067034
+ 3.0111111 0.095244
+ 3.0113889 0.131129
+ 3.0116667 0.172923
+ 3.0119444 0.218459
+ 3.0122222 0.265569
+ 3.0125000 0.312085
+ 3.0127778 0.355841
+ 3.0130556 0.394669
+ 3.0133333 0.426401
+ 3.0136111 0.448870
+ 3.0138889 0.459908
+ 3.0141667 0.458027
+ 3.0144444 0.444452
+ 3.0147222 0.421087
+ 3.0150000 0.389836
+ 3.0152778 0.352603
+ 3.0155556 0.311292
+ 3.0158333 0.267807
+ 3.0161111 0.224051
+ 3.0163889 0.181930
+ 3.0166667 0.143347
+ 3.0169444 0.109934
+ 3.0172222 0.082232
+ 3.0175000 0.060512
+ 3.0177778 0.050000
+ 3.0180556 0.050000
+ 3.0183333 0.050000
+ 3.0186111 0.050000
+ 3.0188889 0.051071
+ 3.0191667 0.070903
+ 3.0194444 0.098604
+ 3.0197222 0.134037
+ 3.0200000 0.175431
+ 3.0202778 0.220609
+ 3.0205556 0.267394
+ 3.0208333 0.313608
+ 3.0211111 0.357074
+ 3.0213889 0.395615
+ 3.0216667 0.427052
+ 3.0219444 0.449209
+ 3.0222222 0.459908
+ 3.0225000 0.457658
+ 3.0227778 0.443709
+ 3.0230556 0.419997
+ 3.0233333 0.388460
+ 3.0236111 0.351034
+ 3.0238889 0.309656
+ 3.0241667 0.266261
+ 3.0244444 0.222787
+ 3.0247222 0.181170
+ 3.0250000 0.143347
+ 3.0252778 0.110963
+ 3.0255556 0.084500
+ 3.0258333 0.064146
+ 3.0261111 0.050093
+ 3.0263889 0.050000
+ 3.0266667 0.050000
+ 3.0269444 0.050000
+ 3.0272222 0.060679
+ 3.0275000 0.080975
+ 3.0277778 0.108711
+ 3.0280556 0.143700
+ 3.0283333 0.184246
+ 3.0286111 0.228276
+ 3.0288889 0.273718
+ 3.0291667 0.318500
+ 3.0294444 0.360549
+ 3.0297222 0.397792
+ 3.0300000 0.428156
+ 3.0302778 0.449570
+ 3.0305556 0.459961
+ 3.0308333 0.457904
+ 3.0311111 0.444569
+ 3.0313889 0.421774
+ 3.0316667 0.391337
+ 3.0319444 0.355077
+ 3.0322222 0.314810
+ 3.0325000 0.272355
+ 3.0327778 0.229530
+ 3.0330556 0.188153
+ 3.0333333 0.150042
+ 3.0336111 0.116765
+ 3.0338889 0.088890
+ 3.0341667 0.066737
+ 3.0344444 0.050623
+ 3.0347222 0.050000
+ 3.0350000 0.050000
+ 3.0352778 0.050000
+ 3.0355556 0.052944
+ 3.0358333 0.071811
+ 3.0361111 0.098630
+ 3.0363889 0.133306
+ 3.0366667 0.174086
+ 3.0369444 0.218801
+ 3.0372222 0.265285
+ 3.0375000 0.311369
+ 3.0377778 0.354888
+ 3.0380556 0.393672
+ 3.0383333 0.425555
+ 3.0386111 0.448370
+ 3.0388889 0.459948
+ 3.0391667 0.458791
+ 3.0394444 0.446078
+ 3.0397222 0.423657
+ 3.0400000 0.393373
+ 3.0402778 0.357076
+ 3.0405556 0.316613
+ 3.0408333 0.273830
+ 3.0411111 0.230576
+ 3.0413889 0.188697
+ 3.0416667 0.150042
+ 3.0419444 0.116205
+ 3.0422222 0.087775
+ 3.0425000 0.065088
+ 3.0427778 0.050000
+ 3.0430556 0.050000
+ 3.0433333 0.050000
+ 3.0436111 0.050000
+ 3.0438889 0.050000
+ 3.0441667 0.068367
+ 3.0444444 0.095283
+ 3.0447222 0.130205
+ 3.0450000 0.171351
+ 3.0452778 0.216515
+ 3.0455556 0.263491
+ 3.0458333 0.310073
+ 3.0461111 0.354056
+ 3.0463889 0.393232
+ 3.0466667 0.425398
+ 3.0469444 0.448345
+ 3.0472222 0.459869
+ 3.0475000 0.458449
+ 3.0477778 0.445305
+ 3.0480556 0.422341
+ 3.0483333 0.391464
+ 3.0486111 0.354578
+ 3.0488889 0.313588
+ 3.0491667 0.270400
+ 3.0494444 0.226918
+ 3.0497222 0.185048
+ 3.0500000 0.146694
+ 3.0502778 0.113490
+ 3.0505556 0.085969
+ 3.0508333 0.064397
+ 3.0511111 0.050000
+ 3.0513889 0.050000
+ 3.0516667 0.050000
+ 3.0519444 0.050000
+ 3.0522222 0.054943
+ 3.0525000 0.074574
+ 3.0527778 0.101991
+ 3.0530556 0.137055
+ 3.0533333 0.178018
+ 3.0536111 0.222727
+ 3.0538889 0.269033
+ 3.0541667 0.314783
+ 3.0544444 0.357826
+ 3.0547222 0.396012
+ 3.0550000 0.427188
+ 3.0552778 0.449204
+ 3.0555556 0.459908
+ 3.0558333 0.457818
+ 3.0561111 0.444125
+ 3.0563889 0.420688
+ 3.0566667 0.389367
+ 3.0569444 0.352020
+ 3.0572222 0.310509
+ 3.0575000 0.266692
+ 3.0577778 0.222428
+ 3.0580556 0.179578
+ 3.0583333 0.140000
+ 3.0586111 0.105303
+ 3.0588889 0.076090
+ 3.0591667 0.052710
+ 3.0594444 0.050000
+ 3.0597222 0.050000
+ 3.0600000 0.050000
+ 3.0602778 0.050000
+ 3.0605556 0.050000
+ 3.0608333 0.054598
+ 3.0611111 0.081881
+ 3.0613889 0.117378
+ 3.0616667 0.159299
+ 3.0619444 0.205427
+ 3.0622222 0.253545
+ 3.0625000 0.301437
+ 3.0627778 0.346884
+ 3.0630556 0.387671
+ 3.0633333 0.421580
+ 3.0636111 0.446394
+ 3.0638889 0.459895
+ 3.0641667 0.460540
+ 3.0644444 0.449469
+ 3.0647222 0.428496
+ 3.0650000 0.399433
+ 3.0652778 0.364095
+ 3.0655556 0.324295
+ 3.0658333 0.281846
+ 3.0661111 0.238560
+ 3.0663889 0.196253
+ 3.0666667 0.156736
+ 3.0669444 0.121595
+ 3.0672222 0.091498
+ 3.0675000 0.066887
+ 3.0677778 0.050000
+ 3.0680556 0.050000
+ 3.0683333 0.050000
+ 3.0686111 0.050000
+ 3.0688889 0.050000
+ 3.0691667 0.059091
+ 3.0694444 0.085215
+ 3.0697222 0.119896
+ 3.0700000 0.161298
+ 3.0702778 0.207133
+ 3.0705556 0.255113
+ 3.0708333 0.302950
+ 3.0711111 0.348353
+ 3.0713889 0.389035
+ 3.0716667 0.422708
+ 3.0719444 0.447082
+ 3.0722222 0.459869
+ 3.0725000 0.459480
+ 3.0727778 0.447126
+ 3.0730556 0.424715
+ 3.0733333 0.394158
+ 3.0736111 0.357365
+ 3.0738889 0.316245
+ 3.0741667 0.272708
+ 3.0744444 0.228664
+ 3.0747222 0.186023
+ 3.0750000 0.146694
+ 3.0752778 0.112324
+ 3.0755556 0.083503
+ 3.0758333 0.060559
+ 3.0761111 0.050000
+ 3.0763889 0.050000
+ 3.0766667 0.050000
+ 3.0769444 0.050000
+ 3.0772222 0.050000
+ 3.0775000 0.064585
+ 3.0777778 0.091923
+ 3.0780556 0.127324
+ 3.0783333 0.168985
+ 3.0786111 0.214674
+ 3.0788889 0.262160
+ 3.0791667 0.309212
+ 3.0794444 0.353598
+ 3.0797222 0.393089
+ 3.0800000 0.425451
+ 3.0802778 0.448455
+ 3.0805556 0.459869
+ 3.0808333 0.458153
+ 3.0811111 0.444531
+ 3.0813889 0.420917
+ 3.0816667 0.389225
+ 3.0819444 0.351369
+ 3.0822222 0.309266
+ 3.0825000 0.264828
+ 3.0827778 0.219970
+ 3.0830556 0.176607
+ 3.0833333 0.136653
+ 3.0836111 0.101758
+ 3.0838889 0.072518
+ 3.0841667 0.050000
+ 3.0844444 0.050000
+ 3.0847222 0.050000
+ 3.0850000 0.050000
+ 3.0852778 0.050000
+ 3.0855556 0.050000
+ 3.0858333 0.053931
+ 3.0861111 0.081829
+ 3.0863889 0.117926
+ 3.0866667 0.160404
+ 3.0869444 0.207010
+ 3.0872222 0.255496
+ 3.0875000 0.303611
+ 3.0877778 0.349104
+ 3.0880556 0.389726
+ 3.0883333 0.423225
+ 3.0886111 0.447352
+ 3.0888889 0.459856
+ 3.0891667 0.459180
+ 3.0894444 0.446537
+ 3.0897222 0.423833
+ 3.0900000 0.392975
+ 3.0902778 0.355870
+ 3.0905556 0.314423
+ 3.0908333 0.270541
+ 3.0911111 0.226130
+ 3.0913889 0.183097
+ 3.0916667 0.143347
+ 3.0919444 0.108527
+ 3.0922222 0.079240
+ 3.0925000 0.055828
+ 3.0927778 0.050000
+ 3.0930556 0.050000
+ 3.0933333 0.050000
+ 3.0936111 0.050000
+ 3.0938889 0.050000
+ 3.0941667 0.057903
+ 3.0944444 0.085202
+ 3.0947222 0.120687
+ 3.0950000 0.162557
+ 3.0952778 0.208583
+ 3.0955556 0.256534
+ 3.0958333 0.304183
+ 3.0961111 0.349299
+ 3.0963889 0.389654
+ 3.0966667 0.423018
+ 3.0969444 0.447162
+ 3.0972222 0.459856
+ 3.0975000 0.459555
+ 3.0977778 0.447446
+ 3.0980556 0.425401
+ 3.0983333 0.395291
+ 3.0986111 0.358987
+ 3.0988889 0.318359
+ 3.0991667 0.275280
+ 3.0994444 0.231619
+ 3.0997222 0.189250
+ 3.1000000 0.150042
+ 3.1002778 0.115615
+ 3.1005556 0.086582
+ 3.1008333 0.063306
+ 3.1011111 0.050000
+ 3.1013889 0.050000
+ 3.1016667 0.050000
+ 3.1019444 0.050000
+ 3.1022222 0.050000
+ 3.1025000 0.064798
+ 3.1027778 0.091949
+ 3.1030556 0.127312
+ 3.1033333 0.169053
+ 3.1036111 0.214900
+ 3.1038889 0.262580
+ 3.1041667 0.309820
+ 3.1044444 0.354348
+ 3.1047222 0.393891
+ 3.1050000 0.426176
+ 3.1052778 0.448931
+ 3.1055556 0.459882
+ 3.1058333 0.457464
+ 3.1061111 0.442936
+ 3.1063889 0.418264
+ 3.1066667 0.385412
+ 3.1069444 0.346346
+ 3.1072222 0.303033
+ 3.1075000 0.257437
+ 3.1077778 0.211524
+ 3.1080556 0.167261
+ 3.1083333 0.126611
+ 3.1086111 0.091265
+ 3.1088889 0.061808
+ 3.1091667 0.050000
+ 3.1094444 0.050000
+ 3.1097222 0.050000
+ 3.1100000 0.050000
+ 3.1102778 0.050000
+ 3.1105556 0.050000
+ 3.1108333 0.050000
+ 3.1111111 0.075134
+ 3.1113889 0.112119
+ 3.1116667 0.155494
+ 3.1119444 0.202988
+ 3.1122222 0.252327
+ 3.1125000 0.301238
+ 3.1127778 0.347449
+ 3.1130556 0.388686
+ 3.1133333 0.422677
+ 3.1136111 0.447150
+ 3.1138889 0.459830
+ 3.1141667 0.459144
+ 3.1144444 0.446313
+ 3.1147222 0.423254
+ 3.1150000 0.391886
+ 3.1152778 0.354129
+ 3.1155556 0.311901
+ 3.1158333 0.267120
+ 3.1161111 0.221706
+ 3.1163889 0.177578
+ 3.1166667 0.136653
+ 3.1169444 0.100597
+ 3.1172222 0.070059
+ 3.1175000 0.050000
+ 3.1177778 0.050000
+ 3.1180556 0.050000
+ 3.1183333 0.050000
+ 3.1186111 0.050000
+ 3.1188889 0.050000
+ 3.1191667 0.050000
+ 3.1194444 0.071813
+ 3.1197222 0.108263
+ 3.1200000 0.151454
+ 3.1202778 0.199054
+ 3.1205556 0.248731
+ 3.1208333 0.298153
+ 3.1211111 0.344987
+ 3.1213889 0.386899
+ 3.1216667 0.421559
+ 3.1219444 0.446634
+ 3.1222222 0.459791
+ 3.1225000 0.459411
+ 3.1227778 0.446732
+ 3.1230556 0.423705
+ 3.1233333 0.392281
+ 3.1236111 0.354410
+ 3.1238889 0.312045
+ 3.1241667 0.267135
+ 3.1244444 0.221633
+ 3.1247222 0.177488
+ 3.1250000 0.136653
+ 3.1252778 0.100813
+ 3.1255556 0.070599
+ 3.1258333 0.050000
+ 3.1261111 0.050000
+ 3.1263889 0.050000
+ 3.1266667 0.050000
+ 3.1269444 0.050000
+ 3.1272222 0.050000
+ 3.1275000 0.050000
+ 3.1277778 0.075187
+ 3.1280556 0.111578
+ 3.1283333 0.154575
+ 3.1286111 0.201874
+ 3.1288889 0.251170
+ 3.1291667 0.300160
+ 3.1294444 0.346538
+ 3.1297222 0.388001
+ 3.1300000 0.422244
+ 3.1302778 0.446964
+ 3.1305556 0.459856
+ 3.1308333 0.459321
+ 3.1311111 0.446582
+ 3.1313889 0.423566
+ 3.1316667 0.392202
+ 3.1319444 0.354417
+ 3.1322222 0.312139
+ 3.1325000 0.267296
+ 3.1327778 0.221815
+ 3.1330556 0.177625
+ 3.1333333 0.136653
+ 3.1336111 0.100571
+ 3.1338889 0.070025
+ 3.1341667 0.050000
+ 3.1344444 0.050000
+ 3.1347222 0.050000
+ 3.1350000 0.050000
+ 3.1352778 0.050000
+ 3.1355556 0.050000
+ 3.1358333 0.050000
+ 3.1361111 0.071787
+ 3.1363889 0.108174
+ 3.1366667 0.151288
+ 3.1369444 0.198808
+ 3.1372222 0.248413
+ 3.1375000 0.297782
+ 3.1377778 0.344594
+ 3.1380556 0.386529
+ 3.1383333 0.421265
+ 3.1386111 0.446481
+ 3.1388889 0.459856
+ 3.1391667 0.459778
+ 3.1394444 0.447467
+ 3.1397222 0.424852
+ 3.1400000 0.393860
+ 3.1402778 0.356420
+ 3.1405556 0.314461
+ 3.1408333 0.269911
+ 3.1411111 0.224699
+ 3.1413889 0.180752
+ 3.1416667 0.140000
+ 3.1419444 0.104114
+ 3.1422222 0.073735
+ 3.1425000 0.050000
+ 3.1427778 0.050000
+ 3.1430556 0.050000
+ 3.1433333 0.050000
+ 3.1436111 0.050000
+ 3.1438889 0.050000
+ 3.1441667 0.050000
+ 3.1444444 0.075174
+ 3.1447222 0.111238
+ 3.1450000 0.153973
+ 3.1452778 0.201076
+ 3.1455556 0.250247
+ 3.1458333 0.299184
+ 3.1461111 0.345585
+ 3.1463889 0.387149
+ 3.1466667 0.421575
+ 3.1469444 0.446560
+ 3.1472222 0.459804
+ 3.1475000 0.459708
+ 3.1477778 0.447486
+ 3.1480556 0.425057
+ 3.1483333 0.394339
+ 3.1486111 0.357249
+ 3.1488889 0.315705
+ 3.1491667 0.271625
+ 3.1494444 0.226926
+ 3.1497222 0.183528
+ 3.1500000 0.143347
+ 3.1502778 0.108043
+ 3.1505556 0.078241
+ 3.1508333 0.054308
+ 3.1511111 0.050000
+ 3.1513889 0.050000
+ 3.1516667 0.050000
+ 3.1519444 0.050000
+ 3.1522222 0.050000
+ 3.1525000 0.054472
+ 3.1527778 0.081881
+ 3.1530556 0.117650
+ 3.1533333 0.159943
+ 3.1536111 0.206483
+ 3.1538889 0.254991
+ 3.1541667 0.303191
+ 3.1544444 0.348806
+ 3.1547222 0.389559
+ 3.1550000 0.423172
+ 3.1552778 0.447367
+ 3.1555556 0.459869
+ 3.1558333 0.459096
+ 3.1561111 0.446249
+ 3.1563889 0.423228
+ 3.1566667 0.391930
+ 3.1569444 0.354255
+ 3.1572222 0.312100
+ 3.1575000 0.267364
+ 3.1577778 0.221945
+ 3.1580556 0.177742
+ 3.1583333 0.136653
+ 3.1586111 0.100330
+ 3.1588889 0.069440
+ 3.1591667 0.050000
+ 3.1594444 0.050000
+ 3.1597222 0.050000
+ 3.1600000 0.050000
+ 3.1602778 0.050000
+ 3.1605556 0.050000
+ 3.1608333 0.050000
+ 3.1611111 0.068427
+ 3.1613889 0.104915
+ 3.1616667 0.148269
+ 3.1619444 0.196137
+ 3.1622222 0.246163
+ 3.1625000 0.295993
+ 3.1627778 0.343273
+ 3.1630556 0.385648
+ 3.1633333 0.420764
+ 3.1636111 0.446268
+ 3.1638889 0.459804
+ 3.1641667 0.459736
+ 3.1644444 0.447297
+ 3.1647222 0.424440
+ 3.1650000 0.393116
+ 3.1652778 0.355277
+ 3.1655556 0.312874
+ 3.1658333 0.267858
+ 3.1661111 0.222181
+ 3.1663889 0.177796
+ 3.1666667 0.136653
+ 3.1669444 0.100443
+ 3.1672222 0.069811
+ 3.1675000 0.050000
+ 3.1677778 0.050000
+ 3.1680556 0.050000
+ 3.1683333 0.050000
+ 3.1686111 0.050000
+ 3.1688889 0.050000
+ 3.1691667 0.050000
+ 3.1694444 0.071813
+ 3.1697222 0.108269
+ 3.1700000 0.151445
+ 3.1702778 0.199015
+ 3.1705556 0.248656
+ 3.1708333 0.298043
+ 3.1711111 0.344850
+ 3.1713889 0.386753
+ 3.1716667 0.421427
+ 3.1719444 0.446548
+ 3.1722222 0.459791
+ 3.1725000 0.459543
+ 3.1727778 0.447043
+ 3.1730556 0.424240
+ 3.1733333 0.393086
+ 3.1736111 0.355531
+ 3.1738889 0.313525
+ 3.1741667 0.269018
+ 3.1744444 0.223961
+ 3.1747222 0.180305
+ 3.1750000 0.140000
+ 3.1752778 0.104728
+ 3.1755556 0.075096
+ 3.1758333 0.051446
+ 3.1761111 0.050000
+ 3.1763889 0.050000
+ 3.1766667 0.050000
+ 3.1769444 0.050000
+ 3.1772222 0.050000
+ 3.1775000 0.054157
+ 3.1777778 0.081881
+ 3.1780556 0.117870
+ 3.1783333 0.160294
+ 3.1786111 0.206891
+ 3.1788889 0.255398
+ 3.1791667 0.303553
+ 3.1794444 0.349092
+ 3.1797222 0.389753
+ 3.1800000 0.423274
+ 3.1802778 0.447391
+ 3.1805556 0.459843
+ 3.1808333 0.459061
+ 3.1811111 0.446259
+ 3.1813889 0.423343
+ 3.1816667 0.392222
+ 3.1819444 0.354802
+ 3.1822222 0.312992
+ 3.1825000 0.268699
+ 3.1827778 0.223831
+ 3.1830556 0.180296
+ 3.1833333 0.140000
+ 3.1836111 0.104595
+ 3.1838889 0.074708
+ 3.1841667 0.050705
+ 3.1844444 0.050000
+ 3.1847222 0.050000
+ 3.1850000 0.050000
+ 3.1852778 0.050000
+ 3.1855556 0.050000
+ 3.1858333 0.050962
+ 3.1861111 0.078495
+ 3.1863889 0.114425
+ 3.1866667 0.156916
+ 3.1869444 0.203693
+ 3.1872222 0.252478
+ 3.1875000 0.300994
+ 3.1877778 0.346964
+ 3.1880556 0.388113
+ 3.1883333 0.422162
+ 3.1886111 0.446835
+ 3.1888889 0.459856
+ 3.1891667 0.459643
+ 3.1894444 0.447393
+ 3.1897222 0.425002
+ 3.1900000 0.394362
+ 3.1902778 0.357367
+ 3.1905556 0.315911
+ 3.1908333 0.271888
+ 3.1911111 0.227190
+ 3.1913889 0.183712
+ 3.1916667 0.143347
+ 3.1919444 0.107740
+ 3.1922222 0.077540
+ 3.1925000 0.053145
+ 3.1927778 0.050000
+ 3.1930556 0.050000
+ 3.1933333 0.050000
+ 3.1936111 0.050000
+ 3.1938889 0.050000
+ 3.1941667 0.051065
+ 3.1944444 0.078495
+ 3.1947222 0.114471
+ 3.1950000 0.157125
+ 3.1952778 0.204132
+ 3.1955556 0.253167
+ 3.1958333 0.301907
+ 3.1961111 0.348027
+ 3.1963889 0.389204
+ 3.1966667 0.423112
+ 3.1969444 0.447429
+ 3.1972222 0.459830
+ 3.1975000 0.458710
+ 3.1977778 0.445343
+ 3.1980556 0.421721
+ 3.1983333 0.389838
+ 3.1986111 0.351686
+ 3.1988889 0.309259
+ 3.1991667 0.264549
+ 3.1994444 0.219550
+ 3.1997222 0.176253
+ 3.2000000 0.136653
+ 3.2002778 0.102451
+ 3.2005556 0.074189
+ 3.2008333 0.052116
+ 3.2011111 0.050000
+ 3.2013889 0.050000
+ 3.2016667 0.050000
+ 3.2019444 0.050000
+ 3.2022222 0.050000
+ 3.2025000 0.063674
+ 3.2027778 0.091936
+ 3.2030556 0.127983
+ 3.2033333 0.170033
+ 3.2036111 0.215897
+ 3.2038889 0.263387
+ 3.2041667 0.310314
+ 3.2044444 0.354488
+ 3.2047222 0.393723
+ 3.2050000 0.425828
+ 3.2052778 0.448615
+ 3.2055556 0.459895
+ 3.2058333 0.458162
+ 3.2061111 0.444635
+ 3.2063889 0.421215
+ 3.2066667 0.389804
+ 3.2069444 0.352303
+ 3.2072222 0.310614
+ 3.2075000 0.266637
+ 3.2077778 0.222275
+ 3.2080556 0.179429
+ 3.2083333 0.140000
+ 3.2086111 0.105626
+ 3.2088889 0.076891
+ 3.2091667 0.054117
+ 3.2094444 0.050000
+ 3.2097222 0.050000
+ 3.2100000 0.050000
+ 3.2102778 0.050000
+ 3.2105556 0.050000
+ 3.2108333 0.060595
+ 3.2111111 0.088523
+ 3.2113889 0.124548
+ 3.2116667 0.166842
+ 3.2119444 0.213146
+ 3.2122222 0.261204
+ 3.2125000 0.308757
+ 3.2127778 0.353548
+ 3.2130556 0.393319
+ 3.2133333 0.425812
+ 3.2136111 0.448770
+ 3.2138889 0.459935
+ 3.2141667 0.457759
+ 3.2144444 0.443537
+ 3.2147222 0.419273
+ 3.2150000 0.386973
+ 3.2152778 0.348640
+ 3.2155556 0.306280
+ 3.2158333 0.261896
+ 3.2161111 0.217494
+ 3.2163889 0.175078
+ 3.2166667 0.136653
+ 3.2169444 0.103915
+ 3.2172222 0.077332
+ 3.2175000 0.057063
+ 3.2177778 0.050000
+ 3.2180556 0.050000
+ 3.2183333 0.050000
+ 3.2186111 0.050000
+ 3.2188889 0.055971
+ 3.2191667 0.076916
+ 3.2194444 0.105286
+ 3.2197222 0.140867
+ 3.2200000 0.181958
+ 3.2202778 0.226481
+ 3.2205556 0.272363
+ 3.2208333 0.317527
+ 3.2211111 0.359898
+ 3.2213889 0.397401
+ 3.2216667 0.427961
+ 3.2219444 0.449501
+ 3.2222222 0.459948
+ 3.2225000 0.457884
+ 3.2227778 0.444529
+ 3.2230556 0.421763
+ 3.2233333 0.391465
+ 3.2236111 0.355514
+ 3.2238889 0.315790
+ 3.2241667 0.274170
+ 3.2244444 0.232536
+ 3.2247222 0.192764
+ 3.2250000 0.156736
+ 3.2252778 0.126043
+ 3.2255556 0.101129
+ 3.2258333 0.082152
+ 3.2261111 0.069270
+ 3.2263889 0.062640
+ 3.2266667 0.062419
+ 3.2269444 0.068766
+ 3.2272222 0.081836
+ 3.2275000 0.101789
+ 3.2277778 0.128782
+ 3.2280556 0.162610
+ 3.2283333 0.201631
+ 3.2286111 0.243838
+ 3.2288889 0.287226
+ 3.2291667 0.329789
+ 3.2294444 0.369523
+ 3.2297222 0.404421
+ 3.2300000 0.432479
+ 3.2302778 0.451691
+ 3.2305556 0.460052
+ 3.2308333 0.456204
+ 3.2311111 0.441381
+ 3.2313889 0.417463
+ 3.2316667 0.386331
+ 3.2319444 0.349866
+ 3.2322222 0.309950
+ 3.2325000 0.268463
+ 3.2327778 0.227287
+ 3.2330556 0.188302
+ 3.2333333 0.153389
+ 3.2336111 0.124126
+ 3.2338889 0.100878
+ 3.2341667 0.083706
+ 3.2344444 0.072673
+ 3.2347222 0.067839
+ 3.2350000 0.069267
+ 3.2352778 0.077018
+ 3.2355556 0.091153
+ 3.2358333 0.111734
+ 3.2361111 0.138823
+ 3.2363889 0.172161
+ 3.2366667 0.210203
+ 3.2369444 0.251084
+ 3.2372222 0.292940
+ 3.2375000 0.333906
+ 3.2377778 0.372116
+ 3.2380556 0.405706
+ 3.2383333 0.432811
+ 3.2386111 0.451565
+ 3.2388889 0.460105
+ 3.2391667 0.457164
+ 3.2394444 0.443879
+ 3.2397222 0.421985
+ 3.2400000 0.393217
+ 3.2402778 0.359313
+ 3.2405556 0.322006
+ 3.2408333 0.283033
+ 3.2411111 0.244129
+ 3.2413889 0.207030
+ 3.2416667 0.173472
+ 3.2419444 0.144925
+ 3.2422222 0.121796
+ 3.2425000 0.104228
+ 3.2427778 0.092363
+ 3.2430556 0.086343
+ 3.2433333 0.086311
+ 3.2436111 0.092409
+ 3.2438889 0.104779
+ 3.2441667 0.123563
+ 3.2444444 0.148904
+ 3.2447222 0.180610
+ 3.2450000 0.217152
+ 3.2452778 0.256669
+ 3.2455556 0.297297
+ 3.2458333 0.337173
+ 3.2461111 0.374437
+ 3.2463889 0.407224
+ 3.2466667 0.433673
+ 3.2469444 0.451920
+ 3.2472222 0.460105
+ 3.2475000 0.456958
+ 3.2477778 0.443591
+ 3.2480556 0.421710
+ 3.2483333 0.393022
+ 3.2486111 0.359232
+ 3.2488889 0.322046
+ 3.2491667 0.283172
+ 3.2494444 0.244314
+ 3.2497222 0.207178
+ 3.2500000 0.173472
+ 3.2502778 0.144646
+ 3.2505556 0.121133
+ 3.2508333 0.103110
+ 3.2511111 0.090755
+ 3.2513889 0.084245
+ 3.2516667 0.083759
+ 3.2519444 0.089473
+ 3.2522222 0.101566
+ 3.2525000 0.120214
+ 3.2527778 0.145596
+ 3.2530556 0.177541
+ 3.2533333 0.214481
+ 3.2536111 0.254503
+ 3.2538889 0.295692
+ 3.2541667 0.336132
+ 3.2544444 0.373910
+ 3.2547222 0.407109
+ 3.2550000 0.433816
+ 3.2552778 0.452115
+ 3.2555556 0.460092
+ 3.2558333 0.456443
+ 3.2561111 0.442319
+ 3.2563889 0.419478
+ 3.2566667 0.389681
+ 3.2569444 0.354690
+ 3.2572222 0.316264
+ 3.2575000 0.276165
+ 3.2577778 0.236152
+ 3.2580556 0.197987
+ 3.2583333 0.163431
+ 3.2586111 0.133974
+ 3.2588889 0.110039
+ 3.2591667 0.091776
+ 3.2594444 0.079337
+ 3.2597222 0.072875
+ 3.2600000 0.072542
+ 3.2602778 0.078488
+ 3.2605556 0.090867
+ 3.2608333 0.109830
+ 3.2611111 0.135528
+ 3.2613889 0.167779
+ 3.2616667 0.205051
+ 3.2619444 0.245478
+ 3.2622222 0.287194
+ 3.2625000 0.328332
+ 3.2627778 0.367027
+ 3.2630556 0.401411
+ 3.2633333 0.429619
+ 3.2636111 0.449784
+ 3.2638889 0.460039
+ 3.2641667 0.459099
+ 3.2644444 0.447996
+ 3.2647222 0.428343
+ 3.2650000 0.401753
+ 3.2652778 0.369839
+ 3.2655556 0.334214
+ 3.2658333 0.296491
+ 3.2661111 0.258282
+ 3.2663889 0.221202
+ 3.2666667 0.186861
+ 3.2669444 0.156661
+ 3.2672222 0.131146
+ 3.2675000 0.110649
+ 3.2677778 0.095502
+ 3.2680556 0.086038
+ 3.2683333 0.082588
+ 3.2686111 0.085486
+ 3.2688889 0.095062
+ 3.2691667 0.111649
+ 3.2694444 0.135581
+ 3.2697222 0.166796
+ 3.2700000 0.203667
+ 3.2702778 0.244177
+ 3.2705556 0.286305
+ 3.2708333 0.328033
+ 3.2711111 0.367341
+ 3.2713889 0.402211
+ 3.2716667 0.430624
+ 3.2719444 0.450560
+ 3.2722222 0.460000
+ 3.2725000 0.457566
+ 3.2727778 0.444442
+ 3.2730556 0.422451
+ 3.2733333 0.393417
+ 3.2736111 0.359166
+ 3.2738889 0.321519
+ 3.2741667 0.282303
+ 3.2744444 0.243340
+ 3.2747222 0.206455
+ 3.2750000 0.173472
+ 3.2752778 0.145918
+ 3.2755556 0.124130
+ 3.2758333 0.108150
+ 3.2761111 0.098017
+ 3.2763889 0.093773
+ 3.2766667 0.095459
+ 3.2769444 0.103114
+ 3.2772222 0.116780
+ 3.2775000 0.136497
+ 3.2777778 0.162306
+ 3.2780556 0.193944
+ 3.2783333 0.229929
+ 3.2786111 0.268477
+ 3.2788889 0.307802
+ 3.2791667 0.346121
+ 3.2794444 0.381647
+ 3.2797222 0.412596
+ 3.2800000 0.437183
+ 3.2802778 0.453623
+ 3.2805556 0.460131
+ 3.2808333 0.455492
+ 3.2811111 0.440775
+ 3.2813889 0.417616
+ 3.2816667 0.387654
+ 3.2819444 0.352526
+ 3.2822222 0.313872
+ 3.2825000 0.273327
+ 3.2827778 0.232531
+ 3.2830556 0.193122
+ 3.2833333 0.156736
+ 3.2836111 0.124798
+ 3.2838889 0.097876
+ 3.2841667 0.076320
+ 3.2844444 0.060484
+ 3.2847222 0.050721
+ 3.2850000 0.050000
+ 3.2852778 0.050824
+ 3.2855556 0.061394
+ 3.2858333 0.079448
+ 3.2861111 0.105338
+ 3.2863889 0.139003
+ 3.2866667 0.178732
+ 3.2869444 0.222401
+ 3.2872222 0.267885
+ 3.2875000 0.313059
+ 3.2877778 0.355800
+ 3.2880556 0.393982
+ 3.2883333 0.425482
+ 3.2886111 0.448174
+ 3.2888889 0.459935
+ 3.2891667 0.459284
+ 3.2894444 0.447319
+ 3.2897222 0.425783
+ 3.2900000 0.396417
+ 3.2902778 0.360965
+ 3.2905556 0.321169
+ 3.2908333 0.278771
+ 3.2911111 0.235513
+ 3.2913889 0.193139
+ 3.2916667 0.153389
+ 3.2919444 0.117798
+ 3.2922222 0.087068
+ 3.2925000 0.061689
+ 3.2927778 0.050000
+ 3.2930556 0.050000
+ 3.2933333 0.050000
+ 3.2936111 0.050000
+ 3.2938889 0.050000
+ 3.2941667 0.050000
+ 3.2944444 0.075226
+ 3.2947222 0.109912
+ 3.2950000 0.151583
+ 3.2952778 0.197933
+ 3.2955556 0.246659
+ 3.2958333 0.295456
+ 3.2961111 0.342019
+ 3.2963889 0.384044
+ 3.2966667 0.419226
+ 3.2969444 0.445260
+ 3.2972222 0.459843
+ 3.2975000 0.461354
+ 3.2977778 0.450912
+ 3.2980556 0.430319
+ 3.2983333 0.401378
+ 3.2986111 0.365892
+ 3.2988889 0.325665
+ 3.2991667 0.282497
+ 3.2994444 0.238194
+ 3.2997222 0.194557
+ 3.3000000 0.153389
+ 3.3002778 0.116284
+ 3.3005556 0.084001
+ 3.3008333 0.057087
+ 3.3011111 0.050000
+ 3.3013889 0.050000
+ 3.3016667 0.050000
+ 3.3019444 0.050000
+ 3.3022222 0.050000
+ 3.3025000 0.050000
+ 3.3027778 0.065184
+ 3.3030556 0.100506
+ 3.3033333 0.143180
+ 3.3036111 0.190793
+ 3.3038889 0.240935
+ 3.3041667 0.291193
+ 3.3044444 0.339156
+ 3.3047222 0.382413
+ 3.3050000 0.418552
+ 3.3052778 0.445162
+ 3.3055556 0.459830
+ 3.3058333 0.460870
+ 3.3061111 0.449490
+ 3.3063889 0.427625
+ 3.3066667 0.397206
+ 3.3069444 0.360168
+ 3.3072222 0.318444
+ 3.3075000 0.273966
+ 3.3077778 0.228669
+ 3.3080556 0.184485
+ 3.3083333 0.143347
+ 3.3086111 0.106937
+ 3.3088889 0.075921
+ 3.3091667 0.050715
+ 3.3094444 0.050000
+ 3.3097222 0.050000
+ 3.3100000 0.050000
+ 3.3102778 0.050000
+ 3.3105556 0.050000
+ 3.3108333 0.050000
+ 3.3111111 0.071800
+ 3.3113889 0.107557
+ 3.3116667 0.150137
+ 3.3119444 0.197236
+ 3.3122222 0.246549
+ 3.3125000 0.295770
+ 3.3127778 0.342594
+ 3.3130556 0.384716
+ 3.3133333 0.419831
+ 3.3136111 0.445633
+ 3.3138889 0.459817
+ 3.3141667 0.460773
+ 3.3144444 0.449667
+ 3.3147222 0.428362
+ 3.3150000 0.398720
+ 3.3152778 0.362602
+ 3.3155556 0.321870
+ 3.3158333 0.278386
+ 3.3161111 0.234012
+ 3.3163889 0.190610
+ 3.3166667 0.150042
+ 3.3169444 0.113934
+ 3.3172222 0.082976
+ 3.3175000 0.057622
+ 3.3177778 0.050000
+ 3.3180556 0.050000
+ 3.3183333 0.050000
+ 3.3186111 0.050000
+ 3.3188889 0.050000
+ 3.3191667 0.050000
+ 3.3194444 0.075187
+ 3.3197222 0.110544
+ 3.3200000 0.152808
+ 3.3202778 0.199646
+ 3.3205556 0.248728
+ 3.3208333 0.297724
+ 3.3211111 0.344302
+ 3.3213889 0.386133
+ 3.3216667 0.420885
+ 3.3219444 0.446228
+ 3.3222222 0.459830
+ 3.3225000 0.460068
+ 3.3227778 0.448140
+ 3.3230556 0.425951
+ 3.3233333 0.395406
+ 3.3236111 0.358411
+ 3.3238889 0.316870
+ 3.3241667 0.272688
+ 3.3244444 0.227770
+ 3.3247222 0.184021
+ 3.3250000 0.143347
+ 3.3252778 0.107403
+ 3.3255556 0.076845
+ 3.3258333 0.052081
+ 3.3261111 0.050000
+ 3.3263889 0.050000
+ 3.3266667 0.050000
+ 3.3269444 0.050000
+ 3.3272222 0.050000
+ 3.3275000 0.050000
+ 3.3277778 0.075213
+ 3.3280556 0.111023
+ 3.3283333 0.153579
+ 3.3286111 0.200572
+ 3.3288889 0.249693
+ 3.3291667 0.298633
+ 3.3294444 0.345083
+ 3.3297222 0.386734
+ 3.3300000 0.421277
+ 3.3302778 0.446403
+ 3.3305556 0.459804
+ 3.3308333 0.459865
+ 3.3311111 0.447758
+ 3.3313889 0.425346
+ 3.3316667 0.394496
+ 3.3319444 0.357073
+ 3.3322222 0.314943
+ 3.3325000 0.269970
+ 3.3327778 0.224021
+ 3.3330556 0.178960
+ 3.3333333 0.136653
+ 3.3336111 0.098742
+ 3.3338889 0.065973
+ 3.3341667 0.050000
+ 3.3344444 0.050000
+ 3.3347222 0.050000
+ 3.3350000 0.050000
+ 3.3352778 0.050000
+ 3.3355556 0.050000
+ 3.3358333 0.050000
+ 3.3361111 0.051756
+ 3.3363889 0.088327
+ 3.3366667 0.132319
+ 3.3369444 0.181303
+ 3.3372222 0.232848
+ 3.3375000 0.284524
+ 3.3377778 0.333900
+ 3.3380556 0.378546
+ 3.3383333 0.416033
+ 3.3386111 0.443929
+ 3.3388889 0.459804
+ 3.3391667 0.461952
+ 3.3394444 0.451562
+ 3.3397222 0.430548
+ 3.3400000 0.400824
+ 3.3402778 0.364301
+ 3.3405556 0.322895
+ 3.3408333 0.278517
+ 3.3411111 0.233083
+ 3.3413889 0.188504
+ 3.3416667 0.146694
+ 3.3419444 0.109331
+ 3.3422222 0.077144
+ 3.3425000 0.050625
+ 3.3427778 0.050000
+ 3.3430556 0.050000
+ 3.3433333 0.050000
+ 3.3436111 0.050000
+ 3.3438889 0.050000
+ 3.3441667 0.050000
+ 3.3444444 0.065132
+ 3.3447222 0.101227
+ 3.3450000 0.144517
+ 3.3452778 0.192585
+ 3.3455556 0.243012
+ 3.3458333 0.293382
+ 3.3461111 0.341277
+ 3.3463889 0.384279
+ 3.3466667 0.419971
+ 3.3469444 0.445934
+ 3.3472222 0.459752
+ 3.3475000 0.459734
+ 3.3477778 0.447107
+ 3.3480556 0.423825
+ 3.3483333 0.391841
+ 3.3486111 0.353108
+ 3.3488889 0.309582
+ 3.3491667 0.263215
+ 3.3494444 0.215962
+ 3.3497222 0.169776
+ 3.3500000 0.126611
+ 3.3502778 0.088182
+ 3.3505556 0.055246
+ 3.3508333 0.050000
+ 3.3511111 0.050000
+ 3.3513889 0.050000
+ 3.3516667 0.050000
+ 3.3519444 0.050000
+ 3.3522222 0.050000
+ 3.3525000 0.050000
+ 3.3527778 0.051638
+ 3.3530556 0.090907
+ 3.3533333 0.137653
+ 3.3536111 0.189200
+ 3.3538889 0.242871
+ 3.3541667 0.295991
+ 3.3544444 0.345884
+ 3.3547222 0.389873
+ 3.3550000 0.425283
+ 3.3552778 0.449438
+ 3.3555556 0.459660
+ 3.3558333 0.454131
+ 3.3561111 0.434454
+ 3.3563889 0.403091
+ 3.3566667 0.362502
+ 3.3569444 0.315148
+ 3.3572222 0.263488
+ 3.3575000 0.209985
+ 3.3577778 0.157097
+ 3.3580556 0.107287
+ 3.3583333 0.063014
+ 3.3586111 0.050000
+ 3.3588889 0.050000
+ 3.3591667 0.050000
+ 3.3594444 0.050000
+ 3.3597222 0.050000
+ 3.3600000 0.050000
+ 3.3602778 0.050000
+ 3.3605556 0.050000
+ 3.3608333 0.050000
+ 3.3611111 0.050000
+ 3.3613889 0.090943
+ 3.3616667 0.137437
+ 3.3619444 0.187401
+ 3.3622222 0.238752
+ 3.3625000 0.289409
+ 3.3627778 0.337288
+ 3.3630556 0.380309
+ 3.3633333 0.416389
+ 3.3636111 0.443446
+ 3.3638889 0.459399
+ 3.3641667 0.462784
+ 3.3644444 0.454621
+ 3.3647222 0.436547
+ 3.3650000 0.410200
+ 3.3652778 0.377219
+ 3.3655556 0.339241
+ 3.3658333 0.297905
+ 3.3661111 0.254848
+ 3.3663889 0.211709
+ 3.3666667 0.170125
+ 3.3669444 0.131585
+ 3.3672222 0.096975
+ 3.3675000 0.067033
+ 3.3677778 0.050000
+ 3.3680556 0.050000
+ 3.3683333 0.050000
+ 3.3686111 0.050000
+ 3.3688889 0.050000
+ 3.3691667 0.050000
+ 3.3694444 0.050000
+ 3.3697222 0.083444
+ 3.3700000 0.125350
+ 3.3702778 0.173619
+ 3.3705556 0.226153
+ 3.3708333 0.280852
+ 3.3711111 0.335618
+ 3.3713889 0.388352
+ 3.3716667 0.436955
+ 3.3719444 0.479328
+ 3.3722222 0.513373
+ 3.3725000 0.537554
+ 3.3727778 0.552596
+ 3.3730556 0.559785
+ 3.3733333 0.560408
+ 3.3736111 0.555754
+ 3.3738889 0.547108
+ 3.3741667 0.535759
+ 3.3744444 0.522993
+ 3.3747222 0.510099
+ 3.3750000 0.498362
+ 3.3752778 0.488799
+ 3.3755556 0.481331
+ 3.3758333 0.475610
+ 3.3761111 0.471286
+ 3.3763889 0.468009
+ 3.3766667 0.465430
+ 3.3769444 0.463198
+ 3.3772222 0.460965
+ 3.3775000 0.458382
+ 3.3777778 0.455097
+ 3.3780556 0.450971
+ 3.3783333 0.446697
+ 3.3786111 0.443179
+ 3.3788889 0.441320
+ 3.3791667 0.442023
+ 3.3794444 0.446191
+ 3.3797222 0.454726
+ 3.3800000 0.468532
+ 3.3802778 0.488512
+ 3.3805556 0.515569
+ 3.3808333 0.549958
+ 3.3811111 0.589341
+ 3.3813889 0.630734
+ 3.3816667 0.671150
+ 3.3819444 0.707606
+ 3.3822222 0.737116
+ 3.3825000 0.756694
+ 3.3827778 0.763355
+ 3.3830556 0.754115
+ 3.3833333 0.725987
+ 3.3836111 0.677294
+ 3.3838889 0.611591
+ 3.3841667 0.533739
+ 3.3844444 0.448599
+ 3.3847222 0.361034
+ 3.3850000 0.275904
+ 3.3852778 0.198071
+ 3.3855556 0.132397
+ 3.3858333 0.083744
+ 3.3861111 0.056973
+ 3.3863889 0.055346
+ 3.3866667 0.075728
+ 3.3869444 0.113383
+ 3.3872222 0.163576
+ 3.3875000 0.221571
+ 3.3877778 0.282634
+ 3.3880556 0.342028
+ 3.3883333 0.395019
+ 3.3886111 0.436872
+ 3.3888889 0.462850
+ 3.3891667 0.469515
+ 3.3894444 0.458607
+ 3.3897222 0.433165
+ 3.3900000 0.396224
+ 3.3902778 0.350822
+ 3.3905556 0.299996
+ 3.3908333 0.246783
+ 3.3911111 0.194220
+ 3.3913889 0.145345
+ 3.3916667 0.103194
+ 3.3919444 0.070219
+ 3.3922222 0.050000
+ 3.3925000 0.050000
+ 3.3927778 0.050000
+ 3.3930556 0.050000
+ 3.3933333 0.050000
+ 3.3936111 0.051063
+ 3.3938889 0.073270
+ 3.3941667 0.101481
+ 3.3944444 0.135228
+ 3.3947222 0.173825
+ 3.3950000 0.215734
+ 3.3952778 0.259197
+ 3.3955556 0.302461
+ 3.3958333 0.343769
+ 3.3961111 0.381368
+ 3.3963889 0.413501
+ 3.3966667 0.438413
+ 3.3969444 0.454350
+ 3.3972222 0.459555
+ 3.3975000 0.452856
+ 3.3977778 0.435404
+ 3.3980556 0.408930
+ 3.3983333 0.375169
+ 3.3986111 0.335851
+ 3.3988889 0.292711
+ 3.3991667 0.247480
+ 3.3994444 0.201891
+ 3.3997222 0.157677
+ 3.4000000 0.116569
+ 3.4002778 0.080095
+ 3.4005556 0.050000
+ 3.4008333 0.050000
+ 3.4011111 0.050000
+ 3.4013889 0.050000
+ 3.4016667 0.050000
+ 3.4019444 0.050000
+ 3.4022222 0.050000
+ 3.4025000 0.050000
+ 3.4027778 0.050000
+ 3.4030556 0.088224
+ 3.4033333 0.133678
+ 3.4036111 0.183879
+ 3.4038889 0.236346
+ 3.4041667 0.288596
+ 3.4044444 0.338147
+ 3.4047222 0.382518
+ 3.4050000 0.419226
+ 3.4052778 0.445789
+ 3.4055556 0.459725
+ 3.4058333 0.459311
+ 3.4061111 0.445853
+ 3.4063889 0.421418
+ 3.4066667 0.388072
+ 3.4069444 0.347882
+ 3.4072222 0.302913
+ 3.4075000 0.255231
+ 3.4077778 0.206902
+ 3.4080556 0.159993
+ 3.4083333 0.116569
+ 3.4086111 0.078419
+ 3.4088889 0.050000
+ 3.4091667 0.050000
+ 3.4094444 0.050000
+ 3.4097222 0.050000
+ 3.4100000 0.050000
+ 3.4102778 0.050000
+ 3.4105556 0.050000
+ 3.4108333 0.050000
+ 3.4111111 0.050000
+ 3.4113889 0.088598
+ 3.4116667 0.134247
+ 3.4119444 0.184502
+ 3.4122222 0.236916
+ 3.4125000 0.289043
+ 3.4127778 0.338435
+ 3.4130556 0.382647
+ 3.4133333 0.419233
+ 3.4136111 0.445746
+ 3.4138889 0.459738
+ 3.4141667 0.459513
+ 3.4144444 0.446356
+ 3.4147222 0.422306
+ 3.4150000 0.389397
+ 3.4152778 0.349665
+ 3.4155556 0.305146
+ 3.4158333 0.257876
+ 3.4161111 0.209891
+ 3.4163889 0.163225
+ 3.4166667 0.119917
+ 3.4169444 0.081731
+ 3.4172222 0.050000
+ 3.4175000 0.050000
+ 3.4177778 0.050000
+ 3.4180556 0.050000
+ 3.4183333 0.050000
+ 3.4186111 0.050000
+ 3.4188889 0.050000
+ 3.4191667 0.050000
+ 3.4194444 0.050000
+ 3.4197222 0.088356
+ 3.4200000 0.133846
+ 3.4202778 0.184013
+ 3.4205556 0.236398
+ 3.4208333 0.288544
+ 3.4211111 0.337993
+ 3.4213889 0.382287
+ 3.4216667 0.418968
+ 3.4219444 0.445578
+ 3.4222222 0.459660
+ 3.4225000 0.459504
+ 3.4227778 0.446400
+ 3.4230556 0.422384
+ 3.4233333 0.389494
+ 3.4236111 0.349768
+ 3.4238889 0.305244
+ 3.4241667 0.257959
+ 3.4244444 0.209951
+ 3.4247222 0.163258
+ 3.4250000 0.119917
+ 3.4252778 0.081696
+ 3.4255556 0.050000
+ 3.4258333 0.050000
+ 3.4261111 0.050000
+ 3.4263889 0.050000
+ 3.4266667 0.050000
+ 3.4269444 0.050000
+ 3.4272222 0.050000
+ 3.4275000 0.050000
+ 3.4277778 0.050000
+ 3.4280556 0.088445
+ 3.4283333 0.134038
+ 3.4286111 0.184307
+ 3.4288889 0.236785
+ 3.4291667 0.289000
+ 3.4294444 0.338483
+ 3.4297222 0.382765
+ 3.4300000 0.419374
+ 3.4302778 0.445842
+ 3.4305556 0.459699
+ 3.4308333 0.459230
+ 3.4311111 0.445742
+ 3.4313889 0.421296
+ 3.4316667 0.387955
+ 3.4319444 0.347781
+ 3.4322222 0.302834
+ 3.4325000 0.255178
+ 3.4327778 0.206874
+ 3.4330556 0.159984
+ 3.4333333 0.116569
+ 3.4336111 0.078416
+ 3.4338889 0.050000
+ 3.4341667 0.050000
+ 3.4344444 0.050000
+ 3.4347222 0.050000
+ 3.4350000 0.050000
+ 3.4352778 0.050000
+ 3.4355556 0.050000
+ 3.4358333 0.050000
+ 3.4361111 0.050000
+ 3.4363889 0.088671
+ 3.4366667 0.134407
+ 3.4369444 0.184751
+ 3.4372222 0.237244
+ 3.4375000 0.289428
+ 3.4377778 0.338846
+ 3.4380556 0.383039
+ 3.4383333 0.419548
+ 3.4386111 0.445917
+ 3.4388889 0.459686
+ 3.4391667 0.459151
+ 3.4394444 0.445618
+ 3.4397222 0.421147
+ 3.4400000 0.387796
+ 3.4402778 0.347627
+ 3.4405556 0.302697
+ 3.4408333 0.255067
+ 3.4411111 0.206796
+ 3.4413889 0.159944
+ 3.4416667 0.116569
+ 3.4419444 0.078455
+ 3.4422222 0.050000
+ 3.4425000 0.050000
+ 3.4427778 0.050000
+ 3.4430556 0.050000
+ 3.4433333 0.050000
+ 3.4436111 0.050000
+ 3.4438889 0.050000
+ 3.4441667 0.050000
+ 3.4444444 0.050000
+ 3.4447222 0.088582
+ 3.4450000 0.134217
+ 3.4452778 0.184460
+ 3.4455556 0.236864
+ 3.4458333 0.288984
+ 3.4461111 0.338372
+ 3.4463889 0.382582
+ 3.4466667 0.419169
+ 3.4469444 0.445686
+ 3.4472222 0.459686
+ 3.4475000 0.459471
+ 3.4477778 0.446327
+ 3.4480556 0.422290
+ 3.4483333 0.389394
+ 3.4486111 0.349674
+ 3.4488889 0.305164
+ 3.4491667 0.257899
+ 3.4494444 0.209913
+ 3.4497222 0.163240
+ 3.4500000 0.119917
+ 3.4502778 0.081707
+ 3.4505556 0.050000
+ 3.4508333 0.050000
+ 3.4511111 0.050000
+ 3.4513889 0.050000
+ 3.4516667 0.050000
+ 3.4519444 0.050000
+ 3.4522222 0.050000
+ 3.4525000 0.050000
+ 3.4527778 0.050000
+ 3.4530556 0.088452
+ 3.4533333 0.134055
+ 3.4536111 0.184337
+ 3.4538889 0.236827
+ 3.4541667 0.289053
+ 3.4544444 0.338545
+ 3.4547222 0.382831
+ 3.4550000 0.419439
+ 3.4552778 0.445899
+ 3.4555556 0.459738
+ 3.4558333 0.459243
+ 3.4561111 0.445722
+ 3.4563889 0.421241
+ 3.4566667 0.387868
+ 3.4569444 0.347667
+ 3.4572222 0.302706
+ 3.4575000 0.255049
+ 3.4577778 0.206763
+ 3.4580556 0.159915
+ 3.4583333 0.116569
+ 3.4586111 0.078513
+ 3.4588889 0.050000
+ 3.4591667 0.050000
+ 3.4594444 0.050000
+ 3.4597222 0.050000
+ 3.4600000 0.050000
+ 3.4602778 0.050000
+ 3.4605556 0.050000
+ 3.4608333 0.050000
+ 3.4611111 0.050000
+ 3.4613889 0.088297
+ 3.4616667 0.133600
+ 3.4619444 0.183506
+ 3.4622222 0.235608
+ 3.4625000 0.287504
+ 3.4627778 0.336790
+ 3.4630556 0.381060
+ 3.4633333 0.417911
+ 3.4636111 0.444939
+ 3.4638889 0.459738
+ 3.4641667 0.460634
+ 3.4644444 0.448855
+ 3.4647222 0.426360
+ 3.4650000 0.395106
+ 3.4652778 0.357053
+ 3.4655556 0.314157
+ 3.4658333 0.268376
+ 3.4661111 0.221669
+ 3.4663889 0.175993
+ 3.4666667 0.133306
+ 3.4669444 0.095319
+ 3.4672222 0.062758
+ 3.4675000 0.050000
+ 3.4677778 0.050000
+ 3.4680556 0.050000
+ 3.4683333 0.050000
+ 3.4686111 0.050000
+ 3.4688889 0.050000
+ 3.4691667 0.050000
+ 3.4694444 0.055012
+ 3.4697222 0.092324
+ 3.4700000 0.136906
+ 3.4702778 0.186294
+ 3.4705556 0.238026
+ 3.4708333 0.289639
+ 3.4711111 0.338671
+ 3.4713889 0.382658
+ 3.4716667 0.419138
+ 3.4719444 0.445648
+ 3.4722222 0.459725
+ 3.4725000 0.459655
+ 3.4727778 0.446717
+ 3.4730556 0.422939
+ 3.4733333 0.390347
+ 3.4736111 0.350970
+ 3.4738889 0.306835
+ 3.4741667 0.259969
+ 3.4744444 0.212400
+ 3.4747222 0.166156
+ 3.4750000 0.123264
+ 3.4752778 0.085482
+ 3.4755556 0.053488
+ 3.4758333 0.050000
+ 3.4761111 0.050000
+ 3.4763889 0.050000
+ 3.4766667 0.050000
+ 3.4769444 0.050000
+ 3.4772222 0.050000
+ 3.4775000 0.050000
+ 3.4777778 0.055012
+ 3.4780556 0.093048
+ 3.4783333 0.138120
+ 3.4786111 0.187791
+ 3.4788889 0.239626
+ 3.4791667 0.291192
+ 3.4794444 0.340052
+ 3.4797222 0.383772
+ 3.4800000 0.419916
+ 3.4802778 0.446050
+ 3.4805556 0.459738
+ 3.4808333 0.459290
+ 3.4811111 0.445986
+ 3.4813889 0.421854
+ 3.4816667 0.388919
+ 3.4819444 0.349208
+ 3.4822222 0.304746
+ 3.4825000 0.257560
+ 3.4827778 0.209676
+ 3.4830556 0.163120
+ 3.4833333 0.119917
+ 3.4836111 0.081825
+ 3.4838889 0.050000
+ 3.4841667 0.050000
+ 3.4844444 0.050000
+ 3.4847222 0.050000
+ 3.4850000 0.050000
+ 3.4852778 0.050000
+ 3.4855556 0.050000
+ 3.4858333 0.050000
+ 3.4861111 0.050000
+ 3.4863889 0.088199
+ 3.4866667 0.133516
+ 3.4869444 0.183513
+ 3.4872222 0.235752
+ 3.4875000 0.287795
+ 3.4877778 0.337205
+ 3.4880556 0.381543
+ 3.4883333 0.418373
+ 3.4886111 0.445255
+ 3.4888889 0.459752
+ 3.4891667 0.460165
+ 3.4894444 0.447754
+ 3.4897222 0.424517
+ 3.4900000 0.392453
+ 3.4902778 0.353560
+ 3.4905556 0.309837
+ 3.4908333 0.263282
+ 3.4911111 0.215894
+ 3.4913889 0.169671
+ 3.4916667 0.126611
+ 3.4919444 0.088456
+ 3.4922222 0.055913
+ 3.4925000 0.050000
+ 3.4927778 0.050000
+ 3.4930556 0.050000
+ 3.4933333 0.050000
+ 3.4936111 0.050000
+ 3.4938889 0.050000
+ 3.4941667 0.050000
+ 3.4944444 0.051652
+ 3.4947222 0.089399
+ 3.4950000 0.134361
+ 3.4952778 0.184086
+ 3.4955556 0.236125
+ 3.4958333 0.288026
+ 3.4961111 0.337339
+ 3.4963889 0.381613
+ 3.4966667 0.418398
+ 3.4969444 0.445244
+ 3.4972222 0.459699
+ 3.4975000 0.460057
+ 3.4977778 0.447580
+ 3.4980556 0.424278
+ 3.4983333 0.392155
+ 3.4986111 0.353221
+ 3.4988889 0.309481
+ 3.4991667 0.262943
+ 3.4994444 0.215614
+ 3.4997222 0.169501
+ 3.5000000 0.126611
+ 3.5002778 0.088690
+ 3.5005556 0.056438
+ 3.5008333 0.050000
+ 3.5011111 0.050000
+ 3.5013889 0.050000
+ 3.5016667 0.050000
+ 3.5019444 0.050000
+ 3.5022222 0.050000
+ 3.5025000 0.050000
+ 3.5027778 0.055025
+ 3.5030556 0.093009
+ 3.5033333 0.138132
+ 3.5036111 0.187925
+ 3.5038889 0.239918
+ 3.5041667 0.291641
+ 3.5044444 0.340625
+ 3.5047222 0.384399
+ 3.5050000 0.420493
+ 3.5052778 0.446439
+ 3.5055556 0.459765
+ 3.5058333 0.458759
+ 3.5061111 0.444741
+ 3.5063889 0.419785
+ 3.5066667 0.385968
+ 3.5069444 0.345365
+ 3.5072222 0.300052
+ 3.5075000 0.252106
+ 3.5077778 0.203602
+ 3.5080556 0.156615
+ 3.5083333 0.113222
+ 3.5086111 0.075215
+ 3.5088889 0.050000
+ 3.5091667 0.050000
+ 3.5094444 0.050000
+ 3.5097222 0.050000
+ 3.5100000 0.050000
+ 3.5102778 0.050000
+ 3.5105556 0.050000
+ 3.5108333 0.050000
+ 3.5111111 0.050000
+ 3.5113889 0.088793
+ 3.5116667 0.134562
+ 3.5119444 0.184872
+ 3.5122222 0.237290
+ 3.5125000 0.289381
+ 3.5127778 0.338711
+ 3.5130556 0.382846
+ 3.5133333 0.419352
+ 3.5136111 0.445794
+ 3.5138889 0.459738
+ 3.5141667 0.459495
+ 3.5144444 0.446347
+ 3.5147222 0.422323
+ 3.5150000 0.389449
+ 3.5152778 0.349753
+ 3.5155556 0.305264
+ 3.5158333 0.258008
+ 3.5161111 0.210013
+ 3.5163889 0.163307
+ 3.5166667 0.119917
+ 3.5169444 0.081606
+ 3.5172222 0.050000
+ 3.5175000 0.050000
+ 3.5177778 0.050000
+ 3.5180556 0.050000
+ 3.5183333 0.050000
+ 3.5186111 0.050000
+ 3.5188889 0.050000
+ 3.5191667 0.050000
+ 3.5194444 0.050000
+ 3.5197222 0.088873
+ 3.5200000 0.134965
+ 3.5202778 0.185744
+ 3.5205556 0.238677
+ 3.5208333 0.291231
+ 3.5211111 0.340876
+ 3.5213889 0.385077
+ 3.5216667 0.421303
+ 3.5219444 0.447021
+ 3.5222222 0.459699
+ 3.5225000 0.457593
+ 3.5227778 0.442107
+ 3.5230556 0.415437
+ 3.5233333 0.379775
+ 3.5236111 0.337315
+ 3.5238889 0.290252
+ 3.5241667 0.240778
+ 3.5244444 0.191088
+ 3.5247222 0.143375
+ 3.5250000 0.099833
+ 3.5252778 0.062335
+ 3.5255556 0.050000
+ 3.5258333 0.050000
+ 3.5261111 0.050000
+ 3.5263889 0.050000
+ 3.5266667 0.050000
+ 3.5269444 0.050000
+ 3.5272222 0.050000
+ 3.5275000 0.050000
+ 3.5277778 0.054946
+ 3.5280556 0.095206
+ 3.5283333 0.142033
+ 3.5286111 0.192984
+ 3.5288889 0.245613
+ 3.5291667 0.297476
+ 3.5294444 0.346128
+ 3.5297222 0.389125
+ 3.5300000 0.424022
+ 3.5302778 0.448375
+ 3.5305556 0.459738
+ 3.5308333 0.456440
+ 3.5311111 0.439896
+ 3.5313889 0.412292
+ 3.5316667 0.375816
+ 3.5319444 0.332656
+ 3.5322222 0.284998
+ 3.5325000 0.235030
+ 3.5327778 0.184940
+ 3.5330556 0.136913
+ 3.5333333 0.093139
+ 3.5336111 0.055483
+ 3.5338889 0.050000
+ 3.5341667 0.050000
+ 3.5344444 0.050000
+ 3.5347222 0.050000
+ 3.5350000 0.050000
+ 3.5352778 0.050000
+ 3.5355556 0.050000
+ 3.5358333 0.050000
+ 3.5361111 0.050000
+ 3.5363889 0.090834
+ 3.5366667 0.138283
+ 3.5369444 0.189879
+ 3.5372222 0.243152
+ 3.5375000 0.295632
+ 3.5377778 0.344850
+ 3.5380556 0.388337
+ 3.5383333 0.423622
+ 3.5386111 0.448237
+ 3.5388889 0.459712
+ 3.5391667 0.456359
+ 3.5394444 0.439615
+ 3.5397222 0.411697
+ 3.5400000 0.374826
+ 3.5402778 0.331219
+ 3.5405556 0.283094
+ 3.5408333 0.232671
+ 3.5411111 0.182167
+ 3.5413889 0.133801
+ 3.5416667 0.089792
+ 3.5419444 0.052030
+ 3.5422222 0.050000
+ 3.5425000 0.050000
+ 3.5427778 0.050000
+ 3.5430556 0.050000
+ 3.5433333 0.050000
+ 3.5436111 0.050000
+ 3.5438889 0.050000
+ 3.5441667 0.050000
+ 3.5444444 0.050000
+ 3.5447222 0.091511
+ 3.5450000 0.139621
+ 3.5452778 0.191810
+ 3.5455556 0.245558
+ 3.5458333 0.298348
+ 3.5461111 0.347658
+ 3.5463889 0.390971
+ 3.5466667 0.425766
+ 3.5469444 0.449524
+ 3.5472222 0.459725
+ 3.5475000 0.454663
+ 3.5477778 0.435872
+ 3.5480556 0.405702
+ 3.5483333 0.366498
+ 3.5486111 0.320609
+ 3.5488889 0.270383
+ 3.5491667 0.218167
+ 3.5494444 0.166309
+ 3.5497222 0.117156
+ 3.5500000 0.073055
+ 3.5502778 0.050000
+ 3.5505556 0.050000
+ 3.5508333 0.050000
+ 3.5511111 0.050000
+ 3.5513889 0.050000
+ 3.5516667 0.050000
+ 3.5519444 0.050000
+ 3.5522222 0.050000
+ 3.5525000 0.050000
+ 3.5527778 0.054855
+ 3.5530556 0.097850
+ 3.5533333 0.146935
+ 3.5536111 0.199617
+ 3.5538889 0.253404
+ 3.5541667 0.305804
+ 3.5544444 0.354324
+ 3.5547222 0.396473
+ 3.5550000 0.429757
+ 3.5552778 0.451685
+ 3.5555556 0.459765
+ 3.5558333 0.452326
+ 3.5561111 0.430988
+ 3.5563889 0.398194
+ 3.5566667 0.356385
+ 3.5569444 0.308003
+ 3.5572222 0.255490
+ 3.5575000 0.201289
+ 3.5577778 0.147841
+ 3.5580556 0.097588
+ 3.5583333 0.052972
+ 3.5586111 0.050000
+ 3.5588889 0.050000
+ 3.5591667 0.050000
+ 3.5594444 0.050000
+ 3.5597222 0.050000
+ 3.5600000 0.050000
+ 3.5602778 0.050000
+ 3.5605556 0.050000
+ 3.5608333 0.050000
+ 3.5611111 0.050000
+ 3.5613889 0.094395
+ 3.5616667 0.144585
+ 3.5619444 0.198111
+ 3.5622222 0.252516
+ 3.5625000 0.305341
+ 3.5627778 0.354129
+ 3.5630556 0.396420
+ 3.5633333 0.429758
+ 3.5636111 0.451683
+ 3.5638889 0.459738
+ 3.5641667 0.452282
+ 3.5644444 0.430936
+ 3.5647222 0.398142
+ 3.5650000 0.356339
+ 3.5652778 0.307968
+ 3.5655556 0.255467
+ 3.5658333 0.201277
+ 3.5661111 0.147838
+ 3.5663889 0.097590
+ 3.5666667 0.052972
+ 3.5669444 0.050000
+ 3.5672222 0.050000
+ 3.5675000 0.050000
+ 3.5677778 0.050000
+ 3.5680556 0.050000
+ 3.5683333 0.050000
+ 3.5686111 0.050000
+ 3.5688889 0.050000
+ 3.5691667 0.050000
+ 3.5694444 0.050000
+ 3.5697222 0.094460
+ 3.5700000 0.144726
+ 3.5702778 0.198329
+ 3.5705556 0.252802
+ 3.5708333 0.305676
+ 3.5711111 0.354483
+ 3.5713889 0.396754
+ 3.5716667 0.430022
+ 3.5719444 0.451818
+ 3.5722222 0.459673
+ 3.5725000 0.451942
+ 3.5727778 0.430262
+ 3.5730556 0.397096
+ 3.5733333 0.354903
+ 3.5736111 0.306145
+ 3.5738889 0.253282
+ 3.5741667 0.198776
+ 3.5744444 0.145086
+ 3.5747222 0.094674
+ 3.5750000 0.050000
+ 3.5752778 0.050000
+ 3.5755556 0.050000
+ 3.5758333 0.050000
+ 3.5761111 0.050000
+ 3.5763889 0.050000
+ 3.5766667 0.050000
+ 3.5769444 0.050000
+ 3.5772222 0.050000
+ 3.5775000 0.050000
+ 3.5777778 0.050000
+ 3.5780556 0.094659
+ 3.5783333 0.145053
+ 3.5786111 0.198723
+ 3.5788889 0.253211
+ 3.5791667 0.306060
+ 3.5794444 0.354812
+ 3.5797222 0.397008
+ 3.5800000 0.430191
+ 3.5802778 0.451903
+ 3.5805556 0.459686
+ 3.5808333 0.451901
+ 3.5811111 0.430188
+ 3.5813889 0.397003
+ 3.5816667 0.354806
+ 3.5819444 0.306053
+ 3.5822222 0.253204
+ 3.5825000 0.198716
+ 3.5827778 0.145048
+ 3.5830556 0.094656
+ 3.5833333 0.050000
+ 3.5836111 0.050000
+ 3.5838889 0.050000
+ 3.5841667 0.050000
+ 3.5844444 0.050000
+ 3.5847222 0.050000
+ 3.5850000 0.050000
+ 3.5852778 0.050000
+ 3.5855556 0.050000
+ 3.5858333 0.050000
+ 3.5861111 0.050000
+ 3.5863889 0.094659
+ 3.5866667 0.145055
+ 3.5869444 0.198727
+ 3.5872222 0.253218
+ 3.5875000 0.306069
+ 3.5877778 0.354821
+ 3.5880556 0.397015
+ 3.5883333 0.430191
+ 3.5886111 0.451893
+ 3.5888889 0.459660
+ 3.5891667 0.451854
+ 3.5894444 0.430116
+ 3.5897222 0.396907
+ 3.5900000 0.354689
+ 3.5902778 0.305922
+ 3.5905556 0.253068
+ 3.5908333 0.198587
+ 3.5911111 0.144942
+ 3.5913889 0.094592
+ 3.5916667 0.050000
+ 3.5919444 0.050000
+ 3.5922222 0.050000
+ 3.5925000 0.050000
+ 3.5927778 0.050000
+ 3.5930556 0.050000
+ 3.5933333 0.050000
+ 3.5936111 0.050000
+ 3.5938889 0.050000
+ 3.5941667 0.050000
+ 3.5944444 0.050000
+ 3.5947222 0.094341
+ 3.5950000 0.144369
+ 3.5952778 0.197668
+ 3.5955556 0.251826
+ 3.5958333 0.304430
+ 3.5961111 0.353065
+ 3.5963889 0.395319
+ 3.5966667 0.428779
+ 3.5969444 0.451030
+ 3.5972222 0.459660
+ 3.5975000 0.453052
+ 3.5977778 0.432779
+ 3.5980556 0.401210
+ 3.5983333 0.360716
+ 3.5986111 0.313665
+ 3.5988889 0.262428
+ 3.5991667 0.209375
+ 3.5994444 0.156875
+ 3.5997222 0.107298
+ 3.6000000 0.063014
+ 3.6002778 0.050000
+ 3.6005556 0.050000
+ 3.6008333 0.050000
+ 3.6011111 0.050000
+ 3.6013889 0.050000
+ 3.6016667 0.050000
+ 3.6019444 0.050000
+ 3.6022222 0.050000
+ 3.6025000 0.050000
+ 3.6027778 0.050000
+ 3.6030556 0.093276
+ 3.6033333 0.142524
+ 3.6036111 0.195312
+ 3.6038889 0.249210
+ 3.6041667 0.301786
+ 3.6044444 0.350610
+ 3.6047222 0.393249
+ 3.6050000 0.427273
+ 3.6052778 0.450251
+ 3.6055556 0.459752
+ 3.6058333 0.454144
+ 3.6061111 0.435004
+ 3.6063889 0.404706
+ 3.6066667 0.365626
+ 3.6069444 0.320139
+ 3.6072222 0.270621
+ 3.6075000 0.219448
+ 3.6077778 0.168995
+ 3.6080556 0.121637
+ 3.6083333 0.079750
+ 3.6086111 0.050000
+ 3.6088889 0.050000
+ 3.6091667 0.050000
+ 3.6094444 0.050000
+ 3.6097222 0.050000
+ 3.6100000 0.050000
+ 3.6102778 0.050000
+ 3.6105556 0.050000
+ 3.6108333 0.050000
+ 3.6111111 0.078338
+ 3.6113889 0.118669
+ 3.6116667 0.164131
+ 3.6119444 0.212620
+ 3.6122222 0.262030
+ 3.6125000 0.310255
+ 3.6127778 0.355188
+ 3.6130556 0.394724
+ 3.6133333 0.426758
+ 3.6136111 0.449184
+ 3.6138889 0.459895
+ 3.6141667 0.457464
+ 3.6144444 0.443170
+ 3.6147222 0.418971
+ 3.6150000 0.386824
+ 3.6152778 0.348687
+ 3.6155556 0.306516
+ 3.6158333 0.262270
+ 3.6161111 0.217906
+ 3.6163889 0.175381
+ 3.6166667 0.136653
+ 3.6169444 0.103388
+ 3.6172222 0.076093
+ 3.6175000 0.054985
+ 3.6177778 0.050000
+ 3.6180556 0.050000
+ 3.6183333 0.050000
+ 3.6186111 0.050000
+ 3.6188889 0.050000
+ 3.6191667 0.070346
+ 3.6194444 0.098591
+ 3.6197222 0.134360
+ 3.6200000 0.175906
+ 3.6202778 0.221095
+ 3.6205556 0.267789
+ 3.6208333 0.313851
+ 3.6211111 0.357145
+ 3.6213889 0.395535
+ 3.6216667 0.426883
+ 3.6219444 0.449053
+ 3.6222222 0.459908
+ 3.6225000 0.457987
+ 3.6227778 0.444521
+ 3.6230556 0.421418
+ 3.6233333 0.390585
+ 3.6236111 0.353928
+ 3.6238889 0.313355
+ 3.6241667 0.270773
+ 3.6244444 0.228089
+ 3.6247222 0.187210
+ 3.6250000 0.150042
+ 3.6252778 0.118206
+ 3.6255556 0.092176
+ 3.6258333 0.072139
+ 3.6261111 0.058281
+ 3.6263889 0.050791
+ 3.6266667 0.050000
+ 3.6269444 0.055660
+ 3.6272222 0.068393
+ 3.6275000 0.088242
+ 3.6277778 0.115393
+ 3.6280556 0.149663
+ 3.6283333 0.189392
+ 3.6286111 0.232549
+ 3.6288889 0.277102
+ 3.6291667 0.321019
+ 3.6294444 0.362271
+ 3.6297222 0.398827
+ 3.6300000 0.428654
+ 3.6302778 0.449722
+ 3.6305556 0.460000
+ 3.6308333 0.458094
+ 3.6311111 0.445162
+ 3.6313889 0.422998
+ 3.6316667 0.393396
+ 3.6319444 0.358151
+ 3.6322222 0.319057
+ 3.6325000 0.277908
+ 3.6327778 0.236500
+ 3.6330556 0.196627
+ 3.6333333 0.160083
+ 3.6336111 0.128406
+ 3.6338889 0.102104
+ 3.6341667 0.081430
+ 3.6344444 0.066635
+ 3.6347222 0.057971
+ 3.6350000 0.055690
+ 3.6352778 0.060044
+ 3.6355556 0.071284
+ 3.6358333 0.089663
+ 3.6361111 0.115432
+ 3.6363889 0.148468
+ 3.6366667 0.187149
+ 3.6369444 0.229475
+ 3.6372222 0.273449
+ 3.6375000 0.317074
+ 3.6377778 0.358350
+ 3.6380556 0.395280
+ 3.6383333 0.425866
+ 3.6386111 0.448110
+ 3.6388889 0.460013
+ 3.6391667 0.460187
+ 3.6394444 0.449682
+ 3.6397222 0.430155
+ 3.6400000 0.403264
+ 3.6402778 0.370669
+ 3.6405556 0.334028
+ 3.6408333 0.294998
+ 3.6411111 0.255239
+ 3.6413889 0.216409
+ 3.6416667 0.180167
+ 3.6419444 0.147960
+ 3.6422222 0.120401
+ 3.6425000 0.097891
+ 3.6427778 0.080832
+ 3.6430556 0.069626
+ 3.6433333 0.064674
+ 3.6436111 0.066378
+ 3.6438889 0.075140
+ 3.6441667 0.091362
+ 3.6444444 0.115445
+ 3.6447222 0.147374
+ 3.6450000 0.185465
+ 3.6452778 0.227619
+ 3.6455556 0.271733
+ 3.6458333 0.315708
+ 3.6461111 0.357444
+ 3.6463889 0.394838
+ 3.6466667 0.425792
+ 3.6469444 0.448204
+ 3.6472222 0.459974
+ 3.6475000 0.459644
+ 3.6477778 0.448330
+ 3.6480556 0.427791
+ 3.6483333 0.399786
+ 3.6486111 0.366075
+ 3.6488889 0.328415
+ 3.6491667 0.288565
+ 3.6494444 0.248286
+ 3.6497222 0.209335
+ 3.6500000 0.173472
+ 3.6502778 0.142210
+ 3.6505556 0.116076
+ 3.6508333 0.095354
+ 3.6511111 0.080325
+ 3.6513889 0.071272
+ 3.6516667 0.068478
+ 3.6519444 0.072223
+ 3.6522222 0.082792
+ 3.6525000 0.100465
+ 3.6527778 0.125526
+ 3.6530556 0.157872
+ 3.6533333 0.195863
+ 3.6536111 0.237474
+ 3.6538889 0.280680
+ 3.6541667 0.323457
+ 3.6544444 0.363781
+ 3.6547222 0.399625
+ 3.6550000 0.428966
+ 3.6552778 0.449779
+ 3.6555556 0.460039
+ 3.6558333 0.458352
+ 3.6561111 0.445842
+ 3.6563889 0.424265
+ 3.6566667 0.395375
+ 3.6569444 0.360929
+ 3.6572222 0.322682
+ 3.6575000 0.282387
+ 3.6577778 0.241802
+ 3.6580556 0.202680
+ 3.6583333 0.166778
+ 3.6586111 0.135601
+ 3.6588889 0.109660
+ 3.6591667 0.089219
+ 3.6594444 0.074539
+ 3.6597222 0.065882
+ 3.6600000 0.063512
+ 3.6602778 0.067690
+ 3.6605556 0.078679
+ 3.6608333 0.096742
+ 3.6611111 0.122139
+ 3.6613889 0.154758
+ 3.6616667 0.192973
+ 3.6619444 0.234783
+ 3.6622222 0.278187
+ 3.6625000 0.321184
+ 3.6627778 0.361773
+ 3.6630556 0.397951
+ 3.6633333 0.427718
+ 3.6636111 0.449072
+ 3.6638889 0.460013
+ 3.6641667 0.459156
+ 3.6644444 0.447584
+ 3.6647222 0.427000
+ 3.6650000 0.399105
+ 3.6652778 0.365600
+ 3.6655556 0.328186
+ 3.6658333 0.288566
+ 3.6661111 0.248439
+ 3.6663889 0.209507
+ 3.6666667 0.173472
+ 3.6669444 0.141807
+ 3.6672222 0.115074
+ 3.6675000 0.093606
+ 3.6677778 0.077737
+ 3.6680556 0.067800
+ 3.6683333 0.064130
+ 3.6686111 0.067058
+ 3.6688889 0.076921
+ 3.6691667 0.094050
+ 3.6694444 0.118779
+ 3.6697222 0.151045
+ 3.6700000 0.189194
+ 3.6702778 0.231173
+ 3.6705556 0.274933
+ 3.6708333 0.318420
+ 3.6711111 0.359584
+ 3.6713889 0.396372
+ 3.6716667 0.426735
+ 3.6719444 0.448619
+ 3.6722222 0.459974
+ 3.6725000 0.459378
+ 3.6727778 0.447932
+ 3.6730556 0.427367
+ 3.6733333 0.399414
+ 3.6736111 0.365803
+ 3.6738889 0.328266
+ 3.6741667 0.288534
+ 3.6744444 0.248337
+ 3.6747222 0.209406
+ 3.6750000 0.173472
+ 3.6752778 0.142029
+ 3.6755556 0.115620
+ 3.6758333 0.094549
+ 3.6761111 0.079122
+ 3.6763889 0.069645
+ 3.6766667 0.066423
+ 3.6769444 0.069761
+ 3.6772222 0.079965
+ 3.6775000 0.097340
+ 3.6777778 0.122192
+ 3.6780556 0.154436
+ 3.6783333 0.192433
+ 3.6786111 0.234153
+ 3.6788889 0.277568
+ 3.6791667 0.320650
+ 3.6794444 0.361367
+ 3.6797222 0.397693
+ 3.6800000 0.427597
+ 3.6802778 0.449051
+ 3.6805556 0.460026
+ 3.6808333 0.459116
+ 3.6811111 0.447407
+ 3.6813889 0.426609
+ 3.6816667 0.398431
+ 3.6819444 0.364583
+ 3.6822222 0.326774
+ 3.6825000 0.286715
+ 3.6827778 0.246114
+ 3.6830556 0.206681
+ 3.6833333 0.170125
+ 3.6836111 0.137930
+ 3.6838889 0.110670
+ 3.6841667 0.088694
+ 3.6844444 0.072351
+ 3.6847222 0.061989
+ 3.6850000 0.057956
+ 3.6852778 0.060600
+ 3.6855556 0.070271
+ 3.6858333 0.087316
+ 3.6861111 0.112085
+ 3.6863889 0.144523
+ 3.6866667 0.182974
+ 3.6869444 0.225379
+ 3.6872222 0.269678
+ 3.6875000 0.313813
+ 3.6877778 0.355725
+ 3.6880556 0.393355
+ 3.6883333 0.424643
+ 3.6886111 0.447532
+ 3.6888889 0.459961
+ 3.6891667 0.460493
+ 3.6894444 0.450173
+ 3.6897222 0.430666
+ 3.6900000 0.403638
+ 3.6902778 0.370756
+ 3.6905556 0.333684
+ 3.6908333 0.294089
+ 3.6911111 0.253636
+ 3.6913889 0.213991
+ 3.6916667 0.176819
+ 3.6919444 0.143585
+ 3.6922222 0.114943
+ 3.6925000 0.091345
+ 3.6927778 0.073244
+ 3.6930556 0.061092
+ 3.6933333 0.055341
+ 3.6936111 0.056445
+ 3.6938889 0.064855
+ 3.6941667 0.081023
+ 3.6944444 0.105403
+ 3.6947222 0.138006
+ 3.6950000 0.177083
+ 3.6952778 0.220443
+ 3.6955556 0.265896
+ 3.6958333 0.311252
+ 3.6961111 0.354321
+ 3.6963889 0.392912
+ 3.6966667 0.424837
+ 3.6969444 0.447903
+ 3.6972222 0.459922
+ 3.6975000 0.459372
+ 3.6977778 0.447410
+ 3.6980556 0.425864
+ 3.6983333 0.396559
+ 3.6986111 0.361322
+ 3.6988889 0.321979
+ 3.6991667 0.280358
+ 3.6994444 0.238283
+ 3.6997222 0.197583
+ 3.7000000 0.160083
+ 3.7002778 0.127356
+ 3.7005556 0.099957
+ 3.7008333 0.078188
+ 3.7011111 0.062350
+ 3.7013889 0.052744
+ 3.7016667 0.050000
+ 3.7019444 0.053436
+ 3.7022222 0.064336
+ 3.7025000 0.082673
+ 3.7027778 0.108751
+ 3.7030556 0.142467
+ 3.7033333 0.182116
+ 3.7036111 0.225590
+ 3.7038889 0.270782
+ 3.7041667 0.315583
+ 3.7044444 0.357887
+ 3.7047222 0.395584
+ 3.7050000 0.426567
+ 3.7052778 0.448728
+ 3.7055556 0.459961
+ 3.7058333 0.458805
+ 3.7061111 0.446400
+ 3.7063889 0.424534
+ 3.7066667 0.394994
+ 3.7069444 0.359569
+ 3.7072222 0.320046
+ 3.7075000 0.278214
+ 3.7077778 0.235859
+ 3.7080556 0.194771
+ 3.7083333 0.156736
+ 3.7086111 0.123304
+ 3.7088889 0.095068
+ 3.7091667 0.072381
+ 3.7094444 0.055597
+ 3.7097222 0.050000
+ 3.7100000 0.050000
+ 3.7102778 0.050000
+ 3.7105556 0.054562
+ 3.7108333 0.072597
+ 3.7111111 0.098657
+ 3.7113889 0.132676
+ 3.7116667 0.172917
+ 3.7119444 0.217222
+ 3.7122222 0.263434
+ 3.7125000 0.309395
+ 3.7127778 0.352948
+ 3.7130556 0.391935
+ 3.7133333 0.424201
+ 3.7136111 0.447586
+ 3.7138889 0.459935
+ 3.7141667 0.459747
+ 3.7144444 0.448158
+ 3.7147222 0.426959
+ 3.7150000 0.397944
+ 3.7152778 0.362904
+ 3.7155556 0.323633
+ 3.7158333 0.281923
+ 3.7161111 0.239566
+ 3.7163889 0.198356
+ 3.7166667 0.160083
+ 3.7169444 0.126308
+ 3.7172222 0.097647
+ 3.7175000 0.074486
+ 3.7177778 0.057209
+ 3.7180556 0.050000
+ 3.7183333 0.050000
+ 3.7186111 0.050000
+ 3.7188889 0.054627
+ 3.7191667 0.072534
+ 3.7194444 0.098630
+ 3.7197222 0.132866
+ 3.7200000 0.173452
+ 3.7202778 0.218164
+ 3.7205556 0.264779
+ 3.7208333 0.311072
+ 3.7211111 0.354820
+ 3.7213889 0.393799
+ 3.7216667 0.425785
+ 3.7219444 0.448554
+ 3.7222222 0.459882
+ 3.7225000 0.458238
+ 3.7227778 0.444858
+ 3.7230556 0.421670
+ 3.7233333 0.390602
+ 3.7236111 0.353582
+ 3.7238889 0.312539
+ 3.7241667 0.269400
+ 3.7244444 0.226095
+ 3.7247222 0.184550
+ 3.7250000 0.146694
+ 3.7252778 0.114170
+ 3.7255556 0.087472
+ 3.7258333 0.066809
+ 3.7261111 0.052390
+ 3.7263889 0.050000
+ 3.7266667 0.050000
+ 3.7269444 0.050000
+ 3.7272222 0.061338
+ 3.7275000 0.081276
+ 3.7277778 0.108711
+ 3.7280556 0.143473
+ 3.7283333 0.183861
+ 3.7286111 0.227796
+ 3.7288889 0.273199
+ 3.7291667 0.317988
+ 3.7294444 0.360084
+ 3.7297222 0.397407
+ 3.7300000 0.427876
+ 3.7302778 0.449412
+ 3.7305556 0.459935
+ 3.7308333 0.458012
+ 3.7311111 0.444805
+ 3.7313889 0.422123
+ 3.7316667 0.391776
+ 3.7319444 0.355573
+ 3.7322222 0.315323
+ 3.7325000 0.272835
+ 3.7327778 0.229920
+ 3.7330556 0.188385
+ 3.7333333 0.150042
+ 3.7336111 0.116453
+ 3.7338889 0.088204
+ 3.7341667 0.065635
+ 3.7344444 0.050000
+ 3.7347222 0.050000
+ 3.7350000 0.050000
+ 3.7352778 0.050000
+ 3.7355556 0.050000
+ 3.7358333 0.068526
+ 3.7361111 0.095231
+ 3.7363889 0.129914
+ 3.7366667 0.170812
+ 3.7369444 0.215745
+ 3.7372222 0.262529
+ 3.7375000 0.308982
+ 3.7377778 0.352921
+ 3.7380556 0.392164
+ 3.7383333 0.424530
+ 3.7386111 0.447834
+ 3.7388889 0.459895
+ 3.7391667 0.459199
+ 3.7394444 0.446904
+ 3.7397222 0.424834
+ 3.7400000 0.394816
+ 3.7402778 0.358676
+ 3.7405556 0.318239
+ 3.7408333 0.275332
+ 3.7411111 0.231779
+ 3.7413889 0.189407
+ 3.7416667 0.150042
+ 3.7419444 0.115270
+ 3.7422222 0.085728
+ 3.7425000 0.061811
+ 3.7427778 0.050000
+ 3.7430556 0.050000
+ 3.7433333 0.050000
+ 3.7436111 0.050000
+ 3.7438889 0.050000
+ 3.7441667 0.058669
+ 3.7444444 0.085241
+ 3.7447222 0.120173
+ 3.7450000 0.161657
+ 3.7452778 0.207448
+ 3.7455556 0.255298
+ 3.7458333 0.302962
+ 3.7461111 0.348192
+ 3.7463889 0.388741
+ 3.7466667 0.422364
+ 3.7469444 0.446814
+ 3.7472222 0.459843
+ 3.7475000 0.459891
+ 3.7477778 0.448140
+ 3.7480556 0.426456
+ 3.7483333 0.396706
+ 3.7486111 0.360758
+ 3.7488889 0.320479
+ 3.7491667 0.277735
+ 3.7494444 0.234394
+ 3.7497222 0.192323
+ 3.7500000 0.153389
+ 3.7502778 0.119207
+ 3.7505556 0.090383
+ 3.7508333 0.067274
+ 3.7511111 0.050233
+ 3.7513889 0.050000
+ 3.7516667 0.050000
+ 3.7519444 0.050000
+ 3.7522222 0.050000
+ 3.7525000 0.068474
+ 3.7527778 0.095296
+ 3.7530556 0.130238
+ 3.7533333 0.171491
+ 3.7536111 0.216817
+ 3.7538889 0.263973
+ 3.7541667 0.310719
+ 3.7544444 0.354816
+ 3.7547222 0.394023
+ 3.7550000 0.426098
+ 3.7552778 0.448803
+ 3.7555556 0.459895
+ 3.7558333 0.457830
+ 3.7561111 0.443836
+ 3.7563889 0.419837
+ 3.7566667 0.387757
+ 3.7569444 0.349520
+ 3.7572222 0.307049
+ 3.7575000 0.262269
+ 3.7577778 0.217102
+ 3.7580556 0.173473
+ 3.7583333 0.133306
+ 3.7586111 0.098256
+ 3.7588889 0.068916
+ 3.7591667 0.050000
+ 3.7594444 0.050000
+ 3.7597222 0.050000
+ 3.7600000 0.050000
+ 3.7602778 0.050000
+ 3.7605556 0.050000
+ 3.7608333 0.050546
+ 3.7611111 0.078521
+ 3.7613889 0.114690
+ 3.7616667 0.157247
+ 3.7619444 0.203961
+ 3.7622222 0.252599
+ 3.7625000 0.300930
+ 3.7627778 0.346721
+ 3.7630556 0.387742
+ 3.7633333 0.421759
+ 3.7636111 0.446541
+ 3.7638889 0.459856
+ 3.7641667 0.460151
+ 3.7644444 0.448588
+ 3.7647222 0.427007
+ 3.7650000 0.397249
+ 3.7652778 0.361153
+ 3.7655556 0.320562
+ 3.7658333 0.277314
+ 3.7661111 0.233251
+ 3.7663889 0.190214
+ 3.7666667 0.150042
+ 3.7669444 0.114343
+ 3.7672222 0.083798
+ 3.7675000 0.058851
+ 3.7677778 0.050000
+ 3.7680556 0.050000
+ 3.7683333 0.050000
+ 3.7686111 0.050000
+ 3.7688889 0.050000
+ 3.7691667 0.051758
+ 3.7694444 0.078508
+ 3.7697222 0.113964
+ 3.7700000 0.156253
+ 3.7702778 0.203035
+ 3.7705556 0.251971
+ 3.7708333 0.300721
+ 3.7711111 0.346948
+ 3.7713889 0.388311
+ 3.7716667 0.422472
+ 3.7719444 0.447091
+ 3.7722222 0.459830
+ 3.7725000 0.459070
+ 3.7727778 0.446076
+ 3.7730556 0.422835
+ 3.7733333 0.391330
+ 3.7736111 0.353550
+ 3.7738889 0.311478
+ 3.7741667 0.267102
+ 3.7744444 0.222406
+ 3.7747222 0.179377
+ 3.7750000 0.140000
+ 3.7752778 0.105972
+ 3.7755556 0.077836
+ 3.7758333 0.055845
+ 3.7761111 0.050000
+ 3.7763889 0.050000
+ 3.7766667 0.050000
+ 3.7769444 0.050000
+ 3.7772222 0.050000
+ 3.7775000 0.067146
+ 3.7777778 0.095270
+ 3.7780556 0.131160
+ 3.7783333 0.173029
+ 3.7786111 0.218682
+ 3.7788889 0.265925
+ 3.7791667 0.312564
+ 3.7794444 0.356404
+ 3.7797222 0.395250
+ 3.7800000 0.426908
+ 3.7802778 0.449184
+ 3.7805556 0.459882
+ 3.7808333 0.457495
+ 3.7811111 0.443258
+ 3.7813889 0.419092
+ 3.7816667 0.386918
+ 3.7819444 0.348658
+ 3.7822222 0.306233
+ 3.7825000 0.261563
+ 3.7827778 0.216572
+ 3.7830556 0.173179
+ 3.7833333 0.133306
+ 3.7836111 0.098605
+ 3.7838889 0.069653
+ 3.7841667 0.050000
+ 3.7844444 0.050000
+ 3.7847222 0.050000
+ 3.7850000 0.050000
+ 3.7852778 0.050000
+ 3.7855556 0.050000
+ 3.7858333 0.053757
+ 3.7861111 0.081855
+ 3.7863889 0.118045
+ 3.7866667 0.160525
+ 3.7869444 0.207070
+ 3.7872222 0.255456
+ 3.7875000 0.303460
+ 3.7877778 0.348856
+ 3.7880556 0.389420
+ 3.7883333 0.422929
+ 3.7886111 0.447158
+ 3.7888889 0.459882
+ 3.7891667 0.459560
+ 3.7894444 0.447375
+ 3.7897222 0.425192
+ 3.7900000 0.394878
+ 3.7902778 0.358297
+ 3.7905556 0.317315
+ 3.7908333 0.273799
+ 3.7911111 0.229613
+ 3.7913889 0.186623
+ 3.7916667 0.146694
+ 3.7919444 0.111449
+ 3.7922222 0.081529
+ 3.7925000 0.057335
+ 3.7927778 0.050000
+ 3.7930556 0.050000
+ 3.7933333 0.050000
+ 3.7936111 0.050000
+ 3.7938889 0.050000
+ 3.7941667 0.054756
+ 3.7944444 0.081816
+ 3.7947222 0.117345
+ 3.7950000 0.159498
+ 3.7952778 0.205979
+ 3.7955556 0.254496
+ 3.7958333 0.302752
+ 3.7961111 0.348453
+ 3.7963889 0.389305
+ 3.7966667 0.423013
+ 3.7969444 0.447282
+ 3.7972222 0.459817
+ 3.7975000 0.459029
+ 3.7977778 0.446149
+ 3.7980556 0.423111
+ 3.7983333 0.391850
+ 3.7986111 0.354303
+ 3.7988889 0.312405
+ 3.7991667 0.268090
+ 3.7994444 0.223294
+ 3.7997222 0.179952
+ 3.8000000 0.140000
+ 3.8002778 0.105106
+ 3.8005556 0.075867
+ 3.8008333 0.052614
+ 3.8011111 0.050000
+ 3.8013889 0.050000
+ 3.8016667 0.050000
+ 3.8019444 0.050000
+ 3.8022222 0.050000
+ 3.8025000 0.057340
+ 3.8027778 0.085255
+ 3.8030556 0.121368
+ 3.8033333 0.163841
+ 3.8036111 0.210402
+ 3.8038889 0.258777
+ 3.8041667 0.306695
+ 3.8044444 0.351881
+ 3.8047222 0.392065
+ 3.8050000 0.424972
+ 3.8052778 0.448331
+ 3.8055556 0.459869
+ 3.8058333 0.458018
+ 3.8061111 0.444030
+ 3.8063889 0.419860
+ 3.8066667 0.387467
+ 3.8069444 0.348805
+ 3.8072222 0.305832
+ 3.8075000 0.260505
+ 3.8077778 0.214779
+ 3.8080556 0.170611
+ 3.8083333 0.129958
+ 3.8086111 0.094505
+ 3.8088889 0.064847
+ 3.8091667 0.050000
+ 3.8094444 0.050000
+ 3.8097222 0.050000
+ 3.8100000 0.050000
+ 3.8102778 0.050000
+ 3.8105556 0.050000
+ 3.8108333 0.050000
+ 3.8111111 0.075134
+ 3.8113889 0.111797
+ 3.8116667 0.154907
+ 3.8119444 0.202196
+ 3.8122222 0.251400
+ 3.8125000 0.300250
+ 3.8127778 0.346479
+ 3.8130556 0.387822
+ 3.8133333 0.422010
+ 3.8136111 0.446777
+ 3.8138889 0.459856
+ 3.8141667 0.459675
+ 3.8144444 0.447438
+ 3.8147222 0.425043
+ 3.8150000 0.394389
+ 3.8152778 0.357374
+ 3.8155556 0.315898
+ 3.8158333 0.271859
+ 3.8161111 0.227155
+ 3.8163889 0.183685
+ 3.8166667 0.143347
+ 3.8169444 0.107790
+ 3.8172222 0.077653
+ 3.8175000 0.053327
+ 3.8177778 0.050000
+ 3.8180556 0.050000
+ 3.8183333 0.050000
+ 3.8186111 0.050000
+ 3.8188889 0.050000
+ 3.8191667 0.051239
+ 3.8194444 0.078508
+ 3.8197222 0.114260
+ 3.8200000 0.156651
+ 3.8202778 0.203390
+ 3.8205556 0.252185
+ 3.8208333 0.300745
+ 3.8211111 0.346780
+ 3.8213889 0.387996
+ 3.8216667 0.422105
+ 3.8219444 0.446813
+ 3.8222222 0.459830
+ 3.8225000 0.459568
+ 3.8227778 0.447256
+ 3.8230556 0.424824
+ 3.8233333 0.394203
+ 3.8236111 0.357327
+ 3.8238889 0.316125
+ 3.8241667 0.272529
+ 3.8244444 0.228471
+ 3.8247222 0.185882
+ 3.8250000 0.146694
+ 3.8252778 0.112567
+ 3.8255556 0.084075
+ 3.8258333 0.061520
+ 3.8261111 0.050000
+ 3.8263889 0.050000
+ 3.8266667 0.050000
+ 3.8269444 0.050000
+ 3.8272222 0.050000
+ 3.8275000 0.067818
+ 3.8277778 0.095296
+ 3.8280556 0.130713
+ 3.8283333 0.172271
+ 3.8286111 0.217755
+ 3.8288889 0.264949
+ 3.8291667 0.311635
+ 3.8294444 0.355598
+ 3.8297222 0.394622
+ 3.8300000 0.426490
+ 3.8302778 0.448987
+ 3.8305556 0.459895
+ 3.8308333 0.457692
+ 3.8311111 0.443624
+ 3.8313889 0.419630
+ 3.8316667 0.387650
+ 3.8319444 0.349622
+ 3.8322222 0.307487
+ 3.8325000 0.263183
+ 3.8327778 0.218650
+ 3.8330556 0.175827
+ 3.8333333 0.136653
+ 3.8336111 0.102787
+ 3.8338889 0.074767
+ 3.8341667 0.052849
+ 3.8344444 0.050000
+ 3.8347222 0.050000
+ 3.8350000 0.050000
+ 3.8352778 0.050000
+ 3.8355556 0.050000
+ 3.8358333 0.063888
+ 3.8361111 0.091884
+ 3.8363889 0.127635
+ 3.8366667 0.169383
+ 3.8369444 0.214967
+ 3.8372222 0.262225
+ 3.8375000 0.308996
+ 3.8377778 0.353118
+ 3.8380556 0.392431
+ 3.8383333 0.424772
+ 3.8386111 0.447981
+ 3.8388889 0.459895
+ 3.8391667 0.459022
+ 3.8394444 0.446539
+ 3.8397222 0.424289
+ 3.8400000 0.394117
+ 3.8402778 0.357869
+ 3.8405556 0.317389
+ 3.8408333 0.274522
+ 3.8411111 0.231112
+ 3.8413889 0.189003
+ 3.8416667 0.150042
+ 3.8419444 0.115824
+ 3.8422222 0.086958
+ 3.8425000 0.063803
+ 3.8427778 0.050000
+ 3.8430556 0.050000
+ 3.8433333 0.050000
+ 3.8436111 0.050000
+ 3.8438889 0.050000
+ 3.8441667 0.065005
+ 3.8444444 0.091923
+ 3.8447222 0.127002
+ 3.8450000 0.168435
+ 3.8452778 0.213983
+ 3.8455556 0.261405
+ 3.8458333 0.308462
+ 3.8461111 0.352913
+ 3.8463889 0.392517
+ 3.8466667 0.425036
+ 3.8469444 0.448229
+ 3.8472222 0.459856
+ 3.8475000 0.458373
+ 3.8477778 0.445021
+ 3.8480556 0.421737
+ 3.8483333 0.390457
+ 3.8486111 0.353119
+ 3.8488889 0.311660
+ 3.8491667 0.268016
+ 3.8494444 0.224125
+ 3.8497222 0.181923
+ 3.8500000 0.143347
+ 3.8502778 0.110054
+ 3.8505556 0.082573
+ 3.8508333 0.061155
+ 3.8511111 0.050000
+ 3.8513889 0.050000
+ 3.8516667 0.050000
+ 3.8519444 0.050000
+ 3.8522222 0.053747
+ 3.8525000 0.073950
+ 3.8527778 0.101965
+ 3.8530556 0.137633
+ 3.8533333 0.179171
+ 3.8536111 0.224389
+ 3.8538889 0.271097
+ 3.8541667 0.317103
+ 3.8544444 0.360217
+ 3.8547222 0.398249
+ 3.8550000 0.429009
+ 3.8552778 0.450305
+ 3.8555556 0.459948
+ 3.8558333 0.456449
+ 3.8561111 0.441135
+ 3.8563889 0.416033
+ 3.8566667 0.383172
+ 3.8569444 0.344580
+ 3.8572222 0.302286
+ 3.8575000 0.258318
+ 3.8577778 0.214704
+ 3.8580556 0.173473
+ 3.8583333 0.136653
+ 3.8586111 0.105940
+ 3.8588889 0.081704
+ 3.8591667 0.063980
+ 3.8594444 0.052806
+ 3.8597222 0.050000
+ 3.8600000 0.050253
+ 3.8602778 0.058948
+ 3.8605556 0.074338
+ 3.8608333 0.096462
+ 3.8611111 0.125356
+ 3.8613889 0.160721
+ 3.8616667 0.200922
+ 3.8619444 0.243986
+ 3.8622222 0.287944
+ 3.8625000 0.330824
+ 3.8627778 0.370655
+ 3.8630556 0.405466
+ 3.8633333 0.433285
+ 3.8636111 0.452142
+ 3.8638889 0.460065
+ 3.8641667 0.455727
+ 3.8644444 0.440367
+ 3.8647222 0.415868
+ 3.8650000 0.384115
+ 3.8652778 0.346990
+ 3.8655556 0.306376
+ 3.8658333 0.264156
+ 3.8661111 0.222214
+ 3.8663889 0.182432
+ 3.8666667 0.146694
+ 3.8669444 0.116586
+ 3.8672222 0.092505
+ 3.8675000 0.074549
+ 3.8677778 0.062817
+ 3.8680556 0.057411
+ 3.8683333 0.058427
+ 3.8686111 0.065967
+ 3.8688889 0.080129
+ 3.8691667 0.101012
+ 3.8694444 0.128716
+ 3.8697222 0.162998
+ 3.8700000 0.202243
+ 3.8702778 0.244494
+ 3.8705556 0.287793
+ 3.8708333 0.330185
+ 3.8711111 0.369712
+ 3.8713889 0.404416
+ 3.8716667 0.432342
+ 3.8719444 0.451531
+ 3.8722222 0.460026
+ 3.8725000 0.456505
+ 3.8727778 0.442179
+ 3.8730556 0.418894
+ 3.8733333 0.388496
+ 3.8736111 0.352830
+ 3.8738889 0.313742
+ 3.8741667 0.273078
+ 3.8744444 0.232683
+ 3.8747222 0.194403
+ 3.8750000 0.160083
+ 3.8752778 0.131275
+ 3.8755556 0.108347
+ 3.8758333 0.091374
+ 3.8761111 0.080430
+ 3.8763889 0.075589
+ 3.8766667 0.076926
+ 3.8769444 0.084514
+ 3.8772222 0.098428
+ 3.8775000 0.118742
+ 3.8777778 0.145531
+ 3.8780556 0.178542
+ 3.8783333 0.216222
+ 3.8786111 0.256690
+ 3.8788889 0.298068
+ 3.8791667 0.338474
+ 3.8794444 0.376029
+ 3.8797222 0.408854
+ 3.8800000 0.435068
+ 3.8802778 0.452791
+ 3.8805556 0.460144
+ 3.8808333 0.455860
+ 3.8811111 0.441128
+ 3.8813889 0.417751
+ 3.8816667 0.387530
+ 3.8819444 0.352268
+ 3.8822222 0.313768
+ 3.8825000 0.273832
+ 3.8827778 0.234262
+ 3.8830556 0.196861
+ 3.8833333 0.163431
+ 3.8836111 0.135482
+ 3.8838889 0.113358
+ 3.8841667 0.097109
+ 3.8844444 0.086788
+ 3.8847222 0.082445
+ 3.8850000 0.084132
+ 3.8852778 0.091899
+ 3.8855556 0.105799
+ 3.8858333 0.125882
+ 3.8861111 0.152199
+ 3.8863889 0.184493
+ 3.8866667 0.221268
+ 3.8869444 0.260718
+ 3.8872222 0.301038
+ 3.8875000 0.340424
+ 3.8877778 0.377071
+ 3.8880556 0.409172
+ 3.8883333 0.434924
+ 3.8886111 0.452520
+ 3.8888889 0.460157
+ 3.8891667 0.456610
+ 3.8894444 0.442984
+ 3.8897222 0.420965
+ 3.8900000 0.392240
+ 3.8902778 0.358494
+ 3.8905556 0.321413
+ 3.8908333 0.282685
+ 3.8911111 0.243994
+ 3.8913889 0.207028
+ 3.8916667 0.173472
+ 3.8919444 0.144762
+ 3.8922222 0.121330
+ 3.8925000 0.103357
+ 3.8927778 0.091024
+ 3.8930556 0.084513
+ 3.8933333 0.084004
+ 3.8936111 0.089680
+ 3.8938889 0.101721
+ 3.8941667 0.120308
+ 3.8944444 0.145622
+ 3.8947222 0.177497
+ 3.8950000 0.214371
+ 3.8952778 0.254333
+ 3.8955556 0.295473
+ 3.8958333 0.335881
+ 3.8961111 0.373646
+ 3.8963889 0.406859
+ 3.8966667 0.433609
+ 3.8969444 0.451985
+ 3.8972222 0.460078
+ 3.8975000 0.456593
+ 3.8977778 0.442693
+ 3.8980556 0.420158
+ 3.8983333 0.390769
+ 3.8986111 0.356303
+ 3.8988889 0.318542
+ 3.8991667 0.279264
+ 3.8994444 0.240248
+ 3.8997222 0.203276
+ 3.9000000 0.170125
+ 3.9002778 0.142291
+ 3.9005556 0.120130
+ 3.9008333 0.103713
+ 3.9011111 0.093113
+ 3.9013889 0.088399
+ 3.9016667 0.089644
+ 3.9019444 0.096919
+ 3.9022222 0.110295
+ 3.9025000 0.129844
+ 3.9027778 0.155638
+ 3.9030556 0.187434
+ 3.9033333 0.223743
+ 3.9036111 0.262758
+ 3.9038889 0.302677
+ 3.9041667 0.341694
+ 3.9044444 0.378006
+ 3.9047222 0.409809
+ 3.9050000 0.435298
+ 3.9052778 0.452669
+ 3.9055556 0.460118
+ 3.9058333 0.456425
+ 3.9061111 0.442711
+ 3.9063889 0.420681
+ 3.9066667 0.392039
+ 3.9069444 0.358490
+ 3.9072222 0.321740
+ 3.9075000 0.283493
+ 3.9077778 0.245454
+ 3.9080556 0.209328
+ 3.9083333 0.176819
+ 3.9086111 0.149367
+ 3.9088889 0.127342
+ 3.9091667 0.110848
+ 3.9094444 0.099988
+ 3.9097222 0.094866
+ 3.9100000 0.095587
+ 3.9102778 0.102254
+ 3.9105556 0.114971
+ 3.9108333 0.133843
+ 3.9111111 0.158972
+ 3.9113889 0.190146
+ 3.9116667 0.225883
+ 3.9119444 0.264385
+ 3.9122222 0.303852
+ 3.9125000 0.342486
+ 3.9127778 0.378487
+ 3.9130556 0.410058
+ 3.9133333 0.435399
+ 3.9136111 0.452711
+ 3.9138889 0.460196
+ 3.9141667 0.456626
+ 3.9144444 0.443060
+ 3.9147222 0.421125
+ 3.9150000 0.392451
+ 3.9152778 0.358668
+ 3.9155556 0.321404
+ 3.9158333 0.282289
+ 3.9161111 0.242951
+ 3.9163889 0.205020
+ 3.9166667 0.170125
+ 3.9169444 0.139674
+ 3.9172222 0.114189
+ 3.9175000 0.093975
+ 3.9177778 0.079333
+ 3.9180556 0.070566
+ 3.9183333 0.067975
+ 3.9186111 0.071865
+ 3.9188889 0.082536
+ 3.9191667 0.100292
+ 3.9194444 0.125434
+ 3.9197222 0.157877
+ 3.9200000 0.195972
+ 3.9202778 0.237686
+ 3.9205556 0.280982
+ 3.9208333 0.323823
+ 3.9211111 0.364176
+ 3.9213889 0.400003
+ 3.9216667 0.429269
+ 3.9219444 0.449938
+ 3.9222222 0.459974
+ 3.9225000 0.457971
+ 3.9227778 0.445038
+ 3.9230556 0.422914
+ 3.9233333 0.393337
+ 3.9236111 0.358047
+ 3.9238889 0.318781
+ 3.9241667 0.277278
+ 3.9244444 0.235277
+ 3.9247222 0.194517
+ 3.9250000 0.156736
+ 3.9252778 0.123446
+ 3.9255556 0.095253
+ 3.9258333 0.072535
+ 3.9261111 0.055672
+ 3.9263889 0.050000
+ 3.9266667 0.050000
+ 3.9269444 0.050000
+ 3.9272222 0.054342
+ 3.9275000 0.072435
+ 3.9277778 0.098657
+ 3.9280556 0.132953
+ 3.9283333 0.173547
+ 3.9286111 0.218229
+ 3.9288889 0.264790
+ 3.9291667 0.311021
+ 3.9294444 0.354711
+ 3.9297222 0.393651
+ 3.9300000 0.425633
+ 3.9302778 0.448447
+ 3.9305556 0.459882
+ 3.9308333 0.458409
+ 3.9311111 0.445204
+ 3.9313889 0.422125
+ 3.9316667 0.391027
+ 3.9319444 0.353767
+ 3.9322222 0.312201
+ 3.9325000 0.268185
+ 3.9327778 0.223575
+ 3.9330556 0.180228
+ 3.9333333 0.140000
+ 3.9336111 0.104504
+ 3.9338889 0.074385
+ 3.9341667 0.050044
+ 3.9344444 0.050000
+ 3.9347222 0.050000
+ 3.9350000 0.050000
+ 3.9352778 0.050000
+ 3.9355556 0.050000
+ 3.9358333 0.050000
+ 3.9361111 0.075148
+ 3.9363889 0.111028
+ 3.9366667 0.153603
+ 3.9369444 0.200578
+ 3.9372222 0.249656
+ 3.9375000 0.298545
+ 3.9377778 0.344948
+ 3.9380556 0.386572
+ 3.9383333 0.421121
+ 3.9386111 0.446301
+ 3.9388889 0.459817
+ 3.9391667 0.460069
+ 3.9394444 0.448236
+ 3.9397222 0.426191
+ 3.9400000 0.395809
+ 3.9402778 0.358962
+ 3.9405556 0.317525
+ 3.9408333 0.273372
+ 3.9411111 0.228375
+ 3.9413889 0.184409
+ 3.9416667 0.143347
+ 3.9419444 0.106827
+ 3.9422222 0.075542
+ 3.9425000 0.050000
+ 3.9427778 0.050000
+ 3.9430556 0.050000
+ 3.9433333 0.050000
+ 3.9436111 0.050000
+ 3.9438889 0.050000
+ 3.9441667 0.050000
+ 3.9444444 0.068466
+ 3.9447222 0.104361
+ 3.9450000 0.147247
+ 3.9452778 0.194772
+ 3.9455556 0.244583
+ 3.9458333 0.294330
+ 3.9461111 0.341660
+ 3.9463889 0.384222
+ 3.9466667 0.419663
+ 3.9469444 0.445632
+ 3.9472222 0.459778
+ 3.9475000 0.460457
+ 3.9477778 0.448869
+ 3.9480556 0.426919
+ 3.9483333 0.396514
+ 3.9486111 0.359563
+ 3.9488889 0.317971
+ 3.9491667 0.273647
+ 3.9494444 0.228497
+ 3.9497222 0.184428
+ 3.9500000 0.143347
+ 3.9502778 0.106918
+ 3.9505556 0.075823
+ 3.9508333 0.050502
+ 3.9511111 0.050000
+ 3.9513889 0.050000
+ 3.9516667 0.050000
+ 3.9519444 0.050000
+ 3.9522222 0.050000
+ 3.9525000 0.050000
+ 3.9527778 0.071826
+ 3.9530556 0.108042
+ 3.9533333 0.151169
+ 3.9536111 0.198831
+ 3.9538889 0.248652
+ 3.9541667 0.298255
+ 3.9544444 0.345264
+ 3.9547222 0.387303
+ 3.9550000 0.421994
+ 3.9552778 0.446962
+ 3.9555556 0.459830
+ 3.9558333 0.458948
+ 3.9561111 0.445571
+ 3.9563889 0.421683
+ 3.9566667 0.389264
+ 3.9569444 0.350297
+ 3.9572222 0.306764
+ 3.9575000 0.260646
+ 3.9577778 0.213927
+ 3.9580556 0.168588
+ 3.9583333 0.126611
+ 3.9586111 0.089712
+ 3.9588889 0.058543
+ 3.9591667 0.050000
+ 3.9594444 0.050000
+ 3.9597222 0.050000
+ 3.9600000 0.050000
+ 3.9602778 0.050000
+ 3.9605556 0.050000
+ 3.9608333 0.050000
+ 3.9611111 0.061693
+ 3.9613889 0.098973
+ 3.9616667 0.143096
+ 3.9619444 0.191706
+ 3.9622222 0.242448
+ 3.9625000 0.292968
+ 3.9627778 0.340911
+ 3.9630556 0.383920
+ 3.9633333 0.419643
+ 3.9636111 0.445722
+ 3.9638889 0.459804
+ 3.9641667 0.460247
+ 3.9644444 0.448267
+ 3.9647222 0.425791
+ 3.9650000 0.394751
+ 3.9652778 0.357073
+ 3.9655556 0.314688
+ 3.9658333 0.269525
+ 3.9661111 0.223512
+ 3.9663889 0.178578
+ 3.9666667 0.136653
+ 3.9669444 0.099420
+ 3.9672222 0.067580
+ 3.9675000 0.050000
+ 3.9677778 0.050000
+ 3.9680556 0.050000
+ 3.9683333 0.050000
+ 3.9686111 0.050000
+ 3.9688889 0.050000
+ 3.9691667 0.050000
+ 3.9694444 0.061746
+ 3.9697222 0.098490
+ 3.9700000 0.142326
+ 3.9702778 0.190851
+ 3.9705556 0.241658
+ 3.9708333 0.292344
+ 3.9711111 0.340503
+ 3.9713889 0.383730
+ 3.9716667 0.419622
+ 3.9719444 0.445773
+ 3.9722222 0.459778
+ 3.9725000 0.459963
+ 3.9727778 0.447576
+ 3.9730556 0.424595
+ 3.9733333 0.393000
+ 3.9736111 0.354768
+ 3.9738889 0.311878
+ 3.9741667 0.266308
+ 3.9744444 0.220037
+ 3.9747222 0.175043
+ 3.9750000 0.133306
+ 3.9752778 0.096540
+ 3.9755556 0.065417
+ 3.9758333 0.050000
+ 3.9761111 0.050000
+ 3.9763889 0.050000
+ 3.9766667 0.050000
+ 3.9769444 0.050000
+ 3.9772222 0.050000
+ 3.9775000 0.050000
+ 3.9777778 0.068479
+ 3.9780556 0.106009
+ 3.9783333 0.150409
+ 3.9786111 0.199236
+ 3.9788889 0.250046
+ 3.9791667 0.300399
+ 3.9794444 0.347850
+ 3.9797222 0.389957
+ 3.9800000 0.424278
+ 3.9802778 0.448370
+ 3.9805556 0.459791
+ 3.9808333 0.456857
+ 3.9811111 0.440928
+ 3.9813889 0.414121
+ 3.9816667 0.378554
+ 3.9819444 0.336347
+ 3.9822222 0.289616
+ 3.9825000 0.240482
+ 3.9827778 0.191061
+ 3.9830556 0.143472
+ 3.9833333 0.099833
+ 3.9836111 0.061967
+ 3.9838889 0.050000
+ 3.9841667 0.050000
+ 3.9844444 0.050000
+ 3.9847222 0.050000
+ 3.9850000 0.050000
+ 3.9852778 0.050000
+ 3.9855556 0.050000
+ 3.9858333 0.050000
+ 3.9861111 0.050000
+ 3.9863889 0.090916
+ 3.9866667 0.138704
+ 3.9869444 0.190791
+ 3.9872222 0.244603
+ 3.9875000 0.297566
+ 3.9877778 0.347105
+ 3.9880556 0.390646
+ 3.9883333 0.425615
+ 3.9886111 0.449439
+ 3.9888889 0.459542
+ 3.9891667 0.454178
+ 3.9894444 0.434906
+ 3.9897222 0.404112
+ 3.9900000 0.364182
+ 3.9902778 0.317501
+ 3.9905556 0.266457
+ 3.9908333 0.213435
+ 3.9911111 0.160821
+ 3.9913889 0.111001
+ 3.9916667 0.066361
+ 3.9919444 0.050000
+ 3.9922222 0.050000
+ 3.9925000 0.050000
+ 3.9927778 0.050000
+ 3.9930556 0.050000
+ 3.9933333 0.050000
+ 3.9936111 0.050000
+ 3.9938889 0.050000
+ 3.9941667 0.050000
+ 3.9944444 0.050000
+ 3.9947222 0.093668
+ 3.9950000 0.143454
+ 3.9952778 0.196836
+ 3.9955556 0.251293
+ 3.9958333 0.304304
+ 3.9961111 0.353348
+ 3.9963889 0.395903
+ 3.9966667 0.429448
+ 3.9969444 0.451462
+ 3.9972222 0.459425
+ 3.9975000 0.451652
+ 3.9977778 0.429816
+ 3.9980556 0.396426
+ 3.9983333 0.353992
+ 3.9986111 0.305023
+ 3.9988889 0.252030
+ 3.9991667 0.197521
+ 3.9994444 0.144006
+ 3.9997222 0.093996
+ 4.0000000 0.050000
+ 4.0002778 0.050000
+ 4.0005556 0.050000
+ 4.0008333 0.050000
+ 4.0011111 0.050000
+ 4.0013889 0.050000
+ 4.0016667 0.050000
+ 4.0019444 0.050000
+ 4.0022222 0.050000
+ 4.0025000 0.050000
+ 4.0027778 0.050000
+ 4.0030556 0.090890
+ 4.0033333 0.136905
+ 4.0036111 0.186126
+ 4.0038889 0.236632
+ 4.0041667 0.286504
+ 4.0044444 0.333822
+ 4.0047222 0.376666
+ 4.0050000 0.413118
+ 4.0052778 0.441257
+ 4.0055556 0.459163
+ 4.0058333 0.465468
+ 4.0061111 0.461004
+ 4.0063889 0.447154
+ 4.0066667 0.425302
+ 4.0069444 0.396830
+ 4.0072222 0.363123
+ 4.0075000 0.325563
+ 4.0077778 0.285533
+ 4.0080556 0.244417
+ 4.0083333 0.203597
+ 4.0086111 0.164392
+ 4.0088889 0.127854
+ 4.0091667 0.094970
+ 4.0094444 0.066727
+ 4.0097222 0.050000
+ 4.0100000 0.050000
+ 4.0102778 0.050000
+ 4.0105556 0.050000
+ 4.0108333 0.050000
+ 4.0111111 0.050000
+ 4.0113889 0.081341
+ 4.0116667 0.121993
+ 4.0119444 0.169714
+ 4.0122222 0.222265
+ 4.0125000 0.277407
+ 4.0127778 0.332898
+ 4.0130556 0.386500
+ 4.0133333 0.435973
+ 4.0136111 0.479075
+ 4.0138889 0.513569
+ 4.0141667 0.537819
+ 4.0144444 0.552617
+ 4.0147222 0.559359
+ 4.0150000 0.559444
+ 4.0152778 0.554267
+ 4.0155556 0.545226
+ 4.0158333 0.533718
+ 4.0161111 0.521140
+ 4.0163889 0.508889
+ 4.0166667 0.498362
+ 4.0169444 0.490640
+ 4.0172222 0.485535
+ 4.0175000 0.482544
+ 4.0177778 0.481164
+ 4.0180556 0.480890
+ 4.0183333 0.481220
+ 4.0186111 0.481650
+ 4.0188889 0.481675
+ 4.0191667 0.480794
+ 4.0194444 0.478501
+ 4.0197222 0.474543
+ 4.0200000 0.469657
+ 4.0202778 0.464830
+ 4.0205556 0.461049
+ 4.0208333 0.459301
+ 4.0211111 0.460573
+ 4.0213889 0.465851
+ 4.0216667 0.476123
+ 4.0219444 0.492376
+ 4.0222222 0.515595
+ 4.0225000 0.546120
+ 4.0227778 0.581693
+ 4.0230556 0.619406
+ 4.0233333 0.656354
+ 4.0236111 0.689631
+ 4.0238889 0.716329
+ 4.0241667 0.733542
+ 4.0244444 0.738364
+ 4.0247222 0.727889
+ 4.0250000 0.699209
+ 4.0252778 0.650697
+ 4.0255556 0.585837
+ 4.0258333 0.509392
+ 4.0261111 0.426126
+ 4.0263889 0.340801
+ 4.0266667 0.258180
+ 4.0269444 0.183026
+ 4.0272222 0.120103
+ 4.0275000 0.074173
+ 4.0277778 0.050000
+ 4.0280556 0.050756
+ 4.0283333 0.073253
+ 4.0286111 0.112714
+ 4.0288889 0.164360
+ 4.0291667 0.223414
+ 4.0294444 0.285098
+ 4.0297222 0.344634
+ 4.0300000 0.397244
+ 4.0302778 0.438151
+ 4.0305556 0.462576
+ 4.0308333 0.467062
+ 4.0311111 0.453433
+ 4.0313889 0.424836
+ 4.0316667 0.384414
+ 4.0319444 0.335315
+ 4.0322222 0.280682
+ 4.0325000 0.223660
+ 4.0327778 0.167397
+ 4.0330556 0.115035
+ 4.0333333 0.069721
+ 4.0336111 0.050000
+ 4.0338889 0.050000
+ 4.0341667 0.050000
+ 4.0344444 0.050000
+ 4.0347222 0.050000
+ 4.0350000 0.050000
+ 4.0352778 0.050000
+ 4.0355556 0.050000
+ 4.0358333 0.062219
+ 4.0361111 0.098369
+ 4.0363889 0.140051
+ 4.0366667 0.185599
+ 4.0369444 0.233098
+ 4.0372222 0.280635
+ 4.0375000 0.326298
+ 4.0377778 0.368172
+ 4.0380556 0.404346
+ 4.0383333 0.432905
+ 4.0386111 0.451938
+ 4.0388889 0.459529
+ 4.0391667 0.454395
+ 4.0394444 0.437762
+ 4.0397222 0.411483
+ 4.0400000 0.377414
+ 4.0402778 0.337407
+ 4.0405556 0.293319
+ 4.0408333 0.247001
+ 4.0411111 0.200310
+ 4.0413889 0.155099
+ 4.0416667 0.113222
+ 4.0419444 0.076298
+ 4.0422222 0.050000
+ 4.0425000 0.050000
+ 4.0427778 0.050000
+ 4.0430556 0.050000
+ 4.0433333 0.050000
+ 4.0436111 0.050000
+ 4.0438889 0.050000
+ 4.0441667 0.050000
+ 4.0444444 0.050000
+ 4.0447222 0.088654
+ 4.0450000 0.134419
+ 4.0452778 0.184820
+ 4.0455556 0.237385
+ 4.0458333 0.289640
+ 4.0461111 0.339110
+ 4.0463889 0.383322
+ 4.0466667 0.419803
+ 4.0469444 0.446077
+ 4.0472222 0.459673
+ 4.0475000 0.458875
+ 4.0477778 0.445005
+ 4.0480556 0.420145
+ 4.0483333 0.386375
+ 4.0486111 0.345778
+ 4.0488889 0.300434
+ 4.0491667 0.252426
+ 4.0494444 0.203833
+ 4.0497222 0.156738
+ 4.0500000 0.113222
+ 4.0502778 0.075084
+ 4.0505556 0.050000
+ 4.0508333 0.050000
+ 4.0511111 0.050000
+ 4.0513889 0.050000
+ 4.0516667 0.050000
+ 4.0519444 0.050000
+ 4.0522222 0.050000
+ 4.0525000 0.050000
+ 4.0527778 0.050000
+ 4.0530556 0.089137
+ 4.0533333 0.135299
+ 4.0536111 0.186004
+ 4.0538889 0.238771
+ 4.0541667 0.291119
+ 4.0544444 0.340566
+ 4.0547222 0.384632
+ 4.0550000 0.420835
+ 4.0552778 0.446693
+ 4.0555556 0.459725
+ 4.0558333 0.458219
+ 4.0561111 0.443531
+ 4.0563889 0.417786
+ 4.0566667 0.383111
+ 4.0569444 0.341630
+ 4.0572222 0.295469
+ 4.0575000 0.246753
+ 4.0577778 0.197607
+ 4.0580556 0.150157
+ 4.0583333 0.106528
+ 4.0586111 0.068547
+ 4.0588889 0.050000
+ 4.0591667 0.050000
+ 4.0594444 0.050000
+ 4.0597222 0.050000
+ 4.0600000 0.050000
+ 4.0602778 0.050000
+ 4.0605556 0.050000
+ 4.0608333 0.050000
+ 4.0611111 0.050000
+ 4.0613889 0.089581
+ 4.0616667 0.136027
+ 4.0619444 0.186877
+ 4.0622222 0.239675
+ 4.0625000 0.291963
+ 4.0627778 0.341282
+ 4.0630556 0.385175
+ 4.0633333 0.421183
+ 4.0636111 0.446848
+ 4.0638889 0.459712
+ 4.0641667 0.458081
+ 4.0644444 0.443310
+ 4.0647222 0.417521
+ 4.0650000 0.382832
+ 4.0652778 0.341364
+ 4.0655556 0.295236
+ 4.0658333 0.246569
+ 4.0661111 0.197481
+ 4.0663889 0.150095
+ 4.0666667 0.106528
+ 4.0669444 0.068603
+ 4.0672222 0.050000
+ 4.0675000 0.050000
+ 4.0677778 0.050000
+ 4.0680556 0.050000
+ 4.0683333 0.050000
+ 4.0686111 0.050000
+ 4.0688889 0.050000
+ 4.0691667 0.050000
+ 4.0694444 0.050000
+ 4.0697222 0.089484
+ 4.0700000 0.135821
+ 4.0702778 0.186565
+ 4.0705556 0.239269
+ 4.0708333 0.291487
+ 4.0711111 0.340774
+ 4.0713889 0.384684
+ 4.0716667 0.420770
+ 4.0719444 0.446586
+ 4.0722222 0.459686
+ 4.0725000 0.458382
+ 4.0727778 0.444009
+ 4.0730556 0.418663
+ 4.0733333 0.384438
+ 4.0736111 0.343426
+ 4.0738889 0.297723
+ 4.0741667 0.249423
+ 4.0744444 0.200618
+ 4.0747222 0.153405
+ 4.0750000 0.109875
+ 4.0752778 0.071836
+ 4.0755556 0.050000
+ 4.0758333 0.050000
+ 4.0761111 0.050000
+ 4.0763889 0.050000
+ 4.0766667 0.050000
+ 4.0769444 0.050000
+ 4.0772222 0.050000
+ 4.0775000 0.050000
+ 4.0777778 0.050000
+ 4.0780556 0.089433
+ 4.0783333 0.135828
+ 4.0786111 0.186702
+ 4.0788889 0.239574
+ 4.0791667 0.291961
+ 4.0794444 0.341381
+ 4.0797222 0.385350
+ 4.0800000 0.421388
+ 4.0802778 0.447012
+ 4.0805556 0.459738
+ 4.0808333 0.457858
+ 4.0811111 0.442745
+ 4.0813889 0.416549
+ 4.0816667 0.381415
+ 4.0819444 0.339491
+ 4.0822222 0.292925
+ 4.0825000 0.243863
+ 4.0827778 0.194454
+ 4.0830556 0.146844
+ 4.0833333 0.103181
+ 4.0836111 0.065305
+ 4.0838889 0.050000
+ 4.0841667 0.050000
+ 4.0844444 0.050000
+ 4.0847222 0.050000
+ 4.0850000 0.050000
+ 4.0852778 0.050000
+ 4.0855556 0.050000
+ 4.0858333 0.050000
+ 4.0861111 0.050000
+ 4.0863889 0.089721
+ 4.0866667 0.136213
+ 4.0869444 0.187042
+ 4.0872222 0.239772
+ 4.0875000 0.291969
+ 4.0877778 0.341197
+ 4.0880556 0.385023
+ 4.0883333 0.421012
+ 4.0886111 0.446729
+ 4.0888889 0.459738
+ 4.0891667 0.458361
+ 4.0894444 0.443935
+ 4.0897222 0.418552
+ 4.0900000 0.384306
+ 4.0902778 0.343289
+ 4.0905556 0.297593
+ 4.0908333 0.249311
+ 4.0911111 0.200535
+ 4.0913889 0.153359
+ 4.0916667 0.109875
+ 4.0919444 0.071887
+ 4.0922222 0.050000
+ 4.0925000 0.050000
+ 4.0927778 0.050000
+ 4.0930556 0.050000
+ 4.0933333 0.050000
+ 4.0936111 0.050000
+ 4.0938889 0.050000
+ 4.0941667 0.050000
+ 4.0944444 0.050000
+ 4.0947222 0.089288
+ 4.0950000 0.135516
+ 4.0952778 0.186222
+ 4.0955556 0.238942
+ 4.0958333 0.291216
+ 4.0961111 0.340578
+ 4.0963889 0.384568
+ 4.0966667 0.420722
+ 4.0969444 0.446578
+ 4.0972222 0.459673
+ 4.0975000 0.458307
+ 4.0977778 0.443832
+ 4.0980556 0.418363
+ 4.0983333 0.384014
+ 4.0986111 0.342901
+ 4.0988889 0.297137
+ 4.0991667 0.248838
+ 4.0994444 0.200118
+ 4.0997222 0.153092
+ 4.1000000 0.109875
+ 4.1002778 0.072284
+ 4.1005556 0.050000
+ 4.1008333 0.050000
+ 4.1011111 0.050000
+ 4.1013889 0.050000
+ 4.1016667 0.050000
+ 4.1019444 0.050000
+ 4.1022222 0.050000
+ 4.1025000 0.050000
+ 4.1027778 0.054986
+ 4.1030556 0.094322
+ 4.1033333 0.140437
+ 4.1036111 0.190882
+ 4.1038889 0.243212
+ 4.1041667 0.294979
+ 4.1044444 0.343737
+ 4.1047222 0.387038
+ 4.1050000 0.422437
+ 4.1052778 0.447486
+ 4.1055556 0.459738
+ 4.1058333 0.457511
+ 4.1061111 0.442171
+ 4.1063889 0.415851
+ 4.1066667 0.380681
+ 4.1069444 0.338793
+ 4.1072222 0.292319
+ 4.1075000 0.243389
+ 4.1077778 0.194135
+ 4.1080556 0.146689
+ 4.1083333 0.103181
+ 4.1086111 0.065439
+ 4.1088889 0.050000
+ 4.1091667 0.050000
+ 4.1094444 0.050000
+ 4.1097222 0.050000
+ 4.1100000 0.050000
+ 4.1102778 0.050000
+ 4.1105556 0.050000
+ 4.1108333 0.050000
+ 4.1111111 0.050000
+ 4.1113889 0.089534
+ 4.1116667 0.135822
+ 4.1119444 0.186451
+ 4.1122222 0.239008
+ 4.1125000 0.291081
+ 4.1127778 0.340258
+ 4.1130556 0.384124
+ 4.1133333 0.420268
+ 4.1136111 0.446277
+ 4.1138889 0.459738
+ 4.1141667 0.458983
+ 4.1144444 0.445313
+ 4.1147222 0.420774
+ 4.1150000 0.387414
+ 4.1152778 0.347278
+ 4.1155556 0.302411
+ 4.1158333 0.254861
+ 4.1161111 0.206674
+ 4.1163889 0.159894
+ 4.1166667 0.116569
+ 4.1169444 0.078472
+ 4.1172222 0.050000
+ 4.1175000 0.050000
+ 4.1177778 0.050000
+ 4.1180556 0.050000
+ 4.1183333 0.050000
+ 4.1186111 0.050000
+ 4.1188889 0.050000
+ 4.1191667 0.050000
+ 4.1194444 0.050000
+ 4.1197222 0.088723
+ 4.1200000 0.134530
+ 4.1202778 0.184952
+ 4.1205556 0.237518
+ 4.1208333 0.289760
+ 4.1211111 0.339206
+ 4.1213889 0.383388
+ 4.1216667 0.419835
+ 4.1219444 0.446078
+ 4.1222222 0.459647
+ 4.1225000 0.458830
+ 4.1227778 0.444950
+ 4.1230556 0.420086
+ 4.1233333 0.386319
+ 4.1236111 0.345727
+ 4.1238889 0.300393
+ 4.1241667 0.252395
+ 4.1244444 0.203814
+ 4.1247222 0.156730
+ 4.1250000 0.113222
+ 4.1252778 0.075089
+ 4.1255556 0.050000
+ 4.1258333 0.050000
+ 4.1261111 0.050000
+ 4.1263889 0.050000
+ 4.1266667 0.050000
+ 4.1269444 0.050000
+ 4.1272222 0.050000
+ 4.1275000 0.050000
+ 4.1277778 0.050000
+ 4.1280556 0.089140
+ 4.1283333 0.135306
+ 4.1286111 0.186016
+ 4.1288889 0.238788
+ 4.1291667 0.291140
+ 4.1294444 0.340590
+ 4.1297222 0.384655
+ 4.1300000 0.420854
+ 4.1302778 0.446705
+ 4.1305556 0.459725
+ 4.1308333 0.458202
+ 4.1311111 0.443493
+ 4.1313889 0.417728
+ 4.1316667 0.383034
+ 4.1319444 0.341539
+ 4.1322222 0.295371
+ 4.1325000 0.246658
+ 4.1327778 0.197528
+ 4.1330556 0.150109
+ 4.1333333 0.106528
+ 4.1336111 0.068614
+ 4.1338889 0.050000
+ 4.1341667 0.050000
+ 4.1344444 0.050000
+ 4.1347222 0.050000
+ 4.1350000 0.050000
+ 4.1352778 0.050000
+ 4.1355556 0.050000
+ 4.1358333 0.050000
+ 4.1361111 0.050000
+ 4.1363889 0.089333
+ 4.1366667 0.135490
+ 4.1369444 0.186049
+ 4.1372222 0.238587
+ 4.1375000 0.290683
+ 4.1377778 0.339914
+ 4.1380556 0.383857
+ 4.1383333 0.420090
+ 4.1386111 0.446192
+ 4.1388889 0.459738
+ 4.1391667 0.459053
+ 4.1394444 0.445438
+ 4.1397222 0.420938
+ 4.1400000 0.387600
+ 4.1402778 0.347471
+ 4.1405556 0.302596
+ 4.1408333 0.255023
+ 4.1411111 0.206796
+ 4.1413889 0.159963
+ 4.1416667 0.116569
+ 4.1419444 0.078390
+ 4.1422222 0.050000
+ 4.1425000 0.050000
+ 4.1427778 0.050000
+ 4.1430556 0.050000
+ 4.1433333 0.050000
+ 4.1436111 0.050000
+ 4.1438889 0.050000
+ 4.1441667 0.050000
+ 4.1444444 0.050000
+ 4.1447222 0.088979
+ 4.1450000 0.135081
+ 4.1452778 0.185802
+ 4.1455556 0.238636
+ 4.1458333 0.291078
+ 4.1461111 0.340622
+ 4.1463889 0.384764
+ 4.1466667 0.420999
+ 4.1469444 0.446821
+ 4.1472222 0.459725
+ 4.1475000 0.457983
+ 4.1477778 0.442968
+ 4.1480556 0.416832
+ 4.1483333 0.381726
+ 4.1486111 0.339801
+ 4.1488889 0.293209
+ 4.1491667 0.244099
+ 4.1494444 0.194624
+ 4.1497222 0.146934
+ 4.1500000 0.103181
+ 4.1502778 0.065209
+ 4.1505556 0.050000
+ 4.1508333 0.050000
+ 4.1511111 0.050000
+ 4.1513889 0.050000
+ 4.1516667 0.050000
+ 4.1519444 0.050000
+ 4.1522222 0.050000
+ 4.1525000 0.050000
+ 4.1527778 0.050000
+ 4.1530556 0.089973
+ 4.1533333 0.136752
+ 4.1536111 0.187868
+ 4.1538889 0.240852
+ 4.1541667 0.293235
+ 4.1544444 0.342548
+ 4.1547222 0.386321
+ 4.1550000 0.422086
+ 4.1552778 0.447373
+ 4.1555556 0.459712
+ 4.1558333 0.457408
+ 4.1561111 0.441850
+ 4.1563889 0.415202
+ 4.1566667 0.379627
+ 4.1569444 0.337287
+ 4.1572222 0.290347
+ 4.1575000 0.240968
+ 4.1577778 0.191314
+ 4.1580556 0.143548
+ 4.1583333 0.099833
+ 4.1586111 0.062021
+ 4.1588889 0.050000
+ 4.1591667 0.050000
+ 4.1594444 0.050000
+ 4.1597222 0.050000
+ 4.1600000 0.050000
+ 4.1602778 0.050000
+ 4.1605556 0.050000
+ 4.1608333 0.050000
+ 4.1611111 0.050000
+ 4.1613889 0.090091
+ 4.1616667 0.136899
+ 4.1619444 0.187980
+ 4.1622222 0.240887
+ 4.1625000 0.293175
+ 4.1627778 0.342399
+ 4.1630556 0.386113
+ 4.1633333 0.421871
+ 4.1636111 0.447228
+ 4.1638889 0.459738
+ 4.1641667 0.457720
+ 4.1644444 0.442541
+ 4.1647222 0.416334
+ 4.1650000 0.381231
+ 4.1652778 0.339363
+ 4.1655556 0.292864
+ 4.1658333 0.243863
+ 4.1661111 0.194495
+ 4.1663889 0.146890
+ 4.1666667 0.103181
+ 4.1669444 0.065199
+ 4.1672222 0.050000
+ 4.1675000 0.050000
+ 4.1677778 0.050000
+ 4.1680556 0.050000
+ 4.1683333 0.050000
+ 4.1686111 0.050000
+ 4.1688889 0.050000
+ 4.1691667 0.050000
+ 4.1694444 0.050000
+ 4.1697222 0.090283
+ 4.1700000 0.137434
+ 4.1702778 0.188933
+ 4.1705556 0.242262
+ 4.1708333 0.294904
+ 4.1711111 0.344341
+ 4.1713889 0.388055
+ 4.1716667 0.423526
+ 4.1719444 0.448239
+ 4.1722222 0.459673
+ 4.1725000 0.456112
+ 4.1727778 0.439037
+ 4.1730556 0.410730
+ 4.1733333 0.373474
+ 4.1736111 0.329551
+ 4.1738889 0.281242
+ 4.1741667 0.230829
+ 4.1744444 0.180595
+ 4.1747222 0.132822
+ 4.1750000 0.089792
+ 4.1752778 0.053429
+ 4.1755556 0.050000
+ 4.1758333 0.050000
+ 4.1761111 0.050000
+ 4.1763889 0.050000
+ 4.1766667 0.050000
+ 4.1769444 0.050000
+ 4.1772222 0.050000
+ 4.1775000 0.050000
+ 4.1777778 0.064962
+ 4.1780556 0.105988
+ 4.1783333 0.153029
+ 4.1786111 0.203700
+ 4.1788889 0.255617
+ 4.1791667 0.306394
+ 4.1794444 0.353647
+ 4.1797222 0.394992
+ 4.1800000 0.428043
+ 4.1802778 0.450416
+ 4.1805556 0.459725
+ 4.1808333 0.454358
+ 4.1811111 0.435777
+ 4.1813889 0.406221
+ 4.1816667 0.367922
+ 4.1819444 0.323118
+ 4.1822222 0.274044
+ 4.1825000 0.222934
+ 4.1827778 0.172025
+ 4.1830556 0.123552
+ 4.1833333 0.079750
+ 4.1836111 0.050000
+ 4.1838889 0.050000
+ 4.1841667 0.050000
+ 4.1844444 0.050000
+ 4.1847222 0.050000
+ 4.1850000 0.050000
+ 4.1852778 0.050000
+ 4.1855556 0.050000
+ 4.1858333 0.050000
+ 4.1861111 0.050000
+ 4.1863889 0.091988
+ 4.1866667 0.140339
+ 4.1869444 0.192582
+ 4.1872222 0.246246
+ 4.1875000 0.298859
+ 4.1877778 0.347952
+ 4.1880556 0.391051
+ 4.1883333 0.425688
+ 4.1886111 0.449390
+ 4.1888889 0.459686
+ 4.1891667 0.454901
+ 4.1894444 0.436536
+ 4.1897222 0.406888
+ 4.1900000 0.368256
+ 4.1902778 0.322935
+ 4.1905556 0.273222
+ 4.1908333 0.221416
+ 4.1911111 0.169813
+ 4.1913889 0.120709
+ 4.1916667 0.076403
+ 4.1919444 0.050000
+ 4.1922222 0.050000
+ 4.1925000 0.050000
+ 4.1927778 0.050000
+ 4.1930556 0.050000
+ 4.1933333 0.050000
+ 4.1936111 0.050000
+ 4.1938889 0.050000
+ 4.1941667 0.050000
+ 4.1944444 0.050000
+ 4.1947222 0.092924
+ 4.1950000 0.142212
+ 4.1952778 0.195314
+ 4.1955556 0.249681
+ 4.1958333 0.302763
+ 4.1961111 0.352012
+ 4.1963889 0.394878
+ 4.1966667 0.428812
+ 4.1969444 0.451264
+ 4.1972222 0.459686
+ 4.1975000 0.452367
+ 4.1977778 0.430949
+ 4.1980556 0.397917
+ 4.1983333 0.355752
+ 4.1986111 0.306938
+ 4.1988889 0.253955
+ 4.1991667 0.199288
+ 4.1994444 0.145418
+ 4.1997222 0.094828
+ 4.2000000 0.050000
+ 4.2002778 0.050000
+ 4.2005556 0.050000
+ 4.2008333 0.050000
+ 4.2011111 0.050000
+ 4.2013889 0.050000
+ 4.2016667 0.050000
+ 4.2019444 0.050000
+ 4.2022222 0.050000
+ 4.2025000 0.050000
+ 4.2027778 0.050000
+ 4.2030556 0.094695
+ 4.2033333 0.145115
+ 4.2036111 0.198803
+ 4.2038889 0.253303
+ 4.2041667 0.306156
+ 4.2044444 0.354907
+ 4.2047222 0.397099
+ 4.2050000 0.430275
+ 4.2052778 0.451978
+ 4.2055556 0.459752
+ 4.2058333 0.451957
+ 4.2061111 0.430235
+ 4.2063889 0.397042
+ 4.2066667 0.354837
+ 4.2069444 0.306077
+ 4.2072222 0.253222
+ 4.2075000 0.198728
+ 4.2077778 0.145054
+ 4.2080556 0.094659
+ 4.2083333 0.050000
+ 4.2086111 0.050000
+ 4.2088889 0.050000
+ 4.2091667 0.050000
+ 4.2094444 0.050000
+ 4.2097222 0.050000
+ 4.2100000 0.050000
+ 4.2102778 0.050000
+ 4.2105556 0.050000
+ 4.2108333 0.050000
+ 4.2111111 0.050000
+ 4.2113889 0.094659
+ 4.2116667 0.145054
+ 4.2119444 0.198726
+ 4.2122222 0.253218
+ 4.2125000 0.306071
+ 4.2127778 0.354827
+ 4.2130556 0.397027
+ 4.2133333 0.430214
+ 4.2136111 0.451928
+ 4.2138889 0.459712
+ 4.2141667 0.451927
+ 4.2144444 0.430212
+ 4.2147222 0.397025
+ 4.2150000 0.354824
+ 4.2152778 0.306068
+ 4.2155556 0.253215
+ 4.2158333 0.198724
+ 4.2161111 0.145052
+ 4.2163889 0.094658
+ 4.2166667 0.050000
+ 4.2169444 0.050000
+ 4.2172222 0.050000
+ 4.2175000 0.050000
+ 4.2177778 0.050000
+ 4.2180556 0.050000
+ 4.2183333 0.050000
+ 4.2186111 0.050000
+ 4.2188889 0.050000
+ 4.2191667 0.050000
+ 4.2194444 0.050000
+ 4.2197222 0.094654
+ 4.2200000 0.145042
+ 4.2202778 0.198708
+ 4.2205556 0.253193
+ 4.2208333 0.306039
+ 4.2211111 0.354788
+ 4.2213889 0.396983
+ 4.2216667 0.430165
+ 4.2219444 0.451877
+ 4.2222222 0.459660
+ 4.2225000 0.451877
+ 4.2227778 0.430165
+ 4.2230556 0.396983
+ 4.2233333 0.354788
+ 4.2236111 0.306039
+ 4.2238889 0.253193
+ 4.2241667 0.198708
+ 4.2244444 0.145042
+ 4.2247222 0.094654
+ 4.2250000 0.050000
+ 4.2252778 0.050000
+ 4.2255556 0.050000
+ 4.2258333 0.050000
+ 4.2261111 0.050000
+ 4.2263889 0.050000
+ 4.2266667 0.050000
+ 4.2269444 0.050000
+ 4.2272222 0.050000
+ 4.2275000 0.050000
+ 4.2277778 0.050000
+ 4.2280556 0.094658
+ 4.2283333 0.145052
+ 4.2286111 0.198723
+ 4.2288889 0.253215
+ 4.2291667 0.306068
+ 4.2294444 0.354824
+ 4.2297222 0.397025
+ 4.2300000 0.430212
+ 4.2302778 0.451927
+ 4.2305556 0.459712
+ 4.2308333 0.451928
+ 4.2311111 0.430214
+ 4.2313889 0.397028
+ 4.2316667 0.354828
+ 4.2319444 0.306073
+ 4.2322222 0.253220
+ 4.2325000 0.198728
+ 4.2327778 0.145055
+ 4.2330556 0.094660
+ 4.2333333 0.050000
+ 4.2336111 0.050000
+ 4.2338889 0.050000
+ 4.2341667 0.050000
+ 4.2344444 0.050000
+ 4.2347222 0.050000
+ 4.2350000 0.050000
+ 4.2352778 0.050000
+ 4.2355556 0.050000
+ 4.2358333 0.050000
+ 4.2361111 0.050000
+ 4.2363889 0.094664
+ 4.2366667 0.145064
+ 4.2369444 0.198742
+ 4.2372222 0.253239
+ 4.2375000 0.306095
+ 4.2377778 0.354851
+ 4.2380556 0.397049
+ 4.2383333 0.430229
+ 4.2386111 0.451932
+ 4.2388889 0.459699
+ 4.2391667 0.451892
+ 4.2394444 0.430150
+ 4.2397222 0.396937
+ 4.2400000 0.354714
+ 4.2402778 0.305942
+ 4.2405556 0.253082
+ 4.2408333 0.198596
+ 4.2411111 0.144946
+ 4.2413889 0.094594
+ 4.2416667 0.050000
+ 4.2419444 0.050000
+ 4.2422222 0.050000
+ 4.2425000 0.050000
+ 4.2427778 0.050000
+ 4.2430556 0.050000
+ 4.2433333 0.050000
+ 4.2436111 0.050000
+ 4.2438889 0.050000
+ 4.2441667 0.050000
+ 4.2444444 0.050000
+ 4.2447222 0.094332
+ 4.2450000 0.144349
+ 4.2452778 0.197638
+ 4.2455556 0.251787
+ 4.2458333 0.304385
+ 4.2461111 0.353021
+ 4.2463889 0.395282
+ 4.2466667 0.428756
+ 4.2469444 0.451033
+ 4.2472222 0.459699
+ 4.2475000 0.453147
+ 4.2477778 0.432976
+ 4.2480556 0.401590
+ 4.2483333 0.361391
+ 4.2486111 0.314783
+ 4.2488889 0.264168
+ 4.2491667 0.211950
+ 4.2494444 0.160533
+ 4.2497222 0.112317
+ 4.2500000 0.069708
+ 4.2502778 0.050000
+ 4.2505556 0.050000
+ 4.2508333 0.050000
+ 4.2511111 0.050000
+ 4.2513889 0.050000
+ 4.2516667 0.050000
+ 4.2519444 0.050000
+ 4.2522222 0.050000
+ 4.2525000 0.050000
+ 4.2527778 0.071617
+ 4.2530556 0.113534
+ 4.2533333 0.160717
+ 4.2536111 0.210934
+ 4.2538889 0.261952
+ 4.2541667 0.311538
+ 4.2544444 0.357458
+ 4.2547222 0.397481
+ 4.2550000 0.429372
+ 4.2552778 0.450900
+ 4.2555556 0.459830
+ 4.2558333 0.454665
+ 4.2561111 0.436846
+ 4.2563889 0.408548
+ 4.2566667 0.371948
+ 4.2569444 0.329220
+ 4.2572222 0.282542
+ 4.2575000 0.234088
+ 4.2577778 0.186035
+ 4.2580556 0.140558
+ 4.2583333 0.099833
+ 4.2586111 0.065686
+ 4.2588889 0.050000
+ 4.2591667 0.050000
+ 4.2594444 0.050000
+ 4.2597222 0.050000
+ 4.2600000 0.050000
+ 4.2602778 0.050000
+ 4.2605556 0.050000
+ 4.2608333 0.050344
+ 4.2611111 0.081711
+ 4.2613889 0.120342
+ 4.2616667 0.164474
+ 4.2619444 0.211976
+ 4.2622222 0.260717
+ 4.2625000 0.308568
+ 4.2627778 0.353397
+ 4.2630556 0.393075
+ 4.2633333 0.425471
+ 4.2636111 0.448455
+ 4.2638889 0.459895
+ 4.2641667 0.458335
+ 4.2644444 0.445007
+ 4.2647222 0.421816
+ 4.2650000 0.390667
+ 4.2652778 0.353466
+ 4.2655556 0.312116
+ 4.2658333 0.268525
+ 4.2661111 0.224596
+ 4.2663889 0.182235
+ 4.2666667 0.143347
+ 4.2669444 0.109568
+ 4.2672222 0.081456
+ 4.2675000 0.059301
+ 4.2677778 0.050000
+ 4.2680556 0.050000
+ 4.2683333 0.050000
+ 4.2686111 0.050000
+ 4.2688889 0.050000
+ 4.2691667 0.067638
+ 4.2694444 0.095270
+ 4.2697222 0.130757
+ 4.2700000 0.172317
+ 4.2702778 0.217755
+ 4.2705556 0.264874
+ 4.2708333 0.311479
+ 4.2711111 0.355375
+ 4.2713889 0.394366
+ 4.2716667 0.426255
+ 4.2719444 0.448847
+ 4.2722222 0.459948
+ 4.2725000 0.458051
+ 4.2727778 0.444415
+ 4.2730556 0.420991
+ 4.2733333 0.389727
+ 4.2736111 0.352573
+ 4.2738889 0.311480
+ 4.2741667 0.268395
+ 4.2744444 0.225270
+ 4.2747222 0.184053
+ 4.2750000 0.146694
+ 4.2752778 0.114845
+ 4.2755556 0.088959
+ 4.2758333 0.069195
+ 4.2761111 0.055708
+ 4.2763889 0.050000
+ 4.2766667 0.050000
+ 4.2769444 0.054481
+ 4.2772222 0.067672
+ 4.2775000 0.087923
+ 4.2777778 0.115393
+ 4.2780556 0.149875
+ 4.2783333 0.189718
+ 4.2786111 0.232911
+ 4.2788889 0.277440
+ 4.2791667 0.321294
+ 4.2794444 0.362459
+ 4.2797222 0.398924
+ 4.2800000 0.428675
+ 4.2802778 0.449700
+ 4.2805556 0.459987
+ 4.2808333 0.458150
+ 4.2811111 0.445313
+ 4.2813889 0.423227
+ 4.2816667 0.393643
+ 4.2819444 0.358312
+ 4.2822222 0.318985
+ 4.2825000 0.277413
+ 4.2827778 0.235347
+ 4.2830556 0.194538
+ 4.2833333 0.156736
+ 4.2836111 0.123463
+ 4.2838889 0.095315
+ 4.2841667 0.072658
+ 4.2844444 0.055860
+ 4.2847222 0.050000
+ 4.2850000 0.050000
+ 4.2852778 0.050000
+ 4.2855556 0.054580
+ 4.2858333 0.072570
+ 4.2861111 0.098617
+ 4.2863889 0.132665
+ 4.2866667 0.172966
+ 4.2869444 0.217350
+ 4.2872222 0.263644
+ 4.2875000 0.309679
+ 4.2877778 0.353284
+ 4.2880556 0.392288
+ 4.2883333 0.424520
+ 4.2886111 0.447810
+ 4.2888889 0.459987
+ 4.2891667 0.459547
+ 4.2894444 0.447655
+ 4.2897222 0.426143
+ 4.2900000 0.396843
+ 4.2902778 0.361587
+ 4.2905556 0.322207
+ 4.2908333 0.280534
+ 4.2911111 0.238402
+ 4.2913889 0.197641
+ 4.2916667 0.160083
+ 4.2919444 0.127307
+ 4.2922222 0.099867
+ 4.2925000 0.078067
+ 4.2927778 0.062207
+ 4.2930556 0.052590
+ 4.2933333 0.050000
+ 4.2936111 0.053289
+ 4.2938889 0.064209
+ 4.2941667 0.082578
+ 4.2944444 0.108698
+ 4.2947222 0.142468
+ 4.2950000 0.182177
+ 4.2952778 0.225709
+ 4.2955556 0.270952
+ 4.2958333 0.315791
+ 4.2961111 0.358113
+ 4.2963889 0.395802
+ 4.2966667 0.426744
+ 4.2969444 0.448827
+ 4.2972222 0.459935
+ 4.2975000 0.458612
+ 4.2977778 0.446033
+ 4.2980556 0.424030
+ 4.2983333 0.394437
+ 4.2986111 0.359085
+ 4.2988889 0.319807
+ 4.2991667 0.278435
+ 4.2994444 0.236802
+ 4.2997222 0.196741
+ 4.3000000 0.160083
+ 4.3002778 0.128397
+ 4.3005556 0.102190
+ 4.3008333 0.081703
+ 4.3011111 0.067179
+ 4.3013889 0.058859
+ 4.3016667 0.056987
+ 4.3019444 0.061803
+ 4.3022222 0.073550
+ 4.3025000 0.092470
+ 4.3027778 0.118805
+ 4.3030556 0.152414
+ 4.3033333 0.191623
+ 4.3036111 0.234375
+ 4.3038889 0.278612
+ 4.3041667 0.322277
+ 4.3044444 0.363314
+ 4.3047222 0.399664
+ 4.3050000 0.429271
+ 4.3052778 0.450078
+ 4.3055556 0.460026
+ 4.3058333 0.457707
+ 4.3061111 0.444297
+ 4.3063889 0.421622
+ 4.3066667 0.391506
+ 4.3069444 0.355773
+ 4.3072222 0.316250
+ 4.3075000 0.274760
+ 4.3077778 0.233127
+ 4.3080556 0.193178
+ 4.3083333 0.156736
+ 4.3086111 0.125359
+ 4.3088889 0.099530
+ 4.3091667 0.079468
+ 4.3094444 0.065388
+ 4.3097222 0.057509
+ 4.3100000 0.056046
+ 4.3102778 0.061217
+ 4.3105556 0.073238
+ 4.3108333 0.092327
+ 4.3111111 0.118701
+ 4.3113889 0.152204
+ 4.3116667 0.191202
+ 4.3119444 0.233685
+ 4.3122222 0.277645
+ 4.3125000 0.321075
+ 4.3127778 0.361968
+ 4.3130556 0.398314
+ 4.3133333 0.428107
+ 4.3136111 0.449338
+ 4.3138889 0.460000
+ 4.3141667 0.458704
+ 4.3144444 0.446543
+ 4.3147222 0.425226
+ 4.3150000 0.396466
+ 4.3152778 0.361975
+ 4.3155556 0.323462
+ 4.3158333 0.282640
+ 4.3161111 0.241220
+ 4.3163889 0.200913
+ 4.3166667 0.163431
+ 4.3169444 0.130266
+ 4.3172222 0.102037
+ 4.3175000 0.079146
+ 4.3177778 0.061993
+ 4.3180556 0.050979
+ 4.3183333 0.050000
+ 4.3186111 0.050000
+ 4.3188889 0.058777
+ 4.3191667 0.076325
+ 4.3194444 0.102017
+ 4.3197222 0.135817
+ 4.3200000 0.175950
+ 4.3202778 0.220209
+ 4.3205556 0.266381
+ 4.3208333 0.312260
+ 4.3211111 0.355633
+ 4.3213889 0.394293
+ 4.3216667 0.426030
+ 4.3219444 0.448634
+ 4.3222222 0.459895
+ 4.3225000 0.458289
+ 4.3227778 0.445026
+ 4.3230556 0.422001
+ 4.3233333 0.391109
+ 4.3236111 0.354247
+ 4.3238889 0.313308
+ 4.3241667 0.270188
+ 4.3244444 0.226782
+ 4.3247222 0.184986
+ 4.3250000 0.146694
+ 4.3252778 0.113531
+ 4.3255556 0.086034
+ 4.3258333 0.064469
+ 4.3261111 0.050000
+ 4.3263889 0.050000
+ 4.3266667 0.050000
+ 4.3269444 0.050000
+ 4.3272222 0.054950
+ 4.3275000 0.074572
+ 4.3277778 0.101991
+ 4.3280556 0.137069
+ 4.3283333 0.178054
+ 4.3286111 0.222791
+ 4.3288889 0.269125
+ 4.3291667 0.314899
+ 4.3294444 0.357958
+ 4.3297222 0.396147
+ 4.3300000 0.427310
+ 4.3302778 0.449291
+ 4.3305556 0.459935
+ 4.3308333 0.457761
+ 4.3311111 0.443987
+ 4.3313889 0.420506
+ 4.3316667 0.389211
+ 4.3319444 0.351994
+ 4.3322222 0.310750
+ 4.3325000 0.267370
+ 4.3327778 0.223748
+ 4.3330556 0.181776
+ 4.3333333 0.143347
+ 4.3336111 0.110083
+ 4.3338889 0.082517
+ 4.3341667 0.060911
+ 4.3344444 0.050000
+ 4.3347222 0.050000
+ 4.3350000 0.050000
+ 4.3352778 0.050000
+ 4.3355556 0.051462
+ 4.3358333 0.071123
+ 4.3361111 0.098578
+ 4.3363889 0.133691
+ 4.3366667 0.174726
+ 4.3369444 0.219546
+ 4.3372222 0.266018
+ 4.3375000 0.312005
+ 4.3377778 0.355373
+ 4.3380556 0.393985
+ 4.3383333 0.425706
+ 4.3386111 0.448401
+ 4.3388889 0.459935
+ 4.3391667 0.458830
+ 4.3394444 0.446243
+ 4.3397222 0.423991
+ 4.3400000 0.393887
+ 4.3402778 0.357747
+ 4.3405556 0.317386
+ 4.3408333 0.274620
+ 4.3411111 0.231264
+ 4.3413889 0.189133
+ 4.3416667 0.150042
+ 4.3419444 0.115569
+ 4.3422222 0.086344
+ 4.3425000 0.062760
+ 4.3427778 0.050000
+ 4.3430556 0.050000
+ 4.3433333 0.050000
+ 4.3436111 0.050000
+ 4.3438889 0.050000
+ 4.3441667 0.061667
+ 4.3444444 0.088549
+ 4.3447222 0.123765
+ 4.3450000 0.165482
+ 4.3452778 0.211421
+ 4.3455556 0.259304
+ 4.3458333 0.306853
+ 4.3461111 0.351791
+ 4.3463889 0.391838
+ 4.3466667 0.424716
+ 4.3469444 0.448149
+ 4.3472222 0.459856
+ 4.3475000 0.458270
+ 4.3477778 0.444657
+ 4.3480556 0.420995
+ 4.3483333 0.389260
+ 4.3486111 0.351428
+ 4.3488889 0.309476
+ 4.3491667 0.265380
+ 4.3494444 0.221118
+ 4.3497222 0.178666
+ 4.3500000 0.140000
+ 4.3502778 0.106803
+ 4.3505556 0.079578
+ 4.3508333 0.058536
+ 4.3511111 0.050000
+ 4.3513889 0.050000
+ 4.3516667 0.050000
+ 4.3519444 0.050000
+ 4.3522222 0.053401
+ 4.3525000 0.073858
+ 4.3527778 0.101965
+ 4.3530556 0.137542
+ 4.3533333 0.178848
+ 4.3536111 0.223754
+ 4.3538889 0.270128
+ 4.3541667 0.315839
+ 4.3544444 0.358757
+ 4.3547222 0.396751
+ 4.3550000 0.427690
+ 4.3552778 0.449444
+ 4.3555556 0.459882
+ 4.3558333 0.457541
+ 4.3561111 0.443623
+ 4.3563889 0.419999
+ 4.3566667 0.388540
+ 4.3569444 0.351117
+ 4.3572222 0.309600
+ 4.3575000 0.265859
+ 4.3577778 0.221765
+ 4.3580556 0.179188
+ 4.3583333 0.140000
+ 4.3586111 0.105813
+ 4.3588889 0.077210
+ 4.3591667 0.054517
+ 4.3594444 0.050000
+ 4.3597222 0.050000
+ 4.3600000 0.050000
+ 4.3602778 0.050000
+ 4.3605556 0.050000
+ 4.3608333 0.060712
+ 4.3611111 0.088510
+ 4.3613889 0.124396
+ 4.3616667 0.166551
+ 4.3619444 0.212729
+ 4.3622222 0.260683
+ 4.3625000 0.308166
+ 4.3627778 0.352933
+ 4.3630556 0.392736
+ 4.3633333 0.425328
+ 4.3636111 0.448464
+ 4.3638889 0.459895
+ 4.3641667 0.458077
+ 4.3644444 0.444265
+ 4.3647222 0.420414
+ 4.3650000 0.388479
+ 4.3652778 0.350418
+ 4.3655556 0.308185
+ 4.3658333 0.263736
+ 4.3661111 0.219027
+ 4.3663889 0.176014
+ 4.3666667 0.136653
+ 4.3669444 0.102616
+ 4.3672222 0.074449
+ 4.3675000 0.052413
+ 4.3677778 0.050000
+ 4.3680556 0.050000
+ 4.3683333 0.050000
+ 4.3686111 0.050000
+ 4.3688889 0.050000
+ 4.3691667 0.063644
+ 4.3694444 0.091871
+ 4.3697222 0.127916
+ 4.3700000 0.169991
+ 4.3702778 0.215898
+ 4.3705556 0.263438
+ 4.3708333 0.310410
+ 4.3711111 0.354618
+ 4.3713889 0.393861
+ 4.3716667 0.425941
+ 4.3719444 0.448660
+ 4.3722222 0.459817
+ 4.3725000 0.457900
+ 4.3727778 0.444133
+ 4.3730556 0.420427
+ 4.3733333 0.388692
+ 4.3736111 0.350838
+ 4.3738889 0.308777
+ 4.3741667 0.264417
+ 4.3744444 0.219670
+ 4.3747222 0.176445
+ 4.3750000 0.136653
+ 4.3752778 0.101941
+ 4.3755556 0.072908
+ 4.3758333 0.050000
+ 4.3761111 0.050000
+ 4.3763889 0.050000
+ 4.3766667 0.050000
+ 4.3769444 0.050000
+ 4.3772222 0.050000
+ 4.3775000 0.056765
+ 4.3777778 0.085202
+ 4.3780556 0.121887
+ 4.3783333 0.164939
+ 4.3786111 0.212037
+ 4.3788889 0.260856
+ 4.3791667 0.309076
+ 4.3794444 0.354373
+ 4.3797222 0.394424
+ 4.3800000 0.426908
+ 4.3802778 0.449502
+ 4.3805556 0.459882
+ 4.3808333 0.456460
+ 4.3811111 0.440573
+ 4.3813889 0.414292
+ 4.3816667 0.379687
+ 4.3819444 0.338829
+ 4.3822222 0.293790
+ 4.3825000 0.246639
+ 4.3827778 0.199446
+ 4.3830556 0.154284
+ 4.3833333 0.113222
+ 4.3836111 0.078023
+ 4.3838889 0.050000
+ 4.3841667 0.050000
+ 4.3844444 0.050000
+ 4.3847222 0.050000
+ 4.3850000 0.050000
+ 4.3852778 0.050000
+ 4.3855556 0.050000
+ 4.3858333 0.050000
+ 4.3861111 0.075056
+ 4.3863889 0.113198
+ 4.3866667 0.157441
+ 4.3869444 0.205525
+ 4.3872222 0.255190
+ 4.3875000 0.304176
+ 4.3877778 0.350224
+ 4.3880556 0.391073
+ 4.3883333 0.424464
+ 4.3886111 0.448136
+ 4.3888889 0.459830
+ 4.3891667 0.457992
+ 4.3894444 0.443890
+ 4.3897222 0.419500
+ 4.3900000 0.386797
+ 4.3902778 0.347757
+ 4.3905556 0.304353
+ 4.3908333 0.258562
+ 4.3911111 0.212357
+ 4.3913889 0.167716
+ 4.3916667 0.126611
+ 4.3919444 0.090746
+ 4.3922222 0.060731
+ 4.3925000 0.050000
+ 4.3927778 0.050000
+ 4.3930556 0.050000
+ 4.3933333 0.050000
+ 4.3936111 0.050000
+ 4.3938889 0.050000
+ 4.3941667 0.050000
+ 4.3944444 0.071748
+ 4.3947222 0.109137
+ 4.3950000 0.153077
+ 4.3952778 0.201229
+ 4.3955556 0.251255
+ 4.3958333 0.300816
+ 4.3961111 0.347573
+ 4.3963889 0.389188
+ 4.3966667 0.423322
+ 4.3969444 0.447635
+ 4.3972222 0.459791
+ 4.3975000 0.458177
+ 4.3977778 0.444099
+ 4.3980556 0.419588
+ 4.3983333 0.386677
+ 4.3986111 0.347398
+ 4.3988889 0.303783
+ 4.3991667 0.257865
+ 4.3994444 0.211675
+ 4.3997222 0.167246
+ 4.4000000 0.126611
+ 4.4002778 0.091507
+ 4.4005556 0.062497
+ 4.4008333 0.050000
+ 4.4011111 0.050000
+ 4.4013889 0.050000
+ 4.4016667 0.050000
+ 4.4019444 0.050000
+ 4.4022222 0.050000
+ 4.4025000 0.052465
+ 4.4027778 0.081816
+ 4.4030556 0.119237
+ 4.4033333 0.162862
+ 4.4036111 0.210395
+ 4.4038889 0.259543
+ 4.4041667 0.308011
+ 4.4044444 0.353504
+ 4.4047222 0.393728
+ 4.4050000 0.426389
+ 4.4052778 0.449192
+ 4.4055556 0.459843
+ 4.4058333 0.456771
+ 4.4061111 0.441298
+ 4.4063889 0.415469
+ 4.4066667 0.381332
+ 4.4069444 0.340930
+ 4.4072222 0.296311
+ 4.4075000 0.249520
+ 4.4077778 0.202602
+ 4.4080556 0.157603
+ 4.4083333 0.116569
+ 4.4086111 0.081247
+ 4.4088889 0.052186
+ 4.4091667 0.050000
+ 4.4094444 0.050000
+ 4.4097222 0.050000
+ 4.4100000 0.050000
+ 4.4102778 0.050000
+ 4.4105556 0.050000
+ 4.4108333 0.050000
+ 4.4111111 0.075069
+ 4.4113889 0.113176
+ 4.4116667 0.157494
+ 4.4119444 0.205725
+ 4.4122222 0.255572
+ 4.4125000 0.304735
+ 4.4127778 0.350916
+ 4.4130556 0.391817
+ 4.4133333 0.425140
+ 4.4136111 0.448586
+ 4.4138889 0.459856
+ 4.4141667 0.457376
+ 4.4144444 0.442459
+ 4.4147222 0.417144
+ 4.4150000 0.383468
+ 4.4152778 0.343467
+ 4.4155556 0.299180
+ 4.4158333 0.252645
+ 4.4161111 0.205897
+ 4.4163889 0.160975
+ 4.4166667 0.119917
+ 4.4169444 0.084464
+ 4.4172222 0.055179
+ 4.4175000 0.050000
+ 4.4177778 0.050000
+ 4.4180556 0.050000
+ 4.4183333 0.050000
+ 4.4186111 0.050000
+ 4.4188889 0.050000
+ 4.4191667 0.050000
+ 4.4194444 0.075056
+ 4.4197222 0.112895
+ 4.4200000 0.157009
+ 4.4202778 0.205099
+ 4.4205556 0.254863
+ 4.4208333 0.304001
+ 4.4211111 0.350213
+ 4.4213889 0.391199
+ 4.4216667 0.424657
+ 4.4219444 0.448288
+ 4.4222222 0.459791
+ 4.4225000 0.457587
+ 4.4227778 0.442984
+ 4.4230556 0.418010
+ 4.4233333 0.384695
+ 4.4236111 0.345068
+ 4.4238889 0.301158
+ 4.4241667 0.254993
+ 4.4244444 0.208603
+ 4.4247222 0.164017
+ 4.4250000 0.123264
+ 4.4252778 0.088078
+ 4.4255556 0.059016
+ 4.4258333 0.050000
+ 4.4261111 0.050000
+ 4.4263889 0.050000
+ 4.4266667 0.050000
+ 4.4269444 0.050000
+ 4.4272222 0.050000
+ 4.4275000 0.050000
+ 4.4277778 0.078482
+ 4.4280556 0.115923
+ 4.4283333 0.159579
+ 4.4286111 0.207176
+ 4.4288889 0.256442
+ 4.4291667 0.305106
+ 4.4294444 0.350894
+ 4.4297222 0.391536
+ 4.4300000 0.424758
+ 4.4302778 0.448289
+ 4.4305556 0.459856
+ 4.4308333 0.457897
+ 4.4311111 0.443683
+ 4.4313889 0.419197
+ 4.4316667 0.386419
+ 4.4319444 0.347332
+ 4.4322222 0.303918
+ 4.4325000 0.258157
+ 4.4327778 0.212031
+ 4.4330556 0.167522
+ 4.4333333 0.126611
+ 4.4336111 0.091004
+ 4.4338889 0.061301
+ 4.4341667 0.050000
+ 4.4344444 0.050000
+ 4.4347222 0.050000
+ 4.4350000 0.050000
+ 4.4352778 0.050000
+ 4.4355556 0.050000
+ 4.4358333 0.050000
+ 4.4361111 0.075082
+ 4.4363889 0.112643
+ 4.4366667 0.156674
+ 4.4369444 0.204824
+ 4.4372222 0.254743
+ 4.4375000 0.304082
+ 4.4377778 0.350491
+ 4.4380556 0.391620
+ 4.4383333 0.425119
+ 4.4386111 0.448639
+ 4.4388889 0.459830
+ 4.4391667 0.457078
+ 4.4394444 0.441717
+ 4.4397222 0.415815
+ 4.4400000 0.381443
+ 4.4402778 0.340670
+ 4.4405556 0.295565
+ 4.4408333 0.248199
+ 4.4411111 0.200640
+ 4.4413889 0.154958
+ 4.4416667 0.113222
+ 4.4419444 0.077203
+ 4.4422222 0.050000
+ 4.4425000 0.050000
+ 4.4427778 0.050000
+ 4.4430556 0.050000
+ 4.4433333 0.050000
+ 4.4436111 0.050000
+ 4.4438889 0.050000
+ 4.4441667 0.050000
+ 4.4444444 0.068375
+ 4.4447222 0.106954
+ 4.4450000 0.151910
+ 4.4452778 0.200898
+ 4.4455556 0.251572
+ 4.4458333 0.301590
+ 4.4461111 0.348606
+ 4.4463889 0.390275
+ 4.4466667 0.424255
+ 4.4469444 0.448199
+ 4.4472222 0.459765
+ 4.4475000 0.457344
+ 4.4477778 0.442282
+ 4.4480556 0.416661
+ 4.4483333 0.382563
+ 4.4486111 0.342070
+ 4.4488889 0.297265
+ 4.4491667 0.250231
+ 4.4494444 0.203048
+ 4.4497222 0.157800
+ 4.4500000 0.116569
+ 4.4502778 0.081130
+ 4.4505556 0.052022
+ 4.4508333 0.050000
+ 4.4511111 0.050000
+ 4.4513889 0.050000
+ 4.4516667 0.050000
+ 4.4519444 0.050000
+ 4.4522222 0.050000
+ 4.4525000 0.050000
+ 4.4527778 0.075069
+ 4.4530556 0.113016
+ 4.4533333 0.157125
+ 4.4536111 0.205129
+ 4.4538889 0.254763
+ 4.4541667 0.303758
+ 4.4544444 0.349850
+ 4.4547222 0.390771
+ 4.4550000 0.424254
+ 4.4552778 0.448034
+ 4.4555556 0.459843
+ 4.4558333 0.458121
+ 4.4561111 0.444130
+ 4.4563889 0.419837
+ 4.4566667 0.387210
+ 4.4569444 0.348216
+ 4.4572222 0.304823
+ 4.4575000 0.258999
+ 4.4577778 0.212710
+ 4.4580556 0.167925
+ 4.4583333 0.126611
+ 4.4586111 0.090467
+ 4.4588889 0.060116
+ 4.4591667 0.050000
+ 4.4594444 0.050000
+ 4.4597222 0.050000
+ 4.4600000 0.050000
+ 4.4602778 0.050000
+ 4.4605556 0.050000
+ 4.4608333 0.050000
+ 4.4611111 0.068414
+ 4.4613889 0.105709
+ 4.4616667 0.149650
+ 4.4619444 0.197900
+ 4.4622222 0.248119
+ 4.4625000 0.297969
+ 4.4627778 0.345113
+ 4.4630556 0.387212
+ 4.4633333 0.421928
+ 4.4636111 0.446922
+ 4.4638889 0.459856
+ 4.4641667 0.459111
+ 4.4644444 0.445941
+ 4.4647222 0.422317
+ 4.4650000 0.390213
+ 4.4652778 0.351602
+ 4.4655556 0.308454
+ 4.4658333 0.262744
+ 4.4661111 0.216442
+ 4.4663889 0.171523
+ 4.4666667 0.129958
+ 4.4669444 0.093456
+ 4.4672222 0.062667
+ 4.4675000 0.050000
+ 4.4677778 0.050000
+ 4.4680556 0.050000
+ 4.4683333 0.050000
+ 4.4686111 0.050000
+ 4.4688889 0.050000
+ 4.4691667 0.050000
+ 4.4694444 0.068401
+ 4.4697222 0.105954
+ 4.4700000 0.150287
+ 4.4702778 0.198991
+ 4.4705556 0.249656
+ 4.4708333 0.299870
+ 4.4711111 0.347224
+ 4.4713889 0.389307
+ 4.4716667 0.423709
+ 4.4719444 0.448020
+ 4.4722222 0.459830
+ 4.4725000 0.457488
+ 4.4727778 0.442382
+ 4.4730556 0.416662
+ 4.4733333 0.382477
+ 4.4736111 0.341975
+ 4.4738889 0.297304
+ 4.4741667 0.250615
+ 4.4744444 0.204054
+ 4.4747222 0.159772
+ 4.4750000 0.119917
+ 4.4752778 0.086298
+ 4.4755556 0.059369
+ 4.4758333 0.050000
+ 4.4761111 0.050000
+ 4.4763889 0.050000
+ 4.4766667 0.050000
+ 4.4769444 0.050000
+ 4.4772222 0.050000
+ 4.4775000 0.067801
+ 4.4777778 0.098513
+ 4.4780556 0.136555
+ 4.4783333 0.180096
+ 4.4786111 0.226917
+ 4.4788889 0.274795
+ 4.4791667 0.321511
+ 4.4794444 0.364844
+ 4.4797222 0.402574
+ 4.4800000 0.432479
+ 4.4802778 0.452340
+ 4.4805556 0.459935
+ 4.4808333 0.453777
+ 4.4811111 0.435316
+ 4.4813889 0.406733
+ 4.4816667 0.370210
+ 4.4819444 0.327929
+ 4.4822222 0.282072
+ 4.4825000 0.234822
+ 4.4827778 0.188360
+ 4.4830556 0.144867
+ 4.4833333 0.106528
+ 4.4836111 0.075148
+ 4.4838889 0.051036
+ 4.4841667 0.050000
+ 4.4844444 0.050000
+ 4.4847222 0.050000
+ 4.4850000 0.050000
+ 4.4852778 0.050000
+ 4.4855556 0.055288
+ 4.4858333 0.080199
+ 4.4861111 0.111849
+ 4.4863889 0.149847
+ 4.4866667 0.192505
+ 4.4869444 0.237810
+ 4.4872222 0.283748
+ 4.4875000 0.328309
+ 4.4877778 0.369478
+ 4.4880556 0.405243
+ 4.4883333 0.433591
+ 4.4886111 0.452510
+ 4.4888889 0.459987
+ 4.4891667 0.454676
+ 4.4894444 0.437902
+ 4.4897222 0.411655
+ 4.4900000 0.377927
+ 4.4902778 0.338709
+ 4.4905556 0.295992
+ 4.4908333 0.251767
+ 4.4911111 0.208026
+ 4.4913889 0.166759
+ 4.4916667 0.129958
+ 4.4919444 0.099291
+ 4.4922222 0.075130
+ 4.4925000 0.057524
+ 4.4927778 0.050000
+ 4.4930556 0.050000
+ 4.4933333 0.050000
+ 4.4936111 0.053640
+ 4.4938889 0.069549
+ 4.4941667 0.092309
+ 4.4944444 0.121969
+ 4.4947222 0.158230
+ 4.4950000 0.199395
+ 4.4952778 0.243421
+ 4.4955556 0.288264
+ 4.4958333 0.331879
+ 4.4961111 0.372223
+ 4.4963889 0.407251
+ 4.4966667 0.434920
+ 4.4969444 0.453184
+ 4.4972222 0.460000
+ 4.4975000 0.454008
+ 4.4977778 0.436588
+ 4.4980556 0.409800
+ 4.4983333 0.375709
+ 4.4986111 0.336377
+ 4.4988889 0.293867
+ 4.4991667 0.250242
+ 4.4994444 0.207565
+ 4.4997222 0.167899
+ 4.5000000 0.133306
+ 4.5002778 0.105481
+ 4.5005556 0.084646
+ 4.5008333 0.070657
+ 4.5011111 0.063366
+ 4.5013889 0.062628
+ 4.5016667 0.068298
+ 4.5019444 0.080229
+ 4.5022222 0.098276
+ 4.5025000 0.122293
+ 4.5027778 0.152134
+ 4.5030556 0.187374
+ 4.5033333 0.226475
+ 4.5036111 0.267618
+ 4.5038889 0.308986
+ 4.5041667 0.348761
+ 4.5044444 0.385126
+ 4.5047222 0.416261
+ 4.5050000 0.440350
+ 4.5052778 0.455575
+ 4.5055556 0.460118
+ 4.5058333 0.452779
+ 4.5061111 0.434833
+ 4.5063889 0.408175
+ 4.5066667 0.374697
+ 4.5069444 0.336293
+ 4.5072222 0.294856
+ 4.5075000 0.252281
+ 4.5077778 0.210459
+ 4.5080556 0.171285
+ 4.5083333 0.136653
+ 4.5086111 0.108137
+ 4.5088889 0.086042
+ 4.5091667 0.070354
+ 4.5094444 0.061059
+ 4.5097222 0.058143
+ 4.5100000 0.061591
+ 4.5102778 0.071391
+ 4.5105556 0.087528
+ 4.5108333 0.109988
+ 4.5111111 0.138758
+ 4.5113889 0.173512
+ 4.5116667 0.212686
+ 4.5119444 0.254404
+ 4.5122222 0.296789
+ 4.5125000 0.337967
+ 4.5127778 0.376060
+ 4.5130556 0.409194
+ 4.5133333 0.435492
+ 4.5136111 0.453079
+ 4.5138889 0.460078
+ 4.5141667 0.455230
+ 4.5144444 0.439732
+ 4.5147222 0.415399
+ 4.5150000 0.384044
+ 4.5152778 0.347482
+ 4.5155556 0.307526
+ 4.5158333 0.265990
+ 4.5161111 0.224688
+ 4.5163889 0.185434
+ 4.5166667 0.150042
+ 4.5169444 0.120046
+ 4.5172222 0.095868
+ 4.5175000 0.077646
+ 4.5177778 0.065524
+ 4.5180556 0.059641
+ 4.5183333 0.060139
+ 4.5186111 0.067158
+ 4.5188889 0.080840
+ 4.5191667 0.101325
+ 4.5194444 0.128755
+ 4.5197222 0.162915
+ 4.5200000 0.202165
+ 4.5202778 0.244511
+ 4.5205556 0.287958
+ 4.5208333 0.330510
+ 4.5211111 0.370174
+ 4.5213889 0.404953
+ 4.5216667 0.432854
+ 4.5219444 0.451881
+ 4.5222222 0.460039
+ 4.5225000 0.455976
+ 4.5227778 0.440904
+ 4.5230556 0.416679
+ 4.5233333 0.385158
+ 4.5236111 0.348195
+ 4.5238889 0.307645
+ 4.5241667 0.265365
+ 4.5244444 0.223209
+ 4.5247222 0.183034
+ 4.5250000 0.146694
+ 4.5252778 0.115766
+ 4.5255556 0.090701
+ 4.5258333 0.071674
+ 4.5261111 0.058858
+ 4.5263889 0.052426
+ 4.5266667 0.052551
+ 4.5269444 0.059407
+ 4.5272222 0.073166
+ 4.5275000 0.094001
+ 4.5277778 0.122087
+ 4.5280556 0.157216
+ 4.5283333 0.197663
+ 4.5286111 0.241322
+ 4.5288889 0.286087
+ 4.5291667 0.329854
+ 4.5294444 0.370516
+ 4.5297222 0.405969
+ 4.5300000 0.434106
+ 4.5302778 0.452823
+ 4.5305556 0.460013
+ 4.5308333 0.454267
+ 4.5311111 0.436955
+ 4.5313889 0.410142
+ 4.5316667 0.375895
+ 4.5319444 0.336278
+ 4.5322222 0.293359
+ 4.5325000 0.249201
+ 4.5327778 0.205871
+ 4.5330556 0.165435
+ 4.5333333 0.129958
+ 4.5336111 0.101146
+ 4.5338889 0.079262
+ 4.5341667 0.064211
+ 4.5344444 0.055896
+ 4.5347222 0.054221
+ 4.5350000 0.059090
+ 4.5352778 0.070406
+ 4.5355556 0.088074
+ 4.5358333 0.111997
+ 4.5361111 0.142079
+ 4.5363889 0.177923
+ 4.5366667 0.217932
+ 4.5369444 0.260207
+ 4.5372222 0.302851
+ 4.5375000 0.343963
+ 4.5377778 0.381647
+ 4.5380556 0.414004
+ 4.5383333 0.439136
+ 4.5386111 0.455144
+ 4.5388889 0.460131
+ 4.5391667 0.452834
+ 4.5394444 0.434542
+ 4.5397222 0.407178
+ 4.5400000 0.372666
+ 4.5402778 0.332932
+ 4.5405556 0.289899
+ 4.5408333 0.245491
+ 4.5411111 0.201633
+ 4.5413889 0.160249
+ 4.5416667 0.123264
+ 4.5419444 0.092294
+ 4.5422222 0.067731
+ 4.5425000 0.050000
+ 4.5427778 0.050000
+ 4.5430556 0.050000
+ 4.5433333 0.050000
+ 4.5436111 0.050000
+ 4.5438889 0.059573
+ 4.5441667 0.082199
+ 4.5444444 0.111902
+ 4.5447222 0.148407
+ 4.5450000 0.190017
+ 4.5452778 0.234675
+ 4.5455556 0.280326
+ 4.5458333 0.324913
+ 4.5461111 0.366380
+ 4.5463889 0.402672
+ 4.5466667 0.431732
+ 4.5469444 0.451505
+ 4.5472222 0.459935
+ 4.5475000 0.455630
+ 4.5477778 0.439862
+ 4.5480556 0.414566
+ 4.5483333 0.381678
+ 4.5486111 0.343133
+ 4.5488889 0.300867
+ 4.5491667 0.256816
+ 4.5494444 0.212915
+ 4.5497222 0.171099
+ 4.5500000 0.133306
+ 4.5502778 0.101175
+ 4.5505556 0.075175
+ 4.5508333 0.055477
+ 4.5511111 0.050000
+ 4.5513889 0.050000
+ 4.5516667 0.050000
+ 4.5519444 0.050000
+ 4.5522222 0.057582
+ 4.5525000 0.079331
+ 4.5527778 0.108594
+ 4.5530556 0.145149
+ 4.5533333 0.187208
+ 4.5536111 0.232588
+ 4.5538889 0.279106
+ 4.5541667 0.324580
+ 4.5544444 0.366828
+ 4.5547222 0.403668
+ 4.5550000 0.432916
+ 4.5552778 0.452390
+ 4.5555556 0.459908
+ 4.5558333 0.453991
+ 4.5561111 0.435967
+ 4.5563889 0.407870
+ 4.5566667 0.371731
+ 4.5569444 0.329582
+ 4.5572222 0.283457
+ 4.5575000 0.235387
+ 4.5577778 0.187405
+ 4.5580556 0.141543
+ 4.5583333 0.099833
+ 4.5586111 0.064012
+ 4.5588889 0.050000
+ 4.5591667 0.050000
+ 4.5594444 0.050000
+ 4.5597222 0.050000
+ 4.5600000 0.050000
+ 4.5602778 0.050000
+ 4.5605556 0.050000
+ 4.5608333 0.050000
+ 4.5611111 0.061641
+ 4.5613889 0.101136
+ 4.5616667 0.146988
+ 4.5619444 0.196838
+ 4.5622222 0.248332
+ 4.5625000 0.299111
+ 4.5627778 0.346819
+ 4.5630556 0.389099
+ 4.5633333 0.423594
+ 4.5636111 0.447948
+ 4.5638889 0.459804
+ 4.5641667 0.457542
+ 4.5644444 0.442492
+ 4.5647222 0.416723
+ 4.5650000 0.382302
+ 4.5652778 0.341297
+ 4.5655556 0.295775
+ 4.5658333 0.247804
+ 4.5661111 0.199452
+ 4.5663889 0.152786
+ 4.5666667 0.109875
+ 4.5669444 0.072498
+ 4.5672222 0.050000
+ 4.5675000 0.050000
+ 4.5677778 0.050000
+ 4.5680556 0.050000
+ 4.5683333 0.050000
+ 4.5686111 0.050000
+ 4.5688889 0.050000
+ 4.5691667 0.050000
+ 4.5694444 0.054933
+ 4.5697222 0.094255
+ 4.5700000 0.140386
+ 4.5702778 0.190869
+ 4.5705556 0.243248
+ 4.5708333 0.295065
+ 4.5711111 0.343863
+ 4.5713889 0.387185
+ 4.5716667 0.422574
+ 4.5719444 0.447573
+ 4.5722222 0.459725
+ 4.5725000 0.457342
+ 4.5727778 0.441813
+ 4.5730556 0.415293
+ 4.5733333 0.379942
+ 4.5736111 0.337917
+ 4.5738889 0.291374
+ 4.5741667 0.242471
+ 4.5744444 0.193367
+ 4.5747222 0.146217
+ 4.5750000 0.103181
+ 4.5752778 0.066098
+ 4.5755556 0.050000
+ 4.5758333 0.050000
+ 4.5761111 0.050000
+ 4.5763889 0.050000
+ 4.5766667 0.050000
+ 4.5769444 0.050000
+ 4.5772222 0.050000
+ 4.5775000 0.050000
+ 4.5777778 0.058307
+ 4.5780556 0.098078
+ 4.5783333 0.144361
+ 4.5786111 0.194747
+ 4.5788889 0.246823
+ 4.5791667 0.298179
+ 4.5794444 0.346402
+ 4.5797222 0.389082
+ 4.5800000 0.423808
+ 4.5802778 0.448168
+ 4.5805556 0.459752
+ 4.5808333 0.456904
+ 4.5811111 0.441002
+ 4.5813889 0.414178
+ 4.5816667 0.378567
+ 4.5819444 0.336301
+ 4.5822222 0.289515
+ 4.5825000 0.240341
+ 4.5827778 0.190914
+ 4.5830556 0.143367
+ 4.5833333 0.099833
+ 4.5836111 0.062142
+ 4.5838889 0.050000
+ 4.5841667 0.050000
+ 4.5844444 0.050000
+ 4.5847222 0.050000
+ 4.5850000 0.050000
+ 4.5852778 0.050000
+ 4.5855556 0.050000
+ 4.5858333 0.050000
+ 4.5861111 0.050000
+ 4.5863889 0.090141
+ 4.5866667 0.137027
+ 4.5869444 0.188198
+ 4.5872222 0.241195
+ 4.5875000 0.293558
+ 4.5877778 0.342825
+ 4.5880556 0.386536
+ 4.5883333 0.422233
+ 4.5886111 0.447454
+ 4.5888889 0.459738
+ 4.5891667 0.457397
+ 4.5894444 0.441820
+ 4.5897222 0.415166
+ 4.5900000 0.379594
+ 4.5902778 0.337264
+ 4.5905556 0.290336
+ 4.5908333 0.240970
+ 4.5911111 0.191324
+ 4.5913889 0.143559
+ 4.5916667 0.099833
+ 4.5919444 0.061997
+ 4.5922222 0.050000
+ 4.5925000 0.050000
+ 4.5927778 0.050000
+ 4.5930556 0.050000
+ 4.5933333 0.050000
+ 4.5936111 0.050000
+ 4.5938889 0.050000
+ 4.5941667 0.050000
+ 4.5944444 0.050000
+ 4.5947222 0.090215
+ 4.5950000 0.137168
+ 4.5952778 0.188395
+ 4.5955556 0.241433
+ 4.5958333 0.293818
+ 4.5961111 0.343085
+ 4.5963889 0.386771
+ 4.5966667 0.422411
+ 4.5969444 0.447542
+ 4.5972222 0.459699
+ 4.5975000 0.457193
+ 4.5977778 0.441431
+ 4.5980556 0.414594
+ 4.5983333 0.378862
+ 4.5986111 0.336417
+ 4.5988889 0.289440
+ 4.5991667 0.240112
+ 4.5994444 0.190615
+ 4.5997222 0.143128
+ 4.6000000 0.099833
+ 4.6002778 0.062593
+ 4.6005556 0.050000
+ 4.6008333 0.050000
+ 4.6011111 0.050000
+ 4.6013889 0.050000
+ 4.6016667 0.050000
+ 4.6019444 0.050000
+ 4.6022222 0.050000
+ 4.6025000 0.050000
+ 4.6027778 0.058307
+ 4.6030556 0.099031
+ 4.6033333 0.146298
+ 4.6036111 0.197606
+ 4.6038889 0.250453
+ 4.6041667 0.302337
+ 4.6044444 0.350757
+ 4.6047222 0.393210
+ 4.6050000 0.427195
+ 4.6052778 0.450209
+ 4.6055556 0.459752
+ 4.6058333 0.454126
+ 4.6061111 0.434860
+ 4.6063889 0.404287
+ 4.6066667 0.364740
+ 4.6069444 0.318555
+ 4.6072222 0.268063
+ 4.6075000 0.215599
+ 4.6077778 0.163496
+ 4.6080556 0.114088
+ 4.6083333 0.069708
+ 4.6086111 0.050000
+ 4.6088889 0.050000
+ 4.6091667 0.050000
+ 4.6094444 0.050000
+ 4.6097222 0.050000
+ 4.6100000 0.050000
+ 4.6102778 0.050000
+ 4.6105556 0.050000
+ 4.6108333 0.050000
+ 4.6111111 0.050000
+ 4.6113889 0.093402
+ 4.6116667 0.143017
+ 4.6119444 0.196309
+ 4.6122222 0.250746
+ 4.6125000 0.303794
+ 4.6127778 0.352919
+ 4.6130556 0.395588
+ 4.6133333 0.429266
+ 4.6136111 0.451420
+ 4.6138889 0.459516
+ 4.6141667 0.451861
+ 4.6144444 0.430121
+ 4.6147222 0.396804
+ 4.6150000 0.354416
+ 4.6152778 0.305465
+ 4.6155556 0.252457
+ 4.6158333 0.197900
+ 4.6161111 0.144300
+ 4.6163889 0.094164
+ 4.6166667 0.050000
+ 4.6169444 0.050000
+ 4.6172222 0.050000
+ 4.6175000 0.050000
+ 4.6177778 0.050000
+ 4.6180556 0.050000
+ 4.6183333 0.050000
+ 4.6186111 0.050000
+ 4.6188889 0.050000
+ 4.6191667 0.050000
+ 4.6194444 0.050000
+ 4.6197222 0.091581
+ 4.6200000 0.138394
+ 4.6202778 0.188422
+ 4.6205556 0.239647
+ 4.6208333 0.290053
+ 4.6211111 0.337622
+ 4.6213889 0.380337
+ 4.6216667 0.416181
+ 4.6219444 0.443138
+ 4.6222222 0.459189
+ 4.6225000 0.462916
+ 4.6227778 0.455287
+ 4.6230556 0.437870
+ 4.6233333 0.412231
+ 4.6236111 0.379937
+ 4.6238889 0.342554
+ 4.6241667 0.301649
+ 4.6244444 0.258790
+ 4.6247222 0.215542
+ 4.6250000 0.173472
+ 4.6252778 0.134036
+ 4.6255556 0.098237
+ 4.6258333 0.066970
+ 4.6261111 0.050000
+ 4.6263889 0.050000
+ 4.6266667 0.050000
+ 4.6269444 0.050000
+ 4.6272222 0.050000
+ 4.6275000 0.050000
+ 4.6277778 0.050000
+ 4.6280556 0.086555
+ 4.6283333 0.132196
+ 4.6286111 0.184333
+ 4.6288889 0.240374
+ 4.6291667 0.297729
+ 4.6294444 0.353809
+ 4.6297222 0.406022
+ 4.6300000 0.451777
+ 4.6302778 0.488486
+ 4.6305556 0.513556
+ 4.6308333 0.525221
+ 4.6311111 0.525008
+ 4.6313889 0.515270
+ 4.6316667 0.498356
+ 4.6319444 0.476619
+ 4.6322222 0.452409
+ 4.6325000 0.428077
+ 4.6327778 0.405974
+ 4.6330556 0.388452
+ 4.6333333 0.377862
+ 4.6336111 0.375913
+ 4.6338889 0.381745
+ 4.6341667 0.393855
+ 4.6344444 0.410743
+ 4.6347222 0.430906
+ 4.6350000 0.452842
+ 4.6352778 0.475049
+ 4.6355556 0.496026
+ 4.6358333 0.514269
+ 4.6361111 0.528278
+ 4.6363889 0.536961
+ 4.6366667 0.540870
+ 4.6369444 0.540967
+ 4.6372222 0.538216
+ 4.6375000 0.533578
+ 4.6377778 0.528017
+ 4.6380556 0.522496
+ 4.6383333 0.517975
+ 4.6386111 0.515420
+ 4.6388889 0.515791
+ 4.6391667 0.519632
+ 4.6394444 0.525801
+ 4.6397222 0.532737
+ 4.6400000 0.538878
+ 4.6402778 0.542663
+ 4.6405556 0.542531
+ 4.6408333 0.536919
+ 4.6411111 0.524268
+ 4.6413889 0.503014
+ 4.6416667 0.471598
+ 4.6419444 0.429251
+ 4.6422222 0.378389
+ 4.6425000 0.322220
+ 4.6427778 0.263954
+ 4.6430556 0.206798
+ 4.6433333 0.153962
+ 4.6436111 0.108656
+ 4.6438889 0.074087
+ 4.6441667 0.053466
+ 4.6444444 0.050000
+ 4.6447222 0.065696
+ 4.6450000 0.097747
+ 4.6452778 0.142145
+ 4.6455556 0.194879
+ 4.6458333 0.251939
+ 4.6461111 0.309318
+ 4.6463889 0.363004
+ 4.6466667 0.408989
+ 4.6469444 0.443263
+ 4.6472222 0.461817
+ 4.6475000 0.461791
+ 4.6477778 0.444921
+ 4.6480556 0.414095
+ 4.6483333 0.372199
+ 4.6486111 0.322119
+ 4.6488889 0.266743
+ 4.6491667 0.208956
+ 4.6494444 0.151646
+ 4.6497222 0.097698
+ 4.6500000 0.050000
+ 4.6502778 0.050000
+ 4.6505556 0.050000
+ 4.6508333 0.050000
+ 4.6511111 0.050000
+ 4.6513889 0.050000
+ 4.6516667 0.050000
+ 4.6519444 0.050000
+ 4.6522222 0.050000
+ 4.6525000 0.050000
+ 4.6527778 0.050000
+ 4.6530556 0.095089
+ 4.6533333 0.145668
+ 4.6536111 0.199332
+ 4.6538889 0.253679
+ 4.6541667 0.306303
+ 4.6544444 0.354801
+ 4.6547222 0.396767
+ 4.6550000 0.429799
+ 4.6552778 0.451490
+ 4.6555556 0.459438
+ 4.6558333 0.452040
+ 4.6561111 0.430903
+ 4.6563889 0.398436
+ 4.6566667 0.357049
+ 4.6569444 0.309151
+ 4.6572222 0.257151
+ 4.6575000 0.203459
+ 4.6577778 0.150483
+ 4.6580556 0.100634
+ 4.6583333 0.056319
+ 4.6586111 0.050000
+ 4.6588889 0.050000
+ 4.6591667 0.050000
+ 4.6594444 0.050000
+ 4.6597222 0.050000
+ 4.6600000 0.050000
+ 4.6602778 0.050000
+ 4.6605556 0.050000
+ 4.6608333 0.050000
+ 4.6611111 0.050000
+ 4.6613889 0.093560
+ 4.6616667 0.142910
+ 4.6619444 0.195661
+ 4.6622222 0.249426
+ 4.6625000 0.301816
+ 4.6627778 0.350443
+ 4.6630556 0.392919
+ 4.6633333 0.426855
+ 4.6636111 0.449863
+ 4.6638889 0.459555
+ 4.6641667 0.454321
+ 4.6644444 0.435661
+ 4.6647222 0.405853
+ 4.6650000 0.367174
+ 4.6652778 0.321904
+ 4.6655556 0.272320
+ 4.6658333 0.220699
+ 4.6661111 0.169321
+ 4.6663889 0.120463
+ 4.6666667 0.076403
+ 4.6669444 0.050000
+ 4.6672222 0.050000
+ 4.6675000 0.050000
+ 4.6677778 0.050000
+ 4.6680556 0.050000
+ 4.6683333 0.050000
+ 4.6686111 0.050000
+ 4.6688889 0.050000
+ 4.6691667 0.050000
+ 4.6694444 0.050000
+ 4.6697222 0.092488
+ 4.6700000 0.141286
+ 4.6702778 0.193900
+ 4.6705556 0.247837
+ 4.6708333 0.300603
+ 4.6711111 0.349703
+ 4.6713889 0.392643
+ 4.6716667 0.426931
+ 4.6719444 0.450070
+ 4.6722222 0.459569
+ 4.6725000 0.453742
+ 4.6727778 0.434151
+ 4.6730556 0.403166
+ 4.6733333 0.363157
+ 4.6736111 0.316495
+ 4.6738889 0.265551
+ 4.6741667 0.212695
+ 4.6744444 0.160297
+ 4.6747222 0.110729
+ 4.6750000 0.066361
+ 4.6752778 0.050000
+ 4.6755556 0.050000
+ 4.6758333 0.050000
+ 4.6761111 0.050000
+ 4.6763889 0.050000
+ 4.6766667 0.050000
+ 4.6769444 0.050000
+ 4.6772222 0.050000
+ 4.6775000 0.050000
+ 4.6777778 0.050000
+ 4.6780556 0.093022
+ 4.6783333 0.142075
+ 4.6786111 0.194726
+ 4.6788889 0.248540
+ 4.6791667 0.301085
+ 4.6794444 0.349927
+ 4.6797222 0.392632
+ 4.6800000 0.426768
+ 4.6802778 0.449900
+ 4.6805556 0.459595
+ 4.6808333 0.454210
+ 4.6811111 0.435267
+ 4.6813889 0.405078
+ 4.6816667 0.365954
+ 4.6819444 0.320208
+ 4.6822222 0.270151
+ 4.6825000 0.218095
+ 4.6827778 0.166353
+ 4.6830556 0.117235
+ 4.6833333 0.073055
+ 4.6836111 0.050000
+ 4.6838889 0.050000
+ 4.6841667 0.050000
+ 4.6844444 0.050000
+ 4.6847222 0.050000
+ 4.6850000 0.050000
+ 4.6852778 0.050000
+ 4.6855556 0.050000
+ 4.6858333 0.050000
+ 4.6861111 0.050000
+ 4.6863889 0.092648
+ 4.6866667 0.141509
+ 4.6869444 0.194113
+ 4.6872222 0.247989
+ 4.6875000 0.300666
+ 4.6877778 0.349676
+ 4.6880556 0.392548
+ 4.6883333 0.426812
+ 4.6886111 0.449997
+ 4.6888889 0.459634
+ 4.6891667 0.454054
+ 4.6894444 0.434800
+ 4.6897222 0.404214
+ 4.6900000 0.364641
+ 4.6902778 0.318424
+ 4.6905556 0.267906
+ 4.6908333 0.215432
+ 4.6911111 0.163346
+ 4.6913889 0.113990
+ 4.6916667 0.069708
+ 4.6919444 0.050000
+ 4.6922222 0.050000
+ 4.6925000 0.050000
+ 4.6927778 0.050000
+ 4.6930556 0.050000
+ 4.6933333 0.050000
+ 4.6936111 0.050000
+ 4.6938889 0.050000
+ 4.6941667 0.050000
+ 4.6944444 0.050000
+ 4.6947222 0.092794
+ 4.6950000 0.141702
+ 4.6952778 0.194278
+ 4.6955556 0.248077
+ 4.6958333 0.300652
+ 4.6961111 0.349559
+ 4.6963889 0.392353
+ 4.6966667 0.426587
+ 4.6969444 0.449816
+ 4.6972222 0.459595
+ 4.6975000 0.454271
+ 4.6977778 0.435368
+ 4.6980556 0.405198
+ 4.6983333 0.366079
+ 4.6986111 0.320324
+ 4.6988889 0.270250
+ 4.6991667 0.218171
+ 4.6994444 0.166402
+ 4.6997222 0.117258
+ 4.7000000 0.073055
+ 4.7002778 0.050000
+ 4.7005556 0.050000
+ 4.7008333 0.050000
+ 4.7011111 0.050000
+ 4.7013889 0.050000
+ 4.7016667 0.050000
+ 4.7019444 0.050000
+ 4.7022222 0.050000
+ 4.7025000 0.050000
+ 4.7027778 0.050000
+ 4.7030556 0.092655
+ 4.7033333 0.141520
+ 4.7036111 0.194127
+ 4.7038889 0.248005
+ 4.7041667 0.300683
+ 4.7044444 0.349691
+ 4.7047222 0.392559
+ 4.7050000 0.426817
+ 4.7052778 0.449994
+ 4.7055556 0.459621
+ 4.7058333 0.454029
+ 4.7061111 0.434761
+ 4.7063889 0.404163
+ 4.7066667 0.364579
+ 4.7069444 0.318355
+ 4.7072222 0.267835
+ 4.7075000 0.215365
+ 4.7077778 0.163291
+ 4.7080556 0.113957
+ 4.7083333 0.069708
+ 4.7086111 0.050000
+ 4.7088889 0.050000
+ 4.7091667 0.050000
+ 4.7094444 0.050000
+ 4.7097222 0.050000
+ 4.7100000 0.050000
+ 4.7102778 0.050000
+ 4.7105556 0.050000
+ 4.7108333 0.050000
+ 4.7111111 0.050000
+ 4.7113889 0.092635
+ 4.7116667 0.141357
+ 4.7119444 0.193746
+ 4.7122222 0.247378
+ 4.7125000 0.299831
+ 4.7127778 0.348682
+ 4.7130556 0.391509
+ 4.7133333 0.425890
+ 4.7136111 0.449401
+ 4.7138889 0.459621
+ 4.7141667 0.454908
+ 4.7144444 0.436751
+ 4.7147222 0.407417
+ 4.7150000 0.369176
+ 4.7152778 0.324298
+ 4.7155556 0.275050
+ 4.7158333 0.223702
+ 4.7161111 0.172524
+ 4.7163889 0.123783
+ 4.7166667 0.079750
+ 4.7169444 0.050000
+ 4.7172222 0.050000
+ 4.7175000 0.050000
+ 4.7177778 0.050000
+ 4.7180556 0.050000
+ 4.7183333 0.050000
+ 4.7186111 0.050000
+ 4.7188889 0.050000
+ 4.7191667 0.050000
+ 4.7194444 0.050000
+ 4.7197222 0.092038
+ 4.7200000 0.140423
+ 4.7202778 0.192685
+ 4.7205556 0.246354
+ 4.7208333 0.298961
+ 4.7211111 0.348036
+ 4.7213889 0.391110
+ 4.7216667 0.425711
+ 4.7219444 0.449372
+ 4.7222222 0.459621
+ 4.7225000 0.454784
+ 4.7227778 0.436369
+ 4.7230556 0.406676
+ 4.7233333 0.368007
+ 4.7236111 0.322665
+ 4.7238889 0.272950
+ 4.7241667 0.221165
+ 4.7244444 0.169611
+ 4.7247222 0.120589
+ 4.7250000 0.076403
+ 4.7252778 0.050000
+ 4.7255556 0.050000
+ 4.7258333 0.050000
+ 4.7261111 0.050000
+ 4.7263889 0.050000
+ 4.7266667 0.050000
+ 4.7269444 0.050000
+ 4.7272222 0.050000
+ 4.7275000 0.050000
+ 4.7277778 0.050000
+ 4.7280556 0.092362
+ 4.7283333 0.140999
+ 4.7286111 0.193441
+ 4.7288889 0.247219
+ 4.7291667 0.299863
+ 4.7294444 0.348904
+ 4.7297222 0.391873
+ 4.7300000 0.426299
+ 4.7302778 0.449714
+ 4.7305556 0.459647
+ 4.7308333 0.454428
+ 4.7311111 0.435583
+ 4.7313889 0.405433
+ 4.7316667 0.366303
+ 4.7319444 0.320517
+ 4.7322222 0.270397
+ 4.7325000 0.218268
+ 4.7327778 0.166452
+ 4.7330556 0.117273
+ 4.7333333 0.073055
+ 4.7336111 0.050000
+ 4.7338889 0.050000
+ 4.7341667 0.050000
+ 4.7344444 0.050000
+ 4.7347222 0.050000
+ 4.7350000 0.050000
+ 4.7352778 0.050000
+ 4.7355556 0.050000
+ 4.7358333 0.050000
+ 4.7361111 0.050000
+ 4.7363889 0.092494
+ 4.7366667 0.141168
+ 4.7369444 0.193577
+ 4.7372222 0.247275
+ 4.7375000 0.299817
+ 4.7377778 0.348757
+ 4.7380556 0.391649
+ 4.7383333 0.426047
+ 4.7386111 0.449507
+ 4.7388889 0.459582
+ 4.7391667 0.454616
+ 4.7394444 0.436117
+ 4.7397222 0.406379
+ 4.7400000 0.367699
+ 4.7402778 0.322372
+ 4.7405556 0.272695
+ 4.7408333 0.220964
+ 4.7411111 0.169474
+ 4.7413889 0.120521
+ 4.7416667 0.076403
+ 4.7419444 0.050000
+ 4.7422222 0.050000
+ 4.7425000 0.050000
+ 4.7427778 0.050000
+ 4.7430556 0.050000
+ 4.7433333 0.050000
+ 4.7436111 0.050000
+ 4.7438889 0.050000
+ 4.7441667 0.050000
+ 4.7444444 0.050000
+ 4.7447222 0.092255
+ 4.7450000 0.140772
+ 4.7452778 0.193094
+ 4.7455556 0.246766
+ 4.7458333 0.299331
+ 4.7461111 0.348332
+ 4.7463889 0.391313
+ 4.7466667 0.425817
+ 4.7469444 0.449387
+ 4.7472222 0.459569
+ 4.7475000 0.454695
+ 4.7477778 0.436271
+ 4.7480556 0.406590
+ 4.7483333 0.367947
+ 4.7486111 0.322637
+ 4.7488889 0.272955
+ 4.7491667 0.221196
+ 4.7494444 0.169654
+ 4.7497222 0.120625
+ 4.7500000 0.076403
+ 4.7502778 0.050000
+ 4.7505556 0.050000
+ 4.7508333 0.050000
+ 4.7511111 0.050000
+ 4.7513889 0.050000
+ 4.7516667 0.050000
+ 4.7519444 0.050000
+ 4.7522222 0.050000
+ 4.7525000 0.050000
+ 4.7527778 0.050000
+ 4.7530556 0.092680
+ 4.7533333 0.141687
+ 4.7536111 0.194506
+ 4.7538889 0.248620
+ 4.7541667 0.301512
+ 4.7544444 0.350667
+ 4.7547222 0.393568
+ 4.7550000 0.427698
+ 4.7552778 0.450541
+ 4.7555556 0.459582
+ 4.7558333 0.453125
+ 4.7561111 0.432766
+ 4.7563889 0.400925
+ 4.7566667 0.360020
+ 4.7569444 0.312469
+ 4.7572222 0.260690
+ 4.7575000 0.207102
+ 4.7577778 0.154123
+ 4.7580556 0.104172
+ 4.7583333 0.059667
+ 4.7586111 0.050000
+ 4.7588889 0.050000
+ 4.7591667 0.050000
+ 4.7594444 0.050000
+ 4.7597222 0.050000
+ 4.7600000 0.050000
+ 4.7602778 0.050000
+ 4.7605556 0.050000
+ 4.7608333 0.050000
+ 4.7611111 0.050000
+ 4.7613889 0.093466
+ 4.7616667 0.142799
+ 4.7619444 0.195589
+ 4.7622222 0.249428
+ 4.7625000 0.301907
+ 4.7627778 0.350614
+ 4.7630556 0.393143
+ 4.7633333 0.427082
+ 4.7636111 0.450022
+ 4.7638889 0.459555
+ 4.7641667 0.454057
+ 4.7644444 0.435046
+ 4.7647222 0.404827
+ 4.7650000 0.365705
+ 4.7652778 0.319984
+ 4.7655556 0.269969
+ 4.7658333 0.217963
+ 4.7661111 0.166273
+ 4.7663889 0.117202
+ 4.7666667 0.073055
+ 4.7669444 0.050000
+ 4.7672222 0.050000
+ 4.7675000 0.050000
+ 4.7677778 0.050000
+ 4.7680556 0.050000
+ 4.7683333 0.050000
+ 4.7686111 0.050000
+ 4.7688889 0.050000
+ 4.7691667 0.050000
+ 4.7694444 0.050000
+ 4.7697222 0.092715
+ 4.7700000 0.141658
+ 4.7702778 0.194347
+ 4.7705556 0.248300
+ 4.7708333 0.301036
+ 4.7711111 0.350071
+ 4.7713889 0.392926
+ 4.7716667 0.427117
+ 4.7719444 0.450163
+ 4.7722222 0.459582
+ 4.7725000 0.453700
+ 4.7727778 0.434076
+ 4.7730556 0.403077
+ 4.7733333 0.363068
+ 4.7736111 0.316418
+ 4.7738889 0.265491
+ 4.7741667 0.212656
+ 4.7744444 0.160278
+ 4.7747222 0.110724
+ 4.7750000 0.066361
+ 4.7752778 0.050000
+ 4.7755556 0.050000
+ 4.7758333 0.050000
+ 4.7761111 0.050000
+ 4.7763889 0.050000
+ 4.7766667 0.050000
+ 4.7769444 0.050000
+ 4.7772222 0.050000
+ 4.7775000 0.050000
+ 4.7777778 0.050000
+ 4.7780556 0.093101
+ 4.7783333 0.142247
+ 4.7786111 0.194993
+ 4.7788889 0.248894
+ 4.7791667 0.301504
+ 4.7794444 0.350379
+ 4.7797222 0.393072
+ 4.7800000 0.427138
+ 4.7802778 0.450131
+ 4.7805556 0.459608
+ 4.7808333 0.453918
+ 4.7811111 0.434600
+ 4.7813889 0.403990
+ 4.7816667 0.364424
+ 4.7819444 0.318235
+ 4.7822222 0.267761
+ 4.7825000 0.215335
+ 4.7827778 0.163295
+ 4.7830556 0.113974
+ 4.7833333 0.069708
+ 4.7836111 0.050000
+ 4.7838889 0.050000
+ 4.7841667 0.050000
+ 4.7844444 0.050000
+ 4.7847222 0.050000
+ 4.7850000 0.050000
+ 4.7852778 0.050000
+ 4.7855556 0.050000
+ 4.7858333 0.050000
+ 4.7861111 0.050000
+ 4.7863889 0.092948
+ 4.7866667 0.142038
+ 4.7869444 0.194802
+ 4.7872222 0.248770
+ 4.7875000 0.301473
+ 4.7877778 0.350442
+ 4.7880556 0.393208
+ 4.7883333 0.427302
+ 4.7886111 0.450253
+ 4.7888889 0.459595
+ 4.7891667 0.453661
+ 4.7894444 0.434009
+ 4.7897222 0.403001
+ 4.7900000 0.362999
+ 4.7902778 0.316363
+ 4.7905556 0.265457
+ 4.7908333 0.212642
+ 4.7911111 0.160280
+ 4.7913889 0.110732
+ 4.7916667 0.066361
+ 4.7919444 0.050000
+ 4.7922222 0.050000
+ 4.7925000 0.050000
+ 4.7927778 0.050000
+ 4.7930556 0.050000
+ 4.7933333 0.050000
+ 4.7936111 0.050000
+ 4.7938889 0.050000
+ 4.7941667 0.050000
+ 4.7944444 0.050000
+ 4.7947222 0.093250
+ 4.7950000 0.142572
+ 4.7952778 0.195497
+ 4.7955556 0.249558
+ 4.7958333 0.302286
+ 4.7961111 0.351214
+ 4.7963889 0.393875
+ 4.7966667 0.427799
+ 4.7969444 0.450520
+ 4.7972222 0.459569
+ 4.7975000 0.453286
+ 4.7977778 0.433243
+ 4.7980556 0.401818
+ 4.7983333 0.361391
+ 4.7986111 0.314341
+ 4.7988889 0.263047
+ 4.7991667 0.209889
+ 4.7994444 0.157244
+ 4.7997222 0.107493
+ 4.8000000 0.063014
+ 4.8002778 0.050000
+ 4.8005556 0.050000
+ 4.8008333 0.050000
+ 4.8011111 0.050000
+ 4.8013889 0.050000
+ 4.8016667 0.050000
+ 4.8019444 0.050000
+ 4.8022222 0.050000
+ 4.8025000 0.050000
+ 4.8027778 0.050000
+ 4.8030556 0.093793
+ 4.8033333 0.143630
+ 4.8036111 0.197008
+ 4.8038889 0.251424
+ 4.8041667 0.304377
+ 4.8044444 0.353363
+ 4.8047222 0.395880
+ 4.8050000 0.429426
+ 4.8052778 0.451498
+ 4.8055556 0.459595
+ 4.8058333 0.452041
+ 4.8061111 0.430478
+ 4.8063889 0.397376
+ 4.8066667 0.355204
+ 4.8069444 0.306432
+ 4.8072222 0.253528
+ 4.8075000 0.198964
+ 4.8077778 0.145208
+ 4.8080556 0.094730
+ 4.8083333 0.050000
+ 4.8086111 0.050000
+ 4.8088889 0.050000
+ 4.8091667 0.050000
+ 4.8094444 0.050000
+ 4.8097222 0.050000
+ 4.8100000 0.050000
+ 4.8102778 0.050000
+ 4.8105556 0.050000
+ 4.8108333 0.050000
+ 4.8111111 0.050000
+ 4.8113889 0.094665
+ 4.8116667 0.145058
+ 4.8119444 0.198724
+ 4.8122222 0.253205
+ 4.8125000 0.306044
+ 4.8127778 0.354784
+ 4.8130556 0.396969
+ 4.8133333 0.430141
+ 4.8136111 0.451844
+ 4.8138889 0.459621
+ 4.8141667 0.451833
+ 4.8144444 0.430120
+ 4.8147222 0.396939
+ 4.8150000 0.354748
+ 4.8152778 0.306003
+ 4.8155556 0.253163
+ 4.8158333 0.198685
+ 4.8161111 0.145027
+ 4.8163889 0.094646
+ 4.8166667 0.050000
+ 4.8169444 0.050000
+ 4.8172222 0.050000
+ 4.8175000 0.050000
+ 4.8177778 0.050000
+ 4.8180556 0.050000
+ 4.8183333 0.050000
+ 4.8186111 0.050000
+ 4.8188889 0.050000
+ 4.8191667 0.050000
+ 4.8194444 0.050000
+ 4.8197222 0.094644
+ 4.8200000 0.145021
+ 4.8202778 0.198674
+ 4.8205556 0.253147
+ 4.8208333 0.305981
+ 4.8211111 0.354720
+ 4.8213889 0.396905
+ 4.8216667 0.430080
+ 4.8219444 0.451787
+ 4.8222222 0.459569
+ 4.8225000 0.451787
+ 4.8227778 0.430080
+ 4.8230556 0.396905
+ 4.8233333 0.354719
+ 4.8236111 0.305980
+ 4.8238889 0.253146
+ 4.8241667 0.198674
+ 4.8244444 0.145020
+ 4.8247222 0.094643
+ 4.8250000 0.050000
+ 4.8252778 0.050000
+ 4.8255556 0.050000
+ 4.8258333 0.050000
+ 4.8261111 0.050000
+ 4.8263889 0.050000
+ 4.8266667 0.050000
+ 4.8269444 0.050000
+ 4.8272222 0.050000
+ 4.8275000 0.050000
+ 4.8277778 0.050000
+ 4.8280556 0.094644
+ 4.8283333 0.145023
+ 4.8286111 0.198678
+ 4.8288889 0.253152
+ 4.8291667 0.305989
+ 4.8294444 0.354729
+ 4.8297222 0.396916
+ 4.8300000 0.430092
+ 4.8302778 0.451800
+ 4.8305556 0.459582
+ 4.8308333 0.451799
+ 4.8311111 0.430091
+ 4.8313889 0.396914
+ 4.8316667 0.354727
+ 4.8319444 0.305986
+ 4.8322222 0.253150
+ 4.8325000 0.198676
+ 4.8327778 0.145021
+ 4.8330556 0.094643
+ 4.8333333 0.050000
+ 4.8336111 0.050000
+ 4.8338889 0.050000
+ 4.8341667 0.050000
+ 4.8344444 0.050000
+ 4.8347222 0.050000
+ 4.8350000 0.050000
+ 4.8352778 0.050000
+ 4.8355556 0.050000
+ 4.8358333 0.050000
+ 4.8361111 0.050000
+ 4.8363889 0.094638
+ 4.8366667 0.145010
+ 4.8369444 0.198657
+ 4.8372222 0.253123
+ 4.8375000 0.305950
+ 4.8377778 0.354682
+ 4.8380556 0.396862
+ 4.8383333 0.430032
+ 4.8386111 0.451736
+ 4.8388889 0.459516
+ 4.8391667 0.451735
+ 4.8394444 0.430030
+ 4.8397222 0.396859
+ 4.8400000 0.354679
+ 4.8402778 0.305946
+ 4.8405556 0.253119
+ 4.8408333 0.198653
+ 4.8411111 0.145007
+ 4.8413889 0.094637
+ 4.8416667 0.050000
+ 4.8419444 0.050000
+ 4.8422222 0.050000
+ 4.8425000 0.050000
+ 4.8427778 0.050000
+ 4.8430556 0.050000
+ 4.8433333 0.050000
+ 4.8436111 0.050000
+ 4.8438889 0.050000
+ 4.8441667 0.050000
+ 4.8444444 0.050000
+ 4.8447222 0.094635
+ 4.8450000 0.145002
+ 4.8452778 0.198646
+ 4.8455556 0.253108
+ 4.8458333 0.305932
+ 4.8461111 0.354661
+ 4.8463889 0.396838
+ 4.8466667 0.430007
+ 4.8469444 0.451710
+ 4.8472222 0.459490
+ 4.8475000 0.451710
+ 4.8477778 0.430007
+ 4.8480556 0.396838
+ 4.8483333 0.354661
+ 4.8486111 0.305932
+ 4.8488889 0.253108
+ 4.8491667 0.198646
+ 4.8494444 0.145002
+ 4.8497222 0.094635
+ 4.8500000 0.050000
+ 4.8502778 0.050000
+ 4.8505556 0.050000
+ 4.8508333 0.050000
+ 4.8511111 0.050000
+ 4.8513889 0.050000
+ 4.8516667 0.050000
+ 4.8519444 0.050000
+ 4.8522222 0.050000
+ 4.8525000 0.050000
+ 4.8527778 0.050000
+ 4.8530556 0.094637
+ 4.8533333 0.145007
+ 4.8536111 0.198653
+ 4.8538889 0.253119
+ 4.8541667 0.305947
+ 4.8544444 0.354679
+ 4.8547222 0.396860
+ 4.8550000 0.430031
+ 4.8552778 0.451735
+ 4.8555556 0.459516
+ 4.8558333 0.451736
+ 4.8561111 0.430031
+ 4.8563889 0.396861
+ 4.8566667 0.354681
+ 4.8569444 0.305948
+ 4.8572222 0.253121
+ 4.8575000 0.198655
+ 4.8577778 0.145008
+ 4.8580556 0.094637
+ 4.8583333 0.050000
+ 4.8586111 0.050000
+ 4.8588889 0.050000
+ 4.8591667 0.050000
+ 4.8594444 0.050000
+ 4.8597222 0.050000
+ 4.8600000 0.050000
+ 4.8602778 0.050000
+ 4.8605556 0.050000
+ 4.8608333 0.050000
+ 4.8611111 0.050000
+ 4.8613889 0.094638
+ 4.8616667 0.145010
+ 4.8619444 0.198658
+ 4.8622222 0.253125
+ 4.8625000 0.305954
+ 4.8627778 0.354688
+ 4.8630556 0.396869
+ 4.8633333 0.430042
+ 4.8636111 0.451747
+ 4.8638889 0.459529
+ 4.8641667 0.451749
+ 4.8644444 0.430046
+ 4.8647222 0.396875
+ 4.8650000 0.354695
+ 4.8652778 0.305962
+ 4.8655556 0.253133
+ 4.8658333 0.198665
+ 4.8661111 0.145016
+ 4.8663889 0.094642
+ 4.8666667 0.050000
+ 4.8669444 0.050000
+ 4.8672222 0.050000
+ 4.8675000 0.050000
+ 4.8677778 0.050000
+ 4.8680556 0.050000
+ 4.8683333 0.050000
+ 4.8686111 0.050000
+ 4.8688889 0.050000
+ 4.8691667 0.050000
+ 4.8694444 0.050000
+ 4.8697222 0.094655
+ 4.8700000 0.145045
+ 4.8702778 0.198714
+ 4.8705556 0.253201
+ 4.8708333 0.306047
+ 4.8711111 0.354794
+ 4.8713889 0.396982
+ 4.8716667 0.430154
+ 4.8719444 0.451848
+ 4.8722222 0.459608
+ 4.8725000 0.451793
+ 4.8727778 0.430047
+ 4.8730556 0.396830
+ 4.8733333 0.354607
+ 4.8736111 0.305838
+ 4.8738889 0.252987
+ 4.8741667 0.198515
+ 4.8744444 0.144885
+ 4.8747222 0.094559
+ 4.8750000 0.050000
+ 4.8752778 0.050000
+ 4.8755556 0.050000
+ 4.8758333 0.050000
+ 4.8761111 0.050000
+ 4.8763889 0.050000
+ 4.8766667 0.050000
+ 4.8769444 0.050000
+ 4.8772222 0.050000
+ 4.8775000 0.050000
+ 4.8777778 0.050000
+ 4.8780556 0.094196
+ 4.8783333 0.144055
+ 4.8786111 0.197185
+ 4.8788889 0.251193
+ 4.8791667 0.303686
+ 4.8794444 0.352273
+ 4.8797222 0.394560
+ 4.8800000 0.428155
+ 4.8802778 0.450666
+ 4.8805556 0.459699
+ 4.8808333 0.453651
+ 4.8811111 0.434063
+ 4.8813889 0.403269
+ 4.8816667 0.363598
+ 4.8819444 0.317381
+ 4.8822222 0.266951
+ 4.8825000 0.214637
+ 4.8827778 0.162772
+ 4.8830556 0.113685
+ 4.8833333 0.069708
+ 4.8836111 0.050000
+ 4.8838889 0.050000
+ 4.8841667 0.050000
+ 4.8844444 0.050000
+ 4.8847222 0.050000
+ 4.8850000 0.050000
+ 4.8852778 0.050000
+ 4.8855556 0.050000
+ 4.8858333 0.050000
+ 4.8861111 0.051508
+ 4.8863889 0.093938
+ 4.8866667 0.142390
+ 4.8869444 0.194472
+ 4.8872222 0.247792
+ 4.8875000 0.299960
+ 4.8877778 0.348584
+ 4.8880556 0.391273
+ 4.8883333 0.425636
+ 4.8886111 0.449281
+ 4.8888889 0.459817
+ 4.8891667 0.455628
+ 4.8894444 0.438198
+ 4.8897222 0.409786
+ 4.8900000 0.372651
+ 4.8902778 0.329050
+ 4.8905556 0.281244
+ 4.8908333 0.231491
+ 4.8911111 0.182050
+ 4.8913889 0.135180
+ 4.8916667 0.093139
+ 4.8919444 0.057826
+ 4.8922222 0.050000
+ 4.8925000 0.050000
+ 4.8927778 0.050000
+ 4.8930556 0.050000
+ 4.8933333 0.050000
+ 4.8936111 0.050000
+ 4.8938889 0.050000
+ 4.8941667 0.050000
+ 4.8944444 0.074938
+ 4.8947222 0.115423
+ 4.8950000 0.161645
+ 4.8952778 0.211286
+ 4.8955556 0.262029
+ 4.8958333 0.311555
+ 4.8961111 0.357547
+ 4.8963889 0.397687
+ 4.8966667 0.429658
+ 4.8969444 0.451140
+ 4.8972222 0.459817
+ 4.8975000 0.454131
+ 4.8977778 0.435569
+ 4.8980556 0.406377
+ 4.8983333 0.368803
+ 4.8986111 0.325092
+ 4.8988889 0.277492
+ 4.8991667 0.228250
+ 4.8994444 0.179613
+ 4.8997222 0.133827
+ 4.9000000 0.093139
+ 4.9002778 0.059423
+ 4.9005556 0.050000
+ 4.9008333 0.050000
+ 4.9011111 0.050000
+ 4.9013889 0.050000
+ 4.9016667 0.050000
+ 4.9019444 0.050000
+ 4.9022222 0.050000
+ 4.9025000 0.055490
+ 4.9027778 0.088393
+ 4.9030556 0.128385
+ 4.9033333 0.173630
+ 4.9036111 0.221920
+ 4.9038889 0.271049
+ 4.9041667 0.318811
+ 4.9044444 0.362998
+ 4.9047222 0.401404
+ 4.9050000 0.431823
+ 4.9052778 0.452047
+ 4.9055556 0.459869
+ 4.9058333 0.453807
+ 4.9061111 0.435265
+ 4.9063889 0.406373
+ 4.9066667 0.369260
+ 4.9069444 0.326054
+ 4.9072222 0.278884
+ 4.9075000 0.229878
+ 4.9077778 0.181166
+ 4.9080556 0.134877
+ 4.9083333 0.093139
+ 4.9086111 0.057754
+ 4.9088889 0.050000
+ 4.9091667 0.050000
+ 4.9094444 0.050000
+ 4.9097222 0.050000
+ 4.9100000 0.050000
+ 4.9102778 0.050000
+ 4.9105556 0.050000
+ 4.9108333 0.050000
+ 4.9111111 0.068296
+ 4.9113889 0.108756
+ 4.9116667 0.155246
+ 4.9119444 0.205398
+ 4.9122222 0.256840
+ 4.9125000 0.307202
+ 4.9127778 0.354115
+ 4.9130556 0.395206
+ 4.9133333 0.428107
+ 4.9136111 0.450448
+ 4.9138889 0.459856
+ 4.9141667 0.454735
+ 4.9144444 0.436573
+ 4.9147222 0.407632
+ 4.9150000 0.370172
+ 4.9152778 0.326454
+ 4.9155556 0.278740
+ 4.9158333 0.229291
+ 4.9161111 0.180366
+ 4.9163889 0.134229
+ 4.9166667 0.093139
+ 4.9169444 0.058985
+ 4.9172222 0.050000
+ 4.9175000 0.050000
+ 4.9177778 0.050000
+ 4.9180556 0.050000
+ 4.9183333 0.050000
+ 4.9186111 0.050000
+ 4.9188889 0.050000
+ 4.9191667 0.052150
+ 4.9194444 0.085006
+ 4.9197222 0.125069
+ 4.9200000 0.170490
+ 4.9202778 0.219045
+ 4.9205556 0.268510
+ 4.9208333 0.316661
+ 4.9211111 0.361273
+ 4.9213889 0.400123
+ 4.9216667 0.430986
+ 4.9219444 0.451639
+ 4.9222222 0.459856
+ 4.9225000 0.454145
+ 4.9227778 0.435938
+ 4.9230556 0.407395
+ 4.9233333 0.370680
+ 4.9236111 0.327953
+ 4.9238889 0.281378
+ 4.9241667 0.233117
+ 4.9244444 0.185331
+ 4.9247222 0.140182
+ 4.9250000 0.099833
+ 4.9252778 0.066099
+ 4.9255556 0.050000
+ 4.9258333 0.050000
+ 4.9261111 0.050000
+ 4.9263889 0.050000
+ 4.9266667 0.050000
+ 4.9269444 0.050000
+ 4.9272222 0.050000
+ 4.9275000 0.056047
+ 4.9277778 0.088419
+ 4.9280556 0.128129
+ 4.9283333 0.173305
+ 4.9286111 0.221683
+ 4.9288889 0.271000
+ 4.9291667 0.318993
+ 4.9294444 0.363399
+ 4.9297222 0.401953
+ 4.9300000 0.432395
+ 4.9302778 0.452459
+ 4.9305556 0.459882
+ 4.9308333 0.453148
+ 4.9311111 0.433720
+ 4.9313889 0.403807
+ 4.9316667 0.365620
+ 4.9319444 0.321366
+ 4.9322222 0.273256
+ 4.9325000 0.223500
+ 4.9327778 0.174306
+ 4.9330556 0.127885
+ 4.9333333 0.086444
+ 4.9336111 0.051838
+ 4.9338889 0.050000
+ 4.9341667 0.050000
+ 4.9344444 0.050000
+ 4.9347222 0.050000
+ 4.9350000 0.050000
+ 4.9352778 0.050000
+ 4.9355556 0.050000
+ 4.9358333 0.050000
+ 4.9361111 0.074978
+ 4.9363889 0.115559
+ 4.9366667 0.161728
+ 4.9369444 0.211215
+ 4.9372222 0.261750
+ 4.9375000 0.311062
+ 4.9377778 0.356883
+ 4.9380556 0.396941
+ 4.9383333 0.428967
+ 4.9386111 0.450691
+ 4.9388889 0.459843
+ 4.9391667 0.454889
+ 4.9394444 0.437239
+ 4.9397222 0.409038
+ 4.9400000 0.372434
+ 4.9402778 0.329570
+ 4.9405556 0.282595
+ 4.9408333 0.233653
+ 4.9411111 0.184890
+ 4.9413889 0.138452
+ 4.9416667 0.096486
+ 4.9419444 0.060810
+ 4.9422222 0.050000
+ 4.9425000 0.050000
+ 4.9427778 0.050000
+ 4.9430556 0.050000
+ 4.9433333 0.050000
+ 4.9436111 0.050000
+ 4.9438889 0.050000
+ 4.9441667 0.050000
+ 4.9444444 0.068257
+ 4.9447222 0.108577
+ 4.9450000 0.154994
+ 4.9452778 0.205125
+ 4.9455556 0.256586
+ 4.9458333 0.306993
+ 4.9461111 0.353962
+ 4.9463889 0.395111
+ 4.9466667 0.428054
+ 4.9469444 0.450409
+ 4.9472222 0.459791
+ 4.9475000 0.454591
+ 4.9477778 0.436295
+ 4.9480556 0.407165
+ 4.9483333 0.369461
+ 4.9486111 0.325444
+ 4.9488889 0.277375
+ 4.9491667 0.227514
+ 4.9494444 0.178123
+ 4.9497222 0.131462
+ 4.9500000 0.089792
+ 4.9502778 0.055007
+ 4.9505556 0.050000
+ 4.9508333 0.050000
+ 4.9511111 0.050000
+ 4.9513889 0.050000
+ 4.9516667 0.050000
+ 4.9519444 0.050000
+ 4.9522222 0.050000
+ 4.9525000 0.050000
+ 4.9527778 0.078312
+ 4.9530556 0.118998
+ 4.9533333 0.165248
+ 4.9536111 0.214763
+ 4.9538889 0.265247
+ 4.9541667 0.314403
+ 4.9544444 0.359932
+ 4.9547222 0.399538
+ 4.9550000 0.430923
+ 4.9552778 0.451791
+ 4.9555556 0.459843
+ 4.9558333 0.453536
+ 4.9561111 0.434337
+ 4.9563889 0.404467
+ 4.9566667 0.366146
+ 4.9569444 0.321595
+ 4.9572222 0.273033
+ 4.9575000 0.222682
+ 4.9577778 0.172762
+ 4.9580556 0.125494
+ 4.9583333 0.083097
+ 4.9586111 0.050000
+ 4.9588889 0.050000
+ 4.9591667 0.050000
+ 4.9594444 0.050000
+ 4.9597222 0.050000
+ 4.9600000 0.050000
+ 4.9602778 0.050000
+ 4.9605556 0.050000
+ 4.9608333 0.050000
+ 4.9611111 0.064884
+ 4.9613889 0.106133
+ 4.9616667 0.153280
+ 4.9619444 0.203966
+ 4.9622222 0.255834
+ 4.9625000 0.306526
+ 4.9627778 0.353684
+ 4.9630556 0.394952
+ 4.9633333 0.427970
+ 4.9636111 0.450382
+ 4.9638889 0.459830
+ 4.9641667 0.454723
+ 4.9644444 0.436540
+ 4.9647222 0.407527
+ 4.9650000 0.369928
+ 4.9652778 0.325989
+ 4.9655556 0.277956
+ 4.9658333 0.228074
+ 4.9661111 0.178589
+ 4.9663889 0.131746
+ 4.9666667 0.089792
+ 4.9669444 0.054612
+ 4.9672222 0.050000
+ 4.9675000 0.050000
+ 4.9677778 0.050000
+ 4.9680556 0.050000
+ 4.9683333 0.050000
+ 4.9686111 0.050000
+ 4.9688889 0.050000
+ 4.9691667 0.050000
+ 4.9694444 0.074951
+ 4.9697222 0.116013
+ 4.9700000 0.162811
+ 4.9702778 0.212978
+ 4.9705556 0.264150
+ 4.9708333 0.313961
+ 4.9711111 0.360047
+ 4.9713889 0.400042
+ 4.9716667 0.431581
+ 4.9719444 0.452299
+ 4.9722222 0.459830
+ 4.9725000 0.452593
+ 4.9727778 0.432140
+ 4.9730556 0.400807
+ 4.9733333 0.360931
+ 4.9736111 0.314846
+ 4.9738889 0.264889
+ 4.9741667 0.213395
+ 4.9744444 0.162701
+ 4.9747222 0.115143
+ 4.9750000 0.073055
+ 4.9752778 0.050000
+ 4.9755556 0.050000
+ 4.9758333 0.050000
+ 4.9761111 0.050000
+ 4.9763889 0.050000
+ 4.9766667 0.050000
+ 4.9769444 0.050000
+ 4.9772222 0.050000
+ 4.9775000 0.050000
+ 4.9777778 0.074951
+ 4.9780556 0.117068
+ 4.9783333 0.164523
+ 4.9786111 0.215012
+ 4.9788889 0.266230
+ 4.9791667 0.315874
+ 4.9794444 0.361639
+ 4.9797222 0.401220
+ 4.9800000 0.432313
+ 4.9802778 0.452614
+ 4.9805556 0.459817
+ 4.9808333 0.452384
+ 4.9811111 0.431836
+ 4.9813889 0.400459
+ 4.9816667 0.360541
+ 4.9819444 0.314368
+ 4.9822222 0.264226
+ 4.9825000 0.212403
+ 4.9827778 0.161184
+ 4.9830556 0.112857
+ 4.9833333 0.069708
+ 4.9836111 0.050000
+ 4.9838889 0.050000
+ 4.9841667 0.050000
+ 4.9844444 0.050000
+ 4.9847222 0.050000
+ 4.9850000 0.050000
+ 4.9852778 0.050000
+ 4.9855556 0.050000
+ 4.9858333 0.050000
+ 4.9861111 0.058124
+ 4.9863889 0.100647
+ 4.9866667 0.149031
+ 4.9869444 0.200880
+ 4.9872222 0.253800
+ 4.9875000 0.305398
+ 4.9877778 0.353279
+ 4.9880556 0.395049
+ 4.9883333 0.428314
+ 4.9886111 0.450679
+ 4.9888889 0.459752
+ 4.9891667 0.453917
+ 4.9894444 0.434683
+ 4.9897222 0.404338
+ 4.9900000 0.365172
+ 4.9902778 0.319471
+ 4.9905556 0.269525
+ 4.9908333 0.217622
+ 4.9911111 0.166050
+ 4.9913889 0.117099
+ 4.9916667 0.073055
+ 4.9919444 0.050000
+ 4.9922222 0.050000
+ 4.9925000 0.050000
+ 4.9927778 0.050000
+ 4.9930556 0.050000
+ 4.9933333 0.050000
+ 4.9936111 0.050000
+ 4.9938889 0.050000
+ 4.9941667 0.050000
+ 4.9944444 0.050000
+ 4.9947222 0.092698
+ 4.9950000 0.141633
+ 4.9952778 0.194322
+ 4.9955556 0.248282
+ 4.9958333 0.301032
+ 4.9961111 0.350088
+ 4.9963889 0.392967
+ 4.9966667 0.427189
+ 4.9969444 0.450269
+ 4.9972222 0.459725
+ 4.9975000 0.453887
+ 4.9977778 0.434325
+ 4.9980556 0.403422
+ 4.9983333 0.363561
+ 4.9986111 0.317125
+ 4.9988889 0.266496
+ 4.9991667 0.214058
+ 4.9994444 0.162191
+ 4.9997222 0.113281
+ 5.0000000 0.069708
+ 5.0002778 0.050000
+ 5.0005556 0.050000
+ 5.0008333 0.050000
+ 5.0011111 0.050000
+ 5.0013889 0.050000
+ 5.0016667 0.050000
+ 5.0019444 0.050000
+ 5.0022222 0.050000
+ 5.0025000 0.050000
+ 5.0027778 0.061523
+ 5.0030556 0.104349
+ 5.0033333 0.152907
+ 5.0036111 0.204798
+ 5.0038889 0.257622
+ 5.0041667 0.308978
+ 5.0044444 0.356466
+ 5.0047222 0.397686
+ 5.0050000 0.430239
+ 5.0052778 0.451723
+ 5.0055556 0.459738
+ 5.0058333 0.452678
+ 5.0061111 0.432100
+ 5.0063889 0.400356
+ 5.0066667 0.359798
+ 5.0069444 0.312776
+ 5.0072222 0.261642
+ 5.0075000 0.208748
+ 5.0077778 0.156444
+ 5.0080556 0.107082
+ 5.0083333 0.063014
+ 5.0086111 0.050000
+ 5.0088889 0.050000
+ 5.0091667 0.050000
+ 5.0094444 0.050000
+ 5.0097222 0.050000
+ 5.0100000 0.050000
+ 5.0102778 0.050000
+ 5.0105556 0.050000
+ 5.0108333 0.050000
+ 5.0111111 0.051416
+ 5.0113889 0.094783
+ 5.0116667 0.144104
+ 5.0119444 0.196936
+ 5.0122222 0.250835
+ 5.0125000 0.303357
+ 5.0127778 0.352058
+ 5.0130556 0.394494
+ 5.0133333 0.428222
+ 5.0136111 0.450798
+ 5.0138889 0.459778
+ 5.0141667 0.453520
+ 5.0144444 0.433592
+ 5.0147222 0.402363
+ 5.0150000 0.362202
+ 5.0152778 0.315480
+ 5.0155556 0.264564
+ 5.0158333 0.211825
+ 5.0161111 0.159632
+ 5.0163889 0.110354
+ 5.0166667 0.066361
+ 5.0169444 0.050000
+ 5.0172222 0.050000
+ 5.0175000 0.050000
+ 5.0177778 0.050000
+ 5.0180556 0.050000
+ 5.0183333 0.050000
+ 5.0186111 0.050000
+ 5.0188889 0.050000
+ 5.0191667 0.050000
+ 5.0194444 0.054750
+ 5.0197222 0.097879
+ 5.0200000 0.146907
+ 5.0202778 0.199404
+ 5.0205556 0.252937
+ 5.0208333 0.305076
+ 5.0211111 0.353388
+ 5.0213889 0.395442
+ 5.0216667 0.428806
+ 5.0219444 0.451049
+ 5.0222222 0.459738
+ 5.0225000 0.453244
+ 5.0227778 0.433133
+ 5.0230556 0.401776
+ 5.0233333 0.361541
+ 5.0236111 0.314797
+ 5.0238889 0.263914
+ 5.0241667 0.211260
+ 5.0244444 0.159203
+ 5.0247222 0.110114
+ 5.0250000 0.066361
+ 5.0252778 0.050000
+ 5.0255556 0.050000
+ 5.0258333 0.050000
+ 5.0261111 0.050000
+ 5.0263889 0.050000
+ 5.0266667 0.050000
+ 5.0269444 0.050000
+ 5.0272222 0.050000
+ 5.0275000 0.050000
+ 5.0277778 0.058150
+ 5.0280556 0.101482
+ 5.0283333 0.150639
+ 5.0286111 0.203173
+ 5.0288889 0.256636
+ 5.0291667 0.308577
+ 5.0294444 0.356550
+ 5.0297222 0.398103
+ 5.0300000 0.430789
+ 5.0302778 0.452160
+ 5.0305556 0.459765
+ 5.0308333 0.451969
+ 5.0311111 0.430388
+ 5.0313889 0.397452
+ 5.0316667 0.355589
+ 5.0319444 0.307228
+ 5.0322222 0.254798
+ 5.0325000 0.200729
+ 5.0327778 0.147449
+ 5.0330556 0.097387
+ 5.0333333 0.052972
+ 5.0336111 0.050000
+ 5.0338889 0.050000
+ 5.0341667 0.050000
+ 5.0344444 0.050000
+ 5.0347222 0.050000
+ 5.0350000 0.050000
+ 5.0352778 0.050000
+ 5.0355556 0.050000
+ 5.0358333 0.050000
+ 5.0361111 0.050000
+ 5.0363889 0.093958
+ 5.0366667 0.143654
+ 5.0369444 0.196687
+ 5.0372222 0.250656
+ 5.0375000 0.303161
+ 5.0377778 0.351802
+ 5.0380556 0.394178
+ 5.0383333 0.427889
+ 5.0386111 0.450534
+ 5.0388889 0.459712
+ 5.0391667 0.453811
+ 5.0394444 0.434365
+ 5.0397222 0.403694
+ 5.0400000 0.364120
+ 5.0402778 0.317965
+ 5.0405556 0.267549
+ 5.0408333 0.215194
+ 5.0411111 0.163222
+ 5.0413889 0.113953
+ 5.0416667 0.069708
+ 5.0419444 0.050000
+ 5.0422222 0.050000
+ 5.0425000 0.050000
+ 5.0427778 0.050000
+ 5.0430556 0.050000
+ 5.0433333 0.050000
+ 5.0436111 0.050000
+ 5.0438889 0.050000
+ 5.0441667 0.050000
+ 5.0444444 0.050000
+ 5.0447222 0.093206
+ 5.0450000 0.142604
+ 5.0452778 0.195686
+ 5.0455556 0.249943
+ 5.0458333 0.302867
+ 5.0461111 0.351950
+ 5.0463889 0.394682
+ 5.0466667 0.428557
+ 5.0469444 0.451066
+ 5.0472222 0.459699
+ 5.0475000 0.452778
+ 5.0477778 0.431937
+ 5.0480556 0.399639
+ 5.0483333 0.358348
+ 5.0486111 0.310526
+ 5.0488889 0.258636
+ 5.0491667 0.205142
+ 5.0494444 0.152507
+ 5.0497222 0.103194
+ 5.0500000 0.059667
+ 5.0502778 0.050000
+ 5.0505556 0.050000
+ 5.0508333 0.050000
+ 5.0511111 0.050000
+ 5.0513889 0.050000
+ 5.0516667 0.050000
+ 5.0519444 0.050000
+ 5.0522222 0.050000
+ 5.0525000 0.050000
+ 5.0527778 0.064857
+ 5.0530556 0.108263
+ 5.0533333 0.157034
+ 5.0536111 0.208832
+ 5.0538889 0.261318
+ 5.0541667 0.312154
+ 5.0544444 0.359003
+ 5.0547222 0.399525
+ 5.0550000 0.431383
+ 5.0552778 0.452238
+ 5.0555556 0.459752
+ 5.0558333 0.452366
+ 5.0561111 0.431641
+ 5.0563889 0.399915
+ 5.0566667 0.359529
+ 5.0569444 0.312823
+ 5.0572222 0.262134
+ 5.0575000 0.209805
+ 5.0577778 0.158173
+ 5.0580556 0.109578
+ 5.0583333 0.066361
+ 5.0586111 0.050000
+ 5.0588889 0.050000
+ 5.0591667 0.050000
+ 5.0594444 0.050000
+ 5.0597222 0.050000
+ 5.0600000 0.050000
+ 5.0602778 0.050000
+ 5.0605556 0.050000
+ 5.0608333 0.050000
+ 5.0611111 0.061432
+ 5.0613889 0.104526
+ 5.0616667 0.153328
+ 5.0619444 0.205426
+ 5.0622222 0.258408
+ 5.0625000 0.309861
+ 5.0627778 0.357374
+ 5.0630556 0.398534
+ 5.0633333 0.430930
+ 5.0636111 0.452148
+ 5.0638889 0.459778
+ 5.0641667 0.452207
+ 5.0644444 0.431034
+ 5.0647222 0.398654
+ 5.0650000 0.357467
+ 5.0652778 0.309871
+ 5.0655556 0.258262
+ 5.0658333 0.205039
+ 5.0661111 0.152601
+ 5.0663889 0.103344
+ 5.0666667 0.059667
+ 5.0669444 0.050000
+ 5.0672222 0.050000
+ 5.0675000 0.050000
+ 5.0677778 0.050000
+ 5.0680556 0.050000
+ 5.0683333 0.050000
+ 5.0686111 0.050000
+ 5.0688889 0.050000
+ 5.0691667 0.050000
+ 5.0694444 0.058111
+ 5.0697222 0.101538
+ 5.0700000 0.150588
+ 5.0702778 0.202881
+ 5.0705556 0.256037
+ 5.0708333 0.307673
+ 5.0711111 0.355411
+ 5.0713889 0.396868
+ 5.0716667 0.429664
+ 5.0719444 0.451419
+ 5.0722222 0.459752
+ 5.0725000 0.453069
+ 5.0727778 0.432935
+ 5.0730556 0.401700
+ 5.0733333 0.361715
+ 5.0736111 0.315330
+ 5.0738889 0.264898
+ 5.0741667 0.212768
+ 5.0744444 0.161293
+ 5.0747222 0.112823
+ 5.0750000 0.069708
+ 5.0752778 0.050000
+ 5.0755556 0.050000
+ 5.0758333 0.050000
+ 5.0761111 0.050000
+ 5.0763889 0.050000
+ 5.0766667 0.050000
+ 5.0769444 0.050000
+ 5.0772222 0.050000
+ 5.0775000 0.050000
+ 5.0777778 0.064857
+ 5.0780556 0.107812
+ 5.0783333 0.156439
+ 5.0786111 0.208320
+ 5.0788889 0.261042
+ 5.0791667 0.312190
+ 5.0794444 0.359346
+ 5.0797222 0.400098
+ 5.0800000 0.432028
+ 5.0802778 0.452722
+ 5.0805556 0.459765
+ 5.0808333 0.451545
+ 5.0811111 0.429674
+ 5.0813889 0.396564
+ 5.0816667 0.354632
+ 5.0819444 0.306291
+ 5.0822222 0.253957
+ 5.0825000 0.200043
+ 5.0827778 0.146964
+ 5.0830556 0.097136
+ 5.0833333 0.052972
+ 5.0836111 0.050000
+ 5.0838889 0.050000
+ 5.0841667 0.050000
+ 5.0844444 0.050000
+ 5.0847222 0.050000
+ 5.0850000 0.050000
+ 5.0852778 0.050000
+ 5.0855556 0.050000
+ 5.0858333 0.050000
+ 5.0861111 0.051390
+ 5.0863889 0.095207
+ 5.0866667 0.144708
+ 5.0869444 0.197512
+ 5.0872222 0.251241
+ 5.0875000 0.303514
+ 5.0877778 0.351953
+ 5.0880556 0.394179
+ 5.0883333 0.427811
+ 5.0886111 0.450470
+ 5.0888889 0.459778
+ 5.0891667 0.454135
+ 5.0894444 0.435070
+ 5.0897222 0.404891
+ 5.0900000 0.365908
+ 5.0902778 0.320428
+ 5.0905556 0.270762
+ 5.0908333 0.219217
+ 5.0911111 0.168103
+ 5.0913889 0.119729
+ 5.0916667 0.076403
+ 5.0919444 0.050000
+ 5.0922222 0.050000
+ 5.0925000 0.050000
+ 5.0927778 0.050000
+ 5.0930556 0.050000
+ 5.0933333 0.050000
+ 5.0936111 0.050000
+ 5.0938889 0.050000
+ 5.0941667 0.050000
+ 5.0944444 0.061484
+ 5.0947222 0.104080
+ 5.0950000 0.152624
+ 5.0952778 0.204654
+ 5.0955556 0.257710
+ 5.0958333 0.309329
+ 5.0961111 0.357051
+ 5.0963889 0.398415
+ 5.0966667 0.430958
+ 5.0969444 0.452220
+ 5.0972222 0.459738
+ 5.0975000 0.451875
+ 5.0977778 0.430279
+ 5.0980556 0.397421
+ 5.0983333 0.355773
+ 5.0986111 0.307805
+ 5.0988889 0.255989
+ 5.0991667 0.202796
+ 5.0994444 0.150697
+ 5.0997222 0.102163
+ 5.1000000 0.059667
+ 5.1002778 0.050000
+ 5.1005556 0.050000
+ 5.1008333 0.050000
+ 5.1011111 0.050000
+ 5.1013889 0.050000
+ 5.1016667 0.050000
+ 5.1019444 0.050000
+ 5.1022222 0.050000
+ 5.1025000 0.050000
+ 5.1027778 0.078246
+ 5.1030556 0.121850
+ 5.1033333 0.170427
+ 5.1036111 0.221659
+ 5.1038889 0.273227
+ 5.1041667 0.322812
+ 5.1044444 0.368095
+ 5.1047222 0.406759
+ 5.1050000 0.436484
+ 5.1052778 0.454951
+ 5.1055556 0.459843
+ 5.1058333 0.449641
+ 5.1061111 0.426032
+ 5.1063889 0.391502
+ 5.1066667 0.348540
+ 5.1069444 0.299633
+ 5.1072222 0.247268
+ 5.1075000 0.193931
+ 5.1077778 0.142112
+ 5.1080556 0.094296
+ 5.1083333 0.052972
+ 5.1086111 0.050000
+ 5.1088889 0.050000
+ 5.1091667 0.050000
+ 5.1094444 0.050000
+ 5.1097222 0.050000
+ 5.1100000 0.050000
+ 5.1102778 0.050000
+ 5.1105556 0.050000
+ 5.1108333 0.051355
+ 5.1111111 0.088249
+ 5.1113889 0.131337
+ 5.1116667 0.178799
+ 5.1119444 0.228503
+ 5.1122222 0.278312
+ 5.1125000 0.326094
+ 5.1127778 0.369713
+ 5.1130556 0.407036
+ 5.1133333 0.435928
+ 5.1136111 0.454255
+ 5.1138889 0.459882
+ 5.1141667 0.451411
+ 5.1144444 0.430382
+ 5.1147222 0.399070
+ 5.1150000 0.359750
+ 5.1152778 0.314699
+ 5.1155556 0.266190
+ 5.1158333 0.216500
+ 5.1161111 0.167905
+ 5.1163889 0.122679
+ 5.1166667 0.083097
+ 5.1169444 0.051039
+ 5.1172222 0.050000
+ 5.1175000 0.050000
+ 5.1177778 0.050000
+ 5.1180556 0.050000
+ 5.1183333 0.050000
+ 5.1186111 0.050000
+ 5.1188889 0.050000
+ 5.1191667 0.067158
+ 5.1194444 0.101677
+ 5.1197222 0.142723
+ 5.1200000 0.188452
+ 5.1202778 0.236673
+ 5.1205556 0.285195
+ 5.1208333 0.331826
+ 5.1211111 0.374375
+ 5.1213889 0.410650
+ 5.1216667 0.438461
+ 5.1219444 0.455615
+ 5.1222222 0.459922
+ 5.1225000 0.449955
+ 5.1227778 0.427350
+ 5.1230556 0.394510
+ 5.1233333 0.353835
+ 5.1236111 0.307728
+ 5.1238889 0.258589
+ 5.1241667 0.208820
+ 5.1244444 0.160823
+ 5.1247222 0.116999
+ 5.1250000 0.079750
+ 5.1252778 0.051015
+ 5.1255556 0.050000
+ 5.1258333 0.050000
+ 5.1261111 0.050000
+ 5.1263889 0.050000
+ 5.1266667 0.050000
+ 5.1269444 0.050000
+ 5.1272222 0.070099
+ 5.1275000 0.099842
+ 5.1277778 0.135228
+ 5.1280556 0.175628
+ 5.1283333 0.219384
+ 5.1286111 0.264577
+ 5.1288889 0.309289
+ 5.1291667 0.351603
+ 5.1294444 0.389600
+ 5.1297222 0.421362
+ 5.1300000 0.444973
+ 5.1302778 0.458513
+ 5.1305556 0.460065
+ 5.1308333 0.448401
+ 5.1311111 0.425045
+ 5.1313889 0.392213
+ 5.1316667 0.352120
+ 5.1319444 0.306980
+ 5.1322222 0.259008
+ 5.1325000 0.210419
+ 5.1327778 0.163428
+ 5.1330556 0.120249
+ 5.1333333 0.083097
+ 5.1336111 0.053779
+ 5.1338889 0.050000
+ 5.1341667 0.050000
+ 5.1344444 0.050000
+ 5.1347222 0.050000
+ 5.1350000 0.050000
+ 5.1352778 0.050000
+ 5.1355556 0.059463
+ 5.1358333 0.087568
+ 5.1361111 0.121786
+ 5.1363889 0.161594
+ 5.1366667 0.205314
+ 5.1369444 0.250980
+ 5.1372222 0.296627
+ 5.1375000 0.340289
+ 5.1377778 0.380000
+ 5.1380556 0.413795
+ 5.1383333 0.439708
+ 5.1386111 0.455774
+ 5.1388889 0.460026
+ 5.1391667 0.451180
+ 5.1394444 0.430665
+ 5.1397222 0.400594
+ 5.1400000 0.363078
+ 5.1402778 0.320227
+ 5.1405556 0.274151
+ 5.1408333 0.226964
+ 5.1411111 0.180774
+ 5.1413889 0.137694
+ 5.1416667 0.099833
+ 5.1419444 0.068943
+ 5.1422222 0.050000
+ 5.1425000 0.050000
+ 5.1427778 0.050000
+ 5.1430556 0.050000
+ 5.1433333 0.050000
+ 5.1436111 0.050000
+ 5.1438889 0.053391
+ 5.1441667 0.079181
+ 5.1444444 0.111810
+ 5.1447222 0.150881
+ 5.1450000 0.194629
+ 5.1452778 0.240944
+ 5.1455556 0.287719
+ 5.1458333 0.332845
+ 5.1461111 0.374214
+ 5.1463889 0.409719
+ 5.1466667 0.437250
+ 5.1469444 0.454700
+ 5.1472222 0.459961
+ 5.1475000 0.451638
+ 5.1477778 0.431199
+ 5.1480556 0.400823
+ 5.1483333 0.362691
+ 5.1486111 0.318983
+ 5.1488889 0.271881
+ 5.1491667 0.223565
+ 5.1494444 0.176216
+ 5.1497222 0.132013
+ 5.1500000 0.093139
+ 5.1502778 0.061401
+ 5.1505556 0.050000
+ 5.1508333 0.050000
+ 5.1511111 0.050000
+ 5.1513889 0.050000
+ 5.1516667 0.050000
+ 5.1519444 0.050000
+ 5.1522222 0.050000
+ 5.1525000 0.071602
+ 5.1527778 0.105116
+ 5.1530556 0.145265
+ 5.1533333 0.190218
+ 5.1536111 0.237783
+ 5.1538889 0.285772
+ 5.1541667 0.331995
+ 5.1544444 0.374263
+ 5.1547222 0.410385
+ 5.1550000 0.438173
+ 5.1552778 0.455437
+ 5.1555556 0.459987
+ 5.1558333 0.450386
+ 5.1561111 0.428203
+ 5.1563889 0.395761
+ 5.1566667 0.355380
+ 5.1569444 0.309383
+ 5.1572222 0.260091
+ 5.1575000 0.209825
+ 5.1577778 0.160907
+ 5.1580556 0.115659
+ 5.1583333 0.076403
+ 5.1586111 0.050000
+ 5.1588889 0.050000
+ 5.1591667 0.050000
+ 5.1594444 0.050000
+ 5.1597222 0.050000
+ 5.1600000 0.050000
+ 5.1602778 0.050000
+ 5.1605556 0.050000
+ 5.1608333 0.070262
+ 5.1611111 0.105037
+ 5.1613889 0.145885
+ 5.1616667 0.191050
+ 5.1619444 0.238468
+ 5.1622222 0.286072
+ 5.1625000 0.331796
+ 5.1627778 0.373573
+ 5.1630556 0.409338
+ 5.1633333 0.437024
+ 5.1636111 0.454565
+ 5.1638889 0.459895
+ 5.1641667 0.451645
+ 5.1644444 0.431227
+ 5.1647222 0.400753
+ 5.1650000 0.362332
+ 5.1652778 0.318075
+ 5.1655556 0.270091
+ 5.1658333 0.220491
+ 5.1661111 0.171386
+ 5.1663889 0.124884
+ 5.1666667 0.083097
+ 5.1669444 0.050000
+ 5.1672222 0.050000
+ 5.1675000 0.050000
+ 5.1677778 0.050000
+ 5.1680556 0.050000
+ 5.1683333 0.050000
+ 5.1686111 0.050000
+ 5.1688889 0.050000
+ 5.1691667 0.050000
+ 5.1694444 0.064884
+ 5.1697222 0.106588
+ 5.1700000 0.154336
+ 5.1702778 0.205676
+ 5.1705556 0.258157
+ 5.1708333 0.309327
+ 5.1711111 0.356736
+ 5.1713889 0.397933
+ 5.1716667 0.430467
+ 5.1719444 0.451885
+ 5.1722222 0.459738
+ 5.1725000 0.452382
+ 5.1727778 0.431398
+ 5.1730556 0.399176
+ 5.1733333 0.358105
+ 5.1736111 0.310575
+ 5.1738889 0.258976
+ 5.1741667 0.205696
+ 5.1744444 0.153125
+ 5.1747222 0.103652
+ 5.1750000 0.059667
+ 5.1752778 0.050000
+ 5.1755556 0.050000
+ 5.1758333 0.050000
+ 5.1761111 0.050000
+ 5.1763889 0.050000
+ 5.1766667 0.050000
+ 5.1769444 0.050000
+ 5.1772222 0.050000
+ 5.1775000 0.050000
+ 5.1777778 0.054776
+ 5.1780556 0.098518
+ 5.1783333 0.148040
+ 5.1786111 0.200905
+ 5.1788889 0.254675
+ 5.1791667 0.306911
+ 5.1794444 0.355174
+ 5.1797222 0.397027
+ 5.1800000 0.430031
+ 5.1802778 0.451748
+ 5.1805556 0.459738
+ 5.1808333 0.452373
+ 5.1811111 0.431254
+ 5.1813889 0.398790
+ 5.1816667 0.357392
+ 5.1819444 0.309468
+ 5.1822222 0.257429
+ 5.1825000 0.203685
+ 5.1827778 0.150646
+ 5.1830556 0.100721
+ 5.1833333 0.056319
+ 5.1836111 0.050000
+ 5.1838889 0.050000
+ 5.1841667 0.050000
+ 5.1844444 0.050000
+ 5.1847222 0.050000
+ 5.1850000 0.050000
+ 5.1852778 0.050000
+ 5.1855556 0.050000
+ 5.1858333 0.050000
+ 5.1861111 0.050000
+ 5.1863889 0.093831
+ 5.1866667 0.143492
+ 5.1869444 0.196558
+ 5.1872222 0.250606
+ 5.1875000 0.303209
+ 5.1877778 0.351945
+ 5.1880556 0.394388
+ 5.1883333 0.428113
+ 5.1886111 0.450696
+ 5.1888889 0.459712
+ 5.1891667 0.453533
+ 5.1894444 0.433715
+ 5.1897222 0.402608
+ 5.1900000 0.362566
+ 5.1902778 0.315940
+ 5.1905556 0.265081
+ 5.1908333 0.212342
+ 5.1911111 0.160075
+ 5.1913889 0.110630
+ 5.1916667 0.066361
+ 5.1919444 0.050000
+ 5.1922222 0.050000
+ 5.1925000 0.050000
+ 5.1927778 0.050000
+ 5.1930556 0.050000
+ 5.1933333 0.050000
+ 5.1936111 0.050000
+ 5.1938889 0.050000
+ 5.1941667 0.050000
+ 5.1944444 0.050000
+ 5.1947222 0.093096
+ 5.1950000 0.142247
+ 5.1952778 0.195005
+ 5.1955556 0.248922
+ 5.1958333 0.301549
+ 5.1961111 0.350439
+ 5.1963889 0.393143
+ 5.1966667 0.427214
+ 5.1969444 0.450202
+ 5.1972222 0.459660
+ 5.1975000 0.453938
+ 5.1977778 0.434579
+ 5.1980556 0.403924
+ 5.1983333 0.364314
+ 5.1986111 0.318091
+ 5.1988889 0.267595
+ 5.1991667 0.215168
+ 5.1994444 0.163150
+ 5.1997222 0.113883
+ 5.2000000 0.069708
+ 5.2002778 0.050000
+ 5.2005556 0.050000
+ 5.2008333 0.050000
+ 5.2011111 0.050000
+ 5.2013889 0.050000
+ 5.2016667 0.050000
+ 5.2019444 0.050000
+ 5.2022222 0.050000
+ 5.2025000 0.050000
+ 5.2027778 0.051495
+ 5.2030556 0.094427
+ 5.2033333 0.143449
+ 5.2036111 0.196101
+ 5.2038889 0.249924
+ 5.2041667 0.302458
+ 5.2044444 0.351243
+ 5.2047222 0.393820
+ 5.2050000 0.427728
+ 5.2052778 0.450507
+ 5.2055556 0.459699
+ 5.2058333 0.453647
+ 5.2061111 0.433906
+ 5.2063889 0.402837
+ 5.2066667 0.362799
+ 5.2069444 0.316151
+ 5.2072222 0.265254
+ 5.2075000 0.212467
+ 5.2077778 0.160149
+ 5.2080556 0.110661
+ 5.2083333 0.066361
+ 5.2086111 0.050000
+ 5.2088889 0.050000
+ 5.2091667 0.050000
+ 5.2094444 0.050000
+ 5.2097222 0.050000
+ 5.2100000 0.050000
+ 5.2102778 0.050000
+ 5.2105556 0.050000
+ 5.2108333 0.050000
+ 5.2111111 0.050000
+ 5.2113889 0.093018
+ 5.2116667 0.142075
+ 5.2119444 0.194734
+ 5.2122222 0.248562
+ 5.2125000 0.301123
+ 5.2127778 0.349982
+ 5.2130556 0.392704
+ 5.2133333 0.426854
+ 5.2136111 0.449997
+ 5.2138889 0.459699
+ 5.2141667 0.454316
+ 5.2144444 0.435368
+ 5.2147222 0.405170
+ 5.2150000 0.366035
+ 5.2152778 0.320274
+ 5.2155556 0.270202
+ 5.2158333 0.218131
+ 5.2161111 0.166374
+ 5.2163889 0.117245
+ 5.2166667 0.073055
+ 5.2169444 0.050000
+ 5.2172222 0.050000
+ 5.2175000 0.050000
+ 5.2177778 0.050000
+ 5.2180556 0.050000
+ 5.2183333 0.050000
+ 5.2186111 0.050000
+ 5.2188889 0.050000
+ 5.2191667 0.050000
+ 5.2194444 0.050000
+ 5.2197222 0.092642
+ 5.2200000 0.141495
+ 5.2202778 0.194089
+ 5.2205556 0.247957
+ 5.2208333 0.300630
+ 5.2211111 0.349639
+ 5.2213889 0.392515
+ 5.2216667 0.426789
+ 5.2219444 0.449994
+ 5.2222222 0.459660
+ 5.2225000 0.454120
+ 5.2227778 0.434911
+ 5.2230556 0.404370
+ 5.2233333 0.364837
+ 5.2236111 0.318648
+ 5.2238889 0.268142
+ 5.2241667 0.215657
+ 5.2244444 0.163531
+ 5.2247222 0.114102
+ 5.2250000 0.069708
+ 5.2252778 0.050000
+ 5.2255556 0.050000
+ 5.2258333 0.050000
+ 5.2261111 0.050000
+ 5.2263889 0.050000
+ 5.2266667 0.050000
+ 5.2269444 0.050000
+ 5.2272222 0.050000
+ 5.2275000 0.050000
+ 5.2277778 0.050000
+ 5.2280556 0.093361
+ 5.2283333 0.142926
+ 5.2286111 0.196169
+ 5.2288889 0.250564
+ 5.2291667 0.303585
+ 5.2294444 0.352706
+ 5.2297222 0.395401
+ 5.2300000 0.429145
+ 5.2302778 0.451411
+ 5.2305556 0.459673
+ 5.2308333 0.452239
+ 5.2311111 0.430752
+ 5.2313889 0.397686
+ 5.2316667 0.355518
+ 5.2319444 0.306723
+ 5.2322222 0.253777
+ 5.2325000 0.199156
+ 5.2327778 0.145336
+ 5.2330556 0.094792
+ 5.2333333 0.050000
+ 5.2336111 0.050000
+ 5.2338889 0.050000
+ 5.2341667 0.050000
+ 5.2344444 0.050000
+ 5.2347222 0.050000
+ 5.2350000 0.050000
+ 5.2352778 0.050000
+ 5.2355556 0.050000
+ 5.2358333 0.050000
+ 5.2361111 0.050000
+ 5.2363889 0.094731
+ 5.2366667 0.145195
+ 5.2369444 0.198927
+ 5.2372222 0.253460
+ 5.2375000 0.306329
+ 5.2377778 0.355069
+ 5.2380556 0.397212
+ 5.2383333 0.430294
+ 5.2386111 0.451850
+ 5.2388889 0.459412
+ 5.2391667 0.451342
+ 5.2394444 0.429310
+ 5.2397222 0.395813
+ 5.2400000 0.353347
+ 5.2402778 0.304407
+ 5.2405556 0.251492
+ 5.2408333 0.197097
+ 5.2411111 0.143719
+ 5.2413889 0.093855
+ 5.2416667 0.050000
+ 5.2419444 0.050000
+ 5.2422222 0.050000
+ 5.2425000 0.050000
+ 5.2427778 0.050000
+ 5.2430556 0.050000
+ 5.2433333 0.050000
+ 5.2436111 0.050000
+ 5.2438889 0.050000
+ 5.2441667 0.050000
+ 5.2444444 0.050000
+ 5.2447222 0.090686
+ 5.2450000 0.136476
+ 5.2452778 0.185476
+ 5.2455556 0.235792
+ 5.2458333 0.285530
+ 5.2461111 0.332796
+ 5.2463889 0.375697
+ 5.2466667 0.412339
+ 5.2469444 0.440827
+ 5.2472222 0.459268
+ 5.2475000 0.466337
+ 5.2477778 0.462988
+ 5.2480556 0.450741
+ 5.2483333 0.431120
+ 5.2486111 0.405647
+ 5.2488889 0.375843
+ 5.2491667 0.343230
+ 5.2494444 0.309332
+ 5.2497222 0.275669
+ 5.2500000 0.243764
+ 5.2502778 0.214946
+ 5.2505556 0.189769
+ 5.2508333 0.168594
+ 5.2511111 0.151784
+ 5.2513889 0.139699
+ 5.2516667 0.132701
+ 5.2519444 0.131151
+ 5.2522222 0.135411
+ 5.2525000 0.145841
+ 5.2527778 0.162803
+ 5.2530556 0.186402
+ 5.2533333 0.215713
+ 5.2536111 0.249556
+ 5.2538889 0.286749
+ 5.2541667 0.326113
+ 5.2544444 0.366467
+ 5.2547222 0.406629
+ 5.2550000 0.445418
+ 5.2552778 0.481655
+ 5.2555556 0.514157
+ 5.2558333 0.541856
+ 5.2561111 0.564125
+ 5.2563889 0.580449
+ 5.2566667 0.590312
+ 5.2569444 0.593201
+ 5.2572222 0.588599
+ 5.2575000 0.575992
+ 5.2577778 0.554864
+ 5.2580556 0.524701
+ 5.2583333 0.484987
+ 5.2586111 0.435807
+ 5.2588889 0.379651
+ 5.2591667 0.319609
+ 5.2594444 0.258769
+ 5.2597222 0.200221
+ 5.2600000 0.147055
+ 5.2602778 0.102361
+ 5.2605556 0.069227
+ 5.2608333 0.050743
+ 5.2611111 0.050000
+ 5.2613889 0.068904
+ 5.2616667 0.104638
+ 5.2619444 0.153201
+ 5.2622222 0.210594
+ 5.2625000 0.272815
+ 5.2627778 0.335865
+ 5.2630556 0.395744
+ 5.2633333 0.448452
+ 5.2636111 0.489989
+ 5.2638889 0.516354
+ 5.2641667 0.524786
+ 5.2644444 0.517478
+ 5.2647222 0.497864
+ 5.2650000 0.469373
+ 5.2652778 0.435439
+ 5.2655556 0.399493
+ 5.2658333 0.364968
+ 5.2661111 0.335296
+ 5.2663889 0.313908
+ 5.2666667 0.304236
+ 5.2669444 0.308720
+ 5.2672222 0.325827
+ 5.2675000 0.353030
+ 5.2677778 0.387803
+ 5.2680556 0.427620
+ 5.2683333 0.469956
+ 5.2686111 0.512284
+ 5.2688889 0.552078
+ 5.2691667 0.586811
+ 5.2694444 0.613959
+ 5.2697222 0.631544
+ 5.2700000 0.639780
+ 5.2702778 0.639435
+ 5.2705556 0.631272
+ 5.2708333 0.616056
+ 5.2711111 0.594552
+ 5.2713889 0.567525
+ 5.2716667 0.535740
+ 5.2719444 0.499962
+ 5.2722222 0.460954
+ 5.2725000 0.419472
+ 5.2727778 0.376221
+ 5.2730556 0.331898
+ 5.2733333 0.287196
+ 5.2736111 0.242813
+ 5.2738889 0.199442
+ 5.2741667 0.157780
+ 5.2744444 0.118523
+ 5.2747222 0.082364
+ 5.2750000 0.050000
+ 5.2752778 0.050000
+ 5.2755556 0.050000
+ 5.2758333 0.050000
+ 5.2761111 0.050000
+ 5.2763889 0.050000
+ 5.2766667 0.050000
+ 5.2769444 0.050000
+ 5.2772222 0.050000
+ 5.2775000 0.050000
+ 5.2777778 0.050000
+ 5.2780556 0.092171
+ 5.2783333 0.140929
+ 5.2786111 0.193702
+ 5.2788889 0.247917
+ 5.2791667 0.301001
+ 5.2794444 0.350381
+ 5.2797222 0.393484
+ 5.2800000 0.427736
+ 5.2802778 0.450565
+ 5.2805556 0.459399
+ 5.2808333 0.452504
+ 5.2811111 0.431514
+ 5.2813889 0.398901
+ 5.2816667 0.357140
+ 5.2819444 0.308705
+ 5.2822222 0.256067
+ 5.2825000 0.201702
+ 5.2827778 0.148082
+ 5.2830556 0.097681
+ 5.2833333 0.052972
+ 5.2836111 0.050000
+ 5.2838889 0.050000
+ 5.2841667 0.050000
+ 5.2844444 0.050000
+ 5.2847222 0.050000
+ 5.2850000 0.050000
+ 5.2852778 0.050000
+ 5.2855556 0.050000
+ 5.2858333 0.050000
+ 5.2861111 0.050000
+ 5.2863889 0.094011
+ 5.2866667 0.143737
+ 5.2869444 0.196780
+ 5.2872222 0.250743
+ 5.2875000 0.303228
+ 5.2877778 0.351839
+ 5.2880556 0.394177
+ 5.2883333 0.427845
+ 5.2886111 0.450446
+ 5.2888889 0.459582
+ 5.2891667 0.453642
+ 5.2894444 0.434162
+ 5.2897222 0.403467
+ 5.2900000 0.363880
+ 5.2902778 0.317722
+ 5.2905556 0.267319
+ 5.2908333 0.214993
+ 5.2911111 0.163066
+ 5.2913889 0.113864
+ 5.2916667 0.069708
+ 5.2919444 0.050000
+ 5.2922222 0.050000
+ 5.2925000 0.050000
+ 5.2927778 0.050000
+ 5.2930556 0.050000
+ 5.2933333 0.050000
+ 5.2936111 0.050000
+ 5.2938889 0.050000
+ 5.2941667 0.050000
+ 5.2944444 0.050000
+ 5.2947222 0.092839
+ 5.2950000 0.141814
+ 5.2952778 0.194465
+ 5.2955556 0.248336
+ 5.2958333 0.300970
+ 5.2961111 0.349909
+ 5.2963889 0.392696
+ 5.2966667 0.426873
+ 5.2969444 0.449983
+ 5.2972222 0.459569
+ 5.2975000 0.453971
+ 5.2977778 0.434727
+ 5.2980556 0.404171
+ 5.2983333 0.364638
+ 5.2986111 0.318465
+ 5.2988889 0.267985
+ 5.2991667 0.215535
+ 5.2994444 0.163448
+ 5.2997222 0.114061
+ 5.3000000 0.069708
+ 5.3002778 0.050000
+ 5.3005556 0.050000
+ 5.3008333 0.050000
+ 5.3011111 0.050000
+ 5.3013889 0.050000
+ 5.3016667 0.050000
+ 5.3019444 0.050000
+ 5.3022222 0.050000
+ 5.3025000 0.050000
+ 5.3027778 0.050000
+ 5.3030556 0.093290
+ 5.3033333 0.142776
+ 5.3036111 0.195940
+ 5.3038889 0.250265
+ 5.3041667 0.303233
+ 5.3044444 0.352329
+ 5.3047222 0.395034
+ 5.3050000 0.428831
+ 5.3052778 0.451203
+ 5.3055556 0.459634
+ 5.3058333 0.452435
+ 5.3061111 0.431237
+ 5.3063889 0.398501
+ 5.3066667 0.356688
+ 5.3069444 0.308258
+ 5.3072222 0.255671
+ 5.3075000 0.201389
+ 5.3077778 0.147871
+ 5.3080556 0.097579
+ 5.3083333 0.052972
+ 5.3086111 0.050000
+ 5.3088889 0.050000
+ 5.3091667 0.050000
+ 5.3094444 0.050000
+ 5.3097222 0.050000
+ 5.3100000 0.050000
+ 5.3102778 0.050000
+ 5.3105556 0.050000
+ 5.3108333 0.050000
+ 5.3111111 0.050000
+ 5.3113889 0.093913
+ 5.3116667 0.143535
+ 5.3119444 0.196479
+ 5.3122222 0.250358
+ 5.3125000 0.302785
+ 5.3127778 0.351375
+ 5.3130556 0.393740
+ 5.3133333 0.427493
+ 5.3136111 0.450249
+ 5.3138889 0.459621
+ 5.3141667 0.454002
+ 5.3144444 0.434912
+ 5.3147222 0.404648
+ 5.3150000 0.365509
+ 5.3152778 0.319796
+ 5.3155556 0.269805
+ 5.3158333 0.217837
+ 5.3161111 0.166190
+ 5.3163889 0.117163
+ 5.3166667 0.073055
+ 5.3169444 0.050000
+ 5.3172222 0.050000
+ 5.3175000 0.050000
+ 5.3177778 0.050000
+ 5.3180556 0.050000
+ 5.3183333 0.050000
+ 5.3186111 0.050000
+ 5.3188889 0.050000
+ 5.3191667 0.050000
+ 5.3194444 0.050000
+ 5.3197222 0.092700
+ 5.3200000 0.141629
+ 5.3202778 0.194305
+ 5.3205556 0.248247
+ 5.3208333 0.300974
+ 5.3211111 0.350004
+ 5.3213889 0.392856
+ 5.3216667 0.427049
+ 5.3219444 0.450100
+ 5.3222222 0.459529
+ 5.3225000 0.453662
+ 5.3227778 0.434057
+ 5.3230556 0.403076
+ 5.3233333 0.363086
+ 5.3236111 0.316451
+ 5.3238889 0.265535
+ 5.3241667 0.212704
+ 5.3244444 0.160321
+ 5.3247222 0.110752
+ 5.3250000 0.066361
+ 5.3252778 0.050000
+ 5.3255556 0.050000
+ 5.3258333 0.050000
+ 5.3261111 0.050000
+ 5.3263889 0.050000
+ 5.3266667 0.050000
+ 5.3269444 0.050000
+ 5.3272222 0.050000
+ 5.3275000 0.050000
+ 5.3277778 0.050000
+ 5.3280556 0.093264
+ 5.3283333 0.142600
+ 5.3286111 0.195539
+ 5.3288889 0.249611
+ 5.3291667 0.302348
+ 5.3294444 0.351280
+ 5.3297222 0.393939
+ 5.3300000 0.427854
+ 5.3302778 0.450558
+ 5.3305556 0.459582
+ 5.3308333 0.453264
+ 5.3311111 0.433179
+ 5.3313889 0.401713
+ 5.3316667 0.361249
+ 5.3319444 0.314171
+ 5.3322222 0.262863
+ 5.3325000 0.209710
+ 5.3327778 0.157094
+ 5.3330556 0.107401
+ 5.3333333 0.063014
+ 5.3336111 0.050000
+ 5.3338889 0.050000
+ 5.3341667 0.050000
+ 5.3344444 0.050000
+ 5.3347222 0.050000
+ 5.3350000 0.050000
+ 5.3352778 0.050000
+ 5.3355556 0.050000
+ 5.3358333 0.050000
+ 5.3361111 0.050000
+ 5.3363889 0.093318
+ 5.3366667 0.142605
+ 5.3369444 0.195424
+ 5.3372222 0.249341
+ 5.3375000 0.301923
+ 5.3377778 0.350734
+ 5.3380556 0.393340
+ 5.3383333 0.427306
+ 5.3386111 0.450198
+ 5.3388889 0.459582
+ 5.3391667 0.453816
+ 5.3394444 0.434442
+ 5.3397222 0.403795
+ 5.3400000 0.364208
+ 5.3402778 0.318016
+ 5.3405556 0.267555
+ 5.3408333 0.215159
+ 5.3411111 0.163163
+ 5.3413889 0.113901
+ 5.3416667 0.069708
+ 5.3419444 0.050000
+ 5.3422222 0.050000
+ 5.3425000 0.050000
+ 5.3427778 0.050000
+ 5.3430556 0.050000
+ 5.3433333 0.050000
+ 5.3436111 0.050000
+ 5.3438889 0.050000
+ 5.3441667 0.050000
+ 5.3444444 0.050000
+ 5.3447222 0.092690
+ 5.3450000 0.141484
+ 5.3452778 0.193948
+ 5.3455556 0.247648
+ 5.3458333 0.300152
+ 5.3461111 0.349025
+ 5.3463889 0.391834
+ 5.3466667 0.426146
+ 5.3469444 0.449527
+ 5.3472222 0.459542
+ 5.3475000 0.454547
+ 5.3477778 0.436043
+ 5.3480556 0.406319
+ 5.3483333 0.367665
+ 5.3486111 0.322369
+ 5.3488889 0.272722
+ 5.3491667 0.221013
+ 5.3494444 0.169530
+ 5.3497222 0.120564
+ 5.3500000 0.076403
+ 5.3502778 0.050000
+ 5.3505556 0.050000
+ 5.3508333 0.050000
+ 5.3511111 0.050000
+ 5.3513889 0.050000
+ 5.3516667 0.050000
+ 5.3519444 0.050000
+ 5.3522222 0.050000
+ 5.3525000 0.050000
+ 5.3527778 0.050000
+ 5.3530556 0.092590
+ 5.3533333 0.141497
+ 5.3536111 0.194218
+ 5.3538889 0.248246
+ 5.3541667 0.301076
+ 5.3544444 0.350204
+ 5.3547222 0.393124
+ 5.3550000 0.427330
+ 5.3552778 0.450318
+ 5.3555556 0.459582
+ 5.3558333 0.453433
+ 5.3561111 0.433451
+ 5.3563889 0.402031
+ 5.3566667 0.361567
+ 5.3569444 0.314456
+ 5.3572222 0.263091
+ 5.3575000 0.209870
+ 5.3577778 0.157186
+ 5.3580556 0.107436
+ 5.3583333 0.063014
+ 5.3586111 0.050000
+ 5.3588889 0.050000
+ 5.3591667 0.050000
+ 5.3594444 0.050000
+ 5.3597222 0.050000
+ 5.3600000 0.050000
+ 5.3602778 0.050000
+ 5.3605556 0.050000
+ 5.3608333 0.050000
+ 5.3611111 0.050000
+ 5.3613889 0.093167
+ 5.3616667 0.142272
+ 5.3619444 0.194903
+ 5.3622222 0.248650
+ 5.3625000 0.301103
+ 5.3627778 0.349851
+ 5.3630556 0.392485
+ 5.3633333 0.426594
+ 5.3636111 0.449767
+ 5.3638889 0.459595
+ 5.3641667 0.454449
+ 5.3644444 0.435834
+ 5.3647222 0.406036
+ 5.3650000 0.367341
+ 5.3652778 0.322037
+ 5.3655556 0.272410
+ 5.3658333 0.220746
+ 5.3661111 0.169333
+ 5.3663889 0.120456
+ 5.3666667 0.076403
+ 5.3669444 0.050000
+ 5.3672222 0.050000
+ 5.3675000 0.050000
+ 5.3677778 0.050000
+ 5.3680556 0.050000
+ 5.3683333 0.050000
+ 5.3686111 0.050000
+ 5.3688889 0.050000
+ 5.3691667 0.050000
+ 5.3694444 0.050000
+ 5.3697222 0.092241
+ 5.3700000 0.140749
+ 5.3702778 0.193066
+ 5.3705556 0.246735
+ 5.3708333 0.299299
+ 5.3711111 0.348301
+ 5.3713889 0.391284
+ 5.3716667 0.425790
+ 5.3719444 0.449361
+ 5.3722222 0.459542
+ 5.3725000 0.454667
+ 5.3727778 0.436239
+ 5.3730556 0.406555
+ 5.3733333 0.367909
+ 5.3736111 0.322597
+ 5.3738889 0.272915
+ 5.3741667 0.221159
+ 5.3744444 0.169625
+ 5.3747222 0.120607
+ 5.3750000 0.076403
+ 5.3752778 0.050000
+ 5.3755556 0.050000
+ 5.3758333 0.050000
+ 5.3761111 0.050000
+ 5.3763889 0.050000
+ 5.3766667 0.050000
+ 5.3769444 0.050000
+ 5.3772222 0.050000
+ 5.3775000 0.050000
+ 5.3777778 0.050000
+ 5.3780556 0.092596
+ 5.3783333 0.141507
+ 5.3786111 0.194228
+ 5.3788889 0.248255
+ 5.3791667 0.301085
+ 5.3794444 0.350211
+ 5.3797222 0.393131
+ 5.3800000 0.427340
+ 5.3802778 0.450334
+ 5.3805556 0.459608
+ 5.3808333 0.453474
+ 5.3811111 0.433509
+ 5.3813889 0.402106
+ 5.3816667 0.361657
+ 5.3819444 0.314556
+ 5.3822222 0.263195
+ 5.3825000 0.209968
+ 5.3827778 0.157267
+ 5.3830556 0.107484
+ 5.3833333 0.063014
+ 5.3836111 0.050000
+ 5.3838889 0.050000
+ 5.3841667 0.050000
+ 5.3844444 0.050000
+ 5.3847222 0.050000
+ 5.3850000 0.050000
+ 5.3852778 0.050000
+ 5.3855556 0.050000
+ 5.3858333 0.050000
+ 5.3861111 0.050000
+ 5.3863889 0.093409
+ 5.3866667 0.142792
+ 5.3869444 0.195706
+ 5.3872222 0.249704
+ 5.3875000 0.302343
+ 5.3877778 0.351177
+ 5.3880556 0.393762
+ 5.3883333 0.427652
+ 5.3886111 0.450402
+ 5.3888889 0.459569
+ 5.3891667 0.453505
+ 5.3894444 0.433769
+ 5.3897222 0.402715
+ 5.3900000 0.362700
+ 5.3902778 0.316080
+ 5.3905556 0.265211
+ 5.3908333 0.212448
+ 5.3911111 0.160148
+ 5.3913889 0.110667
+ 5.3916667 0.066361
+ 5.3919444 0.050000
+ 5.3922222 0.050000
+ 5.3925000 0.050000
+ 5.3927778 0.050000
+ 5.3930556 0.050000
+ 5.3933333 0.050000
+ 5.3936111 0.050000
+ 5.3938889 0.050000
+ 5.3941667 0.050000
+ 5.3944444 0.050000
+ 5.3947222 0.093153
+ 5.3950000 0.142367
+ 5.3952778 0.195185
+ 5.3955556 0.249152
+ 5.3958333 0.301810
+ 5.3961111 0.350704
+ 5.3963889 0.393378
+ 5.3966667 0.427376
+ 5.3969444 0.450240
+ 5.3972222 0.459516
+ 5.3975000 0.453549
+ 5.3977778 0.433891
+ 5.3980556 0.402898
+ 5.3983333 0.362925
+ 5.3986111 0.316325
+ 5.3988889 0.265455
+ 5.3991667 0.212669
+ 5.3994444 0.160321
+ 5.3997222 0.110767
+ 5.4000000 0.066361
+ 5.4002778 0.050000
+ 5.4005556 0.050000
+ 5.4008333 0.050000
+ 5.4011111 0.050000
+ 5.4013889 0.050000
+ 5.4016667 0.050000
+ 5.4019444 0.050000
+ 5.4022222 0.050000
+ 5.4025000 0.050000
+ 5.4027778 0.050000
+ 5.4030556 0.093570
+ 5.4033333 0.143266
+ 5.4036111 0.196573
+ 5.4038889 0.250975
+ 5.4041667 0.303958
+ 5.4044444 0.353007
+ 5.4047222 0.395607
+ 5.4050000 0.429244
+ 5.4052778 0.451403
+ 5.4055556 0.459569
+ 5.4058333 0.452058
+ 5.4061111 0.430515
+ 5.4063889 0.397414
+ 5.4066667 0.355230
+ 5.4069444 0.306439
+ 5.4072222 0.253516
+ 5.4075000 0.198935
+ 5.4077778 0.145172
+ 5.4080556 0.094702
+ 5.4083333 0.050000
+ 5.4086111 0.050000
+ 5.4088889 0.050000
+ 5.4091667 0.050000
+ 5.4094444 0.050000
+ 5.4097222 0.050000
+ 5.4100000 0.050000
+ 5.4102778 0.050000
+ 5.4105556 0.050000
+ 5.4108333 0.050000
+ 5.4111111 0.050000
+ 5.4113889 0.094423
+ 5.4116667 0.144533
+ 5.4119444 0.197910
+ 5.4122222 0.252130
+ 5.4125000 0.304773
+ 5.4127778 0.353415
+ 5.4130556 0.395635
+ 5.4133333 0.429011
+ 5.4136111 0.451121
+ 5.4138889 0.459542
+ 5.4141667 0.452656
+ 5.4144444 0.432046
+ 5.4147222 0.400102
+ 5.4150000 0.359210
+ 5.4152778 0.311758
+ 5.4155556 0.260134
+ 5.4158333 0.206725
+ 5.4161111 0.153920
+ 5.4163889 0.104104
+ 5.4166667 0.059667
+ 5.4169444 0.050000
+ 5.4172222 0.050000
+ 5.4175000 0.050000
+ 5.4177778 0.050000
+ 5.4180556 0.050000
+ 5.4183333 0.050000
+ 5.4186111 0.050000
+ 5.4188889 0.050000
+ 5.4191667 0.050000
+ 5.4194444 0.050000
+ 5.4197222 0.093993
+ 5.4200000 0.143954
+ 5.4202778 0.197394
+ 5.4205556 0.251819
+ 5.4208333 0.304739
+ 5.4211111 0.353662
+ 5.4213889 0.396097
+ 5.4216667 0.429551
+ 5.4219444 0.451535
+ 5.4222222 0.459555
+ 5.4225000 0.451948
+ 5.4227778 0.430353
+ 5.4230556 0.397236
+ 5.4233333 0.355064
+ 5.4236111 0.306304
+ 5.4238889 0.253422
+ 5.4241667 0.198884
+ 5.4244444 0.145157
+ 5.4247222 0.094706
+ 5.4250000 0.050000
+ 5.4252778 0.050000
+ 5.4255556 0.050000
+ 5.4258333 0.050000
+ 5.4261111 0.050000
+ 5.4263889 0.050000
+ 5.4266667 0.050000
+ 5.4269444 0.050000
+ 5.4272222 0.050000
+ 5.4275000 0.050000
+ 5.4277778 0.050000
+ 5.4280556 0.094659
+ 5.4283333 0.145048
+ 5.4286111 0.198711
+ 5.4288889 0.253189
+ 5.4291667 0.306027
+ 5.4294444 0.354767
+ 5.4297222 0.396952
+ 5.4300000 0.430125
+ 5.4302778 0.451830
+ 5.4305556 0.459608
+ 5.4308333 0.451822
+ 5.4311111 0.430110
+ 5.4313889 0.396931
+ 5.4316667 0.354741
+ 5.4319444 0.305998
+ 5.4322222 0.253159
+ 5.4325000 0.198682
+ 5.4327778 0.145025
+ 5.4330556 0.094645
+ 5.4333333 0.050000
+ 5.4336111 0.050000
+ 5.4338889 0.050000
+ 5.4341667 0.050000
+ 5.4344444 0.050000
+ 5.4347222 0.050000
+ 5.4350000 0.050000
+ 5.4352778 0.050000
+ 5.4355556 0.050000
+ 5.4358333 0.050000
+ 5.4361111 0.050000
+ 5.4363889 0.094644
+ 5.4366667 0.145021
+ 5.4369444 0.198675
+ 5.4372222 0.253147
+ 5.4375000 0.305982
+ 5.4377778 0.354720
+ 5.4380556 0.396905
+ 5.4383333 0.430080
+ 5.4386111 0.451787
+ 5.4388889 0.459569
+ 5.4391667 0.451786
+ 5.4394444 0.430079
+ 5.4397222 0.396903
+ 5.4400000 0.354718
+ 5.4402778 0.305979
+ 5.4405556 0.253144
+ 5.4408333 0.198672
+ 5.4411111 0.145019
+ 5.4413889 0.094642
+ 5.4416667 0.050000
+ 5.4419444 0.050000
+ 5.4422222 0.050000
+ 5.4425000 0.050000
+ 5.4427778 0.050000
+ 5.4430556 0.050000
+ 5.4433333 0.050000
+ 5.4436111 0.050000
+ 5.4438889 0.050000
+ 5.4441667 0.050000
+ 5.4444444 0.050000
+ 5.4447222 0.094639
+ 5.4450000 0.145012
+ 5.4452778 0.198661
+ 5.4455556 0.253128
+ 5.4458333 0.305957
+ 5.4461111 0.354691
+ 5.4463889 0.396873
+ 5.4466667 0.430044
+ 5.4469444 0.451749
+ 5.4472222 0.459529
+ 5.4475000 0.451748
+ 5.4477778 0.430042
+ 5.4480556 0.396870
+ 5.4483333 0.354688
+ 5.4486111 0.305954
+ 5.4488889 0.253125
+ 5.4491667 0.198658
+ 5.4494444 0.145010
+ 5.4497222 0.094638
+ 5.4500000 0.050000
+ 5.4502778 0.050000
+ 5.4505556 0.050000
+ 5.4508333 0.050000
+ 5.4511111 0.050000
+ 5.4513889 0.050000
+ 5.4516667 0.050000
+ 5.4519444 0.050000
+ 5.4522222 0.050000
+ 5.4525000 0.050000
+ 5.4527778 0.050000
+ 5.4530556 0.094635
+ 5.4533333 0.145003
+ 5.4536111 0.198646
+ 5.4538889 0.253109
+ 5.4541667 0.305933
+ 5.4544444 0.354662
+ 5.4547222 0.396839
+ 5.4550000 0.430008
+ 5.4552778 0.451710
+ 5.4555556 0.459490
+ 5.4558333 0.451709
+ 5.4561111 0.430006
+ 5.4563889 0.396837
+ 5.4566667 0.354659
+ 5.4569444 0.305930
+ 5.4572222 0.253105
+ 5.4575000 0.198643
+ 5.4577778 0.145000
+ 5.4580556 0.094634
+ 5.4583333 0.050000
+ 5.4586111 0.050000
+ 5.4588889 0.050000
+ 5.4591667 0.050000
+ 5.4594444 0.050000
+ 5.4597222 0.050000
+ 5.4600000 0.050000
+ 5.4602778 0.050000
+ 5.4605556 0.050000
+ 5.4608333 0.050000
+ 5.4611111 0.050000
+ 5.4613889 0.094631
+ 5.4616667 0.144994
+ 5.4619444 0.198632
+ 5.4622222 0.253090
+ 5.4625000 0.305909
+ 5.4627778 0.354633
+ 5.4630556 0.396806
+ 5.4633333 0.429971
+ 5.4636111 0.451672
+ 5.4638889 0.459451
+ 5.4641667 0.451671
+ 5.4644444 0.429969
+ 5.4647222 0.396803
+ 5.4650000 0.354629
+ 5.4652778 0.305904
+ 5.4655556 0.253085
+ 5.4658333 0.198628
+ 5.4661111 0.144991
+ 5.4663889 0.094629
+ 5.4666667 0.050000
+ 5.4669444 0.050000
+ 5.4672222 0.050000
+ 5.4675000 0.050000
+ 5.4677778 0.050000
+ 5.4680556 0.050000
+ 5.4683333 0.050000
+ 5.4686111 0.050000
+ 5.4688889 0.050000
+ 5.4691667 0.050000
+ 5.4694444 0.050000
+ 5.4697222 0.094624
+ 5.4700000 0.144979
+ 5.4702778 0.198609
+ 5.4705556 0.253057
+ 5.4708333 0.305867
+ 5.4711111 0.354584
+ 5.4713889 0.396750
+ 5.4716667 0.429910
+ 5.4719444 0.451607
+ 5.4722222 0.459385
+ 5.4725000 0.451607
+ 5.4727778 0.429910
+ 5.4730556 0.396751
+ 5.4733333 0.354584
+ 5.4736111 0.305868
+ 5.4738889 0.253057
+ 5.4741667 0.198609
+ 5.4744444 0.144979
+ 5.4747222 0.094624
+ 5.4750000 0.050000
+ 5.4752778 0.050000
+ 5.4755556 0.050000
+ 5.4758333 0.050000
+ 5.4761111 0.050000
+ 5.4763889 0.050000
+ 5.4766667 0.050000
+ 5.4769444 0.050000
+ 5.4772222 0.050000
+ 5.4775000 0.050000
+ 5.4777778 0.050000
+ 5.4780556 0.094630
+ 5.4783333 0.144993
+ 5.4786111 0.198631
+ 5.4788889 0.253090
+ 5.4791667 0.305910
+ 5.4794444 0.354637
+ 5.4797222 0.396812
+ 5.4800000 0.429980
+ 5.4802778 0.451683
+ 5.4805556 0.459464
+ 5.4808333 0.451686
+ 5.4811111 0.429986
+ 5.4813889 0.396821
+ 5.4816667 0.354648
+ 5.4819444 0.305923
+ 5.4822222 0.253102
+ 5.4825000 0.198643
+ 5.4827778 0.145002
+ 5.4830556 0.094635
+ 5.4833333 0.050000
+ 5.4836111 0.050000
+ 5.4838889 0.050000
+ 5.4841667 0.050000
+ 5.4844444 0.050000
+ 5.4847222 0.050000
+ 5.4850000 0.050000
+ 5.4852778 0.050000
+ 5.4855556 0.050000
+ 5.4858333 0.050000
+ 5.4861111 0.050000
+ 5.4863889 0.094650
+ 5.4866667 0.145037
+ 5.4869444 0.198700
+ 5.4872222 0.253182
+ 5.4875000 0.306023
+ 5.4877778 0.354765
+ 5.4880556 0.396947
+ 5.4883333 0.430113
+ 5.4886111 0.451802
+ 5.4888889 0.459555
+ 5.4891667 0.451735
+ 5.4894444 0.429984
+ 5.4897222 0.396764
+ 5.4900000 0.354539
+ 5.4902778 0.305771
+ 5.4905556 0.252924
+ 5.4908333 0.198460
+ 5.4911111 0.144843
+ 5.4913889 0.094535
+ 5.4916667 0.050000
+ 5.4919444 0.050000
+ 5.4922222 0.050000
+ 5.4925000 0.050000
+ 5.4927778 0.050000
+ 5.4930556 0.050000
+ 5.4933333 0.050000
+ 5.4936111 0.050000
+ 5.4938889 0.050000
+ 5.4941667 0.050000
+ 5.4944444 0.050000
+ 5.4947222 0.094096
+ 5.4950000 0.143840
+ 5.4952778 0.196852
+ 5.4955556 0.250754
+ 5.4958333 0.303166
+ 5.4961111 0.351710
+ 5.4963889 0.394006
+ 5.4966667 0.427676
+ 5.4969444 0.450341
+ 5.4972222 0.459621
+ 5.4975000 0.453918
+ 5.4977778 0.434754
+ 5.4980556 0.404430
+ 5.4983333 0.365249
+ 5.4986111 0.319512
+ 5.4988889 0.269521
+ 5.4991667 0.217578
+ 5.4994444 0.165985
+ 5.4997222 0.117043
+ 5.5000000 0.073055
+ 5.5002778 0.050000
+ 5.5005556 0.050000
+ 5.5008333 0.050000
+ 5.5011111 0.050000
+ 5.5013889 0.050000
+ 5.5016667 0.050000
+ 5.5019444 0.050000
+ 5.5022222 0.050000
+ 5.5025000 0.050000
+ 5.5027778 0.050000
+ 5.5030556 0.092169
+ 5.5033333 0.140486
+ 5.5036111 0.192544
+ 5.5038889 0.245940
+ 5.5041667 0.298269
+ 5.5044444 0.347125
+ 5.5047222 0.390103
+ 5.5050000 0.424800
+ 5.5052778 0.448809
+ 5.5055556 0.459725
+ 5.5058333 0.455915
+ 5.5061111 0.438823
+ 5.5063889 0.410665
+ 5.5066667 0.373655
+ 5.5069444 0.330011
+ 5.5072222 0.281946
+ 5.5075000 0.231676
+ 5.5077778 0.181417
+ 5.5080556 0.133383
+ 5.5083333 0.089792
+ 5.5086111 0.052523
+ 5.5088889 0.050000
+ 5.5091667 0.050000
+ 5.5094444 0.050000
+ 5.5097222 0.050000
+ 5.5100000 0.050000
+ 5.5102778 0.050000
+ 5.5105556 0.050000
+ 5.5108333 0.050000
+ 5.5111111 0.051560
+ 5.5113889 0.092062
+ 5.5116667 0.138964
+ 5.5119444 0.189892
+ 5.5122222 0.242472
+ 5.5125000 0.294333
+ 5.5127778 0.343100
+ 5.5130556 0.386401
+ 5.5133333 0.421863
+ 5.5136111 0.447113
+ 5.5138889 0.459778
+ 5.5141667 0.458228
+ 5.5144444 0.443814
+ 5.5147222 0.418628
+ 5.5150000 0.384764
+ 5.5152778 0.344315
+ 5.5155556 0.299375
+ 5.5158333 0.252037
+ 5.5161111 0.204394
+ 5.5163889 0.158541
+ 5.5166667 0.116569
+ 5.5169444 0.080271
+ 5.5172222 0.050227
+ 5.5175000 0.050000
+ 5.5177778 0.050000
+ 5.5180556 0.050000
+ 5.5183333 0.050000
+ 5.5186111 0.050000
+ 5.5188889 0.050000
+ 5.5191667 0.050000
+ 5.5194444 0.068388
+ 5.5197222 0.106708
+ 5.5200000 0.151447
+ 5.5202778 0.200265
+ 5.5205556 0.250824
+ 5.5208333 0.300786
+ 5.5211111 0.347812
+ 5.5213889 0.389562
+ 5.5216667 0.423699
+ 5.5219444 0.447884
+ 5.5222222 0.459778
+ 5.5225000 0.457777
+ 5.5227778 0.443218
+ 5.5230556 0.418173
+ 5.5233333 0.384714
+ 5.5236111 0.344911
+ 5.5238889 0.300838
+ 5.5241667 0.254564
+ 5.5244444 0.208163
+ 5.5247222 0.163706
+ 5.5250000 0.123264
+ 5.5252778 0.088599
+ 5.5255556 0.060230
+ 5.5258333 0.050000
+ 5.5261111 0.050000
+ 5.5263889 0.050000
+ 5.5266667 0.050000
+ 5.5269444 0.050000
+ 5.5272222 0.050000
+ 5.5275000 0.055581
+ 5.5277778 0.085137
+ 5.5280556 0.122472
+ 5.5283333 0.165767
+ 5.5286111 0.212799
+ 5.5288889 0.261344
+ 5.5291667 0.309178
+ 5.5294444 0.354076
+ 5.5297222 0.393816
+ 5.5300000 0.426173
+ 5.5302778 0.448923
+ 5.5305556 0.459843
+ 5.5308333 0.457406
+ 5.5311111 0.442876
+ 5.5313889 0.418213
+ 5.5316667 0.385380
+ 5.5319444 0.346337
+ 5.5322222 0.303045
+ 5.5325000 0.257465
+ 5.5327778 0.211559
+ 5.5330556 0.167287
+ 5.5333333 0.126611
+ 5.5336111 0.091218
+ 5.5338889 0.061699
+ 5.5341667 0.050000
+ 5.5344444 0.050000
+ 5.5347222 0.050000
+ 5.5350000 0.050000
+ 5.5352778 0.050000
+ 5.5355556 0.050000
+ 5.5358333 0.050000
+ 5.5361111 0.075082
+ 5.5363889 0.112269
+ 5.5366667 0.155884
+ 5.5369444 0.203622
+ 5.5372222 0.253181
+ 5.5375000 0.302260
+ 5.5377778 0.348555
+ 5.5380556 0.389763
+ 5.5383333 0.423582
+ 5.5386111 0.447710
+ 5.5388889 0.459843
+ 5.5391667 0.458394
+ 5.5394444 0.444636
+ 5.5397222 0.420557
+ 5.5400000 0.388143
+ 5.5402778 0.349383
+ 5.5405556 0.306265
+ 5.5408333 0.260775
+ 5.5411111 0.214903
+ 5.5413889 0.170634
+ 5.5416667 0.129958
+ 5.5419444 0.094582
+ 5.5422222 0.065097
+ 5.5425000 0.050000
+ 5.5427778 0.050000
+ 5.5430556 0.050000
+ 5.5433333 0.050000
+ 5.5436111 0.050000
+ 5.5438889 0.050000
+ 5.5441667 0.050000
+ 5.5444444 0.078456
+ 5.5447222 0.115497
+ 5.5450000 0.158919
+ 5.5452778 0.206418
+ 5.5455556 0.255695
+ 5.5458333 0.304447
+ 5.5461111 0.350374
+ 5.5463889 0.391174
+ 5.5466667 0.424547
+ 5.5469444 0.448190
+ 5.5472222 0.459804
+ 5.5475000 0.457804
+ 5.5477778 0.443484
+ 5.5480556 0.418853
+ 5.5483333 0.385922
+ 5.5486111 0.346700
+ 5.5488889 0.303200
+ 5.5491667 0.257430
+ 5.5494444 0.211402
+ 5.5497222 0.167125
+ 5.5500000 0.126611
+ 5.5502778 0.091580
+ 5.5505556 0.062600
+ 5.5508333 0.050000
+ 5.5511111 0.050000
+ 5.5513889 0.050000
+ 5.5516667 0.050000
+ 5.5519444 0.050000
+ 5.5522222 0.050000
+ 5.5525000 0.052427
+ 5.5527778 0.081829
+ 5.5530556 0.119345
+ 5.5533333 0.163094
+ 5.5536111 0.210761
+ 5.5538889 0.260034
+ 5.5541667 0.308599
+ 5.5544444 0.354142
+ 5.5547222 0.394350
+ 5.5550000 0.426910
+ 5.5552778 0.449508
+ 5.5555556 0.459830
+ 5.5558333 0.456294
+ 5.5561111 0.440242
+ 5.5563889 0.413745
+ 5.5566667 0.378876
+ 5.5569444 0.337706
+ 5.5572222 0.292307
+ 5.5575000 0.244753
+ 5.5577778 0.197115
+ 5.5580556 0.151465
+ 5.5583333 0.109875
+ 5.5586111 0.074113
+ 5.5588889 0.050000
+ 5.5591667 0.050000
+ 5.5594444 0.050000
+ 5.5597222 0.050000
+ 5.5600000 0.050000
+ 5.5602778 0.050000
+ 5.5605556 0.050000
+ 5.5608333 0.050000
+ 5.5611111 0.068348
+ 5.5613889 0.106866
+ 5.5616667 0.151651
+ 5.5619444 0.200405
+ 5.5622222 0.250831
+ 5.5625000 0.300631
+ 5.5627778 0.347507
+ 5.5630556 0.389161
+ 5.5633333 0.423296
+ 5.5636111 0.447614
+ 5.5638889 0.459817
+ 5.5641667 0.458320
+ 5.5644444 0.444393
+ 5.5647222 0.420016
+ 5.5650000 0.387172
+ 5.5652778 0.347842
+ 5.5655556 0.304008
+ 5.5658333 0.257651
+ 5.5661111 0.210754
+ 5.5663889 0.165297
+ 5.5666667 0.123264
+ 5.5669444 0.086369
+ 5.5672222 0.055268
+ 5.5675000 0.050000
+ 5.5677778 0.050000
+ 5.5680556 0.050000
+ 5.5683333 0.050000
+ 5.5686111 0.050000
+ 5.5688889 0.050000
+ 5.5691667 0.050000
+ 5.5694444 0.061693
+ 5.5697222 0.099765
+ 5.5700000 0.144702
+ 5.5702778 0.194073
+ 5.5705556 0.245449
+ 5.5708333 0.296400
+ 5.5711111 0.344498
+ 5.5713889 0.387311
+ 5.5716667 0.422411
+ 5.5719444 0.447368
+ 5.5722222 0.459752
+ 5.5725000 0.457892
+ 5.5727778 0.443155
+ 5.5730556 0.417664
+ 5.5733333 0.383543
+ 5.5736111 0.342918
+ 5.5738889 0.297912
+ 5.5741667 0.250650
+ 5.5744444 0.203255
+ 5.5747222 0.157854
+ 5.5750000 0.116569
+ 5.5752778 0.081207
+ 5.5755556 0.052296
+ 5.5758333 0.050000
+ 5.5761111 0.050000
+ 5.5763889 0.050000
+ 5.5766667 0.050000
+ 5.5769444 0.050000
+ 5.5772222 0.050000
+ 5.5775000 0.050000
+ 5.5777778 0.078429
+ 5.5780556 0.116608
+ 5.5783333 0.160849
+ 5.5786111 0.208876
+ 5.5788889 0.258412
+ 5.5791667 0.307181
+ 5.5794444 0.352905
+ 5.5797222 0.393308
+ 5.5800000 0.426112
+ 5.5802778 0.449040
+ 5.5805556 0.459817
+ 5.5808333 0.456879
+ 5.5811111 0.441525
+ 5.5813889 0.415767
+ 5.5816667 0.381618
+ 5.5819444 0.341091
+ 5.5822222 0.296198
+ 5.5825000 0.248951
+ 5.5827778 0.201365
+ 5.5830556 0.155451
+ 5.5833333 0.113222
+ 5.5836111 0.076413
+ 5.5838889 0.050000
+ 5.5841667 0.050000
+ 5.5844444 0.050000
+ 5.5847222 0.050000
+ 5.5850000 0.050000
+ 5.5852778 0.050000
+ 5.5855556 0.050000
+ 5.5858333 0.050000
+ 5.5861111 0.058333
+ 5.5863889 0.096978
+ 5.5866667 0.142361
+ 5.5869444 0.192081
+ 5.5872222 0.243735
+ 5.5875000 0.294922
+ 5.5877778 0.343240
+ 5.5880556 0.386286
+ 5.5883333 0.421659
+ 5.5886111 0.446957
+ 5.5888889 0.459778
+ 5.5891667 0.458463
+ 5.5894444 0.444326
+ 5.5897222 0.419426
+ 5.5900000 0.385819
+ 5.5902778 0.345564
+ 5.5905556 0.300717
+ 5.5908333 0.253337
+ 5.5911111 0.205480
+ 5.5913889 0.159205
+ 5.5916667 0.116569
+ 5.5919444 0.079346
+ 5.5922222 0.050000
+ 5.5925000 0.050000
+ 5.5927778 0.050000
+ 5.5930556 0.050000
+ 5.5933333 0.050000
+ 5.5936111 0.050000
+ 5.5938889 0.050000
+ 5.5941667 0.050000
+ 5.5944444 0.058294
+ 5.5947222 0.096782
+ 5.5950000 0.142053
+ 5.5952778 0.191701
+ 5.5955556 0.243321
+ 5.5958333 0.294507
+ 5.5961111 0.342852
+ 5.5963889 0.385953
+ 5.5966667 0.421402
+ 5.5969444 0.446795
+ 5.5972222 0.459725
+ 5.5975000 0.458533
+ 5.5977778 0.444541
+ 5.5980556 0.419816
+ 5.5983333 0.386427
+ 5.5986111 0.346440
+ 5.5988889 0.301923
+ 5.5991667 0.254945
+ 5.5994444 0.207573
+ 5.5997222 0.161874
+ 5.6000000 0.119917
+ 5.6002778 0.083475
+ 5.6005556 0.053155
+ 5.6008333 0.050000
+ 5.6011111 0.050000
+ 5.6013889 0.050000
+ 5.6016667 0.050000
+ 5.6019444 0.050000
+ 5.6022222 0.050000
+ 5.6025000 0.050000
+ 5.6027778 0.068388
+ 5.6030556 0.106746
+ 5.6033333 0.151646
+ 5.6036111 0.200699
+ 5.6038889 0.251517
+ 5.6041667 0.301714
+ 5.6044444 0.348900
+ 5.6047222 0.390689
+ 5.6050000 0.424692
+ 5.6052778 0.448522
+ 5.6055556 0.459791
+ 5.6058333 0.456858
+ 5.6061111 0.441069
+ 5.6063889 0.414518
+ 5.6066667 0.379299
+ 5.6069444 0.337505
+ 5.6072222 0.291229
+ 5.6075000 0.242566
+ 5.6077778 0.193607
+ 5.6080556 0.146448
+ 5.6083333 0.103181
+ 5.6086111 0.065604
+ 5.6088889 0.050000
+ 5.6091667 0.050000
+ 5.6094444 0.050000
+ 5.6097222 0.050000
+ 5.6100000 0.050000
+ 5.6102778 0.050000
+ 5.6105556 0.050000
+ 5.6108333 0.050000
+ 5.6111111 0.050000
+ 5.6113889 0.089564
+ 5.6116667 0.135913
+ 5.6119444 0.186621
+ 5.6122222 0.239259
+ 5.6125000 0.291402
+ 5.6127778 0.340623
+ 5.6130556 0.384495
+ 5.6133333 0.420592
+ 5.6136111 0.446486
+ 5.6138889 0.459752
+ 5.6141667 0.458711
+ 5.6144444 0.444683
+ 5.6147222 0.419738
+ 5.6150000 0.385944
+ 5.6152778 0.345371
+ 5.6155556 0.300087
+ 5.6158333 0.252161
+ 5.6161111 0.203662
+ 5.6163889 0.156659
+ 5.6166667 0.113222
+ 5.6169444 0.075139
+ 5.6172222 0.050000
+ 5.6175000 0.050000
+ 5.6177778 0.050000
+ 5.6180556 0.050000
+ 5.6183333 0.050000
+ 5.6186111 0.050000
+ 5.6188889 0.050000
+ 5.6191667 0.050000
+ 5.6194444 0.050000
+ 5.6197222 0.089137
+ 5.6200000 0.135307
+ 5.6202778 0.186025
+ 5.6205556 0.238808
+ 5.6208333 0.291171
+ 5.6211111 0.340630
+ 5.6213889 0.384700
+ 5.6216667 0.420898
+ 5.6219444 0.446739
+ 5.6222222 0.459738
+ 5.6225000 0.458186
+ 5.6227778 0.443461
+ 5.6230556 0.417717
+ 5.6233333 0.383108
+ 5.6236111 0.341787
+ 5.6238889 0.295908
+ 5.6241667 0.247624
+ 5.6244444 0.199088
+ 5.6247222 0.152454
+ 5.6250000 0.109875
+ 5.6252778 0.073189
+ 5.6255556 0.050000
+ 5.6258333 0.050000
+ 5.6261111 0.050000
+ 5.6263889 0.050000
+ 5.6266667 0.050000
+ 5.6269444 0.050000
+ 5.6272222 0.050000
+ 5.6275000 0.050000
+ 5.6277778 0.065027
+ 5.6280556 0.104197
+ 5.6283333 0.149779
+ 5.6286111 0.199395
+ 5.6288889 0.250667
+ 5.6291667 0.301214
+ 5.6294444 0.348659
+ 5.6297222 0.390622
+ 5.6300000 0.424724
+ 5.6302778 0.448586
+ 5.6305556 0.459830
+ 5.6308333 0.456824
+ 5.6311111 0.440932
+ 5.6313889 0.414263
+ 5.6316667 0.378930
+ 5.6319444 0.337043
+ 5.6322222 0.290712
+ 5.6325000 0.242050
+ 5.6327778 0.193167
+ 5.6330556 0.146173
+ 5.6333333 0.103181
+ 5.6336111 0.065997
+ 5.6338889 0.050000
+ 5.6341667 0.050000
+ 5.6344444 0.050000
+ 5.6347222 0.050000
+ 5.6350000 0.050000
+ 5.6352778 0.050000
+ 5.6355556 0.050000
+ 5.6358333 0.050000
+ 5.6361111 0.054920
+ 5.6363889 0.094585
+ 5.6366667 0.140884
+ 5.6369444 0.191398
+ 5.6372222 0.243707
+ 5.6375000 0.295392
+ 5.6377778 0.344033
+ 5.6380556 0.387210
+ 5.6383333 0.422504
+ 5.6386111 0.447496
+ 5.6388889 0.459765
+ 5.6391667 0.457648
+ 5.6394444 0.442506
+ 5.6397222 0.416457
+ 5.6400000 0.381616
+ 5.6402778 0.340103
+ 5.6405556 0.294032
+ 5.6408333 0.245523
+ 5.6411111 0.196690
+ 5.6413889 0.149653
+ 5.6416667 0.106528
+ 5.6419444 0.069130
+ 5.6422222 0.050000
+ 5.6425000 0.050000
+ 5.6427778 0.050000
+ 5.6430556 0.050000
+ 5.6433333 0.050000
+ 5.6436111 0.050000
+ 5.6438889 0.050000
+ 5.6441667 0.050000
+ 5.6444444 0.054960
+ 5.6447222 0.094430
+ 5.6450000 0.140599
+ 5.6452778 0.191038
+ 5.6455556 0.243318
+ 5.6458333 0.295012
+ 5.6461111 0.343691
+ 5.6463889 0.386928
+ 5.6466667 0.422294
+ 5.6469444 0.447360
+ 5.6472222 0.459699
+ 5.6475000 0.457641
+ 5.6477778 0.442544
+ 5.6480556 0.416528
+ 5.6483333 0.381709
+ 5.6486111 0.340205
+ 5.6488889 0.294133
+ 5.6491667 0.245612
+ 5.6494444 0.196759
+ 5.6497222 0.149692
+ 5.6500000 0.106528
+ 5.6502778 0.069084
+ 5.6505556 0.050000
+ 5.6508333 0.050000
+ 5.6511111 0.050000
+ 5.6513889 0.050000
+ 5.6516667 0.050000
+ 5.6519444 0.050000
+ 5.6522222 0.050000
+ 5.6525000 0.050000
+ 5.6527778 0.054973
+ 5.6530556 0.094592
+ 5.6533333 0.140931
+ 5.6536111 0.191542
+ 5.6538889 0.243977
+ 5.6541667 0.295787
+ 5.6544444 0.344523
+ 5.6547222 0.387738
+ 5.6550000 0.422982
+ 5.6552778 0.447807
+ 5.6555556 0.459765
+ 5.6558333 0.457173
+ 5.6561111 0.441419
+ 5.6563889 0.414654
+ 5.6566667 0.379031
+ 5.6569444 0.336703
+ 5.6572222 0.289823
+ 5.6575000 0.240543
+ 5.6577778 0.191016
+ 5.6580556 0.143396
+ 5.6583333 0.099833
+ 5.6586111 0.062171
+ 5.6588889 0.050000
+ 5.6591667 0.050000
+ 5.6594444 0.050000
+ 5.6597222 0.050000
+ 5.6600000 0.050000
+ 5.6602778 0.050000
+ 5.6605556 0.050000
+ 5.6608333 0.050000
+ 5.6611111 0.050000
+ 5.6613889 0.089763
+ 5.6616667 0.136200
+ 5.6619444 0.186910
+ 5.6622222 0.239491
+ 5.6625000 0.291541
+ 5.6627778 0.340658
+ 5.6630556 0.384439
+ 5.6633333 0.420483
+ 5.6636111 0.446388
+ 5.6638889 0.459752
+ 5.6641667 0.458913
+ 5.6644444 0.445178
+ 5.6647222 0.420592
+ 5.6650000 0.387202
+ 5.6652778 0.347055
+ 5.6655556 0.302195
+ 5.6658333 0.254671
+ 5.6661111 0.206527
+ 5.6663889 0.159811
+ 5.6666667 0.116569
+ 5.6669444 0.078574
+ 5.6672222 0.050000
+ 5.6675000 0.050000
+ 5.6677778 0.050000
+ 5.6680556 0.050000
+ 5.6683333 0.050000
+ 5.6686111 0.050000
+ 5.6688889 0.050000
+ 5.6691667 0.050000
+ 5.6694444 0.051586
+ 5.6697222 0.090498
+ 5.6700000 0.136474
+ 5.6702778 0.187023
+ 5.6705556 0.239655
+ 5.6708333 0.291879
+ 5.6711111 0.341205
+ 5.6713889 0.385142
+ 5.6716667 0.421199
+ 5.6719444 0.446886
+ 5.6722222 0.459712
+ 5.6725000 0.457961
+ 5.6727778 0.443011
+ 5.6730556 0.417015
+ 5.6733333 0.382124
+ 5.6736111 0.340491
+ 5.6738889 0.294268
+ 5.6741667 0.245608
+ 5.6744444 0.196663
+ 5.6747222 0.149586
+ 5.6750000 0.106528
+ 5.6752778 0.069329
+ 5.6755556 0.050000
+ 5.6758333 0.050000
+ 5.6761111 0.050000
+ 5.6763889 0.050000
+ 5.6766667 0.050000
+ 5.6769444 0.050000
+ 5.6772222 0.050000
+ 5.6775000 0.050000
+ 5.6777778 0.058320
+ 5.6780556 0.097741
+ 5.6783333 0.143723
+ 5.6786111 0.193867
+ 5.6788889 0.245772
+ 5.6791667 0.297037
+ 5.6794444 0.345262
+ 5.6797222 0.388046
+ 5.6800000 0.422990
+ 5.6802778 0.447692
+ 5.6805556 0.459752
+ 5.6808333 0.457519
+ 5.6811111 0.442341
+ 5.6813889 0.416314
+ 5.6816667 0.381536
+ 5.6819444 0.340104
+ 5.6822222 0.294115
+ 5.6825000 0.245666
+ 5.6827778 0.196854
+ 5.6830556 0.149775
+ 5.6833333 0.106528
+ 5.6836111 0.068914
+ 5.6838889 0.050000
+ 5.6841667 0.050000
+ 5.6844444 0.050000
+ 5.6847222 0.050000
+ 5.6850000 0.050000
+ 5.6852778 0.050000
+ 5.6855556 0.050000
+ 5.6858333 0.050000
+ 5.6861111 0.051573
+ 5.6863889 0.090921
+ 5.6866667 0.137068
+ 5.6869444 0.187588
+ 5.6872222 0.240052
+ 5.6875000 0.292033
+ 5.6877778 0.341105
+ 5.6880556 0.384840
+ 5.6883333 0.420811
+ 5.6886111 0.446591
+ 5.6888889 0.459752
+ 5.6891667 0.458617
+ 5.6894444 0.444508
+ 5.6897222 0.419498
+ 5.6900000 0.385658
+ 5.6902778 0.345060
+ 5.6905556 0.299776
+ 5.6908333 0.251878
+ 5.6911111 0.203439
+ 5.6913889 0.156529
+ 5.6916667 0.113222
+ 5.6919444 0.075307
+ 5.6922222 0.050000
+ 5.6925000 0.050000
+ 5.6927778 0.050000
+ 5.6930556 0.050000
+ 5.6933333 0.050000
+ 5.6936111 0.050000
+ 5.6938889 0.050000
+ 5.6941667 0.050000
+ 5.6944444 0.051599
+ 5.6947222 0.090683
+ 5.6950000 0.136739
+ 5.6952778 0.187298
+ 5.6955556 0.239889
+ 5.6958333 0.292042
+ 5.6961111 0.341286
+ 5.6963889 0.385151
+ 5.6966667 0.421166
+ 5.6969444 0.446861
+ 5.6972222 0.459765
+ 5.6975000 0.458175
+ 5.6977778 0.443463
+ 5.6980556 0.417765
+ 5.6983333 0.383219
+ 5.6986111 0.341964
+ 5.6988889 0.296138
+ 5.6991667 0.247878
+ 5.6994444 0.199322
+ 5.6997222 0.152608
+ 5.7000000 0.109875
+ 5.7002778 0.072950
+ 5.7005556 0.050000
+ 5.7008333 0.050000
+ 5.7011111 0.050000
+ 5.7013889 0.050000
+ 5.7016667 0.050000
+ 5.7019444 0.050000
+ 5.7022222 0.050000
+ 5.7025000 0.050000
+ 5.7027778 0.061693
+ 5.7030556 0.100758
+ 5.7033333 0.146334
+ 5.7036111 0.196041
+ 5.7038889 0.247500
+ 5.7041667 0.298331
+ 5.7044444 0.346153
+ 5.7047222 0.388588
+ 5.7050000 0.423254
+ 5.7052778 0.447773
+ 5.7055556 0.459765
+ 5.7058333 0.457591
+ 5.7061111 0.442588
+ 5.7063889 0.416830
+ 5.7066667 0.382396
+ 5.7069444 0.341361
+ 5.7072222 0.295803
+ 5.7075000 0.247799
+ 5.7077778 0.199425
+ 5.7080556 0.152758
+ 5.7083333 0.109875
+ 5.7086111 0.072562
+ 5.7088889 0.050000
+ 5.7091667 0.050000
+ 5.7094444 0.050000
+ 5.7097222 0.050000
+ 5.7100000 0.050000
+ 5.7102778 0.050000
+ 5.7105556 0.050000
+ 5.7108333 0.050000
+ 5.7111111 0.054933
+ 5.7113889 0.093924
+ 5.7116667 0.139668
+ 5.7119444 0.189757
+ 5.7122222 0.241784
+ 5.7125000 0.293341
+ 5.7127778 0.342019
+ 5.7130556 0.385411
+ 5.7133333 0.421109
+ 5.7136111 0.446705
+ 5.7138889 0.459791
+ 5.7141667 0.458706
+ 5.7144444 0.444778
+ 5.7147222 0.420081
+ 5.7150000 0.386689
+ 5.7152778 0.346677
+ 5.7155556 0.302119
+ 5.7158333 0.255089
+ 5.7161111 0.207663
+ 5.7163889 0.161914
+ 5.7166667 0.119917
+ 5.7169444 0.083451
+ 5.7172222 0.053121
+ 5.7175000 0.050000
+ 5.7177778 0.050000
+ 5.7180556 0.050000
+ 5.7183333 0.050000
+ 5.7186111 0.050000
+ 5.7188889 0.050000
+ 5.7191667 0.050000
+ 5.7194444 0.068348
+ 5.7197222 0.106666
+ 5.7200000 0.151515
+ 5.7202778 0.200515
+ 5.7205556 0.251286
+ 5.7208333 0.301447
+ 5.7211111 0.348619
+ 5.7213889 0.390420
+ 5.7216667 0.424472
+ 5.7219444 0.448393
+ 5.7222222 0.459804
+ 5.7225000 0.457081
+ 5.7227778 0.441634
+ 5.7230556 0.415629
+ 5.7233333 0.381231
+ 5.7236111 0.340607
+ 5.7238889 0.295924
+ 5.7241667 0.249347
+ 5.7244444 0.203042
+ 5.7247222 0.159177
+ 5.7250000 0.119917
+ 5.7252778 0.087076
+ 5.7255556 0.061061
+ 5.7258333 0.050000
+ 5.7261111 0.050000
+ 5.7263889 0.050000
+ 5.7266667 0.050000
+ 5.7269444 0.050000
+ 5.7272222 0.051383
+ 5.7275000 0.074683
+ 5.7277778 0.105246
+ 5.7280556 0.142766
+ 5.7283333 0.185483
+ 5.7286111 0.231279
+ 5.7288889 0.278033
+ 5.7291667 0.323624
+ 5.7294444 0.365932
+ 5.7297222 0.402838
+ 5.7300000 0.432220
+ 5.7302778 0.451959
+ 5.7305556 0.459935
+ 5.7308333 0.454720
+ 5.7311111 0.437663
+ 5.7313889 0.410807
+ 5.7316667 0.376192
+ 5.7319444 0.335860
+ 5.7322222 0.291854
+ 5.7325000 0.246214
+ 5.7327778 0.200984
+ 5.7330556 0.158204
+ 5.7333333 0.119917
+ 5.7336111 0.087836
+ 5.7338889 0.062362
+ 5.7341667 0.050000
+ 5.7344444 0.050000
+ 5.7347222 0.050000
+ 5.7350000 0.050000
+ 5.7352778 0.050000
+ 5.7355556 0.052367
+ 5.7358333 0.075191
+ 5.7361111 0.105207
+ 5.7363889 0.142131
+ 5.7366667 0.184252
+ 5.7369444 0.229499
+ 5.7372222 0.275804
+ 5.7375000 0.321098
+ 5.7377778 0.363312
+ 5.7380556 0.400377
+ 5.7383333 0.430224
+ 5.7386111 0.450784
+ 5.7388889 0.459987
+ 5.7391667 0.456436
+ 5.7394444 0.441417
+ 5.7397222 0.416889
+ 5.7400000 0.384808
+ 5.7402778 0.347132
+ 5.7405556 0.305819
+ 5.7408333 0.262826
+ 5.7411111 0.220112
+ 5.7413889 0.179633
+ 5.7416667 0.143347
+ 5.7419444 0.112900
+ 5.7422222 0.088682
+ 5.7425000 0.070773
+ 5.7427778 0.059252
+ 5.7430556 0.054198
+ 5.7433333 0.055689
+ 5.7436111 0.063805
+ 5.7438889 0.078624
+ 5.7441667 0.100226
+ 5.7444444 0.128690
+ 5.7447222 0.163746
+ 5.7450000 0.203733
+ 5.7452778 0.246642
+ 5.7455556 0.290464
+ 5.7458333 0.333189
+ 5.7461111 0.372808
+ 5.7463889 0.407311
+ 5.7466667 0.434691
+ 5.7469444 0.452936
+ 5.7472222 0.460039
+ 5.7475000 0.454654
+ 5.7477778 0.438089
+ 5.7480556 0.412321
+ 5.7483333 0.379321
+ 5.7486111 0.341063
+ 5.7488889 0.299523
+ 5.7491667 0.256672
+ 5.7494444 0.214486
+ 5.7497222 0.174937
+ 5.7500000 0.140000
+ 5.7502778 0.111312
+ 5.7505556 0.089164
+ 5.7508333 0.073514
+ 5.7511111 0.064317
+ 5.7513889 0.061528
+ 5.7516667 0.065104
+ 5.7519444 0.075000
+ 5.7522222 0.091173
+ 5.7525000 0.113578
+ 5.7527778 0.142170
+ 5.7530556 0.176609
+ 5.7533333 0.215355
+ 5.7536111 0.256572
+ 5.7538889 0.298425
+ 5.7541667 0.339078
+ 5.7544444 0.376693
+ 5.7547222 0.409436
+ 5.7550000 0.435470
+ 5.7552778 0.452958
+ 5.7555556 0.460065
+ 5.7558333 0.455552
+ 5.7561111 0.440568
+ 5.7563889 0.416861
+ 5.7566667 0.386177
+ 5.7569444 0.350263
+ 5.7572222 0.310866
+ 5.7575000 0.269733
+ 5.7577778 0.228612
+ 5.7580556 0.189248
+ 5.7583333 0.153389
+ 5.7586111 0.122529
+ 5.7588889 0.097148
+ 5.7591667 0.077474
+ 5.7594444 0.063735
+ 5.7597222 0.056159
+ 5.7600000 0.054973
+ 5.7602778 0.060406
+ 5.7605556 0.072684
+ 5.7608333 0.092035
+ 5.7611111 0.118688
+ 5.7613889 0.152492
+ 5.7616667 0.191792
+ 5.7619444 0.234555
+ 5.7622222 0.278746
+ 5.7625000 0.322333
+ 5.7627778 0.363283
+ 5.7630556 0.399562
+ 5.7633333 0.429136
+ 5.7636111 0.449973
+ 5.7638889 0.460039
+ 5.7641667 0.457937
+ 5.7644444 0.444812
+ 5.7647222 0.422446
+ 5.7650000 0.392619
+ 5.7652778 0.357112
+ 5.7655556 0.317708
+ 5.7658333 0.276187
+ 5.7661111 0.234331
+ 5.7663889 0.193920
+ 5.7666667 0.156736
+ 5.7669444 0.124315
+ 5.7672222 0.097209
+ 5.7675000 0.075728
+ 5.7677778 0.060179
+ 5.7680556 0.050871
+ 5.7683333 0.050000
+ 5.7686111 0.052206
+ 5.7688889 0.063466
+ 5.7691667 0.082198
+ 5.7694444 0.108711
+ 5.7697222 0.142903
+ 5.7700000 0.183034
+ 5.7702778 0.226954
+ 5.7705556 0.272515
+ 5.7708333 0.317566
+ 5.7711111 0.359959
+ 5.7713889 0.397545
+ 5.7716667 0.428173
+ 5.7719444 0.449695
+ 5.7722222 0.459961
+ 5.7725000 0.457504
+ 5.7727778 0.443589
+ 5.7730556 0.420163
+ 5.7733333 0.389172
+ 5.7736111 0.352563
+ 5.7738889 0.312283
+ 5.7741667 0.270278
+ 5.7744444 0.228497
+ 5.7747222 0.188885
+ 5.7750000 0.153389
+ 5.7752778 0.123642
+ 5.7755556 0.100019
+ 5.7758333 0.082580
+ 5.7761111 0.071387
+ 5.7763889 0.066501
+ 5.7766667 0.067981
+ 5.7769444 0.075888
+ 5.7772222 0.090284
+ 5.7775000 0.111229
+ 5.7777778 0.138784
+ 5.7780556 0.172678
+ 5.7783333 0.211316
+ 5.7786111 0.252771
+ 5.7788889 0.295116
+ 5.7791667 0.336424
+ 5.7794444 0.374769
+ 5.7797222 0.408223
+ 5.7800000 0.434859
+ 5.7802778 0.452752
+ 5.7805556 0.459974
+ 5.7808333 0.455210
+ 5.7811111 0.439592
+ 5.7813889 0.414867
+ 5.7816667 0.382777
+ 5.7819444 0.345069
+ 5.7822222 0.303486
+ 5.7825000 0.259774
+ 5.7827778 0.215676
+ 5.7830556 0.172939
+ 5.7833333 0.133306
+ 5.7836111 0.098302
+ 5.7838889 0.068573
+ 5.7841667 0.050000
+ 5.7844444 0.050000
+ 5.7847222 0.050000
+ 5.7850000 0.050000
+ 5.7852778 0.050000
+ 5.7855556 0.050000
+ 5.7858333 0.050000
+ 5.7861111 0.071774
+ 5.7863889 0.108232
+ 5.7866667 0.151458
+ 5.7869444 0.199109
+ 5.7872222 0.248843
+ 5.7875000 0.298318
+ 5.7877778 0.345193
+ 5.7880556 0.387125
+ 5.7883333 0.421772
+ 5.7886111 0.446792
+ 5.7888889 0.459843
+ 5.7891667 0.459296
+ 5.7894444 0.446375
+ 5.7897222 0.423017
+ 5.7900000 0.391158
+ 5.7902778 0.352735
+ 5.7905556 0.309686
+ 5.7908333 0.263947
+ 5.7911111 0.217454
+ 5.7913889 0.172146
+ 5.7916667 0.129958
+ 5.7919444 0.092581
+ 5.7922222 0.060713
+ 5.7925000 0.050000
+ 5.7927778 0.050000
+ 5.7930556 0.050000
+ 5.7933333 0.050000
+ 5.7936111 0.050000
+ 5.7938889 0.050000
+ 5.7941667 0.050000
+ 5.7944444 0.058372
+ 5.7947222 0.095952
+ 5.7950000 0.140653
+ 5.7952778 0.190018
+ 5.7955556 0.241589
+ 5.7958333 0.292909
+ 5.7961111 0.341520
+ 5.7963889 0.384964
+ 5.7966667 0.420785
+ 5.7969444 0.446525
+ 5.7972222 0.459725
+ 5.7975000 0.458685
+ 5.7977778 0.444721
+ 5.7980556 0.419908
+ 5.7983333 0.386318
+ 5.7986111 0.346024
+ 5.7988889 0.301100
+ 5.7991667 0.253620
+ 5.7994444 0.205656
+ 5.7997222 0.159281
+ 5.8000000 0.116569
+ 5.8002778 0.079305
+ 5.8005556 0.050000
+ 5.8008333 0.050000
+ 5.8011111 0.050000
+ 5.8013889 0.050000
+ 5.8016667 0.050000
+ 5.8019444 0.050000
+ 5.8022222 0.050000
+ 5.8025000 0.050000
+ 5.8027778 0.058359
+ 5.8030556 0.096770
+ 5.8033333 0.141939
+ 5.8036111 0.191477
+ 5.8038889 0.242993
+ 5.8041667 0.294096
+ 5.8044444 0.342398
+ 5.8047222 0.385507
+ 5.8050000 0.421033
+ 5.8052778 0.446587
+ 5.8055556 0.459778
+ 5.8058333 0.458949
+ 5.8061111 0.445382
+ 5.8063889 0.421089
+ 5.8066667 0.388085
+ 5.8069444 0.348385
+ 5.8072222 0.304001
+ 5.8075000 0.256948
+ 5.8077778 0.209241
+ 5.8080556 0.162892
+ 5.8083333 0.119917
+ 5.8086111 0.082061
+ 5.8088889 0.050004
+ 5.8091667 0.050000
+ 5.8094444 0.050000
+ 5.8097222 0.050000
+ 5.8100000 0.050000
+ 5.8102778 0.050000
+ 5.8105556 0.050000
+ 5.8108333 0.050000
+ 5.8111111 0.051638
+ 5.8113889 0.089799
+ 5.8116667 0.135029
+ 5.8119444 0.184898
+ 5.8122222 0.236977
+ 5.8125000 0.288835
+ 5.8127778 0.338043
+ 5.8130556 0.382169
+ 5.8133333 0.418785
+ 5.8136111 0.445460
+ 5.8138889 0.459765
+ 5.8141667 0.460007
+ 5.8144444 0.447451
+ 5.8147222 0.424100
+ 5.8150000 0.391956
+ 5.8152778 0.353023
+ 5.8155556 0.309303
+ 5.8158333 0.262799
+ 5.8161111 0.215514
+ 5.8163889 0.169450
+ 5.8166667 0.126611
+ 5.8169444 0.088738
+ 5.8172222 0.056528
+ 5.8175000 0.050000
+ 5.8177778 0.050000
+ 5.8180556 0.050000
+ 5.8183333 0.050000
+ 5.8186111 0.050000
+ 5.8188889 0.050000
+ 5.8191667 0.050000
+ 5.8194444 0.055012
+ 5.8197222 0.092897
+ 5.8200000 0.137910
+ 5.8202778 0.187593
+ 5.8205556 0.239488
+ 5.8208333 0.291138
+ 5.8211111 0.340085
+ 5.8213889 0.383870
+ 5.8216667 0.420037
+ 5.8219444 0.446129
+ 5.8222222 0.459686
+ 5.8225000 0.459004
+ 5.8227778 0.445380
+ 5.8230556 0.420866
+ 5.8233333 0.387512
+ 5.8236111 0.347368
+ 5.8238889 0.302485
+ 5.8241667 0.254913
+ 5.8244444 0.206703
+ 5.8247222 0.159905
+ 5.8250000 0.116569
+ 5.8252778 0.078472
+ 5.8255556 0.050000
+ 5.8258333 0.050000
+ 5.8261111 0.050000
+ 5.8263889 0.050000
+ 5.8266667 0.050000
+ 5.8269444 0.050000
+ 5.8272222 0.050000
+ 5.8275000 0.050000
+ 5.8277778 0.050000
+ 5.8280556 0.088663
+ 5.8283333 0.134399
+ 5.8286111 0.184748
+ 5.8288889 0.237251
+ 5.8291667 0.289448
+ 5.8294444 0.338879
+ 5.8297222 0.383084
+ 5.8300000 0.419605
+ 5.8302778 0.445980
+ 5.8305556 0.459752
+ 5.8308333 0.459212
+ 5.8311111 0.445670
+ 5.8313889 0.421185
+ 5.8316667 0.387821
+ 5.8319444 0.347636
+ 5.8322222 0.302694
+ 5.8325000 0.255055
+ 5.8327778 0.206781
+ 5.8330556 0.159932
+ 5.8333333 0.116569
+ 5.8336111 0.078477
+ 5.8338889 0.050000
+ 5.8341667 0.050000
+ 5.8344444 0.050000
+ 5.8347222 0.050000
+ 5.8350000 0.050000
+ 5.8352778 0.050000
+ 5.8355556 0.050000
+ 5.8358333 0.050000
+ 5.8361111 0.050000
+ 5.8363889 0.088482
+ 5.8366667 0.134001
+ 5.8369444 0.184126
+ 5.8372222 0.236425
+ 5.8375000 0.288466
+ 5.8377778 0.337818
+ 5.8380556 0.382049
+ 5.8383333 0.418727
+ 5.8386111 0.445421
+ 5.8388889 0.459699
+ 5.8391667 0.459869
+ 5.8394444 0.447190
+ 5.8397222 0.423665
+ 5.8400000 0.391292
+ 5.8402778 0.352072
+ 5.8405556 0.308004
+ 5.8408333 0.261090
+ 5.8411111 0.213328
+ 5.8413889 0.166720
+ 5.8416667 0.123264
+ 5.8419444 0.084709
+ 5.8422222 0.051795
+ 5.8425000 0.050000
+ 5.8427778 0.050000
+ 5.8430556 0.050000
+ 5.8433333 0.050000
+ 5.8436111 0.050000
+ 5.8438889 0.050000
+ 5.8441667 0.050000
+ 5.8444444 0.050000
+ 5.8447222 0.089255
+ 5.8450000 0.135904
+ 5.8452778 0.187318
+ 5.8455556 0.240866
+ 5.8458333 0.293918
+ 5.8461111 0.343842
+ 5.8463889 0.388009
+ 5.8466667 0.423788
+ 5.8469444 0.448549
+ 5.8472222 0.459660
+ 5.8475000 0.455324
+ 5.8477778 0.437068
+ 5.8480556 0.407251
+ 5.8483333 0.368234
+ 5.8486111 0.322376
+ 5.8488889 0.272036
+ 5.8491667 0.219575
+ 5.8494444 0.167351
+ 5.8497222 0.117725
+ 5.8500000 0.073055
+ 5.8502778 0.050000
+ 5.8505556 0.050000
+ 5.8508333 0.050000
+ 5.8511111 0.050000
+ 5.8513889 0.050000
+ 5.8516667 0.050000
+ 5.8519444 0.050000
+ 5.8522222 0.050000
+ 5.8525000 0.050000
+ 5.8527778 0.050000
+ 5.8530556 0.093297
+ 5.8533333 0.142870
+ 5.8536111 0.196170
+ 5.8538889 0.250648
+ 5.8541667 0.303752
+ 5.8544444 0.352935
+ 5.8547222 0.395646
+ 5.8550000 0.429335
+ 5.8552778 0.451453
+ 5.8555556 0.459451
+ 5.8558333 0.451626
+ 5.8561111 0.429670
+ 5.8563889 0.396123
+ 5.8566667 0.353522
+ 5.8569444 0.304408
+ 5.8572222 0.251319
+ 5.8575000 0.196794
+ 5.8577778 0.143374
+ 5.8580556 0.093596
+ 5.8583333 0.050000
+ 5.8586111 0.050000
+ 5.8588889 0.050000
+ 5.8591667 0.050000
+ 5.8594444 0.050000
+ 5.8597222 0.050000
+ 5.8600000 0.050000
+ 5.8602778 0.050000
+ 5.8605556 0.050000
+ 5.8608333 0.050000
+ 5.8611111 0.050000
+ 5.8613889 0.088622
+ 5.8616667 0.132003
+ 5.8619444 0.178552
+ 5.8622222 0.226676
+ 5.8625000 0.274781
+ 5.8627778 0.321276
+ 5.8630556 0.364567
+ 5.8633333 0.403062
+ 5.8636111 0.435169
+ 5.8638889 0.459294
+ 5.8641667 0.474271
+ 5.8644444 0.480641
+ 5.8647222 0.479370
+ 5.8650000 0.471423
+ 5.8652778 0.457769
+ 5.8655556 0.439372
+ 5.8658333 0.417200
+ 5.8661111 0.392219
+ 5.8663889 0.365395
+ 5.8666667 0.337696
+ 5.8669444 0.310044
+ 5.8672222 0.283199
+ 5.8675000 0.257875
+ 5.8677778 0.234789
+ 5.8680556 0.214657
+ 5.8683333 0.198193
+ 5.8686111 0.186114
+ 5.8688889 0.179136
+ 5.8691667 0.177974
+ 5.8694444 0.183344
+ 5.8697222 0.195722
+ 5.8700000 0.214627
+ 5.8702778 0.239337
+ 5.8705556 0.269130
+ 5.8708333 0.303286
+ 5.8711111 0.341083
+ 5.8713889 0.381799
+ 5.8716667 0.424712
+ 5.8719444 0.469103
+ 5.8722222 0.514249
+ 5.8725000 0.559249
+ 5.8727778 0.602484
+ 5.8730556 0.642158
+ 5.8733333 0.676470
+ 5.8736111 0.703625
+ 5.8738889 0.721822
+ 5.8741667 0.729265
+ 5.8744444 0.724155
+ 5.8747222 0.704694
+ 5.8750000 0.669084
+ 5.8752778 0.616548
+ 5.8755556 0.550391
+ 5.8758333 0.474940
+ 5.8761111 0.394522
+ 5.8763889 0.313464
+ 5.8766667 0.236092
+ 5.8769444 0.166733
+ 5.8772222 0.109713
+ 5.8775000 0.069360
+ 5.8777778 0.050000
+ 5.8780556 0.054513
+ 5.8783333 0.079994
+ 5.8786111 0.122093
+ 5.8788889 0.176457
+ 5.8791667 0.238736
+ 5.8794444 0.304577
+ 5.8797222 0.369631
+ 5.8800000 0.429545
+ 5.8802778 0.479969
+ 5.8805556 0.516550
+ 5.8808333 0.536142
+ 5.8811111 0.540414
+ 5.8813889 0.532238
+ 5.8816667 0.514489
+ 5.8819444 0.490039
+ 5.8822222 0.461761
+ 5.8825000 0.432528
+ 5.8827778 0.405214
+ 5.8830556 0.382691
+ 5.8833333 0.367834
+ 5.8836111 0.362771
+ 5.8838889 0.366666
+ 5.8841667 0.377935
+ 5.8844444 0.394999
+ 5.8847222 0.416275
+ 5.8850000 0.440183
+ 5.8852778 0.465140
+ 5.8855556 0.489567
+ 5.8858333 0.511881
+ 5.8861111 0.530501
+ 5.8863889 0.544141
+ 5.8866667 0.552694
+ 5.8869444 0.556349
+ 5.8872222 0.555293
+ 5.8875000 0.549715
+ 5.8877778 0.539804
+ 5.8880556 0.525747
+ 5.8883333 0.507734
+ 5.8886111 0.485951
+ 5.8888889 0.460588
+ 5.8891667 0.431898
+ 5.8894444 0.400395
+ 5.8897222 0.366658
+ 5.8900000 0.331265
+ 5.8902778 0.294796
+ 5.8905556 0.257830
+ 5.8908333 0.220945
+ 5.8911111 0.184721
+ 5.8913889 0.149736
+ 5.8916667 0.116569
+ 5.8919444 0.085838
+ 5.8922222 0.058309
+ 5.8925000 0.050000
+ 5.8927778 0.050000
+ 5.8930556 0.050000
+ 5.8933333 0.050000
+ 5.8936111 0.050000
+ 5.8938889 0.050000
+ 5.8941667 0.050000
+ 5.8944444 0.050000
+ 5.8947222 0.086961
+ 5.8950000 0.131763
+ 5.8952778 0.181799
+ 5.8955556 0.234461
+ 5.8958333 0.287140
+ 5.8961111 0.337228
+ 5.8963889 0.382118
+ 5.8966667 0.419201
+ 5.8969444 0.445870
+ 5.8972222 0.459516
+ 5.8975000 0.458329
+ 5.8977778 0.443686
+ 5.8980556 0.417764
+ 5.8983333 0.382736
+ 5.8986111 0.340779
+ 5.8988889 0.294067
+ 5.8991667 0.244776
+ 5.8994444 0.195081
+ 5.8997222 0.147158
+ 5.9000000 0.103181
+ 5.9002778 0.065016
+ 5.9005556 0.050000
+ 5.9008333 0.050000
+ 5.9011111 0.050000
+ 5.9013889 0.050000
+ 5.9016667 0.050000
+ 5.9019444 0.050000
+ 5.9022222 0.050000
+ 5.9025000 0.050000
+ 5.9027778 0.050000
+ 5.9030556 0.090244
+ 5.9033333 0.137319
+ 5.9036111 0.188724
+ 5.9038889 0.241957
+ 5.9041667 0.294517
+ 5.9044444 0.343902
+ 5.9047222 0.387610
+ 5.9050000 0.423140
+ 5.9052778 0.447991
+ 5.9055556 0.459660
+ 5.9058333 0.456435
+ 5.9061111 0.439759
+ 5.9063889 0.411861
+ 5.9066667 0.374973
+ 5.9069444 0.331327
+ 5.9072222 0.283152
+ 5.9075000 0.232680
+ 5.9077778 0.182142
+ 5.9080556 0.133769
+ 5.9083333 0.089792
+ 5.9086111 0.052108
+ 5.9088889 0.050000
+ 5.9091667 0.050000
+ 5.9094444 0.050000
+ 5.9097222 0.050000
+ 5.9100000 0.050000
+ 5.9102778 0.050000
+ 5.9105556 0.050000
+ 5.9108333 0.050000
+ 5.9111111 0.050000
+ 5.9113889 0.091082
+ 5.9116667 0.138689
+ 5.9119444 0.190363
+ 5.9122222 0.243648
+ 5.9125000 0.296089
+ 5.9127778 0.345227
+ 5.9130556 0.388607
+ 5.9133333 0.423773
+ 5.9136111 0.448267
+ 5.9138889 0.459634
+ 5.9141667 0.456195
+ 5.9144444 0.439389
+ 5.9147222 0.411434
+ 5.9150000 0.374546
+ 5.9152778 0.330942
+ 5.9155556 0.282840
+ 5.9158333 0.232456
+ 5.9161111 0.182009
+ 5.9163889 0.133715
+ 5.9166667 0.089792
+ 5.9169444 0.052127
+ 5.9172222 0.050000
+ 5.9175000 0.050000
+ 5.9177778 0.050000
+ 5.9180556 0.050000
+ 5.9183333 0.050000
+ 5.9186111 0.050000
+ 5.9188889 0.050000
+ 5.9191667 0.050000
+ 5.9194444 0.050000
+ 5.9197222 0.091228
+ 5.9200000 0.139012
+ 5.9202778 0.190872
+ 5.9205556 0.244326
+ 5.9208333 0.296893
+ 5.9211111 0.346094
+ 5.9213889 0.389446
+ 5.9216667 0.424470
+ 5.9219444 0.448684
+ 5.9222222 0.459608
+ 5.9225000 0.455551
+ 5.9227778 0.437989
+ 5.9230556 0.409186
+ 5.9233333 0.371407
+ 5.9236111 0.326918
+ 5.9238889 0.277984
+ 5.9241667 0.226869
+ 5.9244444 0.175840
+ 5.9247222 0.127161
+ 5.9250000 0.083097
+ 5.9252778 0.050000
+ 5.9255556 0.050000
+ 5.9258333 0.050000
+ 5.9261111 0.050000
+ 5.9263889 0.050000
+ 5.9266667 0.050000
+ 5.9269444 0.050000
+ 5.9272222 0.050000
+ 5.9275000 0.050000
+ 5.9277778 0.050000
+ 5.9280556 0.091686
+ 5.9283333 0.139768
+ 5.9286111 0.191787
+ 5.9288889 0.245284
+ 5.9291667 0.297802
+ 5.9294444 0.346882
+ 5.9297222 0.390066
+ 5.9300000 0.424896
+ 5.9302778 0.448913
+ 5.9305556 0.459660
+ 5.9308333 0.455465
+ 5.9311111 0.437802
+ 5.9313889 0.408934
+ 5.9316667 0.371123
+ 5.9319444 0.326629
+ 5.9322222 0.277716
+ 5.9325000 0.226644
+ 5.9327778 0.175676
+ 5.9330556 0.127073
+ 5.9333333 0.083097
+ 5.9336111 0.050000
+ 5.9338889 0.050000
+ 5.9341667 0.050000
+ 5.9344444 0.050000
+ 5.9347222 0.050000
+ 5.9350000 0.050000
+ 5.9352778 0.050000
+ 5.9355556 0.050000
+ 5.9358333 0.050000
+ 5.9361111 0.050000
+ 5.9363889 0.091431
+ 5.9366667 0.139221
+ 5.9369444 0.190946
+ 5.9372222 0.244183
+ 5.9375000 0.296509
+ 5.9377778 0.345501
+ 5.9380556 0.388735
+ 5.9383333 0.423788
+ 5.9386111 0.448238
+ 5.9388889 0.459660
+ 5.9391667 0.456401
+ 5.9394444 0.439881
+ 5.9397222 0.412291
+ 5.9400000 0.375820
+ 5.9402778 0.332658
+ 5.9405556 0.284996
+ 5.9408333 0.235023
+ 5.9411111 0.184929
+ 5.9413889 0.136905
+ 5.9416667 0.093139
+ 5.9419444 0.055501
+ 5.9422222 0.050000
+ 5.9425000 0.050000
+ 5.9427778 0.050000
+ 5.9430556 0.050000
+ 5.9433333 0.050000
+ 5.9436111 0.050000
+ 5.9438889 0.050000
+ 5.9441667 0.050000
+ 5.9444444 0.050000
+ 5.9447222 0.090745
+ 5.9450000 0.138091
+ 5.9452778 0.189579
+ 5.9455556 0.242754
+ 5.9458333 0.295157
+ 5.9461111 0.344331
+ 5.9463889 0.387819
+ 5.9466667 0.423164
+ 5.9469444 0.447908
+ 5.9472222 0.459595
+ 5.9475000 0.456542
+ 5.9477778 0.440169
+ 5.9480556 0.412673
+ 5.9483333 0.376248
+ 5.9486111 0.333089
+ 5.9488889 0.285393
+ 5.9491667 0.235354
+ 5.9494444 0.185169
+ 5.9497222 0.137032
+ 5.9500000 0.093139
+ 5.9502778 0.055365
+ 5.9505556 0.050000
+ 5.9508333 0.050000
+ 5.9511111 0.050000
+ 5.9513889 0.050000
+ 5.9516667 0.050000
+ 5.9519444 0.050000
+ 5.9522222 0.050000
+ 5.9525000 0.050000
+ 5.9527778 0.050000
+ 5.9530556 0.091101
+ 5.9533333 0.138852
+ 5.9536111 0.190750
+ 5.9538889 0.244287
+ 5.9541667 0.296958
+ 5.9544444 0.346258
+ 5.9547222 0.389681
+ 5.9550000 0.424722
+ 5.9552778 0.448875
+ 5.9555556 0.459634
+ 5.9558333 0.455295
+ 5.9561111 0.437353
+ 5.9563889 0.408106
+ 5.9566667 0.369850
+ 5.9569444 0.324882
+ 5.9572222 0.275499
+ 5.9575000 0.223998
+ 5.9577778 0.172674
+ 5.9580556 0.123826
+ 5.9583333 0.079750
+ 5.9586111 0.050000
+ 5.9588889 0.050000
+ 5.9591667 0.050000
+ 5.9594444 0.050000
+ 5.9597222 0.050000
+ 5.9600000 0.050000
+ 5.9602778 0.050000
+ 5.9605556 0.050000
+ 5.9608333 0.050000
+ 5.9611111 0.050000
+ 5.9613889 0.091500
+ 5.9616667 0.139246
+ 5.9619444 0.190851
+ 5.9622222 0.243928
+ 5.9625000 0.296090
+ 5.9627778 0.344950
+ 5.9630556 0.388121
+ 5.9633333 0.423217
+ 5.9636111 0.447850
+ 5.9638889 0.459634
+ 5.9641667 0.456935
+ 5.9644444 0.441139
+ 5.9647222 0.414383
+ 5.9650000 0.378805
+ 5.9652778 0.336544
+ 5.9655556 0.289739
+ 5.9658333 0.240526
+ 5.9661111 0.191046
+ 5.9663889 0.143435
+ 5.9666667 0.099833
+ 5.9669444 0.062073
+ 5.9672222 0.050000
+ 5.9675000 0.050000
+ 5.9677778 0.050000
+ 5.9680556 0.050000
+ 5.9683333 0.050000
+ 5.9686111 0.050000
+ 5.9688889 0.050000
+ 5.9691667 0.050000
+ 5.9694444 0.050000
+ 5.9697222 0.090297
+ 5.9700000 0.137361
+ 5.9702778 0.188708
+ 5.9705556 0.241857
+ 5.9708333 0.294327
+ 5.9711111 0.343634
+ 5.9713889 0.387298
+ 5.9716667 0.422836
+ 5.9719444 0.447767
+ 5.9722222 0.459608
+ 5.9725000 0.456658
+ 5.9727778 0.440342
+ 5.9730556 0.412863
+ 5.9733333 0.376427
+ 5.9736111 0.333236
+ 5.9738889 0.285497
+ 5.9741667 0.235413
+ 5.9744444 0.185189
+ 5.9747222 0.137030
+ 5.9750000 0.093139
+ 5.9752778 0.055397
+ 5.9755556 0.050000
+ 5.9758333 0.050000
+ 5.9761111 0.050000
+ 5.9763889 0.050000
+ 5.9766667 0.050000
+ 5.9769444 0.050000
+ 5.9772222 0.050000
+ 5.9775000 0.050000
+ 5.9777778 0.050000
+ 5.9780556 0.090862
+ 5.9783333 0.138332
+ 5.9786111 0.189941
+ 5.9788889 0.243218
+ 5.9791667 0.295695
+ 5.9794444 0.344902
+ 5.9797222 0.388369
+ 5.9800000 0.423626
+ 5.9802778 0.448205
+ 5.9805556 0.459634
+ 5.9808333 0.456227
+ 5.9811111 0.439427
+ 5.9813889 0.411457
+ 5.9816667 0.374542
+ 5.9819444 0.330908
+ 5.9822222 0.282778
+ 5.9825000 0.232376
+ 5.9827778 0.181928
+ 5.9830556 0.133659
+ 5.9833333 0.089792
+ 5.9836111 0.052219
+ 5.9838889 0.050000
+ 5.9841667 0.050000
+ 5.9844444 0.050000
+ 5.9847222 0.050000
+ 5.9850000 0.050000
+ 5.9852778 0.050000
+ 5.9855556 0.050000
+ 5.9858333 0.050000
+ 5.9861111 0.050000
+ 5.9863889 0.090828
+ 5.9866667 0.138146
+ 5.9869444 0.189531
+ 5.9872222 0.242563
+ 5.9875000 0.294818
+ 5.9877778 0.343874
+ 5.9880556 0.387308
+ 5.9883333 0.422699
+ 5.9886111 0.447624
+ 5.9888889 0.459660
+ 5.9891667 0.457147
+ 5.9894444 0.441471
+ 5.9897222 0.414778
+ 5.9900000 0.379217
+ 5.9902778 0.336933
+ 5.9905556 0.290074
+ 5.9908333 0.240787
+ 5.9911111 0.191220
+ 5.9913889 0.143520
+ 5.9916667 0.099833
+ 5.9919444 0.062002
+ 5.9922222 0.050000
+ 5.9925000 0.050000
+ 5.9927778 0.050000
+ 5.9930556 0.050000
+ 5.9933333 0.050000
+ 5.9936111 0.050000
+ 5.9938889 0.050000
+ 5.9941667 0.050000
+ 5.9944444 0.050000
+ 5.9947222 0.090391
+ 5.9950000 0.137556
+ 5.9952778 0.189003
+ 5.9955556 0.242238
+ 5.9958333 0.294770
+ 5.9961111 0.344105
+ 5.9963889 0.387752
+ 5.9966667 0.423217
+ 5.9969444 0.448009
+ 5.9972222 0.459634
+ 5.9975000 0.456386
+ 5.9977778 0.439706
+ 5.9980556 0.411818
+ 5.9983333 0.374949
+ 5.9986111 0.331326
+ 5.9988889 0.283173
+ 5.9991667 0.232717
+ 5.9994444 0.182184
+ 5.9997222 0.133800
+ 6.0000000 0.089792
+ 6.0002778 0.052054
+ 6.0005556 0.050000
+ 6.0008333 0.050000
+ 6.0011111 0.050000
+ 6.0013889 0.050000
+ 6.0016667 0.050000
+ 6.0019444 0.050000
+ 6.0022222 0.050000
+ 6.0025000 0.050000
+ 6.0027778 0.050000
+ 6.0030556 0.091330
+ 6.0033333 0.139226
+ 6.0036111 0.191196
+ 6.0038889 0.244746
+ 6.0041667 0.297385
+ 6.0044444 0.346620
+ 6.0047222 0.389959
+ 6.0050000 0.424909
+ 6.0052778 0.448978
+ 6.0055556 0.459673
+ 6.0058333 0.455299
+ 6.0061111 0.437349
+ 6.0063889 0.408112
+ 6.0066667 0.369878
+ 6.0069444 0.324936
+ 6.0072222 0.275577
+ 6.0075000 0.224088
+ 6.0077778 0.172762
+ 6.0080556 0.123886
+ 6.0083333 0.079750
+ 6.0086111 0.050000
+ 6.0088889 0.050000
+ 6.0091667 0.050000
+ 6.0094444 0.050000
+ 6.0097222 0.050000
+ 6.0100000 0.050000
+ 6.0102778 0.050000
+ 6.0105556 0.050000
+ 6.0108333 0.050000
+ 6.0111111 0.050000
+ 6.0113889 0.091900
+ 6.0116667 0.140111
+ 6.0119444 0.192189
+ 6.0122222 0.245689
+ 6.0125000 0.298167
+ 6.0127778 0.347177
+ 6.0130556 0.390274
+ 6.0133333 0.425015
+ 6.0136111 0.448954
+ 6.0138889 0.459647
+ 6.0141667 0.455431
+ 6.0144444 0.437778
+ 6.0147222 0.408938
+ 6.0150000 0.371166
+ 6.0152778 0.326713
+ 6.0155556 0.277834
+ 6.0158333 0.226779
+ 6.0161111 0.175803
+ 6.0163889 0.127158
+ 6.0166667 0.083097
+ 6.0169444 0.050000
+ 6.0172222 0.050000
+ 6.0175000 0.050000
+ 6.0177778 0.050000
+ 6.0180556 0.050000
+ 6.0183333 0.050000
+ 6.0186111 0.050000
+ 6.0188889 0.050000
+ 6.0191667 0.050000
+ 6.0194444 0.050000
+ 6.0197222 0.091984
+ 6.0200000 0.140416
+ 6.0202778 0.192794
+ 6.0205556 0.246614
+ 6.0208333 0.299372
+ 6.0211111 0.348565
+ 6.0213889 0.391690
+ 6.0216667 0.426244
+ 6.0219444 0.449721
+ 6.0222222 0.459621
+ 6.0225000 0.454247
+ 6.0227778 0.435139
+ 6.0230556 0.404647
+ 6.0233333 0.365119
+ 6.0236111 0.318902
+ 6.0238889 0.268347
+ 6.0241667 0.215802
+ 6.0244444 0.163614
+ 6.0247222 0.114134
+ 6.0250000 0.069708
+ 6.0252778 0.050000
+ 6.0255556 0.050000
+ 6.0258333 0.050000
+ 6.0261111 0.050000
+ 6.0263889 0.050000
+ 6.0266667 0.050000
+ 6.0269444 0.050000
+ 6.0272222 0.050000
+ 6.0275000 0.050000
+ 6.0277778 0.050000
+ 6.0280556 0.093219
+ 6.0283333 0.142614
+ 6.0286111 0.195680
+ 6.0288889 0.249915
+ 6.0291667 0.302815
+ 6.0294444 0.351878
+ 6.0297222 0.394600
+ 6.0300000 0.428477
+ 6.0302778 0.451007
+ 6.0305556 0.459686
+ 6.0308333 0.452834
+ 6.0311111 0.432058
+ 6.0313889 0.399790
+ 6.0316667 0.358461
+ 6.0319444 0.310501
+ 6.0322222 0.258341
+ 6.0325000 0.204412
+ 6.0327778 0.151145
+ 6.0330556 0.100970
+ 6.0333333 0.056319
+ 6.0336111 0.050000
+ 6.0338889 0.050000
+ 6.0341667 0.050000
+ 6.0344444 0.050000
+ 6.0347222 0.050000
+ 6.0350000 0.050000
+ 6.0352778 0.050000
+ 6.0355556 0.050000
+ 6.0358333 0.050000
+ 6.0361111 0.050000
+ 6.0363889 0.094258
+ 6.0366667 0.144397
+ 6.0369444 0.197937
+ 6.0372222 0.252399
+ 6.0375000 0.305304
+ 6.0377778 0.354172
+ 6.0380556 0.396526
+ 6.0383333 0.429884
+ 6.0386111 0.451768
+ 6.0388889 0.459699
+ 6.0391667 0.452022
+ 6.0394444 0.430376
+ 6.0397222 0.397225
+ 6.0400000 0.355033
+ 6.0402778 0.306264
+ 6.0405556 0.253382
+ 6.0408333 0.198851
+ 6.0411111 0.145134
+ 6.0413889 0.094696
+ 6.0416667 0.050000
+ 6.0419444 0.050000
+ 6.0422222 0.050000
+ 6.0425000 0.050000
+ 6.0427778 0.050000
+ 6.0430556 0.050000
+ 6.0433333 0.050000
+ 6.0436111 0.050000
+ 6.0438889 0.050000
+ 6.0441667 0.050000
+ 6.0444444 0.050000
+ 6.0447222 0.094661
+ 6.0450000 0.145055
+ 6.0452778 0.198723
+ 6.0455556 0.253208
+ 6.0458333 0.306053
+ 6.0461111 0.354800
+ 6.0463889 0.396992
+ 6.0466667 0.430171
+ 6.0469444 0.451879
+ 6.0472222 0.459660
+ 6.0475000 0.451875
+ 6.0477778 0.430161
+ 6.0480556 0.396979
+ 6.0483333 0.354784
+ 6.0486111 0.306035
+ 6.0488889 0.253189
+ 6.0491667 0.198705
+ 6.0494444 0.145041
+ 6.0497222 0.094653
+ 6.0500000 0.050000
+ 6.0502778 0.050000
+ 6.0505556 0.050000
+ 6.0508333 0.050000
+ 6.0511111 0.050000
+ 6.0513889 0.050000
+ 6.0516667 0.050000
+ 6.0519444 0.050000
+ 6.0522222 0.050000
+ 6.0525000 0.050000
+ 6.0527778 0.050000
+ 6.0530556 0.094657
+ 6.0533333 0.145049
+ 6.0536111 0.198720
+ 6.0538889 0.253210
+ 6.0541667 0.306061
+ 6.0544444 0.354816
+ 6.0547222 0.397015
+ 6.0550000 0.430201
+ 6.0552778 0.451915
+ 6.0555556 0.459699
+ 6.0558333 0.451915
+ 6.0561111 0.430200
+ 6.0563889 0.397014
+ 6.0566667 0.354814
+ 6.0569444 0.306059
+ 6.0572222 0.253208
+ 6.0575000 0.198718
+ 6.0577778 0.145048
+ 6.0580556 0.094656
+ 6.0583333 0.050000
+ 6.0586111 0.050000
+ 6.0588889 0.050000
+ 6.0591667 0.050000
+ 6.0594444 0.050000
+ 6.0597222 0.050000
+ 6.0600000 0.050000
+ 6.0602778 0.050000
+ 6.0605556 0.050000
+ 6.0608333 0.050000
+ 6.0611111 0.050000
+ 6.0613889 0.094649
+ 6.0616667 0.145032
+ 6.0619444 0.198691
+ 6.0622222 0.253169
+ 6.0625000 0.306008
+ 6.0627778 0.354751
+ 6.0630556 0.396940
+ 6.0633333 0.430117
+ 6.0636111 0.451826
+ 6.0638889 0.459608
+ 6.0641667 0.451825
+ 6.0644444 0.430115
+ 6.0647222 0.396937
+ 6.0650000 0.354747
+ 6.0652778 0.306004
+ 6.0655556 0.253164
+ 6.0658333 0.198687
+ 6.0661111 0.145028
+ 6.0663889 0.094647
+ 6.0666667 0.050000
+ 6.0669444 0.050000
+ 6.0672222 0.050000
+ 6.0675000 0.050000
+ 6.0677778 0.050000
+ 6.0680556 0.050000
+ 6.0683333 0.050000
+ 6.0686111 0.050000
+ 6.0688889 0.050000
+ 6.0691667 0.050000
+ 6.0694444 0.050000
+ 6.0697222 0.094646
+ 6.0700000 0.145026
+ 6.0702778 0.198683
+ 6.0705556 0.253159
+ 6.0708333 0.305996
+ 6.0711111 0.354738
+ 6.0713889 0.396926
+ 6.0716667 0.430103
+ 6.0719444 0.451812
+ 6.0722222 0.459595
+ 6.0725000 0.451813
+ 6.0727778 0.430105
+ 6.0730556 0.396928
+ 6.0733333 0.354740
+ 6.0736111 0.305999
+ 6.0738889 0.253162
+ 6.0741667 0.198685
+ 6.0744444 0.145028
+ 6.0747222 0.094647
+ 6.0750000 0.050000
+ 6.0752778 0.050000
+ 6.0755556 0.050000
+ 6.0758333 0.050000
+ 6.0761111 0.050000
+ 6.0763889 0.050000
+ 6.0766667 0.050000
+ 6.0769444 0.050000
+ 6.0772222 0.050000
+ 6.0775000 0.050000
+ 6.0777778 0.050000
+ 6.0780556 0.094653
+ 6.0783333 0.145041
+ 6.0786111 0.198708
+ 6.0788889 0.253194
+ 6.0791667 0.306042
+ 6.0794444 0.354793
+ 6.0797222 0.396990
+ 6.0800000 0.430174
+ 6.0802778 0.451888
+ 6.0805556 0.459673
+ 6.0808333 0.451891
+ 6.0811111 0.430179
+ 6.0813889 0.396997
+ 6.0816667 0.354802
+ 6.0819444 0.306052
+ 6.0822222 0.253204
+ 6.0825000 0.198717
+ 6.0827778 0.145049
+ 6.0830556 0.094657
+ 6.0833333 0.050000
+ 6.0836111 0.050000
+ 6.0838889 0.050000
+ 6.0841667 0.050000
+ 6.0844444 0.050000
+ 6.0847222 0.050000
+ 6.0850000 0.050000
+ 6.0852778 0.050000
+ 6.0855556 0.050000
+ 6.0858333 0.050000
+ 6.0861111 0.050000
+ 6.0863889 0.094668
+ 6.0866667 0.145074
+ 6.0869444 0.198758
+ 6.0872222 0.253260
+ 6.0875000 0.306119
+ 6.0877778 0.354877
+ 6.0880556 0.397072
+ 6.0883333 0.430245
+ 6.0886111 0.451937
+ 6.0888889 0.459686
+ 6.0891667 0.451855
+ 6.0894444 0.430086
+ 6.0897222 0.396846
+ 6.0900000 0.354598
+ 6.0902778 0.305809
+ 6.0905556 0.252942
+ 6.0908333 0.198462
+ 6.0911111 0.144836
+ 6.0913889 0.094527
+ 6.0916667 0.050000
+ 6.0919444 0.050000
+ 6.0922222 0.050000
+ 6.0925000 0.050000
+ 6.0927778 0.050000
+ 6.0930556 0.050000
+ 6.0933333 0.050000
+ 6.0936111 0.050000
+ 6.0938889 0.050000
+ 6.0941667 0.050000
+ 6.0944444 0.050000
+ 6.0947222 0.093994
+ 6.0950000 0.143618
+ 6.0952778 0.196510
+ 6.0955556 0.250306
+ 6.0958333 0.302644
+ 6.0961111 0.351160
+ 6.0963889 0.393492
+ 6.0966667 0.427277
+ 6.0969444 0.450151
+ 6.0972222 0.459752
+ 6.0975000 0.454496
+ 6.0977778 0.435925
+ 6.0980556 0.406359
+ 6.0983333 0.368117
+ 6.0986111 0.323521
+ 6.0988889 0.274891
+ 6.0991667 0.224548
+ 6.0994444 0.174813
+ 6.0997222 0.128004
+ 6.1000000 0.086444
+ 6.1002778 0.052065
+ 6.1005556 0.050000
+ 6.1008333 0.050000
+ 6.1011111 0.050000
+ 6.1013889 0.050000
+ 6.1016667 0.050000
+ 6.1019444 0.050000
+ 6.1022222 0.050000
+ 6.1025000 0.050000
+ 6.1027778 0.081698
+ 6.1030556 0.122127
+ 6.1033333 0.167833
+ 6.1036111 0.216621
+ 6.1038889 0.266293
+ 6.1041667 0.314652
+ 6.1044444 0.359501
+ 6.1047222 0.398643
+ 6.1050000 0.429881
+ 6.1052778 0.451017
+ 6.1055556 0.459856
+ 6.1058333 0.454921
+ 6.1061111 0.437622
+ 6.1063889 0.410091
+ 6.1066667 0.374458
+ 6.1069444 0.332854
+ 6.1072222 0.287412
+ 6.1075000 0.240261
+ 6.1077778 0.193534
+ 6.1080556 0.149362
+ 6.1083333 0.109875
+ 6.1086111 0.076859
+ 6.1088889 0.050712
+ 6.1091667 0.050000
+ 6.1094444 0.050000
+ 6.1097222 0.050000
+ 6.1100000 0.050000
+ 6.1102778 0.050000
+ 6.1105556 0.050000
+ 6.1108333 0.064459
+ 6.1111111 0.095165
+ 6.1113889 0.132861
+ 6.1116667 0.175823
+ 6.1119444 0.221976
+ 6.1122222 0.269242
+ 6.1125000 0.315546
+ 6.1127778 0.358810
+ 6.1130556 0.396957
+ 6.1133333 0.427911
+ 6.1136111 0.449596
+ 6.1138889 0.459935
+ 6.1141667 0.457511
+ 6.1144444 0.443553
+ 6.1147222 0.419951
+ 6.1150000 0.388592
+ 6.1152778 0.351366
+ 6.1155556 0.310162
+ 6.1158333 0.266870
+ 6.1161111 0.223377
+ 6.1163889 0.181573
+ 6.1166667 0.143347
+ 6.1169444 0.110317
+ 6.1172222 0.083013
+ 6.1175000 0.061696
+ 6.1177778 0.050000
+ 6.1180556 0.050000
+ 6.1183333 0.050000
+ 6.1186111 0.050000
+ 6.1188889 0.053997
+ 6.1191667 0.074052
+ 6.1194444 0.101912
+ 6.1197222 0.137430
+ 6.1200000 0.178829
+ 6.1202778 0.223928
+ 6.1205556 0.270545
+ 6.1208333 0.316498
+ 6.1211111 0.359604
+ 6.1213889 0.397682
+ 6.1216667 0.428549
+ 6.1219444 0.450023
+ 6.1222222 0.459922
+ 6.1225000 0.456758
+ 6.1227778 0.441821
+ 6.1230556 0.417096
+ 6.1233333 0.384568
+ 6.1236111 0.346221
+ 6.1238889 0.304038
+ 6.1241667 0.260006
+ 6.1244444 0.216108
+ 6.1247222 0.174329
+ 6.1250000 0.136653
+ 6.1252778 0.104755
+ 6.1255556 0.079068
+ 6.1258333 0.059716
+ 6.1261111 0.050000
+ 6.1263889 0.050000
+ 6.1266667 0.050000
+ 6.1269444 0.050000
+ 6.1272222 0.062303
+ 6.1275000 0.083555
+ 6.1277778 0.112006
+ 6.1280556 0.147421
+ 6.1283333 0.188124
+ 6.1286111 0.232081
+ 6.1288889 0.277256
+ 6.1291667 0.321616
+ 6.1294444 0.363125
+ 6.1297222 0.399749
+ 6.1300000 0.429453
+ 6.1302778 0.450202
+ 6.1305556 0.459961
+ 6.1308333 0.457337
+ 6.1311111 0.443501
+ 6.1313889 0.420266
+ 6.1316667 0.389444
+ 6.1319444 0.352848
+ 6.1322222 0.312290
+ 6.1325000 0.269584
+ 6.1327778 0.226540
+ 6.1330556 0.184973
+ 6.1333333 0.146694
+ 6.1336111 0.113269
+ 6.1338889 0.085267
+ 6.1341667 0.063012
+ 6.1344444 0.050000
+ 6.1347222 0.050000
+ 6.1350000 0.050000
+ 6.1352778 0.050000
+ 6.1355556 0.050000
+ 6.1358333 0.068254
+ 6.1361111 0.095270
+ 6.1363889 0.130199
+ 6.1366667 0.171281
+ 6.1369444 0.216335
+ 6.1372222 0.263183
+ 6.1375000 0.309647
+ 6.1377778 0.353548
+ 6.1380556 0.392707
+ 6.1383333 0.424946
+ 6.1386111 0.448086
+ 6.1388889 0.459948
+ 6.1391667 0.459028
+ 6.1394444 0.446519
+ 6.1397222 0.424289
+ 6.1400000 0.394206
+ 6.1402778 0.358138
+ 6.1405556 0.317953
+ 6.1408333 0.275517
+ 6.1411111 0.232699
+ 6.1413889 0.191367
+ 6.1416667 0.153389
+ 6.1419444 0.120368
+ 6.1422222 0.092854
+ 6.1425000 0.071133
+ 6.1427778 0.055491
+ 6.1430556 0.050000
+ 6.1433333 0.050000
+ 6.1436111 0.050000
+ 6.1438889 0.059427
+ 6.1441667 0.078466
+ 6.1444444 0.105299
+ 6.1447222 0.139806
+ 6.1450000 0.180247
+ 6.1452778 0.224476
+ 6.1455556 0.270347
+ 6.1458333 0.315715
+ 6.1461111 0.358435
+ 6.1463889 0.396359
+ 6.1466667 0.427344
+ 6.1469444 0.449242
+ 6.1472222 0.459908
+ 6.1475000 0.457871
+ 6.1477778 0.444350
+ 6.1480556 0.421239
+ 6.1483333 0.390433
+ 6.1486111 0.353824
+ 6.1488889 0.313308
+ 6.1491667 0.270778
+ 6.1494444 0.228127
+ 6.1497222 0.187251
+ 6.1500000 0.150042
+ 6.1502778 0.118113
+ 6.1505556 0.091955
+ 6.1508333 0.071774
+ 6.1511111 0.057780
+ 6.1513889 0.050181
+ 6.1516667 0.050000
+ 6.1519444 0.054999
+ 6.1522222 0.067833
+ 6.1525000 0.087895
+ 6.1527778 0.115393
+ 6.1530556 0.150149
+ 6.1533333 0.190448
+ 6.1536111 0.234184
+ 6.1538889 0.279257
+ 6.1541667 0.323563
+ 6.1544444 0.364998
+ 6.1547222 0.401461
+ 6.1550000 0.430849
+ 6.1552778 0.451059
+ 6.1555556 0.459987
+ 6.1558333 0.456202
+ 6.1561111 0.440953
+ 6.1563889 0.416160
+ 6.1566667 0.383743
+ 6.1569444 0.345622
+ 6.1572222 0.303717
+ 6.1575000 0.259947
+ 6.1577778 0.216234
+ 6.1580556 0.174495
+ 6.1583333 0.136653
+ 6.1586111 0.104336
+ 6.1588889 0.078017
+ 6.1591667 0.057879
+ 6.1594444 0.050000
+ 6.1597222 0.050000
+ 6.1600000 0.050000
+ 6.1602778 0.050000
+ 6.1605556 0.056278
+ 6.1608333 0.077053
+ 6.1611111 0.105286
+ 6.1613889 0.140780
+ 6.1616667 0.181829
+ 6.1619444 0.226348
+ 6.1622222 0.272251
+ 6.1625000 0.317454
+ 6.1627778 0.359870
+ 6.1630556 0.397415
+ 6.1633333 0.428005
+ 6.1636111 0.449553
+ 6.1638889 0.459974
+ 6.1641667 0.457837
+ 6.1644444 0.444322
+ 6.1647222 0.421263
+ 6.1650000 0.390496
+ 6.1652778 0.353852
+ 6.1655556 0.313167
+ 6.1658333 0.270275
+ 6.1661111 0.227009
+ 6.1663889 0.185205
+ 6.1666667 0.146694
+ 6.1669444 0.113062
+ 6.1672222 0.084886
+ 6.1675000 0.062495
+ 6.1677778 0.050000
+ 6.1680556 0.050000
+ 6.1683333 0.050000
+ 6.1686111 0.050000
+ 6.1688889 0.050000
+ 6.1691667 0.067978
+ 6.1694444 0.095257
+ 6.1697222 0.130518
+ 6.1700000 0.171966
+ 6.1702778 0.217381
+ 6.1705556 0.264544
+ 6.1708333 0.311234
+ 6.1711111 0.355231
+ 6.1713889 0.394315
+ 6.1716667 0.426268
+ 6.1719444 0.448868
+ 6.1722222 0.459895
+ 6.1725000 0.457826
+ 6.1727778 0.443912
+ 6.1730556 0.420102
+ 6.1733333 0.388345
+ 6.1736111 0.350589
+ 6.1738889 0.308781
+ 6.1741667 0.264870
+ 6.1744444 0.220804
+ 6.1747222 0.178531
+ 6.1750000 0.140000
+ 6.1752778 0.106871
+ 6.1755556 0.079658
+ 6.1758333 0.058585
+ 6.1761111 0.050000
+ 6.1763889 0.050000
+ 6.1766667 0.050000
+ 6.1769444 0.050000
+ 6.1772222 0.053227
+ 6.1775000 0.073736
+ 6.1777778 0.101965
+ 6.1780556 0.137740
+ 6.1783333 0.179295
+ 6.1786111 0.224465
+ 6.1788889 0.271083
+ 6.1791667 0.316985
+ 6.1794444 0.360004
+ 6.1797222 0.397976
+ 6.1800000 0.428734
+ 6.1802778 0.450113
+ 6.1805556 0.459948
+ 6.1808333 0.456756
+ 6.1811111 0.441786
+ 6.1813889 0.416972
+ 6.1816667 0.384246
+ 6.1819444 0.345540
+ 6.1822222 0.302787
+ 6.1825000 0.257920
+ 6.1827778 0.212871
+ 6.1830556 0.169573
+ 6.1833333 0.129958
+ 6.1836111 0.095683
+ 6.1838889 0.067299
+ 6.1841667 0.050000
+ 6.1844444 0.050000
+ 6.1847222 0.050000
+ 6.1850000 0.050000
+ 6.1852778 0.050000
+ 6.1855556 0.050000
+ 6.1858333 0.056558
+ 6.1861111 0.085163
+ 6.1863889 0.121709
+ 6.1866667 0.164390
+ 6.1869444 0.210982
+ 6.1872222 0.259263
+ 6.1875000 0.307009
+ 6.1877778 0.351998
+ 6.1880556 0.392006
+ 6.1883333 0.424812
+ 6.1886111 0.448191
+ 6.1888889 0.459922
+ 6.1891667 0.458473
+ 6.1894444 0.445084
+ 6.1897222 0.421687
+ 6.1900000 0.390216
+ 6.1902778 0.352600
+ 6.1905556 0.310774
+ 6.1908333 0.266669
+ 6.1911111 0.222217
+ 6.1913889 0.179350
+ 6.1916667 0.140000
+ 6.1919444 0.105827
+ 6.1922222 0.077396
+ 6.1925000 0.055002
+ 6.1927778 0.050000
+ 6.1930556 0.050000
+ 6.1933333 0.050000
+ 6.1936111 0.050000
+ 6.1938889 0.050000
+ 6.1941667 0.063815
+ 6.1944444 0.091884
+ 6.1947222 0.127912
+ 6.1950000 0.170084
+ 6.1952778 0.216159
+ 6.1955556 0.263898
+ 6.1958333 0.311062
+ 6.1961111 0.355412
+ 6.1963889 0.394708
+ 6.1966667 0.426711
+ 6.1969444 0.449183
+ 6.1972222 0.459882
+ 6.1975000 0.457278
+ 6.1977778 0.442663
+ 6.1980556 0.418036
+ 6.1983333 0.385398
+ 6.1986111 0.346747
+ 6.1988889 0.304085
+ 6.1991667 0.259410
+ 6.1994444 0.214722
+ 6.1997222 0.172020
+ 6.2000000 0.133306
+ 6.2002778 0.100273
+ 6.2005556 0.073407
+ 6.2008333 0.052885
+ 6.2011111 0.050000
+ 6.2013889 0.050000
+ 6.2016667 0.050000
+ 6.2019444 0.050000
+ 6.2022222 0.051725
+ 6.2025000 0.073038
+ 6.2027778 0.101951
+ 6.2030556 0.138256
+ 6.2033333 0.180187
+ 6.2036111 0.225593
+ 6.2038889 0.272320
+ 6.2041667 0.318217
+ 6.2044444 0.361130
+ 6.2047222 0.398907
+ 6.2050000 0.429395
+ 6.2052778 0.450442
+ 6.2055556 0.459895
+ 6.2058333 0.456285
+ 6.2061111 0.440877
+ 6.2063889 0.415618
+ 6.2066667 0.382456
+ 6.2069444 0.343339
+ 6.2072222 0.300216
+ 6.2075000 0.255033
+ 6.2077778 0.209740
+ 6.2080556 0.166283
+ 6.2083333 0.126611
+ 6.2086111 0.092390
+ 6.2088889 0.064162
+ 6.2091667 0.050000
+ 6.2094444 0.050000
+ 6.2097222 0.050000
+ 6.2100000 0.050000
+ 6.2102778 0.050000
+ 6.2105556 0.050000
+ 6.2108333 0.056092
+ 6.2111111 0.085124
+ 6.2113889 0.122063
+ 6.2116667 0.165088
+ 6.2119444 0.211962
+ 6.2122222 0.260447
+ 6.2125000 0.308304
+ 6.2127778 0.353298
+ 6.2130556 0.393191
+ 6.2133333 0.425744
+ 6.2136111 0.448720
+ 6.2138889 0.459882
+ 6.2141667 0.457693
+ 6.2144444 0.443418
+ 6.2147222 0.419022
+ 6.2150000 0.386471
+ 6.2152778 0.347729
+ 6.2155556 0.304763
+ 6.2158333 0.259537
+ 6.2161111 0.214018
+ 6.2163889 0.170170
+ 6.2166667 0.129958
+ 6.2169444 0.095071
+ 6.2172222 0.066080
+ 6.2175000 0.050000
+ 6.2177778 0.050000
+ 6.2180556 0.050000
+ 6.2183333 0.050000
+ 6.2186111 0.050000
+ 6.2188889 0.050000
+ 6.2191667 0.053020
+ 6.2194444 0.081816
+ 6.2197222 0.118733
+ 6.2200000 0.161921
+ 6.2202778 0.209103
+ 6.2205556 0.258001
+ 6.2208333 0.306336
+ 6.2211111 0.351830
+ 6.2213889 0.392207
+ 6.2216667 0.425186
+ 6.2219444 0.448491
+ 6.2222222 0.459843
+ 6.2225000 0.457680
+ 6.2227778 0.443299
+ 6.2230556 0.418713
+ 6.2233333 0.385935
+ 6.2236111 0.346978
+ 6.2238889 0.303855
+ 6.2241667 0.258578
+ 6.2244444 0.213161
+ 6.2247222 0.169617
+ 6.2250000 0.129958
+ 6.2252778 0.095900
+ 6.2255556 0.067964
+ 6.2258333 0.050000
+ 6.2261111 0.050000
+ 6.2263889 0.050000
+ 6.2266667 0.050000
+ 6.2269444 0.050000
+ 6.2272222 0.050000
+ 6.2275000 0.062724
+ 6.2277778 0.091857
+ 6.2280556 0.128727
+ 6.2283333 0.171516
+ 6.2286111 0.217998
+ 6.2288889 0.265949
+ 6.2291667 0.313143
+ 6.2294444 0.357356
+ 6.2297222 0.396361
+ 6.2300000 0.427934
+ 6.2302778 0.449850
+ 6.2305556 0.459882
+ 6.2308333 0.456510
+ 6.2311111 0.441020
+ 6.2313889 0.415407
+ 6.2316667 0.381660
+ 6.2319444 0.341771
+ 6.2322222 0.297733
+ 6.2325000 0.251537
+ 6.2327778 0.205174
+ 6.2330556 0.160637
+ 6.2333333 0.119917
+ 6.2336111 0.084719
+ 6.2338889 0.055608
+ 6.2341667 0.050000
+ 6.2344444 0.050000
+ 6.2347222 0.050000
+ 6.2350000 0.050000
+ 6.2352778 0.050000
+ 6.2355556 0.050000
+ 6.2358333 0.050000
+ 6.2361111 0.075095
+ 6.2363889 0.112810
+ 6.2366667 0.156813
+ 6.2369444 0.204809
+ 6.2372222 0.254503
+ 6.2375000 0.303601
+ 6.2377778 0.349807
+ 6.2380556 0.390828
+ 6.2383333 0.424369
+ 6.2386111 0.448134
+ 6.2388889 0.459830
+ 6.2391667 0.457880
+ 6.2394444 0.443582
+ 6.2397222 0.418952
+ 6.2400000 0.386006
+ 6.2402778 0.346761
+ 6.2405556 0.303233
+ 6.2408333 0.257437
+ 6.2411111 0.211391
+ 6.2413889 0.167110
+ 6.2416667 0.126611
+ 6.2419444 0.091618
+ 6.2422222 0.062691
+ 6.2425000 0.050000
+ 6.2427778 0.050000
+ 6.2430556 0.050000
+ 6.2433333 0.050000
+ 6.2436111 0.050000
+ 6.2438889 0.050000
+ 6.2441667 0.052547
+ 6.2444444 0.081790
+ 6.2447222 0.119085
+ 6.2450000 0.162575
+ 6.2452778 0.209980
+ 6.2455556 0.259018
+ 6.2458333 0.307409
+ 6.2461111 0.352870
+ 6.2463889 0.393122
+ 6.2466667 0.425882
+ 6.2469444 0.448870
+ 6.2472222 0.459804
+ 6.2475000 0.457122
+ 6.2477778 0.442138
+ 6.2480556 0.416884
+ 6.2483333 0.383393
+ 6.2486111 0.343696
+ 6.2488889 0.299826
+ 6.2491667 0.253815
+ 6.2494444 0.207697
+ 6.2497222 0.163502
+ 6.2500000 0.123264
+ 6.2502778 0.088714
+ 6.2505556 0.060383
+ 6.2508333 0.050000
+ 6.2511111 0.050000
+ 6.2513889 0.050000
+ 6.2516667 0.050000
+ 6.2519444 0.050000
+ 6.2522222 0.050000
+ 6.2525000 0.055467
+ 6.2527778 0.085150
+ 6.2530556 0.122702
+ 6.2533333 0.166275
+ 6.2536111 0.213604
+ 6.2538889 0.262424
+ 6.2541667 0.310473
+ 6.2544444 0.355484
+ 6.2547222 0.395193
+ 6.2550000 0.427337
+ 6.2552778 0.449651
+ 6.2555556 0.459869
+ 6.2558333 0.456447
+ 6.2561111 0.440708
+ 6.2563889 0.414696
+ 6.2566667 0.380453
+ 6.2569444 0.340024
+ 6.2572222 0.295450
+ 6.2575000 0.248774
+ 6.2577778 0.202040
+ 6.2580556 0.157291
+ 6.2583333 0.116569
+ 6.2586111 0.081616
+ 6.2588889 0.052965
+ 6.2591667 0.050000
+ 6.2594444 0.050000
+ 6.2597222 0.050000
+ 6.2600000 0.050000
+ 6.2602778 0.050000
+ 6.2605556 0.050000
+ 6.2608333 0.050000
+ 6.2611111 0.078403
+ 6.2613889 0.116467
+ 6.2616667 0.160634
+ 6.2619444 0.208623
+ 6.2622222 0.258151
+ 6.2625000 0.306938
+ 6.2627778 0.352700
+ 6.2630556 0.393156
+ 6.2633333 0.426024
+ 6.2636111 0.449022
+ 6.2638889 0.459869
+ 6.2641667 0.457005
+ 6.2644444 0.441756
+ 6.2647222 0.416174
+ 6.2650000 0.382307
+ 6.2652778 0.342206
+ 6.2655556 0.297919
+ 6.2658333 0.251497
+ 6.2661111 0.204990
+ 6.2663889 0.160446
+ 6.2666667 0.119917
+ 6.2669444 0.085146
+ 6.2672222 0.056661
+ 6.2675000 0.050000
+ 6.2677778 0.050000
+ 6.2680556 0.050000
+ 6.2683333 0.050000
+ 6.2686111 0.050000
+ 6.2688889 0.050000
+ 6.2691667 0.051973
+ 6.2694444 0.081790
+ 6.2697222 0.119483
+ 6.2700000 0.163212
+ 6.2702778 0.210722
+ 6.2705556 0.259760
+ 6.2708333 0.308072
+ 6.2711111 0.353405
+ 6.2713889 0.393503
+ 6.2716667 0.426113
+ 6.2719444 0.448983
+ 6.2722222 0.459856
+ 6.2725000 0.457194
+ 6.2727778 0.442311
+ 6.2730556 0.417233
+ 6.2733333 0.383991
+ 6.2736111 0.344610
+ 6.2738889 0.301119
+ 6.2741667 0.255546
+ 6.2744444 0.209918
+ 6.2747222 0.166264
+ 6.2750000 0.126611
+ 6.2752778 0.092683
+ 6.2755556 0.064985
+ 6.2758333 0.050000
+ 6.2761111 0.050000
+ 6.2763889 0.050000
+ 6.2766667 0.050000
+ 6.2769444 0.050000
+ 6.2772222 0.050000
+ 6.2775000 0.062474
+ 6.2777778 0.091871
+ 6.2780556 0.128909
+ 6.2783333 0.171782
+ 6.2786111 0.218283
+ 6.2788889 0.266203
+ 6.2791667 0.313334
+ 6.2794444 0.357469
+ 6.2797222 0.396399
+ 6.2800000 0.427916
+ 6.2802778 0.449813
+ 6.2805556 0.459882
+ 6.2808333 0.456611
+ 6.2811111 0.441268
+ 6.2813889 0.415822
+ 6.2816667 0.382237
+ 6.2819444 0.342480
+ 6.2822222 0.298516
+ 6.2825000 0.252312
+ 6.2827778 0.205834
+ 6.2830556 0.161046
+ 6.2833333 0.119917
+ 6.2836111 0.084136
+ 6.2838889 0.054302
+ 6.2841667 0.050000
+ 6.2844444 0.050000
+ 6.2847222 0.050000
+ 6.2850000 0.050000
+ 6.2852778 0.050000
+ 6.2855556 0.050000
+ 6.2858333 0.050000
+ 6.2861111 0.068388
+ 6.2863889 0.106140
+ 6.2866667 0.150411
+ 6.2869444 0.198874
+ 6.2872222 0.249199
+ 6.2875000 0.299057
+ 6.2877778 0.346119
+ 6.2880556 0.388056
+ 6.2883333 0.422540
+ 6.2886111 0.447241
+ 6.2888889 0.459830
+ 6.2891667 0.458702
+ 6.2894444 0.445140
+ 6.2897222 0.421154
+ 6.2900000 0.388749
+ 6.2902778 0.349933
+ 6.2905556 0.306715
+ 6.2908333 0.261100
+ 6.2911111 0.215098
+ 6.2913889 0.170715
+ 6.2916667 0.129958
+ 6.2919444 0.094551
+ 6.2922222 0.065075
+ 6.2925000 0.050000
+ 6.2927778 0.050000
+ 6.2930556 0.050000
+ 6.2933333 0.050000
+ 6.2936111 0.050000
+ 6.2938889 0.050000
+ 6.2941667 0.050000
+ 6.2944444 0.078442
+ 6.2947222 0.115289
+ 6.2950000 0.158471
+ 6.2952778 0.205722
+ 6.2955556 0.254771
+ 6.2958333 0.303351
+ 6.2961111 0.349192
+ 6.2963889 0.390027
+ 6.2966667 0.423586
+ 6.2969444 0.447601
+ 6.2972222 0.459804
+ 6.2975000 0.458629
+ 6.2977778 0.445325
+ 6.2980556 0.421847
+ 6.2983333 0.390146
+ 6.2986111 0.352176
+ 6.2988889 0.309891
+ 6.2991667 0.265243
+ 6.2994444 0.220185
+ 6.2997222 0.176671
+ 6.3000000 0.136653
+ 6.3002778 0.101811
+ 6.3005556 0.072733
+ 6.3008333 0.050000
+ 6.3011111 0.050000
+ 6.3013889 0.050000
+ 6.3016667 0.050000
+ 6.3019444 0.050000
+ 6.3022222 0.050000
+ 6.3025000 0.056860
+ 6.3027778 0.085163
+ 6.3030556 0.121616
+ 6.3033333 0.164373
+ 6.3036111 0.211155
+ 6.3038889 0.259682
+ 6.3041667 0.307676
+ 6.3044444 0.352857
+ 6.3047222 0.392948
+ 6.3050000 0.425668
+ 6.3052778 0.448739
+ 6.3055556 0.459882
+ 6.3058333 0.457531
+ 6.3061111 0.442971
+ 6.3063889 0.418198
+ 6.3066667 0.385210
+ 6.3069444 0.346004
+ 6.3072222 0.302577
+ 6.3075000 0.256927
+ 6.3077778 0.211052
+ 6.3080556 0.166947
+ 6.3083333 0.126611
+ 6.3086111 0.091753
+ 6.3088889 0.062929
+ 6.3091667 0.050000
+ 6.3094444 0.050000
+ 6.3097222 0.050000
+ 6.3100000 0.050000
+ 6.3102778 0.050000
+ 6.3105556 0.050000
+ 6.3108333 0.052674
+ 6.3111111 0.081790
+ 6.3113889 0.118934
+ 6.3116667 0.162264
+ 6.3119444 0.209516
+ 6.3122222 0.258425
+ 6.3125000 0.306728
+ 6.3127778 0.352159
+ 6.3130556 0.392455
+ 6.3133333 0.425350
+ 6.3136111 0.448581
+ 6.3138889 0.459882
+ 6.3141667 0.457709
+ 6.3144444 0.443386
+ 6.3147222 0.418957
+ 6.3150000 0.386465
+ 6.3152778 0.347955
+ 6.3155556 0.305470
+ 6.3158333 0.261054
+ 6.3161111 0.216749
+ 6.3163889 0.174601
+ 6.3166667 0.136653
+ 6.3169444 0.104625
+ 6.3172222 0.078950
+ 6.3175000 0.059735
+ 6.3177778 0.050000
+ 6.3180556 0.050000
+ 6.3183333 0.050000
+ 6.3186111 0.050000
+ 6.3188889 0.064395
+ 6.3191667 0.086236
+ 6.3194444 0.115301
+ 6.3197222 0.151332
+ 6.3200000 0.192601
+ 6.3202778 0.237014
+ 6.3205556 0.282476
+ 6.3208333 0.326894
+ 6.3211111 0.368174
+ 6.3213889 0.404219
+ 6.3216667 0.432937
+ 6.3219444 0.452234
+ 6.3222222 0.460013
+ 6.3225000 0.454871
+ 6.3227778 0.438163
+ 6.3230556 0.411930
+ 6.3233333 0.378218
+ 6.3236111 0.339069
+ 6.3238889 0.296528
+ 6.3241667 0.252637
+ 6.3244444 0.209441
+ 6.3247222 0.168982
+ 6.3250000 0.133306
+ 6.3252778 0.104104
+ 6.3255556 0.081669
+ 6.3258333 0.065942
+ 6.3261111 0.056865
+ 6.3263889 0.054379
+ 6.3266667 0.058426
+ 6.3269444 0.068947
+ 6.3272222 0.085884
+ 6.3275000 0.109178
+ 6.3277778 0.138771
+ 6.3280556 0.174296
+ 6.3283333 0.214153
+ 6.3286111 0.256436
+ 6.3288889 0.299236
+ 6.3291667 0.340645
+ 6.3294444 0.378756
+ 6.3297222 0.411661
+ 6.3300000 0.437453
+ 6.3302778 0.454224
+ 6.3305556 0.460065
+ 6.3308333 0.453710
+ 6.3311111 0.436443
+ 6.3313889 0.410192
+ 6.3316667 0.376883
+ 6.3319444 0.338441
+ 6.3322222 0.296792
+ 6.3325000 0.253863
+ 6.3327778 0.211579
+ 6.3330556 0.171867
+ 6.3333333 0.136653
+ 6.3336111 0.107541
+ 6.3338889 0.084858
+ 6.3341667 0.068608
+ 6.3344444 0.058796
+ 6.3347222 0.055426
+ 6.3350000 0.058504
+ 6.3352778 0.068034
+ 6.3355556 0.084021
+ 6.3358333 0.106469
+ 6.3361111 0.135384
+ 6.3363889 0.170450
+ 6.3366667 0.210064
+ 6.3369444 0.252305
+ 6.3372222 0.295250
+ 6.3375000 0.336978
+ 6.3377778 0.375567
+ 6.3380556 0.409093
+ 6.3383333 0.435635
+ 6.3386111 0.453271
+ 6.3388889 0.460078
+ 6.3391667 0.454775
+ 6.3394444 0.438641
+ 6.3397222 0.413596
+ 6.3400000 0.381560
+ 6.3402778 0.344452
+ 6.3405556 0.304193
+ 6.3408333 0.262703
+ 6.3411111 0.221901
+ 6.3413889 0.183707
+ 6.3416667 0.150042
+ 6.3419444 0.122495
+ 6.3422222 0.101340
+ 6.3425000 0.086522
+ 6.3427778 0.077984
+ 6.3430556 0.075670
+ 6.3433333 0.079526
+ 6.3436111 0.089495
+ 6.3438889 0.105520
+ 6.3441667 0.127548
+ 6.3444444 0.155520
+ 6.3447222 0.189093
+ 6.3450000 0.226760
+ 6.3452778 0.266727
+ 6.3455556 0.307199
+ 6.3458333 0.346381
+ 6.3461111 0.382477
+ 6.3463889 0.413695
+ 6.3466667 0.438237
+ 6.3469444 0.454310
+ 6.3472222 0.460118
+ 6.3475000 0.454468
+ 6.3477778 0.438571
+ 6.3480556 0.414241
+ 6.3483333 0.383290
+ 6.3486111 0.347532
+ 6.3488889 0.308779
+ 6.3491667 0.268845
+ 6.3494444 0.229542
+ 6.3497222 0.192684
+ 6.3500000 0.160083
+ 6.3502778 0.133248
+ 6.3505556 0.112468
+ 6.3508333 0.097727
+ 6.3511111 0.089008
+ 6.3513889 0.086297
+ 6.3516667 0.089577
+ 6.3519444 0.098832
+ 6.3522222 0.114047
+ 6.3525000 0.135206
+ 6.3527778 0.162293
+ 6.3530556 0.194996
+ 6.3533333 0.231822
+ 6.3536111 0.270982
+ 6.3538889 0.310686
+ 6.3541667 0.349145
+ 6.3544444 0.384570
+ 6.3547222 0.415172
+ 6.3550000 0.439161
+ 6.3552778 0.454748
+ 6.3555556 0.460144
+ 6.3558333 0.454153
+ 6.3561111 0.437953
+ 6.3563889 0.413315
+ 6.3566667 0.382011
+ 6.3569444 0.345811
+ 6.3572222 0.306489
+ 6.3575000 0.265814
+ 6.3577778 0.225558
+ 6.3580556 0.187492
+ 6.3583333 0.153389
+ 6.3586111 0.124737
+ 6.3588889 0.101904
+ 6.3591667 0.084972
+ 6.3594444 0.074028
+ 6.3597222 0.069155
+ 6.3600000 0.070438
+ 6.3602778 0.077962
+ 6.3605556 0.091811
+ 6.3608333 0.112070
+ 6.3611111 0.138823
+ 6.3613889 0.171834
+ 6.3616667 0.209575
+ 6.3619444 0.250200
+ 6.3622222 0.291860
+ 6.3625000 0.332709
+ 6.3627778 0.370897
+ 6.3630556 0.404577
+ 6.3633333 0.431901
+ 6.3636111 0.451022
+ 6.3638889 0.460092
+ 6.3641667 0.457847
+ 6.3644444 0.445368
+ 6.3647222 0.424319
+ 6.3650000 0.396364
+ 6.3652778 0.363167
+ 6.3655556 0.326394
+ 6.3658333 0.287708
+ 6.3661111 0.248774
+ 6.3663889 0.211256
+ 6.3666667 0.176819
+ 6.3669444 0.146896
+ 6.3672222 0.121986
+ 6.3675000 0.102361
+ 6.3677778 0.088288
+ 6.3680556 0.080038
+ 6.3683333 0.077879
+ 6.3686111 0.082081
+ 6.3688889 0.092912
+ 6.3691667 0.110643
+ 6.3694444 0.135541
+ 6.3697222 0.167499
+ 6.3700000 0.204896
+ 6.3702778 0.245733
+ 6.3705556 0.288011
+ 6.3708333 0.329731
+ 6.3711111 0.368895
+ 6.3713889 0.403504
+ 6.3716667 0.431559
+ 6.3719444 0.451062
+ 6.3722222 0.460013
+ 6.3725000 0.457052
+ 6.3727778 0.443365
+ 6.3730556 0.420779
+ 6.3733333 0.391118
+ 6.3736111 0.356207
+ 6.3738889 0.317871
+ 6.3741667 0.277935
+ 6.3744444 0.238224
+ 6.3747222 0.200563
+ 6.3750000 0.166778
+ 6.3752778 0.138401
+ 6.3755556 0.115802
+ 6.3758333 0.099058
+ 6.3761111 0.088247
+ 6.3763889 0.083446
+ 6.3766667 0.084732
+ 6.3769444 0.092184
+ 6.3772222 0.105878
+ 6.3775000 0.125892
+ 6.3777778 0.152304
+ 6.3780556 0.184865
+ 6.3783333 0.222028
+ 6.3786111 0.261920
+ 6.3788889 0.302666
+ 6.3791667 0.342393
+ 6.3794444 0.379229
+ 6.3797222 0.411299
+ 6.3800000 0.436730
+ 6.3802778 0.453649
+ 6.3805556 0.460183
+ 6.3808333 0.455066
+ 6.3811111 0.439463
+ 6.3813889 0.415149
+ 6.3816667 0.383898
+ 6.3819444 0.347483
+ 6.3822222 0.307679
+ 6.3825000 0.266258
+ 6.3827778 0.224996
+ 6.3830556 0.185666
+ 6.3833333 0.150042
+ 6.3836111 0.119631
+ 6.3838889 0.094879
+ 6.3841667 0.075965
+ 6.3844444 0.063068
+ 6.3847222 0.056366
+ 6.3850000 0.056039
+ 6.3852778 0.062267
+ 6.3855556 0.075226
+ 6.3858333 0.095098
+ 6.3861111 0.122061
+ 6.3863889 0.155933
+ 6.3866667 0.195087
+ 6.3869444 0.237536
+ 6.3872222 0.281293
+ 6.3875000 0.324370
+ 6.3877778 0.364780
+ 6.3880556 0.400535
+ 6.3883333 0.429649
+ 6.3886111 0.450133
+ 6.3888889 0.460000
+ 6.3891667 0.457879
+ 6.3894444 0.444861
+ 6.3897222 0.422655
+ 6.3900000 0.392968
+ 6.3902778 0.357508
+ 6.3905556 0.317983
+ 6.3908333 0.276101
+ 6.3911111 0.233569
+ 6.3913889 0.192096
+ 6.3916667 0.153389
+ 6.3919444 0.118947
+ 6.3922222 0.089433
+ 6.3925000 0.065301
+ 6.3927778 0.050000
+ 6.3930556 0.050000
+ 6.3933333 0.050000
+ 6.3936111 0.050000
+ 6.3938889 0.050000
+ 6.3941667 0.058979
+ 6.3944444 0.085241
+ 6.3947222 0.120062
+ 6.3950000 0.161599
+ 6.3952778 0.207554
+ 6.3955556 0.255628
+ 6.3958333 0.303522
+ 6.3961111 0.348938
+ 6.3963889 0.389575
+ 6.3966667 0.423136
+ 6.3969444 0.447320
+ 6.3972222 0.459830
+ 6.3975000 0.459066
+ 6.3977778 0.446226
+ 6.3980556 0.423210
+ 6.3983333 0.391916
+ 6.3986111 0.354244
+ 6.3988889 0.312091
+ 6.3991667 0.267357
+ 6.3994444 0.221940
+ 6.3997222 0.177739
+ 6.4000000 0.136653
+ 6.4002778 0.100334
+ 6.4005556 0.069449
+ 6.4008333 0.050000
+ 6.4011111 0.050000
+ 6.4013889 0.050000
+ 6.4016667 0.050000
+ 6.4019444 0.050000
+ 6.4022222 0.050000
+ 6.4025000 0.050000
+ 6.4027778 0.068518
+ 6.4030556 0.105021
+ 6.4033333 0.148391
+ 6.4036111 0.196270
+ 6.4038889 0.246304
+ 6.4041667 0.296136
+ 6.4044444 0.343410
+ 6.4047222 0.385770
+ 6.4050000 0.420860
+ 6.4052778 0.446323
+ 6.4055556 0.459804
+ 6.4058333 0.459662
+ 6.4061111 0.447123
+ 6.4063889 0.424125
+ 6.4066667 0.392610
+ 6.4069444 0.354517
+ 6.4072222 0.311788
+ 6.4075000 0.266361
+ 6.4077778 0.220179
+ 6.4080556 0.175180
+ 6.4083333 0.133306
+ 6.4086111 0.096244
+ 6.4088889 0.064678
+ 6.4091667 0.050000
+ 6.4094444 0.050000
+ 6.4097222 0.050000
+ 6.4100000 0.050000
+ 6.4102778 0.050000
+ 6.4105556 0.050000
+ 6.4108333 0.050000
+ 6.4111111 0.061706
+ 6.4113889 0.098526
+ 6.4116667 0.142345
+ 6.4119444 0.190788
+ 6.4122222 0.241478
+ 6.4125000 0.292040
+ 6.4127778 0.340099
+ 6.4130556 0.383279
+ 6.4133333 0.419205
+ 6.4136111 0.445500
+ 6.4138889 0.459791
+ 6.4141667 0.460417
+ 6.4144444 0.448588
+ 6.4147222 0.426230
+ 6.4150000 0.395267
+ 6.4152778 0.357627
+ 6.4155556 0.315234
+ 6.4158333 0.270015
+ 6.4161111 0.223894
+ 6.4163889 0.178798
+ 6.4166667 0.136653
+ 6.4169444 0.099141
+ 6.4172222 0.066974
+ 6.4175000 0.050000
+ 6.4177778 0.050000
+ 6.4180556 0.050000
+ 6.4183333 0.050000
+ 6.4186111 0.050000
+ 6.4188889 0.050000
+ 6.4191667 0.050000
+ 6.4194444 0.058385
+ 6.4197222 0.094966
+ 6.4200000 0.138722
+ 6.4202778 0.187257
+ 6.4205556 0.238179
+ 6.4208333 0.289092
+ 6.4211111 0.337603
+ 6.4213889 0.381317
+ 6.4216667 0.417841
+ 6.4219444 0.444779
+ 6.4222222 0.459738
+ 6.4225000 0.461040
+ 6.4227778 0.449872
+ 6.4230556 0.428137
+ 6.4233333 0.397739
+ 6.4236111 0.360580
+ 6.4238889 0.318564
+ 6.4241667 0.273595
+ 6.4244444 0.227576
+ 6.4247222 0.182410
+ 6.4250000 0.140000
+ 6.4252778 0.102019
+ 6.4255556 0.069214
+ 6.4258333 0.050000
+ 6.4261111 0.050000
+ 6.4263889 0.050000
+ 6.4266667 0.050000
+ 6.4269444 0.050000
+ 6.4272222 0.050000
+ 6.4275000 0.050000
+ 6.4277778 0.055077
+ 6.4280556 0.091601
+ 6.4283333 0.135508
+ 6.4286111 0.184358
+ 6.4288889 0.235712
+ 6.4291667 0.287129
+ 6.4294444 0.336169
+ 6.4297222 0.380393
+ 6.4300000 0.417360
+ 6.4302778 0.444631
+ 6.4305556 0.459765
+ 6.4308333 0.461052
+ 6.4311111 0.449701
+ 6.4313889 0.427653
+ 6.4316667 0.396845
+ 6.4319444 0.359217
+ 6.4322222 0.316709
+ 6.4325000 0.271259
+ 6.4327778 0.224807
+ 6.4330556 0.179292
+ 6.4333333 0.136653
+ 6.4336111 0.098589
+ 6.4338889 0.065840
+ 6.4341667 0.050000
+ 6.4344444 0.050000
+ 6.4347222 0.050000
+ 6.4350000 0.050000
+ 6.4352778 0.050000
+ 6.4355556 0.050000
+ 6.4358333 0.050000
+ 6.4361111 0.055051
+ 6.4363889 0.092095
+ 6.4366667 0.136478
+ 6.4369444 0.185735
+ 6.4372222 0.237397
+ 6.4375000 0.288999
+ 6.4377778 0.338075
+ 6.4380556 0.382157
+ 6.4383333 0.418779
+ 6.4386111 0.445475
+ 6.4388889 0.459778
+ 6.4391667 0.459966
+ 6.4394444 0.447296
+ 6.4397222 0.423770
+ 6.4400000 0.391389
+ 6.4402778 0.352156
+ 6.4405556 0.308072
+ 6.4408333 0.261140
+ 6.4411111 0.213359
+ 6.4413889 0.166734
+ 6.4416667 0.123264
+ 6.4419444 0.084701
+ 6.4422222 0.051792
+ 6.4425000 0.050000
+ 6.4427778 0.050000
+ 6.4430556 0.050000
+ 6.4433333 0.050000
+ 6.4436111 0.050000
+ 6.4438889 0.050000
+ 6.4441667 0.050000
+ 6.4444444 0.051573
+ 6.4447222 0.091334
+ 6.4450000 0.138517
+ 6.4452778 0.190424
+ 6.4455556 0.244361
+ 6.4458333 0.297631
+ 6.4461111 0.347539
+ 6.4463889 0.391387
+ 6.4466667 0.426481
+ 6.4469444 0.450125
+ 6.4472222 0.459621
+ 6.4475000 0.453144
+ 6.4477778 0.432346
+ 6.4480556 0.399748
+ 6.4483333 0.357871
+ 6.4486111 0.309238
+ 6.4488889 0.256370
+ 6.4491667 0.201787
+ 6.4494444 0.148013
+ 6.4497222 0.097567
+ 6.4500000 0.052972
+ 6.4502778 0.050000
+ 6.4505556 0.050000
+ 6.4508333 0.050000
+ 6.4511111 0.050000
+ 6.4513889 0.050000
+ 6.4516667 0.050000
+ 6.4519444 0.050000
+ 6.4522222 0.050000
+ 6.4525000 0.050000
+ 6.4527778 0.050000
+ 6.4530556 0.092335
+ 6.4533333 0.140094
+ 6.4536111 0.191126
+ 6.4538889 0.243281
+ 6.4541667 0.294409
+ 6.4544444 0.342358
+ 6.4547222 0.384978
+ 6.4550000 0.420119
+ 6.4552778 0.445630
+ 6.4555556 0.459359
+ 6.4558333 0.459822
+ 6.4561111 0.448189
+ 6.4563889 0.426296
+ 6.4566667 0.395980
+ 6.4569444 0.359076
+ 6.4572222 0.317421
+ 6.4575000 0.272849
+ 6.4577778 0.227198
+ 6.4580556 0.182303
+ 6.4583333 0.140000
+ 6.4586111 0.101912
+ 6.4588889 0.068806
+ 6.4591667 0.050000
+ 6.4594444 0.050000
+ 6.4597222 0.050000
+ 6.4600000 0.050000
+ 6.4602778 0.050000
+ 6.4605556 0.050000
+ 6.4608333 0.050000
+ 6.4611111 0.050000
+ 6.4613889 0.086288
+ 6.4616667 0.130444
+ 6.4619444 0.180353
+ 6.4622222 0.233903
+ 6.4625000 0.288980
+ 6.4627778 0.343470
+ 6.4630556 0.395260
+ 6.4633333 0.442237
+ 6.4636111 0.482286
+ 6.4638889 0.513294
+ 6.4641667 0.533738
+ 6.4644444 0.544457
+ 6.4647222 0.546878
+ 6.4650000 0.542431
+ 6.4652778 0.532544
+ 6.4655556 0.518644
+ 6.4658333 0.502162
+ 6.4661111 0.484525
+ 6.4663889 0.467162
+ 6.4666667 0.451501
+ 6.4669444 0.438680
+ 6.4672222 0.428670
+ 6.4675000 0.421151
+ 6.4677778 0.415804
+ 6.4680556 0.412308
+ 6.4683333 0.410345
+ 6.4686111 0.409593
+ 6.4688889 0.409734
+ 6.4691667 0.410447
+ 6.4694444 0.411413
+ 6.4697222 0.412462
+ 6.4700000 0.414029
+ 6.4702778 0.416698
+ 6.4705556 0.421055
+ 6.4708333 0.427682
+ 6.4711111 0.437166
+ 6.4713889 0.450091
+ 6.4716667 0.467042
+ 6.4719444 0.488604
+ 6.4722222 0.515360
+ 6.4725000 0.547375
+ 6.4727778 0.582625
+ 6.4730556 0.618566
+ 6.4733333 0.652654
+ 6.4736111 0.682344
+ 6.4738889 0.705093
+ 6.4741667 0.718355
+ 6.4744444 0.719586
+ 6.4747222 0.706242
+ 6.4750000 0.675778
+ 6.4752778 0.626831
+ 6.4755556 0.562757
+ 6.4758333 0.488093
+ 6.4761111 0.407375
+ 6.4763889 0.325140
+ 6.4766667 0.245925
+ 6.4769444 0.174267
+ 6.4772222 0.114702
+ 6.4775000 0.071767
+ 6.4777778 0.050000
+ 6.4780556 0.052404
+ 6.4783333 0.075855
+ 6.4786111 0.115696
+ 6.4788889 0.167271
+ 6.4791667 0.225922
+ 6.4794444 0.286993
+ 6.4797222 0.345827
+ 6.4800000 0.397768
+ 6.4802778 0.438158
+ 6.4805556 0.462340
+ 6.4808333 0.466937
+ 6.4811111 0.453682
+ 6.4813889 0.425586
+ 6.4816667 0.385661
+ 6.4819444 0.336920
+ 6.4822222 0.282374
+ 6.4825000 0.225034
+ 6.4827778 0.167913
+ 6.4830556 0.114023
+ 6.4833333 0.066374
+ 6.4836111 0.050000
+ 6.4838889 0.050000
+ 6.4841667 0.050000
+ 6.4844444 0.050000
+ 6.4847222 0.050000
+ 6.4850000 0.050000
+ 6.4852778 0.050000
+ 6.4855556 0.050000
+ 6.4858333 0.050000
+ 6.4861111 0.061562
+ 6.4863889 0.104193
+ 6.4866667 0.151974
+ 6.4869444 0.202737
+ 6.4872222 0.254315
+ 6.4875000 0.304540
+ 6.4877778 0.351244
+ 6.4880556 0.392260
+ 6.4883333 0.425420
+ 6.4886111 0.448557
+ 6.4888889 0.459503
+ 6.4891667 0.456782
+ 6.4894444 0.441685
+ 6.4897222 0.416194
+ 6.4900000 0.382291
+ 6.4902778 0.341958
+ 6.4905556 0.297177
+ 6.4908333 0.249931
+ 6.4911111 0.202202
+ 6.4913889 0.155972
+ 6.4916667 0.113222
+ 6.4919444 0.075673
+ 6.4922222 0.050000
+ 6.4925000 0.050000
+ 6.4927778 0.050000
+ 6.4930556 0.050000
+ 6.4933333 0.050000
+ 6.4936111 0.050000
+ 6.4938889 0.050000
+ 6.4941667 0.050000
+ 6.4944444 0.050000
+ 6.4947222 0.088749
+ 6.4950000 0.134533
+ 6.4952778 0.184900
+ 6.4955556 0.237395
+ 6.4958333 0.289566
+ 6.4961111 0.338959
+ 6.4963889 0.383121
+ 6.4966667 0.419599
+ 6.4969444 0.445938
+ 6.4972222 0.459686
+ 6.4975000 0.459141
+ 6.4977778 0.445608
+ 6.4980556 0.421144
+ 6.4983333 0.387805
+ 6.4986111 0.347647
+ 6.4988889 0.302728
+ 6.4991667 0.255105
+ 6.4994444 0.206832
+ 6.4997222 0.159968
+ 6.5000000 0.116569
+ 6.5002778 0.078416
+ 6.5005556 0.050000
+ 6.5008333 0.050000
+ 6.5011111 0.050000
+ 6.5013889 0.050000
+ 6.5016667 0.050000
+ 6.5019444 0.050000
+ 6.5022222 0.050000
+ 6.5025000 0.050000
+ 6.5027778 0.050000
+ 6.5030556 0.088748
+ 6.5033333 0.134576
+ 6.5036111 0.185016
+ 6.5038889 0.237598
+ 6.5041667 0.289850
+ 6.5044444 0.339303
+ 6.5047222 0.383488
+ 6.5050000 0.419933
+ 6.5052778 0.446169
+ 6.5055556 0.459725
+ 6.5058333 0.458892
+ 6.5061111 0.444990
+ 6.5063889 0.420104
+ 6.5066667 0.386315
+ 6.5069444 0.345706
+ 6.5072222 0.300357
+ 6.5075000 0.252353
+ 6.5077778 0.203774
+ 6.5080556 0.156703
+ 6.5083333 0.113222
+ 6.5086111 0.075130
+ 6.5088889 0.050000
+ 6.5091667 0.050000
+ 6.5094444 0.050000
+ 6.5097222 0.050000
+ 6.5100000 0.050000
+ 6.5102778 0.050000
+ 6.5105556 0.050000
+ 6.5108333 0.050000
+ 6.5111111 0.050000
+ 6.5113889 0.088975
+ 6.5116667 0.134948
+ 6.5119444 0.185463
+ 6.5122222 0.238060
+ 6.5125000 0.290282
+ 6.5127778 0.339671
+ 6.5130556 0.383767
+ 6.5133333 0.420114
+ 6.5136111 0.446253
+ 6.5138889 0.459725
+ 6.5141667 0.458830
+ 6.5144444 0.444889
+ 6.5147222 0.419982
+ 6.5150000 0.386188
+ 6.5152778 0.345585
+ 6.5155556 0.300254
+ 6.5158333 0.252273
+ 6.5161111 0.203721
+ 6.5163889 0.156678
+ 6.5166667 0.113222
+ 6.5169444 0.075149
+ 6.5172222 0.050000
+ 6.5175000 0.050000
+ 6.5177778 0.050000
+ 6.5180556 0.050000
+ 6.5183333 0.050000
+ 6.5186111 0.050000
+ 6.5188889 0.050000
+ 6.5191667 0.050000
+ 6.5194444 0.050000
+ 6.5197222 0.088957
+ 6.5200000 0.134913
+ 6.5202778 0.185409
+ 6.5205556 0.237991
+ 6.5208333 0.290200
+ 6.5211111 0.339580
+ 6.5213889 0.383674
+ 6.5216667 0.420026
+ 6.5219444 0.446178
+ 6.5222222 0.459673
+ 6.5225000 0.458810
+ 6.5227778 0.444909
+ 6.5230556 0.420043
+ 6.5233333 0.386287
+ 6.5236111 0.345715
+ 6.5238889 0.300401
+ 6.5241667 0.252421
+ 6.5244444 0.203848
+ 6.5247222 0.156757
+ 6.5250000 0.113222
+ 6.5252778 0.075038
+ 6.5255556 0.050000
+ 6.5258333 0.050000
+ 6.5261111 0.050000
+ 6.5263889 0.050000
+ 6.5266667 0.050000
+ 6.5269444 0.050000
+ 6.5272222 0.050000
+ 6.5275000 0.050000
+ 6.5277778 0.050000
+ 6.5280556 0.089384
+ 6.5283333 0.135836
+ 6.5286111 0.186836
+ 6.5288889 0.239868
+ 6.5291667 0.292413
+ 6.5294444 0.341953
+ 6.5297222 0.385971
+ 6.5300000 0.421949
+ 6.5302778 0.447369
+ 6.5305556 0.459712
+ 6.5308333 0.457248
+ 6.5311111 0.441391
+ 6.5313889 0.414342
+ 6.5316667 0.378302
+ 6.5319444 0.335470
+ 6.5322222 0.288050
+ 6.5325000 0.238240
+ 6.5327778 0.188242
+ 6.5330556 0.140257
+ 6.5333333 0.096486
+ 6.5336111 0.058805
+ 6.5338889 0.050000
+ 6.5341667 0.050000
+ 6.5344444 0.050000
+ 6.5347222 0.050000
+ 6.5350000 0.050000
+ 6.5352778 0.050000
+ 6.5355556 0.050000
+ 6.5358333 0.050000
+ 6.5361111 0.050000
+ 6.5363889 0.089917
+ 6.5366667 0.136400
+ 6.5369444 0.187074
+ 6.5372222 0.239565
+ 6.5375000 0.291497
+ 6.5377778 0.340496
+ 6.5380556 0.384188
+ 6.5383333 0.420198
+ 6.5386111 0.446151
+ 6.5388889 0.459673
+ 6.5391667 0.459120
+ 6.5394444 0.445774
+ 6.5397222 0.421647
+ 6.5400000 0.388750
+ 6.5402778 0.349098
+ 6.5405556 0.304700
+ 6.5408333 0.257571
+ 6.5411111 0.209723
+ 6.5413889 0.163167
+ 6.5416667 0.119917
+ 6.5419444 0.081722
+ 6.5422222 0.050000
+ 6.5425000 0.050000
+ 6.5427778 0.050000
+ 6.5430556 0.050000
+ 6.5433333 0.050000
+ 6.5436111 0.050000
+ 6.5438889 0.050000
+ 6.5441667 0.050000
+ 6.5444444 0.050000
+ 6.5447222 0.088736
+ 6.5450000 0.134681
+ 6.5452778 0.185317
+ 6.5455556 0.238127
+ 6.5458333 0.290593
+ 6.5461111 0.340197
+ 6.5463889 0.384422
+ 6.5466667 0.420751
+ 6.5469444 0.446665
+ 6.5472222 0.459647
+ 6.5475000 0.457958
+ 6.5477778 0.442976
+ 6.5480556 0.416854
+ 6.5483333 0.381750
+ 6.5486111 0.339817
+ 6.5488889 0.293213
+ 6.5491667 0.244091
+ 6.5494444 0.194608
+ 6.5497222 0.146920
+ 6.5500000 0.103181
+ 6.5502778 0.065239
+ 6.5505556 0.050000
+ 6.5508333 0.050000
+ 6.5511111 0.050000
+ 6.5513889 0.050000
+ 6.5516667 0.050000
+ 6.5519444 0.050000
+ 6.5522222 0.050000
+ 6.5525000 0.050000
+ 6.5527778 0.050000
+ 6.5530556 0.089818
+ 6.5533333 0.136416
+ 6.5536111 0.187348
+ 6.5538889 0.240167
+ 6.5541667 0.292427
+ 6.5544444 0.341681
+ 6.5547222 0.385483
+ 6.5550000 0.421387
+ 6.5552778 0.446945
+ 6.5555556 0.459712
+ 6.5558333 0.458002
+ 6.5561111 0.443173
+ 6.5563889 0.417344
+ 6.5566667 0.382634
+ 6.5569444 0.341161
+ 6.5572222 0.295045
+ 6.5575000 0.246405
+ 6.5577778 0.197360
+ 6.5580556 0.150027
+ 6.5583333 0.106528
+ 6.5586111 0.068681
+ 6.5588889 0.050000
+ 6.5591667 0.050000
+ 6.5594444 0.050000
+ 6.5597222 0.050000
+ 6.5600000 0.050000
+ 6.5602778 0.050000
+ 6.5605556 0.050000
+ 6.5608333 0.050000
+ 6.5611111 0.050000
+ 6.5613889 0.089253
+ 6.5616667 0.135324
+ 6.5619444 0.185800
+ 6.5622222 0.238267
+ 6.5625000 0.290312
+ 6.5627778 0.339521
+ 6.5630556 0.383480
+ 6.5633333 0.419776
+ 6.5636111 0.445996
+ 6.5638889 0.459725
+ 6.5641667 0.459292
+ 6.5644444 0.445986
+ 6.5647222 0.421840
+ 6.5650000 0.388884
+ 6.5652778 0.349151
+ 6.5655556 0.304671
+ 6.5658333 0.257476
+ 6.5661111 0.209598
+ 6.5663889 0.163067
+ 6.5666667 0.119917
+ 6.5669444 0.081907
+ 6.5672222 0.050000
+ 6.5675000 0.050000
+ 6.5677778 0.050000
+ 6.5680556 0.050000
+ 6.5683333 0.050000
+ 6.5686111 0.050000
+ 6.5688889 0.050000
+ 6.5691667 0.050000
+ 6.5694444 0.051638
+ 6.5697222 0.090034
+ 6.5700000 0.135522
+ 6.5702778 0.185644
+ 6.5705556 0.237941
+ 6.5708333 0.289954
+ 6.5711111 0.339224
+ 6.5713889 0.383293
+ 6.5716667 0.419701
+ 6.5719444 0.445989
+ 6.5722222 0.459699
+ 6.5725000 0.459125
+ 6.5727778 0.445569
+ 6.5730556 0.421089
+ 6.5733333 0.387741
+ 6.5736111 0.347581
+ 6.5738889 0.302665
+ 6.5741667 0.255049
+ 6.5744444 0.206791
+ 6.5747222 0.159945
+ 6.5750000 0.116569
+ 6.5752778 0.078443
+ 6.5755556 0.050000
+ 6.5758333 0.050000
+ 6.5761111 0.050000
+ 6.5763889 0.050000
+ 6.5766667 0.050000
+ 6.5769444 0.050000
+ 6.5772222 0.050000
+ 6.5775000 0.050000
+ 6.5777778 0.050000
+ 6.5780556 0.088665
+ 6.5783333 0.134400
+ 6.5786111 0.184745
+ 6.5788889 0.237241
+ 6.5791667 0.289430
+ 6.5794444 0.338853
+ 6.5797222 0.383051
+ 6.5800000 0.419567
+ 6.5802778 0.445940
+ 6.5805556 0.459712
+ 6.5808333 0.459179
+ 6.5811111 0.445645
+ 6.5813889 0.421172
+ 6.5816667 0.387819
+ 6.5819444 0.347646
+ 6.5822222 0.302712
+ 6.5825000 0.255078
+ 6.5827778 0.206803
+ 6.5830556 0.159947
+ 6.5833333 0.116569
+ 6.5836111 0.078453
+ 6.5838889 0.050000
+ 6.5841667 0.050000
+ 6.5844444 0.050000
+ 6.5847222 0.050000
+ 6.5850000 0.050000
+ 6.5852778 0.050000
+ 6.5855556 0.050000
+ 6.5858333 0.050000
+ 6.5861111 0.050000
+ 6.5863889 0.088581
+ 6.5866667 0.134216
+ 6.5869444 0.184459
+ 6.5872222 0.236864
+ 6.5875000 0.288986
+ 6.5877778 0.338378
+ 6.5880556 0.382595
+ 6.5883333 0.419191
+ 6.5886111 0.445721
+ 6.5888889 0.459738
+ 6.5891667 0.459544
+ 6.5894444 0.446423
+ 6.5897222 0.422408
+ 6.5900000 0.389529
+ 6.5902778 0.349820
+ 6.5905556 0.305311
+ 6.5908333 0.258035
+ 6.5911111 0.210022
+ 6.5913889 0.163306
+ 6.5916667 0.119917
+ 6.5919444 0.081621
+ 6.5922222 0.050000
+ 6.5925000 0.050000
+ 6.5927778 0.050000
+ 6.5930556 0.050000
+ 6.5933333 0.050000
+ 6.5936111 0.050000
+ 6.5938889 0.050000
+ 6.5941667 0.050000
+ 6.5944444 0.050000
+ 6.5947222 0.088762
+ 6.5950000 0.134724
+ 6.5952778 0.185369
+ 6.5955556 0.238181
+ 6.5958333 0.290644
+ 6.5961111 0.340243
+ 6.5963889 0.384461
+ 6.5966667 0.420783
+ 6.5969444 0.446692
+ 6.5972222 0.459673
+ 6.5975000 0.457988
+ 6.5977778 0.443012
+ 6.5980556 0.416899
+ 6.5983333 0.381803
+ 6.5986111 0.339877
+ 6.5988889 0.293275
+ 6.5991667 0.244151
+ 6.5994444 0.194658
+ 6.5997222 0.146950
+ 6.6000000 0.103181
+ 6.6002778 0.065198
+ 6.6005556 0.050000
+ 6.6008333 0.050000
+ 6.6011111 0.050000
+ 6.6013889 0.050000
+ 6.6016667 0.050000
+ 6.6019444 0.050000
+ 6.6022222 0.050000
+ 6.6025000 0.050000
+ 6.6027778 0.050000
+ 6.6030556 0.089974
+ 6.6033333 0.136752
+ 6.6036111 0.187867
+ 6.6038889 0.240850
+ 6.6041667 0.293232
+ 6.6044444 0.342544
+ 6.6047222 0.386318
+ 6.6050000 0.422086
+ 6.6052778 0.447378
+ 6.6055556 0.459725
+ 6.6058333 0.457432
+ 6.6061111 0.441887
+ 6.6063889 0.415252
+ 6.6066667 0.379689
+ 6.6069444 0.337357
+ 6.6072222 0.290420
+ 6.6075000 0.241037
+ 6.6077778 0.191371
+ 6.6080556 0.143583
+ 6.6083333 0.099833
+ 6.6086111 0.061974
+ 6.6088889 0.050000
+ 6.6091667 0.050000
+ 6.6094444 0.050000
+ 6.6097222 0.050000
+ 6.6100000 0.050000
+ 6.6102778 0.050000
+ 6.6105556 0.050000
+ 6.6108333 0.050000
+ 6.6111111 0.050000
+ 6.6113889 0.090263
+ 6.6116667 0.137272
+ 6.6119444 0.188555
+ 6.6122222 0.241643
+ 6.6125000 0.294065
+ 6.6127778 0.343352
+ 6.6130556 0.387032
+ 6.6133333 0.422637
+ 6.6136111 0.447696
+ 6.6138889 0.459738
+ 6.6141667 0.457070
+ 6.6144444 0.441099
+ 6.6147222 0.414009
+ 6.6150000 0.377984
+ 6.6152778 0.335208
+ 6.6155556 0.287864
+ 6.6158333 0.238136
+ 6.6161111 0.188208
+ 6.6163889 0.140263
+ 6.6166667 0.096486
+ 6.6169444 0.058743
+ 6.6172222 0.050000
+ 6.6175000 0.050000
+ 6.6177778 0.050000
+ 6.6180556 0.050000
+ 6.6183333 0.050000
+ 6.6186111 0.050000
+ 6.6188889 0.050000
+ 6.6191667 0.050000
+ 6.6194444 0.051534
+ 6.6197222 0.092396
+ 6.6200000 0.139931
+ 6.6202778 0.191634
+ 6.6205556 0.244998
+ 6.6208333 0.297516
+ 6.6211111 0.346683
+ 6.6213889 0.389993
+ 6.6216667 0.424938
+ 6.6219444 0.449014
+ 6.6222222 0.459712
+ 6.6225000 0.455332
+ 6.6227778 0.437383
+ 6.6230556 0.408181
+ 6.6233333 0.370040
+ 6.6236111 0.325274
+ 6.6238889 0.276200
+ 6.6241667 0.225130
+ 6.6244444 0.174380
+ 6.6247222 0.126264
+ 6.6250000 0.083097
+ 6.6252778 0.050000
+ 6.6255556 0.050000
+ 6.6258333 0.050000
+ 6.6261111 0.050000
+ 6.6263889 0.050000
+ 6.6266667 0.050000
+ 6.6269444 0.050000
+ 6.6272222 0.050000
+ 6.6275000 0.050000
+ 6.6277778 0.064897
+ 6.6280556 0.106724
+ 6.6283333 0.154470
+ 6.6286111 0.205721
+ 6.6288889 0.258061
+ 6.6291667 0.309077
+ 6.6294444 0.356355
+ 6.6297222 0.397479
+ 6.6300000 0.430036
+ 6.6302778 0.451612
+ 6.6305556 0.459791
+ 6.6308333 0.452952
+ 6.6311111 0.432645
+ 6.6313889 0.401211
+ 6.6316667 0.360993
+ 6.6319444 0.314332
+ 6.6322222 0.263571
+ 6.6325000 0.211051
+ 6.6327778 0.159115
+ 6.6330556 0.110104
+ 6.6333333 0.066361
+ 6.6336111 0.050000
+ 6.6338889 0.050000
+ 6.6341667 0.050000
+ 6.6344444 0.050000
+ 6.6347222 0.050000
+ 6.6350000 0.050000
+ 6.6352778 0.050000
+ 6.6355556 0.050000
+ 6.6358333 0.050000
+ 6.6361111 0.054790
+ 6.6363889 0.097670
+ 6.6366667 0.146430
+ 6.6369444 0.198667
+ 6.6372222 0.251978
+ 6.6375000 0.303958
+ 6.6377778 0.352204
+ 6.6380556 0.394313
+ 6.6383333 0.427880
+ 6.6386111 0.450503
+ 6.6388889 0.459778
+ 6.6391667 0.454084
+ 6.6394444 0.434936
+ 6.6397222 0.404630
+ 6.6400000 0.365465
+ 6.6402778 0.319736
+ 6.6405556 0.269742
+ 6.6408333 0.217780
+ 6.6411111 0.166147
+ 6.6413889 0.117139
+ 6.6416667 0.073055
+ 6.6419444 0.050000
+ 6.6422222 0.050000
+ 6.6425000 0.050000
+ 6.6427778 0.050000
+ 6.6430556 0.050000
+ 6.6433333 0.050000
+ 6.6436111 0.050000
+ 6.6438889 0.050000
+ 6.6441667 0.050000
+ 6.6444444 0.051416
+ 6.6447222 0.094499
+ 6.6450000 0.143827
+ 6.6452778 0.196870
+ 6.6455556 0.251098
+ 6.6458333 0.303983
+ 6.6461111 0.352994
+ 6.6463889 0.395602
+ 6.6466667 0.429277
+ 6.6469444 0.451491
+ 6.6472222 0.459712
+ 6.6475000 0.452247
+ 6.6477778 0.430736
+ 6.6480556 0.397654
+ 6.6483333 0.355476
+ 6.6486111 0.306677
+ 6.6488889 0.253733
+ 6.6491667 0.199118
+ 6.6494444 0.145307
+ 6.6497222 0.094776
+ 6.6500000 0.050000
+ 6.6502778 0.050000
+ 6.6505556 0.050000
+ 6.6508333 0.050000
+ 6.6511111 0.050000
+ 6.6513889 0.050000
+ 6.6516667 0.050000
+ 6.6519444 0.050000
+ 6.6522222 0.050000
+ 6.6525000 0.050000
+ 6.6527778 0.050000
+ 6.6530556 0.094682
+ 6.6533333 0.145091
+ 6.6536111 0.198771
+ 6.6538889 0.253264
+ 6.6541667 0.306114
+ 6.6544444 0.354863
+ 6.6547222 0.397054
+ 6.6550000 0.430231
+ 6.6552778 0.451936
+ 6.6555556 0.459712
+ 6.6558333 0.451922
+ 6.6561111 0.430203
+ 6.6563889 0.397014
+ 6.6566667 0.354814
+ 6.6569444 0.306059
+ 6.6572222 0.253207
+ 6.6575000 0.198718
+ 6.6577778 0.145048
+ 6.6580556 0.094656
+ 6.6583333 0.050000
+ 6.6586111 0.050000
+ 6.6588889 0.050000
+ 6.6591667 0.050000
+ 6.6594444 0.050000
+ 6.6597222 0.050000
+ 6.6600000 0.050000
+ 6.6602778 0.050000
+ 6.6605556 0.050000
+ 6.6608333 0.050000
+ 6.6611111 0.050000
+ 6.6613889 0.094658
+ 6.6616667 0.145053
+ 6.6619444 0.198725
+ 6.6622222 0.253217
+ 6.6625000 0.306070
+ 6.6627778 0.354826
+ 6.6630556 0.397026
+ 6.6633333 0.430213
+ 6.6636111 0.451928
+ 6.6638889 0.459712
+ 6.6641667 0.451928
+ 6.6644444 0.430213
+ 6.6647222 0.397026
+ 6.6650000 0.354825
+ 6.6652778 0.306069
+ 6.6655556 0.253216
+ 6.6658333 0.198724
+ 6.6661111 0.145052
+ 6.6663889 0.094658
+ 6.6666667 0.050000
+ 6.6669444 0.050000
+ 6.6672222 0.050000
+ 6.6675000 0.050000
+ 6.6677778 0.050000
+ 6.6680556 0.050000
+ 6.6683333 0.050000
+ 6.6686111 0.050000
+ 6.6688889 0.050000
+ 6.6691667 0.050000
+ 6.6694444 0.050000
+ 6.6697222 0.094655
+ 6.6700000 0.145045
+ 6.6702778 0.198713
+ 6.6705556 0.253199
+ 6.6708333 0.306047
+ 6.6711111 0.354798
+ 6.6713889 0.396994
+ 6.6716667 0.430177
+ 6.6719444 0.451889
+ 6.6722222 0.459673
+ 6.6725000 0.451889
+ 6.6727778 0.430177
+ 6.6730556 0.396994
+ 6.6733333 0.354797
+ 6.6736111 0.306047
+ 6.6738889 0.253199
+ 6.6741667 0.198712
+ 6.6744444 0.145045
+ 6.6747222 0.094655
+ 6.6750000 0.050000
+ 6.6752778 0.050000
+ 6.6755556 0.050000
+ 6.6758333 0.050000
+ 6.6761111 0.050000
+ 6.6763889 0.050000
+ 6.6766667 0.050000
+ 6.6769444 0.050000
+ 6.6772222 0.050000
+ 6.6775000 0.050000
+ 6.6777778 0.050000
+ 6.6780556 0.094658
+ 6.6783333 0.145052
+ 6.6786111 0.198723
+ 6.6788889 0.253215
+ 6.6791667 0.306068
+ 6.6794444 0.354823
+ 6.6797222 0.397024
+ 6.6800000 0.430211
+ 6.6802778 0.451927
+ 6.6805556 0.459712
+ 6.6808333 0.451929
+ 6.6811111 0.430215
+ 6.6813889 0.397030
+ 6.6816667 0.354831
+ 6.6819444 0.306076
+ 6.6822222 0.253223
+ 6.6825000 0.198731
+ 6.6827778 0.145058
+ 6.6830556 0.094661
+ 6.6833333 0.050000
+ 6.6836111 0.050000
+ 6.6838889 0.050000
+ 6.6841667 0.050000
+ 6.6844444 0.050000
+ 6.6847222 0.050000
+ 6.6850000 0.050000
+ 6.6852778 0.050000
+ 6.6855556 0.050000
+ 6.6858333 0.050000
+ 6.6861111 0.050000
+ 6.6863889 0.094672
+ 6.6866667 0.145083
+ 6.6869444 0.198772
+ 6.6872222 0.253278
+ 6.6875000 0.306143
+ 6.6877778 0.354904
+ 6.6880556 0.397104
+ 6.6883333 0.430281
+ 6.6886111 0.451975
+ 6.6888889 0.459725
+ 6.6891667 0.451894
+ 6.6894444 0.430125
+ 6.6897222 0.396882
+ 6.6900000 0.354631
+ 6.6902778 0.305838
+ 6.6905556 0.252966
+ 6.6908333 0.198481
+ 6.6911111 0.144849
+ 6.6913889 0.094533
+ 6.6916667 0.050000
+ 6.6919444 0.050000
+ 6.6922222 0.050000
+ 6.6925000 0.050000
+ 6.6927778 0.050000
+ 6.6930556 0.050000
+ 6.6933333 0.050000
+ 6.6936111 0.050000
+ 6.6938889 0.050000
+ 6.6941667 0.050000
+ 6.6944444 0.051351
+ 6.6947222 0.095797
+ 6.6950000 0.145901
+ 6.6952778 0.199239
+ 6.6955556 0.253391
+ 6.6958333 0.305934
+ 6.6961111 0.354447
+ 6.6963889 0.396507
+ 6.6966667 0.429692
+ 6.6969444 0.451581
+ 6.6972222 0.459752
+ 6.6975000 0.452591
+ 6.6977778 0.431721
+ 6.6980556 0.399573
+ 6.6983333 0.358580
+ 6.6986111 0.311172
+ 6.6988889 0.259781
+ 6.6991667 0.206838
+ 6.6994444 0.154775
+ 6.6997222 0.106023
+ 6.7000000 0.063014
+ 6.7002778 0.050000
+ 6.7005556 0.050000
+ 6.7008333 0.050000
+ 6.7011111 0.050000
+ 6.7013889 0.050000
+ 6.7016667 0.050000
+ 6.7019444 0.050000
+ 6.7022222 0.050000
+ 6.7025000 0.050000
+ 6.7027778 0.068205
+ 6.7030556 0.110947
+ 6.7033333 0.158970
+ 6.7036111 0.209996
+ 6.7038889 0.261745
+ 6.7041667 0.311939
+ 6.7044444 0.358298
+ 6.7047222 0.398544
+ 6.7050000 0.430399
+ 6.7052778 0.451583
+ 6.7055556 0.459817
+ 6.7058333 0.453577
+ 6.7061111 0.434358
+ 6.7063889 0.404406
+ 6.7066667 0.365971
+ 6.7069444 0.321300
+ 6.7072222 0.272641
+ 6.7075000 0.222244
+ 6.7077778 0.172355
+ 6.7080556 0.125223
+ 6.7083333 0.083097
+ 6.7086111 0.050000
+ 6.7088889 0.050000
+ 6.7091667 0.050000
+ 6.7094444 0.050000
+ 6.7097222 0.050000
+ 6.7100000 0.050000
+ 6.7102778 0.050000
+ 6.7105556 0.050000
+ 6.7108333 0.050000
+ 6.7111111 0.068270
+ 6.7113889 0.108891
+ 6.7116667 0.155190
+ 6.7119444 0.204914
+ 6.7122222 0.255814
+ 6.7125000 0.305639
+ 6.7127778 0.352138
+ 6.7130556 0.393060
+ 6.7133333 0.426154
+ 6.7136111 0.449170
+ 6.7138889 0.459856
+ 6.7141667 0.456686
+ 6.7144444 0.441024
+ 6.7147222 0.414957
+ 6.7150000 0.380575
+ 6.7152778 0.339965
+ 6.7155556 0.295214
+ 6.7158333 0.248411
+ 6.7161111 0.201644
+ 6.7163889 0.157001
+ 6.7166667 0.116569
+ 6.7169444 0.082119
+ 6.7172222 0.054148
+ 6.7175000 0.050000
+ 6.7177778 0.050000
+ 6.7180556 0.050000
+ 6.7183333 0.050000
+ 6.7186111 0.050000
+ 6.7188889 0.050000
+ 6.7191667 0.054784
+ 6.7194444 0.085085
+ 6.7197222 0.123072
+ 6.7200000 0.166912
+ 6.7202778 0.214367
+ 6.7205556 0.263200
+ 6.7208333 0.311174
+ 6.7211111 0.356051
+ 6.7213889 0.395595
+ 6.7216667 0.427569
+ 6.7219444 0.449735
+ 6.7222222 0.459856
+ 6.7225000 0.456416
+ 6.7227778 0.440777
+ 6.7230556 0.415024
+ 6.7233333 0.381241
+ 6.7236111 0.341512
+ 6.7238889 0.297921
+ 6.7241667 0.252551
+ 6.7244444 0.207487
+ 6.7247222 0.164812
+ 6.7250000 0.126611
+ 6.7252778 0.094630
+ 6.7255556 0.069268
+ 6.7258333 0.050585
+ 6.7261111 0.050000
+ 6.7263889 0.050000
+ 6.7266667 0.050000
+ 6.7269444 0.050000
+ 6.7272222 0.059504
+ 6.7275000 0.082182
+ 6.7277778 0.111967
+ 6.7280556 0.148566
+ 6.7283333 0.190270
+ 6.7286111 0.235014
+ 6.7288889 0.280734
+ 6.7291667 0.325366
+ 6.7294444 0.366845
+ 6.7297222 0.403109
+ 6.7300000 0.432092
+ 6.7302778 0.451731
+ 6.7305556 0.459961
+ 6.7308333 0.455387
+ 6.7311111 0.439293
+ 6.7313889 0.413629
+ 6.7316667 0.380347
+ 6.7319444 0.341398
+ 6.7322222 0.298734
+ 6.7325000 0.254306
+ 6.7327778 0.210067
+ 6.7330556 0.167967
+ 6.7333333 0.129958
+ 6.7336111 0.097693
+ 6.7338889 0.071628
+ 6.7341667 0.051921
+ 6.7344444 0.050000
+ 6.7347222 0.050000
+ 6.7350000 0.050000
+ 6.7352778 0.050000
+ 6.7355556 0.054264
+ 6.7358333 0.076012
+ 6.7361111 0.105220
+ 6.7363889 0.141665
+ 6.7366667 0.183591
+ 6.7369444 0.228862
+ 6.7372222 0.275342
+ 6.7375000 0.320894
+ 6.7377778 0.363382
+ 6.7380556 0.400670
+ 6.7383333 0.430619
+ 6.7386111 0.451095
+ 6.7388889 0.459961
+ 6.7391667 0.455769
+ 6.7394444 0.439834
+ 6.7397222 0.414159
+ 6.7400000 0.380745
+ 6.7402778 0.341598
+ 6.7405556 0.298720
+ 6.7408333 0.254113
+ 6.7411111 0.209782
+ 6.7413889 0.167729
+ 6.7416667 0.129958
+ 6.7419444 0.098155
+ 6.7422222 0.072741
+ 6.7425000 0.053820
+ 6.7427778 0.050000
+ 6.7430556 0.050000
+ 6.7433333 0.050000
+ 6.7436111 0.050000
+ 6.7438889 0.060257
+ 6.7441667 0.082481
+ 6.7444444 0.111928
+ 6.7447222 0.148334
+ 6.7450000 0.189971
+ 6.7452778 0.234744
+ 6.7455556 0.280557
+ 6.7458333 0.325316
+ 6.7461111 0.366924
+ 6.7463889 0.403286
+ 6.7466667 0.432308
+ 6.7469444 0.451894
+ 6.7472222 0.459948
+ 6.7475000 0.455060
+ 6.7477778 0.438558
+ 6.7480556 0.412454
+ 6.7483333 0.378762
+ 6.7486111 0.339494
+ 6.7488889 0.296663
+ 6.7491667 0.252281
+ 6.7494444 0.208361
+ 6.7497222 0.166916
+ 6.7500000 0.129958
+ 6.7502778 0.099173
+ 6.7505556 0.074932
+ 6.7508333 0.057281
+ 6.7511111 0.050000
+ 6.7513889 0.050000
+ 6.7516667 0.050000
+ 6.7519444 0.053466
+ 6.7522222 0.069432
+ 6.7525000 0.092256
+ 6.7527778 0.121983
+ 6.7530556 0.158307
+ 6.7533333 0.199530
+ 6.7536111 0.243606
+ 6.7538889 0.288485
+ 6.7541667 0.332121
+ 6.7544444 0.372466
+ 6.7547222 0.407473
+ 6.7550000 0.435094
+ 6.7552778 0.453281
+ 6.7555556 0.459987
+ 6.7558333 0.453836
+ 6.7561111 0.436137
+ 6.7563889 0.408872
+ 6.7566667 0.374021
+ 6.7569444 0.333567
+ 6.7572222 0.289489
+ 6.7575000 0.243769
+ 6.7577778 0.198389
+ 6.7580556 0.155328
+ 6.7583333 0.116569
+ 6.7586111 0.083787
+ 6.7588889 0.057430
+ 6.7591667 0.050000
+ 6.7594444 0.050000
+ 6.7597222 0.050000
+ 6.7600000 0.050000
+ 6.7602778 0.050000
+ 6.7605556 0.050000
+ 6.7608333 0.064930
+ 6.7611111 0.095152
+ 6.7613889 0.132708
+ 6.7616667 0.175811
+ 6.7619444 0.222292
+ 6.7622222 0.269980
+ 6.7625000 0.316705
+ 6.7627778 0.360296
+ 6.7630556 0.398582
+ 6.7633333 0.429393
+ 6.7636111 0.450559
+ 6.7638889 0.459908
+ 6.7641667 0.455969
+ 6.7644444 0.440056
+ 6.7647222 0.414182
+ 6.7650000 0.380361
+ 6.7652778 0.340605
+ 6.7655556 0.296928
+ 6.7658333 0.251342
+ 6.7661111 0.205861
+ 6.7663889 0.162497
+ 6.7666667 0.123264
+ 6.7669444 0.089868
+ 6.7672222 0.062795
+ 6.7675000 0.050000
+ 6.7677778 0.050000
+ 6.7680556 0.050000
+ 6.7683333 0.050000
+ 6.7686111 0.050000
+ 6.7688889 0.050000
+ 6.7691667 0.065242
+ 6.7694444 0.095152
+ 6.7697222 0.132587
+ 6.7700000 0.175727
+ 6.7702778 0.222352
+ 6.7705556 0.270243
+ 6.7708333 0.317180
+ 6.7711111 0.360943
+ 6.7713889 0.399313
+ 6.7716667 0.430071
+ 6.7719444 0.450996
+ 6.7722222 0.459869
+ 6.7725000 0.455187
+ 6.7727778 0.438308
+ 6.7730556 0.411308
+ 6.7733333 0.376262
+ 6.7736111 0.335245
+ 6.7738889 0.290332
+ 6.7741667 0.243598
+ 6.7744444 0.197118
+ 6.7747222 0.152968
+ 6.7750000 0.113222
+ 6.7752778 0.079633
+ 6.7755556 0.052663
+ 6.7758333 0.050000
+ 6.7761111 0.050000
+ 6.7763889 0.050000
+ 6.7766667 0.050000
+ 6.7769444 0.050000
+ 6.7772222 0.050000
+ 6.7775000 0.060863
+ 6.7777778 0.091844
+ 6.7780556 0.130298
+ 6.7783333 0.174374
+ 6.7786111 0.221827
+ 6.7788889 0.270412
+ 6.7791667 0.317881
+ 6.7794444 0.361989
+ 6.7797222 0.400489
+ 6.7800000 0.431135
+ 6.7802778 0.451682
+ 6.7805556 0.459882
+ 6.7808333 0.454222
+ 6.7811111 0.436110
+ 6.7813889 0.407687
+ 6.7816667 0.371093
+ 6.7819444 0.328470
+ 6.7822222 0.281958
+ 6.7825000 0.233698
+ 6.7827778 0.185830
+ 6.7830556 0.140495
+ 6.7833333 0.099833
+ 6.7836111 0.065646
+ 6.7838889 0.050000
+ 6.7841667 0.050000
+ 6.7844444 0.050000
+ 6.7847222 0.050000
+ 6.7850000 0.050000
+ 6.7852778 0.050000
+ 6.7855556 0.050000
+ 6.7858333 0.050000
+ 6.7861111 0.081737
+ 6.7863889 0.121015
+ 6.7866667 0.165914
+ 6.7869444 0.214205
+ 6.7872222 0.263657
+ 6.7875000 0.312041
+ 6.7877778 0.357124
+ 6.7880556 0.396678
+ 6.7883333 0.428472
+ 6.7886111 0.450275
+ 6.7888889 0.459856
+ 6.7891667 0.455707
+ 6.7894444 0.439197
+ 6.7897222 0.412421
+ 6.7900000 0.377469
+ 6.7902778 0.336433
+ 6.7905556 0.291406
+ 6.7908333 0.244479
+ 6.7911111 0.197745
+ 6.7913889 0.153295
+ 6.7916667 0.113222
+ 6.7919444 0.079293
+ 6.7922222 0.051974
+ 6.7925000 0.050000
+ 6.7927778 0.050000
+ 6.7930556 0.050000
+ 6.7933333 0.050000
+ 6.7936111 0.050000
+ 6.7938889 0.050000
+ 6.7941667 0.057776
+ 6.7944444 0.088458
+ 6.7947222 0.126636
+ 6.7950000 0.170489
+ 6.7952778 0.217802
+ 6.7955556 0.266359
+ 6.7958333 0.313948
+ 6.7961111 0.358352
+ 6.7963889 0.397357
+ 6.7966667 0.428748
+ 6.7969444 0.450311
+ 6.7972222 0.459830
+ 6.7975000 0.455803
+ 6.7977778 0.439570
+ 6.7980556 0.413183
+ 6.7983333 0.378695
+ 6.7986111 0.338158
+ 6.7988889 0.293625
+ 6.7991667 0.247147
+ 6.7994444 0.200777
+ 6.7997222 0.156567
+ 6.8000000 0.116569
+ 6.8002778 0.082525
+ 6.8005556 0.054930
+ 6.8008333 0.050000
+ 6.8011111 0.050000
+ 6.8013889 0.050000
+ 6.8016667 0.050000
+ 6.8019444 0.050000
+ 6.8022222 0.050000
+ 6.8025000 0.057833
+ 6.8027778 0.088471
+ 6.8030556 0.126807
+ 6.8033333 0.170969
+ 6.8036111 0.218671
+ 6.8038889 0.267630
+ 6.8041667 0.315562
+ 6.8044444 0.360181
+ 6.8047222 0.399205
+ 6.8050000 0.430348
+ 6.8052778 0.451327
+ 6.8055556 0.459856
+ 6.8058333 0.454395
+ 6.8061111 0.436367
+ 6.8063889 0.407941
+ 6.8066667 0.371283
+ 6.8069444 0.328560
+ 6.8072222 0.281941
+ 6.8075000 0.233591
+ 6.8077778 0.185679
+ 6.8080556 0.140370
+ 6.8083333 0.099833
+ 6.8086111 0.065886
+ 6.8088889 0.050000
+ 6.8091667 0.050000
+ 6.8094444 0.050000
+ 6.8097222 0.050000
+ 6.8100000 0.050000
+ 6.8102778 0.050000
+ 6.8105556 0.050000
+ 6.8108333 0.053132
+ 6.8111111 0.085019
+ 6.8113889 0.124218
+ 6.8116667 0.168907
+ 6.8119444 0.216885
+ 6.8122222 0.265949
+ 6.8125000 0.313898
+ 6.8127778 0.358531
+ 6.8130556 0.397646
+ 6.8133333 0.429042
+ 6.8136111 0.450517
+ 6.8138889 0.459869
+ 6.8141667 0.455609
+ 6.8144444 0.439089
+ 6.8147222 0.412372
+ 6.8150000 0.377523
+ 6.8152778 0.336606
+ 6.8155556 0.291684
+ 6.8158333 0.244820
+ 6.8161111 0.198080
+ 6.8163889 0.153526
+ 6.8166667 0.113222
+ 6.8169444 0.078920
+ 6.8172222 0.051118
+ 6.8175000 0.050000
+ 6.8177778 0.050000
+ 6.8180556 0.050000
+ 6.8183333 0.050000
+ 6.8186111 0.050000
+ 6.8188889 0.050000
+ 6.8191667 0.054155
+ 6.8194444 0.085058
+ 6.8197222 0.123724
+ 6.8200000 0.168263
+ 6.8202778 0.216375
+ 6.8205556 0.265758
+ 6.8208333 0.314111
+ 6.8211111 0.359131
+ 6.8213889 0.398517
+ 6.8216667 0.429968
+ 6.8219444 0.451182
+ 6.8222222 0.459856
+ 6.8225000 0.454436
+ 6.8227778 0.436349
+ 6.8230556 0.407769
+ 6.8233333 0.370869
+ 6.8236111 0.327823
+ 6.8238889 0.280806
+ 6.8241667 0.231989
+ 6.8244444 0.183548
+ 6.8247222 0.137656
+ 6.8250000 0.096486
+ 6.8252778 0.061868
+ 6.8255556 0.050000
+ 6.8258333 0.050000
+ 6.8261111 0.050000
+ 6.8263889 0.050000
+ 6.8266667 0.050000
+ 6.8269444 0.050000
+ 6.8272222 0.050000
+ 6.8275000 0.050000
+ 6.8277778 0.078351
+ 6.8280556 0.118203
+ 6.8283333 0.163748
+ 6.8286111 0.212709
+ 6.8288889 0.262809
+ 6.8291667 0.311771
+ 6.8294444 0.357320
+ 6.8297222 0.397176
+ 6.8300000 0.429065
+ 6.8302778 0.450708
+ 6.8305556 0.459830
+ 6.8308333 0.454888
+ 6.8311111 0.437280
+ 6.8313889 0.409141
+ 6.8316667 0.372603
+ 6.8319444 0.329800
+ 6.8322222 0.282866
+ 6.8325000 0.233934
+ 6.8327778 0.185138
+ 6.8330556 0.138611
+ 6.8333333 0.096486
+ 6.8336111 0.060576
+ 6.8338889 0.050000
+ 6.8341667 0.050000
+ 6.8344444 0.050000
+ 6.8347222 0.050000
+ 6.8350000 0.050000
+ 6.8352778 0.050000
+ 6.8355556 0.050000
+ 6.8358333 0.050000
+ 6.8361111 0.064936
+ 6.8363889 0.105100
+ 6.8366667 0.151451
+ 6.8369444 0.201612
+ 6.8372222 0.253207
+ 6.8375000 0.303862
+ 6.8377778 0.351198
+ 6.8380556 0.392842
+ 6.8383333 0.426417
+ 6.8386111 0.449547
+ 6.8388889 0.459856
+ 6.8391667 0.455730
+ 6.8394444 0.438599
+ 6.8397222 0.410657
+ 6.8400000 0.374095
+ 6.8402778 0.331106
+ 6.8405556 0.283882
+ 6.8408333 0.234616
+ 6.8411111 0.185499
+ 6.8413889 0.138725
+ 6.8416667 0.096486
+ 6.8419444 0.060637
+ 6.8422222 0.050000
+ 6.8425000 0.050000
+ 6.8427778 0.050000
+ 6.8430556 0.050000
+ 6.8433333 0.050000
+ 6.8436111 0.050000
+ 6.8438889 0.050000
+ 6.8441667 0.050000
+ 6.8444444 0.068296
+ 6.8447222 0.108493
+ 6.8450000 0.154734
+ 6.8452778 0.204666
+ 6.8455556 0.255936
+ 6.8458333 0.306189
+ 6.8461111 0.353071
+ 6.8463889 0.394229
+ 6.8466667 0.427309
+ 6.8469444 0.449956
+ 6.8472222 0.459817
+ 6.8475000 0.455297
+ 6.8477778 0.437838
+ 6.8480556 0.409641
+ 6.8483333 0.372907
+ 6.8486111 0.329837
+ 6.8488889 0.282632
+ 6.8491667 0.233494
+ 6.8494444 0.184622
+ 6.8497222 0.138220
+ 6.8500000 0.096486
+ 6.8502778 0.061278
+ 6.8505556 0.050000
+ 6.8508333 0.050000
+ 6.8511111 0.050000
+ 6.8513889 0.050000
+ 6.8516667 0.050000
+ 6.8519444 0.050000
+ 6.8522222 0.050000
+ 6.8525000 0.050000
+ 6.8527778 0.075004
+ 6.8530556 0.115233
+ 6.8533333 0.161297
+ 6.8536111 0.210864
+ 6.8538889 0.261598
+ 6.8541667 0.311167
+ 6.8544444 0.357236
+ 6.8547222 0.397472
+ 6.8550000 0.429541
+ 6.8552778 0.451109
+ 6.8555556 0.459843
+ 6.8558333 0.454167
+ 6.8561111 0.435541
+ 6.8563889 0.406182
+ 6.8566667 0.368308
+ 6.8569444 0.324137
+ 6.8572222 0.275886
+ 6.8575000 0.225774
+ 6.8577778 0.176018
+ 6.8580556 0.128835
+ 6.8583333 0.086444
+ 6.8586111 0.050714
+ 6.8588889 0.050000
+ 6.8591667 0.050000
+ 6.8594444 0.050000
+ 6.8597222 0.050000
+ 6.8600000 0.050000
+ 6.8602778 0.050000
+ 6.8605556 0.050000
+ 6.8608333 0.050000
+ 6.8611111 0.064923
+ 6.8613889 0.105666
+ 6.8616667 0.152328
+ 6.8619444 0.202585
+ 6.8622222 0.254114
+ 6.8625000 0.304589
+ 6.8627778 0.351686
+ 6.8630556 0.393082
+ 6.8633333 0.426452
+ 6.8636111 0.449472
+ 6.8638889 0.459817
+ 6.8641667 0.455909
+ 6.8644444 0.439148
+ 6.8647222 0.411679
+ 6.8650000 0.375649
+ 6.8652778 0.333204
+ 6.8655556 0.286487
+ 6.8658333 0.237647
+ 6.8661111 0.188827
+ 6.8663889 0.142174
+ 6.8666667 0.099833
+ 6.8669444 0.063630
+ 6.8672222 0.050000
+ 6.8675000 0.050000
+ 6.8677778 0.050000
+ 6.8680556 0.050000
+ 6.8683333 0.050000
+ 6.8686111 0.050000
+ 6.8688889 0.050000
+ 6.8691667 0.050000
+ 6.8694444 0.064923
+ 6.8697222 0.105033
+ 6.8700000 0.151412
+ 6.8702778 0.201656
+ 6.8705556 0.253364
+ 6.8708333 0.304131
+ 6.8711111 0.351556
+ 6.8713889 0.393236
+ 6.8716667 0.426768
+ 6.8719444 0.449749
+ 6.8722222 0.459778
+ 6.8725000 0.455224
+ 6.8727778 0.437557
+ 6.8730556 0.409017
+ 6.8733333 0.371847
+ 6.8736111 0.328289
+ 6.8738889 0.280584
+ 6.8741667 0.230975
+ 6.8744444 0.181703
+ 6.8747222 0.135011
+ 6.8750000 0.093139
+ 6.8752778 0.057972
+ 6.8755556 0.050000
+ 6.8758333 0.050000
+ 6.8761111 0.050000
+ 6.8763889 0.050000
+ 6.8766667 0.050000
+ 6.8769444 0.050000
+ 6.8772222 0.050000
+ 6.8775000 0.050000
+ 6.8777778 0.075030
+ 6.8780556 0.115335
+ 6.8783333 0.161360
+ 6.8786111 0.210807
+ 6.8788889 0.261380
+ 6.8791667 0.310782
+ 6.8794444 0.356716
+ 6.8797222 0.396886
+ 6.8800000 0.428995
+ 6.8802778 0.450746
+ 6.8805556 0.459843
+ 6.8808333 0.454732
+ 6.8811111 0.436835
+ 6.8813889 0.408317
+ 6.8816667 0.371342
+ 6.8819444 0.328075
+ 6.8822222 0.280682
+ 6.8825000 0.231327
+ 6.8827778 0.182174
+ 6.8830556 0.135390
+ 6.8833333 0.093139
+ 6.8836111 0.057254
+ 6.8838889 0.050000
+ 6.8841667 0.050000
+ 6.8844444 0.050000
+ 6.8847222 0.050000
+ 6.8850000 0.050000
+ 6.8852778 0.050000
+ 6.8855556 0.050000
+ 6.8858333 0.050000
+ 6.8861111 0.064923
+ 6.8863889 0.105337
+ 6.8866667 0.151854
+ 6.8869444 0.202109
+ 6.8872222 0.253737
+ 6.8875000 0.304370
+ 6.8877778 0.351643
+ 6.8880556 0.393190
+ 6.8883333 0.426645
+ 6.8886111 0.449643
+ 6.8888889 0.459817
+ 6.8891667 0.455562
+ 6.8894444 0.438316
+ 6.8897222 0.410278
+ 6.8900000 0.373645
+ 6.8902778 0.330616
+ 6.8905556 0.283391
+ 6.8908333 0.234167
+ 6.8911111 0.185142
+ 6.8913889 0.138516
+ 6.8916667 0.096486
+ 6.8919444 0.060911
+ 6.8922222 0.050000
+ 6.8925000 0.050000
+ 6.8927778 0.050000
+ 6.8930556 0.050000
+ 6.8933333 0.050000
+ 6.8936111 0.050000
+ 6.8938889 0.050000
+ 6.8941667 0.050000
+ 6.8944444 0.071630
+ 6.8947222 0.111960
+ 6.8950000 0.158247
+ 6.8952778 0.208131
+ 6.8955556 0.259252
+ 6.8958333 0.309250
+ 6.8961111 0.355765
+ 6.8963889 0.396436
+ 6.8966667 0.428905
+ 6.8969444 0.450809
+ 6.8972222 0.459791
+ 6.8975000 0.454259
+ 6.8977778 0.435704
+ 6.8980556 0.406388
+ 6.8983333 0.368572
+ 6.8986111 0.324517
+ 6.8988889 0.276483
+ 6.8991667 0.226733
+ 6.8994444 0.177527
+ 6.8997222 0.131126
+ 6.9000000 0.089792
+ 6.9002778 0.055414
+ 6.9005556 0.050000
+ 6.9008333 0.050000
+ 6.9011111 0.050000
+ 6.9013889 0.050000
+ 6.9016667 0.050000
+ 6.9019444 0.050000
+ 6.9022222 0.050000
+ 6.9025000 0.050000
+ 6.9027778 0.081711
+ 6.9030556 0.122212
+ 6.9033333 0.168141
+ 6.9036111 0.217240
+ 6.9038889 0.267248
+ 6.9041667 0.315906
+ 6.9044444 0.360955
+ 6.9047222 0.400134
+ 6.9050000 0.431183
+ 6.9052778 0.451844
+ 6.9055556 0.459856
+ 6.9058333 0.453699
+ 6.9061111 0.434811
+ 6.9063889 0.405365
+ 6.9066667 0.367539
+ 6.9069444 0.323509
+ 6.9072222 0.275450
+ 6.9075000 0.225538
+ 6.9077778 0.175949
+ 6.9080556 0.128859
+ 6.9083333 0.086444
+ 6.9086111 0.050544
+ 6.9088889 0.050000
+ 6.9091667 0.050000
+ 6.9094444 0.050000
+ 6.9097222 0.050000
+ 6.9100000 0.050000
+ 6.9102778 0.050000
+ 6.9105556 0.050000
+ 6.9108333 0.050000
+ 6.9111111 0.061562
+ 6.9113889 0.102364
+ 6.9116667 0.149228
+ 6.9119444 0.199799
+ 6.9122222 0.251723
+ 6.9125000 0.302645
+ 6.9127778 0.350211
+ 6.9130556 0.392065
+ 6.9133333 0.425854
+ 6.9136111 0.449223
+ 6.9138889 0.459817
+ 6.9141667 0.456043
+ 6.9144444 0.439353
+ 6.9147222 0.411961
+ 6.9150000 0.376081
+ 6.9152778 0.333927
+ 6.9155556 0.287712
+ 6.9158333 0.239651
+ 6.9161111 0.191958
+ 6.9163889 0.146845
+ 6.9166667 0.106528
+ 6.9169444 0.072860
+ 6.9172222 0.050000
+ 6.9175000 0.050000
+ 6.9177778 0.050000
+ 6.9180556 0.050000
+ 6.9183333 0.050000
+ 6.9186111 0.050000
+ 6.9188889 0.050000
+ 6.9191667 0.062963
+ 6.9194444 0.095048
+ 6.9197222 0.134351
+ 6.9200000 0.179013
+ 6.9202778 0.226789
+ 6.9205556 0.275435
+ 6.9208333 0.322708
+ 6.9211111 0.366361
+ 6.9213889 0.404153
+ 6.9216667 0.433837
+ 6.9219444 0.453170
+ 6.9222222 0.459908
+ 6.9225000 0.452559
+ 6.9227778 0.432640
+ 6.9230556 0.402421
+ 6.9233333 0.364172
+ 6.9236111 0.320162
+ 6.9238889 0.272661
+ 6.9241667 0.223938
+ 6.9244444 0.176264
+ 6.9247222 0.131907
+ 6.9250000 0.093139
+ 6.9252778 0.061827
+ 6.9255556 0.050000
+ 6.9258333 0.050000
+ 6.9261111 0.050000
+ 6.9263889 0.050000
+ 6.9266667 0.050000
+ 6.9269444 0.050000
+ 6.9272222 0.051578
+ 6.9275000 0.078378
+ 6.9277778 0.111849
+ 6.9280556 0.151535
+ 6.9283333 0.195680
+ 6.9286111 0.242208
+ 6.9288889 0.289038
+ 6.9291667 0.334093
+ 6.9294444 0.375294
+ 6.9297222 0.410562
+ 6.9300000 0.437819
+ 6.9302778 0.454987
+ 6.9305556 0.459987
+ 6.9308333 0.451450
+ 6.9311111 0.430845
+ 6.9313889 0.400353
+ 6.9316667 0.362153
+ 6.9319444 0.318425
+ 6.9322222 0.271347
+ 6.9325000 0.223100
+ 6.9327778 0.175864
+ 6.9330556 0.131817
+ 6.9333333 0.093139
+ 6.9336111 0.061634
+ 6.9338889 0.050000
+ 6.9341667 0.050000
+ 6.9344444 0.050000
+ 6.9347222 0.050000
+ 6.9350000 0.050000
+ 6.9352778 0.050000
+ 6.9355556 0.050000
+ 6.9358333 0.072156
+ 6.9361111 0.105142
+ 6.9363889 0.144575
+ 6.9366667 0.188702
+ 6.9369444 0.235433
+ 6.9372222 0.282679
+ 6.9375000 0.328352
+ 6.9377778 0.370361
+ 6.9380556 0.406618
+ 6.9383333 0.435035
+ 6.9386111 0.453520
+ 6.9388889 0.459987
+ 6.9391667 0.453054
+ 6.9394444 0.434179
+ 6.9397222 0.405528
+ 6.9400000 0.369268
+ 6.9402778 0.327564
+ 6.9405556 0.282584
+ 6.9408333 0.236493
+ 6.9411111 0.191459
+ 6.9413889 0.149646
+ 6.9416667 0.113222
+ 6.9419444 0.083967
+ 6.9422222 0.062112
+ 6.9425000 0.050000
+ 6.9427778 0.050000
+ 6.9430556 0.050000
+ 6.9433333 0.050000
+ 6.9436111 0.058480
+ 6.9438889 0.077806
+ 6.9441667 0.103457
+ 6.9444444 0.135280
+ 6.9447222 0.172822
+ 6.9450000 0.214433
+ 6.9452778 0.258166
+ 6.9455556 0.302072
+ 6.9458333 0.344202
+ 6.9461111 0.382608
+ 6.9463889 0.415342
+ 6.9466667 0.440456
+ 6.9469444 0.456000
+ 6.9472222 0.460026
+ 6.9475000 0.451258
+ 6.9477778 0.431107
+ 6.9480556 0.401652
+ 6.9483333 0.364977
+ 6.9486111 0.323164
+ 6.9488889 0.278293
+ 6.9491667 0.232447
+ 6.9494444 0.187707
+ 6.9497222 0.146156
+ 6.9500000 0.109875
+ 6.9502778 0.080579
+ 6.9505556 0.058520
+ 6.9508333 0.050000
+ 6.9511111 0.050000
+ 6.9513889 0.050000
+ 6.9516667 0.050000
+ 6.9519444 0.052712
+ 6.9522222 0.071638
+ 6.9525000 0.096989
+ 6.9527778 0.128651
+ 6.9530556 0.166200
+ 6.9533333 0.207987
+ 6.9536111 0.252055
+ 6.9538889 0.296448
+ 6.9541667 0.339211
+ 6.9544444 0.378385
+ 6.9547222 0.412015
+ 6.9550000 0.438145
+ 6.9552778 0.454819
+ 6.9555556 0.460078
+ 6.9558333 0.452634
+ 6.9561111 0.433856
+ 6.9563889 0.405780
+ 6.9566667 0.370442
+ 6.9569444 0.329878
+ 6.9572222 0.286123
+ 6.9575000 0.241214
+ 6.9577778 0.197186
+ 6.9580556 0.156075
+ 6.9583333 0.119917
+ 6.9586111 0.090397
+ 6.9588889 0.067802
+ 6.9591667 0.052069
+ 6.9594444 0.050000
+ 6.9597222 0.050000
+ 6.9600000 0.050000
+ 6.9602778 0.056462
+ 6.9605556 0.074074
+ 6.9608333 0.098162
+ 6.9611111 0.128664
+ 6.9613889 0.165203
+ 6.9616667 0.206154
+ 6.9619444 0.249579
+ 6.9622222 0.293541
+ 6.9625000 0.336103
+ 6.9627778 0.375326
+ 6.9630556 0.409274
+ 6.9633333 0.436010
+ 6.9636111 0.453595
+ 6.9638889 0.460092
+ 6.9641667 0.454207
+ 6.9644444 0.437227
+ 6.9647222 0.411077
+ 6.9650000 0.377688
+ 6.9652778 0.338987
+ 6.9655556 0.296903
+ 6.9658333 0.253364
+ 6.9661111 0.210300
+ 6.9663889 0.169637
+ 6.9666667 0.133306
+ 6.9669444 0.102926
+ 6.9672222 0.078891
+ 6.9675000 0.061286
+ 6.9677778 0.050198
+ 6.9680556 0.050000
+ 6.9683333 0.050000
+ 6.9686111 0.056883
+ 6.9688889 0.072713
+ 6.9691667 0.095487
+ 6.9694444 0.125291
+ 6.9697222 0.161840
+ 6.9700000 0.203377
+ 6.9702778 0.247775
+ 6.9705556 0.292907
+ 6.9708333 0.336646
+ 6.9711111 0.376865
+ 6.9713889 0.411437
+ 6.9716667 0.438234
+ 6.9719444 0.455131
+ 6.9722222 0.460000
+ 6.9725000 0.451438
+ 6.9727778 0.430938
+ 6.9730556 0.400716
+ 6.9733333 0.362990
+ 6.9736111 0.319976
+ 6.9738889 0.273892
+ 6.9741667 0.226953
+ 6.9744444 0.181377
+ 6.9747222 0.139381
+ 6.9750000 0.103181
+ 6.9752778 0.074584
+ 6.9755556 0.053764
+ 6.9758333 0.050000
+ 6.9761111 0.050000
+ 6.9763889 0.050000
+ 6.9766667 0.050000
+ 6.9769444 0.057994
+ 6.9772222 0.078845
+ 6.9775000 0.105810
+ 6.9777778 0.138653
+ 6.9780556 0.176858
+ 6.9783333 0.218796
+ 6.9786111 0.262563
+ 6.9788889 0.306251
+ 6.9791667 0.347955
+ 6.9794444 0.385769
+ 6.9797222 0.417786
+ 6.9800000 0.442101
+ 6.9802778 0.456808
+ 6.9805556 0.460000
+ 6.9808333 0.450425
+ 6.9811111 0.429447
+ 6.9813889 0.399083
+ 6.9816667 0.361349
+ 6.9819444 0.318262
+ 6.9822222 0.271841
+ 6.9825000 0.224100
+ 6.9827778 0.177058
+ 6.9830556 0.132732
+ 6.9833333 0.093139
+ 6.9836111 0.059975
+ 6.9838889 0.050000
+ 6.9841667 0.050000
+ 6.9844444 0.050000
+ 6.9847222 0.050000
+ 6.9850000 0.050000
+ 6.9852778 0.050000
+ 6.9855556 0.050000
+ 6.9858333 0.050000
+ 6.9861111 0.081659
+ 6.9863889 0.121081
+ 6.9866667 0.166037
+ 6.9869444 0.214320
+ 6.9872222 0.263718
+ 6.9875000 0.312023
+ 6.9877778 0.357024
+ 6.9880556 0.396513
+ 6.9883333 0.428278
+ 6.9886111 0.450112
+ 6.9888889 0.459804
+ 6.9891667 0.455848
+ 6.9894444 0.439553
+ 6.9897222 0.412933
+ 6.9900000 0.377999
+ 6.9902778 0.336764
+ 6.9905556 0.291242
+ 6.9908333 0.243444
+ 6.9911111 0.195384
+ 6.9913889 0.149075
+ 6.9916667 0.106528
+ 6.9919444 0.069481
+ 6.9922222 0.050000
+ 6.9925000 0.050000
+ 6.9927778 0.050000
+ 6.9930556 0.050000
+ 6.9933333 0.050000
+ 6.9936111 0.050000
+ 6.9938889 0.050000
+ 6.9941667 0.050000
+ 6.9944444 0.054894
+ 6.9947222 0.094769
+ 6.9950000 0.141479
+ 6.9952778 0.192511
+ 6.9955556 0.245354
+ 6.9958333 0.297494
+ 6.9961111 0.346419
+ 6.9963889 0.389617
+ 6.9966667 0.424576
+ 6.9969444 0.448783
+ 6.9972222 0.459725
+ 6.9975000 0.455691
+ 6.9977778 0.438165
+ 6.9980556 0.409432
+ 6.9983333 0.371777
+ 6.9986111 0.327485
+ 6.9988889 0.278841
+ 6.9991667 0.228130
+ 6.9994444 0.177637
+ 6.9997222 0.129647
+ 7.0000000 0.086444
+ 7.0002778 0.050000
+ 7.0005556 0.050000
+ 7.0008333 0.050000
+ 7.0011111 0.050000
+ 7.0013889 0.050000
+ 7.0016667 0.050000
+ 7.0019444 0.050000
+ 7.0022222 0.050000
+ 7.0025000 0.050000
+ 7.0027778 0.061562
+ 7.0030556 0.102630
+ 7.0033333 0.149724
+ 7.0036111 0.200481
+ 7.0038889 0.252538
+ 7.0041667 0.303529
+ 7.0044444 0.351093
+ 7.0047222 0.392864
+ 7.0050000 0.426480
+ 7.0052778 0.449577
+ 7.0055556 0.459791
+ 7.0058333 0.455515
+ 7.0061111 0.438167
+ 7.0063889 0.409922
+ 7.0066667 0.372956
+ 7.0069444 0.329442
+ 7.0072222 0.281557
+ 7.0075000 0.231474
+ 7.0077778 0.181369
+ 7.0080556 0.133416
+ 7.0083333 0.089792
+ 7.0086111 0.052349
+ 7.0088889 0.050000
+ 7.0091667 0.050000
+ 7.0094444 0.050000
+ 7.0097222 0.050000
+ 7.0100000 0.050000
+ 7.0102778 0.050000
+ 7.0105556 0.050000
+ 7.0108333 0.050000
+ 7.0111111 0.050000
+ 7.0113889 0.091134
+ 7.0116667 0.138841
+ 7.0119444 0.190641
+ 7.0122222 0.244058
+ 7.0125000 0.296614
+ 7.0127778 0.345831
+ 7.0130556 0.389233
+ 7.0133333 0.424341
+ 7.0136111 0.448677
+ 7.0138889 0.459765
+ 7.0141667 0.455915
+ 7.0144444 0.438600
+ 7.0147222 0.410077
+ 7.0150000 0.372607
+ 7.0152778 0.328450
+ 7.0155556 0.279865
+ 7.0158333 0.229112
+ 7.0161111 0.178451
+ 7.0163889 0.130142
+ 7.0166667 0.086444
+ 7.0169444 0.050000
+ 7.0172222 0.050000
+ 7.0175000 0.050000
+ 7.0177778 0.050000
+ 7.0180556 0.050000
+ 7.0183333 0.050000
+ 7.0186111 0.050000
+ 7.0188889 0.050000
+ 7.0191667 0.050000
+ 7.0194444 0.054868
+ 7.0197222 0.096283
+ 7.0200000 0.144002
+ 7.0202778 0.195584
+ 7.0205556 0.248588
+ 7.0208333 0.300571
+ 7.0211111 0.349093
+ 7.0213889 0.391710
+ 7.0216667 0.425983
+ 7.0219444 0.449468
+ 7.0222222 0.459725
+ 7.0225000 0.455098
+ 7.0227778 0.437072
+ 7.0230556 0.407918
+ 7.0233333 0.369910
+ 7.0236111 0.325317
+ 7.0238889 0.276412
+ 7.0241667 0.225465
+ 7.0244444 0.174750
+ 7.0247222 0.126537
+ 7.0250000 0.083097
+ 7.0252778 0.050000
+ 7.0255556 0.050000
+ 7.0258333 0.050000
+ 7.0261111 0.050000
+ 7.0263889 0.050000
+ 7.0266667 0.050000
+ 7.0269444 0.050000
+ 7.0272222 0.050000
+ 7.0275000 0.050000
+ 7.0277778 0.058268
+ 7.0280556 0.100074
+ 7.0283333 0.148033
+ 7.0286111 0.199698
+ 7.0288889 0.252624
+ 7.0291667 0.304366
+ 7.0294444 0.352480
+ 7.0297222 0.394519
+ 7.0300000 0.428039
+ 7.0302778 0.450593
+ 7.0305556 0.459738
+ 7.0308333 0.453822
+ 7.0311111 0.434370
+ 7.0313889 0.403700
+ 7.0316667 0.364132
+ 7.0319444 0.317984
+ 7.0322222 0.267575
+ 7.0325000 0.215224
+ 7.0327778 0.163250
+ 7.0330556 0.113972
+ 7.0333333 0.069708
+ 7.0336111 0.050000
+ 7.0338889 0.050000
+ 7.0341667 0.050000
+ 7.0344444 0.050000
+ 7.0347222 0.050000
+ 7.0350000 0.050000
+ 7.0352778 0.050000
+ 7.0355556 0.050000
+ 7.0358333 0.050000
+ 7.0361111 0.050000
+ 7.0363889 0.093336
+ 7.0366667 0.142886
+ 7.0369444 0.196121
+ 7.0372222 0.250514
+ 7.0375000 0.303537
+ 7.0377778 0.352663
+ 7.0380556 0.395365
+ 7.0383333 0.429115
+ 7.0386111 0.451384
+ 7.0388889 0.459647
+ 7.0391667 0.452209
+ 7.0394444 0.430714
+ 7.0397222 0.397639
+ 7.0400000 0.355461
+ 7.0402778 0.306660
+ 7.0405556 0.253711
+ 7.0408333 0.199094
+ 7.0411111 0.145284
+ 7.0413889 0.094760
+ 7.0416667 0.050000
+ 7.0419444 0.050000
+ 7.0422222 0.050000
+ 7.0425000 0.050000
+ 7.0427778 0.050000
+ 7.0430556 0.050000
+ 7.0433333 0.050000
+ 7.0436111 0.050000
+ 7.0438889 0.050000
+ 7.0441667 0.050000
+ 7.0444444 0.050000
+ 7.0447222 0.094568
+ 7.0450000 0.144843
+ 7.0452778 0.198382
+ 7.0455556 0.252743
+ 7.0458333 0.305482
+ 7.0461111 0.354157
+ 7.0463889 0.396325
+ 7.0466667 0.429543
+ 7.0469444 0.451369
+ 7.0472222 0.459359
+ 7.0475000 0.451887
+ 7.0477778 0.430587
+ 7.0480556 0.397907
+ 7.0483333 0.356299
+ 7.0486111 0.308211
+ 7.0488889 0.256094
+ 7.0491667 0.202396
+ 7.0494444 0.149568
+ 7.0497222 0.100059
+ 7.0500000 0.056319
+ 7.0502778 0.050000
+ 7.0505556 0.050000
+ 7.0508333 0.050000
+ 7.0511111 0.050000
+ 7.0513889 0.050000
+ 7.0516667 0.050000
+ 7.0519444 0.050000
+ 7.0522222 0.050000
+ 7.0525000 0.050000
+ 7.0527778 0.050000
+ 7.0530556 0.090371
+ 7.0533333 0.136019
+ 7.0536111 0.185014
+ 7.0538889 0.235426
+ 7.0541667 0.285326
+ 7.0544444 0.332782
+ 7.0547222 0.375866
+ 7.0550000 0.412647
+ 7.0552778 0.441196
+ 7.0555556 0.459582
+ 7.0558333 0.466462
+ 7.0561111 0.462843
+ 7.0563889 0.450318
+ 7.0566667 0.430480
+ 7.0569444 0.404923
+ 7.0572222 0.375240
+ 7.0575000 0.343023
+ 7.0577778 0.309868
+ 7.0580556 0.277366
+ 7.0583333 0.247111
+ 7.0586111 0.220468
+ 7.0588889 0.197883
+ 7.0591667 0.179575
+ 7.0594444 0.165763
+ 7.0597222 0.156665
+ 7.0600000 0.152500
+ 7.0602778 0.153485
+ 7.0605556 0.159839
+ 7.0608333 0.171781
+ 7.0611111 0.189528
+ 7.0613889 0.213080
+ 7.0616667 0.241554
+ 7.0619444 0.273846
+ 7.0622222 0.308855
+ 7.0625000 0.345478
+ 7.0627778 0.382613
+ 7.0630556 0.419155
+ 7.0633333 0.454004
+ 7.0636111 0.486056
+ 7.0638889 0.514209
+ 7.0641667 0.537487
+ 7.0644444 0.555417
+ 7.0647222 0.567654
+ 7.0650000 0.573854
+ 7.0652778 0.573669
+ 7.0655556 0.566756
+ 7.0658333 0.552768
+ 7.0661111 0.531360
+ 7.0663889 0.502187
+ 7.0666667 0.464903
+ 7.0669444 0.419643
+ 7.0672222 0.368461
+ 7.0675000 0.313893
+ 7.0677778 0.258472
+ 7.0680556 0.204734
+ 7.0683333 0.155214
+ 7.0686111 0.112445
+ 7.0688889 0.078964
+ 7.0691667 0.057304
+ 7.0694444 0.050000
+ 7.0697222 0.058779
+ 7.0700000 0.082138
+ 7.0702778 0.117763
+ 7.0705556 0.163342
+ 7.0708333 0.216564
+ 7.0711111 0.275116
+ 7.0713889 0.336685
+ 7.0716667 0.398961
+ 7.0719444 0.459630
+ 7.0722222 0.516380
+ 7.0725000 0.567152
+ 7.0727778 0.610896
+ 7.0730556 0.646815
+ 7.0733333 0.674111
+ 7.0736111 0.691988
+ 7.0738889 0.699649
+ 7.0741667 0.696295
+ 7.0744444 0.681131
+ 7.0747222 0.653359
+ 7.0750000 0.612181
+ 7.0752778 0.557563
+ 7.0755556 0.492520
+ 7.0758333 0.420826
+ 7.0761111 0.346260
+ 7.0763889 0.272596
+ 7.0766667 0.203613
+ 7.0769444 0.143085
+ 7.0772222 0.094789
+ 7.0775000 0.062502
+ 7.0777778 0.050000
+ 7.0780556 0.059678
+ 7.0783333 0.088405
+ 7.0786111 0.131668
+ 7.0788889 0.184955
+ 7.0791667 0.243753
+ 7.0794444 0.303550
+ 7.0797222 0.359833
+ 7.0800000 0.408089
+ 7.0802778 0.443806
+ 7.0805556 0.462471
+ 7.0808333 0.460904
+ 7.0811111 0.441248
+ 7.0813889 0.406981
+ 7.0816667 0.361579
+ 7.0819444 0.308518
+ 7.0822222 0.251274
+ 7.0825000 0.193324
+ 7.0827778 0.138144
+ 7.0830556 0.089211
+ 7.0833333 0.050000
+ 7.0836111 0.050000
+ 7.0838889 0.050000
+ 7.0841667 0.050000
+ 7.0844444 0.050000
+ 7.0847222 0.050000
+ 7.0850000 0.050000
+ 7.0852778 0.075955
+ 7.0855556 0.109688
+ 7.0858333 0.147511
+ 7.0861111 0.188286
+ 7.0863889 0.230827
+ 7.0866667 0.273753
+ 7.0869444 0.315637
+ 7.0872222 0.355053
+ 7.0875000 0.390573
+ 7.0877778 0.420768
+ 7.0880556 0.444213
+ 7.0883333 0.459478
+ 7.0886111 0.465138
+ 7.0888889 0.459765
+ 7.0891667 0.442495
+ 7.0894444 0.414726
+ 7.0897222 0.378420
+ 7.0900000 0.335537
+ 7.0902778 0.288041
+ 7.0905556 0.237891
+ 7.0908333 0.187051
+ 7.0911111 0.137481
+ 7.0913889 0.091144
+ 7.0916667 0.050000
+ 7.0919444 0.050000
+ 7.0922222 0.050000
+ 7.0925000 0.050000
+ 7.0927778 0.050000
+ 7.0930556 0.050000
+ 7.0933333 0.050000
+ 7.0936111 0.050000
+ 7.0938889 0.050000
+ 7.0941667 0.050000
+ 7.0944444 0.050000
+ 7.0947222 0.093809
+ 7.0950000 0.143572
+ 7.0952778 0.196819
+ 7.0955556 0.251078
+ 7.0958333 0.303880
+ 7.0961111 0.352754
+ 7.0963889 0.395229
+ 7.0966667 0.428835
+ 7.0969444 0.451100
+ 7.0972222 0.459555
+ 7.0975000 0.452545
+ 7.0977778 0.431674
+ 7.0980556 0.399365
+ 7.0983333 0.358038
+ 7.0986111 0.310117
+ 7.0988889 0.258020
+ 7.0991667 0.204171
+ 7.0994444 0.150990
+ 7.0997222 0.100899
+ 7.1000000 0.056319
+ 7.1002778 0.050000
+ 7.1005556 0.050000
+ 7.1008333 0.050000
+ 7.1011111 0.050000
+ 7.1013889 0.050000
+ 7.1016667 0.050000
+ 7.1019444 0.050000
+ 7.1022222 0.050000
+ 7.1025000 0.050000
+ 7.1027778 0.050000
+ 7.1030556 0.094246
+ 7.1033333 0.144377
+ 7.1036111 0.197914
+ 7.1038889 0.252377
+ 7.1041667 0.305285
+ 7.1044444 0.354158
+ 7.1047222 0.396517
+ 7.1050000 0.429880
+ 7.1052778 0.451767
+ 7.1055556 0.459699
+ 7.1058333 0.452020
+ 7.1061111 0.430369
+ 7.1063889 0.397213
+ 7.1066667 0.355015
+ 7.1069444 0.306242
+ 7.1072222 0.253357
+ 7.1075000 0.198825
+ 7.1077778 0.145112
+ 7.1080556 0.094682
+ 7.1083333 0.050000
+ 7.1086111 0.050000
+ 7.1088889 0.050000
+ 7.1091667 0.050000
+ 7.1094444 0.050000
+ 7.1097222 0.050000
+ 7.1100000 0.050000
+ 7.1102778 0.050000
+ 7.1105556 0.050000
+ 7.1108333 0.050000
+ 7.1111111 0.050000
+ 7.1113889 0.094582
+ 7.1116667 0.144884
+ 7.1119444 0.198457
+ 7.1122222 0.252857
+ 7.1125000 0.305637
+ 7.1127778 0.354349
+ 7.1130556 0.396547
+ 7.1133333 0.429785
+ 7.1136111 0.451617
+ 7.1138889 0.459595
+ 7.1141667 0.452087
+ 7.1144444 0.430715
+ 7.1147222 0.397915
+ 7.1150000 0.356124
+ 7.1152778 0.307777
+ 7.1155556 0.255310
+ 7.1158333 0.201161
+ 7.1161111 0.147764
+ 7.1163889 0.097555
+ 7.1166667 0.052972
+ 7.1169444 0.050000
+ 7.1172222 0.050000
+ 7.1175000 0.050000
+ 7.1177778 0.050000
+ 7.1180556 0.050000
+ 7.1183333 0.050000
+ 7.1186111 0.050000
+ 7.1188889 0.050000
+ 7.1191667 0.050000
+ 7.1194444 0.050000
+ 7.1197222 0.094447
+ 7.1200000 0.144702
+ 7.1202778 0.198295
+ 7.1205556 0.252758
+ 7.1208333 0.305625
+ 7.1211111 0.354425
+ 7.1213889 0.396692
+ 7.1216667 0.429957
+ 7.1219444 0.451751
+ 7.1222222 0.459608
+ 7.1225000 0.451879
+ 7.1227778 0.430205
+ 7.1230556 0.397045
+ 7.1233333 0.354859
+ 7.1236111 0.306109
+ 7.1238889 0.253255
+ 7.1241667 0.198756
+ 7.1244444 0.145074
+ 7.1247222 0.094668
+ 7.1250000 0.050000
+ 7.1252778 0.050000
+ 7.1255556 0.050000
+ 7.1258333 0.050000
+ 7.1261111 0.050000
+ 7.1263889 0.050000
+ 7.1266667 0.050000
+ 7.1269444 0.050000
+ 7.1272222 0.050000
+ 7.1275000 0.050000
+ 7.1277778 0.050000
+ 7.1280556 0.094659
+ 7.1283333 0.145053
+ 7.1286111 0.198723
+ 7.1288889 0.253211
+ 7.1291667 0.306059
+ 7.1294444 0.354809
+ 7.1297222 0.397002
+ 7.1300000 0.430180
+ 7.1302778 0.451886
+ 7.1305556 0.459660
+ 7.1308333 0.451864
+ 7.1311111 0.430139
+ 7.1313889 0.396942
+ 7.1316667 0.354735
+ 7.1319444 0.305977
+ 7.1322222 0.253127
+ 7.1325000 0.198644
+ 7.1327778 0.144990
+ 7.1330556 0.094622
+ 7.1333333 0.050000
+ 7.1336111 0.050000
+ 7.1338889 0.050000
+ 7.1341667 0.050000
+ 7.1344444 0.050000
+ 7.1347222 0.050000
+ 7.1350000 0.050000
+ 7.1352778 0.050000
+ 7.1355556 0.050000
+ 7.1358333 0.050000
+ 7.1361111 0.050000
+ 7.1363889 0.094493
+ 7.1366667 0.144696
+ 7.1369444 0.198173
+ 7.1372222 0.252489
+ 7.1375000 0.305209
+ 7.1377778 0.353897
+ 7.1380556 0.396117
+ 7.1383333 0.429435
+ 7.1386111 0.451414
+ 7.1388889 0.459621
+ 7.1391667 0.452426
+ 7.1394444 0.431435
+ 7.1397222 0.399061
+ 7.1400000 0.357714
+ 7.1402778 0.309808
+ 7.1405556 0.257755
+ 7.1408333 0.203967
+ 7.1411111 0.150857
+ 7.1413889 0.100837
+ 7.1416667 0.056319
+ 7.1419444 0.050000
+ 7.1422222 0.050000
+ 7.1425000 0.050000
+ 7.1427778 0.050000
+ 7.1430556 0.050000
+ 7.1433333 0.050000
+ 7.1436111 0.050000
+ 7.1438889 0.050000
+ 7.1441667 0.050000
+ 7.1444444 0.050000
+ 7.1447222 0.094226
+ 7.1450000 0.144341
+ 7.1452778 0.197864
+ 7.1455556 0.252316
+ 7.1458333 0.305216
+ 7.1461111 0.354084
+ 7.1463889 0.396440
+ 7.1466667 0.429803
+ 7.1469444 0.451695
+ 7.1472222 0.459634
+ 7.1475000 0.451964
+ 7.1477778 0.430326
+ 7.1480556 0.397183
+ 7.1483333 0.354998
+ 7.1486111 0.306237
+ 7.1488889 0.253361
+ 7.1491667 0.198836
+ 7.1494444 0.145125
+ 7.1497222 0.094692
+ 7.1500000 0.050000
+ 7.1502778 0.050000
+ 7.1505556 0.050000
+ 7.1508333 0.050000
+ 7.1511111 0.050000
+ 7.1513889 0.050000
+ 7.1516667 0.050000
+ 7.1519444 0.050000
+ 7.1522222 0.050000
+ 7.1525000 0.050000
+ 7.1527778 0.050000
+ 7.1530556 0.094657
+ 7.1533333 0.145046
+ 7.1536111 0.198709
+ 7.1538889 0.253189
+ 7.1541667 0.306028
+ 7.1544444 0.354769
+ 7.1547222 0.396955
+ 7.1550000 0.430129
+ 7.1552778 0.451832
+ 7.1555556 0.459608
+ 7.1558333 0.451818
+ 7.1561111 0.430102
+ 7.1563889 0.396917
+ 7.1566667 0.354722
+ 7.1569444 0.305975
+ 7.1572222 0.253135
+ 7.1575000 0.198659
+ 7.1577778 0.145005
+ 7.1580556 0.094633
+ 7.1583333 0.050000
+ 7.1586111 0.050000
+ 7.1588889 0.050000
+ 7.1591667 0.050000
+ 7.1594444 0.050000
+ 7.1597222 0.050000
+ 7.1600000 0.050000
+ 7.1602778 0.050000
+ 7.1605556 0.050000
+ 7.1608333 0.050000
+ 7.1611111 0.050000
+ 7.1613889 0.094579
+ 7.1616667 0.144881
+ 7.1619444 0.198461
+ 7.1622222 0.252869
+ 7.1625000 0.305658
+ 7.1627778 0.354381
+ 7.1630556 0.396590
+ 7.1633333 0.429838
+ 7.1636111 0.451677
+ 7.1638889 0.459660
+ 7.1641667 0.452153
+ 7.1644444 0.430778
+ 7.1647222 0.397973
+ 7.1650000 0.356174
+ 7.1652778 0.307818
+ 7.1655556 0.255342
+ 7.1658333 0.201183
+ 7.1661111 0.147777
+ 7.1663889 0.097561
+ 7.1666667 0.052972
+ 7.1669444 0.050000
+ 7.1672222 0.050000
+ 7.1675000 0.050000
+ 7.1677778 0.050000
+ 7.1680556 0.050000
+ 7.1683333 0.050000
+ 7.1686111 0.050000
+ 7.1688889 0.050000
+ 7.1691667 0.050000
+ 7.1694444 0.050000
+ 7.1697222 0.094442
+ 7.1700000 0.144688
+ 7.1702778 0.198272
+ 7.1705556 0.252725
+ 7.1708333 0.305581
+ 7.1711111 0.354371
+ 7.1713889 0.396629
+ 7.1716667 0.429886
+ 7.1719444 0.451675
+ 7.1722222 0.459529
+ 7.1725000 0.451802
+ 7.1727778 0.430131
+ 7.1730556 0.396977
+ 7.1733333 0.354800
+ 7.1736111 0.306059
+ 7.1738889 0.253215
+ 7.1741667 0.198727
+ 7.1744444 0.145055
+ 7.1747222 0.094660
+ 7.1750000 0.050000
+ 7.1752778 0.050000
+ 7.1755556 0.050000
+ 7.1758333 0.050000
+ 7.1761111 0.050000
+ 7.1763889 0.050000
+ 7.1766667 0.050000
+ 7.1769444 0.050000
+ 7.1772222 0.050000
+ 7.1775000 0.050000
+ 7.1777778 0.050000
+ 7.1780556 0.094651
+ 7.1783333 0.145036
+ 7.1786111 0.198697
+ 7.1788889 0.253176
+ 7.1791667 0.306017
+ 7.1794444 0.354761
+ 7.1797222 0.396952
+ 7.1800000 0.430130
+ 7.1802778 0.451839
+ 7.1805556 0.459621
+ 7.1808333 0.451837
+ 7.1811111 0.430127
+ 7.1813889 0.396948
+ 7.1816667 0.354757
+ 7.1819444 0.306012
+ 7.1822222 0.253171
+ 7.1825000 0.198692
+ 7.1827778 0.145032
+ 7.1830556 0.094648
+ 7.1833333 0.050000
+ 7.1836111 0.050000
+ 7.1838889 0.050000
+ 7.1841667 0.050000
+ 7.1844444 0.050000
+ 7.1847222 0.050000
+ 7.1850000 0.050000
+ 7.1852778 0.050000
+ 7.1855556 0.050000
+ 7.1858333 0.050000
+ 7.1861111 0.050000
+ 7.1863889 0.094649
+ 7.1866667 0.145032
+ 7.1869444 0.198692
+ 7.1872222 0.253172
+ 7.1875000 0.306013
+ 7.1877778 0.354758
+ 7.1880556 0.396949
+ 7.1883333 0.430128
+ 7.1886111 0.451838
+ 7.1888889 0.459621
+ 7.1891667 0.451838
+ 7.1894444 0.430128
+ 7.1897222 0.396949
+ 7.1900000 0.354758
+ 7.1902778 0.306013
+ 7.1905556 0.253172
+ 7.1908333 0.198692
+ 7.1911111 0.145032
+ 7.1913889 0.094649
+ 7.1916667 0.050000
+ 7.1919444 0.050000
+ 7.1922222 0.050000
+ 7.1925000 0.050000
+ 7.1927778 0.050000
+ 7.1930556 0.050000
+ 7.1933333 0.050000
+ 7.1936111 0.050000
+ 7.1938889 0.050000
+ 7.1941667 0.050000
+ 7.1944444 0.050000
+ 7.1947222 0.094649
+ 7.1950000 0.145032
+ 7.1952778 0.198692
+ 7.1955556 0.253172
+ 7.1958333 0.306013
+ 7.1961111 0.354758
+ 7.1963889 0.396949
+ 7.1966667 0.430128
+ 7.1969444 0.451838
+ 7.1972222 0.459621
+ 7.1975000 0.451838
+ 7.1977778 0.430128
+ 7.1980556 0.396949
+ 7.1983333 0.354758
+ 7.1986111 0.306013
+ 7.1988889 0.253172
+ 7.1991667 0.198693
+ 7.1994444 0.145032
+ 7.1997222 0.094649
+ 7.2000000 0.050000
+ 7.2002778 0.050000
+ 7.2005556 0.050000
+ 7.2008333 0.050000
+ 7.2011111 0.050000
+ 7.2013889 0.050000
+ 7.2016667 0.050000
+ 7.2019444 0.050000
+ 7.2022222 0.050000
+ 7.2025000 0.050000
+ 7.2027778 0.050000
+ 7.2030556 0.094650
+ 7.2033333 0.145035
+ 7.2036111 0.198697
+ 7.2038889 0.253178
+ 7.2041667 0.306021
+ 7.2044444 0.354768
+ 7.2047222 0.396960
+ 7.2050000 0.430140
+ 7.2052778 0.451851
+ 7.2055556 0.459634
+ 7.2058333 0.451851
+ 7.2061111 0.430140
+ 7.2063889 0.396959
+ 7.2066667 0.354767
+ 7.2069444 0.306020
+ 7.2072222 0.253177
+ 7.2075000 0.198696
+ 7.2077778 0.145034
+ 7.2080556 0.094649
+ 7.2083333 0.050000
+ 7.2086111 0.050000
+ 7.2088889 0.050000
+ 7.2091667 0.050000
+ 7.2094444 0.050000
+ 7.2097222 0.050000
+ 7.2100000 0.050000
+ 7.2102778 0.050000
+ 7.2105556 0.050000
+ 7.2108333 0.050000
+ 7.2111111 0.050000
+ 7.2113889 0.094647
+ 7.2116667 0.145027
+ 7.2119444 0.198684
+ 7.2122222 0.253160
+ 7.2125000 0.305998
+ 7.2127778 0.354740
+ 7.2130556 0.396928
+ 7.2133333 0.430105
+ 7.2136111 0.451813
+ 7.2138889 0.459595
+ 7.2141667 0.451812
+ 7.2144444 0.430103
+ 7.2147222 0.396926
+ 7.2150000 0.354738
+ 7.2152778 0.305996
+ 7.2155556 0.253158
+ 7.2158333 0.198682
+ 7.2161111 0.145025
+ 7.2163889 0.094645
+ 7.2166667 0.050000
+ 7.2169444 0.050000
+ 7.2172222 0.050000
+ 7.2175000 0.050000
+ 7.2177778 0.050000
+ 7.2180556 0.050000
+ 7.2183333 0.050000
+ 7.2186111 0.050000
+ 7.2188889 0.050000
+ 7.2191667 0.050000
+ 7.2194444 0.050000
+ 7.2197222 0.094644
+ 7.2200000 0.145023
+ 7.2202778 0.198678
+ 7.2205556 0.253152
+ 7.2208333 0.305988
+ 7.2211111 0.354728
+ 7.2213889 0.396915
+ 7.2216667 0.430091
+ 7.2219444 0.451799
+ 7.2222222 0.459582
+ 7.2225000 0.451800
+ 7.2227778 0.430093
+ 7.2230556 0.396917
+ 7.2233333 0.354731
+ 7.2236111 0.305991
+ 7.2238889 0.253155
+ 7.2241667 0.198681
+ 7.2244444 0.145025
+ 7.2247222 0.094646
+ 7.2250000 0.050000
+ 7.2252778 0.050000
+ 7.2255556 0.050000
+ 7.2258333 0.050000
+ 7.2261111 0.050000
+ 7.2263889 0.050000
+ 7.2266667 0.050000
+ 7.2269444 0.050000
+ 7.2272222 0.050000
+ 7.2275000 0.050000
+ 7.2277778 0.050000
+ 7.2280556 0.094652
+ 7.2283333 0.145039
+ 7.2286111 0.198704
+ 7.2288889 0.253189
+ 7.2291667 0.306035
+ 7.2294444 0.354785
+ 7.2297222 0.396980
+ 7.2300000 0.430164
+ 7.2302778 0.451876
+ 7.2305556 0.459660
+ 7.2308333 0.451877
+ 7.2311111 0.430165
+ 7.2313889 0.396983
+ 7.2316667 0.354787
+ 7.2319444 0.306038
+ 7.2322222 0.253192
+ 7.2325000 0.198707
+ 7.2327778 0.145041
+ 7.2330556 0.094653
+ 7.2333333 0.050000
+ 7.2336111 0.050000
+ 7.2338889 0.050000
+ 7.2341667 0.050000
+ 7.2344444 0.050000
+ 7.2347222 0.050000
+ 7.2350000 0.050000
+ 7.2352778 0.050000
+ 7.2355556 0.050000
+ 7.2358333 0.050000
+ 7.2361111 0.050000
+ 7.2363889 0.094652
+ 7.2366667 0.145039
+ 7.2369444 0.198703
+ 7.2372222 0.253186
+ 7.2375000 0.306030
+ 7.2377778 0.354778
+ 7.2380556 0.396972
+ 7.2383333 0.430153
+ 7.2386111 0.451864
+ 7.2388889 0.459647
+ 7.2391667 0.451863
+ 7.2394444 0.430152
+ 7.2397222 0.396970
+ 7.2400000 0.354776
+ 7.2402778 0.306028
+ 7.2405556 0.253183
+ 7.2408333 0.198700
+ 7.2411111 0.145037
+ 7.2413889 0.094651
+ 7.2416667 0.050000
+ 7.2419444 0.050000
+ 7.2422222 0.050000
+ 7.2425000 0.050000
+ 7.2427778 0.050000
+ 7.2430556 0.050000
+ 7.2433333 0.050000
+ 7.2436111 0.050000
+ 7.2438889 0.050000
+ 7.2441667 0.050000
+ 7.2444444 0.050000
+ 7.2447222 0.094648
+ 7.2450000 0.145030
+ 7.2452778 0.198689
+ 7.2455556 0.253167
+ 7.2458333 0.306006
+ 7.2461111 0.354749
+ 7.2463889 0.396939
+ 7.2466667 0.430117
+ 7.2469444 0.451826
+ 7.2472222 0.459608
+ 7.2475000 0.451825
+ 7.2477778 0.430115
+ 7.2480556 0.396937
+ 7.2483333 0.354747
+ 7.2486111 0.306004
+ 7.2488889 0.253164
+ 7.2491667 0.198687
+ 7.2494444 0.145028
+ 7.2497222 0.094647
+ 7.2500000 0.050000
+ 7.2502778 0.050000
+ 7.2505556 0.050000
+ 7.2508333 0.050000
+ 7.2511111 0.050000
+ 7.2513889 0.050000
+ 7.2516667 0.050000
+ 7.2519444 0.050000
+ 7.2522222 0.050000
+ 7.2525000 0.050000
+ 7.2527778 0.050000
+ 7.2530556 0.094645
+ 7.2533333 0.145024
+ 7.2536111 0.198680
+ 7.2538889 0.253154
+ 7.2541667 0.305991
+ 7.2544444 0.354731
+ 7.2547222 0.396917
+ 7.2550000 0.430093
+ 7.2552778 0.451800
+ 7.2555556 0.459582
+ 7.2558333 0.451799
+ 7.2561111 0.430090
+ 7.2563889 0.396913
+ 7.2566667 0.354725
+ 7.2569444 0.305984
+ 7.2572222 0.253148
+ 7.2575000 0.198673
+ 7.2577778 0.145019
+ 7.2580556 0.094642
+ 7.2583333 0.050000
+ 7.2586111 0.050000
+ 7.2588889 0.050000
+ 7.2591667 0.050000
+ 7.2594444 0.050000
+ 7.2597222 0.050000
+ 7.2600000 0.050000
+ 7.2602778 0.050000
+ 7.2605556 0.050000
+ 7.2608333 0.050000
+ 7.2611111 0.050000
+ 7.2613889 0.094632
+ 7.2616667 0.144996
+ 7.2619444 0.198635
+ 7.2622222 0.253092
+ 7.2625000 0.305911
+ 7.2627778 0.354635
+ 7.2630556 0.396808
+ 7.2633333 0.429972
+ 7.2636111 0.451672
+ 7.2638889 0.459451
+ 7.2641667 0.451671
+ 7.2644444 0.429969
+ 7.2647222 0.396804
+ 7.2650000 0.354630
+ 7.2652778 0.305906
+ 7.2655556 0.253087
+ 7.2658333 0.198630
+ 7.2661111 0.144992
+ 7.2663889 0.094630
+ 7.2666667 0.050000
+ 7.2669444 0.050000
+ 7.2672222 0.050000
+ 7.2675000 0.050000
+ 7.2677778 0.050000
+ 7.2680556 0.050000
+ 7.2683333 0.050000
+ 7.2686111 0.050000
+ 7.2688889 0.050000
+ 7.2691667 0.050000
+ 7.2694444 0.050000
+ 7.2697222 0.094630
+ 7.2700000 0.144992
+ 7.2702778 0.198630
+ 7.2705556 0.253087
+ 7.2708333 0.305906
+ 7.2711111 0.354631
+ 7.2713889 0.396804
+ 7.2716667 0.429970
+ 7.2719444 0.451671
+ 7.2722222 0.459451
+ 7.2725000 0.451672
+ 7.2727778 0.429971
+ 7.2730556 0.396806
+ 7.2733333 0.354633
+ 7.2736111 0.305908
+ 7.2738889 0.253089
+ 7.2741667 0.198632
+ 7.2744444 0.144994
+ 7.2747222 0.094631
+ 7.2750000 0.050000
+ 7.2752778 0.050000
+ 7.2755556 0.050000
+ 7.2758333 0.050000
+ 7.2761111 0.050000
+ 7.2763889 0.050000
+ 7.2766667 0.050000
+ 7.2769444 0.050000
+ 7.2772222 0.050000
+ 7.2775000 0.050000
+ 7.2777778 0.050000
+ 7.2780556 0.094634
+ 7.2783333 0.145000
+ 7.2786111 0.198643
+ 7.2788889 0.253105
+ 7.2791667 0.305930
+ 7.2794444 0.354659
+ 7.2797222 0.396837
+ 7.2800000 0.430006
+ 7.2802778 0.451709
+ 7.2805556 0.459490
+ 7.2808333 0.451710
+ 7.2811111 0.430007
+ 7.2813889 0.396839
+ 7.2816667 0.354662
+ 7.2819444 0.305932
+ 7.2822222 0.253108
+ 7.2825000 0.198646
+ 7.2827778 0.145003
+ 7.2830556 0.094635
+ 7.2833333 0.050000
+ 7.2836111 0.050000
+ 7.2838889 0.050000
+ 7.2841667 0.050000
+ 7.2844444 0.050000
+ 7.2847222 0.050000
+ 7.2850000 0.050000
+ 7.2852778 0.050000
+ 7.2855556 0.050000
+ 7.2858333 0.050000
+ 7.2861111 0.050000
+ 7.2863889 0.094637
+ 7.2866667 0.145007
+ 7.2869444 0.198653
+ 7.2872222 0.253119
+ 7.2875000 0.305946
+ 7.2877778 0.354679
+ 7.2880556 0.396859
+ 7.2883333 0.430030
+ 7.2886111 0.451735
+ 7.2888889 0.459516
+ 7.2891667 0.451736
+ 7.2894444 0.430032
+ 7.2897222 0.396862
+ 7.2900000 0.354682
+ 7.2902778 0.305950
+ 7.2905556 0.253122
+ 7.2908333 0.198656
+ 7.2911111 0.145009
+ 7.2913889 0.094638
+ 7.2916667 0.050000
+ 7.2919444 0.050000
+ 7.2922222 0.050000
+ 7.2925000 0.050000
+ 7.2927778 0.050000
+ 7.2930556 0.050000
+ 7.2933333 0.050000
+ 7.2936111 0.050000
+ 7.2938889 0.050000
+ 7.2941667 0.050000
+ 7.2944444 0.050000
+ 7.2947222 0.094642
+ 7.2950000 0.145019
+ 7.2952778 0.198673
+ 7.2955556 0.253147
+ 7.2958333 0.305983
+ 7.2961111 0.354724
+ 7.2963889 0.396913
+ 7.2966667 0.430093
+ 7.2969444 0.451806
+ 7.2972222 0.459595
+ 7.2975000 0.451821
+ 7.2977778 0.430122
+ 7.2980556 0.396954
+ 7.2983333 0.354775
+ 7.2986111 0.306039
+ 7.2988889 0.253204
+ 7.2991667 0.198726
+ 7.2994444 0.145062
+ 7.2997222 0.094668
+ 7.3000000 0.050000
+ 7.3002778 0.050000
+ 7.3005556 0.050000
+ 7.3008333 0.050000
+ 7.3011111 0.050000
+ 7.3013889 0.050000
+ 7.3016667 0.050000
+ 7.3019444 0.050000
+ 7.3022222 0.050000
+ 7.3025000 0.050000
+ 7.3027778 0.050000
+ 7.3030556 0.094758
+ 7.3033333 0.145270
+ 7.3036111 0.199062
+ 7.3038889 0.253662
+ 7.3041667 0.306596
+ 7.3044444 0.355393
+ 7.3047222 0.397580
+ 7.3050000 0.430684
+ 7.3052778 0.452232
+ 7.3055556 0.459752
+ 7.3058333 0.451601
+ 7.3061111 0.429460
+ 7.3063889 0.395839
+ 7.3066667 0.353251
+ 7.3069444 0.304205
+ 7.3072222 0.251213
+ 7.3075000 0.196785
+ 7.3077778 0.143433
+ 7.3080556 0.093668
+ 7.3083333 0.050000
+ 7.3086111 0.050000
+ 7.3088889 0.050000
+ 7.3091667 0.050000
+ 7.3094444 0.050000
+ 7.3097222 0.050000
+ 7.3100000 0.050000
+ 7.3102778 0.050000
+ 7.3105556 0.050000
+ 7.3108333 0.050000
+ 7.3111111 0.064727
+ 7.3113889 0.109044
+ 7.3116667 0.158550
+ 7.3119444 0.210899
+ 7.3122222 0.263744
+ 7.3125000 0.314739
+ 7.3127778 0.361537
+ 7.3130556 0.401792
+ 7.3133333 0.433157
+ 7.3136111 0.453285
+ 7.3138889 0.459830
+ 7.3141667 0.451243
+ 7.3144444 0.429166
+ 7.3147222 0.396039
+ 7.3150000 0.354300
+ 7.3152778 0.306391
+ 7.3155556 0.254750
+ 7.3158333 0.201818
+ 7.3161111 0.150033
+ 7.3163889 0.101836
+ 7.3166667 0.059667
+ 7.3169444 0.050000
+ 7.3172222 0.050000
+ 7.3175000 0.050000
+ 7.3177778 0.050000
+ 7.3180556 0.050000
+ 7.3183333 0.050000
+ 7.3186111 0.050000
+ 7.3188889 0.050000
+ 7.3191667 0.050000
+ 7.3194444 0.078220
+ 7.3197222 0.121354
+ 7.3200000 0.169411
+ 7.3202778 0.220131
+ 7.3205556 0.271252
+ 7.3208333 0.320514
+ 7.3211111 0.365654
+ 7.3213889 0.404412
+ 7.3216667 0.434526
+ 7.3219444 0.453735
+ 7.3222222 0.459778
+ 7.3225000 0.451164
+ 7.3227778 0.429488
+ 7.3230556 0.397115
+ 7.3233333 0.356412
+ 7.3236111 0.309743
+ 7.3238889 0.259474
+ 7.3241667 0.207970
+ 7.3244444 0.157598
+ 7.3247222 0.110722
+ 7.3250000 0.069708
+ 7.3252778 0.050000
+ 7.3255556 0.050000
+ 7.3258333 0.050000
+ 7.3261111 0.050000
+ 7.3263889 0.050000
+ 7.3266667 0.050000
+ 7.3269444 0.050000
+ 7.3272222 0.050000
+ 7.3275000 0.052802
+ 7.3277778 0.088288
+ 7.3280556 0.130459
+ 7.3283333 0.177443
+ 7.3286111 0.227018
+ 7.3288889 0.276961
+ 7.3291667 0.325050
+ 7.3294444 0.369061
+ 7.3297222 0.406773
+ 7.3300000 0.435962
+ 7.3302778 0.454406
+ 7.3305556 0.459882
+ 7.3308333 0.450926
+ 7.3311111 0.429100
+ 7.3313889 0.396726
+ 7.3316667 0.356125
+ 7.3319444 0.309617
+ 7.3322222 0.259523
+ 7.3325000 0.208164
+ 7.3327778 0.157862
+ 7.3330556 0.110936
+ 7.3333333 0.069708
+ 7.3336111 0.050000
+ 7.3338889 0.050000
+ 7.3341667 0.050000
+ 7.3344444 0.050000
+ 7.3347222 0.050000
+ 7.3350000 0.050000
+ 7.3352778 0.050000
+ 7.3355556 0.050000
+ 7.3358333 0.050000
+ 7.3361111 0.081554
+ 7.3363889 0.123472
+ 7.3366667 0.170406
+ 7.3369444 0.220133
+ 7.3372222 0.270432
+ 7.3375000 0.319083
+ 7.3377778 0.363865
+ 7.3380556 0.402555
+ 7.3383333 0.432934
+ 7.3386111 0.452779
+ 7.3388889 0.459869
+ 7.3391667 0.452727
+ 7.3394444 0.432842
+ 7.3397222 0.402449
+ 7.3400000 0.363781
+ 7.3402778 0.319073
+ 7.3405556 0.270557
+ 7.3408333 0.220468
+ 7.3411111 0.171039
+ 7.3413889 0.124504
+ 7.3416667 0.083097
+ 7.3419444 0.050000
+ 7.3422222 0.050000
+ 7.3425000 0.050000
+ 7.3427778 0.050000
+ 7.3430556 0.050000
+ 7.3433333 0.050000
+ 7.3436111 0.050000
+ 7.3438889 0.050000
+ 7.3441667 0.050000
+ 7.3444444 0.078233
+ 7.3447222 0.119697
+ 7.3450000 0.166665
+ 7.3452778 0.216799
+ 7.3455556 0.267757
+ 7.3458333 0.317201
+ 7.3461111 0.362790
+ 7.3463889 0.402185
+ 7.3466667 0.433045
+ 7.3469444 0.453032
+ 7.3472222 0.459804
+ 7.3475000 0.451806
+ 7.3477778 0.430617
+ 7.3480556 0.398599
+ 7.3483333 0.358114
+ 7.3486111 0.311526
+ 7.3488889 0.261196
+ 7.3491667 0.209487
+ 7.3494444 0.158761
+ 7.3497222 0.111380
+ 7.3500000 0.069708
+ 7.3502778 0.050000
+ 7.3505556 0.050000
+ 7.3508333 0.050000
+ 7.3511111 0.050000
+ 7.3513889 0.050000
+ 7.3516667 0.050000
+ 7.3519444 0.050000
+ 7.3522222 0.050000
+ 7.3525000 0.050000
+ 7.3527778 0.081594
+ 7.3530556 0.124178
+ 7.3533333 0.171849
+ 7.3536111 0.222302
+ 7.3538889 0.273235
+ 7.3541667 0.322342
+ 7.3544444 0.367320
+ 7.3547222 0.405866
+ 7.3550000 0.435675
+ 7.3552778 0.454444
+ 7.3555556 0.459869
+ 7.3558333 0.450433
+ 7.3561111 0.427762
+ 7.3563889 0.394272
+ 7.3566667 0.352377
+ 7.3569444 0.304489
+ 7.3572222 0.253024
+ 7.3575000 0.200395
+ 7.3577778 0.149016
+ 7.3580556 0.101302
+ 7.3583333 0.059667
+ 7.3586111 0.050000
+ 7.3588889 0.050000
+ 7.3591667 0.050000
+ 7.3594444 0.050000
+ 7.3597222 0.050000
+ 7.3600000 0.050000
+ 7.3602778 0.050000
+ 7.3605556 0.050000
+ 7.3608333 0.050000
+ 7.3611111 0.081528
+ 7.3613889 0.124340
+ 7.3616667 0.171943
+ 7.3619444 0.222126
+ 7.3622222 0.272676
+ 7.3625000 0.321384
+ 7.3627778 0.366037
+ 7.3630556 0.404425
+ 7.3633333 0.434336
+ 7.3636111 0.453559
+ 7.3638889 0.459882
+ 7.3641667 0.451845
+ 7.3644444 0.430981
+ 7.3647222 0.399574
+ 7.3650000 0.359910
+ 7.3652778 0.314271
+ 7.3655556 0.264941
+ 7.3658333 0.214206
+ 7.3661111 0.164348
+ 7.3663889 0.117652
+ 7.3666667 0.076403
+ 7.3669444 0.050000
+ 7.3672222 0.050000
+ 7.3675000 0.050000
+ 7.3677778 0.050000
+ 7.3680556 0.050000
+ 7.3683333 0.050000
+ 7.3686111 0.050000
+ 7.3688889 0.050000
+ 7.3691667 0.050000
+ 7.3694444 0.081594
+ 7.3697222 0.123405
+ 7.3700000 0.170438
+ 7.3702778 0.220401
+ 7.3705556 0.271005
+ 7.3708333 0.319958
+ 7.3711111 0.364973
+ 7.3713889 0.403757
+ 7.3716667 0.434021
+ 7.3719444 0.453476
+ 7.3722222 0.459830
+ 7.3725000 0.451565
+ 7.3727778 0.430243
+ 7.3730556 0.398199
+ 7.3733333 0.357767
+ 7.3736111 0.311279
+ 7.3738889 0.261071
+ 7.3741667 0.209476
+ 7.3744444 0.158828
+ 7.3747222 0.111461
+ 7.3750000 0.069708
+ 7.3752778 0.050000
+ 7.3755556 0.050000
+ 7.3758333 0.050000
+ 7.3761111 0.050000
+ 7.3763889 0.050000
+ 7.3766667 0.050000
+ 7.3769444 0.050000
+ 7.3772222 0.050000
+ 7.3775000 0.050000
+ 7.3777778 0.078194
+ 7.3780556 0.120703
+ 7.3783333 0.168411
+ 7.3786111 0.219008
+ 7.3788889 0.270181
+ 7.3791667 0.319618
+ 7.3794444 0.365006
+ 7.3797222 0.404034
+ 7.3800000 0.434388
+ 7.3802778 0.453758
+ 7.3805556 0.459830
+ 7.3808333 0.451072
+ 7.3811111 0.429067
+ 7.3813889 0.396179
+ 7.3816667 0.354768
+ 7.3819444 0.307199
+ 7.3822222 0.255834
+ 7.3825000 0.203036
+ 7.3827778 0.151167
+ 7.3830556 0.102589
+ 7.3833333 0.059667
+ 7.3836111 0.050000
+ 7.3838889 0.050000
+ 7.3841667 0.050000
+ 7.3844444 0.050000
+ 7.3847222 0.050000
+ 7.3850000 0.050000
+ 7.3852778 0.050000
+ 7.3855556 0.050000
+ 7.3858333 0.050000
+ 7.3861111 0.064779
+ 7.3863889 0.108372
+ 7.3866667 0.157432
+ 7.3869444 0.209567
+ 7.3872222 0.262387
+ 7.3875000 0.313500
+ 7.3877778 0.360518
+ 7.3880556 0.401047
+ 7.3883333 0.432699
+ 7.3886111 0.453081
+ 7.3888889 0.459804
+ 7.3891667 0.451283
+ 7.3894444 0.429160
+ 7.3897222 0.395883
+ 7.3900000 0.353901
+ 7.3902778 0.305663
+ 7.3905556 0.253617
+ 7.3908333 0.200211
+ 7.3911111 0.147894
+ 7.3913889 0.099114
+ 7.3916667 0.056319
+ 7.3919444 0.050000
+ 7.3922222 0.050000
+ 7.3925000 0.050000
+ 7.3927778 0.050000
+ 7.3930556 0.050000
+ 7.3933333 0.050000
+ 7.3936111 0.050000
+ 7.3938889 0.050000
+ 7.3941667 0.050000
+ 7.3944444 0.071486
+ 7.3947222 0.115166
+ 7.3950000 0.163957
+ 7.3952778 0.215538
+ 7.3955556 0.267589
+ 7.3958333 0.317787
+ 7.3961111 0.363812
+ 7.3963889 0.403342
+ 7.3966667 0.434056
+ 7.3969444 0.453633
+ 7.3972222 0.459752
+ 7.3975000 0.450877
+ 7.3977778 0.428619
+ 7.3980556 0.395373
+ 7.3983333 0.353538
+ 7.3986111 0.305508
+ 7.3988889 0.253680
+ 7.3991667 0.200451
+ 7.3994444 0.148217
+ 7.3997222 0.099374
+ 7.4000000 0.056319
+ 7.4002778 0.050000
+ 7.4005556 0.050000
+ 7.4008333 0.050000
+ 7.4011111 0.050000
+ 7.4013889 0.050000
+ 7.4016667 0.050000
+ 7.4019444 0.050000
+ 7.4022222 0.050000
+ 7.4025000 0.050000
+ 7.4027778 0.064818
+ 7.4030556 0.108655
+ 7.4033333 0.157871
+ 7.4036111 0.210088
+ 7.4038889 0.262926
+ 7.4041667 0.314007
+ 7.4044444 0.360950
+ 7.4047222 0.401376
+ 7.4050000 0.432907
+ 7.4052778 0.453163
+ 7.4055556 0.459765
+ 7.4058333 0.451131
+ 7.4061111 0.428877
+ 7.4063889 0.395415
+ 7.4066667 0.353157
+ 7.4069444 0.304515
+ 7.4072222 0.251903
+ 7.4075000 0.197733
+ 7.4077778 0.144417
+ 7.4080556 0.094369
+ 7.4083333 0.050000
+ 7.4086111 0.050000
+ 7.4088889 0.050000
+ 7.4091667 0.050000
+ 7.4094444 0.050000
+ 7.4097222 0.050000
+ 7.4100000 0.050000
+ 7.4102778 0.050000
+ 7.4105556 0.050000
+ 7.4108333 0.050000
+ 7.4111111 0.050000
+ 7.4113889 0.094701
+ 7.4116667 0.145177
+ 7.4119444 0.198951
+ 7.4122222 0.253549
+ 7.4125000 0.306493
+ 7.4127778 0.355309
+ 7.4130556 0.397519
+ 7.4133333 0.430650
+ 7.4136111 0.452223
+ 7.4138889 0.459765
+ 7.4141667 0.451629
+ 7.4144444 0.429497
+ 7.4147222 0.395881
+ 7.4150000 0.353292
+ 7.4152778 0.304243
+ 7.4155556 0.251244
+ 7.4158333 0.196809
+ 7.4161111 0.143448
+ 7.4163889 0.093675
+ 7.4166667 0.050000
+ 7.4169444 0.050000
+ 7.4172222 0.050000
+ 7.4175000 0.050000
+ 7.4177778 0.050000
+ 7.4180556 0.050000
+ 7.4183333 0.050000
+ 7.4186111 0.050000
+ 7.4188889 0.050000
+ 7.4191667 0.050000
+ 7.4194444 0.064753
+ 7.4197222 0.109079
+ 7.4200000 0.158595
+ 7.4202778 0.210952
+ 7.4205556 0.263801
+ 7.4208333 0.314796
+ 7.4211111 0.361588
+ 7.4213889 0.401828
+ 7.4216667 0.433170
+ 7.4219444 0.453265
+ 7.4222222 0.459765
+ 7.4225000 0.451117
+ 7.4227778 0.428954
+ 7.4230556 0.395702
+ 7.4233333 0.353788
+ 7.4236111 0.305639
+ 7.4238889 0.253682
+ 7.4241667 0.200345
+ 7.4244444 0.148054
+ 7.4247222 0.099237
+ 7.4250000 0.056319
+ 7.4252778 0.050000
+ 7.4255556 0.050000
+ 7.4258333 0.050000
+ 7.4261111 0.050000
+ 7.4263889 0.050000
+ 7.4266667 0.050000
+ 7.4269444 0.050000
+ 7.4272222 0.050000
+ 7.4275000 0.050000
+ 7.4277778 0.068139
+ 7.4280556 0.111750
+ 7.4283333 0.160582
+ 7.4286111 0.212307
+ 7.4288889 0.264596
+ 7.4291667 0.315120
+ 7.4294444 0.361552
+ 7.4297222 0.401564
+ 7.4300000 0.432826
+ 7.4302778 0.453011
+ 7.4305556 0.459791
+ 7.4308333 0.451618
+ 7.4311111 0.430073
+ 7.4313889 0.397516
+ 7.4316667 0.356310
+ 7.4319444 0.308816
+ 7.4322222 0.257394
+ 7.4325000 0.204407
+ 7.4327778 0.152216
+ 7.4330556 0.103182
+ 7.4333333 0.059667
+ 7.4336111 0.050000
+ 7.4338889 0.050000
+ 7.4341667 0.050000
+ 7.4344444 0.050000
+ 7.4347222 0.050000
+ 7.4350000 0.050000
+ 7.4352778 0.050000
+ 7.4355556 0.050000
+ 7.4358333 0.050000
+ 7.4361111 0.058032
+ 7.4363889 0.101737
+ 7.4366667 0.151135
+ 7.4369444 0.203797
+ 7.4372222 0.257294
+ 7.4375000 0.309196
+ 7.4377778 0.357073
+ 7.4380556 0.398495
+ 7.4383333 0.431033
+ 7.4386111 0.452258
+ 7.4388889 0.459738
+ 7.4391667 0.451855
+ 7.4394444 0.430222
+ 7.4397222 0.397263
+ 7.4400000 0.355400
+ 7.4402778 0.307058
+ 7.4405556 0.254660
+ 7.4408333 0.200629
+ 7.4411111 0.147388
+ 7.4413889 0.097362
+ 7.4416667 0.052972
+ 7.4419444 0.050000
+ 7.4422222 0.050000
+ 7.4425000 0.050000
+ 7.4427778 0.050000
+ 7.4430556 0.050000
+ 7.4433333 0.050000
+ 7.4436111 0.050000
+ 7.4438889 0.050000
+ 7.4441667 0.050000
+ 7.4444444 0.051390
+ 7.4447222 0.095848
+ 7.4450000 0.146081
+ 7.4452778 0.199621
+ 7.4455556 0.253999
+ 7.4458333 0.306749
+ 7.4461111 0.355404
+ 7.4463889 0.397495
+ 7.4466667 0.430555
+ 7.4469444 0.452117
+ 7.4472222 0.459712
+ 7.4475000 0.451700
+ 7.4477778 0.429738
+ 7.4480556 0.396312
+ 7.4483333 0.353905
+ 7.4486111 0.305002
+ 7.4488889 0.252087
+ 7.4491667 0.197646
+ 7.4494444 0.144161
+ 7.4497222 0.094117
+ 7.4500000 0.050000
+ 7.4502778 0.050000
+ 7.4505556 0.050000
+ 7.4508333 0.050000
+ 7.4511111 0.050000
+ 7.4513889 0.050000
+ 7.4516667 0.050000
+ 7.4519444 0.050000
+ 7.4522222 0.050000
+ 7.4525000 0.050000
+ 7.4527778 0.058058
+ 7.4530556 0.102606
+ 7.4533333 0.152603
+ 7.4536111 0.205643
+ 7.4538889 0.259315
+ 7.4541667 0.311212
+ 7.4544444 0.358925
+ 7.4547222 0.400046
+ 7.4550000 0.432165
+ 7.4552778 0.452874
+ 7.4555556 0.459765
+ 7.4558333 0.451239
+ 7.4561111 0.428946
+ 7.4563889 0.395343
+ 7.4566667 0.352890
+ 7.4569444 0.304044
+ 7.4572222 0.251266
+ 7.4575000 0.197014
+ 7.4577778 0.143746
+ 7.4580556 0.093922
+ 7.4583333 0.050000
+ 7.4586111 0.050000
+ 7.4588889 0.050000
+ 7.4591667 0.050000
+ 7.4594444 0.050000
+ 7.4597222 0.050000
+ 7.4600000 0.050000
+ 7.4602778 0.050000
+ 7.4605556 0.050000
+ 7.4608333 0.050000
+ 7.4611111 0.058058
+ 7.4613889 0.102498
+ 7.4616667 0.152389
+ 7.4619444 0.205332
+ 7.4622222 0.258927
+ 7.4625000 0.310773
+ 7.4627778 0.358471
+ 7.4630556 0.399621
+ 7.4633333 0.431821
+ 7.4636111 0.452674
+ 7.4638889 0.459778
+ 7.4641667 0.451539
+ 7.4644444 0.429590
+ 7.4647222 0.396369
+ 7.4650000 0.354312
+ 7.4652778 0.305859
+ 7.4655556 0.253447
+ 7.4658333 0.199515
+ 7.4661111 0.146499
+ 7.4663889 0.096839
+ 7.4666667 0.052972
+ 7.4669444 0.050000
+ 7.4672222 0.050000
+ 7.4675000 0.050000
+ 7.4677778 0.050000
+ 7.4680556 0.050000
+ 7.4683333 0.050000
+ 7.4686111 0.050000
+ 7.4688889 0.050000
+ 7.4691667 0.050000
+ 7.4694444 0.058071
+ 7.4697222 0.102328
+ 7.4700000 0.152110
+ 7.4702778 0.205005
+ 7.4705556 0.258598
+ 7.4708333 0.310477
+ 7.4711111 0.358229
+ 7.4713889 0.399440
+ 7.4716667 0.431698
+ 7.4719444 0.452588
+ 7.4722222 0.459699
+ 7.4725000 0.451428
+ 7.4727778 0.429416
+ 7.4730556 0.396117
+ 7.4733333 0.353982
+ 7.4736111 0.305464
+ 7.4738889 0.253016
+ 7.4741667 0.199090
+ 7.4744444 0.146139
+ 7.4747222 0.096616
+ 7.4750000 0.052972
+ 7.4752778 0.050000
+ 7.4755556 0.050000
+ 7.4758333 0.050000
+ 7.4761111 0.050000
+ 7.4763889 0.050000
+ 7.4766667 0.050000
+ 7.4769444 0.050000
+ 7.4772222 0.050000
+ 7.4775000 0.050000
+ 7.4777778 0.061484
+ 7.4780556 0.105638
+ 7.4783333 0.155185
+ 7.4786111 0.207743
+ 7.4788889 0.260928
+ 7.4791667 0.312358
+ 7.4794444 0.359648
+ 7.4797222 0.400415
+ 7.4800000 0.432278
+ 7.4802778 0.452851
+ 7.4805556 0.459752
+ 7.4808333 0.451398
+ 7.4811111 0.429408
+ 7.4813889 0.396202
+ 7.4816667 0.354200
+ 7.4819444 0.305822
+ 7.4822222 0.253487
+ 7.4825000 0.199614
+ 7.4827778 0.146625
+ 7.4830556 0.096937
+ 7.4833333 0.052972
+ 7.4836111 0.050000
+ 7.4838889 0.050000
+ 7.4841667 0.050000
+ 7.4844444 0.050000
+ 7.4847222 0.050000
+ 7.4850000 0.050000
+ 7.4852778 0.050000
+ 7.4855556 0.050000
+ 7.4858333 0.050000
+ 7.4861111 0.054711
+ 7.4863889 0.098720
+ 7.4866667 0.148334
+ 7.4869444 0.201160
+ 7.4872222 0.254803
+ 7.4875000 0.306871
+ 7.4877778 0.354968
+ 7.4880556 0.396701
+ 7.4883333 0.429676
+ 7.4886111 0.451500
+ 7.4888889 0.459778
+ 7.4891667 0.452908
+ 7.4894444 0.432458
+ 7.4897222 0.400786
+ 7.4900000 0.360250
+ 7.4902778 0.313211
+ 7.4905556 0.262027
+ 7.4908333 0.209056
+ 7.4911111 0.156657
+ 7.4913889 0.107191
+ 7.4916667 0.063014
+ 7.4919444 0.050000
+ 7.4922222 0.050000
+ 7.4925000 0.050000
+ 7.4927778 0.050000
+ 7.4930556 0.050000
+ 7.4933333 0.050000
+ 7.4936111 0.050000
+ 7.4938889 0.050000
+ 7.4941667 0.050000
+ 7.4944444 0.051416
+ 7.4947222 0.094996
+ 7.4950000 0.144558
+ 7.4952778 0.197629
+ 7.4955556 0.251737
+ 7.4958333 0.304411
+ 7.4961111 0.353179
+ 7.4963889 0.395569
+ 7.4966667 0.429109
+ 7.4969444 0.451327
+ 7.4972222 0.459752
+ 7.4975000 0.452729
+ 7.4977778 0.431878
+ 7.4980556 0.399635
+ 7.4983333 0.358438
+ 7.4986111 0.310723
+ 7.4988889 0.258926
+ 7.4991667 0.205485
+ 7.4994444 0.152837
+ 7.4997222 0.103419
+ 7.5000000 0.059667
+ 7.5002778 0.050000
+ 7.5005556 0.050000
+ 7.5008333 0.050000
+ 7.5011111 0.050000
+ 7.5013889 0.050000
+ 7.5016667 0.050000
+ 7.5019444 0.050000
+ 7.5022222 0.050000
+ 7.5025000 0.050000
+ 7.5027778 0.061484
+ 7.5030556 0.105308
+ 7.5033333 0.154683
+ 7.5036111 0.207196
+ 7.5038889 0.260430
+ 7.5041667 0.311973
+ 7.5044444 0.359408
+ 7.5047222 0.400320
+ 7.5050000 0.432296
+ 7.5052778 0.452920
+ 7.5055556 0.459778
+ 7.5058333 0.451270
+ 7.5061111 0.429065
+ 7.5063889 0.395645
+ 7.5066667 0.353495
+ 7.5069444 0.305097
+ 7.5072222 0.252935
+ 7.5075000 0.199493
+ 7.5077778 0.147254
+ 7.5080556 0.098701
+ 7.5083333 0.056319
+ 7.5086111 0.050000
+ 7.5088889 0.050000
+ 7.5091667 0.050000
+ 7.5094444 0.050000
+ 7.5097222 0.050000
+ 7.5100000 0.050000
+ 7.5102778 0.050000
+ 7.5105556 0.050000
+ 7.5108333 0.050000
+ 7.5111111 0.078181
+ 7.5113889 0.121577
+ 7.5116667 0.169810
+ 7.5119444 0.220630
+ 7.5122222 0.271789
+ 7.5125000 0.321036
+ 7.5127778 0.366123
+ 7.5130556 0.404800
+ 7.5133333 0.434819
+ 7.5136111 0.453929
+ 7.5138889 0.459882
+ 7.5141667 0.451201
+ 7.5144444 0.429497
+ 7.5147222 0.397153
+ 7.5150000 0.356553
+ 7.5152778 0.310081
+ 7.5155556 0.260120
+ 7.5158333 0.209053
+ 7.5161111 0.159264
+ 7.5163889 0.113137
+ 7.5166667 0.073055
+ 7.5169444 0.050000
+ 7.5172222 0.050000
+ 7.5175000 0.050000
+ 7.5177778 0.050000
+ 7.5180556 0.050000
+ 7.5183333 0.050000
+ 7.5186111 0.050000
+ 7.5188889 0.050000
+ 7.5191667 0.066015
+ 7.5194444 0.101638
+ 7.5197222 0.143545
+ 7.5200000 0.189897
+ 7.5202778 0.238519
+ 7.5205556 0.287238
+ 7.5208333 0.333883
+ 7.5211111 0.376279
+ 7.5213889 0.412254
+ 7.5216667 0.439635
+ 7.5219444 0.456248
+ 7.5222222 0.459922
+ 7.5225000 0.449245
+ 7.5227778 0.425858
+ 7.5230556 0.392167
+ 7.5233333 0.350574
+ 7.5236111 0.303483
+ 7.5238889 0.253300
+ 7.5241667 0.202426
+ 7.5244444 0.153267
+ 7.5247222 0.108227
+ 7.5250000 0.069708
+ 7.5252778 0.050000
+ 7.5255556 0.050000
+ 7.5258333 0.050000
+ 7.5261111 0.050000
+ 7.5263889 0.050000
+ 7.5266667 0.050000
+ 7.5269444 0.050000
+ 7.5272222 0.052567
+ 7.5275000 0.082484
+ 7.5277778 0.118465
+ 7.5280556 0.159912
+ 7.5283333 0.205096
+ 7.5286111 0.252008
+ 7.5288889 0.298640
+ 7.5291667 0.342983
+ 7.5294444 0.383027
+ 7.5297222 0.416764
+ 7.5300000 0.442184
+ 7.5302778 0.457279
+ 7.5305556 0.460039
+ 7.5308333 0.449172
+ 7.5311111 0.426247
+ 7.5313889 0.393551
+ 7.5316667 0.353369
+ 7.5319444 0.307988
+ 7.5322222 0.259693
+ 7.5325000 0.210771
+ 7.5327778 0.163507
+ 7.5330556 0.120187
+ 7.5333333 0.083097
+ 7.5336111 0.054095
+ 7.5338889 0.050000
+ 7.5341667 0.050000
+ 7.5344444 0.050000
+ 7.5347222 0.050000
+ 7.5350000 0.050000
+ 7.5352778 0.050000
+ 7.5355556 0.065199
+ 7.5358333 0.093898
+ 7.5361111 0.128507
+ 7.5363889 0.168459
+ 7.5366667 0.212087
+ 7.5369444 0.257445
+ 7.5372222 0.302589
+ 7.5375000 0.345575
+ 7.5377778 0.384459
+ 7.5380556 0.417295
+ 7.5383333 0.442140
+ 7.5386111 0.457050
+ 7.5388889 0.460078
+ 7.5391667 0.449967
+ 7.5394444 0.428189
+ 7.5397222 0.396906
+ 7.5400000 0.358276
+ 7.5402778 0.314459
+ 7.5405556 0.267613
+ 7.5408333 0.219899
+ 7.5411111 0.173476
+ 7.5413889 0.130503
+ 7.5416667 0.093139
+ 7.5419444 0.063159
+ 7.5422222 0.050000
+ 7.5425000 0.050000
+ 7.5427778 0.050000
+ 7.5430556 0.050000
+ 7.5433333 0.050000
+ 7.5436111 0.050000
+ 7.5438889 0.058382
+ 7.5441667 0.085219
+ 7.5444444 0.118491
+ 7.5447222 0.157739
+ 7.5450000 0.201250
+ 7.5452778 0.247000
+ 7.5455556 0.292968
+ 7.5458333 0.337127
+ 7.5461111 0.377456
+ 7.5463889 0.411930
+ 7.5466667 0.438526
+ 7.5469444 0.455219
+ 7.5472222 0.459987
+ 7.5475000 0.451502
+ 7.5477778 0.431224
+ 7.5480556 0.401308
+ 7.5483333 0.363912
+ 7.5486111 0.321191
+ 7.5488889 0.275301
+ 7.5491667 0.228399
+ 7.5494444 0.182641
+ 7.5497222 0.140183
+ 7.5500000 0.103181
+ 7.5502778 0.073408
+ 7.5505556 0.051111
+ 7.5508333 0.050000
+ 7.5511111 0.050000
+ 7.5513889 0.050000
+ 7.5516667 0.050000
+ 7.5519444 0.050000
+ 7.5522222 0.066573
+ 7.5525000 0.092739
+ 7.5527778 0.125277
+ 7.5530556 0.163739
+ 7.5533333 0.206433
+ 7.5536111 0.251356
+ 7.5538889 0.296505
+ 7.5541667 0.339878
+ 7.5544444 0.379472
+ 7.5547222 0.413283
+ 7.5550000 0.439310
+ 7.5552778 0.455550
+ 7.5555556 0.460000
+ 7.5558333 0.451341
+ 7.5561111 0.430994
+ 7.5563889 0.401060
+ 7.5566667 0.363645
+ 7.5569444 0.320851
+ 7.5572222 0.274782
+ 7.5575000 0.227543
+ 7.5577778 0.181236
+ 7.5580556 0.137965
+ 7.5583333 0.099833
+ 7.5586111 0.068590
+ 7.5588889 0.050000
+ 7.5591667 0.050000
+ 7.5594444 0.050000
+ 7.5597222 0.050000
+ 7.5600000 0.050000
+ 7.5602778 0.050000
+ 7.5605556 0.050211
+ 7.5608333 0.075848
+ 7.5611111 0.108463
+ 7.5613889 0.147673
+ 7.5616667 0.191690
+ 7.5619444 0.238373
+ 7.5622222 0.285582
+ 7.5625000 0.331176
+ 7.5627778 0.373016
+ 7.5630556 0.408960
+ 7.5633333 0.436868
+ 7.5636111 0.454599
+ 7.5638889 0.460013
+ 7.5641667 0.451700
+ 7.5644444 0.431174
+ 7.5647222 0.400677
+ 7.5650000 0.362453
+ 7.5652778 0.318746
+ 7.5655556 0.271799
+ 7.5658333 0.223856
+ 7.5661111 0.177161
+ 7.5663889 0.133956
+ 7.5666667 0.096486
+ 7.5669444 0.066589
+ 7.5672222 0.050000
+ 7.5675000 0.050000
+ 7.5677778 0.050000
+ 7.5680556 0.050000
+ 7.5683333 0.050000
+ 7.5686111 0.050000
+ 7.5688889 0.064718
+ 7.5691667 0.091799
+ 7.5694444 0.125147
+ 7.5697222 0.164269
+ 7.5700000 0.207469
+ 7.5702778 0.252747
+ 7.5705556 0.298104
+ 7.5708333 0.341542
+ 7.5711111 0.381060
+ 7.5713889 0.414660
+ 7.5716667 0.440343
+ 7.5719444 0.456110
+ 7.5722222 0.459961
+ 7.5725000 0.450584
+ 7.5727778 0.429412
+ 7.5730556 0.398566
+ 7.5733333 0.360164
+ 7.5736111 0.316326
+ 7.5738889 0.269173
+ 7.5741667 0.220823
+ 7.5744444 0.173396
+ 7.5747222 0.129012
+ 7.5750000 0.089792
+ 7.5752778 0.057500
+ 7.5755556 0.050000
+ 7.5758333 0.050000
+ 7.5761111 0.050000
+ 7.5763889 0.050000
+ 7.5766667 0.050000
+ 7.5769444 0.050000
+ 7.5772222 0.050000
+ 7.5775000 0.061672
+ 7.5777778 0.095048
+ 7.5780556 0.135362
+ 7.5783333 0.180760
+ 7.5786111 0.229017
+ 7.5788889 0.277905
+ 7.5791667 0.325199
+ 7.5794444 0.368673
+ 7.5797222 0.406100
+ 7.5800000 0.435255
+ 7.5802778 0.453911
+ 7.5805556 0.459843
+ 7.5808333 0.451564
+ 7.5811111 0.430549
+ 7.5813889 0.399013
+ 7.5816667 0.359171
+ 7.5819444 0.313237
+ 7.5822222 0.263426
+ 7.5825000 0.211953
+ 7.5827778 0.161032
+ 7.5830556 0.112879
+ 7.5833333 0.069708
+ 7.5836111 0.050000
+ 7.5838889 0.050000
+ 7.5841667 0.050000
+ 7.5844444 0.050000
+ 7.5847222 0.050000
+ 7.5850000 0.050000
+ 7.5852778 0.050000
+ 7.5855556 0.050000
+ 7.5858333 0.050000
+ 7.5861111 0.051455
+ 7.5863889 0.093716
+ 7.5866667 0.142055
+ 7.5869444 0.194072
+ 7.5872222 0.247371
+ 7.5875000 0.299551
+ 7.5877778 0.348215
+ 7.5880556 0.390964
+ 7.5883333 0.425400
+ 7.5886111 0.449124
+ 7.5888889 0.459738
+ 7.5891667 0.455613
+ 7.5894444 0.438197
+ 7.5897222 0.409706
+ 7.5900000 0.372359
+ 7.5902778 0.328372
+ 7.5905556 0.279962
+ 7.5908333 0.229348
+ 7.5911111 0.178745
+ 7.5913889 0.130371
+ 7.5916667 0.086444
+ 7.5919444 0.050000
+ 7.5922222 0.050000
+ 7.5925000 0.050000
+ 7.5927778 0.050000
+ 7.5930556 0.050000
+ 7.5933333 0.050000
+ 7.5936111 0.050000
+ 7.5938889 0.050000
+ 7.5941667 0.050000
+ 7.5944444 0.050000
+ 7.5947222 0.091789
+ 7.5950000 0.140122
+ 7.5952778 0.192474
+ 7.5955556 0.246326
+ 7.5958333 0.299154
+ 7.5961111 0.348436
+ 7.5963889 0.391652
+ 7.5966667 0.426278
+ 7.5969444 0.449792
+ 7.5972222 0.459673
+ 7.5975000 0.454215
+ 7.5977778 0.434974
+ 7.5980556 0.404325
+ 7.5983333 0.364641
+ 7.5986111 0.318294
+ 7.5988889 0.267660
+ 7.5991667 0.215111
+ 7.5994444 0.163020
+ 7.5997222 0.113762
+ 7.6000000 0.069708
+ 7.6002778 0.050000
+ 7.6005556 0.050000
+ 7.6008333 0.050000
+ 7.6011111 0.050000
+ 7.6013889 0.050000
+ 7.6016667 0.050000
+ 7.6019444 0.050000
+ 7.6022222 0.050000
+ 7.6025000 0.050000
+ 7.6027778 0.054855
+ 7.6030556 0.097595
+ 7.6033333 0.146269
+ 7.6036111 0.198464
+ 7.6038889 0.251768
+ 7.6041667 0.303768
+ 7.6044444 0.352051
+ 7.6047222 0.394205
+ 7.6050000 0.427817
+ 7.6052778 0.450475
+ 7.6055556 0.459765
+ 7.6058333 0.454061
+ 7.6061111 0.434883
+ 7.6063889 0.404536
+ 7.6066667 0.365326
+ 7.6069444 0.319559
+ 7.6072222 0.269540
+ 7.6075000 0.217574
+ 7.6077778 0.165968
+ 7.6080556 0.117026
+ 7.6083333 0.073055
+ 7.6086111 0.050000
+ 7.6088889 0.050000
+ 7.6091667 0.050000
+ 7.6094444 0.050000
+ 7.6097222 0.050000
+ 7.6100000 0.050000
+ 7.6102778 0.050000
+ 7.6105556 0.050000
+ 7.6108333 0.050000
+ 7.6111111 0.051455
+ 7.6113889 0.093913
+ 7.6116667 0.142513
+ 7.6119444 0.194816
+ 7.6122222 0.248383
+ 7.6125000 0.300776
+ 7.6127778 0.349554
+ 7.6130556 0.392278
+ 7.6133333 0.426510
+ 7.6136111 0.449810
+ 7.6138889 0.459738
+ 7.6141667 0.454646
+ 7.6144444 0.436041
+ 7.6147222 0.406220
+ 7.6150000 0.367480
+ 7.6152778 0.322119
+ 7.6155556 0.272434
+ 7.6158333 0.220723
+ 7.6161111 0.169282
+ 7.6163889 0.120410
+ 7.6166667 0.076403
+ 7.6169444 0.050000
+ 7.6172222 0.050000
+ 7.6175000 0.050000
+ 7.6177778 0.050000
+ 7.6180556 0.050000
+ 7.6183333 0.050000
+ 7.6186111 0.050000
+ 7.6188889 0.050000
+ 7.6191667 0.050000
+ 7.6194444 0.051468
+ 7.6197222 0.093716
+ 7.6200000 0.142179
+ 7.6202778 0.194408
+ 7.6205556 0.247954
+ 7.6208333 0.300367
+ 7.6211111 0.349200
+ 7.6213889 0.392002
+ 7.6216667 0.426325
+ 7.6219444 0.449720
+ 7.6222222 0.459738
+ 7.6225000 0.454721
+ 7.6227778 0.436175
+ 7.6230556 0.406397
+ 7.6233333 0.367684
+ 7.6236111 0.322332
+ 7.6238889 0.272640
+ 7.6241667 0.220904
+ 7.6244444 0.169421
+ 7.6247222 0.120488
+ 7.6250000 0.076403
+ 7.6252778 0.050000
+ 7.6255556 0.050000
+ 7.6258333 0.050000
+ 7.6261111 0.050000
+ 7.6263889 0.050000
+ 7.6266667 0.050000
+ 7.6269444 0.050000
+ 7.6272222 0.050000
+ 7.6275000 0.050000
+ 7.6277778 0.051508
+ 7.6280556 0.094073
+ 7.6283333 0.142900
+ 7.6286111 0.195496
+ 7.6288889 0.249367
+ 7.6291667 0.302020
+ 7.6294444 0.350961
+ 7.6297222 0.393697
+ 7.6300000 0.427734
+ 7.6302778 0.450579
+ 7.6305556 0.459738
+ 7.6308333 0.453532
+ 7.6311111 0.433531
+ 7.6313889 0.402119
+ 7.6316667 0.361680
+ 7.6319444 0.314600
+ 7.6322222 0.263261
+ 7.6325000 0.210049
+ 7.6327778 0.157348
+ 7.6330556 0.107541
+ 7.6333333 0.063014
+ 7.6336111 0.050000
+ 7.6338889 0.050000
+ 7.6341667 0.050000
+ 7.6344444 0.050000
+ 7.6347222 0.050000
+ 7.6350000 0.050000
+ 7.6352778 0.050000
+ 7.6355556 0.050000
+ 7.6358333 0.050000
+ 7.6361111 0.050000
+ 7.6363889 0.093823
+ 7.6366667 0.143690
+ 7.6369444 0.197096
+ 7.6372222 0.251537
+ 7.6375000 0.304508
+ 7.6377778 0.353504
+ 7.6380556 0.396021
+ 7.6383333 0.429553
+ 7.6386111 0.451597
+ 7.6388889 0.459647
+ 7.6391667 0.452029
+ 7.6394444 0.430392
+ 7.6397222 0.397214
+ 7.6400000 0.354973
+ 7.6402778 0.306147
+ 7.6405556 0.253215
+ 7.6408333 0.198657
+ 7.6411111 0.144949
+ 7.6413889 0.094570
+ 7.6416667 0.050000
+ 7.6419444 0.050000
+ 7.6422222 0.050000
+ 7.6425000 0.050000
+ 7.6427778 0.050000
+ 7.6430556 0.050000
+ 7.6433333 0.050000
+ 7.6436111 0.050000
+ 7.6438889 0.050000
+ 7.6441667 0.050000
+ 7.6444444 0.050000
+ 7.6447222 0.093824
+ 7.6450000 0.143241
+ 7.6452778 0.195913
+ 7.6455556 0.249500
+ 7.6458333 0.301664
+ 7.6461111 0.350067
+ 7.6463889 0.392370
+ 7.6466667 0.426234
+ 7.6469444 0.449322
+ 7.6472222 0.459294
+ 7.6475000 0.454572
+ 7.6477778 0.436616
+ 7.6480556 0.407649
+ 7.6483333 0.369890
+ 7.6486111 0.325561
+ 7.6488889 0.276883
+ 7.6491667 0.226077
+ 7.6494444 0.175363
+ 7.6497222 0.126963
+ 7.6500000 0.083097
+ 7.6502778 0.050000
+ 7.6505556 0.050000
+ 7.6508333 0.050000
+ 7.6511111 0.050000
+ 7.6513889 0.050000
+ 7.6516667 0.050000
+ 7.6519444 0.050000
+ 7.6522222 0.050000
+ 7.6525000 0.050000
+ 7.6527778 0.050000
+ 7.6530556 0.092151
+ 7.6533333 0.141113
+ 7.6536111 0.194681
+ 7.6538889 0.250648
+ 7.6541667 0.306807
+ 7.6544444 0.360954
+ 7.6547222 0.410881
+ 7.6550000 0.454382
+ 7.6552778 0.489251
+ 7.6555556 0.513281
+ 7.6558333 0.524963
+ 7.6561111 0.525568
+ 7.6563889 0.517064
+ 7.6566667 0.501420
+ 7.6569444 0.480604
+ 7.6572222 0.456584
+ 7.6575000 0.431327
+ 7.6577778 0.406802
+ 7.6580556 0.384977
+ 7.6583333 0.367821
+ 7.6586111 0.356828
+ 7.6588889 0.351611
+ 7.6591667 0.351308
+ 7.6594444 0.355058
+ 7.6597222 0.361999
+ 7.6600000 0.371272
+ 7.6602778 0.382013
+ 7.6605556 0.393364
+ 7.6608333 0.404462
+ 7.6611111 0.414446
+ 7.6613889 0.422708
+ 7.6616667 0.429645
+ 7.6619444 0.435908
+ 7.6622222 0.442146
+ 7.6625000 0.449009
+ 7.6627778 0.457149
+ 7.6630556 0.467214
+ 7.6633333 0.479855
+ 7.6636111 0.495722
+ 7.6638889 0.515465
+ 7.6641667 0.539270
+ 7.6644444 0.565470
+ 7.6647222 0.591932
+ 7.6650000 0.616526
+ 7.6652778 0.637121
+ 7.6655556 0.651583
+ 7.6658333 0.657782
+ 7.6661111 0.653587
+ 7.6663889 0.636866
+ 7.6666667 0.605487
+ 7.6669444 0.558352
+ 7.6672222 0.498497
+ 7.6675000 0.429990
+ 7.6677778 0.356901
+ 7.6680556 0.283299
+ 7.6683333 0.213252
+ 7.6686111 0.150830
+ 7.6688889 0.100101
+ 7.6691667 0.065135
+ 7.6694444 0.050000
+ 7.6697222 0.057343
+ 7.6700000 0.084124
+ 7.6702778 0.125878
+ 7.6705556 0.178144
+ 7.6708333 0.236456
+ 7.6711111 0.296354
+ 7.6713889 0.353372
+ 7.6716667 0.403049
+ 7.6719444 0.440920
+ 7.6722222 0.462523
+ 7.6725000 0.464643
+ 7.6727778 0.449057
+ 7.6730556 0.418790
+ 7.6733333 0.376868
+ 7.6736111 0.326316
+ 7.6738889 0.270160
+ 7.6741667 0.211425
+ 7.6744444 0.153136
+ 7.6747222 0.098319
+ 7.6750000 0.050000
+ 7.6752778 0.050000
+ 7.6755556 0.050000
+ 7.6758333 0.050000
+ 7.6761111 0.050000
+ 7.6763889 0.050000
+ 7.6766667 0.050000
+ 7.6769444 0.050000
+ 7.6772222 0.050000
+ 7.6775000 0.050000
+ 7.6777778 0.054567
+ 7.6780556 0.099883
+ 7.6783333 0.150482
+ 7.6786111 0.203979
+ 7.6788889 0.257992
+ 7.6791667 0.310136
+ 7.6794444 0.358028
+ 7.6797222 0.399286
+ 7.6800000 0.431524
+ 7.6802778 0.452361
+ 7.6805556 0.459412
+ 7.6808333 0.451096
+ 7.6811111 0.429044
+ 7.6813889 0.395687
+ 7.6816667 0.353459
+ 7.6819444 0.304791
+ 7.6822222 0.252117
+ 7.6825000 0.197868
+ 7.6827778 0.144477
+ 7.6830556 0.094377
+ 7.6833333 0.050000
+ 7.6836111 0.050000
+ 7.6838889 0.050000
+ 7.6841667 0.050000
+ 7.6844444 0.050000
+ 7.6847222 0.050000
+ 7.6850000 0.050000
+ 7.6852778 0.050000
+ 7.6855556 0.050000
+ 7.6858333 0.050000
+ 7.6861111 0.050000
+ 7.6863889 0.094286
+ 7.6866667 0.144269
+ 7.6869444 0.197537
+ 7.6872222 0.251675
+ 7.6875000 0.304270
+ 7.6877778 0.352907
+ 7.6880556 0.395174
+ 7.6883333 0.428655
+ 7.6886111 0.450938
+ 7.6888889 0.459608
+ 7.6891667 0.453048
+ 7.6894444 0.432827
+ 7.6897222 0.401308
+ 7.6900000 0.360858
+ 7.6902778 0.313841
+ 7.6905556 0.262621
+ 7.6908333 0.209564
+ 7.6911111 0.157033
+ 7.6913889 0.107395
+ 7.6916667 0.063014
+ 7.6919444 0.050000
+ 7.6922222 0.050000
+ 7.6925000 0.050000
+ 7.6927778 0.050000
+ 7.6930556 0.050000
+ 7.6933333 0.050000
+ 7.6936111 0.050000
+ 7.6938889 0.050000
+ 7.6941667 0.050000
+ 7.6944444 0.050000
+ 7.6947222 0.093778
+ 7.6950000 0.143607
+ 7.6952778 0.196983
+ 7.6955556 0.251403
+ 7.6958333 0.304363
+ 7.6961111 0.353360
+ 7.6963889 0.395889
+ 7.6966667 0.429447
+ 7.6969444 0.451529
+ 7.6972222 0.459634
+ 7.6975000 0.452085
+ 7.6977778 0.430524
+ 7.6980556 0.397420
+ 7.6983333 0.355245
+ 7.6986111 0.306467
+ 7.6988889 0.253558
+ 7.6991667 0.198986
+ 7.6994444 0.145223
+ 7.6997222 0.094737
+ 7.7000000 0.050000
+ 7.7002778 0.050000
+ 7.7005556 0.050000
+ 7.7008333 0.050000
+ 7.7011111 0.050000
+ 7.7013889 0.050000
+ 7.7016667 0.050000
+ 7.7019444 0.050000
+ 7.7022222 0.050000
+ 7.7025000 0.050000
+ 7.7027778 0.050000
+ 7.7030556 0.094672
+ 7.7033333 0.145074
+ 7.7036111 0.198748
+ 7.7038889 0.253238
+ 7.7041667 0.306084
+ 7.7044444 0.354830
+ 7.7047222 0.397018
+ 7.7050000 0.430191
+ 7.7052778 0.451891
+ 7.7055556 0.459660
+ 7.7058333 0.451861
+ 7.7061111 0.430134
+ 7.7063889 0.396937
+ 7.7066667 0.354730
+ 7.7069444 0.305972
+ 7.7072222 0.253123
+ 7.7075000 0.198642
+ 7.7077778 0.144989
+ 7.7080556 0.094621
+ 7.7083333 0.050000
+ 7.7086111 0.050000
+ 7.7088889 0.050000
+ 7.7091667 0.050000
+ 7.7094444 0.050000
+ 7.7097222 0.050000
+ 7.7100000 0.050000
+ 7.7102778 0.050000
+ 7.7105556 0.050000
+ 7.7108333 0.050000
+ 7.7111111 0.050000
+ 7.7113889 0.094499
+ 7.7116667 0.144709
+ 7.7119444 0.198194
+ 7.7122222 0.252516
+ 7.7125000 0.305241
+ 7.7127778 0.353931
+ 7.7130556 0.396150
+ 7.7133333 0.429462
+ 7.7136111 0.451431
+ 7.7138889 0.459621
+ 7.7141667 0.452403
+ 7.7144444 0.431385
+ 7.7147222 0.398983
+ 7.7150000 0.357612
+ 7.7152778 0.309688
+ 7.7155556 0.257627
+ 7.7158333 0.203843
+ 7.7161111 0.150754
+ 7.7163889 0.100774
+ 7.7166667 0.056319
+ 7.7169444 0.050000
+ 7.7172222 0.050000
+ 7.7175000 0.050000
+ 7.7177778 0.050000
+ 7.7180556 0.050000
+ 7.7183333 0.050000
+ 7.7186111 0.050000
+ 7.7188889 0.050000
+ 7.7191667 0.050000
+ 7.7194444 0.050000
+ 7.7197222 0.093903
+ 7.7200000 0.143643
+ 7.7202778 0.196785
+ 7.7205556 0.250896
+ 7.7208333 0.303541
+ 7.7211111 0.352286
+ 7.7213889 0.394697
+ 7.7216667 0.428339
+ 7.7219444 0.450779
+ 7.7222222 0.459582
+ 7.7225000 0.453114
+ 7.7227778 0.432948
+ 7.7230556 0.401453
+ 7.7233333 0.361002
+ 7.7236111 0.313966
+ 7.7238889 0.262716
+ 7.7241667 0.209625
+ 7.7244444 0.157063
+ 7.7247222 0.107402
+ 7.7250000 0.063014
+ 7.7252778 0.050000
+ 7.7255556 0.050000
+ 7.7258333 0.050000
+ 7.7261111 0.050000
+ 7.7263889 0.050000
+ 7.7266667 0.050000
+ 7.7269444 0.050000
+ 7.7272222 0.050000
+ 7.7275000 0.050000
+ 7.7277778 0.050000
+ 7.7280556 0.093638
+ 7.7283333 0.143303
+ 7.7286111 0.196510
+ 7.7288889 0.250779
+ 7.7291667 0.303626
+ 7.7294444 0.352571
+ 7.7297222 0.395130
+ 7.7300000 0.428822
+ 7.7302778 0.451163
+ 7.7305556 0.459673
+ 7.7308333 0.452687
+ 7.7311111 0.431815
+ 7.7313889 0.399485
+ 7.7316667 0.358125
+ 7.7319444 0.310164
+ 7.7322222 0.258029
+ 7.7325000 0.204149
+ 7.7327778 0.150952
+ 7.7330556 0.100866
+ 7.7333333 0.056319
+ 7.7336111 0.050000
+ 7.7338889 0.050000
+ 7.7341667 0.050000
+ 7.7344444 0.050000
+ 7.7347222 0.050000
+ 7.7350000 0.050000
+ 7.7352778 0.050000
+ 7.7355556 0.050000
+ 7.7358333 0.050000
+ 7.7361111 0.050000
+ 7.7363889 0.093930
+ 7.7366667 0.143692
+ 7.7369444 0.196852
+ 7.7372222 0.250977
+ 7.7375000 0.303631
+ 7.7377778 0.352380
+ 7.7380556 0.394790
+ 7.7383333 0.428428
+ 7.7386111 0.450858
+ 7.7388889 0.459647
+ 7.7391667 0.453161
+ 7.7394444 0.432974
+ 7.7397222 0.401457
+ 7.7400000 0.360985
+ 7.7402778 0.313932
+ 7.7405556 0.262671
+ 7.7408333 0.209575
+ 7.7411111 0.157017
+ 7.7413889 0.107373
+ 7.7416667 0.063014
+ 7.7419444 0.050000
+ 7.7422222 0.050000
+ 7.7425000 0.050000
+ 7.7427778 0.050000
+ 7.7430556 0.050000
+ 7.7433333 0.050000
+ 7.7436111 0.050000
+ 7.7438889 0.050000
+ 7.7441667 0.050000
+ 7.7444444 0.050000
+ 7.7447222 0.093466
+ 7.7450000 0.142929
+ 7.7452778 0.195933
+ 7.7455556 0.250018
+ 7.7458333 0.302727
+ 7.7461111 0.351604
+ 7.7463889 0.394189
+ 7.7466667 0.428025
+ 7.7469444 0.450655
+ 7.7472222 0.459621
+ 7.7475000 0.453271
+ 7.7477778 0.433177
+ 7.7480556 0.401717
+ 7.7483333 0.361270
+ 7.7486111 0.314213
+ 7.7488889 0.262924
+ 7.7491667 0.209782
+ 7.7494444 0.157164
+ 7.7497222 0.107449
+ 7.7500000 0.063014
+ 7.7502778 0.050000
+ 7.7505556 0.050000
+ 7.7508333 0.050000
+ 7.7511111 0.050000
+ 7.7513889 0.050000
+ 7.7516667 0.050000
+ 7.7519444 0.050000
+ 7.7522222 0.050000
+ 7.7525000 0.050000
+ 7.7527778 0.050000
+ 7.7530556 0.093644
+ 7.7533333 0.143310
+ 7.7536111 0.196516
+ 7.7538889 0.250780
+ 7.7541667 0.303620
+ 7.7544444 0.352556
+ 7.7547222 0.395106
+ 7.7550000 0.428788
+ 7.7552778 0.451120
+ 7.7555556 0.459621
+ 7.7558333 0.452628
+ 7.7561111 0.431750
+ 7.7563889 0.399417
+ 7.7566667 0.358057
+ 7.7569444 0.310098
+ 7.7572222 0.257969
+ 7.7575000 0.204098
+ 7.7577778 0.150914
+ 7.7580556 0.100845
+ 7.7583333 0.056319
+ 7.7586111 0.050000
+ 7.7588889 0.050000
+ 7.7591667 0.050000
+ 7.7594444 0.050000
+ 7.7597222 0.050000
+ 7.7600000 0.050000
+ 7.7602778 0.050000
+ 7.7605556 0.050000
+ 7.7608333 0.050000
+ 7.7611111 0.050000
+ 7.7613889 0.093850
+ 7.7616667 0.143521
+ 7.7619444 0.196589
+ 7.7622222 0.250632
+ 7.7625000 0.303226
+ 7.7627778 0.351949
+ 7.7630556 0.394379
+ 7.7633333 0.428091
+ 7.7636111 0.450663
+ 7.7638889 0.459673
+ 7.7641667 0.453493
+ 7.7644444 0.433678
+ 7.7647222 0.402578
+ 7.7650000 0.362544
+ 7.7652778 0.315927
+ 7.7655556 0.265077
+ 7.7658333 0.212345
+ 7.7661111 0.160081
+ 7.7663889 0.110637
+ 7.7666667 0.066361
+ 7.7669444 0.050000
+ 7.7672222 0.050000
+ 7.7675000 0.050000
+ 7.7677778 0.050000
+ 7.7680556 0.050000
+ 7.7683333 0.050000
+ 7.7686111 0.050000
+ 7.7688889 0.050000
+ 7.7691667 0.050000
+ 7.7694444 0.050000
+ 7.7697222 0.093158
+ 7.7700000 0.142382
+ 7.7702778 0.195213
+ 7.7705556 0.249194
+ 7.7708333 0.301868
+ 7.7711111 0.350776
+ 7.7713889 0.393462
+ 7.7716667 0.427468
+ 7.7719444 0.450335
+ 7.7722222 0.459608
+ 7.7725000 0.453630
+ 7.7727778 0.433955
+ 7.7730556 0.402942
+ 7.7733333 0.362948
+ 7.7736111 0.316329
+ 7.7738889 0.265442
+ 7.7741667 0.212644
+ 7.7744444 0.160294
+ 7.7747222 0.110747
+ 7.7750000 0.066361
+ 7.7752778 0.050000
+ 7.7755556 0.050000
+ 7.7758333 0.050000
+ 7.7761111 0.050000
+ 7.7763889 0.050000
+ 7.7766667 0.050000
+ 7.7769444 0.050000
+ 7.7772222 0.050000
+ 7.7775000 0.050000
+ 7.7777778 0.050000
+ 7.7780556 0.093423
+ 7.7783333 0.142948
+ 7.7786111 0.196082
+ 7.7788889 0.250331
+ 7.7791667 0.303202
+ 7.7794444 0.352203
+ 7.7797222 0.394841
+ 7.7800000 0.428623
+ 7.7802778 0.451056
+ 7.7805556 0.459647
+ 7.7808333 0.452723
+ 7.7811111 0.431895
+ 7.7813889 0.399592
+ 7.7816667 0.358245
+ 7.7819444 0.310283
+ 7.7822222 0.258137
+ 7.7825000 0.204238
+ 7.7827778 0.151015
+ 7.7830556 0.100899
+ 7.7833333 0.056319
+ 7.7836111 0.050000
+ 7.7838889 0.050000
+ 7.7841667 0.050000
+ 7.7844444 0.050000
+ 7.7847222 0.050000
+ 7.7850000 0.050000
+ 7.7852778 0.050000
+ 7.7855556 0.050000
+ 7.7858333 0.050000
+ 7.7861111 0.050000
+ 7.7863889 0.094008
+ 7.7866667 0.143858
+ 7.7869444 0.197106
+ 7.7872222 0.251307
+ 7.7875000 0.304017
+ 7.7877778 0.352790
+ 7.7880556 0.395182
+ 7.7883333 0.428747
+ 7.7886111 0.451042
+ 7.7888889 0.459621
+ 7.7891667 0.452846
+ 7.7894444 0.432304
+ 7.7897222 0.400390
+ 7.7900000 0.359498
+ 7.7902778 0.312021
+ 7.7905556 0.260354
+ 7.7908333 0.206892
+ 7.7911111 0.154027
+ 7.7913889 0.104154
+ 7.7916667 0.059667
+ 7.7919444 0.050000
+ 7.7922222 0.050000
+ 7.7925000 0.050000
+ 7.7927778 0.050000
+ 7.7930556 0.050000
+ 7.7933333 0.050000
+ 7.7936111 0.050000
+ 7.7938889 0.050000
+ 7.7941667 0.050000
+ 7.7944444 0.050000
+ 7.7947222 0.094005
+ 7.7950000 0.143975
+ 7.7952778 0.197421
+ 7.7955556 0.251851
+ 7.7958333 0.304773
+ 7.7961111 0.353696
+ 7.7963889 0.396130
+ 7.7966667 0.429583
+ 7.7969444 0.451564
+ 7.7972222 0.459582
+ 7.7975000 0.451971
+ 7.7977778 0.430373
+ 7.7980556 0.397253
+ 7.7983333 0.355078
+ 7.7986111 0.306315
+ 7.7988889 0.253430
+ 7.7991667 0.198889
+ 7.7994444 0.145160
+ 7.7997222 0.094708
+ 7.8000000 0.050000
+ 7.8002778 0.050000
+ 7.8005556 0.050000
+ 7.8008333 0.050000
+ 7.8011111 0.050000
+ 7.8013889 0.050000
+ 7.8016667 0.050000
+ 7.8019444 0.050000
+ 7.8022222 0.050000
+ 7.8025000 0.050000
+ 7.8027778 0.050000
+ 7.8030556 0.094659
+ 7.8033333 0.145048
+ 7.8036111 0.198711
+ 7.8038889 0.253190
+ 7.8041667 0.306027
+ 7.8044444 0.354767
+ 7.8047222 0.396952
+ 7.8050000 0.430125
+ 7.8052778 0.451830
+ 7.8055556 0.459608
+ 7.8058333 0.451822
+ 7.8061111 0.430111
+ 7.8063889 0.396932
+ 7.8066667 0.354742
+ 7.8069444 0.305999
+ 7.8072222 0.253160
+ 7.8075000 0.198684
+ 7.8077778 0.145026
+ 7.8080556 0.094646
+ 7.8083333 0.050000
+ 7.8086111 0.050000
+ 7.8088889 0.050000
+ 7.8091667 0.050000
+ 7.8094444 0.050000
+ 7.8097222 0.050000
+ 7.8100000 0.050000
+ 7.8102778 0.050000
+ 7.8105556 0.050000
+ 7.8108333 0.050000
+ 7.8111111 0.050000
+ 7.8113889 0.094647
+ 7.8116667 0.145029
+ 7.8119444 0.198687
+ 7.8122222 0.253165
+ 7.8125000 0.306005
+ 7.8127778 0.354748
+ 7.8130556 0.396938
+ 7.8133333 0.430116
+ 7.8136111 0.451825
+ 7.8138889 0.459608
+ 7.8141667 0.451825
+ 7.8144444 0.430116
+ 7.8147222 0.396938
+ 7.8150000 0.354748
+ 7.8152778 0.306004
+ 7.8155556 0.253165
+ 7.8158333 0.198687
+ 7.8161111 0.145029
+ 7.8163889 0.094647
+ 7.8166667 0.050000
+ 7.8169444 0.050000
+ 7.8172222 0.050000
+ 7.8175000 0.050000
+ 7.8177778 0.050000
+ 7.8180556 0.050000
+ 7.8183333 0.050000
+ 7.8186111 0.050000
+ 7.8188889 0.050000
+ 7.8191667 0.050000
+ 7.8194444 0.050000
+ 7.8197222 0.094646
+ 7.8200000 0.145026
+ 7.8202778 0.198683
+ 7.8205556 0.253159
+ 7.8208333 0.305997
+ 7.8211111 0.354738
+ 7.8213889 0.396926
+ 7.8216667 0.430104
+ 7.8219444 0.451812
+ 7.8222222 0.459595
+ 7.8225000 0.451813
+ 7.8227778 0.430105
+ 7.8230556 0.396928
+ 7.8233333 0.354740
+ 7.8236111 0.305999
+ 7.8238889 0.253161
+ 7.8241667 0.198685
+ 7.8244444 0.145028
+ 7.8247222 0.094647
+ 7.8250000 0.050000
+ 7.8252778 0.050000
+ 7.8255556 0.050000
+ 7.8258333 0.050000
+ 7.8261111 0.050000
+ 7.8263889 0.050000
+ 7.8266667 0.050000
+ 7.8269444 0.050000
+ 7.8272222 0.050000
+ 7.8275000 0.050000
+ 7.8277778 0.050000
+ 7.8280556 0.094652
+ 7.8283333 0.145039
+ 7.8286111 0.198705
+ 7.8288889 0.253189
+ 7.8291667 0.306036
+ 7.8294444 0.354786
+ 7.8297222 0.396981
+ 7.8300000 0.430164
+ 7.8302778 0.451876
+ 7.8305556 0.459660
+ 7.8308333 0.451877
+ 7.8311111 0.430165
+ 7.8313889 0.396982
+ 7.8316667 0.354787
+ 7.8319444 0.306037
+ 7.8322222 0.253191
+ 7.8325000 0.198706
+ 7.8327778 0.145040
+ 7.8330556 0.094652
+ 7.8333333 0.050000
+ 7.8336111 0.050000
+ 7.8338889 0.050000
+ 7.8341667 0.050000
+ 7.8344444 0.050000
+ 7.8347222 0.050000
+ 7.8350000 0.050000
+ 7.8352778 0.050000
+ 7.8355556 0.050000
+ 7.8358333 0.050000
+ 7.8361111 0.050000
+ 7.8363889 0.094650
+ 7.8366667 0.145034
+ 7.8369444 0.198694
+ 7.8372222 0.253174
+ 7.8375000 0.306015
+ 7.8377778 0.354760
+ 7.8380556 0.396951
+ 7.8383333 0.430129
+ 7.8386111 0.451839
+ 7.8388889 0.459621
+ 7.8391667 0.451837
+ 7.8394444 0.430127
+ 7.8397222 0.396946
+ 7.8400000 0.354755
+ 7.8402778 0.306010
+ 7.8405556 0.253168
+ 7.8408333 0.198689
+ 7.8411111 0.145029
+ 7.8413889 0.094647
+ 7.8416667 0.050000
+ 7.8419444 0.050000
+ 7.8422222 0.050000
+ 7.8425000 0.050000
+ 7.8427778 0.050000
+ 7.8430556 0.050000
+ 7.8433333 0.050000
+ 7.8436111 0.050000
+ 7.8438889 0.050000
+ 7.8441667 0.050000
+ 7.8444444 0.050000
+ 7.8447222 0.094640
+ 7.8450000 0.145013
+ 7.8452778 0.198662
+ 7.8455556 0.253129
+ 7.8458333 0.305958
+ 7.8461111 0.354692
+ 7.8463889 0.396873
+ 7.8466667 0.430044
+ 7.8469444 0.451749
+ 7.8472222 0.459529
+ 7.8475000 0.451748
+ 7.8477778 0.430043
+ 7.8480556 0.396871
+ 7.8483333 0.354690
+ 7.8486111 0.305956
+ 7.8488889 0.253127
+ 7.8491667 0.198660
+ 7.8494444 0.145012
+ 7.8497222 0.094639
+ 7.8500000 0.050000
+ 7.8502778 0.050000
+ 7.8505556 0.050000
+ 7.8508333 0.050000
+ 7.8511111 0.050000
+ 7.8513889 0.050000
+ 7.8516667 0.050000
+ 7.8519444 0.050000
+ 7.8522222 0.050000
+ 7.8525000 0.050000
+ 7.8527778 0.050000
+ 7.8530556 0.094642
+ 7.8533333 0.145019
+ 7.8536111 0.198672
+ 7.8538889 0.253145
+ 7.8541667 0.305979
+ 7.8544444 0.354718
+ 7.8547222 0.396904
+ 7.8550000 0.430079
+ 7.8552778 0.451787
+ 7.8555556 0.459569
+ 7.8558333 0.451787
+ 7.8561111 0.430079
+ 7.8563889 0.396904
+ 7.8566667 0.354718
+ 7.8569444 0.305979
+ 7.8572222 0.253145
+ 7.8575000 0.198672
+ 7.8577778 0.145019
+ 7.8580556 0.094642
+ 7.8583333 0.050000
+ 7.8586111 0.050000
+ 7.8588889 0.050000
+ 7.8591667 0.050000
+ 7.8594444 0.050000
+ 7.8597222 0.050000
+ 7.8600000 0.050000
+ 7.8602778 0.050000
+ 7.8605556 0.050000
+ 7.8608333 0.050000
+ 7.8611111 0.050000
+ 7.8613889 0.094639
+ 7.8616667 0.145012
+ 7.8619444 0.198661
+ 7.8622222 0.253128
+ 7.8625000 0.305957
+ 7.8627778 0.354691
+ 7.8630556 0.396872
+ 7.8633333 0.430044
+ 7.8636111 0.451749
+ 7.8638889 0.459529
+ 7.8641667 0.451748
+ 7.8644444 0.430042
+ 7.8647222 0.396870
+ 7.8650000 0.354689
+ 7.8652778 0.305955
+ 7.8655556 0.253125
+ 7.8658333 0.198658
+ 7.8661111 0.145010
+ 7.8663889 0.094638
+ 7.8666667 0.050000
+ 7.8669444 0.050000
+ 7.8672222 0.050000
+ 7.8675000 0.050000
+ 7.8677778 0.050000
+ 7.8680556 0.050000
+ 7.8683333 0.050000
+ 7.8686111 0.050000
+ 7.8688889 0.050000
+ 7.8691667 0.050000
+ 7.8694444 0.050000
+ 7.8697222 0.094636
+ 7.8700000 0.145005
+ 7.8702778 0.198650
+ 7.8705556 0.253114
+ 7.8708333 0.305939
+ 7.8711111 0.354670
+ 7.8713889 0.396849
+ 7.8716667 0.430018
+ 7.8719444 0.451722
+ 7.8722222 0.459503
+ 7.8725000 0.451723
+ 7.8727778 0.430020
+ 7.8730556 0.396851
+ 7.8733333 0.354673
+ 7.8736111 0.305943
+ 7.8738889 0.253117
+ 7.8741667 0.198653
+ 7.8744444 0.145008
+ 7.8747222 0.094638
+ 7.8750000 0.050000
+ 7.8752778 0.050000
+ 7.8755556 0.050000
+ 7.8758333 0.050000
+ 7.8761111 0.050000
+ 7.8763889 0.050000
+ 7.8766667 0.050000
+ 7.8769444 0.050000
+ 7.8772222 0.050000
+ 7.8775000 0.050000
+ 7.8777778 0.050000
+ 7.8780556 0.094646
+ 7.8783333 0.145028
+ 7.8786111 0.198687
+ 7.8788889 0.253165
+ 7.8791667 0.306006
+ 7.8794444 0.354750
+ 7.8797222 0.396940
+ 7.8800000 0.430118
+ 7.8802778 0.451827
+ 7.8805556 0.459608
+ 7.8808333 0.451822
+ 7.8811111 0.430110
+ 7.8813889 0.396928
+ 7.8816667 0.354735
+ 7.8819444 0.305989
+ 7.8822222 0.253148
+ 7.8825000 0.198671
+ 7.8827778 0.145015
+ 7.8830556 0.094639
+ 7.8833333 0.050000
+ 7.8836111 0.050000
+ 7.8838889 0.050000
+ 7.8841667 0.050000
+ 7.8844444 0.050000
+ 7.8847222 0.050000
+ 7.8850000 0.050000
+ 7.8852778 0.050000
+ 7.8855556 0.050000
+ 7.8858333 0.050000
+ 7.8861111 0.050000
+ 7.8863889 0.094602
+ 7.8866667 0.144932
+ 7.8869444 0.198539
+ 7.8872222 0.252973
+ 7.8875000 0.305783
+ 7.8877778 0.354518
+ 7.8880556 0.396728
+ 7.8883333 0.429962
+ 7.8886111 0.451769
+ 7.8888889 0.459699
+ 7.8891667 0.452118
+ 7.8894444 0.430656
+ 7.8897222 0.397762
+ 7.8900000 0.355882
+ 7.8902778 0.307464
+ 7.8905556 0.254956
+ 7.8908333 0.200806
+ 7.8911111 0.147460
+ 7.8913889 0.097366
+ 7.8916667 0.052972
+ 7.8919444 0.050000
+ 7.8922222 0.050000
+ 7.8925000 0.050000
+ 7.8927778 0.050000
+ 7.8930556 0.050000
+ 7.8933333 0.050000
+ 7.8936111 0.050000
+ 7.8938889 0.050000
+ 7.8941667 0.050000
+ 7.8944444 0.051416
+ 7.8947222 0.095297
+ 7.8950000 0.144847
+ 7.8952778 0.197686
+ 7.8955556 0.251435
+ 7.8958333 0.303714
+ 7.8961111 0.352143
+ 7.8963889 0.394343
+ 7.8966667 0.427932
+ 7.8969444 0.450533
+ 7.8972222 0.459765
+ 7.8975000 0.454034
+ 7.8977778 0.434894
+ 7.8980556 0.404684
+ 7.8983333 0.365743
+ 7.8986111 0.320410
+ 7.8988889 0.271025
+ 7.8991667 0.219927
+ 7.8994444 0.169456
+ 7.8997222 0.121951
+ 7.9000000 0.079750
+ 7.9002778 0.050000
+ 7.9005556 0.050000
+ 7.9008333 0.050000
+ 7.9011111 0.050000
+ 7.9013889 0.050000
+ 7.9016667 0.050000
+ 7.9019444 0.050000
+ 7.9022222 0.050000
+ 7.9025000 0.050000
+ 7.9027778 0.074978
+ 7.9030556 0.116326
+ 7.9033333 0.163090
+ 7.9036111 0.213002
+ 7.9038889 0.263792
+ 7.9041667 0.313190
+ 7.9044444 0.358928
+ 7.9047222 0.398735
+ 7.9050000 0.430343
+ 7.9052778 0.451482
+ 7.9055556 0.459882
+ 7.9058333 0.454024
+ 7.9061111 0.435384
+ 7.9063889 0.406187
+ 7.9066667 0.368659
+ 7.9069444 0.325023
+ 7.9072222 0.277507
+ 7.9075000 0.228335
+ 7.9077778 0.179733
+ 7.9080556 0.133926
+ 7.9083333 0.093139
+ 7.9086111 0.059231
+ 7.9088889 0.050000
+ 7.9091667 0.050000
+ 7.9094444 0.050000
+ 7.9097222 0.050000
+ 7.9100000 0.050000
+ 7.9102778 0.050000
+ 7.9105556 0.050000
+ 7.9108333 0.052388
+ 7.9111111 0.085032
+ 7.9113889 0.124848
+ 7.9116667 0.170009
+ 7.9119444 0.218317
+ 7.9122222 0.267572
+ 7.9125000 0.315576
+ 7.9127778 0.360131
+ 7.9130556 0.399037
+ 7.9133333 0.430097
+ 7.9136111 0.451112
+ 7.9138889 0.459882
+ 7.9141667 0.454930
+ 7.9144444 0.437652
+ 7.9147222 0.410168
+ 7.9150000 0.374594
+ 7.9152778 0.333049
+ 7.9155556 0.287650
+ 7.9158333 0.240516
+ 7.9161111 0.193763
+ 7.9163889 0.149510
+ 7.9166667 0.109875
+ 7.9169444 0.076637
+ 7.9172222 0.050222
+ 7.9175000 0.050000
+ 7.9177778 0.050000
+ 7.9180556 0.050000
+ 7.9183333 0.050000
+ 7.9186111 0.050000
+ 7.9188889 0.050000
+ 7.9191667 0.063780
+ 7.9194444 0.095126
+ 7.9197222 0.133707
+ 7.9200000 0.177699
+ 7.9202778 0.224898
+ 7.9205556 0.273099
+ 7.9208333 0.320098
+ 7.9211111 0.363689
+ 7.9213889 0.401668
+ 7.9216667 0.431830
+ 7.9219444 0.451969
+ 7.9222222 0.459882
+ 7.9225000 0.454089
+ 7.9227778 0.436009
+ 7.9230556 0.407788
+ 7.9233333 0.371572
+ 7.9236111 0.329507
+ 7.9238889 0.283738
+ 7.9241667 0.236409
+ 7.9244444 0.189668
+ 7.9247222 0.145659
+ 7.9250000 0.106528
+ 7.9252778 0.074066
+ 7.9255556 0.050000
+ 7.9258333 0.050000
+ 7.9261111 0.050000
+ 7.9263889 0.050000
+ 7.9266667 0.050000
+ 7.9269444 0.050000
+ 7.9272222 0.050000
+ 7.9275000 0.070039
+ 7.9277778 0.101847
+ 7.9280556 0.140551
+ 7.9283333 0.184358
+ 7.9286111 0.231114
+ 7.9288889 0.278663
+ 7.9291667 0.324849
+ 7.9294444 0.367519
+ 7.9297222 0.404516
+ 7.9300000 0.433686
+ 7.9302778 0.452873
+ 7.9305556 0.459922
+ 7.9308333 0.453392
+ 7.9311111 0.434700
+ 7.9313889 0.405979
+ 7.9316667 0.369360
+ 7.9319444 0.326976
+ 7.9322222 0.280957
+ 7.9325000 0.233437
+ 7.9327778 0.186546
+ 7.9330556 0.142416
+ 7.9333333 0.103181
+ 7.9336111 0.070619
+ 7.9338889 0.050000
+ 7.9341667 0.050000
+ 7.9344444 0.050000
+ 7.9347222 0.050000
+ 7.9350000 0.050000
+ 7.9352778 0.050000
+ 7.9355556 0.050000
+ 7.9358333 0.066479
+ 7.9361111 0.098434
+ 7.9363889 0.137337
+ 7.9366667 0.181390
+ 7.9369444 0.228433
+ 7.9372222 0.276305
+ 7.9375000 0.322845
+ 7.9377778 0.365892
+ 7.9380556 0.403286
+ 7.9383333 0.432865
+ 7.9386111 0.452468
+ 7.9388889 0.459935
+ 7.9391667 0.453819
+ 7.9394444 0.435533
+ 7.9397222 0.407207
+ 7.9400000 0.370967
+ 7.9402778 0.328943
+ 7.9405556 0.283261
+ 7.9408333 0.236051
+ 7.9411111 0.189440
+ 7.9413889 0.145556
+ 7.9416667 0.106528
+ 7.9419444 0.074134
+ 7.9422222 0.050000
+ 7.9425000 0.050000
+ 7.9427778 0.050000
+ 7.9430556 0.050000
+ 7.9433333 0.050000
+ 7.9436111 0.050000
+ 7.9438889 0.050000
+ 7.9441667 0.069978
+ 7.9444444 0.101781
+ 7.9447222 0.140502
+ 7.9450000 0.184343
+ 7.9452778 0.231142
+ 7.9455556 0.278735
+ 7.9458333 0.324961
+ 7.9461111 0.367658
+ 7.9463889 0.404662
+ 7.9466667 0.433811
+ 7.9469444 0.452943
+ 7.9472222 0.459895
+ 7.9475000 0.453225
+ 7.9477778 0.434366
+ 7.9480556 0.405473
+ 7.9483333 0.368699
+ 7.9486111 0.326198
+ 7.9488889 0.280125
+ 7.9491667 0.232632
+ 7.9494444 0.185875
+ 7.9497222 0.142006
+ 7.9500000 0.103181
+ 7.9502778 0.071190
+ 7.9505556 0.050000
+ 7.9508333 0.050000
+ 7.9511111 0.050000
+ 7.9513889 0.050000
+ 7.9516667 0.050000
+ 7.9519444 0.050000
+ 7.9522222 0.050000
+ 7.9525000 0.072922
+ 7.9527778 0.105168
+ 7.9530556 0.144137
+ 7.9533333 0.188041
+ 7.9536111 0.234739
+ 7.9538889 0.282089
+ 7.9541667 0.327948
+ 7.9544444 0.370175
+ 7.9547222 0.406626
+ 7.9550000 0.435160
+ 7.9552778 0.453635
+ 7.9555556 0.459908
+ 7.9558333 0.452554
+ 7.9561111 0.433012
+ 7.9563889 0.403435
+ 7.9566667 0.365981
+ 7.9569444 0.322802
+ 7.9572222 0.276056
+ 7.9575000 0.227896
+ 7.9577778 0.180477
+ 7.9580556 0.135956
+ 7.9583333 0.096486
+ 7.9586111 0.063865
+ 7.9588889 0.050000
+ 7.9591667 0.050000
+ 7.9594444 0.050000
+ 7.9597222 0.050000
+ 7.9600000 0.050000
+ 7.9602778 0.050000
+ 7.9605556 0.050000
+ 7.9608333 0.062689
+ 7.9611111 0.095061
+ 7.9613889 0.134311
+ 7.9616667 0.178656
+ 7.9619444 0.225955
+ 7.9622222 0.274067
+ 7.9625000 0.320851
+ 7.9627778 0.364165
+ 7.9630556 0.401869
+ 7.9633333 0.431822
+ 7.9636111 0.451882
+ 7.9638889 0.459908
+ 7.9641667 0.454463
+ 7.9644444 0.436918
+ 7.9647222 0.409346
+ 7.9650000 0.373824
+ 7.9652778 0.332424
+ 7.9655556 0.287222
+ 7.9658333 0.240291
+ 7.9661111 0.193707
+ 7.9663889 0.149544
+ 7.9666667 0.109875
+ 7.9669444 0.076451
+ 7.9672222 0.050000
+ 7.9675000 0.050000
+ 7.9677778 0.050000
+ 7.9680556 0.050000
+ 7.9683333 0.050000
+ 7.9686111 0.050000
+ 7.9688889 0.050000
+ 7.9691667 0.060453
+ 7.9694444 0.091740
+ 7.9697222 0.130443
+ 7.9700000 0.174712
+ 7.9702778 0.222301
+ 7.9705556 0.270967
+ 7.9708333 0.318464
+ 7.9711111 0.362547
+ 7.9713889 0.400972
+ 7.9716667 0.431492
+ 7.9719444 0.451864
+ 7.9722222 0.459843
+ 7.9725000 0.453919
+ 7.9727778 0.435526
+ 7.9730556 0.406833
+ 7.9733333 0.370011
+ 7.9736111 0.327227
+ 7.9738889 0.280653
+ 7.9741667 0.232457
+ 7.9744444 0.184809
+ 7.9747222 0.139878
+ 7.9750000 0.099833
+ 7.9752778 0.066492
+ 7.9755556 0.050000
+ 7.9758333 0.050000
+ 7.9761111 0.050000
+ 7.9763889 0.050000
+ 7.9766667 0.050000
+ 7.9769444 0.050000
+ 7.9772222 0.050000
+ 7.9775000 0.059469
+ 7.9777778 0.091766
+ 7.9780556 0.131216
+ 7.9783333 0.175983
+ 7.9786111 0.223854
+ 7.9788889 0.272614
+ 7.9791667 0.320050
+ 7.9794444 0.363950
+ 7.9797222 0.402099
+ 7.9800000 0.432284
+ 7.9802778 0.452292
+ 7.9805556 0.459908
+ 7.9808333 0.453650
+ 7.9811111 0.434947
+ 7.9813889 0.405959
+ 7.9816667 0.368846
+ 7.9819444 0.325767
+ 7.9822222 0.278883
+ 7.9825000 0.230354
+ 7.9827778 0.182338
+ 7.9830556 0.136995
+ 7.9833333 0.096486
+ 7.9836111 0.062623
+ 7.9838889 0.050000
+ 7.9841667 0.050000
+ 7.9844444 0.050000
+ 7.9847222 0.050000
+ 7.9850000 0.050000
+ 7.9852778 0.050000
+ 7.9855556 0.050000
+ 7.9858333 0.052542
+ 7.9861111 0.085019
+ 7.9863889 0.124858
+ 7.9866667 0.170189
+ 7.9869444 0.218758
+ 7.9872222 0.268309
+ 7.9875000 0.316584
+ 7.9877778 0.361329
+ 7.9880556 0.400288
+ 7.9883333 0.431203
+ 7.9886111 0.451820
+ 7.9888889 0.459882
+ 7.9891667 0.453873
+ 7.9894444 0.435234
+ 7.9897222 0.406146
+ 7.9900000 0.368789
+ 7.9902778 0.325345
+ 7.9905556 0.277994
+ 7.9908333 0.228917
+ 7.9911111 0.180295
+ 7.9913889 0.134309
+ 7.9916667 0.093139
+ 7.9919444 0.058618
+ 7.9922222 0.050000
+ 7.9925000 0.050000
+ 7.9927778 0.050000
+ 7.9930556 0.050000
+ 7.9933333 0.050000
+ 7.9936111 0.050000
+ 7.9938889 0.050000
+ 7.9941667 0.050000
+ 7.9944444 0.078312
+ 7.9947222 0.118534
+ 7.9950000 0.164403
+ 7.9952778 0.213628
+ 7.9955556 0.263920
+ 7.9958333 0.312987
+ 7.9961111 0.358540
+ 7.9963889 0.398289
+ 7.9966667 0.429942
+ 7.9969444 0.451211
+ 7.9972222 0.459804
+ 7.9975000 0.454183
+ 7.9977778 0.435817
+ 7.9980556 0.406926
+ 7.9983333 0.369730
+ 7.9986111 0.326449
+ 7.9988889 0.279304
+ 7.9991667 0.230515
+ 7.9994444 0.182302
+ 7.9997222 0.136886
+ 8.0000000 0.096486
+ 8.0002778 0.062958
+ 8.0005556 0.050000
+ 8.0008333 0.050000
+ 8.0011111 0.050000
+ 8.0013889 0.050000
+ 8.0016667 0.050000
+ 8.0019444 0.050000
+ 8.0022222 0.050000
+ 8.0025000 0.058807
+ 8.0027778 0.091740
+ 8.0030556 0.131824
+ 8.0033333 0.177188
+ 8.0036111 0.225579
+ 8.0038889 0.274745
+ 8.0041667 0.322435
+ 8.0044444 0.366395
+ 8.0047222 0.404373
+ 8.0050000 0.434117
+ 8.0052778 0.453376
+ 8.0055556 0.459895
+ 8.0058333 0.452175
+ 8.0061111 0.431717
+ 8.0063889 0.400772
+ 8.0066667 0.361594
+ 8.0069444 0.316435
+ 8.0072222 0.267546
+ 8.0075000 0.217181
+ 8.0077778 0.167592
+ 8.0080556 0.121031
+ 8.0083333 0.079750
+ 8.0086111 0.050000
+ 8.0088889 0.050000
+ 8.0091667 0.050000
+ 8.0094444 0.050000
+ 8.0097222 0.050000
+ 8.0100000 0.050000
+ 8.0102778 0.050000
+ 8.0105556 0.050000
+ 8.0108333 0.050000
+ 8.0111111 0.078272
+ 8.0113889 0.119361
+ 8.0116667 0.165785
+ 8.0119444 0.215298
+ 8.0122222 0.265657
+ 8.0125000 0.314616
+ 8.0127778 0.359930
+ 8.0130556 0.399355
+ 8.0133333 0.430645
+ 8.0136111 0.451556
+ 8.0138889 0.459843
+ 8.0141667 0.453999
+ 8.0144444 0.435473
+ 8.0147222 0.406452
+ 8.0150000 0.369123
+ 8.0152778 0.325672
+ 8.0155556 0.278287
+ 8.0158333 0.229154
+ 8.0161111 0.180460
+ 8.0163889 0.134393
+ 8.0166667 0.093139
+ 8.0169444 0.058537
+ 8.0172222 0.050000
+ 8.0175000 0.050000
+ 8.0177778 0.050000
+ 8.0180556 0.050000
+ 8.0183333 0.050000
+ 8.0186111 0.050000
+ 8.0188889 0.050000
+ 8.0191667 0.050000
+ 8.0194444 0.078312
+ 8.0197222 0.118705
+ 8.0200000 0.164766
+ 8.0202778 0.214183
+ 8.0205556 0.264642
+ 8.0208333 0.313832
+ 8.0211111 0.359440
+ 8.0213889 0.399152
+ 8.0216667 0.430657
+ 8.0219444 0.451640
+ 8.0222222 0.459791
+ 8.0225000 0.453555
+ 8.0227778 0.434419
+ 8.0230556 0.404629
+ 8.0233333 0.366431
+ 8.0236111 0.322070
+ 8.0238889 0.273794
+ 8.0241667 0.223847
+ 8.0244444 0.174476
+ 8.0247222 0.127926
+ 8.0250000 0.086444
+ 8.0252778 0.051910
+ 8.0255556 0.050000
+ 8.0258333 0.050000
+ 8.0261111 0.050000
+ 8.0263889 0.050000
+ 8.0266667 0.050000
+ 8.0269444 0.050000
+ 8.0272222 0.050000
+ 8.0275000 0.050000
+ 8.0277778 0.078312
+ 8.0280556 0.119222
+ 8.0283333 0.165642
+ 8.0286111 0.215275
+ 8.0288889 0.265826
+ 8.0291667 0.314999
+ 8.0294444 0.360499
+ 8.0297222 0.400030
+ 8.0300000 0.431297
+ 8.0302778 0.452004
+ 8.0305556 0.459856
+ 8.0308333 0.453314
+ 8.0311111 0.433866
+ 8.0313889 0.403757
+ 8.0316667 0.365234
+ 8.0319444 0.320540
+ 8.0322222 0.271920
+ 8.0325000 0.221621
+ 8.0327778 0.171888
+ 8.0330556 0.124965
+ 8.0333333 0.083097
+ 8.0336111 0.050000
+ 8.0338889 0.050000
+ 8.0341667 0.050000
+ 8.0344444 0.050000
+ 8.0347222 0.050000
+ 8.0350000 0.050000
+ 8.0352778 0.050000
+ 8.0355556 0.050000
+ 8.0358333 0.050000
+ 8.0361111 0.071604
+ 8.0363889 0.112389
+ 8.0366667 0.158775
+ 8.0369444 0.208497
+ 8.0372222 0.259292
+ 8.0375000 0.308898
+ 8.0377778 0.355050
+ 8.0380556 0.395485
+ 8.0383333 0.427940
+ 8.0386111 0.450152
+ 8.0388889 0.459856
+ 8.0391667 0.455522
+ 8.0394444 0.438548
+ 8.0397222 0.411061
+ 8.0400000 0.375191
+ 8.0402778 0.333069
+ 8.0405556 0.286822
+ 8.0408333 0.238581
+ 8.0411111 0.190474
+ 8.0413889 0.144631
+ 8.0416667 0.103181
+ 8.0419444 0.067929
+ 8.0422222 0.050000
+ 8.0425000 0.050000
+ 8.0427778 0.050000
+ 8.0430556 0.050000
+ 8.0433333 0.050000
+ 8.0436111 0.050000
+ 8.0438889 0.050000
+ 8.0441667 0.050000
+ 8.0444444 0.074978
+ 8.0447222 0.114793
+ 8.0450000 0.160629
+ 8.0452778 0.210117
+ 8.0455556 0.260889
+ 8.0458333 0.310575
+ 8.0461111 0.356807
+ 8.0463889 0.397215
+ 8.0466667 0.429433
+ 8.0469444 0.451089
+ 8.0472222 0.459817
+ 8.0475000 0.454021
+ 8.0477778 0.435209
+ 8.0480556 0.405660
+ 8.0483333 0.367656
+ 8.0486111 0.323477
+ 8.0488889 0.275404
+ 8.0491667 0.225718
+ 8.0494444 0.176700
+ 8.0497222 0.130631
+ 8.0500000 0.089792
+ 8.0502778 0.056080
+ 8.0505556 0.050000
+ 8.0508333 0.050000
+ 8.0511111 0.050000
+ 8.0513889 0.050000
+ 8.0516667 0.050000
+ 8.0519444 0.050000
+ 8.0522222 0.050000
+ 8.0525000 0.055115
+ 8.0527778 0.088380
+ 8.0530556 0.128653
+ 8.0533333 0.174100
+ 8.0536111 0.222519
+ 8.0538889 0.271710
+ 8.0541667 0.319472
+ 8.0544444 0.363606
+ 8.0547222 0.401910
+ 8.0550000 0.432185
+ 8.0552778 0.452229
+ 8.0555556 0.459843
+ 8.0558333 0.453551
+ 8.0561111 0.434777
+ 8.0563889 0.405670
+ 8.0566667 0.368380
+ 8.0569444 0.325055
+ 8.0572222 0.277846
+ 8.0575000 0.228900
+ 8.0577778 0.180368
+ 8.0580556 0.134397
+ 8.0583333 0.093139
+ 8.0586111 0.058403
+ 8.0588889 0.050000
+ 8.0591667 0.050000
+ 8.0594444 0.050000
+ 8.0597222 0.050000
+ 8.0600000 0.050000
+ 8.0602778 0.050000
+ 8.0605556 0.050000
+ 8.0608333 0.050000
+ 8.0611111 0.074991
+ 8.0613889 0.115280
+ 8.0616667 0.161351
+ 8.0619444 0.210887
+ 8.0622222 0.261567
+ 8.0625000 0.311073
+ 8.0627778 0.357086
+ 8.0630556 0.397287
+ 8.0633333 0.429357
+ 8.0636111 0.450978
+ 8.0638889 0.459830
+ 8.0641667 0.454352
+ 8.0644444 0.436010
+ 8.0647222 0.407030
+ 8.0650000 0.369636
+ 8.0652778 0.326052
+ 8.0655556 0.278502
+ 8.0658333 0.229212
+ 8.0661111 0.180405
+ 8.0663889 0.134306
+ 8.0666667 0.093139
+ 8.0669444 0.058768
+ 8.0672222 0.050000
+ 8.0675000 0.050000
+ 8.0677778 0.050000
+ 8.0680556 0.050000
+ 8.0683333 0.050000
+ 8.0686111 0.050000
+ 8.0688889 0.050000
+ 8.0691667 0.050000
+ 8.0694444 0.081672
+ 8.0697222 0.121876
+ 8.0700000 0.167590
+ 8.0702778 0.216548
+ 8.0705556 0.266485
+ 8.0708333 0.315137
+ 8.0711111 0.360238
+ 8.0713889 0.399525
+ 8.0716667 0.430731
+ 8.0719444 0.451592
+ 8.0722222 0.459843
+ 8.0725000 0.453966
+ 8.0727778 0.435424
+ 8.0730556 0.406429
+ 8.0733333 0.369192
+ 8.0736111 0.325924
+ 8.0738889 0.278834
+ 8.0741667 0.230135
+ 8.0744444 0.182037
+ 8.0747222 0.136750
+ 8.0750000 0.096486
+ 8.0752778 0.063091
+ 8.0755556 0.050000
+ 8.0758333 0.050000
+ 8.0761111 0.050000
+ 8.0763889 0.050000
+ 8.0766667 0.050000
+ 8.0769444 0.050000
+ 8.0772222 0.050000
+ 8.0775000 0.059043
+ 8.0777778 0.091766
+ 8.0780556 0.131576
+ 8.0783333 0.176629
+ 8.0786111 0.224710
+ 8.0788889 0.273602
+ 8.0791667 0.321088
+ 8.0794444 0.364953
+ 8.0797222 0.402979
+ 8.0800000 0.432952
+ 8.0802778 0.452654
+ 8.0805556 0.459869
+ 8.0808333 0.453117
+ 8.0811111 0.433858
+ 8.0813889 0.404290
+ 8.0816667 0.366608
+ 8.0819444 0.323009
+ 8.0822222 0.275689
+ 8.0825000 0.226846
+ 8.0827778 0.178676
+ 8.0830556 0.133374
+ 8.0833333 0.093139
+ 8.0836111 0.059801
+ 8.0838889 0.050000
+ 8.0841667 0.050000
+ 8.0844444 0.050000
+ 8.0847222 0.050000
+ 8.0850000 0.050000
+ 8.0852778 0.050000
+ 8.0855556 0.050000
+ 8.0858333 0.055862
+ 8.0861111 0.088380
+ 8.0863889 0.127908
+ 8.0866667 0.172653
+ 8.0869444 0.220461
+ 8.0872222 0.269176
+ 8.0875000 0.316643
+ 8.0877778 0.360708
+ 8.0880556 0.399215
+ 8.0883333 0.430010
+ 8.0886111 0.450938
+ 8.0888889 0.459843
+ 8.0891667 0.455268
+ 8.0894444 0.438538
+ 8.0897222 0.411676
+ 8.0900000 0.376706
+ 8.0902778 0.335650
+ 8.0905556 0.290530
+ 8.0908333 0.243370
+ 8.0911111 0.196193
+ 8.0913889 0.151020
+ 8.0916667 0.109875
+ 8.0919444 0.074487
+ 8.0922222 0.050000
+ 8.0925000 0.050000
+ 8.0927778 0.050000
+ 8.0930556 0.050000
+ 8.0933333 0.050000
+ 8.0936111 0.050000
+ 8.0938889 0.050000
+ 8.0941667 0.050000
+ 8.0944444 0.071696
+ 8.0947222 0.110845
+ 8.0950000 0.156289
+ 8.0952778 0.205637
+ 8.0955556 0.256503
+ 8.0958333 0.306498
+ 8.0961111 0.353234
+ 8.0963889 0.394322
+ 8.0966667 0.427374
+ 8.0969444 0.450002
+ 8.0972222 0.459817
+ 8.0975000 0.455203
+ 8.0977778 0.437633
+ 8.0980556 0.409348
+ 8.0983333 0.372594
+ 8.0986111 0.329613
+ 8.0988889 0.282648
+ 8.0991667 0.233945
+ 8.0994444 0.185746
+ 8.0997222 0.140294
+ 8.1000000 0.099833
+ 8.1002778 0.066236
+ 8.1005556 0.050000
+ 8.1008333 0.050000
+ 8.1011111 0.050000
+ 8.1013889 0.050000
+ 8.1016667 0.050000
+ 8.1019444 0.050000
+ 8.1022222 0.050000
+ 8.1025000 0.059612
+ 8.1027778 0.091766
+ 8.1030556 0.130935
+ 8.1033333 0.175326
+ 8.1036111 0.222783
+ 8.1038889 0.271153
+ 8.1041667 0.318280
+ 8.1044444 0.362010
+ 8.1047222 0.400187
+ 8.1050000 0.430657
+ 8.1052778 0.451265
+ 8.1055556 0.459856
+ 8.1058333 0.454975
+ 8.1061111 0.437962
+ 8.1063889 0.410856
+ 8.1066667 0.375699
+ 8.1069444 0.334528
+ 8.1072222 0.289385
+ 8.1075000 0.242308
+ 8.1077778 0.195338
+ 8.1080556 0.150513
+ 8.1083333 0.109875
+ 8.1086111 0.075158
+ 8.1088889 0.050000
+ 8.1091667 0.050000
+ 8.1094444 0.050000
+ 8.1097222 0.050000
+ 8.1100000 0.050000
+ 8.1102778 0.050000
+ 8.1105556 0.050000
+ 8.1108333 0.050000
+ 8.1111111 0.078351
+ 8.1113889 0.117296
+ 8.1116667 0.162286
+ 8.1119444 0.210987
+ 8.1122222 0.261066
+ 8.1125000 0.310191
+ 8.1127778 0.356029
+ 8.1130556 0.396247
+ 8.1133333 0.428513
+ 8.1136111 0.450494
+ 8.1138889 0.459856
+ 8.1141667 0.455028
+ 8.1144444 0.437479
+ 8.1147222 0.409435
+ 8.1150000 0.373127
+ 8.1152778 0.330784
+ 8.1155556 0.284632
+ 8.1158333 0.236903
+ 8.1161111 0.189823
+ 8.1163889 0.145622
+ 8.1166667 0.106528
+ 8.1169444 0.074392
+ 8.1172222 0.050000
+ 8.1175000 0.050000
+ 8.1177778 0.050000
+ 8.1180556 0.050000
+ 8.1183333 0.050000
+ 8.1186111 0.050000
+ 8.1188889 0.051380
+ 8.1191667 0.076446
+ 8.1194444 0.108476
+ 8.1197222 0.147087
+ 8.1200000 0.190523
+ 8.1202778 0.236687
+ 8.1205556 0.283481
+ 8.1208333 0.328808
+ 8.1211111 0.370570
+ 8.1213889 0.406669
+ 8.1216667 0.435007
+ 8.1219444 0.453488
+ 8.1222222 0.460013
+ 8.1225000 0.453195
+ 8.1227778 0.434488
+ 8.1230556 0.406057
+ 8.1233333 0.370066
+ 8.1236111 0.328680
+ 8.1238889 0.284062
+ 8.1241667 0.238378
+ 8.1244444 0.193791
+ 8.1247222 0.152467
+ 8.1250000 0.116569
+ 8.1252778 0.087873
+ 8.1255556 0.066590
+ 8.1258333 0.052545
+ 8.1261111 0.050000
+ 8.1263889 0.050000
+ 8.1266667 0.052062
+ 8.1269444 0.065196
+ 8.1272222 0.084681
+ 8.1275000 0.110342
+ 8.1277778 0.142000
+ 8.1280556 0.179191
+ 8.1283333 0.220289
+ 8.1286111 0.263380
+ 8.1288889 0.306551
+ 8.1291667 0.347888
+ 8.1294444 0.385477
+ 8.1297222 0.417404
+ 8.1300000 0.441756
+ 8.1302778 0.456619
+ 8.1305556 0.460078
+ 8.1308333 0.450888
+ 8.1311111 0.430467
+ 8.1313889 0.400903
+ 8.1316667 0.364282
+ 8.1319444 0.322691
+ 8.1322222 0.278217
+ 8.1325000 0.232946
+ 8.1327778 0.188966
+ 8.1330556 0.148362
+ 8.1333333 0.113222
+ 8.1336111 0.085253
+ 8.1338889 0.064645
+ 8.1341667 0.051208
+ 8.1344444 0.050000
+ 8.1347222 0.050000
+ 8.1350000 0.052028
+ 8.1352778 0.065379
+ 8.1355556 0.084954
+ 8.1358333 0.110562
+ 8.1361111 0.142014
+ 8.1363889 0.178843
+ 8.1366667 0.219481
+ 8.1369444 0.262081
+ 8.1372222 0.304796
+ 8.1375000 0.345781
+ 8.1377778 0.383189
+ 8.1380556 0.415174
+ 8.1383333 0.439890
+ 8.1386111 0.455491
+ 8.1388889 0.460131
+ 8.1391667 0.452602
+ 8.1394444 0.434254
+ 8.1397222 0.407076
+ 8.1400000 0.373057
+ 8.1402778 0.334186
+ 8.1405556 0.292451
+ 8.1408333 0.249842
+ 8.1411111 0.208346
+ 8.1413889 0.169954
+ 8.1416667 0.136653
+ 8.1419444 0.110073
+ 8.1422222 0.090409
+ 8.1425000 0.077493
+ 8.1427778 0.071161
+ 8.1430556 0.071247
+ 8.1433333 0.077586
+ 8.1436111 0.090011
+ 8.1438889 0.108357
+ 8.1441667 0.132458
+ 8.1444444 0.162149
+ 8.1447222 0.196994
+ 8.1450000 0.235479
+ 8.1452778 0.275817
+ 8.1455556 0.316223
+ 8.1458333 0.354913
+ 8.1461111 0.390101
+ 8.1463889 0.420002
+ 8.1466667 0.442831
+ 8.1469444 0.456802
+ 8.1472222 0.460131
+ 8.1475000 0.451650
+ 8.1477778 0.432664
+ 8.1480556 0.405095
+ 8.1483333 0.370867
+ 8.1486111 0.331901
+ 8.1488889 0.290121
+ 8.1491667 0.247448
+ 8.1494444 0.205807
+ 8.1497222 0.167118
+ 8.1500000 0.133306
+ 8.1502778 0.105954
+ 8.1505556 0.085298
+ 8.1508333 0.071236
+ 8.1511111 0.063666
+ 8.1513889 0.062484
+ 8.1516667 0.067589
+ 8.1519444 0.078878
+ 8.1522222 0.096249
+ 8.1525000 0.119599
+ 8.1527778 0.148826
+ 8.1530556 0.183546
+ 8.1533333 0.222248
+ 8.1536111 0.263139
+ 8.1538889 0.304427
+ 8.1541667 0.344320
+ 8.1544444 0.381024
+ 8.1547222 0.412747
+ 8.1550000 0.437696
+ 8.1552778 0.454080
+ 8.1555556 0.460105
+ 8.1558333 0.454575
+ 8.1561111 0.438685
+ 8.1563889 0.414223
+ 8.1566667 0.382981
+ 8.1569444 0.346749
+ 8.1572222 0.307316
+ 8.1575000 0.266474
+ 8.1577778 0.226012
+ 8.1580556 0.187720
+ 8.1583333 0.153389
+ 8.1586111 0.124526
+ 8.1588889 0.101507
+ 8.1591667 0.084423
+ 8.1594444 0.073368
+ 8.1597222 0.068433
+ 8.1600000 0.069712
+ 8.1602778 0.077297
+ 8.1605556 0.091280
+ 8.1608333 0.111753
+ 8.1611111 0.138810
+ 8.1613889 0.172211
+ 8.1616667 0.210389
+ 8.1619444 0.251448
+ 8.1622222 0.293489
+ 8.1625000 0.334614
+ 8.1627778 0.372927
+ 8.1630556 0.406529
+ 8.1633333 0.433522
+ 8.1636111 0.452009
+ 8.1638889 0.460092
+ 8.1641667 0.456482
+ 8.1644444 0.442325
+ 8.1647222 0.419379
+ 8.1650000 0.389397
+ 8.1652778 0.354136
+ 8.1655556 0.315351
+ 8.1658333 0.274798
+ 8.1661111 0.234231
+ 8.1663889 0.195408
+ 8.1666667 0.160083
+ 8.1669444 0.129756
+ 8.1672222 0.104897
+ 8.1675000 0.085724
+ 8.1677778 0.072450
+ 8.1680556 0.065291
+ 8.1683333 0.064462
+ 8.1686111 0.070179
+ 8.1688889 0.082656
+ 8.1691667 0.102110
+ 8.1694444 0.128755
+ 8.1697222 0.162429
+ 8.1700000 0.201457
+ 8.1702778 0.243785
+ 8.1705556 0.287361
+ 8.1708333 0.330133
+ 8.1711111 0.370046
+ 8.1713889 0.405049
+ 8.1716667 0.433089
+ 8.1719444 0.452112
+ 8.1722222 0.460065
+ 8.1725000 0.455568
+ 8.1727778 0.439920
+ 8.1730556 0.415095
+ 8.1733333 0.383066
+ 8.1736111 0.345803
+ 8.1738889 0.305281
+ 8.1741667 0.263472
+ 8.1744444 0.222347
+ 8.1747222 0.183879
+ 8.1750000 0.150042
+ 8.1752778 0.122465
+ 8.1755556 0.101415
+ 8.1758333 0.086815
+ 8.1761111 0.078592
+ 8.1763889 0.076667
+ 8.1766667 0.080967
+ 8.1769444 0.091415
+ 8.1772222 0.107936
+ 8.1775000 0.130454
+ 8.1777778 0.158894
+ 8.1780556 0.192887
+ 8.1783333 0.230896
+ 8.1786111 0.271094
+ 8.1788889 0.311650
+ 8.1791667 0.350736
+ 8.1794444 0.386522
+ 8.1797222 0.417180
+ 8.1800000 0.440880
+ 8.1802778 0.455794
+ 8.1805556 0.460092
+ 8.1808333 0.452558
+ 8.1811111 0.434429
+ 8.1813889 0.407555
+ 8.1816667 0.373786
+ 8.1819444 0.334972
+ 8.1822222 0.292961
+ 8.1825000 0.249605
+ 8.1827778 0.206752
+ 8.1830556 0.166254
+ 8.1833333 0.129958
+ 8.1836111 0.099426
+ 8.1838889 0.075058
+ 8.1841667 0.056965
+ 8.1844444 0.050000
+ 8.1847222 0.050000
+ 8.1850000 0.050000
+ 8.1852778 0.050000
+ 8.1855556 0.064487
+ 8.1858333 0.086363
+ 8.1861111 0.115288
+ 8.1863889 0.151016
+ 8.1866667 0.191874
+ 8.1869444 0.235834
+ 8.1872222 0.280866
+ 8.1875000 0.324941
+ 8.1877778 0.366030
+ 8.1880556 0.402104
+ 8.1883333 0.431135
+ 8.1886111 0.451092
+ 8.1888889 0.459948
+ 8.1891667 0.456317
+ 8.1894444 0.441398
+ 8.1897222 0.417031
+ 8.1900000 0.385058
+ 8.1902778 0.347322
+ 8.1905556 0.305664
+ 8.1908333 0.261927
+ 8.1911111 0.217951
+ 8.1913889 0.175579
+ 8.1916667 0.136653
+ 8.1919444 0.102761
+ 8.1922222 0.074476
+ 8.1925000 0.052120
+ 8.1927778 0.050000
+ 8.1930556 0.050000
+ 8.1933333 0.050000
+ 8.1936111 0.050000
+ 8.1938889 0.050000
+ 8.1941667 0.060404
+ 8.1944444 0.088510
+ 8.1947222 0.124677
+ 8.1950000 0.167077
+ 8.1952778 0.213454
+ 8.1955556 0.261550
+ 8.1958333 0.309109
+ 8.1961111 0.353873
+ 8.1963889 0.393587
+ 8.1966667 0.425994
+ 8.1969444 0.448835
+ 8.1972222 0.459856
+ 8.1975000 0.457502
+ 8.1977778 0.443032
+ 8.1980556 0.418410
+ 8.1983333 0.385596
+ 8.1986111 0.346555
+ 8.1988889 0.303248
+ 8.1991667 0.257637
+ 8.1994444 0.211686
+ 8.1997222 0.167356
+ 8.2000000 0.126611
+ 8.2002778 0.091139
+ 8.2005556 0.061539
+ 8.2008333 0.050000
+ 8.2011111 0.050000
+ 8.2013889 0.050000
+ 8.2016667 0.050000
+ 8.2019444 0.050000
+ 8.2022222 0.050000
+ 8.2025000 0.050000
+ 8.2027778 0.075134
+ 8.2030556 0.112566
+ 8.2033333 0.156459
+ 8.2036111 0.204476
+ 8.2038889 0.254282
+ 8.2041667 0.303539
+ 8.2044444 0.349911
+ 8.2047222 0.391061
+ 8.2050000 0.424653
+ 8.2052778 0.448351
+ 8.2055556 0.459817
+ 8.2058333 0.457444
+ 8.2061111 0.442540
+ 8.2063889 0.417142
+ 8.2066667 0.383285
+ 8.2069444 0.343006
+ 8.2072222 0.298343
+ 8.2075000 0.251331
+ 8.2077778 0.204007
+ 8.2080556 0.158408
+ 8.2083333 0.116569
+ 8.2086111 0.080241
+ 8.2088889 0.050018
+ 8.2091667 0.050000
+ 8.2094444 0.050000
+ 8.2097222 0.050000
+ 8.2100000 0.050000
+ 8.2102778 0.050000
+ 8.2105556 0.050000
+ 8.2108333 0.050000
+ 8.2111111 0.065014
+ 8.2113889 0.103166
+ 8.2116667 0.147855
+ 8.2119444 0.196741
+ 8.2122222 0.247482
+ 8.2125000 0.297737
+ 8.2127778 0.345166
+ 8.2130556 0.387426
+ 8.2133333 0.422178
+ 8.2136111 0.447080
+ 8.2138889 0.459791
+ 8.2141667 0.458691
+ 8.2144444 0.445050
+ 8.2147222 0.420858
+ 8.2150000 0.388104
+ 8.2152778 0.348780
+ 8.2155556 0.304876
+ 8.2158333 0.258382
+ 8.2161111 0.211288
+ 8.2163889 0.165585
+ 8.2166667 0.123264
+ 8.2169444 0.086048
+ 8.2172222 0.054602
+ 8.2175000 0.050000
+ 8.2177778 0.050000
+ 8.2180556 0.050000
+ 8.2183333 0.050000
+ 8.2186111 0.050000
+ 8.2188889 0.050000
+ 8.2191667 0.050000
+ 8.2194444 0.058333
+ 8.2197222 0.096199
+ 8.2200000 0.140997
+ 8.2202778 0.190316
+ 8.2205556 0.241747
+ 8.2208333 0.292879
+ 8.2211111 0.341304
+ 8.2213889 0.384611
+ 8.2216667 0.420390
+ 8.2219444 0.446231
+ 8.2222222 0.459725
+ 8.2225000 0.459200
+ 8.2227778 0.445935
+ 8.2230556 0.421947
+ 8.2233333 0.389255
+ 8.2236111 0.349874
+ 8.2238889 0.305823
+ 8.2241667 0.259120
+ 8.2244444 0.211780
+ 8.2247222 0.165822
+ 8.2250000 0.123264
+ 8.2252778 0.085852
+ 8.2255556 0.054253
+ 8.2258333 0.050000
+ 8.2261111 0.050000
+ 8.2263889 0.050000
+ 8.2266667 0.050000
+ 8.2269444 0.050000
+ 8.2272222 0.050000
+ 8.2275000 0.050000
+ 8.2277778 0.058385
+ 8.2280556 0.096499
+ 8.2283333 0.141562
+ 8.2286111 0.191136
+ 8.2288889 0.242786
+ 8.2291667 0.294072
+ 8.2294444 0.342559
+ 8.2297222 0.385809
+ 8.2300000 0.421385
+ 8.2302778 0.446849
+ 8.2305556 0.459765
+ 8.2308333 0.458445
+ 8.2311111 0.444207
+ 8.2313889 0.419116
+ 8.2316667 0.385240
+ 8.2319444 0.344645
+ 8.2322222 0.299398
+ 8.2325000 0.251565
+ 8.2327778 0.203214
+ 8.2330556 0.156411
+ 8.2333333 0.113222
+ 8.2336111 0.075432
+ 8.2338889 0.050000
+ 8.2341667 0.050000
+ 8.2344444 0.050000
+ 8.2347222 0.050000
+ 8.2350000 0.050000
+ 8.2352778 0.050000
+ 8.2355556 0.050000
+ 8.2358333 0.050000
+ 8.2361111 0.051625
+ 8.2363889 0.090397
+ 8.2366667 0.136098
+ 8.2369444 0.186299
+ 8.2372222 0.238574
+ 8.2375000 0.290492
+ 8.2377778 0.339628
+ 8.2380556 0.383552
+ 8.2383333 0.419837
+ 8.2386111 0.446055
+ 8.2388889 0.459778
+ 8.2391667 0.459321
+ 8.2394444 0.445980
+ 8.2397222 0.421791
+ 8.2400000 0.388792
+ 8.2402778 0.349021
+ 8.2405556 0.304517
+ 8.2408333 0.257316
+ 8.2411111 0.209458
+ 8.2413889 0.162978
+ 8.2416667 0.119917
+ 8.2419444 0.082040
+ 8.2422222 0.050032
+ 8.2425000 0.050000
+ 8.2427778 0.050000
+ 8.2430556 0.050000
+ 8.2433333 0.050000
+ 8.2436111 0.050000
+ 8.2438889 0.050000
+ 8.2441667 0.050000
+ 8.2444444 0.054960
+ 8.2447222 0.093920
+ 8.2450000 0.139952
+ 8.2452778 0.190529
+ 8.2455556 0.243128
+ 8.2458333 0.295221
+ 8.2461111 0.344285
+ 8.2463889 0.387793
+ 8.2466667 0.423222
+ 8.2469444 0.448046
+ 8.2472222 0.459738
+ 8.2475000 0.456567
+ 8.2477778 0.439959
+ 8.2480556 0.412135
+ 8.2483333 0.375316
+ 8.2486111 0.331720
+ 8.2488889 0.283568
+ 8.2491667 0.233079
+ 8.2494444 0.182473
+ 8.2497222 0.133971
+ 8.2500000 0.089792
+ 8.2502778 0.051831
+ 8.2505556 0.050000
+ 8.2508333 0.050000
+ 8.2511111 0.050000
+ 8.2513889 0.050000
+ 8.2516667 0.050000
+ 8.2519444 0.050000
+ 8.2522222 0.050000
+ 8.2525000 0.050000
+ 8.2527778 0.050000
+ 8.2530556 0.092117
+ 8.2533333 0.140922
+ 8.2536111 0.193811
+ 8.2538889 0.248179
+ 8.2541667 0.301420
+ 8.2544444 0.350930
+ 8.2547222 0.394103
+ 8.2550000 0.428335
+ 8.2552778 0.451021
+ 8.2555556 0.459555
+ 8.2558333 0.452190
+ 8.2561111 0.430603
+ 8.2563889 0.397327
+ 8.2566667 0.354898
+ 8.2569444 0.305849
+ 8.2572222 0.252714
+ 8.2575000 0.198027
+ 8.2577778 0.144324
+ 8.2580556 0.094136
+ 8.2583333 0.050000
+ 8.2586111 0.050000
+ 8.2588889 0.050000
+ 8.2591667 0.050000
+ 8.2594444 0.050000
+ 8.2597222 0.050000
+ 8.2600000 0.050000
+ 8.2602778 0.050000
+ 8.2605556 0.050000
+ 8.2608333 0.050000
+ 8.2611111 0.050000
+ 8.2613889 0.090786
+ 8.2616667 0.136665
+ 8.2619444 0.185738
+ 8.2622222 0.236107
+ 8.2625000 0.285876
+ 8.2627778 0.333145
+ 8.2630556 0.376019
+ 8.2633333 0.412597
+ 8.2636111 0.440984
+ 8.2638889 0.459281
+ 8.2641667 0.466131
+ 8.2644444 0.462338
+ 8.2647222 0.449249
+ 8.2650000 0.428207
+ 8.2652778 0.400558
+ 8.2655556 0.367648
+ 8.2658333 0.330821
+ 8.2661111 0.291422
+ 8.2663889 0.250798
+ 8.2666667 0.210292
+ 8.2669444 0.171192
+ 8.2672222 0.134556
+ 8.2675000 0.101381
+ 8.2677778 0.072667
+ 8.2680556 0.050000
+ 8.2683333 0.050000
+ 8.2686111 0.050000
+ 8.2688889 0.050000
+ 8.2691667 0.050000
+ 8.2694444 0.050000
+ 8.2697222 0.079960
+ 8.2700000 0.119243
+ 8.2702778 0.165720
+ 8.2705556 0.217260
+ 8.2708333 0.271733
+ 8.2711111 0.327010
+ 8.2713889 0.380961
+ 8.2716667 0.431455
+ 8.2719444 0.476364
+ 8.2722222 0.513556
+ 8.2725000 0.541444
+ 8.2727778 0.560613
+ 8.2730556 0.572188
+ 8.2733333 0.577295
+ 8.2736111 0.577060
+ 8.2738889 0.572611
+ 8.2741667 0.565072
+ 8.2744444 0.555570
+ 8.2747222 0.545231
+ 8.2750000 0.535182
+ 8.2752778 0.526372
+ 8.2755556 0.519046
+ 8.2758333 0.513275
+ 8.2761111 0.509128
+ 8.2763889 0.506673
+ 8.2766667 0.505981
+ 8.2769444 0.507121
+ 8.2772222 0.510162
+ 8.2775000 0.515173
+ 8.2777778 0.522224
+ 8.2780556 0.531181
+ 8.2783333 0.541090
+ 8.2786111 0.550795
+ 8.2788889 0.559140
+ 8.2791667 0.564968
+ 8.2794444 0.567122
+ 8.2797222 0.564446
+ 8.2800000 0.555783
+ 8.2802778 0.539977
+ 8.2805556 0.515870
+ 8.2808333 0.482793
+ 8.2811111 0.442019
+ 8.2813889 0.395310
+ 8.2816667 0.344424
+ 8.2819444 0.291123
+ 8.2822222 0.237168
+ 8.2825000 0.184317
+ 8.2827778 0.134332
+ 8.2830556 0.088973
+ 8.2833333 0.050000
+ 8.2836111 0.050000
+ 8.2838889 0.050000
+ 8.2841667 0.050000
+ 8.2844444 0.050000
+ 8.2847222 0.050000
+ 8.2850000 0.050000
+ 8.2852778 0.050000
+ 8.2855556 0.050000
+ 8.2858333 0.050000
+ 8.2861111 0.083764
+ 8.2863889 0.126609
+ 8.2866667 0.174136
+ 8.2869444 0.224177
+ 8.2872222 0.274566
+ 8.2875000 0.323134
+ 8.2877778 0.367715
+ 8.2880556 0.406142
+ 8.2883333 0.436247
+ 8.2886111 0.455863
+ 8.2888889 0.462824
+ 8.2891667 0.455699
+ 8.2894444 0.436005
+ 8.2897222 0.405997
+ 8.2900000 0.367929
+ 8.2902778 0.324055
+ 8.2905556 0.276630
+ 8.2908333 0.227907
+ 8.2911111 0.180142
+ 8.2913889 0.135588
+ 8.2916667 0.096499
+ 8.2919444 0.064737
+ 8.2922222 0.050000
+ 8.2925000 0.050000
+ 8.2927778 0.050000
+ 8.2930556 0.050000
+ 8.2933333 0.050000
+ 8.2936111 0.050000
+ 8.2938889 0.050000
+ 8.2941667 0.075584
+ 8.2944444 0.108437
+ 8.2947222 0.147604
+ 8.2950000 0.191353
+ 8.2952778 0.237627
+ 8.2955556 0.284370
+ 8.2958333 0.329524
+ 8.2961111 0.371033
+ 8.2963889 0.406840
+ 8.2966667 0.434887
+ 8.2969444 0.453118
+ 8.2972222 0.459477
+ 8.2975000 0.452581
+ 8.2977778 0.433753
+ 8.2980556 0.404988
+ 8.2983333 0.368283
+ 8.2986111 0.325636
+ 8.2988889 0.279042
+ 8.2991667 0.230499
+ 8.2994444 0.182003
+ 8.2997222 0.135550
+ 8.3000000 0.093139
+ 8.3002778 0.056484
+ 8.3005556 0.050000
+ 8.3008333 0.050000
+ 8.3011111 0.050000
+ 8.3013889 0.050000
+ 8.3016667 0.050000
+ 8.3019444 0.050000
+ 8.3022222 0.050000
+ 8.3025000 0.050000
+ 8.3027778 0.050000
+ 8.3030556 0.090497
+ 8.3033333 0.137693
+ 8.3036111 0.189116
+ 8.3038889 0.242293
+ 8.3041667 0.294749
+ 8.3044444 0.344014
+ 8.3047222 0.387612
+ 8.3050000 0.423073
+ 8.3052778 0.447922
+ 8.3055556 0.459686
+ 8.3058333 0.456673
+ 8.3061111 0.440306
+ 8.3063889 0.412790
+ 8.3066667 0.376329
+ 8.3069444 0.333127
+ 8.3072222 0.285387
+ 8.3075000 0.235315
+ 8.3077778 0.185113
+ 8.3080556 0.136986
+ 8.3083333 0.093139
+ 8.3086111 0.055450
+ 8.3088889 0.050000
+ 8.3091667 0.050000
+ 8.3094444 0.050000
+ 8.3097222 0.050000
+ 8.3100000 0.050000
+ 8.3102778 0.050000
+ 8.3105556 0.050000
+ 8.3108333 0.050000
+ 8.3111111 0.050000
+ 8.3113889 0.090696
+ 8.3116667 0.137976
+ 8.3119444 0.189394
+ 8.3122222 0.242504
+ 8.3125000 0.294859
+ 8.3127778 0.344015
+ 8.3130556 0.387526
+ 8.3133333 0.422945
+ 8.3136111 0.447827
+ 8.3138889 0.459725
+ 8.3141667 0.456965
+ 8.3144444 0.440950
+ 8.3147222 0.413853
+ 8.3150000 0.377848
+ 8.3152778 0.335110
+ 8.3155556 0.287811
+ 8.3158333 0.238125
+ 8.3161111 0.188227
+ 8.3163889 0.140289
+ 8.3166667 0.096486
+ 8.3169444 0.058677
+ 8.3172222 0.050000
+ 8.3175000 0.050000
+ 8.3177778 0.050000
+ 8.3180556 0.050000
+ 8.3183333 0.050000
+ 8.3186111 0.050000
+ 8.3188889 0.050000
+ 8.3191667 0.050000
+ 8.3194444 0.050000
+ 8.3197222 0.090720
+ 8.3200000 0.138147
+ 8.3202778 0.189786
+ 8.3205556 0.243143
+ 8.3208333 0.295724
+ 8.3211111 0.345034
+ 8.3213889 0.388580
+ 8.3216667 0.423867
+ 8.3219444 0.448400
+ 8.3222222 0.459686
+ 8.3225000 0.456021
+ 8.3227778 0.438868
+ 8.3230556 0.410479
+ 8.3233333 0.373108
+ 8.3236111 0.329008
+ 8.3238889 0.280433
+ 8.3241667 0.229636
+ 8.3244444 0.178870
+ 8.3247222 0.130388
+ 8.3250000 0.086444
+ 8.3252778 0.050000
+ 8.3255556 0.050000
+ 8.3258333 0.050000
+ 8.3261111 0.050000
+ 8.3263889 0.050000
+ 8.3266667 0.050000
+ 8.3269444 0.050000
+ 8.3272222 0.050000
+ 8.3275000 0.050000
+ 8.3277778 0.051521
+ 8.3280556 0.092965
+ 8.3283333 0.140827
+ 8.3286111 0.192648
+ 8.3288889 0.245969
+ 8.3291667 0.298331
+ 8.3294444 0.347276
+ 8.3297222 0.390344
+ 8.3300000 0.425076
+ 8.3302778 0.449014
+ 8.3305556 0.459699
+ 8.3308333 0.455459
+ 8.3311111 0.437765
+ 8.3313889 0.408879
+ 8.3316667 0.371060
+ 8.3319444 0.326568
+ 8.3322222 0.277662
+ 8.3325000 0.226603
+ 8.3327778 0.175649
+ 8.3330556 0.127060
+ 8.3333333 0.083097
+ 8.3336111 0.050000
+ 8.3338889 0.050000
+ 8.3341667 0.050000
+ 8.3344444 0.050000
+ 8.3347222 0.050000
+ 8.3350000 0.050000
+ 8.3352778 0.050000
+ 8.3355556 0.050000
+ 8.3358333 0.050000
+ 8.3361111 0.050000
+ 8.3363889 0.091428
+ 8.3366667 0.139216
+ 8.3369444 0.190940
+ 8.3372222 0.244177
+ 8.3375000 0.296503
+ 8.3377778 0.345497
+ 8.3380556 0.388734
+ 8.3383333 0.423791
+ 8.3386111 0.448245
+ 8.3388889 0.459673
+ 8.3391667 0.456421
+ 8.3394444 0.439908
+ 8.3397222 0.412324
+ 8.3400000 0.375858
+ 8.3402778 0.332700
+ 8.3405556 0.285038
+ 8.3408333 0.235062
+ 8.3411111 0.184961
+ 8.3413889 0.136923
+ 8.3416667 0.093139
+ 8.3419444 0.055476
+ 8.3422222 0.050000
+ 8.3425000 0.050000
+ 8.3427778 0.050000
+ 8.3430556 0.050000
+ 8.3433333 0.050000
+ 8.3436111 0.050000
+ 8.3438889 0.050000
+ 8.3441667 0.050000
+ 8.3444444 0.050000
+ 8.3447222 0.090833
+ 8.3450000 0.138281
+ 8.3452778 0.189874
+ 8.3455556 0.243142
+ 8.3458333 0.295615
+ 8.3461111 0.344825
+ 8.3463889 0.388301
+ 8.3466667 0.423574
+ 8.3469444 0.448175
+ 8.3472222 0.459634
+ 8.3475000 0.456263
+ 8.3477778 0.439500
+ 8.3480556 0.411567
+ 8.3483333 0.374684
+ 8.3486111 0.331072
+ 8.3488889 0.282951
+ 8.3491667 0.232542
+ 8.3494444 0.182066
+ 8.3497222 0.133742
+ 8.3500000 0.089792
+ 8.3502778 0.052106
+ 8.3505556 0.050000
+ 8.3508333 0.050000
+ 8.3511111 0.050000
+ 8.3513889 0.050000
+ 8.3516667 0.050000
+ 8.3519444 0.050000
+ 8.3522222 0.050000
+ 8.3525000 0.050000
+ 8.3527778 0.050000
+ 8.3530556 0.091244
+ 8.3533333 0.139044
+ 8.3536111 0.190919
+ 8.3538889 0.244387
+ 8.3541667 0.296966
+ 8.3544444 0.346175
+ 8.3547222 0.389532
+ 8.3550000 0.424555
+ 8.3552778 0.448763
+ 8.3555556 0.459673
+ 8.3558333 0.455596
+ 8.3561111 0.438009
+ 8.3563889 0.409179
+ 8.3566667 0.371375
+ 8.3569444 0.326864
+ 8.3572222 0.277914
+ 8.3575000 0.226795
+ 8.3577778 0.175774
+ 8.3580556 0.127118
+ 8.3583333 0.083097
+ 8.3586111 0.050000
+ 8.3588889 0.050000
+ 8.3591667 0.050000
+ 8.3594444 0.050000
+ 8.3597222 0.050000
+ 8.3600000 0.050000
+ 8.3602778 0.050000
+ 8.3605556 0.050000
+ 8.3608333 0.050000
+ 8.3611111 0.050000
+ 8.3613889 0.091441
+ 8.3616667 0.139237
+ 8.3619444 0.190967
+ 8.3622222 0.244206
+ 8.3625000 0.296532
+ 8.3627778 0.345523
+ 8.3630556 0.388755
+ 8.3633333 0.423806
+ 8.3636111 0.448253
+ 8.3638889 0.459673
+ 8.3641667 0.456412
+ 8.3644444 0.439891
+ 8.3647222 0.412300
+ 8.3650000 0.375828
+ 8.3652778 0.332666
+ 8.3655556 0.285003
+ 8.3658333 0.235029
+ 8.3661111 0.184934
+ 8.3663889 0.136907
+ 8.3666667 0.093139
+ 8.3669444 0.055498
+ 8.3672222 0.050000
+ 8.3675000 0.050000
+ 8.3677778 0.050000
+ 8.3680556 0.050000
+ 8.3683333 0.050000
+ 8.3686111 0.050000
+ 8.3688889 0.050000
+ 8.3691667 0.050000
+ 8.3694444 0.050000
+ 8.3697222 0.090756
+ 8.3700000 0.138114
+ 8.3702778 0.189616
+ 8.3705556 0.242804
+ 8.3708333 0.295220
+ 8.3711111 0.344405
+ 8.3713889 0.387901
+ 8.3716667 0.423250
+ 8.3719444 0.447993
+ 8.3722222 0.459673
+ 8.3725000 0.456607
+ 8.3727778 0.440216
+ 8.3730556 0.412699
+ 8.3733333 0.376253
+ 8.3736111 0.333075
+ 8.3738889 0.285364
+ 8.3741667 0.235318
+ 8.3744444 0.185133
+ 8.3747222 0.137007
+ 8.3750000 0.093139
+ 8.3752778 0.055403
+ 8.3755556 0.050000
+ 8.3758333 0.050000
+ 8.3761111 0.050000
+ 8.3763889 0.050000
+ 8.3766667 0.050000
+ 8.3769444 0.050000
+ 8.3772222 0.050000
+ 8.3775000 0.050000
+ 8.3777778 0.050000
+ 8.3780556 0.090938
+ 8.3783333 0.138500
+ 8.3786111 0.190206
+ 8.3788889 0.243573
+ 8.3791667 0.296121
+ 8.3794444 0.345368
+ 8.3797222 0.388832
+ 8.3800000 0.424031
+ 8.3802778 0.448485
+ 8.3805556 0.459712
+ 8.3808333 0.456019
+ 8.3811111 0.438862
+ 8.3813889 0.410489
+ 8.3816667 0.373144
+ 8.3819444 0.329074
+ 8.3822222 0.280524
+ 8.3825000 0.229740
+ 8.3827778 0.178969
+ 8.3830556 0.130455
+ 8.3833333 0.086444
+ 8.3836111 0.050000
+ 8.3838889 0.050000
+ 8.3841667 0.050000
+ 8.3844444 0.050000
+ 8.3847222 0.050000
+ 8.3850000 0.050000
+ 8.3852778 0.050000
+ 8.3855556 0.050000
+ 8.3858333 0.050000
+ 8.3861111 0.050000
+ 8.3863889 0.091390
+ 8.3866667 0.139243
+ 8.3869444 0.191100
+ 8.3872222 0.244503
+ 8.3875000 0.296993
+ 8.3877778 0.346112
+ 8.3880556 0.389401
+ 8.3883333 0.424404
+ 8.3886111 0.448660
+ 8.3888889 0.459712
+ 8.3891667 0.455885
+ 8.3894444 0.438637
+ 8.3897222 0.410210
+ 8.3900000 0.372843
+ 8.3902778 0.328779
+ 8.3905556 0.280259
+ 8.3908333 0.229525
+ 8.3911111 0.178816
+ 8.3913889 0.130376
+ 8.3916667 0.086444
+ 8.3919444 0.050000
+ 8.3922222 0.050000
+ 8.3925000 0.050000
+ 8.3927778 0.050000
+ 8.3930556 0.050000
+ 8.3933333 0.050000
+ 8.3936111 0.050000
+ 8.3938889 0.050000
+ 8.3941667 0.050000
+ 8.3944444 0.050000
+ 8.3947222 0.091204
+ 8.3950000 0.138846
+ 8.3952778 0.190490
+ 8.3955556 0.243703
+ 8.3958333 0.296051
+ 8.3961111 0.345100
+ 8.3963889 0.388417
+ 8.3966667 0.423568
+ 8.3969444 0.448118
+ 8.3972222 0.459634
+ 8.3975000 0.456453
+ 8.3977778 0.439994
+ 8.3980556 0.412447
+ 8.3983333 0.376003
+ 8.3986111 0.332851
+ 8.3988889 0.285182
+ 8.3991667 0.235187
+ 8.3994444 0.185054
+ 8.3997222 0.136975
+ 8.4000000 0.093139
+ 8.4002778 0.055417
+ 8.4005556 0.050000
+ 8.4008333 0.050000
+ 8.4011111 0.050000
+ 8.4013889 0.050000
+ 8.4016667 0.050000
+ 8.4019444 0.050000
+ 8.4022222 0.050000
+ 8.4025000 0.050000
+ 8.4027778 0.050000
+ 8.4030556 0.091010
+ 8.4033333 0.138661
+ 8.4036111 0.190459
+ 8.4038889 0.243911
+ 8.4041667 0.296523
+ 8.4044444 0.345801
+ 8.4047222 0.389251
+ 8.4050000 0.424380
+ 8.4052778 0.448694
+ 8.4055556 0.459699
+ 8.4058333 0.455696
+ 8.4061111 0.438160
+ 8.4063889 0.409361
+ 8.4066667 0.371570
+ 8.4069444 0.327056
+ 8.4072222 0.278089
+ 8.4075000 0.226940
+ 8.4077778 0.175879
+ 8.4080556 0.127174
+ 8.4083333 0.083097
+ 8.4086111 0.050000
+ 8.4088889 0.050000
+ 8.4091667 0.050000
+ 8.4094444 0.050000
+ 8.4097222 0.050000
+ 8.4100000 0.050000
+ 8.4102778 0.050000
+ 8.4105556 0.050000
+ 8.4108333 0.050000
+ 8.4111111 0.050000
+ 8.4113889 0.091602
+ 8.4116667 0.139582
+ 8.4119444 0.191496
+ 8.4122222 0.244900
+ 8.4125000 0.297347
+ 8.4127778 0.346393
+ 8.4130556 0.389594
+ 8.4133333 0.424504
+ 8.4136111 0.448679
+ 8.4138889 0.459673
+ 8.4141667 0.455822
+ 8.4144444 0.438579
+ 8.4147222 0.410176
+ 8.4150000 0.372846
+ 8.4152778 0.328822
+ 8.4155556 0.280338
+ 8.4158333 0.229625
+ 8.4161111 0.178916
+ 8.4163889 0.130445
+ 8.4166667 0.086444
+ 8.4169444 0.050000
+ 8.4172222 0.050000
+ 8.4175000 0.050000
+ 8.4177778 0.050000
+ 8.4180556 0.050000
+ 8.4183333 0.050000
+ 8.4186111 0.050000
+ 8.4188889 0.050000
+ 8.4191667 0.050000
+ 8.4194444 0.050000
+ 8.4197222 0.091688
+ 8.4200000 0.139893
+ 8.4202778 0.192110
+ 8.4205556 0.245836
+ 8.4208333 0.298567
+ 8.4211111 0.347799
+ 8.4213889 0.391028
+ 8.4216667 0.425751
+ 8.4219444 0.449463
+ 8.4222222 0.459660
+ 8.4225000 0.454645
+ 8.4227778 0.435940
+ 8.4230556 0.405877
+ 8.4233333 0.366783
+ 8.4236111 0.320990
+ 8.4238889 0.270826
+ 8.4241667 0.218621
+ 8.4244444 0.166705
+ 8.4247222 0.117406
+ 8.4250000 0.073055
+ 8.4252778 0.050000
+ 8.4255556 0.050000
+ 8.4258333 0.050000
+ 8.4261111 0.050000
+ 8.4263889 0.050000
+ 8.4266667 0.050000
+ 8.4269444 0.050000
+ 8.4272222 0.050000
+ 8.4275000 0.050000
+ 8.4277778 0.050000
+ 8.4280556 0.092844
+ 8.4283333 0.141917
+ 8.4286111 0.194729
+ 8.4288889 0.248785
+ 8.4291667 0.301593
+ 8.4294444 0.350662
+ 8.4297222 0.393498
+ 8.4300000 0.427609
+ 8.4302778 0.450503
+ 8.4305556 0.459686
+ 8.4308333 0.453481
+ 8.4311111 0.433465
+ 8.4313889 0.402027
+ 8.4316667 0.361560
+ 8.4319444 0.314454
+ 8.4322222 0.263099
+ 8.4325000 0.209887
+ 8.4327778 0.157208
+ 8.4330556 0.107453
+ 8.4333333 0.063014
+ 8.4336111 0.050000
+ 8.4338889 0.050000
+ 8.4341667 0.050000
+ 8.4344444 0.050000
+ 8.4347222 0.050000
+ 8.4350000 0.050000
+ 8.4352778 0.050000
+ 8.4355556 0.050000
+ 8.4358333 0.050000
+ 8.4361111 0.050000
+ 8.4363889 0.093331
+ 8.4366667 0.142626
+ 8.4369444 0.195454
+ 8.4372222 0.249380
+ 8.4375000 0.301971
+ 8.4377778 0.350794
+ 8.4380556 0.393416
+ 8.4383333 0.427403
+ 8.4386111 0.450321
+ 8.4388889 0.459738
+ 8.4391667 0.454014
+ 8.4394444 0.434684
+ 8.4397222 0.404078
+ 8.4400000 0.364523
+ 8.4402778 0.318349
+ 8.4405556 0.267885
+ 8.4408333 0.215460
+ 8.4411111 0.163403
+ 8.4413889 0.114043
+ 8.4416667 0.069708
+ 8.4419444 0.050000
+ 8.4422222 0.050000
+ 8.4425000 0.050000
+ 8.4427778 0.050000
+ 8.4430556 0.050000
+ 8.4433333 0.050000
+ 8.4436111 0.050000
+ 8.4438889 0.050000
+ 8.4441667 0.050000
+ 8.4444444 0.050000
+ 8.4447222 0.093350
+ 8.4450000 0.142909
+ 8.4452778 0.196149
+ 8.4455556 0.250544
+ 8.4458333 0.303568
+ 8.4461111 0.352692
+ 8.4463889 0.395392
+ 8.4466667 0.429140
+ 8.4469444 0.451409
+ 8.4472222 0.459673
+ 8.4475000 0.452239
+ 8.4477778 0.430749
+ 8.4480556 0.397680
+ 8.4483333 0.355509
+ 8.4486111 0.306711
+ 8.4488889 0.253763
+ 8.4491667 0.199141
+ 8.4494444 0.145323
+ 8.4497222 0.094783
+ 8.4500000 0.050000
+ 8.4502778 0.050000
+ 8.4505556 0.050000
+ 8.4508333 0.050000
+ 8.4511111 0.050000
+ 8.4513889 0.050000
+ 8.4516667 0.050000
+ 8.4519444 0.050000
+ 8.4522222 0.050000
+ 8.4525000 0.050000
+ 8.4527778 0.050000
+ 8.4530556 0.094682
+ 8.4533333 0.145091
+ 8.4536111 0.198769
+ 8.4538889 0.253261
+ 8.4541667 0.306109
+ 8.4544444 0.354856
+ 8.4547222 0.397046
+ 8.4550000 0.430221
+ 8.4552778 0.451924
+ 8.4555556 0.459699
+ 8.4558333 0.451908
+ 8.4561111 0.430190
+ 8.4563889 0.397002
+ 8.4566667 0.354802
+ 8.4569444 0.306049
+ 8.4572222 0.253200
+ 8.4575000 0.198712
+ 8.4577778 0.145045
+ 8.4580556 0.094655
+ 8.4583333 0.050000
+ 8.4586111 0.050000
+ 8.4588889 0.050000
+ 8.4591667 0.050000
+ 8.4594444 0.050000
+ 8.4597222 0.050000
+ 8.4600000 0.050000
+ 8.4602778 0.050000
+ 8.4605556 0.050000
+ 8.4608333 0.050000
+ 8.4611111 0.050000
+ 8.4613889 0.094656
+ 8.4616667 0.145047
+ 8.4619444 0.198716
+ 8.4622222 0.253204
+ 8.4625000 0.306054
+ 8.4627778 0.354807
+ 8.4630556 0.397005
+ 8.4633333 0.430189
+ 8.4636111 0.451902
+ 8.4638889 0.459686
+ 8.4641667 0.451902
+ 8.4644444 0.430188
+ 8.4647222 0.397003
+ 8.4650000 0.354805
+ 8.4652778 0.306052
+ 8.4655556 0.253202
+ 8.4658333 0.198714
+ 8.4661111 0.145045
+ 8.4663889 0.094655
+ 8.4666667 0.050000
+ 8.4669444 0.050000
+ 8.4672222 0.050000
+ 8.4675000 0.050000
+ 8.4677778 0.050000
+ 8.4680556 0.050000
+ 8.4683333 0.050000
+ 8.4686111 0.050000
+ 8.4688889 0.050000
+ 8.4691667 0.050000
+ 8.4694444 0.050000
+ 8.4697222 0.094650
+ 8.4700000 0.145034
+ 8.4702778 0.198694
+ 8.4705556 0.253174
+ 8.4708333 0.306015
+ 8.4711111 0.354759
+ 8.4713889 0.396950
+ 8.4716667 0.430129
+ 8.4719444 0.451838
+ 8.4722222 0.459621
+ 8.4725000 0.451838
+ 8.4727778 0.430128
+ 8.4730556 0.396949
+ 8.4733333 0.354759
+ 8.4736111 0.306014
+ 8.4738889 0.253173
+ 8.4741667 0.198694
+ 8.4744444 0.145033
+ 8.4747222 0.094649
+ 8.4750000 0.050000
+ 8.4752778 0.050000
+ 8.4755556 0.050000
+ 8.4758333 0.050000
+ 8.4761111 0.050000
+ 8.4763889 0.050000
+ 8.4766667 0.050000
+ 8.4769444 0.050000
+ 8.4772222 0.050000
+ 8.4775000 0.050000
+ 8.4777778 0.050000
+ 8.4780556 0.094653
+ 8.4783333 0.145043
+ 8.4786111 0.198710
+ 8.4788889 0.253196
+ 8.4791667 0.306044
+ 8.4794444 0.354796
+ 8.4797222 0.396992
+ 8.4800000 0.430176
+ 8.4802778 0.451889
+ 8.4805556 0.459673
+ 8.4808333 0.451889
+ 8.4811111 0.430177
+ 8.4813889 0.396993
+ 8.4816667 0.354797
+ 8.4819444 0.306045
+ 8.4822222 0.253197
+ 8.4825000 0.198711
+ 8.4827778 0.145044
+ 8.4830556 0.094654
+ 8.4833333 0.050000
+ 8.4836111 0.050000
+ 8.4838889 0.050000
+ 8.4841667 0.050000
+ 8.4844444 0.050000
+ 8.4847222 0.050000
+ 8.4850000 0.050000
+ 8.4852778 0.050000
+ 8.4855556 0.050000
+ 8.4858333 0.050000
+ 8.4861111 0.050000
+ 8.4863889 0.094652
+ 8.4866667 0.145039
+ 8.4869444 0.198703
+ 8.4872222 0.253186
+ 8.4875000 0.306031
+ 8.4877778 0.354778
+ 8.4880556 0.396972
+ 8.4883333 0.430153
+ 8.4886111 0.451864
+ 8.4888889 0.459647
+ 8.4891667 0.451863
+ 8.4894444 0.430152
+ 8.4897222 0.396970
+ 8.4900000 0.354776
+ 8.4902778 0.306028
+ 8.4905556 0.253184
+ 8.4908333 0.198701
+ 8.4911111 0.145037
+ 8.4913889 0.094651
+ 8.4916667 0.050000
+ 8.4919444 0.050000
+ 8.4922222 0.050000
+ 8.4925000 0.050000
+ 8.4927778 0.050000
+ 8.4930556 0.050000
+ 8.4933333 0.050000
+ 8.4936111 0.050000
+ 8.4938889 0.050000
+ 8.4941667 0.050000
+ 8.4944444 0.050000
+ 8.4947222 0.094649
+ 8.4950000 0.145033
+ 8.4952778 0.198693
+ 8.4955556 0.253173
+ 8.4958333 0.306014
+ 8.4961111 0.354758
+ 8.4963889 0.396949
+ 8.4966667 0.430128
+ 8.4969444 0.451838
+ 8.4972222 0.459621
+ 8.4975000 0.451838
+ 8.4977778 0.430128
+ 8.4980556 0.396949
+ 8.4983333 0.354759
+ 8.4986111 0.306014
+ 8.4988889 0.253173
+ 8.4991667 0.198694
+ 8.4994444 0.145033
+ 8.4997222 0.094649
+ 8.5000000 0.050000
+ 8.5002778 0.050000
+ 8.5005556 0.050000
+ 8.5008333 0.050000
+ 8.5011111 0.050000
+ 8.5013889 0.050000
+ 8.5016667 0.050000
+ 8.5019444 0.050000
+ 8.5022222 0.050000
+ 8.5025000 0.050000
+ 8.5027778 0.050000
+ 8.5030556 0.094652
+ 8.5033333 0.145040
+ 8.5036111 0.198705
+ 8.5038889 0.253190
+ 8.5041667 0.306036
+ 8.5044444 0.354785
+ 8.5047222 0.396981
+ 8.5050000 0.430164
+ 8.5052778 0.451876
+ 8.5055556 0.459660
+ 8.5058333 0.451877
+ 8.5061111 0.430166
+ 8.5063889 0.396983
+ 8.5066667 0.354789
+ 8.5069444 0.306039
+ 8.5072222 0.253193
+ 8.5075000 0.198708
+ 8.5077778 0.145043
+ 8.5080556 0.094654
+ 8.5083333 0.050000
+ 8.5086111 0.050000
+ 8.5088889 0.050000
+ 8.5091667 0.050000
+ 8.5094444 0.050000
+ 8.5097222 0.050000
+ 8.5100000 0.050000
+ 8.5102778 0.050000
+ 8.5105556 0.050000
+ 8.5108333 0.050000
+ 8.5111111 0.050000
+ 8.5113889 0.094657
+ 8.5116667 0.145051
+ 8.5119444 0.198721
+ 8.5122222 0.253211
+ 8.5125000 0.306062
+ 8.5127778 0.354814
+ 8.5130556 0.397010
+ 8.5133333 0.430190
+ 8.5136111 0.451898
+ 8.5138889 0.459673
+ 8.5141667 0.451878
+ 8.5144444 0.430151
+ 8.5147222 0.396954
+ 8.5150000 0.354746
+ 8.5152778 0.305985
+ 8.5155556 0.253133
+ 8.5158333 0.198649
+ 8.5161111 0.144992
+ 8.5163889 0.094623
+ 8.5166667 0.050000
+ 8.5169444 0.050000
+ 8.5172222 0.050000
+ 8.5175000 0.050000
+ 8.5177778 0.050000
+ 8.5180556 0.050000
+ 8.5183333 0.050000
+ 8.5186111 0.050000
+ 8.5188889 0.050000
+ 8.5191667 0.050000
+ 8.5194444 0.050000
+ 8.5197222 0.094491
+ 8.5200000 0.144692
+ 8.5202778 0.198168
+ 8.5205556 0.252484
+ 8.5208333 0.305207
+ 8.5211111 0.353902
+ 8.5213889 0.396135
+ 8.5216667 0.429470
+ 8.5219444 0.451474
+ 8.5222222 0.459712
+ 8.5225000 0.452564
+ 8.5227778 0.431663
+ 8.5230556 0.399456
+ 8.5233333 0.358390
+ 8.5236111 0.310913
+ 8.5238889 0.259472
+ 8.5241667 0.206515
+ 8.5244444 0.154488
+ 8.5247222 0.105838
+ 8.5250000 0.063014
+ 8.5252778 0.050000
+ 8.5255556 0.050000
+ 8.5258333 0.050000
+ 8.5261111 0.050000
+ 8.5263889 0.050000
+ 8.5266667 0.050000
+ 8.5269444 0.050000
+ 8.5272222 0.050000
+ 8.5275000 0.050000
+ 8.5277778 0.071591
+ 8.5280556 0.114333
+ 8.5283333 0.162239
+ 8.5286111 0.213047
+ 8.5288889 0.264492
+ 8.5291667 0.314313
+ 8.5294444 0.360246
+ 8.5297222 0.400028
+ 8.5300000 0.431394
+ 8.5302778 0.452083
+ 8.5305556 0.459830
+ 8.5308333 0.453128
+ 8.5311111 0.433492
+ 8.5313889 0.403190
+ 8.5316667 0.364493
+ 8.5319444 0.319669
+ 8.5322222 0.270989
+ 8.5325000 0.220723
+ 8.5327778 0.171139
+ 8.5330556 0.124507
+ 8.5333333 0.083097
+ 8.5336111 0.050000
+ 8.5338889 0.050000
+ 8.5341667 0.050000
+ 8.5344444 0.050000
+ 8.5347222 0.050000
+ 8.5350000 0.050000
+ 8.5352778 0.050000
+ 8.5355556 0.050000
+ 8.5358333 0.050000
+ 8.5361111 0.078325
+ 8.5363889 0.118930
+ 8.5366667 0.164881
+ 8.5369444 0.213970
+ 8.5372222 0.263988
+ 8.5375000 0.312725
+ 8.5377778 0.357973
+ 8.5380556 0.397521
+ 8.5383333 0.429162
+ 8.5386111 0.450685
+ 8.5388889 0.459882
+ 8.5391667 0.455266
+ 8.5394444 0.438237
+ 8.5397222 0.410918
+ 8.5400000 0.375432
+ 8.5402778 0.333902
+ 8.5405556 0.288449
+ 8.5408333 0.241198
+ 8.5411111 0.194270
+ 8.5413889 0.149788
+ 8.5416667 0.109875
+ 8.5419444 0.076317
+ 8.5422222 0.050000
+ 8.5425000 0.050000
+ 8.5427778 0.050000
+ 8.5430556 0.050000
+ 8.5433333 0.050000
+ 8.5436111 0.050000
+ 8.5438889 0.050000
+ 8.5441667 0.060650
+ 8.5444444 0.091779
+ 8.5447222 0.130210
+ 8.5450000 0.174130
+ 8.5452778 0.221347
+ 8.5455556 0.269666
+ 8.5458333 0.316895
+ 8.5461111 0.360840
+ 8.5463889 0.399308
+ 8.5466667 0.430104
+ 8.5469444 0.451035
+ 8.5472222 0.459908
+ 8.5475000 0.455247
+ 8.5477778 0.438443
+ 8.5480556 0.411605
+ 8.5483333 0.376841
+ 8.5486111 0.336261
+ 8.5488889 0.291973
+ 8.5491667 0.246085
+ 8.5494444 0.200708
+ 8.5497222 0.157949
+ 8.5500000 0.119917
+ 8.5502778 0.088372
+ 8.5505556 0.063683
+ 8.5508333 0.050000
+ 8.5511111 0.050000
+ 8.5513889 0.050000
+ 8.5516667 0.050000
+ 8.5519444 0.050000
+ 8.5522222 0.060582
+ 8.5525000 0.084418
+ 8.5527778 0.115262
+ 8.5530556 0.152781
+ 8.5533333 0.195227
+ 8.5536111 0.240498
+ 8.5538889 0.286492
+ 8.5541667 0.331109
+ 8.5544444 0.372247
+ 8.5547222 0.407803
+ 8.5550000 0.435678
+ 8.5552778 0.453769
+ 8.5555556 0.459974
+ 8.5558333 0.452893
+ 8.5561111 0.433927
+ 8.5563889 0.405177
+ 8.5566667 0.368745
+ 8.5569444 0.326734
+ 8.5572222 0.281243
+ 8.5575000 0.234376
+ 8.5577778 0.188233
+ 8.5580556 0.144916
+ 8.5583333 0.106528
+ 8.5586111 0.074818
+ 8.5588889 0.050134
+ 8.5591667 0.050000
+ 8.5594444 0.050000
+ 8.5597222 0.050000
+ 8.5600000 0.050000
+ 8.5602778 0.050000
+ 8.5605556 0.050000
+ 8.5608333 0.073783
+ 8.5611111 0.105181
+ 8.5613889 0.143231
+ 8.5616667 0.186211
+ 8.5619444 0.232059
+ 8.5622222 0.278712
+ 8.5625000 0.324105
+ 8.5627778 0.366175
+ 8.5630556 0.402859
+ 8.5633333 0.432094
+ 8.5636111 0.451816
+ 8.5638889 0.459961
+ 8.5641667 0.455142
+ 8.5644444 0.438675
+ 8.5647222 0.412551
+ 8.5650000 0.378763
+ 8.5652778 0.339302
+ 8.5655556 0.296159
+ 8.5658333 0.251327
+ 8.5661111 0.206797
+ 8.5663889 0.164561
+ 8.5666667 0.126611
+ 8.5669444 0.094626
+ 8.5672222 0.069035
+ 8.5675000 0.050000
+ 8.5677778 0.050000
+ 8.5680556 0.050000
+ 8.5683333 0.050000
+ 8.5686111 0.050000
+ 8.5688889 0.056328
+ 8.5691667 0.078776
+ 8.5694444 0.108554
+ 8.5697222 0.145405
+ 8.5700000 0.187569
+ 8.5702778 0.232911
+ 8.5705556 0.279295
+ 8.5708333 0.324587
+ 8.5711111 0.366651
+ 8.5713889 0.403354
+ 8.5716667 0.432558
+ 8.5719444 0.452130
+ 8.5722222 0.459935
+ 8.5725000 0.454535
+ 8.5727778 0.437291
+ 8.5730556 0.410261
+ 8.5733333 0.375503
+ 8.5736111 0.335075
+ 8.5738889 0.291034
+ 8.5741667 0.245440
+ 8.5744444 0.200350
+ 8.5747222 0.157823
+ 8.5750000 0.119917
+ 8.5752778 0.088353
+ 8.5755556 0.063511
+ 8.5758333 0.050000
+ 8.5761111 0.050000
+ 8.5763889 0.050000
+ 8.5766667 0.050000
+ 8.5769444 0.050000
+ 8.5772222 0.058030
+ 8.5775000 0.081446
+ 8.5777778 0.111928
+ 8.5780556 0.149164
+ 8.5783333 0.191423
+ 8.5786111 0.236619
+ 8.5788889 0.282664
+ 8.5791667 0.327474
+ 8.5794444 0.368961
+ 8.5797222 0.405040
+ 8.5800000 0.433624
+ 8.5802778 0.452626
+ 8.5805556 0.459961
+ 8.5808333 0.454226
+ 8.5811111 0.436754
+ 8.5813889 0.409564
+ 8.5816667 0.374672
+ 8.5819444 0.334096
+ 8.5822222 0.289854
+ 8.5825000 0.243963
+ 8.5827778 0.198440
+ 8.5830556 0.155303
+ 8.5833333 0.116569
+ 8.5836111 0.083940
+ 8.5838889 0.057848
+ 8.5841667 0.050000
+ 8.5844444 0.050000
+ 8.5847222 0.050000
+ 8.5850000 0.050000
+ 8.5852778 0.050000
+ 8.5855556 0.050000
+ 8.5858333 0.068072
+ 8.5861111 0.098487
+ 8.5863889 0.136111
+ 8.5866667 0.179165
+ 8.5869444 0.225490
+ 8.5872222 0.272926
+ 8.5875000 0.319313
+ 8.5877778 0.362493
+ 8.5880556 0.400305
+ 8.5883333 0.430591
+ 8.5886111 0.451192
+ 8.5888889 0.459948
+ 8.5891667 0.455398
+ 8.5894444 0.438878
+ 8.5897222 0.412422
+ 8.5900000 0.378065
+ 8.5902778 0.337841
+ 8.5905556 0.293785
+ 8.5908333 0.247929
+ 8.5911111 0.202310
+ 8.5913889 0.158961
+ 8.5916667 0.119917
+ 8.5919444 0.086896
+ 8.5922222 0.060356
+ 8.5925000 0.050000
+ 8.5927778 0.050000
+ 8.5930556 0.050000
+ 8.5933333 0.050000
+ 8.5936111 0.050000
+ 8.5938889 0.050000
+ 8.5941667 0.068031
+ 8.5944444 0.098473
+ 8.5947222 0.136286
+ 8.5950000 0.179645
+ 8.5952778 0.226330
+ 8.5955556 0.274122
+ 8.5958333 0.320804
+ 8.5961111 0.364157
+ 8.5963889 0.401961
+ 8.5966667 0.431998
+ 8.5969444 0.452049
+ 8.5972222 0.459895
+ 8.5975000 0.454046
+ 8.5977778 0.435920
+ 8.5980556 0.407664
+ 8.5983333 0.371424
+ 8.5986111 0.329347
+ 8.5988889 0.283579
+ 8.5991667 0.236266
+ 8.5994444 0.189556
+ 8.5997222 0.145594
+ 8.6000000 0.106528
+ 8.6002778 0.074147
+ 8.6005556 0.050000
+ 8.6008333 0.050000
+ 8.6011111 0.050000
+ 8.6013889 0.050000
+ 8.6016667 0.050000
+ 8.6019444 0.050000
+ 8.6022222 0.050000
+ 8.6025000 0.070258
+ 8.6027778 0.101873
+ 8.6030556 0.140313
+ 8.6033333 0.183814
+ 8.6036111 0.230261
+ 8.6038889 0.277534
+ 8.6041667 0.323517
+ 8.6044444 0.366092
+ 8.6047222 0.403141
+ 8.6050000 0.432548
+ 8.6052778 0.452193
+ 8.6055556 0.459961
+ 8.6058333 0.454427
+ 8.6061111 0.436949
+ 8.6063889 0.409577
+ 8.6066667 0.374362
+ 8.6069444 0.333355
+ 8.6072222 0.288607
+ 8.6075000 0.242169
+ 8.6077778 0.196092
+ 8.6080556 0.152426
+ 8.6083333 0.113222
+ 8.6086111 0.080209
+ 8.6088889 0.053825
+ 8.6091667 0.050000
+ 8.6094444 0.050000
+ 8.6097222 0.050000
+ 8.6100000 0.050000
+ 8.6102778 0.050000
+ 8.6105556 0.050000
+ 8.6108333 0.064356
+ 8.6111111 0.095126
+ 8.6113889 0.133174
+ 8.6116667 0.176697
+ 8.6119444 0.223513
+ 8.6122222 0.271436
+ 8.6125000 0.318283
+ 8.6127778 0.361869
+ 8.6130556 0.400010
+ 8.6133333 0.430522
+ 8.6136111 0.451221
+ 8.6138889 0.459922
+ 8.6141667 0.455147
+ 8.6144444 0.438247
+ 8.6147222 0.411276
+ 8.6150000 0.376292
+ 8.6152778 0.335349
+ 8.6155556 0.290504
+ 8.6158333 0.243813
+ 8.6161111 0.197332
+ 8.6163889 0.153116
+ 8.6166667 0.113222
+ 8.6169444 0.079390
+ 8.6172222 0.052096
+ 8.6175000 0.050000
+ 8.6177778 0.050000
+ 8.6180556 0.050000
+ 8.6183333 0.050000
+ 8.6186111 0.050000
+ 8.6188889 0.050000
+ 8.6191667 0.057628
+ 8.6194444 0.088432
+ 8.6197222 0.126820
+ 8.6200000 0.170940
+ 8.6202778 0.218540
+ 8.6205556 0.267365
+ 8.6208333 0.315162
+ 8.6211111 0.359678
+ 8.6213889 0.398658
+ 8.6216667 0.429851
+ 8.6219444 0.451001
+ 8.6222222 0.459856
+ 8.6225000 0.454892
+ 8.6227778 0.437507
+ 8.6230556 0.409828
+ 8.6233333 0.373981
+ 8.6236111 0.332095
+ 8.6238889 0.286297
+ 8.6241667 0.238714
+ 8.6244444 0.191473
+ 8.6247222 0.146702
+ 8.6250000 0.106528
+ 8.6252778 0.072741
+ 8.6255556 0.050000
+ 8.6258333 0.050000
+ 8.6261111 0.050000
+ 8.6263889 0.050000
+ 8.6266667 0.050000
+ 8.6269444 0.050000
+ 8.6272222 0.050000
+ 8.6275000 0.057034
+ 8.6277778 0.088458
+ 8.6280556 0.127262
+ 8.6283333 0.171613
+ 8.6286111 0.219294
+ 8.6288889 0.268085
+ 8.6291667 0.315767
+ 8.6294444 0.360122
+ 8.6297222 0.398929
+ 8.6300000 0.429971
+ 8.6302778 0.451029
+ 8.6305556 0.459882
+ 8.6308333 0.455031
+ 8.6311111 0.437843
+ 8.6313889 0.410405
+ 8.6316667 0.374801
+ 8.6319444 0.333119
+ 8.6322222 0.287443
+ 8.6325000 0.239861
+ 8.6327778 0.192457
+ 8.6330556 0.147317
+ 8.6333333 0.106528
+ 8.6336111 0.071856
+ 8.6338889 0.050000
+ 8.6341667 0.050000
+ 8.6344444 0.050000
+ 8.6347222 0.050000
+ 8.6350000 0.050000
+ 8.6352778 0.050000
+ 8.6355556 0.050000
+ 8.6358333 0.050000
+ 8.6361111 0.078364
+ 8.6363889 0.117285
+ 8.6366667 0.162115
+ 8.6369444 0.210574
+ 8.6372222 0.260382
+ 8.6375000 0.309258
+ 8.6377778 0.354923
+ 8.6380556 0.395097
+ 8.6383333 0.427499
+ 8.6386111 0.449850
+ 8.6388889 0.459869
+ 8.6391667 0.456007
+ 8.6394444 0.439631
+ 8.6397222 0.412839
+ 8.6400000 0.377729
+ 8.6402778 0.336399
+ 8.6405556 0.290947
+ 8.6408333 0.243471
+ 8.6411111 0.196068
+ 8.6413889 0.150837
+ 8.6416667 0.109875
+ 8.6419444 0.074962
+ 8.6422222 0.050000
+ 8.6425000 0.050000
+ 8.6427778 0.050000
+ 8.6430556 0.050000
+ 8.6433333 0.050000
+ 8.6436111 0.050000
+ 8.6438889 0.050000
+ 8.6441667 0.050000
+ 8.6444444 0.078377
+ 8.6447222 0.117094
+ 8.6450000 0.161778
+ 8.6452778 0.210143
+ 8.6455556 0.259905
+ 8.6458333 0.308777
+ 8.6461111 0.354474
+ 8.6463889 0.394711
+ 8.6466667 0.427202
+ 8.6469444 0.449661
+ 8.6472222 0.459804
+ 8.6475000 0.456073
+ 8.6477778 0.439827
+ 8.6480556 0.413154
+ 8.6483333 0.378142
+ 8.6486111 0.336880
+ 8.6488889 0.291454
+ 8.6491667 0.243952
+ 8.6494444 0.196463
+ 8.6497222 0.151075
+ 8.6500000 0.109875
+ 8.6502778 0.074638
+ 8.6505556 0.050000
+ 8.6508333 0.050000
+ 8.6511111 0.050000
+ 8.6513889 0.050000
+ 8.6516667 0.050000
+ 8.6519444 0.050000
+ 8.6522222 0.050000
+ 8.6525000 0.050000
+ 8.6527778 0.075043
+ 8.6530556 0.113849
+ 8.6533333 0.158748
+ 8.6536111 0.207427
+ 8.6538889 0.257574
+ 8.6541667 0.306878
+ 8.6544444 0.353028
+ 8.6547222 0.393711
+ 8.6550000 0.426615
+ 8.6552778 0.449430
+ 8.6555556 0.459843
+ 8.6558333 0.456276
+ 8.6561111 0.440083
+ 8.6563889 0.413351
+ 8.6566667 0.378170
+ 8.6569444 0.336625
+ 8.6572222 0.290805
+ 8.6575000 0.242798
+ 8.6577778 0.194691
+ 8.6580556 0.148572
+ 8.6583333 0.106528
+ 8.6586111 0.070342
+ 8.6588889 0.050000
+ 8.6591667 0.050000
+ 8.6594444 0.050000
+ 8.6597222 0.050000
+ 8.6600000 0.050000
+ 8.6602778 0.050000
+ 8.6605556 0.050000
+ 8.6608333 0.050000
+ 8.6611111 0.065001
+ 8.6613889 0.104335
+ 8.6616667 0.150056
+ 8.6619444 0.199779
+ 8.6622222 0.251124
+ 8.6625000 0.301707
+ 8.6627778 0.349147
+ 8.6630556 0.391060
+ 8.6633333 0.425064
+ 8.6636111 0.448777
+ 8.6638889 0.459817
+ 8.6641667 0.456558
+ 8.6644444 0.440405
+ 8.6647222 0.413522
+ 8.6650000 0.378070
+ 8.6652778 0.336213
+ 8.6655556 0.290112
+ 8.6658333 0.241930
+ 8.6661111 0.193831
+ 8.6663889 0.147976
+ 8.6666667 0.106528
+ 8.6669444 0.071317
+ 8.6672222 0.050000
+ 8.6675000 0.050000
+ 8.6677778 0.050000
+ 8.6680556 0.050000
+ 8.6683333 0.050000
+ 8.6686111 0.050000
+ 8.6688889 0.050000
+ 8.6691667 0.050000
+ 8.6694444 0.078364
+ 8.6697222 0.117866
+ 8.6700000 0.163312
+ 8.6702778 0.212360
+ 8.6705556 0.262667
+ 8.6708333 0.311893
+ 8.6711111 0.357694
+ 8.6713889 0.397731
+ 8.6716667 0.429660
+ 8.6719444 0.451140
+ 8.6722222 0.459830
+ 8.6725000 0.454152
+ 8.6727778 0.435591
+ 8.6730556 0.406394
+ 8.6733333 0.368812
+ 8.6736111 0.325092
+ 8.6738889 0.277483
+ 8.6741667 0.228235
+ 8.6744444 0.179596
+ 8.6747222 0.133814
+ 8.6750000 0.093139
+ 8.6752778 0.059445
+ 8.6755556 0.050000
+ 8.6758333 0.050000
+ 8.6761111 0.050000
+ 8.6763889 0.050000
+ 8.6766667 0.050000
+ 8.6769444 0.050000
+ 8.6772222 0.050000
+ 8.6775000 0.055571
+ 8.6777778 0.088406
+ 8.6780556 0.128303
+ 8.6783333 0.173436
+ 8.6786111 0.221613
+ 8.6788889 0.270640
+ 8.6791667 0.318325
+ 8.6794444 0.362475
+ 8.6797222 0.400897
+ 8.6800000 0.431399
+ 8.6802778 0.451787
+ 8.6805556 0.459869
+ 8.6808333 0.454168
+ 8.6811111 0.436065
+ 8.6813889 0.407658
+ 8.6816667 0.371044
+ 8.6819444 0.328322
+ 8.6822222 0.281588
+ 8.6825000 0.232940
+ 8.6827778 0.184475
+ 8.6830556 0.138291
+ 8.6833333 0.096486
+ 8.6836111 0.060841
+ 8.6838889 0.050000
+ 8.6841667 0.050000
+ 8.6844444 0.050000
+ 8.6847222 0.050000
+ 8.6850000 0.050000
+ 8.6852778 0.050000
+ 8.6855556 0.050000
+ 8.6858333 0.050000
+ 8.6861111 0.064975
+ 8.6863889 0.104840
+ 8.6866667 0.150870
+ 8.6869444 0.200720
+ 8.6872222 0.252048
+ 8.6875000 0.302510
+ 8.6877778 0.349762
+ 8.6880556 0.391461
+ 8.6883333 0.425263
+ 8.6886111 0.448825
+ 8.6888889 0.459804
+ 8.6891667 0.456600
+ 8.6894444 0.440593
+ 8.6897222 0.413907
+ 8.6900000 0.378667
+ 8.6902778 0.336996
+ 8.6905556 0.291019
+ 8.6908333 0.242859
+ 8.6911111 0.194641
+ 8.6913889 0.148489
+ 8.6916667 0.106528
+ 8.6919444 0.070564
+ 8.6922222 0.050000
+ 8.6925000 0.050000
+ 8.6927778 0.050000
+ 8.6930556 0.050000
+ 8.6933333 0.050000
+ 8.6936111 0.050000
+ 8.6938889 0.050000
+ 8.6941667 0.050000
+ 8.6944444 0.068309
+ 8.6947222 0.107486
+ 8.6950000 0.152896
+ 8.6952778 0.202199
+ 8.6955556 0.253056
+ 8.6958333 0.303127
+ 8.6961111 0.350072
+ 8.6963889 0.391550
+ 8.6966667 0.425223
+ 8.6969444 0.448750
+ 8.6972222 0.459791
+ 8.6975000 0.456747
+ 8.6977778 0.440985
+ 8.6980556 0.414612
+ 8.6983333 0.379734
+ 8.6986111 0.338459
+ 8.6988889 0.292894
+ 8.6991667 0.245146
+ 8.6994444 0.197322
+ 8.6997222 0.151529
+ 8.7000000 0.109875
+ 8.7002778 0.074153
+ 8.7005556 0.050000
+ 8.7008333 0.050000
+ 8.7011111 0.050000
+ 8.7013889 0.050000
+ 8.7016667 0.050000
+ 8.7019444 0.050000
+ 8.7022222 0.050000
+ 8.7025000 0.050000
+ 8.7027778 0.071722
+ 8.7030556 0.110699
+ 8.7033333 0.155884
+ 8.7036111 0.204935
+ 8.7038889 0.255509
+ 8.7041667 0.305263
+ 8.7044444 0.351857
+ 8.7047222 0.392948
+ 8.7050000 0.426193
+ 8.7052778 0.449250
+ 8.7055556 0.459778
+ 8.7058333 0.456176
+ 8.7061111 0.439815
+ 8.7063889 0.412809
+ 8.7066667 0.377270
+ 8.7069444 0.335311
+ 8.7072222 0.289046
+ 8.7075000 0.240587
+ 8.7077778 0.192048
+ 8.7080556 0.145541
+ 8.7083333 0.103181
+ 8.7086111 0.066768
+ 8.7088889 0.050000
+ 8.7091667 0.050000
+ 8.7094444 0.050000
+ 8.7097222 0.050000
+ 8.7100000 0.050000
+ 8.7102778 0.050000
+ 8.7105556 0.050000
+ 8.7108333 0.050000
+ 8.7111111 0.061615
+ 8.7113889 0.100994
+ 8.7116667 0.146756
+ 8.7119444 0.196543
+ 8.7122222 0.247999
+ 8.7125000 0.298767
+ 8.7127778 0.346491
+ 8.7130556 0.388815
+ 8.7133333 0.423381
+ 8.7136111 0.447834
+ 8.7138889 0.459817
+ 8.7141667 0.457711
+ 8.7144444 0.442849
+ 8.7147222 0.417302
+ 8.7150000 0.383140
+ 8.7152778 0.342435
+ 8.7155556 0.297256
+ 8.7158333 0.249674
+ 8.7161111 0.201761
+ 8.7163889 0.155587
+ 8.7166667 0.113222
+ 8.7169444 0.076445
+ 8.7172222 0.050000
+ 8.7175000 0.050000
+ 8.7177778 0.050000
+ 8.7180556 0.050000
+ 8.7183333 0.050000
+ 8.7186111 0.050000
+ 8.7188889 0.050000
+ 8.7191667 0.050000
+ 8.7194444 0.061680
+ 8.7197222 0.100461
+ 8.7200000 0.145856
+ 8.7202778 0.195471
+ 8.7205556 0.246910
+ 8.7208333 0.297779
+ 8.7211111 0.345683
+ 8.7213889 0.388227
+ 8.7216667 0.423016
+ 8.7219444 0.447656
+ 8.7222222 0.459752
+ 8.7225000 0.457658
+ 8.7227778 0.442726
+ 8.7230556 0.417057
+ 8.7233333 0.382752
+ 8.7236111 0.341912
+ 8.7238889 0.296638
+ 8.7241667 0.249031
+ 8.7244444 0.201192
+ 8.7247222 0.155222
+ 8.7250000 0.113222
+ 8.7252778 0.076988
+ 8.7255556 0.050000
+ 8.7258333 0.050000
+ 8.7261111 0.050000
+ 8.7263889 0.050000
+ 8.7266667 0.050000
+ 8.7269444 0.050000
+ 8.7272222 0.050000
+ 8.7275000 0.050000
+ 8.7277778 0.068375
+ 8.7280556 0.107178
+ 8.7283333 0.152370
+ 8.7286111 0.201584
+ 8.7288889 0.252452
+ 8.7291667 0.302606
+ 8.7294444 0.349679
+ 8.7297222 0.391304
+ 8.7300000 0.425114
+ 8.7302778 0.448740
+ 8.7305556 0.459817
+ 8.7308333 0.456723
+ 8.7311111 0.440826
+ 8.7313889 0.414242
+ 8.7316667 0.379084
+ 8.7319444 0.337467
+ 8.7322222 0.291507
+ 8.7325000 0.243319
+ 8.7327778 0.195016
+ 8.7330556 0.148714
+ 8.7333333 0.106528
+ 8.7336111 0.070260
+ 8.7338889 0.050000
+ 8.7341667 0.050000
+ 8.7344444 0.050000
+ 8.7347222 0.050000
+ 8.7350000 0.050000
+ 8.7352778 0.050000
+ 8.7355556 0.050000
+ 8.7358333 0.050000
+ 8.7361111 0.065001
+ 8.7363889 0.104197
+ 8.7366667 0.149739
+ 8.7369444 0.199271
+ 8.7372222 0.250438
+ 8.7375000 0.300884
+ 8.7377778 0.348253
+ 8.7380556 0.390189
+ 8.7383333 0.424336
+ 8.7386111 0.448340
+ 8.7388889 0.459843
+ 8.7391667 0.457235
+ 8.7394444 0.441880
+ 8.7397222 0.415887
+ 8.7400000 0.381365
+ 8.7402778 0.340423
+ 8.7405556 0.295170
+ 8.7408333 0.247714
+ 8.7411111 0.200165
+ 8.7413889 0.154631
+ 8.7416667 0.113222
+ 8.7419444 0.077731
+ 8.7422222 0.050000
+ 8.7425000 0.050000
+ 8.7427778 0.050000
+ 8.7430556 0.050000
+ 8.7433333 0.050000
+ 8.7436111 0.050000
+ 8.7438889 0.050000
+ 8.7441667 0.050000
+ 8.7444444 0.075069
+ 8.7447222 0.113577
+ 8.7450000 0.158213
+ 8.7452778 0.206678
+ 8.7455556 0.256670
+ 8.7458333 0.305887
+ 8.7461111 0.352027
+ 8.7463889 0.392791
+ 8.7466667 0.425876
+ 8.7469444 0.448980
+ 8.7472222 0.459804
+ 8.7475000 0.456775
+ 8.7477778 0.441244
+ 8.7480556 0.415291
+ 8.7483333 0.380996
+ 8.7486111 0.340441
+ 8.7488889 0.295706
+ 8.7491667 0.248870
+ 8.7494444 0.202016
+ 8.7497222 0.157222
+ 8.7500000 0.116569
+ 8.7502778 0.081825
+ 8.7505556 0.053501
+ 8.7508333 0.050000
+ 8.7511111 0.050000
+ 8.7513889 0.050000
+ 8.7516667 0.050000
+ 8.7519444 0.050000
+ 8.7522222 0.050000
+ 8.7525000 0.051635
+ 8.7527778 0.081803
+ 8.7530556 0.119766
+ 8.7533333 0.163686
+ 8.7536111 0.211315
+ 8.7538889 0.260407
+ 8.7541667 0.308716
+ 8.7544444 0.353994
+ 8.7547222 0.393995
+ 8.7550000 0.426472
+ 8.7552778 0.449179
+ 8.7555556 0.459869
+ 8.7558333 0.457007
+ 8.7561111 0.441905
+ 8.7563889 0.416586
+ 8.7566667 0.383075
+ 8.7569444 0.343393
+ 8.7572222 0.299565
+ 8.7575000 0.253615
+ 8.7577778 0.207566
+ 8.7580556 0.163441
+ 8.7583333 0.123264
+ 8.7586111 0.088760
+ 8.7588889 0.060458
+ 8.7591667 0.050000
+ 8.7594444 0.050000
+ 8.7597222 0.050000
+ 8.7600000 0.050000
+ 8.7602778 0.050000
+ 8.7605556 0.050000
+ 8.7608333 0.055442
+ 8.7611111 0.085085
+ 8.7613889 0.122596
+ 8.7616667 0.166130
+ 8.7619444 0.213425
+ 8.7622222 0.262222
+ 8.7625000 0.310259
+ 8.7627778 0.355274
+ 8.7630556 0.395008
+ 8.7633333 0.427199
+ 8.7636111 0.449586
+ 8.7638889 0.459908
+ 8.7641667 0.456627
+ 8.7644444 0.441085
+ 8.7647222 0.415349
+ 8.7650000 0.381484
+ 8.7652778 0.341556
+ 8.7655556 0.297631
+ 8.7658333 0.251773
+ 8.7661111 0.206049
+ 8.7663889 0.162524
+ 8.7666667 0.123264
+ 8.7669444 0.090013
+ 8.7672222 0.063231
+ 8.7675000 0.050000
+ 8.7677778 0.050000
+ 8.7680556 0.050000
+ 8.7683333 0.050000
+ 8.7686111 0.050000
+ 8.7688889 0.050000
+ 8.7691667 0.068547
+ 8.7694444 0.098513
+ 8.7697222 0.135811
+ 8.7700000 0.178653
+ 8.7702778 0.224862
+ 8.7705556 0.272264
+ 8.7708333 0.318684
+ 8.7711111 0.361947
+ 8.7713889 0.399877
+ 8.7716667 0.430299
+ 8.7719444 0.451039
+ 8.7722222 0.459922
+ 8.7725000 0.455480
+ 8.7727778 0.439081
+ 8.7730556 0.412802
+ 8.7733333 0.378720
+ 8.7736111 0.338909
+ 8.7738889 0.295447
+ 8.7741667 0.250410
+ 8.7744444 0.205874
+ 8.7747222 0.163916
+ 8.7750000 0.126611
+ 8.7752778 0.095692
+ 8.7755556 0.071513
+ 8.7758333 0.054086
+ 8.7761111 0.050000
+ 8.7763889 0.050000
+ 8.7766667 0.050000
+ 8.7769444 0.052097
+ 8.7772222 0.068583
+ 8.7775000 0.091883
+ 8.7777778 0.122009
+ 8.7780556 0.158629
+ 8.7783333 0.200049
+ 8.7786111 0.244235
+ 8.7788889 0.289150
+ 8.7791667 0.332761
+ 8.7794444 0.373032
+ 8.7797222 0.407928
+ 8.7800000 0.435413
+ 8.7802778 0.453453
+ 8.7805556 0.460013
+ 8.7808333 0.453734
+ 8.7811111 0.435965
+ 8.7813889 0.408732
+ 8.7816667 0.374060
+ 8.7819444 0.333976
+ 8.7822222 0.290505
+ 8.7825000 0.245672
+ 8.7827778 0.201504
+ 8.7830556 0.160026
+ 8.7833333 0.123264
+ 8.7836111 0.092904
+ 8.7838889 0.069280
+ 8.7841667 0.052384
+ 8.7844444 0.050000
+ 8.7847222 0.050000
+ 8.7850000 0.050000
+ 8.7852778 0.051948
+ 8.7855556 0.068594
+ 8.7858333 0.091928
+ 8.7861111 0.121943
+ 8.7863889 0.158306
+ 8.7866667 0.199369
+ 8.7869444 0.243156
+ 8.7872222 0.287694
+ 8.7875000 0.331006
+ 8.7877778 0.371119
+ 8.7880556 0.406056
+ 8.7883333 0.433843
+ 8.7886111 0.452504
+ 8.7888889 0.460065
+ 8.7891667 0.455204
+ 8.7894444 0.439208
+ 8.7897222 0.414019
+ 8.7900000 0.381578
+ 8.7902778 0.343826
+ 8.7905556 0.302705
+ 8.7908333 0.260155
+ 8.7911111 0.218118
+ 8.7913889 0.178535
+ 8.7916667 0.143347
+ 8.7919444 0.114174
+ 8.7922222 0.091350
+ 8.7925000 0.074886
+ 8.7927778 0.064796
+ 8.7930556 0.061091
+ 8.7933333 0.063784
+ 8.7936111 0.072888
+ 8.7938889 0.088414
+ 8.7941667 0.110375
+ 8.7944444 0.138784
+ 8.7947222 0.173332
+ 8.7950000 0.212431
+ 8.7952778 0.254174
+ 8.7955556 0.296650
+ 8.7958333 0.337953
+ 8.7961111 0.376174
+ 8.7963889 0.409403
+ 8.7966667 0.435734
+ 8.7969444 0.453258
+ 8.7972222 0.460065
+ 8.7975000 0.454880
+ 8.7977778 0.438949
+ 8.7980556 0.414150
+ 8.7983333 0.382361
+ 8.7986111 0.345462
+ 8.7988889 0.305330
+ 8.7991667 0.263844
+ 8.7994444 0.222882
+ 8.7997222 0.184321
+ 8.8000000 0.150042
+ 8.8002778 0.121610
+ 8.8005556 0.099354
+ 8.8008333 0.083288
+ 8.8011111 0.073429
+ 8.8013889 0.069792
+ 8.8016667 0.072394
+ 8.8019444 0.081250
+ 8.8022222 0.096376
+ 8.8025000 0.117789
+ 8.8027778 0.145505
+ 8.8030556 0.179225
+ 8.8033333 0.217404
+ 8.8036111 0.258181
+ 8.8038889 0.299695
+ 8.8041667 0.340087
+ 8.8044444 0.377496
+ 8.8047222 0.410063
+ 8.8050000 0.435927
+ 8.8052778 0.453227
+ 8.8055556 0.460105
+ 8.8058333 0.455306
+ 8.8061111 0.440005
+ 8.8063889 0.415985
+ 8.8066667 0.385028
+ 8.8069444 0.348915
+ 8.8072222 0.309429
+ 8.8075000 0.268351
+ 8.8077778 0.227464
+ 8.8080556 0.188549
+ 8.8083333 0.153389
+ 8.8086111 0.123494
+ 8.8088889 0.099288
+ 8.8091667 0.080923
+ 8.8094444 0.068554
+ 8.8097222 0.062332
+ 8.8100000 0.062411
+ 8.8102778 0.068942
+ 8.8105556 0.082079
+ 8.8108333 0.101975
+ 8.8111111 0.128782
+ 8.8113889 0.162302
+ 8.8116667 0.200936
+ 8.8119444 0.242733
+ 8.8122222 0.285744
+ 8.8125000 0.328017
+ 8.8127778 0.367603
+ 8.8130556 0.402551
+ 8.8133333 0.430911
+ 8.8136111 0.450732
+ 8.8138889 0.460065
+ 8.8141667 0.457575
+ 8.8144444 0.444392
+ 8.8147222 0.422260
+ 8.8150000 0.392927
+ 8.8152778 0.358137
+ 8.8155556 0.319635
+ 8.8158333 0.279168
+ 8.8161111 0.238482
+ 8.8163889 0.199320
+ 8.8166667 0.163431
+ 8.8169444 0.132311
+ 8.8172222 0.106476
+ 8.8175000 0.086192
+ 8.8177778 0.071728
+ 8.8180556 0.063349
+ 8.8183333 0.061325
+ 8.8186111 0.065922
+ 8.8188889 0.077407
+ 8.8191667 0.096048
+ 8.8194444 0.122113
+ 8.8197222 0.155479
+ 8.8200000 0.194464
+ 8.8202778 0.236995
+ 8.8205556 0.281002
+ 8.8208333 0.324413
+ 8.8211111 0.365154
+ 8.8213889 0.401156
+ 8.8216667 0.430345
+ 8.8219444 0.450651
+ 8.8222222 0.460000
+ 8.8225000 0.456987
+ 8.8227778 0.442863
+ 8.8230556 0.419548
+ 8.8233333 0.388960
+ 8.8236111 0.353015
+ 8.8238889 0.313632
+ 8.8241667 0.272730
+ 8.8244444 0.232226
+ 8.8247222 0.194038
+ 8.8250000 0.160083
+ 8.8252778 0.131961
+ 8.8255556 0.109991
+ 8.8258333 0.094170
+ 8.8261111 0.084499
+ 8.8263889 0.080976
+ 8.8266667 0.083601
+ 8.8269444 0.092373
+ 8.8272222 0.107290
+ 8.8275000 0.128353
+ 8.8277778 0.155559
+ 8.8280556 0.188604
+ 8.8283333 0.225959
+ 8.8286111 0.265792
+ 8.8288889 0.306271
+ 8.8291667 0.345563
+ 8.8294444 0.381835
+ 8.8297222 0.413255
+ 8.8300000 0.437991
+ 8.8302778 0.454210
+ 8.8305556 0.460078
+ 8.8308333 0.454359
+ 8.8311111 0.438186
+ 8.8313889 0.413289
+ 8.8316667 0.381398
+ 8.8319444 0.344241
+ 8.8322222 0.303549
+ 8.8325000 0.261049
+ 8.8327778 0.218471
+ 8.8330556 0.177545
+ 8.8333333 0.140000
+ 8.8336111 0.107329
+ 8.8338889 0.080083
+ 8.8341667 0.058577
+ 8.8344444 0.050000
+ 8.8347222 0.050000
+ 8.8350000 0.050000
+ 8.8352778 0.050000
+ 8.8355556 0.050000
+ 8.8358333 0.067732
+ 8.8361111 0.095231
+ 8.8363889 0.130574
+ 8.8366667 0.171994
+ 8.8369444 0.217304
+ 8.8372222 0.264321
+ 8.8375000 0.310858
+ 8.8377778 0.354732
+ 8.8380556 0.393756
+ 8.8383333 0.425746
+ 8.8386111 0.448516
+ 8.8388889 0.459882
+ 8.8391667 0.458330
+ 8.8394444 0.445029
+ 8.8397222 0.421822
+ 8.8400000 0.390549
+ 8.8402778 0.353052
+ 8.8405556 0.311173
+ 8.8408333 0.266751
+ 8.8411111 0.221630
+ 8.8413889 0.177650
+ 8.8416667 0.136653
+ 8.8419444 0.100249
+ 8.8422222 0.069126
+ 8.8425000 0.050000
+ 8.8427778 0.050000
+ 8.8430556 0.050000
+ 8.8433333 0.050000
+ 8.8436111 0.050000
+ 8.8438889 0.050000
+ 8.8441667 0.050000
+ 8.8444444 0.065119
+ 8.8447222 0.101624
+ 8.8450000 0.145142
+ 8.8452778 0.193289
+ 8.8455556 0.243683
+ 8.8458333 0.293940
+ 8.8461111 0.341678
+ 8.8463889 0.384514
+ 8.8466667 0.420064
+ 8.8469444 0.445947
+ 8.8472222 0.459778
+ 8.8475000 0.459897
+ 8.8477778 0.447533
+ 8.8480556 0.424636
+ 8.8483333 0.393157
+ 8.8486111 0.355048
+ 8.8488889 0.312257
+ 8.8491667 0.266737
+ 8.8494444 0.220438
+ 8.8497222 0.175311
+ 8.8500000 0.133306
+ 8.8502778 0.096121
+ 8.8505556 0.064447
+ 8.8508333 0.050000
+ 8.8511111 0.050000
+ 8.8513889 0.050000
+ 8.8516667 0.050000
+ 8.8519444 0.050000
+ 8.8522222 0.050000
+ 8.8525000 0.050000
+ 8.8527778 0.061772
+ 8.8530556 0.098850
+ 8.8533333 0.142957
+ 8.8536111 0.191684
+ 8.8538889 0.242622
+ 8.8541667 0.293361
+ 8.8544444 0.341492
+ 8.8547222 0.384608
+ 8.8550000 0.420298
+ 8.8552778 0.446153
+ 8.8555556 0.459765
+ 8.8558333 0.459458
+ 8.8561111 0.446494
+ 8.8563889 0.422869
+ 8.8566667 0.390579
+ 8.8569444 0.351618
+ 8.8572222 0.307983
+ 8.8575000 0.261669
+ 8.8577778 0.214672
+ 8.8580556 0.168988
+ 8.8583333 0.126611
+ 8.8586111 0.089273
+ 8.8588889 0.057641
+ 8.8591667 0.050000
+ 8.8594444 0.050000
+ 8.8597222 0.050000
+ 8.8600000 0.050000
+ 8.8602778 0.050000
+ 8.8605556 0.050000
+ 8.8608333 0.050000
+ 8.8611111 0.058359
+ 8.8613889 0.095749
+ 8.8616667 0.140093
+ 8.8619444 0.189011
+ 8.8622222 0.240127
+ 8.8625000 0.291061
+ 8.8627778 0.339435
+ 8.8630556 0.382870
+ 8.8633333 0.418990
+ 8.8636111 0.445414
+ 8.8638889 0.459765
+ 8.8641667 0.460381
+ 8.8644444 0.448472
+ 8.8647222 0.425961
+ 8.8650000 0.394776
+ 8.8652778 0.356840
+ 8.8655556 0.314080
+ 8.8658333 0.268421
+ 8.8661111 0.221789
+ 8.8663889 0.176109
+ 8.8666667 0.133306
+ 8.8669444 0.095070
+ 8.8672222 0.062150
+ 8.8675000 0.050000
+ 8.8677778 0.050000
+ 8.8680556 0.050000
+ 8.8683333 0.050000
+ 8.8686111 0.050000
+ 8.8688889 0.050000
+ 8.8691667 0.050000
+ 8.8694444 0.051665
+ 8.8697222 0.089150
+ 8.8700000 0.134058
+ 8.8702778 0.183882
+ 8.8705556 0.236115
+ 8.8708333 0.288251
+ 8.8711111 0.337783
+ 8.8713889 0.382204
+ 8.8716667 0.419008
+ 8.8719444 0.445689
+ 8.8722222 0.459738
+ 8.8725000 0.459417
+ 8.8727778 0.446047
+ 8.8730556 0.421716
+ 8.8733333 0.388512
+ 8.8736111 0.348525
+ 8.8738889 0.303842
+ 8.8741667 0.256551
+ 8.8744444 0.208741
+ 8.8747222 0.162500
+ 8.8750000 0.119917
+ 8.8752778 0.082786
+ 8.8755556 0.051731
+ 8.8758333 0.050000
+ 8.8761111 0.050000
+ 8.8763889 0.050000
+ 8.8766667 0.050000
+ 8.8769444 0.050000
+ 8.8772222 0.050000
+ 8.8775000 0.050000
+ 8.8777778 0.061719
+ 8.8780556 0.099783
+ 8.8783333 0.144535
+ 8.8786111 0.193613
+ 8.8788889 0.244654
+ 8.8791667 0.295295
+ 8.8794444 0.343172
+ 8.8797222 0.385922
+ 8.8800000 0.421181
+ 8.8802778 0.446588
+ 8.8805556 0.459778
+ 8.8808333 0.459111
+ 8.8811111 0.445842
+ 8.8813889 0.421948
+ 8.8816667 0.389405
+ 8.8819444 0.350192
+ 8.8822222 0.306285
+ 8.8825000 0.259661
+ 8.8827778 0.212298
+ 8.8830556 0.166174
+ 8.8833333 0.123264
+ 8.8836111 0.085291
+ 8.8838889 0.052951
+ 8.8841667 0.050000
+ 8.8844444 0.050000
+ 8.8847222 0.050000
+ 8.8850000 0.050000
+ 8.8852778 0.050000
+ 8.8855556 0.050000
+ 8.8858333 0.050000
+ 8.8861111 0.050000
+ 8.8863889 0.087743
+ 8.8866667 0.132668
+ 8.8869444 0.182350
+ 8.8872222 0.234366
+ 8.8875000 0.286292
+ 8.8877778 0.335704
+ 8.8880556 0.380179
+ 8.8883333 0.417292
+ 8.8886111 0.444620
+ 8.8888889 0.459738
+ 8.8891667 0.460952
+ 8.8894444 0.449471
+ 8.8897222 0.427235
+ 8.8900000 0.396183
+ 8.8902778 0.358254
+ 8.8905556 0.315386
+ 8.8908333 0.269518
+ 8.8911111 0.222590
+ 8.8913889 0.176539
+ 8.8916667 0.133306
+ 8.8919444 0.094595
+ 8.8922222 0.061184
+ 8.8925000 0.050000
+ 8.8927778 0.050000
+ 8.8930556 0.050000
+ 8.8933333 0.050000
+ 8.8936111 0.050000
+ 8.8938889 0.050000
+ 8.8941667 0.050000
+ 8.8944444 0.050000
+ 8.8947222 0.088251
+ 8.8950000 0.134083
+ 8.8952778 0.184880
+ 8.8955556 0.238026
+ 8.8958333 0.290903
+ 8.8961111 0.340897
+ 8.8963889 0.385389
+ 8.8966667 0.421765
+ 8.8969444 0.447407
+ 8.8972222 0.459699
+ 8.8975000 0.456852
+ 8.8977778 0.440385
+ 8.8980556 0.412643
+ 8.8983333 0.375973
+ 8.8986111 0.332721
+ 8.8988889 0.285232
+ 8.8991667 0.235853
+ 8.8994444 0.186930
+ 8.8997222 0.140808
+ 8.9000000 0.099833
+ 8.9002778 0.065913
+ 8.9005556 0.050000
+ 8.9008333 0.050000
+ 8.9011111 0.050000
+ 8.9013889 0.050000
+ 8.9016667 0.050000
+ 8.9019444 0.050000
+ 8.9022222 0.050000
+ 8.9025000 0.050000
+ 8.9027778 0.050000
+ 8.9030556 0.075068
+ 8.9033333 0.104440
+ 8.9036111 0.137826
+ 8.9038889 0.174937
+ 8.9041667 0.215481
+ 8.9044444 0.259170
+ 8.9047222 0.305713
+ 8.9050000 0.354820
+ 8.9052778 0.406202
+ 8.9055556 0.459569
+ )
Vecg_l1 ecg_amp_l1 0 PWL(
+ 0.0000000 0.459752
+ 0.0002778 0.450778
+ 0.0005556 0.434912
+ 0.0008333 0.413101
+ 0.0011111 0.386290
+ 0.0013889 0.355426
+ 0.0016667 0.321458
+ 0.0019444 0.285330
+ 0.0022222 0.247990
+ 0.0025000 0.210385
+ 0.0027778 0.173462
+ 0.0030556 0.138167
+ 0.0033333 0.105447
+ 0.0036111 0.076248
+ 0.0038889 0.051519
+ 0.0041667 0.050000
+ 0.0044444 0.050000
+ 0.0047222 0.050000
+ 0.0050000 0.050000
+ 0.0052778 0.050000
+ 0.0055556 0.050000
+ 0.0058333 0.082484
+ 0.0061111 0.123551
+ 0.0063889 0.170690
+ 0.0066667 0.221389
+ 0.0069444 0.273136
+ 0.0072222 0.323418
+ 0.0075000 0.369723
+ 0.0077778 0.409540
+ 0.0080556 0.440357
+ 0.0083333 0.459660
+ 0.0086111 0.465645
+ 0.0088889 0.459333
+ 0.0091667 0.442452
+ 0.0094444 0.416728
+ 0.0097222 0.383891
+ 0.0100000 0.345667
+ 0.0102778 0.303784
+ 0.0105556 0.259971
+ 0.0108333 0.215954
+ 0.0111111 0.173462
+ 0.0113889 0.134059
+ 0.0116667 0.098662
+ 0.0119444 0.068022
+ 0.0122222 0.050000
+ 0.0125000 0.050000
+ 0.0127778 0.050000
+ 0.0130556 0.050000
+ 0.0133333 0.050000
+ 0.0136111 0.050000
+ 0.0138889 0.050000
+ 0.0141667 0.083980
+ 0.0144444 0.126224
+ 0.0147222 0.174216
+ 0.0150000 0.225439
+ 0.0152778 0.277376
+ 0.0155556 0.327513
+ 0.0158333 0.373331
+ 0.0161111 0.412314
+ 0.0163889 0.441947
+ 0.0166667 0.459712
+ 0.0169444 0.463820
+ 0.0172222 0.455381
+ 0.0175000 0.436233
+ 0.0177778 0.408215
+ 0.0180556 0.373164
+ 0.0183333 0.332916
+ 0.0186111 0.289311
+ 0.0188889 0.244186
+ 0.0191667 0.199378
+ 0.0194444 0.156724
+ 0.0197222 0.117861
+ 0.0200000 0.083609
+ 0.0202778 0.054590
+ 0.0205556 0.050000
+ 0.0208333 0.050000
+ 0.0211111 0.050000
+ 0.0213889 0.050000
+ 0.0216667 0.050000
+ 0.0219444 0.050000
+ 0.0222222 0.050000
+ 0.0225000 0.084642
+ 0.0227778 0.127078
+ 0.0230556 0.174913
+ 0.0233333 0.225751
+ 0.0236111 0.277197
+ 0.0238889 0.326856
+ 0.0241667 0.372332
+ 0.0244444 0.411231
+ 0.0247222 0.441156
+ 0.0250000 0.459712
+ 0.0252778 0.465189
+ 0.0255556 0.458608
+ 0.0258333 0.441679
+ 0.0261111 0.416107
+ 0.0263889 0.383601
+ 0.0266667 0.345868
+ 0.0269444 0.304615
+ 0.0272222 0.261549
+ 0.0275000 0.218378
+ 0.0277778 0.176809
+ 0.0280556 0.138384
+ 0.0283333 0.103977
+ 0.0286111 0.074298
+ 0.0288889 0.050057
+ 0.0291667 0.050000
+ 0.0294444 0.050000
+ 0.0297222 0.050000
+ 0.0300000 0.050000
+ 0.0302778 0.050000
+ 0.0305556 0.058509
+ 0.0308333 0.091667
+ 0.0311111 0.132812
+ 0.0313889 0.179530
+ 0.0316667 0.229405
+ 0.0319444 0.280023
+ 0.0322222 0.328970
+ 0.0325000 0.373829
+ 0.0327778 0.412187
+ 0.0330556 0.441628
+ 0.0333333 0.459738
+ 0.0336111 0.464790
+ 0.0338889 0.457803
+ 0.0341667 0.440486
+ 0.0344444 0.414546
+ 0.0347222 0.381691
+ 0.0350000 0.343629
+ 0.0352778 0.302067
+ 0.0355556 0.258713
+ 0.0358333 0.215276
+ 0.0361111 0.173462
+ 0.0363889 0.134814
+ 0.0366667 0.100215
+ 0.0369444 0.070382
+ 0.0372222 0.050000
+ 0.0375000 0.050000
+ 0.0377778 0.050000
+ 0.0380556 0.050000
+ 0.0383333 0.050000
+ 0.0386111 0.050000
+ 0.0388889 0.055214
+ 0.0391667 0.088791
+ 0.0394444 0.130423
+ 0.0397222 0.177662
+ 0.0400000 0.228062
+ 0.0402778 0.279176
+ 0.0405556 0.328556
+ 0.0408333 0.373756
+ 0.0411111 0.412329
+ 0.0413889 0.441827
+ 0.0416667 0.459804
+ 0.0419444 0.464511
+ 0.0422222 0.456998
+ 0.0425000 0.439014
+ 0.0427778 0.412305
+ 0.0430556 0.378622
+ 0.0433333 0.339711
+ 0.0436111 0.297322
+ 0.0438889 0.253203
+ 0.0441667 0.209102
+ 0.0444444 0.166767
+ 0.0447222 0.127772
+ 0.0450000 0.092988
+ 0.0452778 0.063114
+ 0.0455556 0.050000
+ 0.0458333 0.050000
+ 0.0461111 0.050000
+ 0.0463889 0.050000
+ 0.0466667 0.050000
+ 0.0469444 0.050000
+ 0.0472222 0.050000
+ 0.0475000 0.083971
+ 0.0477778 0.125992
+ 0.0480556 0.173629
+ 0.0483333 0.224445
+ 0.0486111 0.276006
+ 0.0488889 0.325876
+ 0.0491667 0.371619
+ 0.0494444 0.410801
+ 0.0497222 0.440986
+ 0.0500000 0.459738
+ 0.0502778 0.465314
+ 0.0505556 0.458731
+ 0.0508333 0.441698
+ 0.0511111 0.415926
+ 0.0513889 0.383122
+ 0.0516667 0.344997
+ 0.0519444 0.303259
+ 0.0522222 0.259618
+ 0.0525000 0.215782
+ 0.0527778 0.173462
+ 0.0530556 0.134206
+ 0.0533333 0.098926
+ 0.0536111 0.068374
+ 0.0538889 0.050000
+ 0.0541667 0.050000
+ 0.0544444 0.050000
+ 0.0547222 0.050000
+ 0.0550000 0.050000
+ 0.0552778 0.050000
+ 0.0555556 0.050000
+ 0.0558333 0.083781
+ 0.0561111 0.125807
+ 0.0563889 0.173587
+ 0.0566667 0.224626
+ 0.0569444 0.276430
+ 0.0572222 0.326508
+ 0.0575000 0.372364
+ 0.0577778 0.411506
+ 0.0580556 0.441440
+ 0.0583333 0.459673
+ 0.0586111 0.464425
+ 0.0588889 0.456770
+ 0.0591667 0.438496
+ 0.0594444 0.411391
+ 0.0597222 0.377242
+ 0.0600000 0.337838
+ 0.0602778 0.294966
+ 0.0605556 0.250413
+ 0.0608333 0.205969
+ 0.0611111 0.163419
+ 0.0613889 0.124368
+ 0.0616667 0.089674
+ 0.0619444 0.060014
+ 0.0622222 0.050000
+ 0.0625000 0.050000
+ 0.0627778 0.050000
+ 0.0630556 0.050000
+ 0.0633333 0.050000
+ 0.0636111 0.050000
+ 0.0638889 0.050000
+ 0.0641667 0.084378
+ 0.0644444 0.126741
+ 0.0647222 0.174646
+ 0.0650000 0.225646
+ 0.0652778 0.277296
+ 0.0655556 0.327150
+ 0.0658333 0.372763
+ 0.0661111 0.411689
+ 0.0663889 0.441483
+ 0.0666667 0.459699
+ 0.0669444 0.464592
+ 0.0672222 0.457215
+ 0.0675000 0.439319
+ 0.0677778 0.412658
+ 0.0680556 0.378985
+ 0.0683333 0.340051
+ 0.0686111 0.297610
+ 0.0688889 0.253414
+ 0.0691667 0.209215
+ 0.0694444 0.166767
+ 0.0697222 0.127647
+ 0.0700000 0.092739
+ 0.0702778 0.062748
+ 0.0705556 0.050000
+ 0.0708333 0.050000
+ 0.0711111 0.050000
+ 0.0713889 0.050000
+ 0.0716667 0.050000
+ 0.0719444 0.050000
+ 0.0722222 0.050000
+ 0.0725000 0.084311
+ 0.0727778 0.126721
+ 0.0730556 0.174749
+ 0.0733333 0.225913
+ 0.0736111 0.277730
+ 0.0738889 0.327719
+ 0.0741667 0.373398
+ 0.0744444 0.412284
+ 0.0747222 0.441896
+ 0.0750000 0.459752
+ 0.0752778 0.464083
+ 0.0755556 0.455981
+ 0.0758333 0.437249
+ 0.0761111 0.409692
+ 0.0763889 0.375115
+ 0.0766667 0.335321
+ 0.0769444 0.292115
+ 0.0772222 0.247302
+ 0.0775000 0.202686
+ 0.0777778 0.160072
+ 0.0780556 0.121072
+ 0.0783333 0.086537
+ 0.0786111 0.057125
+ 0.0788889 0.050000
+ 0.0791667 0.050000
+ 0.0794444 0.050000
+ 0.0797222 0.050000
+ 0.0800000 0.050000
+ 0.0802778 0.050000
+ 0.0805556 0.050000
+ 0.0808333 0.084759
+ 0.0811111 0.127452
+ 0.0813889 0.175622
+ 0.0816667 0.226810
+ 0.0819444 0.278559
+ 0.0822222 0.328412
+ 0.0825000 0.373911
+ 0.0827778 0.412599
+ 0.0830556 0.442019
+ 0.0833333 0.459712
+ 0.0836111 0.463934
+ 0.0838889 0.455790
+ 0.0841667 0.437095
+ 0.0844444 0.409666
+ 0.0847222 0.375320
+ 0.0850000 0.335874
+ 0.0852778 0.293144
+ 0.0855556 0.248947
+ 0.0858333 0.205100
+ 0.0861111 0.163419
+ 0.0863889 0.125518
+ 0.0866667 0.092195
+ 0.0869444 0.064045
+ 0.0872222 0.050000
+ 0.0875000 0.050000
+ 0.0877778 0.050000
+ 0.0880556 0.050000
+ 0.0883333 0.050000
+ 0.0886111 0.050000
+ 0.0888889 0.061870
+ 0.0891667 0.096048
+ 0.0894444 0.137793
+ 0.0897222 0.184734
+ 0.0900000 0.234503
+ 0.0902778 0.284729
+ 0.0905556 0.333042
+ 0.0908333 0.377074
+ 0.0911111 0.414453
+ 0.0913889 0.442811
+ 0.0916667 0.459778
+ 0.0919444 0.463668
+ 0.0922222 0.455539
+ 0.0925000 0.437131
+ 0.0927778 0.410187
+ 0.0930556 0.376447
+ 0.0933333 0.337653
+ 0.0936111 0.295546
+ 0.0938889 0.251869
+ 0.0941667 0.208362
+ 0.0944444 0.166767
+ 0.0947222 0.128645
+ 0.0950000 0.094833
+ 0.0952778 0.065991
+ 0.0955556 0.050000
+ 0.0958333 0.050000
+ 0.0961111 0.050000
+ 0.0963889 0.050000
+ 0.0966667 0.050000
+ 0.0969444 0.050000
+ 0.0972222 0.058496
+ 0.0975000 0.092578
+ 0.0977778 0.134467
+ 0.0980556 0.181741
+ 0.0983333 0.231974
+ 0.0986111 0.282742
+ 0.0988889 0.331622
+ 0.0991667 0.376188
+ 0.0994444 0.414016
+ 0.0997222 0.442683
+ 0.1000000 0.459765
+ 0.1002778 0.463536
+ 0.1005556 0.455073
+ 0.1008333 0.436152
+ 0.1011111 0.408549
+ 0.1013889 0.374040
+ 0.1016667 0.334401
+ 0.1019444 0.291409
+ 0.1022222 0.246840
+ 0.1025000 0.202468
+ 0.1027778 0.160072
+ 0.1030556 0.121241
+ 0.1033333 0.086824
+ 0.1036111 0.057484
+ 0.1038889 0.050000
+ 0.1041667 0.050000
+ 0.1044444 0.050000
+ 0.1047222 0.050000
+ 0.1050000 0.050000
+ 0.1052778 0.050000
+ 0.1055556 0.050000
+ 0.1058333 0.084643
+ 0.1061111 0.127222
+ 0.1063889 0.175289
+ 0.1066667 0.226394
+ 0.1069444 0.278089
+ 0.1072222 0.327925
+ 0.1075000 0.373454
+ 0.1077778 0.412228
+ 0.1080556 0.441797
+ 0.1083333 0.459712
+ 0.1086111 0.464231
+ 0.1088889 0.456423
+ 0.1091667 0.438067
+ 0.1094444 0.410938
+ 0.1097222 0.376814
+ 0.1100000 0.337469
+ 0.1102778 0.294681
+ 0.1105556 0.250225
+ 0.1108333 0.205880
+ 0.1111111 0.163419
+ 0.1113889 0.124440
+ 0.1116667 0.089810
+ 0.1119444 0.060216
+ 0.1122222 0.050000
+ 0.1125000 0.050000
+ 0.1127778 0.050000
+ 0.1130556 0.050000
+ 0.1133333 0.050000
+ 0.1136111 0.050000
+ 0.1138889 0.051814
+ 0.1141667 0.086721
+ 0.1144444 0.129645
+ 0.1147222 0.178071
+ 0.1150000 0.229483
+ 0.1152778 0.281365
+ 0.1155556 0.331199
+ 0.1158333 0.376470
+ 0.1161111 0.414661
+ 0.1163889 0.443256
+ 0.1166667 0.459738
+ 0.1169444 0.462331
+ 0.1172222 0.452210
+ 0.1175000 0.431290
+ 0.1177778 0.401486
+ 0.1180556 0.364713
+ 0.1183333 0.322886
+ 0.1186111 0.277919
+ 0.1188889 0.231729
+ 0.1191667 0.186229
+ 0.1194444 0.143334
+ 0.1197222 0.104732
+ 0.1200000 0.071190
+ 0.1202778 0.050000
+ 0.1205556 0.050000
+ 0.1208333 0.050000
+ 0.1211111 0.050000
+ 0.1213889 0.050000
+ 0.1216667 0.050000
+ 0.1219444 0.050000
+ 0.1222222 0.050000
+ 0.1225000 0.085869
+ 0.1227778 0.129270
+ 0.1230556 0.177805
+ 0.1233333 0.229073
+ 0.1236111 0.280677
+ 0.1238889 0.330217
+ 0.1241667 0.375295
+ 0.1244444 0.413511
+ 0.1247222 0.442467
+ 0.1250000 0.459765
+ 0.1252778 0.463700
+ 0.1255556 0.455357
+ 0.1258333 0.436514
+ 0.1261111 0.408951
+ 0.1263889 0.374446
+ 0.1266667 0.334779
+ 0.1269444 0.291729
+ 0.1272222 0.247075
+ 0.1275000 0.202596
+ 0.1277778 0.160072
+ 0.1280556 0.121097
+ 0.1283333 0.086533
+ 0.1286111 0.057056
+ 0.1288889 0.050000
+ 0.1291667 0.050000
+ 0.1294444 0.050000
+ 0.1297222 0.050000
+ 0.1300000 0.050000
+ 0.1302778 0.050000
+ 0.1305556 0.050000
+ 0.1308333 0.085052
+ 0.1311111 0.128100
+ 0.1313889 0.176639
+ 0.1316667 0.228163
+ 0.1319444 0.280167
+ 0.1322222 0.330145
+ 0.1325000 0.375593
+ 0.1327778 0.414005
+ 0.1330556 0.442875
+ 0.1333333 0.459699
+ 0.1336111 0.462704
+ 0.1338889 0.453046
+ 0.1341667 0.432616
+ 0.1344444 0.403302
+ 0.1347222 0.366994
+ 0.1350000 0.325582
+ 0.1352778 0.280955
+ 0.1355556 0.235004
+ 0.1358333 0.189616
+ 0.1361111 0.146682
+ 0.1363889 0.107873
+ 0.1366667 0.073990
+ 0.1369444 0.050000
+ 0.1372222 0.050000
+ 0.1375000 0.050000
+ 0.1377778 0.050000
+ 0.1380556 0.050000
+ 0.1383333 0.050000
+ 0.1386111 0.050000
+ 0.1388889 0.050000
+ 0.1391667 0.086100
+ 0.1394444 0.129884
+ 0.1397222 0.178876
+ 0.1400000 0.230602
+ 0.1402778 0.282586
+ 0.1405556 0.332354
+ 0.1408333 0.377429
+ 0.1411111 0.415337
+ 0.1413889 0.443603
+ 0.1416667 0.459752
+ 0.1419444 0.462041
+ 0.1422222 0.451661
+ 0.1425000 0.430535
+ 0.1427778 0.400587
+ 0.1430556 0.363740
+ 0.1433333 0.321917
+ 0.1436111 0.277041
+ 0.1438889 0.231037
+ 0.1441667 0.185827
+ 0.1444444 0.143334
+ 0.1447222 0.105247
+ 0.1450000 0.072308
+ 0.1452778 0.050000
+ 0.1455556 0.050000
+ 0.1458333 0.050000
+ 0.1461111 0.050000
+ 0.1463889 0.050000
+ 0.1466667 0.050000
+ 0.1469444 0.050000
+ 0.1472222 0.055070
+ 0.1475000 0.090836
+ 0.1477778 0.133954
+ 0.1480556 0.182059
+ 0.1483333 0.232788
+ 0.1486111 0.283774
+ 0.1488889 0.332652
+ 0.1491667 0.377058
+ 0.1494444 0.414626
+ 0.1497222 0.442992
+ 0.1500000 0.459791
+ 0.1502778 0.463346
+ 0.1505556 0.454736
+ 0.1508333 0.435729
+ 0.1511111 0.408093
+ 0.1513889 0.373597
+ 0.1516667 0.334007
+ 0.1519444 0.291091
+ 0.1522222 0.246619
+ 0.1525000 0.202356
+ 0.1527778 0.160072
+ 0.1530556 0.121351
+ 0.1533333 0.087044
+ 0.1536111 0.057820
+ 0.1538889 0.050000
+ 0.1541667 0.050000
+ 0.1544444 0.050000
+ 0.1547222 0.050000
+ 0.1550000 0.050000
+ 0.1552778 0.050000
+ 0.1555556 0.051710
+ 0.1558333 0.086682
+ 0.1561111 0.129592
+ 0.1563889 0.177950
+ 0.1566667 0.229265
+ 0.1569444 0.281045
+ 0.1572222 0.330799
+ 0.1575000 0.376036
+ 0.1577778 0.414266
+ 0.1580556 0.442997
+ 0.1583333 0.459738
+ 0.1586111 0.462729
+ 0.1588889 0.453130
+ 0.1591667 0.432832
+ 0.1594444 0.403727
+ 0.1597222 0.367704
+ 0.1600000 0.326657
+ 0.1602778 0.282474
+ 0.1605556 0.237048
+ 0.1608333 0.192269
+ 0.1611111 0.150029
+ 0.1613889 0.111994
+ 0.1616667 0.078931
+ 0.1619444 0.051381
+ 0.1622222 0.050000
+ 0.1625000 0.050000
+ 0.1627778 0.050000
+ 0.1630556 0.050000
+ 0.1633333 0.050000
+ 0.1636111 0.050000
+ 0.1638889 0.058457
+ 0.1641667 0.094042
+ 0.1644444 0.137066
+ 0.1647222 0.185119
+ 0.1650000 0.235789
+ 0.1652778 0.286666
+ 0.1655556 0.335338
+ 0.1658333 0.379393
+ 0.1661111 0.416421
+ 0.1663889 0.444011
+ 0.1666667 0.459752
+ 0.1669444 0.461943
+ 0.1672222 0.451733
+ 0.1675000 0.430980
+ 0.1677778 0.401544
+ 0.1680556 0.365284
+ 0.1683333 0.324058
+ 0.1686111 0.279726
+ 0.1688889 0.234146
+ 0.1691667 0.189179
+ 0.1694444 0.146682
+ 0.1697222 0.108300
+ 0.1700000 0.074818
+ 0.1702778 0.050000
+ 0.1705556 0.050000
+ 0.1708333 0.050000
+ 0.1711111 0.050000
+ 0.1713889 0.050000
+ 0.1716667 0.050000
+ 0.1719444 0.050000
+ 0.1722222 0.051736
+ 0.1725000 0.087495
+ 0.1727778 0.130852
+ 0.1730556 0.179379
+ 0.1733333 0.230646
+ 0.1736111 0.282224
+ 0.1738889 0.331682
+ 0.1741667 0.376593
+ 0.1744444 0.414525
+ 0.1747222 0.443050
+ 0.1750000 0.459738
+ 0.1752778 0.462876
+ 0.1755556 0.453612
+ 0.1758333 0.433810
+ 0.1761111 0.405334
+ 0.1763889 0.370049
+ 0.1766667 0.329818
+ 0.1769444 0.286506
+ 0.1772222 0.241977
+ 0.1775000 0.198095
+ 0.1777778 0.156724
+ 0.1780556 0.119506
+ 0.1783333 0.087191
+ 0.1786111 0.060307
+ 0.1788889 0.050000
+ 0.1791667 0.050000
+ 0.1794444 0.050000
+ 0.1797222 0.050000
+ 0.1800000 0.050000
+ 0.1802778 0.050000
+ 0.1805556 0.068500
+ 0.1808333 0.103571
+ 0.1811111 0.145909
+ 0.1813889 0.193125
+ 0.1816667 0.242835
+ 0.1819444 0.292652
+ 0.1822222 0.340189
+ 0.1825000 0.383061
+ 0.1827778 0.418880
+ 0.1830556 0.445261
+ 0.1833333 0.459817
+ 0.1836111 0.460882
+ 0.1838889 0.449669
+ 0.1841667 0.428113
+ 0.1844444 0.398147
+ 0.1847222 0.361705
+ 0.1850000 0.320720
+ 0.1852778 0.277126
+ 0.1855556 0.232857
+ 0.1858333 0.189847
+ 0.1861111 0.150029
+ 0.1863889 0.115073
+ 0.1866667 0.085592
+ 0.1869444 0.061933
+ 0.1872222 0.050000
+ 0.1875000 0.050000
+ 0.1877778 0.050000
+ 0.1880556 0.050000
+ 0.1883333 0.050000
+ 0.1886111 0.061759
+ 0.1888889 0.088611
+ 0.1891667 0.123643
+ 0.1894444 0.165064
+ 0.1897222 0.210652
+ 0.1900000 0.258186
+ 0.1902778 0.305446
+ 0.1905556 0.350209
+ 0.1908333 0.390255
+ 0.1911111 0.423363
+ 0.1913889 0.447313
+ 0.1916667 0.459882
+ 0.1919444 0.459533
+ 0.1922222 0.447456
+ 0.1925000 0.425524
+ 0.1927778 0.395609
+ 0.1930556 0.359585
+ 0.1933333 0.319325
+ 0.1936111 0.276701
+ 0.1938889 0.233586
+ 0.1941667 0.191854
+ 0.1944444 0.153377
+ 0.1947222 0.119767
+ 0.1950000 0.091592
+ 0.1952778 0.069158
+ 0.1955556 0.052773
+ 0.1958333 0.050000
+ 0.1961111 0.050000
+ 0.1963889 0.050000
+ 0.1966667 0.053856
+ 0.1969444 0.072316
+ 0.1972222 0.098666
+ 0.1975000 0.132809
+ 0.1977778 0.173033
+ 0.1980556 0.217223
+ 0.1983333 0.263265
+ 0.1986111 0.309044
+ 0.1988889 0.352444
+ 0.1991667 0.391350
+ 0.1994444 0.423649
+ 0.1997222 0.447224
+ 0.2000000 0.459961
+ 0.2002778 0.460392
+ 0.2005556 0.449640
+ 0.2008333 0.429476
+ 0.2011111 0.401669
+ 0.2013889 0.367989
+ 0.2016667 0.330207
+ 0.2019444 0.290093
+ 0.2022222 0.249418
+ 0.2025000 0.209951
+ 0.2027778 0.173462
+ 0.2030556 0.141479
+ 0.2033333 0.114556
+ 0.2036111 0.093006
+ 0.2038889 0.077140
+ 0.2041667 0.067270
+ 0.2044444 0.063707
+ 0.2047222 0.066763
+ 0.2050000 0.076750
+ 0.2052778 0.093980
+ 0.2055556 0.118764
+ 0.2058333 0.151024
+ 0.2061111 0.189118
+ 0.2063889 0.231013
+ 0.2066667 0.274677
+ 0.2069444 0.318078
+ 0.2072222 0.359184
+ 0.2075000 0.395961
+ 0.2077778 0.426377
+ 0.2080556 0.448401
+ 0.2083333 0.460000
+ 0.2086111 0.459762
+ 0.2088889 0.448763
+ 0.2091667 0.428697
+ 0.2094444 0.401260
+ 0.2097222 0.368148
+ 0.2100000 0.331057
+ 0.2102778 0.291682
+ 0.2105556 0.251718
+ 0.2108333 0.212862
+ 0.2111111 0.176809
+ 0.2113889 0.145030
+ 0.2116667 0.118098
+ 0.2119444 0.096360
+ 0.2122222 0.080163
+ 0.2125000 0.069857
+ 0.2127778 0.065788
+ 0.2130556 0.068304
+ 0.2133333 0.077753
+ 0.2136111 0.094484
+ 0.2138889 0.118843
+ 0.2141667 0.150780
+ 0.2144444 0.188650
+ 0.2147222 0.230410
+ 0.2150000 0.274016
+ 0.2152778 0.317425
+ 0.2155556 0.358594
+ 0.2158333 0.395480
+ 0.2161111 0.426038
+ 0.2163889 0.448226
+ 0.2166667 0.460000
+ 0.2169444 0.459935
+ 0.2172222 0.449078
+ 0.2175000 0.429093
+ 0.2177778 0.401645
+ 0.2180556 0.368398
+ 0.2183333 0.331019
+ 0.2186111 0.291171
+ 0.2188889 0.250519
+ 0.2191667 0.210728
+ 0.2194444 0.173462
+ 0.2197222 0.140183
+ 0.2200000 0.111535
+ 0.2202778 0.087961
+ 0.2205556 0.069901
+ 0.2208333 0.057797
+ 0.2211111 0.052091
+ 0.2213889 0.053223
+ 0.2216667 0.061635
+ 0.2219444 0.077769
+ 0.2222222 0.102066
+ 0.2225000 0.134536
+ 0.2227778 0.173465
+ 0.2230556 0.216708
+ 0.2233333 0.262119
+ 0.2236111 0.307552
+ 0.2238889 0.350863
+ 0.2241667 0.389906
+ 0.2244444 0.422536
+ 0.2247222 0.446607
+ 0.2250000 0.459974
+ 0.2252778 0.461132
+ 0.2255556 0.451138
+ 0.2258333 0.431690
+ 0.2261111 0.404486
+ 0.2263889 0.371224
+ 0.2266667 0.333601
+ 0.2269444 0.293316
+ 0.2272222 0.252066
+ 0.2275000 0.211548
+ 0.2277778 0.173462
+ 0.2280556 0.139299
+ 0.2283333 0.109737
+ 0.2286111 0.085244
+ 0.2288889 0.066293
+ 0.2291667 0.053355
+ 0.2294444 0.050000
+ 0.2297222 0.050000
+ 0.2300000 0.055323
+ 0.2302778 0.071144
+ 0.2305556 0.095332
+ 0.2308333 0.127917
+ 0.2311111 0.167164
+ 0.2313889 0.210897
+ 0.2316667 0.256940
+ 0.2319444 0.303117
+ 0.2322222 0.347251
+ 0.2325000 0.387167
+ 0.2327778 0.420689
+ 0.2330556 0.445639
+ 0.2333333 0.459843
+ 0.2336111 0.461772
+ 0.2338889 0.452490
+ 0.2341667 0.433711
+ 0.2344444 0.407146
+ 0.2347222 0.374508
+ 0.2350000 0.337509
+ 0.2352778 0.297862
+ 0.2355556 0.257279
+ 0.2358333 0.217473
+ 0.2361111 0.180157
+ 0.2363889 0.146830
+ 0.2366667 0.118147
+ 0.2369444 0.094547
+ 0.2372222 0.076473
+ 0.2375000 0.064366
+ 0.2377778 0.058667
+ 0.2380556 0.059817
+ 0.2383333 0.068257
+ 0.2386111 0.084429
+ 0.2388889 0.108774
+ 0.2391667 0.141294
+ 0.2394444 0.180237
+ 0.2397222 0.223411
+ 0.2400000 0.268623
+ 0.2402778 0.313683
+ 0.2405556 0.356399
+ 0.2408333 0.394579
+ 0.2411111 0.426032
+ 0.2413889 0.448565
+ 0.2416667 0.459987
+ 0.2419444 0.458776
+ 0.2422222 0.446084
+ 0.2425000 0.423737
+ 0.2427778 0.393555
+ 0.2430556 0.357361
+ 0.2433333 0.316980
+ 0.2436111 0.274233
+ 0.2438889 0.230944
+ 0.2441667 0.188935
+ 0.2444444 0.150029
+ 0.2447222 0.115806
+ 0.2450000 0.086867
+ 0.2452778 0.063570
+ 0.2455556 0.050000
+ 0.2458333 0.050000
+ 0.2461111 0.050000
+ 0.2463889 0.050000
+ 0.2466667 0.050000
+ 0.2469444 0.062369
+ 0.2472222 0.088611
+ 0.2475000 0.122944
+ 0.2477778 0.163636
+ 0.2480556 0.208536
+ 0.2483333 0.255490
+ 0.2486111 0.302347
+ 0.2488889 0.346956
+ 0.2491667 0.387165
+ 0.2494444 0.420821
+ 0.2497222 0.445773
+ 0.2500000 0.459869
+ 0.2502778 0.461591
+ 0.2505556 0.451951
+ 0.2508333 0.432597
+ 0.2511111 0.405175
+ 0.2513889 0.371331
+ 0.2516667 0.332712
+ 0.2519444 0.290965
+ 0.2522222 0.247736
+ 0.2525000 0.204672
+ 0.2527778 0.163419
+ 0.2530556 0.125467
+ 0.2533333 0.091673
+ 0.2536111 0.062739
+ 0.2538889 0.050000
+ 0.2541667 0.050000
+ 0.2544444 0.050000
+ 0.2547222 0.050000
+ 0.2550000 0.050000
+ 0.2552778 0.050000
+ 0.2555556 0.055136
+ 0.2558333 0.089774
+ 0.2561111 0.132377
+ 0.2563889 0.180442
+ 0.2566667 0.231469
+ 0.2569444 0.282955
+ 0.2572222 0.332398
+ 0.2575000 0.377297
+ 0.2577778 0.415151
+ 0.2580556 0.443456
+ 0.2583333 0.459712
+ 0.2586111 0.462152
+ 0.2588889 0.451943
+ 0.2591667 0.430990
+ 0.2594444 0.401195
+ 0.2597222 0.364462
+ 0.2600000 0.322693
+ 0.2602778 0.277793
+ 0.2605556 0.231665
+ 0.2608333 0.186211
+ 0.2611111 0.143334
+ 0.2613889 0.104714
+ 0.2616667 0.071128
+ 0.2619444 0.050000
+ 0.2622222 0.050000
+ 0.2625000 0.050000
+ 0.2627778 0.050000
+ 0.2630556 0.050000
+ 0.2633333 0.050000
+ 0.2636111 0.050000
+ 0.2638889 0.050000
+ 0.2641667 0.086099
+ 0.2644444 0.129774
+ 0.2647222 0.178589
+ 0.2650000 0.230109
+ 0.2652778 0.281900
+ 0.2655556 0.331528
+ 0.2658333 0.376558
+ 0.2661111 0.414555
+ 0.2663889 0.443085
+ 0.2666667 0.459712
+ 0.2669444 0.462717
+ 0.2672222 0.453237
+ 0.2675000 0.433121
+ 0.2677778 0.404222
+ 0.2680556 0.368391
+ 0.2683333 0.327478
+ 0.2686111 0.283334
+ 0.2688889 0.237811
+ 0.2691667 0.192759
+ 0.2694444 0.150029
+ 0.2697222 0.111266
+ 0.2700000 0.077281
+ 0.2702778 0.050000
+ 0.2705556 0.050000
+ 0.2708333 0.050000
+ 0.2711111 0.050000
+ 0.2713889 0.050000
+ 0.2716667 0.050000
+ 0.2719444 0.050000
+ 0.2722222 0.050000
+ 0.2725000 0.085725
+ 0.2727778 0.129202
+ 0.2730556 0.177962
+ 0.2733333 0.229534
+ 0.2736111 0.281450
+ 0.2738889 0.331239
+ 0.2741667 0.376432
+ 0.2744444 0.414559
+ 0.2747222 0.443151
+ 0.2750000 0.459738
+ 0.2752778 0.462576
+ 0.2755556 0.452816
+ 0.2758333 0.432339
+ 0.2761111 0.403023
+ 0.2763889 0.366745
+ 0.2766667 0.325384
+ 0.2769444 0.280819
+ 0.2772222 0.234928
+ 0.2775000 0.189590
+ 0.2777778 0.146682
+ 0.2780556 0.107869
+ 0.2783333 0.073956
+ 0.2786111 0.050000
+ 0.2788889 0.050000
+ 0.2791667 0.050000
+ 0.2794444 0.050000
+ 0.2797222 0.050000
+ 0.2800000 0.050000
+ 0.2802778 0.050000
+ 0.2805556 0.050000
+ 0.2808333 0.086276
+ 0.2811111 0.130269
+ 0.2813889 0.179475
+ 0.2816667 0.231391
+ 0.2819444 0.283512
+ 0.2822222 0.333337
+ 0.2825000 0.378359
+ 0.2827778 0.416077
+ 0.2830556 0.443985
+ 0.2833333 0.459582
+ 0.2836111 0.461107
+ 0.2838889 0.449788
+ 0.2841667 0.427593
+ 0.2844444 0.396495
+ 0.2847222 0.358464
+ 0.2850000 0.315471
+ 0.2852778 0.269486
+ 0.2855556 0.222481
+ 0.2858333 0.176426
+ 0.2861111 0.133292
+ 0.2863889 0.094803
+ 0.2866667 0.061700
+ 0.2869444 0.050000
+ 0.2872222 0.050000
+ 0.2875000 0.050000
+ 0.2877778 0.050000
+ 0.2880556 0.050000
+ 0.2883333 0.050000
+ 0.2886111 0.050000
+ 0.2888889 0.050000
+ 0.2891667 0.087094
+ 0.2894444 0.131571
+ 0.2897222 0.180985
+ 0.2900000 0.232891
+ 0.2902778 0.284843
+ 0.2905556 0.334395
+ 0.2908333 0.379101
+ 0.2911111 0.416515
+ 0.2913889 0.444192
+ 0.2916667 0.459686
+ 0.2919444 0.461281
+ 0.2922222 0.450182
+ 0.2925000 0.428325
+ 0.2927778 0.397644
+ 0.2930556 0.360075
+ 0.2933333 0.317553
+ 0.2936111 0.272013
+ 0.2938889 0.225391
+ 0.2941667 0.179621
+ 0.2944444 0.136639
+ 0.2947222 0.098145
+ 0.2950000 0.064893
+ 0.2952778 0.050000
+ 0.2955556 0.050000
+ 0.2958333 0.050000
+ 0.2961111 0.050000
+ 0.2963889 0.050000
+ 0.2966667 0.050000
+ 0.2969444 0.050000
+ 0.2972222 0.050000
+ 0.2975000 0.086830
+ 0.2977778 0.131126
+ 0.2980556 0.180433
+ 0.2983333 0.232296
+ 0.2986111 0.284259
+ 0.2988889 0.333867
+ 0.2991667 0.378665
+ 0.2994444 0.416198
+ 0.2997222 0.444010
+ 0.3000000 0.459647
+ 0.3002778 0.461383
+ 0.3005556 0.450416
+ 0.3008333 0.428672
+ 0.3011111 0.398080
+ 0.3013889 0.360566
+ 0.3016667 0.318059
+ 0.3019444 0.272485
+ 0.3022222 0.225772
+ 0.3025000 0.179848
+ 0.3027778 0.136639
+ 0.3030556 0.097846
+ 0.3033333 0.064256
+ 0.3036111 0.050000
+ 0.3038889 0.050000
+ 0.3041667 0.050000
+ 0.3044444 0.050000
+ 0.3047222 0.050000
+ 0.3050000 0.050000
+ 0.3052778 0.050000
+ 0.3055556 0.050000
+ 0.3058333 0.087893
+ 0.3061111 0.133419
+ 0.3063889 0.183971
+ 0.3066667 0.236942
+ 0.3069444 0.289723
+ 0.3072222 0.339709
+ 0.3075000 0.384293
+ 0.3077778 0.420866
+ 0.3080556 0.446823
+ 0.3083333 0.459555
+ 0.3086111 0.457264
+ 0.3088889 0.441377
+ 0.3091667 0.414130
+ 0.3094444 0.377759
+ 0.3097222 0.334499
+ 0.3100000 0.286586
+ 0.3102778 0.236257
+ 0.3105556 0.185746
+ 0.3108333 0.137289
+ 0.3111111 0.093122
+ 0.3113889 0.055151
+ 0.3116667 0.050000
+ 0.3119444 0.050000
+ 0.3122222 0.050000
+ 0.3125000 0.050000
+ 0.3127778 0.050000
+ 0.3130556 0.050000
+ 0.3133333 0.050000
+ 0.3136111 0.050000
+ 0.3138889 0.050000
+ 0.3141667 0.091136
+ 0.3144444 0.138899
+ 0.3147222 0.190787
+ 0.3150000 0.244299
+ 0.3152778 0.296933
+ 0.3155556 0.346190
+ 0.3158333 0.389568
+ 0.3161111 0.424564
+ 0.3163889 0.448679
+ 0.3166667 0.459412
+ 0.3169444 0.455062
+ 0.3172222 0.437144
+ 0.3175000 0.407971
+ 0.3177778 0.369858
+ 0.3180556 0.325121
+ 0.3183333 0.276074
+ 0.3186111 0.225031
+ 0.3188889 0.174308
+ 0.3191667 0.126219
+ 0.3194444 0.083079
+ 0.3197222 0.050000
+ 0.3200000 0.050000
+ 0.3202778 0.050000
+ 0.3205556 0.050000
+ 0.3208333 0.050000
+ 0.3211111 0.050000
+ 0.3213889 0.050000
+ 0.3216667 0.050000
+ 0.3219444 0.050000
+ 0.3222222 0.050000
+ 0.3225000 0.086957
+ 0.3227778 0.129554
+ 0.3230556 0.176007
+ 0.3233333 0.224532
+ 0.3236111 0.273345
+ 0.3238889 0.320663
+ 0.3241667 0.364702
+ 0.3244444 0.403678
+ 0.3247222 0.435808
+ 0.3250000 0.459307
+ 0.3252778 0.472873
+ 0.3255556 0.477123
+ 0.3258333 0.473155
+ 0.3261111 0.462069
+ 0.3263889 0.444963
+ 0.3266667 0.422935
+ 0.3269444 0.397083
+ 0.3272222 0.368506
+ 0.3275000 0.338303
+ 0.3277778 0.307571
+ 0.3280556 0.277356
+ 0.3283333 0.248491
+ 0.3286111 0.221753
+ 0.3288889 0.197923
+ 0.3291667 0.177779
+ 0.3294444 0.162100
+ 0.3297222 0.151665
+ 0.3300000 0.147253
+ 0.3302778 0.149643
+ 0.3305556 0.159614
+ 0.3308333 0.177612
+ 0.3311111 0.202748
+ 0.3313889 0.233801
+ 0.3316667 0.269548
+ 0.3319444 0.308767
+ 0.3322222 0.350237
+ 0.3325000 0.392736
+ 0.3327778 0.435042
+ 0.3330556 0.475933
+ 0.3333333 0.514188
+ 0.3336111 0.548646
+ 0.3338889 0.578397
+ 0.3341667 0.602595
+ 0.3344444 0.620391
+ 0.3347222 0.630937
+ 0.3350000 0.633386
+ 0.3352778 0.626890
+ 0.3355556 0.610602
+ 0.3358333 0.583673
+ 0.3361111 0.545257
+ 0.3363889 0.495212
+ 0.3366667 0.436227
+ 0.3369444 0.371697
+ 0.3372222 0.305020
+ 0.3375000 0.239589
+ 0.3377778 0.178802
+ 0.3380556 0.126054
+ 0.3383333 0.084740
+ 0.3386111 0.058257
+ 0.3388889 0.050000
+ 0.3391667 0.062164
+ 0.3394444 0.092143
+ 0.3397222 0.136130
+ 0.3400000 0.190317
+ 0.3402778 0.250898
+ 0.3405556 0.314064
+ 0.3408333 0.376010
+ 0.3411111 0.432928
+ 0.3413889 0.481010
+ 0.3416667 0.516450
+ 0.3419444 0.536534
+ 0.3422222 0.542922
+ 0.3425000 0.538368
+ 0.3427778 0.525626
+ 0.3430556 0.507450
+ 0.3433333 0.486594
+ 0.3436111 0.465811
+ 0.3438889 0.447855
+ 0.3441667 0.435481
+ 0.3444444 0.431442
+ 0.3447222 0.437701
+ 0.3450000 0.453058
+ 0.3452778 0.475524
+ 0.3455556 0.503108
+ 0.3458333 0.533820
+ 0.3461111 0.565670
+ 0.3463889 0.596667
+ 0.3466667 0.624822
+ 0.3469444 0.648144
+ 0.3472222 0.664642
+ 0.3475000 0.672772
+ 0.3477778 0.672767
+ 0.3480556 0.665305
+ 0.3483333 0.651065
+ 0.3486111 0.630725
+ 0.3488889 0.604963
+ 0.3491667 0.574458
+ 0.3494444 0.539889
+ 0.3497222 0.501933
+ 0.3500000 0.461268
+ 0.3502778 0.418570
+ 0.3505556 0.374490
+ 0.3508333 0.329678
+ 0.3511111 0.284783
+ 0.3513889 0.240454
+ 0.3516667 0.197339
+ 0.3519444 0.156087
+ 0.3522222 0.117348
+ 0.3525000 0.081769
+ 0.3527778 0.050000
+ 0.3530556 0.050000
+ 0.3533333 0.050000
+ 0.3536111 0.050000
+ 0.3538889 0.050000
+ 0.3541667 0.050000
+ 0.3544444 0.050000
+ 0.3547222 0.050000
+ 0.3550000 0.050000
+ 0.3552778 0.050000
+ 0.3555556 0.050000
+ 0.3558333 0.091035
+ 0.3561111 0.138516
+ 0.3563889 0.190017
+ 0.3566667 0.243114
+ 0.3569444 0.295381
+ 0.3572222 0.344392
+ 0.3575000 0.387722
+ 0.3577778 0.422946
+ 0.3580556 0.447638
+ 0.3583333 0.459372
+ 0.3586111 0.456490
+ 0.3588889 0.440395
+ 0.3591667 0.413259
+ 0.3594444 0.377252
+ 0.3597222 0.334544
+ 0.3600000 0.287307
+ 0.3602778 0.237710
+ 0.3605556 0.187924
+ 0.3608333 0.140121
+ 0.3611111 0.096469
+ 0.3613889 0.058826
+ 0.3616667 0.050000
+ 0.3619444 0.050000
+ 0.3622222 0.050000
+ 0.3625000 0.050000
+ 0.3627778 0.050000
+ 0.3630556 0.050000
+ 0.3633333 0.050000
+ 0.3636111 0.050000
+ 0.3638889 0.050000
+ 0.3641667 0.090279
+ 0.3644444 0.137199
+ 0.3647222 0.188326
+ 0.3650000 0.241224
+ 0.3652778 0.293459
+ 0.3655556 0.342596
+ 0.3658333 0.386200
+ 0.3661111 0.421836
+ 0.3663889 0.447069
+ 0.3666667 0.459464
+ 0.3669444 0.457348
+ 0.3672222 0.442093
+ 0.3675000 0.415834
+ 0.3677778 0.380704
+ 0.3680556 0.338838
+ 0.3683333 0.292371
+ 0.3686111 0.243435
+ 0.3688889 0.194166
+ 0.3691667 0.146698
+ 0.3694444 0.103164
+ 0.3697222 0.065396
+ 0.3700000 0.050000
+ 0.3702778 0.050000
+ 0.3705556 0.050000
+ 0.3708333 0.050000
+ 0.3711111 0.050000
+ 0.3713889 0.050000
+ 0.3716667 0.050000
+ 0.3719444 0.050000
+ 0.3722222 0.050000
+ 0.3725000 0.089605
+ 0.3727778 0.135971
+ 0.3730556 0.186678
+ 0.3733333 0.239300
+ 0.3736111 0.291415
+ 0.3738889 0.340600
+ 0.3741667 0.384433
+ 0.3744444 0.420489
+ 0.3747222 0.446346
+ 0.3750000 0.459582
+ 0.3752778 0.458520
+ 0.3755556 0.444482
+ 0.3758333 0.419536
+ 0.3761111 0.385749
+ 0.3763889 0.345190
+ 0.3766667 0.299928
+ 0.3769444 0.252030
+ 0.3772222 0.203565
+ 0.3775000 0.156601
+ 0.3777778 0.113207
+ 0.3780556 0.075170
+ 0.3783333 0.050000
+ 0.3786111 0.050000
+ 0.3788889 0.050000
+ 0.3791667 0.050000
+ 0.3794444 0.050000
+ 0.3797222 0.050000
+ 0.3800000 0.050000
+ 0.3802778 0.050000
+ 0.3805556 0.050000
+ 0.3808333 0.089020
+ 0.3811111 0.135054
+ 0.3813889 0.185634
+ 0.3816667 0.238292
+ 0.3819444 0.290557
+ 0.3822222 0.339960
+ 0.3825000 0.384034
+ 0.3827778 0.420308
+ 0.3830556 0.446314
+ 0.3833333 0.459582
+ 0.3836111 0.458404
+ 0.3838889 0.444120
+ 0.3841667 0.418827
+ 0.3844444 0.384624
+ 0.3847222 0.343611
+ 0.3850000 0.297887
+ 0.3852778 0.249551
+ 0.3855556 0.200701
+ 0.3858333 0.153438
+ 0.3861111 0.109859
+ 0.3863889 0.071776
+ 0.3866667 0.050000
+ 0.3869444 0.050000
+ 0.3872222 0.050000
+ 0.3875000 0.050000
+ 0.3877778 0.050000
+ 0.3880556 0.050000
+ 0.3883333 0.050000
+ 0.3886111 0.050000
+ 0.3888889 0.050000
+ 0.3891667 0.089510
+ 0.3894444 0.135989
+ 0.3897222 0.186945
+ 0.3900000 0.239883
+ 0.3902778 0.292312
+ 0.3905556 0.341738
+ 0.3908333 0.385669
+ 0.3911111 0.421610
+ 0.3913889 0.447070
+ 0.3916667 0.459555
+ 0.3919444 0.457351
+ 0.3922222 0.441850
+ 0.3925000 0.415225
+ 0.3927778 0.379648
+ 0.3930556 0.337291
+ 0.3933333 0.290326
+ 0.3936111 0.240924
+ 0.3938889 0.191257
+ 0.3941667 0.143498
+ 0.3944444 0.099817
+ 0.3947222 0.062072
+ 0.3950000 0.050000
+ 0.3952778 0.050000
+ 0.3955556 0.050000
+ 0.3958333 0.050000
+ 0.3961111 0.050000
+ 0.3963889 0.050000
+ 0.3966667 0.050000
+ 0.3969444 0.050000
+ 0.3972222 0.050000
+ 0.3975000 0.089765
+ 0.3977778 0.136192
+ 0.3980556 0.186881
+ 0.3983333 0.239433
+ 0.3986111 0.291450
+ 0.3988889 0.340534
+ 0.3991667 0.384285
+ 0.3994444 0.420304
+ 0.3997222 0.446194
+ 0.4000000 0.459555
+ 0.4002778 0.458729
+ 0.4005556 0.445018
+ 0.4008333 0.420465
+ 0.4011111 0.387111
+ 0.4013889 0.346999
+ 0.4016667 0.302172
+ 0.4019444 0.254671
+ 0.4022222 0.206540
+ 0.4025000 0.159820
+ 0.4027778 0.116554
+ 0.4030556 0.078512
+ 0.4033333 0.050000
+ 0.4036111 0.050000
+ 0.4038889 0.050000
+ 0.4041667 0.050000
+ 0.4044444 0.050000
+ 0.4047222 0.050000
+ 0.4050000 0.050000
+ 0.4052778 0.050000
+ 0.4055556 0.050000
+ 0.4058333 0.088623
+ 0.4061111 0.134318
+ 0.4063889 0.184626
+ 0.4066667 0.237090
+ 0.4069444 0.289252
+ 0.4072222 0.338655
+ 0.4075000 0.382840
+ 0.4077778 0.419351
+ 0.4080556 0.445729
+ 0.4083333 0.459516
+ 0.4086111 0.459008
+ 0.4088889 0.445508
+ 0.4091667 0.421073
+ 0.4094444 0.387758
+ 0.4097222 0.347620
+ 0.4100000 0.302716
+ 0.4102778 0.255101
+ 0.4105556 0.206831
+ 0.4108333 0.159964
+ 0.4111111 0.116554
+ 0.4113889 0.078385
+ 0.4116667 0.050000
+ 0.4119444 0.050000
+ 0.4122222 0.050000
+ 0.4125000 0.050000
+ 0.4127778 0.050000
+ 0.4130556 0.050000
+ 0.4133333 0.050000
+ 0.4136111 0.050000
+ 0.4138889 0.050000
+ 0.4141667 0.088825
+ 0.4144444 0.134742
+ 0.4147222 0.185269
+ 0.4150000 0.237925
+ 0.4152778 0.290227
+ 0.4155556 0.339693
+ 0.4158333 0.383841
+ 0.4161111 0.420189
+ 0.4163889 0.446254
+ 0.4166667 0.459555
+ 0.4169444 0.458375
+ 0.4172222 0.444059
+ 0.4175000 0.418717
+ 0.4177778 0.384459
+ 0.4180556 0.343396
+ 0.4183333 0.297638
+ 0.4186111 0.249295
+ 0.4188889 0.200477
+ 0.4191667 0.153295
+ 0.4194444 0.109859
+ 0.4197222 0.071984
+ 0.4200000 0.050000
+ 0.4202778 0.050000
+ 0.4205556 0.050000
+ 0.4208333 0.050000
+ 0.4211111 0.050000
+ 0.4213889 0.050000
+ 0.4216667 0.050000
+ 0.4219444 0.050000
+ 0.4222222 0.050000
+ 0.4225000 0.088689
+ 0.4227778 0.134215
+ 0.4230556 0.184202
+ 0.4233333 0.236276
+ 0.4236111 0.288062
+ 0.4238889 0.337186
+ 0.4241667 0.381272
+ 0.4244444 0.417945
+ 0.4247222 0.444831
+ 0.4250000 0.459555
+ 0.4252778 0.460460
+ 0.4255556 0.448761
+ 0.4258333 0.426389
+ 0.4261111 0.395278
+ 0.4263889 0.357359
+ 0.4266667 0.314566
+ 0.4269444 0.268830
+ 0.4272222 0.222084
+ 0.4275000 0.176261
+ 0.4277778 0.133292
+ 0.4280556 0.094875
+ 0.4283333 0.061763
+ 0.4286111 0.050000
+ 0.4288889 0.050000
+ 0.4291667 0.050000
+ 0.4294444 0.050000
+ 0.4297222 0.050000
+ 0.4300000 0.050000
+ 0.4302778 0.050000
+ 0.4305556 0.050000
+ 0.4308333 0.087436
+ 0.4311111 0.132333
+ 0.4313889 0.182187
+ 0.4316667 0.234492
+ 0.4319444 0.286743
+ 0.4322222 0.336435
+ 0.4325000 0.381063
+ 0.4327778 0.418123
+ 0.4330556 0.445109
+ 0.4333333 0.459516
+ 0.4336111 0.459599
+ 0.4338889 0.446648
+ 0.4341667 0.422715
+ 0.4344444 0.389849
+ 0.4347222 0.350102
+ 0.4350000 0.305523
+ 0.4352778 0.258163
+ 0.4355556 0.210072
+ 0.4358333 0.163302
+ 0.4361111 0.119902
+ 0.4363889 0.081651
+ 0.4366667 0.050000
+ 0.4369444 0.050000
+ 0.4372222 0.050000
+ 0.4375000 0.050000
+ 0.4377778 0.050000
+ 0.4380556 0.050000
+ 0.4383333 0.050000
+ 0.4386111 0.050000
+ 0.4388889 0.050000
+ 0.4391667 0.088369
+ 0.4394444 0.133863
+ 0.4397222 0.184027
+ 0.4400000 0.236404
+ 0.4402778 0.288537
+ 0.4405556 0.337968
+ 0.4408333 0.382243
+ 0.4411111 0.418903
+ 0.4413889 0.445493
+ 0.4416667 0.459555
+ 0.4419444 0.459383
+ 0.4422222 0.446265
+ 0.4425000 0.422240
+ 0.4427778 0.389346
+ 0.4430556 0.349622
+ 0.4433333 0.305107
+ 0.4436111 0.257839
+ 0.4438889 0.209856
+ 0.4441667 0.163198
+ 0.4444444 0.119902
+ 0.4447222 0.081737
+ 0.4450000 0.050000
+ 0.4452778 0.050000
+ 0.4455556 0.050000
+ 0.4458333 0.050000
+ 0.4461111 0.050000
+ 0.4463889 0.050000
+ 0.4466667 0.050000
+ 0.4469444 0.050000
+ 0.4472222 0.050000
+ 0.4475000 0.088269
+ 0.4477778 0.133657
+ 0.4480556 0.183719
+ 0.4483333 0.236008
+ 0.4486111 0.288078
+ 0.4488889 0.337485
+ 0.4491667 0.381782
+ 0.4494444 0.418523
+ 0.4497222 0.445263
+ 0.4500000 0.459555
+ 0.4502778 0.459699
+ 0.4505556 0.446964
+ 0.4508333 0.423365
+ 0.4511111 0.390919
+ 0.4513889 0.351638
+ 0.4516667 0.307539
+ 0.4519444 0.260636
+ 0.4522222 0.212943
+ 0.4525000 0.166476
+ 0.4527778 0.123249
+ 0.4530556 0.085015
+ 0.4533333 0.052477
+ 0.4536111 0.050000
+ 0.4538889 0.050000
+ 0.4541667 0.050000
+ 0.4544444 0.050000
+ 0.4547222 0.050000
+ 0.4550000 0.050000
+ 0.4552778 0.050000
+ 0.4555556 0.050000
+ 0.4558333 0.088038
+ 0.4561111 0.133274
+ 0.4563889 0.183253
+ 0.4566667 0.235518
+ 0.4569444 0.287611
+ 0.4572222 0.337077
+ 0.4575000 0.381459
+ 0.4577778 0.418299
+ 0.4580556 0.445141
+ 0.4583333 0.459529
+ 0.4586111 0.459751
+ 0.4588889 0.447077
+ 0.4591667 0.423523
+ 0.4594444 0.391102
+ 0.4597222 0.351831
+ 0.4600000 0.307725
+ 0.4602778 0.260798
+ 0.4605556 0.213067
+ 0.4608333 0.166546
+ 0.4611111 0.123249
+ 0.4613889 0.084933
+ 0.4616667 0.052306
+ 0.4619444 0.050000
+ 0.4622222 0.050000
+ 0.4625000 0.050000
+ 0.4627778 0.050000
+ 0.4630556 0.050000
+ 0.4633333 0.050000
+ 0.4636111 0.050000
+ 0.4638889 0.050000
+ 0.4641667 0.088296
+ 0.4644444 0.133831
+ 0.4647222 0.184112
+ 0.4650000 0.236645
+ 0.4652778 0.288939
+ 0.4655556 0.338500
+ 0.4658333 0.382837
+ 0.4661111 0.419455
+ 0.4663889 0.445864
+ 0.4666667 0.459568
+ 0.4669444 0.458841
+ 0.4672222 0.445007
+ 0.4675000 0.420156
+ 0.4677778 0.386377
+ 0.4680556 0.345758
+ 0.4683333 0.300390
+ 0.4686111 0.252362
+ 0.4688889 0.203762
+ 0.4691667 0.156681
+ 0.4694444 0.113207
+ 0.4697222 0.075143
+ 0.4700000 0.050000
+ 0.4702778 0.050000
+ 0.4705556 0.050000
+ 0.4708333 0.050000
+ 0.4711111 0.050000
+ 0.4713889 0.050000
+ 0.4716667 0.050000
+ 0.4719444 0.050000
+ 0.4722222 0.050000
+ 0.4725000 0.088797
+ 0.4727778 0.134560
+ 0.4730556 0.184857
+ 0.4733333 0.237254
+ 0.4736111 0.289319
+ 0.4738889 0.338619
+ 0.4741667 0.382722
+ 0.4744444 0.419194
+ 0.4747222 0.445603
+ 0.4750000 0.459516
+ 0.4752778 0.459245
+ 0.4755556 0.446074
+ 0.4758333 0.422034
+ 0.4761111 0.389154
+ 0.4763889 0.349464
+ 0.4766667 0.304994
+ 0.4769444 0.257773
+ 0.4772222 0.209831
+ 0.4775000 0.163197
+ 0.4777778 0.119902
+ 0.4780556 0.081707
+ 0.4783333 0.050000
+ 0.4786111 0.050000
+ 0.4788889 0.050000
+ 0.4791667 0.050000
+ 0.4794444 0.050000
+ 0.4797222 0.050000
+ 0.4800000 0.050000
+ 0.4802778 0.050000
+ 0.4805556 0.050000
+ 0.4808333 0.088497
+ 0.4811111 0.134155
+ 0.4813889 0.184492
+ 0.4816667 0.237028
+ 0.4819444 0.289283
+ 0.4822222 0.338777
+ 0.4825000 0.383029
+ 0.4827778 0.419558
+ 0.4830556 0.445885
+ 0.4833333 0.459529
+ 0.4836111 0.458770
+ 0.4838889 0.444931
+ 0.4841667 0.420093
+ 0.4844444 0.386339
+ 0.4847222 0.345752
+ 0.4850000 0.300414
+ 0.4852778 0.252408
+ 0.4855556 0.203817
+ 0.4858333 0.156722
+ 0.4861111 0.113207
+ 0.4863889 0.075071
+ 0.4866667 0.050000
+ 0.4869444 0.050000
+ 0.4872222 0.050000
+ 0.4875000 0.050000
+ 0.4877778 0.050000
+ 0.4880556 0.050000
+ 0.4883333 0.050000
+ 0.4886111 0.050000
+ 0.4888889 0.050000
+ 0.4891667 0.089128
+ 0.4894444 0.135278
+ 0.4897222 0.185970
+ 0.4900000 0.238722
+ 0.4902778 0.291054
+ 0.4905556 0.340485
+ 0.4908333 0.384536
+ 0.4911111 0.420724
+ 0.4913889 0.446571
+ 0.4916667 0.459595
+ 0.4919444 0.458083
+ 0.4922222 0.443393
+ 0.4925000 0.417650
+ 0.4927778 0.382980
+ 0.4930556 0.341509
+ 0.4933333 0.295360
+ 0.4936111 0.246661
+ 0.4938889 0.197537
+ 0.4941667 0.150112
+ 0.4944444 0.106512
+ 0.4947222 0.068564
+ 0.4950000 0.050000
+ 0.4952778 0.050000
+ 0.4955556 0.050000
+ 0.4958333 0.050000
+ 0.4961111 0.050000
+ 0.4963889 0.050000
+ 0.4966667 0.050000
+ 0.4969444 0.050000
+ 0.4972222 0.050000
+ 0.4975000 0.089491
+ 0.4977778 0.135832
+ 0.4980556 0.186576
+ 0.4983333 0.239278
+ 0.4986111 0.291491
+ 0.4988889 0.340770
+ 0.4991667 0.384668
+ 0.4994444 0.420740
+ 0.4997222 0.446540
+ 0.5000000 0.459621
+ 0.5002778 0.458295
+ 0.5005556 0.443901
+ 0.5008333 0.418535
+ 0.5011111 0.384294
+ 0.5013889 0.343274
+ 0.5016667 0.297572
+ 0.5019444 0.249282
+ 0.5022222 0.200503
+ 0.5025000 0.153330
+ 0.5027778 0.109859
+ 0.5030556 0.071898
+ 0.5033333 0.050000
+ 0.5036111 0.050000
+ 0.5038889 0.050000
+ 0.5041667 0.050000
+ 0.5044444 0.050000
+ 0.5047222 0.050000
+ 0.5050000 0.050000
+ 0.5052778 0.050000
+ 0.5055556 0.050000
+ 0.5058333 0.089163
+ 0.5061111 0.135245
+ 0.5063889 0.185799
+ 0.5066667 0.238383
+ 0.5069444 0.290550
+ 0.5072222 0.339855
+ 0.5075000 0.383855
+ 0.5077778 0.420104
+ 0.5080556 0.446156
+ 0.5083333 0.459568
+ 0.5086111 0.458648
+ 0.5088889 0.444712
+ 0.5091667 0.419833
+ 0.5094444 0.386081
+ 0.5097222 0.345526
+ 0.5100000 0.300241
+ 0.5102778 0.252296
+ 0.5105556 0.203761
+ 0.5108333 0.156708
+ 0.5111111 0.113207
+ 0.5113889 0.075050
+ 0.5116667 0.050000
+ 0.5119444 0.050000
+ 0.5122222 0.050000
+ 0.5125000 0.050000
+ 0.5127778 0.050000
+ 0.5130556 0.050000
+ 0.5133333 0.050000
+ 0.5136111 0.050000
+ 0.5138889 0.050000
+ 0.5141667 0.089361
+ 0.5144444 0.135786
+ 0.5147222 0.186762
+ 0.5150000 0.239770
+ 0.5152778 0.292295
+ 0.5155556 0.341822
+ 0.5158333 0.385834
+ 0.5161111 0.421815
+ 0.5163889 0.447249
+ 0.5166667 0.459621
+ 0.5169444 0.457198
+ 0.5172222 0.441392
+ 0.5175000 0.414396
+ 0.5177778 0.378405
+ 0.5180556 0.335614
+ 0.5183333 0.288217
+ 0.5186111 0.238409
+ 0.5188889 0.188386
+ 0.5191667 0.140341
+ 0.5194444 0.096469
+ 0.5197222 0.058646
+ 0.5200000 0.050000
+ 0.5202778 0.050000
+ 0.5205556 0.050000
+ 0.5208333 0.050000
+ 0.5211111 0.050000
+ 0.5213889 0.050000
+ 0.5216667 0.050000
+ 0.5219444 0.050000
+ 0.5222222 0.050000
+ 0.5225000 0.090471
+ 0.5227778 0.137596
+ 0.5230556 0.188921
+ 0.5233333 0.241990
+ 0.5236111 0.294350
+ 0.5238889 0.343546
+ 0.5241667 0.387124
+ 0.5244444 0.422630
+ 0.5247222 0.447609
+ 0.5250000 0.459608
+ 0.5252778 0.456941
+ 0.5255556 0.441010
+ 0.5258333 0.413984
+ 0.5261111 0.378034
+ 0.5263889 0.335331
+ 0.5266667 0.288044
+ 0.5269444 0.238343
+ 0.5272222 0.188401
+ 0.5275000 0.140386
+ 0.5277778 0.096469
+ 0.5280556 0.058511
+ 0.5283333 0.050000
+ 0.5286111 0.050000
+ 0.5288889 0.050000
+ 0.5291667 0.050000
+ 0.5294444 0.050000
+ 0.5297222 0.050000
+ 0.5300000 0.050000
+ 0.5302778 0.050000
+ 0.5305556 0.050000
+ 0.5308333 0.091256
+ 0.5311111 0.139301
+ 0.5313889 0.191564
+ 0.5316667 0.245472
+ 0.5319444 0.298455
+ 0.5322222 0.347939
+ 0.5325000 0.391354
+ 0.5327778 0.426128
+ 0.5330556 0.449688
+ 0.5333333 0.459464
+ 0.5336111 0.453713
+ 0.5338889 0.434011
+ 0.5341667 0.402767
+ 0.5344444 0.362385
+ 0.5347222 0.315274
+ 0.5350000 0.263838
+ 0.5352778 0.210486
+ 0.5355556 0.157624
+ 0.5358333 0.107658
+ 0.5361111 0.062994
+ 0.5363889 0.050000
+ 0.5366667 0.050000
+ 0.5369444 0.050000
+ 0.5372222 0.050000
+ 0.5375000 0.050000
+ 0.5377778 0.050000
+ 0.5380556 0.050000
+ 0.5383333 0.050000
+ 0.5386111 0.050000
+ 0.5388889 0.050000
+ 0.5391667 0.093820
+ 0.5394444 0.143668
+ 0.5397222 0.197044
+ 0.5400000 0.251447
+ 0.5402778 0.304379
+ 0.5405556 0.353340
+ 0.5408333 0.395830
+ 0.5411111 0.429349
+ 0.5413889 0.451398
+ 0.5416667 0.459477
+ 0.5419444 0.451914
+ 0.5422222 0.430351
+ 0.5425000 0.397254
+ 0.5427778 0.355093
+ 0.5430556 0.306336
+ 0.5433333 0.253451
+ 0.5436111 0.198906
+ 0.5438889 0.145171
+ 0.5441667 0.094712
+ 0.5444444 0.050000
+ 0.5447222 0.050000
+ 0.5450000 0.050000
+ 0.5452778 0.050000
+ 0.5455556 0.050000
+ 0.5458333 0.050000
+ 0.5461111 0.050000
+ 0.5463889 0.050000
+ 0.5466667 0.050000
+ 0.5469444 0.050000
+ 0.5472222 0.050000
+ 0.5475000 0.094645
+ 0.5477778 0.145017
+ 0.5480556 0.198659
+ 0.5483333 0.253115
+ 0.5486111 0.305931
+ 0.5488889 0.354649
+ 0.5491667 0.396815
+ 0.5494444 0.429972
+ 0.5497222 0.451665
+ 0.5500000 0.459438
+ 0.5502778 0.451653
+ 0.5505556 0.429950
+ 0.5508333 0.396783
+ 0.5511111 0.354610
+ 0.5513889 0.305887
+ 0.5516667 0.253070
+ 0.5519444 0.198617
+ 0.5522222 0.144983
+ 0.5525000 0.094625
+ 0.5527778 0.050000
+ 0.5530556 0.050000
+ 0.5533333 0.050000
+ 0.5536111 0.050000
+ 0.5538889 0.050000
+ 0.5541667 0.050000
+ 0.5544444 0.050000
+ 0.5547222 0.050000
+ 0.5550000 0.050000
+ 0.5552778 0.050000
+ 0.5555556 0.050000
+ 0.5558333 0.094619
+ 0.5561111 0.144967
+ 0.5563889 0.198590
+ 0.5566667 0.253032
+ 0.5569444 0.305835
+ 0.5572222 0.354545
+ 0.5575000 0.396706
+ 0.5577778 0.429862
+ 0.5580556 0.451556
+ 0.5583333 0.459333
+ 0.5586111 0.451556
+ 0.5588889 0.429862
+ 0.5591667 0.396706
+ 0.5594444 0.354546
+ 0.5597222 0.305835
+ 0.5600000 0.253032
+ 0.5602778 0.198591
+ 0.5605556 0.144968
+ 0.5608333 0.094619
+ 0.5611111 0.050000
+ 0.5613889 0.050000
+ 0.5616667 0.050000
+ 0.5619444 0.050000
+ 0.5622222 0.050000
+ 0.5625000 0.050000
+ 0.5627778 0.050000
+ 0.5630556 0.050000
+ 0.5633333 0.050000
+ 0.5636111 0.050000
+ 0.5638889 0.050000
+ 0.5641667 0.094626
+ 0.5644444 0.144984
+ 0.5647222 0.198617
+ 0.5650000 0.253070
+ 0.5652778 0.305885
+ 0.5655556 0.354606
+ 0.5658333 0.396776
+ 0.5661111 0.429938
+ 0.5663889 0.451635
+ 0.5666667 0.459412
+ 0.5669444 0.451629
+ 0.5672222 0.429926
+ 0.5675000 0.396758
+ 0.5677778 0.354585
+ 0.5680556 0.305861
+ 0.5683333 0.253046
+ 0.5686111 0.198595
+ 0.5688889 0.144965
+ 0.5691667 0.094615
+ 0.5694444 0.050000
+ 0.5697222 0.050000
+ 0.5700000 0.050000
+ 0.5702778 0.050000
+ 0.5705556 0.050000
+ 0.5708333 0.050000
+ 0.5711111 0.050000
+ 0.5713889 0.050000
+ 0.5716667 0.050000
+ 0.5719444 0.050000
+ 0.5722222 0.050000
+ 0.5725000 0.094568
+ 0.5727778 0.144858
+ 0.5730556 0.198423
+ 0.5733333 0.252814
+ 0.5736111 0.305583
+ 0.5738889 0.354283
+ 0.5741667 0.396465
+ 0.5744444 0.429682
+ 0.5747222 0.451484
+ 0.5750000 0.459425
+ 0.5752778 0.451870
+ 0.5755556 0.430448
+ 0.5758333 0.397602
+ 0.5761111 0.355773
+ 0.5763889 0.307404
+ 0.5766667 0.254938
+ 0.5769444 0.200817
+ 0.5772222 0.147484
+ 0.5775000 0.097381
+ 0.5777778 0.052952
+ 0.5780556 0.050000
+ 0.5783333 0.050000
+ 0.5786111 0.050000
+ 0.5788889 0.050000
+ 0.5791667 0.050000
+ 0.5794444 0.050000
+ 0.5797222 0.050000
+ 0.5800000 0.050000
+ 0.5802778 0.050000
+ 0.5805556 0.050000
+ 0.5808333 0.093730
+ 0.5811111 0.143152
+ 0.5813889 0.195900
+ 0.5816667 0.249607
+ 0.5819444 0.301907
+ 0.5822222 0.350433
+ 0.5825000 0.392818
+ 0.5827778 0.426696
+ 0.5830556 0.449700
+ 0.5833333 0.459464
+ 0.5836111 0.454392
+ 0.5838889 0.435975
+ 0.5841667 0.406476
+ 0.5844444 0.368157
+ 0.5847222 0.323281
+ 0.5850000 0.274111
+ 0.5852778 0.222908
+ 0.5855556 0.171936
+ 0.5858333 0.123456
+ 0.5861111 0.079732
+ 0.5863889 0.050000
+ 0.5866667 0.050000
+ 0.5869444 0.050000
+ 0.5872222 0.050000
+ 0.5875000 0.050000
+ 0.5877778 0.050000
+ 0.5880556 0.050000
+ 0.5883333 0.050000
+ 0.5886111 0.050000
+ 0.5888889 0.050000
+ 0.5891667 0.091055
+ 0.5894444 0.138313
+ 0.5897222 0.189439
+ 0.5900000 0.242100
+ 0.5902778 0.293962
+ 0.5905556 0.342691
+ 0.5908333 0.385954
+ 0.5911111 0.421417
+ 0.5913889 0.446746
+ 0.5916667 0.459608
+ 0.5919444 0.458395
+ 0.5922222 0.444413
+ 0.5925000 0.419691
+ 0.5927778 0.386262
+ 0.5930556 0.346155
+ 0.5933333 0.301402
+ 0.5936111 0.254035
+ 0.5938889 0.206084
+ 0.5941667 0.159580
+ 0.5944444 0.116554
+ 0.5947222 0.078764
+ 0.5950000 0.050000
+ 0.5952778 0.050000
+ 0.5955556 0.050000
+ 0.5958333 0.050000
+ 0.5961111 0.050000
+ 0.5963889 0.050000
+ 0.5966667 0.050000
+ 0.5969444 0.050000
+ 0.5972222 0.050000
+ 0.5975000 0.087986
+ 0.5977778 0.132956
+ 0.5980556 0.182539
+ 0.5983333 0.234364
+ 0.5986111 0.286062
+ 0.5988889 0.335263
+ 0.5991667 0.379595
+ 0.5994444 0.416690
+ 0.5997222 0.444177
+ 0.6000000 0.459686
+ 0.6002778 0.461555
+ 0.6005556 0.450959
+ 0.6008333 0.429779
+ 0.6011111 0.399899
+ 0.6013889 0.363201
+ 0.6016667 0.321568
+ 0.6019444 0.276882
+ 0.6022222 0.231026
+ 0.6025000 0.185882
+ 0.6027778 0.143334
+ 0.6030556 0.105041
+ 0.6033333 0.071770
+ 0.6036111 0.050000
+ 0.6038889 0.050000
+ 0.6041667 0.050000
+ 0.6044444 0.050000
+ 0.6047222 0.050000
+ 0.6050000 0.050000
+ 0.6052778 0.050000
+ 0.6055556 0.051710
+ 0.6058333 0.087637
+ 0.6061111 0.131075
+ 0.6063889 0.179614
+ 0.6066667 0.230843
+ 0.6069444 0.282353
+ 0.6072222 0.331734
+ 0.6075000 0.376576
+ 0.6077778 0.414468
+ 0.6080556 0.443001
+ 0.6083333 0.459765
+ 0.6086111 0.463060
+ 0.6088889 0.454026
+ 0.6091667 0.434516
+ 0.6094444 0.406380
+ 0.6097222 0.371469
+ 0.6100000 0.331633
+ 0.6102778 0.288725
+ 0.6105556 0.244595
+ 0.6108333 0.201093
+ 0.6111111 0.160072
+ 0.6113889 0.123160
+ 0.6116667 0.091101
+ 0.6119444 0.064415
+ 0.6122222 0.050000
+ 0.6125000 0.050000
+ 0.6127778 0.050000
+ 0.6130556 0.050000
+ 0.6133333 0.050000
+ 0.6136111 0.050000
+ 0.6138889 0.071899
+ 0.6141667 0.106502
+ 0.6144444 0.148303
+ 0.6147222 0.194950
+ 0.6150000 0.244096
+ 0.6152778 0.293392
+ 0.6155556 0.340487
+ 0.6158333 0.383033
+ 0.6161111 0.418680
+ 0.6163889 0.445080
+ 0.6166667 0.459882
+ 0.6169444 0.461442
+ 0.6172222 0.450927
+ 0.6175000 0.430210
+ 0.6177778 0.401161
+ 0.6180556 0.365652
+ 0.6183333 0.325556
+ 0.6186111 0.282743
+ 0.6188889 0.239086
+ 0.6191667 0.196456
+ 0.6194444 0.156724
+ 0.6197222 0.121518
+ 0.6200000 0.091482
+ 0.6202778 0.067015
+ 0.6205556 0.050000
+ 0.6208333 0.050000
+ 0.6211111 0.050000
+ 0.6213889 0.050000
+ 0.6216667 0.050000
+ 0.6219444 0.059545
+ 0.6222222 0.085250
+ 0.6225000 0.119290
+ 0.6227778 0.159912
+ 0.6230556 0.204934
+ 0.6233333 0.252172
+ 0.6236111 0.299443
+ 0.6238889 0.344565
+ 0.6241667 0.385354
+ 0.6244444 0.419627
+ 0.6247222 0.445202
+ 0.6250000 0.459895
+ 0.6252778 0.462169
+ 0.6255556 0.453068
+ 0.6258333 0.434281
+ 0.6261111 0.407496
+ 0.6263889 0.374405
+ 0.6266667 0.336695
+ 0.6269444 0.296057
+ 0.6272222 0.254179
+ 0.6275000 0.212751
+ 0.6277778 0.173462
+ 0.6280556 0.137813
+ 0.6283333 0.106555
+ 0.6286111 0.080248
+ 0.6288889 0.059455
+ 0.6291667 0.050000
+ 0.6294444 0.050000
+ 0.6297222 0.050000
+ 0.6300000 0.050000
+ 0.6302778 0.057847
+ 0.6305556 0.081929
+ 0.6308333 0.114980
+ 0.6311111 0.155188
+ 0.6313889 0.200264
+ 0.6316667 0.247918
+ 0.6319444 0.295861
+ 0.6322222 0.341806
+ 0.6325000 0.383462
+ 0.6327778 0.418542
+ 0.6330556 0.444757
+ 0.6333333 0.459817
+ 0.6336111 0.462107
+ 0.6338889 0.452706
+ 0.6341667 0.433364
+ 0.6344444 0.405834
+ 0.6347222 0.371866
+ 0.6350000 0.333213
+ 0.6352778 0.291624
+ 0.6355556 0.248853
+ 0.6358333 0.206650
+ 0.6361111 0.166767
+ 0.6363889 0.130753
+ 0.6366667 0.099348
+ 0.6369444 0.073091
+ 0.6372222 0.052519
+ 0.6375000 0.050000
+ 0.6377778 0.050000
+ 0.6380556 0.050000
+ 0.6383333 0.050000
+ 0.6386111 0.053778
+ 0.6388889 0.078620
+ 0.6391667 0.112439
+ 0.6394444 0.153393
+ 0.6397222 0.199166
+ 0.6400000 0.247439
+ 0.6402778 0.295897
+ 0.6405556 0.342221
+ 0.6408333 0.384095
+ 0.6411111 0.419201
+ 0.6413889 0.445223
+ 0.6416667 0.459843
+ 0.6419444 0.461432
+ 0.6422222 0.451110
+ 0.6425000 0.430686
+ 0.6427778 0.401967
+ 0.6430556 0.366762
+ 0.6433333 0.326879
+ 0.6436111 0.284125
+ 0.6438889 0.240309
+ 0.6441667 0.197240
+ 0.6444444 0.156724
+ 0.6447222 0.120353
+ 0.6450000 0.088845
+ 0.6452778 0.062699
+ 0.6455556 0.050000
+ 0.6458333 0.050000
+ 0.6461111 0.050000
+ 0.6463889 0.050000
+ 0.6466667 0.050000
+ 0.6469444 0.050000
+ 0.6472222 0.071873
+ 0.6475000 0.106181
+ 0.6477778 0.147572
+ 0.6480556 0.193765
+ 0.6483333 0.242477
+ 0.6486111 0.291427
+ 0.6488889 0.338333
+ 0.6491667 0.380912
+ 0.6494444 0.416882
+ 0.6497222 0.443962
+ 0.6500000 0.459869
+ 0.6502778 0.462989
+ 0.6505556 0.454379
+ 0.6508333 0.435762
+ 0.6511111 0.408863
+ 0.6513889 0.375407
+ 0.6516667 0.337118
+ 0.6519444 0.295720
+ 0.6522222 0.252937
+ 0.6525000 0.210494
+ 0.6527778 0.170114
+ 0.6530556 0.133336
+ 0.6533333 0.100947
+ 0.6536111 0.073547
+ 0.6538889 0.051736
+ 0.6541667 0.050000
+ 0.6544444 0.050000
+ 0.6547222 0.050000
+ 0.6550000 0.050000
+ 0.6552778 0.050000
+ 0.6555556 0.071873
+ 0.6558333 0.105507
+ 0.6561111 0.146575
+ 0.6563889 0.192720
+ 0.6566667 0.241583
+ 0.6569444 0.290808
+ 0.6572222 0.338035
+ 0.6575000 0.380907
+ 0.6577778 0.417067
+ 0.6580556 0.444156
+ 0.6583333 0.459817
+ 0.6586111 0.462386
+ 0.6588889 0.452976
+ 0.6591667 0.433396
+ 0.6594444 0.405453
+ 0.6597222 0.370955
+ 0.6600000 0.331711
+ 0.6602778 0.289527
+ 0.6605556 0.246212
+ 0.6608333 0.203573
+ 0.6611111 0.163419
+ 0.6613889 0.127340
+ 0.6616667 0.096055
+ 0.6619444 0.070065
+ 0.6622222 0.050000
+ 0.6625000 0.050000
+ 0.6627778 0.050000
+ 0.6630556 0.050000
+ 0.6633333 0.050000
+ 0.6636111 0.053447
+ 0.6638889 0.078581
+ 0.6641667 0.112561
+ 0.6644444 0.153563
+ 0.6647222 0.199300
+ 0.6650000 0.247484
+ 0.6652778 0.295827
+ 0.6655556 0.342040
+ 0.6658333 0.383836
+ 0.6661111 0.418928
+ 0.6663889 0.445026
+ 0.6666667 0.459843
+ 0.6669444 0.461767
+ 0.6672222 0.451889
+ 0.6675000 0.431977
+ 0.6677778 0.403797
+ 0.6680556 0.369118
+ 0.6683333 0.329705
+ 0.6686111 0.287327
+ 0.6688889 0.243751
+ 0.6691667 0.200743
+ 0.6694444 0.160072
+ 0.6697222 0.123302
+ 0.6700000 0.091189
+ 0.6702778 0.064289
+ 0.6705556 0.050000
+ 0.6708333 0.050000
+ 0.6711111 0.050000
+ 0.6713889 0.050000
+ 0.6716667 0.050000
+ 0.6719444 0.050000
+ 0.6722222 0.068486
+ 0.6725000 0.102757
+ 0.6727778 0.144338
+ 0.6730556 0.190894
+ 0.6733333 0.240088
+ 0.6736111 0.289586
+ 0.6738889 0.337050
+ 0.6741667 0.380145
+ 0.6744444 0.416535
+ 0.6747222 0.443884
+ 0.6750000 0.459856
+ 0.6752778 0.462799
+ 0.6755556 0.453793
+ 0.6758333 0.434604
+ 0.6761111 0.406997
+ 0.6763889 0.372738
+ 0.6766667 0.333590
+ 0.6769444 0.291319
+ 0.6772222 0.247691
+ 0.6775000 0.204469
+ 0.6777778 0.163419
+ 0.6780556 0.126112
+ 0.6783333 0.093333
+ 0.6786111 0.065675
+ 0.6788889 0.050000
+ 0.6791667 0.050000
+ 0.6794444 0.050000
+ 0.6797222 0.050000
+ 0.6800000 0.050000
+ 0.6802778 0.050000
+ 0.6805556 0.065191
+ 0.6808333 0.099322
+ 0.6811111 0.140945
+ 0.6813889 0.187694
+ 0.6816667 0.237205
+ 0.6819444 0.287112
+ 0.6822222 0.335049
+ 0.6825000 0.378653
+ 0.6827778 0.415556
+ 0.6830556 0.443395
+ 0.6833333 0.459804
+ 0.6836111 0.463109
+ 0.6838889 0.454405
+ 0.6841667 0.435477
+ 0.6844444 0.408112
+ 0.6847222 0.374097
+ 0.6850000 0.335216
+ 0.6852778 0.293257
+ 0.6855556 0.250005
+ 0.6858333 0.207246
+ 0.6861111 0.166767
+ 0.6863889 0.130148
+ 0.6866667 0.098151
+ 0.6869444 0.071331
+ 0.6872222 0.050243
+ 0.6875000 0.050000
+ 0.6877778 0.050000
+ 0.6880556 0.050000
+ 0.6883333 0.050000
+ 0.6886111 0.050234
+ 0.6888889 0.075208
+ 0.6891667 0.109317
+ 0.6894444 0.150687
+ 0.6897222 0.196959
+ 0.6900000 0.245771
+ 0.6902778 0.294765
+ 0.6905556 0.341579
+ 0.6908333 0.383855
+ 0.6911111 0.419230
+ 0.6913889 0.445347
+ 0.6916667 0.459843
+ 0.6919444 0.461060
+ 0.6922222 0.450138
+ 0.6925000 0.428918
+ 0.6927778 0.399242
+ 0.6930556 0.362949
+ 0.6933333 0.321882
+ 0.6936111 0.277880
+ 0.6938889 0.232786
+ 0.6941667 0.188439
+ 0.6944444 0.146682
+ 0.6947222 0.109136
+ 0.6950000 0.076553
+ 0.6952778 0.050000
+ 0.6955556 0.050000
+ 0.6958333 0.050000
+ 0.6961111 0.050000
+ 0.6963889 0.050000
+ 0.6966667 0.050000
+ 0.6969444 0.050000
+ 0.6972222 0.058392
+ 0.6975000 0.093933
+ 0.6977778 0.136845
+ 0.6980556 0.184748
+ 0.6983333 0.235260
+ 0.6986111 0.285999
+ 0.6988889 0.334586
+ 0.6991667 0.378638
+ 0.6994444 0.415775
+ 0.6997222 0.443615
+ 0.7000000 0.459778
+ 0.7002778 0.462580
+ 0.7005556 0.453130
+ 0.7008333 0.433237
+ 0.7011111 0.404708
+ 0.7013889 0.369349
+ 0.7016667 0.328968
+ 0.7019444 0.285373
+ 0.7022222 0.240372
+ 0.7025000 0.195770
+ 0.7027778 0.153377
+ 0.7030556 0.114802
+ 0.7033333 0.080869
+ 0.7036111 0.052206
+ 0.7038889 0.050000
+ 0.7041667 0.050000
+ 0.7044444 0.050000
+ 0.7047222 0.050000
+ 0.7050000 0.050000
+ 0.7052778 0.050000
+ 0.7055556 0.051749
+ 0.7058333 0.087286
+ 0.7061111 0.130621
+ 0.7063889 0.179268
+ 0.7066667 0.230743
+ 0.7069444 0.282558
+ 0.7072222 0.332229
+ 0.7075000 0.377269
+ 0.7077778 0.415194
+ 0.7080556 0.443516
+ 0.7083333 0.459752
+ 0.7086111 0.462150
+ 0.7088889 0.451907
+ 0.7091667 0.430954
+ 0.7094444 0.401223
+ 0.7097222 0.364647
+ 0.7100000 0.323155
+ 0.7102778 0.278682
+ 0.7105556 0.233157
+ 0.7108333 0.188513
+ 0.7111111 0.146682
+ 0.7113889 0.109352
+ 0.7116667 0.077241
+ 0.7119444 0.050824
+ 0.7122222 0.050000
+ 0.7125000 0.050000
+ 0.7127778 0.050000
+ 0.7130556 0.050000
+ 0.7133333 0.050000
+ 0.7136111 0.050000
+ 0.7138889 0.065152
+ 0.7141667 0.100883
+ 0.7144444 0.143741
+ 0.7147222 0.191364
+ 0.7150000 0.241391
+ 0.7152778 0.291461
+ 0.7155556 0.339212
+ 0.7158333 0.382283
+ 0.7161111 0.418313
+ 0.7163889 0.444941
+ 0.7166667 0.459804
+ 0.7169444 0.461247
+ 0.7172222 0.450431
+ 0.7175000 0.429225
+ 0.7177778 0.399495
+ 0.7180556 0.363109
+ 0.7183333 0.321934
+ 0.7186111 0.277836
+ 0.7188889 0.232683
+ 0.7191667 0.188343
+ 0.7194444 0.146682
+ 0.7197222 0.109341
+ 0.7200000 0.077056
+ 0.7202778 0.050334
+ 0.7205556 0.050000
+ 0.7208333 0.050000
+ 0.7211111 0.050000
+ 0.7213889 0.050000
+ 0.7216667 0.050000
+ 0.7219444 0.050000
+ 0.7222222 0.061805
+ 0.7225000 0.097427
+ 0.7227778 0.140308
+ 0.7230556 0.188075
+ 0.7233333 0.238352
+ 0.7236111 0.288767
+ 0.7238889 0.336945
+ 0.7241667 0.380512
+ 0.7244444 0.417093
+ 0.7247222 0.444315
+ 0.7250000 0.459804
+ 0.7252778 0.461888
+ 0.7255556 0.451709
+ 0.7258333 0.431109
+ 0.7261111 0.401934
+ 0.7263889 0.366026
+ 0.7266667 0.325229
+ 0.7269444 0.281387
+ 0.7272222 0.236344
+ 0.7275000 0.191944
+ 0.7277778 0.150029
+ 0.7280556 0.112230
+ 0.7283333 0.079316
+ 0.7286111 0.051841
+ 0.7288889 0.050000
+ 0.7291667 0.050000
+ 0.7294444 0.050000
+ 0.7297222 0.050000
+ 0.7300000 0.050000
+ 0.7302778 0.050000
+ 0.7305556 0.058431
+ 0.7308333 0.093951
+ 0.7311111 0.136935
+ 0.7313889 0.184968
+ 0.7316667 0.235636
+ 0.7319444 0.286525
+ 0.7322222 0.335219
+ 0.7325000 0.379304
+ 0.7327778 0.416367
+ 0.7330556 0.443992
+ 0.7333333 0.459765
+ 0.7336111 0.461987
+ 0.7338889 0.451822
+ 0.7341667 0.431148
+ 0.7344444 0.401845
+ 0.7347222 0.365791
+ 0.7350000 0.324866
+ 0.7352778 0.280948
+ 0.7355556 0.235917
+ 0.7358333 0.191651
+ 0.7361111 0.150029
+ 0.7363889 0.112704
+ 0.7366667 0.080416
+ 0.7369444 0.053679
+ 0.7372222 0.050000
+ 0.7375000 0.050000
+ 0.7377778 0.050000
+ 0.7380556 0.050000
+ 0.7383333 0.050000
+ 0.7386111 0.050000
+ 0.7388889 0.065152
+ 0.7391667 0.100849
+ 0.7394444 0.143803
+ 0.7397222 0.191607
+ 0.7400000 0.241853
+ 0.7402778 0.292135
+ 0.7405556 0.340045
+ 0.7408333 0.383175
+ 0.7411111 0.419119
+ 0.7413889 0.445468
+ 0.7416667 0.459817
+ 0.7419444 0.460480
+ 0.7422222 0.448665
+ 0.7425000 0.426303
+ 0.7427778 0.395325
+ 0.7430556 0.357662
+ 0.7433333 0.315243
+ 0.7436111 0.270001
+ 0.7438889 0.223866
+ 0.7441667 0.178769
+ 0.7444444 0.136639
+ 0.7447222 0.099165
+ 0.7450000 0.067050
+ 0.7452778 0.050000
+ 0.7455556 0.050000
+ 0.7458333 0.050000
+ 0.7461111 0.050000
+ 0.7463889 0.050000
+ 0.7466667 0.050000
+ 0.7469444 0.050000
+ 0.7472222 0.058405
+ 0.7475000 0.094801
+ 0.7477778 0.138339
+ 0.7480556 0.186652
+ 0.7483333 0.237376
+ 0.7486111 0.288142
+ 0.7488889 0.336586
+ 0.7491667 0.380340
+ 0.7494444 0.417038
+ 0.7497222 0.444315
+ 0.7500000 0.459804
+ 0.7502778 0.461839
+ 0.7505556 0.451559
+ 0.7508333 0.430803
+ 0.7511111 0.401411
+ 0.7513889 0.365221
+ 0.7516667 0.324072
+ 0.7519444 0.279805
+ 0.7522222 0.234258
+ 0.7525000 0.189271
+ 0.7527778 0.146682
+ 0.7530556 0.108124
+ 0.7533333 0.074399
+ 0.7536111 0.050000
+ 0.7538889 0.050000
+ 0.7541667 0.050000
+ 0.7544444 0.050000
+ 0.7547222 0.050000
+ 0.7550000 0.050000
+ 0.7552778 0.050000
+ 0.7555556 0.050000
+ 0.7558333 0.086039
+ 0.7561111 0.129788
+ 0.7563889 0.178765
+ 0.7566667 0.230491
+ 0.7569444 0.282486
+ 0.7572222 0.332269
+ 0.7575000 0.377361
+ 0.7577778 0.415281
+ 0.7580556 0.443549
+ 0.7583333 0.459686
+ 0.7586111 0.461946
+ 0.7588889 0.451525
+ 0.7591667 0.430354
+ 0.7594444 0.400364
+ 0.7597222 0.363484
+ 0.7600000 0.321647
+ 0.7602778 0.276783
+ 0.7605556 0.230822
+ 0.7608333 0.185696
+ 0.7611111 0.143334
+ 0.7613889 0.105431
+ 0.7616667 0.072726
+ 0.7619444 0.050000
+ 0.7622222 0.050000
+ 0.7625000 0.050000
+ 0.7627778 0.050000
+ 0.7630556 0.050000
+ 0.7633333 0.050000
+ 0.7636111 0.050000
+ 0.7638889 0.058457
+ 0.7641667 0.094640
+ 0.7644444 0.138129
+ 0.7647222 0.186512
+ 0.7650000 0.237380
+ 0.7652778 0.288322
+ 0.7655556 0.336927
+ 0.7658333 0.380784
+ 0.7661111 0.417483
+ 0.7663889 0.444614
+ 0.7666667 0.459765
+ 0.7669444 0.461243
+ 0.7672222 0.450229
+ 0.7675000 0.428618
+ 0.7677778 0.398308
+ 0.7680556 0.361196
+ 0.7683333 0.319178
+ 0.7686111 0.274151
+ 0.7688889 0.228012
+ 0.7691667 0.182659
+ 0.7694444 0.139987
+ 0.7697222 0.101666
+ 0.7700000 0.068452
+ 0.7702778 0.050000
+ 0.7705556 0.050000
+ 0.7708333 0.050000
+ 0.7711111 0.050000
+ 0.7713889 0.050000
+ 0.7716667 0.050000
+ 0.7719444 0.050000
+ 0.7722222 0.050000
+ 0.7725000 0.086039
+ 0.7727778 0.129550
+ 0.7730556 0.178143
+ 0.7733333 0.229426
+ 0.7736111 0.281010
+ 0.7738889 0.330505
+ 0.7741667 0.375519
+ 0.7744444 0.413663
+ 0.7747222 0.442546
+ 0.7750000 0.459778
+ 0.7752778 0.463663
+ 0.7755556 0.455284
+ 0.7758333 0.436418
+ 0.7761111 0.408844
+ 0.7763889 0.374340
+ 0.7766667 0.334682
+ 0.7769444 0.291648
+ 0.7772222 0.247017
+ 0.7775000 0.202566
+ 0.7777778 0.160072
+ 0.7780556 0.121129
+ 0.7783333 0.086596
+ 0.7786111 0.057147
+ 0.7788889 0.050000
+ 0.7791667 0.050000
+ 0.7794444 0.050000
+ 0.7797222 0.050000
+ 0.7800000 0.050000
+ 0.7802778 0.050000
+ 0.7805556 0.050000
+ 0.7808333 0.084971
+ 0.7811111 0.127927
+ 0.7813889 0.176373
+ 0.7816667 0.227817
+ 0.7819444 0.279762
+ 0.7822222 0.329717
+ 0.7825000 0.375185
+ 0.7827778 0.413675
+ 0.7830556 0.442690
+ 0.7833333 0.459738
+ 0.7836111 0.463055
+ 0.7838889 0.453796
+ 0.7841667 0.433848
+ 0.7844444 0.405098
+ 0.7847222 0.369431
+ 0.7850000 0.328735
+ 0.7852778 0.284895
+ 0.7855556 0.239798
+ 0.7858333 0.195330
+ 0.7861111 0.153377
+ 0.7863889 0.115601
+ 0.7866667 0.082761
+ 0.7869444 0.055391
+ 0.7872222 0.050000
+ 0.7875000 0.050000
+ 0.7877778 0.050000
+ 0.7880556 0.050000
+ 0.7883333 0.050000
+ 0.7886111 0.050000
+ 0.7888889 0.061844
+ 0.7891667 0.096983
+ 0.7894444 0.139490
+ 0.7897222 0.186991
+ 0.7900000 0.237110
+ 0.7902778 0.287471
+ 0.7905556 0.335699
+ 0.7908333 0.379419
+ 0.7911111 0.416256
+ 0.7913889 0.443834
+ 0.7916667 0.459778
+ 0.7919444 0.462409
+ 0.7922222 0.452834
+ 0.7925000 0.432859
+ 0.7927778 0.404287
+ 0.7930556 0.368924
+ 0.7933333 0.328572
+ 0.7936111 0.285038
+ 0.7938889 0.240124
+ 0.7941667 0.195636
+ 0.7944444 0.153377
+ 0.7947222 0.114954
+ 0.7950000 0.081177
+ 0.7952778 0.052660
+ 0.7955556 0.050000
+ 0.7958333 0.050000
+ 0.7961111 0.050000
+ 0.7963889 0.050000
+ 0.7966667 0.050000
+ 0.7969444 0.050000
+ 0.7972222 0.051749
+ 0.7975000 0.086850
+ 0.7977778 0.129686
+ 0.7980556 0.177831
+ 0.7983333 0.228860
+ 0.7986111 0.280348
+ 0.7988889 0.329870
+ 0.7991667 0.375000
+ 0.7994444 0.413314
+ 0.7997222 0.442386
+ 0.8000000 0.459791
+ 0.8002778 0.463805
+ 0.8005556 0.455512
+ 0.8008333 0.436693
+ 0.8011111 0.409132
+ 0.8013889 0.374614
+ 0.8016667 0.334920
+ 0.8019444 0.291836
+ 0.8022222 0.247144
+ 0.8025000 0.202628
+ 0.8027778 0.160072
+ 0.8030556 0.121074
+ 0.8033333 0.086494
+ 0.8036111 0.057008
+ 0.8038889 0.050000
+ 0.8041667 0.050000
+ 0.8044444 0.050000
+ 0.8047222 0.050000
+ 0.8050000 0.050000
+ 0.8052778 0.050000
+ 0.8055556 0.050000
+ 0.8058333 0.085061
+ 0.8061111 0.128116
+ 0.8063889 0.176661
+ 0.8066667 0.228188
+ 0.8069444 0.280194
+ 0.8072222 0.330173
+ 0.8075000 0.375620
+ 0.8077778 0.414028
+ 0.8080556 0.442894
+ 0.8083333 0.459712
+ 0.8086111 0.462716
+ 0.8088889 0.453097
+ 0.8091667 0.432785
+ 0.8094444 0.403711
+ 0.8097222 0.367806
+ 0.8100000 0.327000
+ 0.8102778 0.283223
+ 0.8105556 0.238407
+ 0.8108333 0.194481
+ 0.8111111 0.153377
+ 0.8113889 0.116777
+ 0.8116667 0.085378
+ 0.8119444 0.059627
+ 0.8122222 0.050000
+ 0.8125000 0.050000
+ 0.8127778 0.050000
+ 0.8130556 0.050000
+ 0.8133333 0.050000
+ 0.8136111 0.050000
+ 0.8138889 0.075221
+ 0.8141667 0.110349
+ 0.8144444 0.152397
+ 0.8147222 0.199049
+ 0.8150000 0.247987
+ 0.8152778 0.296893
+ 0.8155556 0.343451
+ 0.8158333 0.385344
+ 0.8161111 0.420254
+ 0.8163889 0.445863
+ 0.8166667 0.459856
+ 0.8169444 0.460617
+ 0.8172222 0.449340
+ 0.8175000 0.427922
+ 0.8177778 0.398260
+ 0.8180556 0.362251
+ 0.8183333 0.321791
+ 0.8186111 0.278776
+ 0.8188889 0.235105
+ 0.8191667 0.192673
+ 0.8194444 0.153377
+ 0.8197222 0.118856
+ 0.8200000 0.089714
+ 0.8202778 0.066301
+ 0.8205556 0.050000
+ 0.8208333 0.050000
+ 0.8211111 0.050000
+ 0.8213889 0.050000
+ 0.8216667 0.050000
+ 0.8219444 0.065543
+ 0.8222222 0.091945
+ 0.8225000 0.126432
+ 0.8227778 0.167245
+ 0.8230556 0.212204
+ 0.8233333 0.259129
+ 0.8236111 0.305840
+ 0.8238889 0.350158
+ 0.8241667 0.389902
+ 0.8244444 0.422893
+ 0.8247222 0.446951
+ 0.8250000 0.459895
+ 0.8252778 0.460215
+ 0.8255556 0.449072
+ 0.8258333 0.428294
+ 0.8261111 0.399712
+ 0.8263889 0.365154
+ 0.8266667 0.326450
+ 0.8269444 0.285431
+ 0.8272222 0.243924
+ 0.8275000 0.203759
+ 0.8277778 0.166767
+ 0.8280556 0.134517
+ 0.8283333 0.107548
+ 0.8286111 0.086139
+ 0.8288889 0.070570
+ 0.8291667 0.061118
+ 0.8294444 0.058065
+ 0.8297222 0.061689
+ 0.8300000 0.072269
+ 0.8302778 0.090085
+ 0.8305556 0.115417
+ 0.8308333 0.148159
+ 0.8311111 0.186674
+ 0.8313889 0.228939
+ 0.8316667 0.272932
+ 0.8319444 0.316633
+ 0.8322222 0.358017
+ 0.8325000 0.395064
+ 0.8327778 0.425752
+ 0.8330556 0.448058
+ 0.8333333 0.459961
+ 0.8336111 0.460056
+ 0.8338889 0.449413
+ 0.8341667 0.429720
+ 0.8344444 0.402662
+ 0.8347222 0.369927
+ 0.8350000 0.333203
+ 0.8352778 0.294177
+ 0.8355556 0.254536
+ 0.8358333 0.215967
+ 0.8361111 0.180157
+ 0.8363889 0.148571
+ 0.8366667 0.121781
+ 0.8369444 0.100140
+ 0.8372222 0.083995
+ 0.8375000 0.073699
+ 0.8377778 0.069601
+ 0.8380556 0.072052
+ 0.8383333 0.081403
+ 0.8386111 0.098003
+ 0.8388889 0.122203
+ 0.8391667 0.153955
+ 0.8394444 0.191612
+ 0.8397222 0.233128
+ 0.8400000 0.276460
+ 0.8402778 0.319562
+ 0.8405556 0.360389
+ 0.8408333 0.396895
+ 0.8411111 0.427036
+ 0.8413889 0.448765
+ 0.8416667 0.460039
+ 0.8419444 0.459438
+ 0.8422222 0.448044
+ 0.8425000 0.427568
+ 0.8427778 0.399717
+ 0.8430556 0.366201
+ 0.8433333 0.328730
+ 0.8436111 0.289011
+ 0.8438889 0.248754
+ 0.8441667 0.209668
+ 0.8444444 0.173462
+ 0.8447222 0.141614
+ 0.8450000 0.114683
+ 0.8452778 0.092995
+ 0.8455556 0.076878
+ 0.8458333 0.066658
+ 0.8461111 0.062664
+ 0.8463889 0.065222
+ 0.8466667 0.074659
+ 0.8469444 0.091304
+ 0.8472222 0.115482
+ 0.8475000 0.147138
+ 0.8477778 0.184681
+ 0.8480556 0.226136
+ 0.8483333 0.269529
+ 0.8486111 0.312885
+ 0.8488889 0.354229
+ 0.8491667 0.391587
+ 0.8494444 0.422985
+ 0.8497222 0.446447
+ 0.8500000 0.460000
+ 0.8502778 0.462249
+ 0.8505556 0.454124
+ 0.8508333 0.437136
+ 0.8511111 0.412794
+ 0.8513889 0.382609
+ 0.8516667 0.348091
+ 0.8519444 0.310750
+ 0.8522222 0.272097
+ 0.8525000 0.233642
+ 0.8527778 0.196894
+ 0.8530556 0.163212
+ 0.8533333 0.133338
+ 0.8536111 0.107860
+ 0.8538889 0.087369
+ 0.8541667 0.072453
+ 0.8544444 0.063702
+ 0.8547222 0.061705
+ 0.8550000 0.067052
+ 0.8552778 0.080331
+ 0.8555556 0.102131
+ 0.8558333 0.132585
+ 0.8561111 0.169988
+ 0.8563889 0.212178
+ 0.8566667 0.256993
+ 0.8569444 0.302272
+ 0.8572222 0.345852
+ 0.8575000 0.385571
+ 0.8577778 0.419269
+ 0.8580556 0.444781
+ 0.8583333 0.459948
+ 0.8586111 0.463232
+ 0.8588889 0.455607
+ 0.8591667 0.438668
+ 0.8594444 0.414014
+ 0.8597222 0.383243
+ 0.8600000 0.347952
+ 0.8602778 0.309739
+ 0.8605556 0.270203
+ 0.8608333 0.230939
+ 0.8611111 0.193547
+ 0.8613889 0.159452
+ 0.8616667 0.129392
+ 0.8619444 0.103935
+ 0.8622222 0.083645
+ 0.8625000 0.069091
+ 0.8627778 0.060838
+ 0.8630556 0.059453
+ 0.8633333 0.065503
+ 0.8636111 0.079553
+ 0.8638889 0.102171
+ 0.8641667 0.133458
+ 0.8644444 0.171661
+ 0.8647222 0.214560
+ 0.8650000 0.259938
+ 0.8652778 0.305576
+ 0.8655556 0.349255
+ 0.8658333 0.388757
+ 0.8661111 0.421863
+ 0.8663889 0.446354
+ 0.8666667 0.460013
+ 0.8669444 0.461285
+ 0.8672222 0.451271
+ 0.8675000 0.431738
+ 0.8677778 0.404451
+ 0.8680556 0.371178
+ 0.8683333 0.333683
+ 0.8686111 0.293732
+ 0.8688889 0.253093
+ 0.8691667 0.213530
+ 0.8694444 0.176809
+ 0.8697222 0.144459
+ 0.8700000 0.117049
+ 0.8702778 0.094911
+ 0.8705556 0.078378
+ 0.8708333 0.067781
+ 0.8711111 0.063452
+ 0.8713889 0.065723
+ 0.8716667 0.074927
+ 0.8719444 0.091393
+ 0.8722222 0.115456
+ 0.8725000 0.147059
+ 0.8727778 0.184600
+ 0.8730556 0.226090
+ 0.8733333 0.269538
+ 0.8736111 0.312955
+ 0.8738889 0.354351
+ 0.8741667 0.391736
+ 0.8744444 0.423122
+ 0.8747222 0.446518
+ 0.8750000 0.459935
+ 0.8752778 0.461961
+ 0.8755556 0.453506
+ 0.8758333 0.436054
+ 0.8761111 0.411092
+ 0.8763889 0.380106
+ 0.8766667 0.344584
+ 0.8769444 0.306011
+ 0.8772222 0.265874
+ 0.8775000 0.225658
+ 0.8777778 0.186852
+ 0.8780556 0.150812
+ 0.8783333 0.118386
+ 0.8786111 0.090292
+ 0.8788889 0.067249
+ 0.8791667 0.050000
+ 0.8794444 0.050000
+ 0.8797222 0.050000
+ 0.8800000 0.050000
+ 0.8802778 0.052937
+ 0.8805556 0.075286
+ 0.8808333 0.107203
+ 0.8811111 0.146847
+ 0.8813889 0.191865
+ 0.8816667 0.239904
+ 0.8819444 0.288611
+ 0.8822222 0.335633
+ 0.8825000 0.378616
+ 0.8827778 0.415207
+ 0.8830556 0.443054
+ 0.8833333 0.459804
+ 0.8836111 0.463773
+ 0.8838889 0.455964
+ 0.8841667 0.438048
+ 0.8844444 0.411698
+ 0.8847222 0.378586
+ 0.8850000 0.340384
+ 0.8852778 0.298763
+ 0.8855556 0.255397
+ 0.8858333 0.211956
+ 0.8861111 0.170114
+ 0.8863889 0.131387
+ 0.8866667 0.096669
+ 0.8869444 0.066698
+ 0.8872222 0.050000
+ 0.8875000 0.050000
+ 0.8877778 0.050000
+ 0.8880556 0.050000
+ 0.8883333 0.050000
+ 0.8886111 0.050000
+ 0.8888889 0.051840
+ 0.8891667 0.085887
+ 0.8894444 0.128091
+ 0.8897222 0.175955
+ 0.8900000 0.226982
+ 0.8902778 0.278676
+ 0.8905556 0.328539
+ 0.8908333 0.374075
+ 0.8911111 0.412787
+ 0.8913889 0.442178
+ 0.8916667 0.459752
+ 0.8919444 0.463731
+ 0.8922222 0.455222
+ 0.8925000 0.436051
+ 0.8927778 0.408044
+ 0.8930556 0.373028
+ 0.8933333 0.332829
+ 0.8936111 0.289272
+ 0.8938889 0.244185
+ 0.8941667 0.199394
+ 0.8944444 0.156724
+ 0.8947222 0.117805
+ 0.8950000 0.083468
+ 0.8952778 0.054350
+ 0.8955556 0.050000
+ 0.8958333 0.050000
+ 0.8961111 0.050000
+ 0.8963889 0.050000
+ 0.8966667 0.050000
+ 0.8969444 0.050000
+ 0.8972222 0.050000
+ 0.8975000 0.084984
+ 0.8977778 0.127822
+ 0.8980556 0.176068
+ 0.8983333 0.227275
+ 0.8986111 0.278999
+ 0.8988889 0.328792
+ 0.8991667 0.374208
+ 0.8994444 0.412802
+ 0.8997222 0.442128
+ 0.9000000 0.459738
+ 0.9002778 0.463895
+ 0.9005556 0.455685
+ 0.9008333 0.436902
+ 0.9011111 0.409340
+ 0.9013889 0.374793
+ 0.9016667 0.335055
+ 0.9019444 0.291920
+ 0.9022222 0.247182
+ 0.9025000 0.202634
+ 0.9027778 0.160072
+ 0.9030556 0.121100
+ 0.9033333 0.086571
+ 0.9036111 0.057149
+ 0.9038889 0.050000
+ 0.9041667 0.050000
+ 0.9044444 0.050000
+ 0.9047222 0.050000
+ 0.9050000 0.050000
+ 0.9052778 0.050000
+ 0.9055556 0.050000
+ 0.9058333 0.084828
+ 0.9061111 0.127607
+ 0.9063889 0.175868
+ 0.9066667 0.227140
+ 0.9069444 0.278955
+ 0.9072222 0.328841
+ 0.9075000 0.374330
+ 0.9077778 0.412952
+ 0.9080556 0.442236
+ 0.9083333 0.459712
+ 0.9086111 0.463627
+ 0.9088889 0.455084
+ 0.9091667 0.435905
+ 0.9094444 0.407910
+ 0.9097222 0.372918
+ 0.9100000 0.332750
+ 0.9102778 0.289227
+ 0.9105556 0.244168
+ 0.9108333 0.199394
+ 0.9111111 0.156724
+ 0.9113889 0.117784
+ 0.9116667 0.083411
+ 0.9119444 0.054249
+ 0.9122222 0.050000
+ 0.9125000 0.050000
+ 0.9127778 0.050000
+ 0.9130556 0.050000
+ 0.9133333 0.050000
+ 0.9136111 0.050000
+ 0.9138889 0.050000
+ 0.9141667 0.085142
+ 0.9144444 0.128166
+ 0.9147222 0.176602
+ 0.9150000 0.227980
+ 0.9152778 0.279832
+ 0.9155556 0.329685
+ 0.9158333 0.375071
+ 0.9161111 0.413520
+ 0.9163889 0.442561
+ 0.9166667 0.459725
+ 0.9169444 0.463261
+ 0.9172222 0.454291
+ 0.9175000 0.434657
+ 0.9177778 0.406203
+ 0.9180556 0.370769
+ 0.9183333 0.330197
+ 0.9186111 0.286330
+ 0.9188889 0.241010
+ 0.9191667 0.196078
+ 0.9194444 0.153377
+ 0.9197222 0.114544
+ 0.9200000 0.080400
+ 0.9202778 0.051561
+ 0.9205556 0.050000
+ 0.9208333 0.050000
+ 0.9211111 0.050000
+ 0.9213889 0.050000
+ 0.9216667 0.050000
+ 0.9219444 0.050000
+ 0.9222222 0.050000
+ 0.9225000 0.085278
+ 0.9227778 0.128346
+ 0.9230556 0.176756
+ 0.9233333 0.228062
+ 0.9236111 0.279819
+ 0.9238889 0.329579
+ 0.9241667 0.374896
+ 0.9244444 0.413324
+ 0.9247222 0.442416
+ 0.9250000 0.459725
+ 0.9252778 0.463517
+ 0.9255556 0.454894
+ 0.9258333 0.435672
+ 0.9261111 0.407664
+ 0.9263889 0.372685
+ 0.9266667 0.332549
+ 0.9269444 0.289070
+ 0.9272222 0.244064
+ 0.9275000 0.199344
+ 0.9277778 0.156724
+ 0.9280556 0.117825
+ 0.9283333 0.083483
+ 0.9286111 0.054342
+ 0.9288889 0.050000
+ 0.9291667 0.050000
+ 0.9294444 0.050000
+ 0.9297222 0.050000
+ 0.9300000 0.050000
+ 0.9302778 0.050000
+ 0.9305556 0.050000
+ 0.9308333 0.085098
+ 0.9311111 0.128075
+ 0.9313889 0.176466
+ 0.9316667 0.227804
+ 0.9319444 0.279624
+ 0.9322222 0.329460
+ 0.9325000 0.374847
+ 0.9327778 0.413317
+ 0.9330556 0.442406
+ 0.9333333 0.459647
+ 0.9336111 0.463290
+ 0.9338889 0.454447
+ 0.9341667 0.434944
+ 0.9344444 0.406607
+ 0.9347222 0.371264
+ 0.9350000 0.330740
+ 0.9352778 0.286863
+ 0.9355556 0.241459
+ 0.9358333 0.196355
+ 0.9361111 0.153377
+ 0.9363889 0.114160
+ 0.9366667 0.079568
+ 0.9369444 0.050273
+ 0.9372222 0.050000
+ 0.9375000 0.050000
+ 0.9377778 0.050000
+ 0.9380556 0.050000
+ 0.9383333 0.050000
+ 0.9386111 0.050000
+ 0.9388889 0.050000
+ 0.9391667 0.086729
+ 0.9394444 0.131477
+ 0.9397222 0.181592
+ 0.9400000 0.234417
+ 0.9402778 0.287299
+ 0.9405556 0.337583
+ 0.9408333 0.382615
+ 0.9411111 0.419739
+ 0.9413889 0.446301
+ 0.9416667 0.459647
+ 0.9419444 0.457936
+ 0.9422222 0.442585
+ 0.9425000 0.415826
+ 0.9427778 0.379888
+ 0.9430556 0.337004
+ 0.9433333 0.289404
+ 0.9436111 0.239319
+ 0.9438889 0.188982
+ 0.9441667 0.140621
+ 0.9444444 0.096469
+ 0.9447222 0.058430
+ 0.9450000 0.050000
+ 0.9452778 0.050000
+ 0.9455556 0.050000
+ 0.9458333 0.050000
+ 0.9461111 0.050000
+ 0.9463889 0.050000
+ 0.9466667 0.050000
+ 0.9469444 0.050000
+ 0.9472222 0.050000
+ 0.9475000 0.090614
+ 0.9477778 0.137877
+ 0.9480556 0.189321
+ 0.9483333 0.242480
+ 0.9486111 0.294888
+ 0.9488889 0.344079
+ 0.9491667 0.387585
+ 0.9494444 0.422940
+ 0.9497222 0.447679
+ 0.9500000 0.459333
+ 0.9502778 0.456217
+ 0.9505556 0.439761
+ 0.9508333 0.412176
+ 0.9511111 0.375671
+ 0.9513889 0.332458
+ 0.9516667 0.284746
+ 0.9519444 0.234746
+ 0.9522222 0.184669
+ 0.9525000 0.136724
+ 0.9527778 0.093122
+ 0.9530556 0.055741
+ 0.9533333 0.050000
+ 0.9536111 0.050000
+ 0.9538889 0.050000
+ 0.9541667 0.050000
+ 0.9544444 0.050000
+ 0.9547222 0.050000
+ 0.9550000 0.050000
+ 0.9552778 0.050000
+ 0.9555556 0.050000
+ 0.9558333 0.089715
+ 0.9561111 0.136173
+ 0.9563889 0.187391
+ 0.9566667 0.241389
+ 0.9569444 0.296188
+ 0.9572222 0.349805
+ 0.9575000 0.400261
+ 0.9577778 0.445575
+ 0.9580556 0.483766
+ 0.9583333 0.512854
+ 0.9586111 0.531378
+ 0.9588889 0.539961
+ 0.9591667 0.539747
+ 0.9594444 0.531877
+ 0.9597222 0.517495
+ 0.9600000 0.497744
+ 0.9602778 0.473768
+ 0.9605556 0.446708
+ 0.9608333 0.417708
+ 0.9611111 0.387911
+ 0.9613889 0.358380
+ 0.9616667 0.329853
+ 0.9619444 0.302992
+ 0.9622222 0.278454
+ 0.9625000 0.256900
+ 0.9627778 0.238988
+ 0.9630556 0.225378
+ 0.9633333 0.216730
+ 0.9636111 0.213702
+ 0.9638889 0.216953
+ 0.9641667 0.226919
+ 0.9644444 0.243130
+ 0.9647222 0.264895
+ 0.9650000 0.291519
+ 0.9652778 0.322311
+ 0.9655556 0.356576
+ 0.9658333 0.393622
+ 0.9661111 0.432756
+ 0.9663889 0.473285
+ 0.9666667 0.514515
+ 0.9669444 0.555582
+ 0.9672222 0.594942
+ 0.9675000 0.630877
+ 0.9677778 0.661671
+ 0.9680556 0.685607
+ 0.9683333 0.700968
+ 0.9686111 0.706038
+ 0.9688889 0.699100
+ 0.9691667 0.678438
+ 0.9694444 0.642334
+ 0.9697222 0.590069
+ 0.9700000 0.524902
+ 0.9702778 0.451093
+ 0.9705556 0.372897
+ 0.9708333 0.294571
+ 0.9711111 0.220373
+ 0.9713889 0.154560
+ 0.9716667 0.101389
+ 0.9719444 0.065116
+ 0.9722222 0.050000
+ 0.9725000 0.058814
+ 0.9727778 0.088404
+ 0.9730556 0.134132
+ 0.9733333 0.191362
+ 0.9736111 0.255455
+ 0.9738889 0.321774
+ 0.9741667 0.385682
+ 0.9744444 0.442542
+ 0.9747222 0.487716
+ 0.9750000 0.516568
+ 0.9752778 0.525802
+ 0.9755556 0.517498
+ 0.9758333 0.495078
+ 0.9761111 0.461966
+ 0.9763889 0.421582
+ 0.9766667 0.377350
+ 0.9769444 0.332691
+ 0.9772222 0.291029
+ 0.9775000 0.255785
+ 0.9777778 0.230382
+ 0.9780556 0.217385
+ 0.9783333 0.215929
+ 0.9786111 0.224291
+ 0.9788889 0.240748
+ 0.9791667 0.263578
+ 0.9794444 0.291058
+ 0.9797222 0.321466
+ 0.9800000 0.353079
+ 0.9802778 0.384175
+ 0.9805556 0.413030
+ 0.9808333 0.438184
+ 0.9811111 0.459217
+ 0.9813889 0.475971
+ 0.9816667 0.488287
+ 0.9819444 0.496008
+ 0.9822222 0.498976
+ 0.9825000 0.497031
+ 0.9827778 0.490016
+ 0.9830556 0.477773
+ 0.9833333 0.460144
+ 0.9836111 0.437137
+ 0.9838889 0.409429
+ 0.9841667 0.377866
+ 0.9844444 0.343292
+ 0.9847222 0.306550
+ 0.9850000 0.268487
+ 0.9852778 0.229946
+ 0.9855556 0.191772
+ 0.9858333 0.154809
+ 0.9861111 0.119902
+ 0.9863889 0.087876
+ 0.9866667 0.059476
+ 0.9869444 0.050000
+ 0.9872222 0.050000
+ 0.9875000 0.050000
+ 0.9877778 0.050000
+ 0.9880556 0.050000
+ 0.9883333 0.050000
+ 0.9886111 0.050000
+ 0.9888889 0.050000
+ 0.9891667 0.086389
+ 0.9894444 0.130446
+ 0.9897222 0.179675
+ 0.9900000 0.231581
+ 0.9902778 0.283668
+ 0.9905556 0.333440
+ 0.9908333 0.378401
+ 0.9911111 0.416056
+ 0.9913889 0.443909
+ 0.9916667 0.459464
+ 0.9919444 0.460969
+ 0.9922222 0.449647
+ 0.9925000 0.427465
+ 0.9927778 0.396389
+ 0.9930556 0.358385
+ 0.9933333 0.315421
+ 0.9936111 0.269464
+ 0.9938889 0.222478
+ 0.9941667 0.176432
+ 0.9944444 0.133292
+ 0.9947222 0.094780
+ 0.9950000 0.061640
+ 0.9952778 0.050000
+ 0.9955556 0.050000
+ 0.9958333 0.050000
+ 0.9961111 0.050000
+ 0.9963889 0.050000
+ 0.9966667 0.050000
+ 0.9969444 0.050000
+ 0.9972222 0.050000
+ 0.9975000 0.087241
+ 0.9977778 0.131891
+ 0.9980556 0.181480
+ 0.9983333 0.233542
+ 0.9986111 0.285607
+ 0.9988889 0.335207
+ 0.9991667 0.379875
+ 0.9994444 0.417141
+ 0.9997222 0.444537
+ 1.0000000 0.459595
+ 1.0002778 0.460588
+ 1.0005556 0.448754
+ 1.0008333 0.426075
+ 1.0011111 0.394529
+ 1.0013889 0.356097
+ 1.0016667 0.312759
+ 1.0019444 0.266494
+ 1.0022222 0.219284
+ 1.0025000 0.173107
+ 1.0027778 0.129944
+ 1.0030556 0.091526
+ 1.0033333 0.058583
+ 1.0036111 0.050000
+ 1.0038889 0.050000
+ 1.0041667 0.050000
+ 1.0044444 0.050000
+ 1.0047222 0.050000
+ 1.0050000 0.050000
+ 1.0052778 0.050000
+ 1.0055556 0.050000
+ 1.0058333 0.087533
+ 1.0061111 0.132411
+ 1.0063889 0.182164
+ 1.0066667 0.234323
+ 1.0069444 0.286420
+ 1.0072222 0.335987
+ 1.0075000 0.380554
+ 1.0077778 0.417652
+ 1.0080556 0.444813
+ 1.0083333 0.459568
+ 1.0086111 0.460194
+ 1.0088889 0.447946
+ 1.0091667 0.424824
+ 1.0094444 0.392831
+ 1.0097222 0.353966
+ 1.0100000 0.310230
+ 1.0102778 0.263625
+ 1.0105556 0.216150
+ 1.0108333 0.169807
+ 1.0111111 0.126597
+ 1.0113889 0.088263
+ 1.0116667 0.055522
+ 1.0119444 0.050000
+ 1.0122222 0.050000
+ 1.0125000 0.050000
+ 1.0127778 0.050000
+ 1.0130556 0.050000
+ 1.0133333 0.050000
+ 1.0136111 0.050000
+ 1.0138889 0.050000
+ 1.0141667 0.087760
+ 1.0144444 0.132787
+ 1.0147222 0.182620
+ 1.0150000 0.234804
+ 1.0152778 0.286878
+ 1.0155556 0.336387
+ 1.0158333 0.380871
+ 1.0161111 0.417872
+ 1.0163889 0.444933
+ 1.0166667 0.459595
+ 1.0169444 0.460143
+ 1.0172222 0.447835
+ 1.0175000 0.424671
+ 1.0177778 0.392652
+ 1.0180556 0.353778
+ 1.0183333 0.310049
+ 1.0186111 0.263467
+ 1.0188889 0.216030
+ 1.0191667 0.169740
+ 1.0194444 0.126597
+ 1.0197222 0.088343
+ 1.0200000 0.055687
+ 1.0202778 0.050000
+ 1.0205556 0.050000
+ 1.0208333 0.050000
+ 1.0211111 0.050000
+ 1.0213889 0.050000
+ 1.0216667 0.050000
+ 1.0219444 0.050000
+ 1.0222222 0.050000
+ 1.0225000 0.087510
+ 1.0227778 0.132248
+ 1.0230556 0.181791
+ 1.0233333 0.233716
+ 1.0236111 0.285600
+ 1.0238889 0.335021
+ 1.0241667 0.379555
+ 1.0244444 0.416779
+ 1.0247222 0.444271
+ 1.0250000 0.459608
+ 1.0252778 0.461092
+ 1.0255556 0.449926
+ 1.0258333 0.428039
+ 1.0261111 0.397359
+ 1.0263889 0.359816
+ 1.0266667 0.317337
+ 1.0269444 0.271852
+ 1.0272222 0.225288
+ 1.0275000 0.179574
+ 1.0277778 0.136639
+ 1.0280556 0.098178
+ 1.0283333 0.064945
+ 1.0286111 0.050000
+ 1.0288889 0.050000
+ 1.0291667 0.050000
+ 1.0294444 0.050000
+ 1.0297222 0.050000
+ 1.0300000 0.050000
+ 1.0302778 0.050000
+ 1.0305556 0.050000
+ 1.0308333 0.086831
+ 1.0311111 0.131133
+ 1.0313889 0.180449
+ 1.0316667 0.232319
+ 1.0319444 0.284288
+ 1.0322222 0.333897
+ 1.0325000 0.378688
+ 1.0327778 0.416205
+ 1.0330556 0.443988
+ 1.0333333 0.459582
+ 1.0336111 0.461259
+ 1.0338889 0.450224
+ 1.0341667 0.428414
+ 1.0344444 0.397763
+ 1.0347222 0.360209
+ 1.0350000 0.317687
+ 1.0352778 0.272133
+ 1.0355556 0.225483
+ 1.0358333 0.179673
+ 1.0361111 0.136639
+ 1.0363889 0.098083
+ 1.0366667 0.064766
+ 1.0369444 0.050000
+ 1.0372222 0.050000
+ 1.0375000 0.050000
+ 1.0377778 0.050000
+ 1.0380556 0.050000
+ 1.0383333 0.050000
+ 1.0386111 0.050000
+ 1.0388889 0.050000
+ 1.0391667 0.087022
+ 1.0394444 0.131539
+ 1.0397222 0.181068
+ 1.0400000 0.233129
+ 1.0402778 0.285237
+ 1.0405556 0.334913
+ 1.0408333 0.379672
+ 1.0411111 0.417033
+ 1.0413889 0.444515
+ 1.0416667 0.459634
+ 1.0419444 0.460654
+ 1.0422222 0.448818
+ 1.0425000 0.426114
+ 1.0427778 0.394532
+ 1.0430556 0.356060
+ 1.0433333 0.312686
+ 1.0436111 0.266399
+ 1.0438889 0.219187
+ 1.0441667 0.173039
+ 1.0444444 0.129944
+ 1.0447222 0.091636
+ 1.0450000 0.058832
+ 1.0452778 0.050000
+ 1.0455556 0.050000
+ 1.0458333 0.050000
+ 1.0461111 0.050000
+ 1.0463889 0.050000
+ 1.0466667 0.050000
+ 1.0469444 0.050000
+ 1.0472222 0.050000
+ 1.0475000 0.087055
+ 1.0477778 0.131376
+ 1.0480556 0.180563
+ 1.0483333 0.232219
+ 1.0486111 0.283943
+ 1.0488889 0.333338
+ 1.0491667 0.378005
+ 1.0494444 0.415545
+ 1.0497222 0.443558
+ 1.0500000 0.459647
+ 1.0502778 0.462122
+ 1.0505556 0.452133
+ 1.0508333 0.431539
+ 1.0511111 0.402201
+ 1.0513889 0.365978
+ 1.0516667 0.324730
+ 1.0519444 0.280317
+ 1.0522222 0.234598
+ 1.0525000 0.189433
+ 1.0527778 0.146682
+ 1.0530556 0.107993
+ 1.0533333 0.074171
+ 1.0536111 0.050000
+ 1.0538889 0.050000
+ 1.0541667 0.050000
+ 1.0544444 0.050000
+ 1.0547222 0.050000
+ 1.0550000 0.050000
+ 1.0552778 0.050000
+ 1.0555556 0.050000
+ 1.0558333 0.086165
+ 1.0561111 0.130044
+ 1.0563889 0.179144
+ 1.0566667 0.230971
+ 1.0569444 0.283033
+ 1.0572222 0.332837
+ 1.0575000 0.377889
+ 1.0577778 0.415697
+ 1.0580556 0.443768
+ 1.0583333 0.459608
+ 1.0586111 0.461464
+ 1.0588889 0.450542
+ 1.0591667 0.428788
+ 1.0594444 0.398147
+ 1.0597222 0.360565
+ 1.0600000 0.317988
+ 1.0602778 0.272361
+ 1.0605556 0.225630
+ 1.0608333 0.179741
+ 1.0611111 0.136639
+ 1.0613889 0.098034
+ 1.0616667 0.064685
+ 1.0619444 0.050000
+ 1.0622222 0.050000
+ 1.0625000 0.050000
+ 1.0627778 0.050000
+ 1.0630556 0.050000
+ 1.0633333 0.050000
+ 1.0636111 0.050000
+ 1.0638889 0.050000
+ 1.0641667 0.087035
+ 1.0644444 0.131560
+ 1.0647222 0.181094
+ 1.0650000 0.233155
+ 1.0652778 0.285263
+ 1.0655556 0.334935
+ 1.0658333 0.379691
+ 1.0661111 0.417049
+ 1.0663889 0.444528
+ 1.0666667 0.459647
+ 1.0669444 0.460669
+ 1.0672222 0.448836
+ 1.0675000 0.426137
+ 1.0677778 0.394559
+ 1.0680556 0.356090
+ 1.0683333 0.312717
+ 1.0686111 0.266429
+ 1.0688889 0.219212
+ 1.0691667 0.173055
+ 1.0694444 0.129944
+ 1.0697222 0.091615
+ 1.0700000 0.058786
+ 1.0702778 0.050000
+ 1.0705556 0.050000
+ 1.0708333 0.050000
+ 1.0711111 0.050000
+ 1.0713889 0.050000
+ 1.0716667 0.050000
+ 1.0719444 0.050000
+ 1.0722222 0.050000
+ 1.0725000 0.087134
+ 1.0727778 0.131545
+ 1.0730556 0.180825
+ 1.0733333 0.232562
+ 1.0736111 0.284346
+ 1.0738889 0.333767
+ 1.0741667 0.378416
+ 1.0744444 0.415881
+ 1.0747222 0.443753
+ 1.0750000 0.459621
+ 1.0752778 0.461790
+ 1.0755556 0.451428
+ 1.0758333 0.430418
+ 1.0761111 0.400642
+ 1.0763889 0.363983
+ 1.0766667 0.322323
+ 1.0769444 0.277546
+ 1.0772222 0.231533
+ 1.0775000 0.186169
+ 1.0777778 0.143334
+ 1.0780556 0.104695
+ 1.0783333 0.071041
+ 1.0786111 0.050000
+ 1.0788889 0.050000
+ 1.0791667 0.050000
+ 1.0794444 0.050000
+ 1.0797222 0.050000
+ 1.0800000 0.050000
+ 1.0802778 0.050000
+ 1.0805556 0.050000
+ 1.0808333 0.086470
+ 1.0811111 0.130586
+ 1.0813889 0.179855
+ 1.0816667 0.231783
+ 1.0819444 0.283878
+ 1.0822222 0.333646
+ 1.0825000 0.378595
+ 1.0827778 0.416231
+ 1.0830556 0.444062
+ 1.0833333 0.459595
+ 1.0836111 0.461079
+ 1.0838889 0.449739
+ 1.0841667 0.427540
+ 1.0844444 0.396449
+ 1.0847222 0.358433
+ 1.0850000 0.315457
+ 1.0852778 0.269489
+ 1.0855556 0.222494
+ 1.0858333 0.176440
+ 1.0861111 0.133292
+ 1.0863889 0.094773
+ 1.0866667 0.061627
+ 1.0869444 0.050000
+ 1.0872222 0.050000
+ 1.0875000 0.050000
+ 1.0877778 0.050000
+ 1.0880556 0.050000
+ 1.0883333 0.050000
+ 1.0886111 0.050000
+ 1.0888889 0.050000
+ 1.0891667 0.087254
+ 1.0894444 0.131918
+ 1.0897222 0.181522
+ 1.0900000 0.233597
+ 1.0902778 0.285673
+ 1.0905556 0.335279
+ 1.0908333 0.379947
+ 1.0911111 0.417207
+ 1.0913889 0.444588
+ 1.0916667 0.459621
+ 1.0919444 0.460578
+ 1.0922222 0.448703
+ 1.0925000 0.425980
+ 1.0927778 0.394395
+ 1.0930556 0.355933
+ 1.0933333 0.312579
+ 1.0936111 0.266318
+ 1.0938889 0.219135
+ 1.0941667 0.173015
+ 1.0944444 0.129944
+ 1.0947222 0.091654
+ 1.0950000 0.058860
+ 1.0952778 0.050000
+ 1.0955556 0.050000
+ 1.0958333 0.050000
+ 1.0961111 0.050000
+ 1.0963889 0.050000
+ 1.0966667 0.050000
+ 1.0969444 0.050000
+ 1.0972222 0.050000
+ 1.0975000 0.087051
+ 1.0977778 0.131369
+ 1.0980556 0.180555
+ 1.0983333 0.232210
+ 1.0986111 0.283935
+ 1.0988889 0.333330
+ 1.0991667 0.377997
+ 1.0994444 0.415536
+ 1.0997222 0.443548
+ 1.1000000 0.459634
+ 1.1002778 0.462104
+ 1.1005556 0.452109
+ 1.1008333 0.431510
+ 1.1011111 0.402168
+ 1.1013889 0.365941
+ 1.1016667 0.324693
+ 1.1019444 0.280282
+ 1.1022222 0.234569
+ 1.1025000 0.189416
+ 1.1027778 0.146682
+ 1.1030556 0.108016
+ 1.1033333 0.074221
+ 1.1036111 0.050000
+ 1.1038889 0.050000
+ 1.1041667 0.050000
+ 1.1044444 0.050000
+ 1.1047222 0.050000
+ 1.1050000 0.050000
+ 1.1052778 0.050000
+ 1.1055556 0.050000
+ 1.1058333 0.086080
+ 1.1061111 0.129861
+ 1.1063889 0.178861
+ 1.1066667 0.230601
+ 1.1069444 0.282598
+ 1.1072222 0.332374
+ 1.1075000 0.377446
+ 1.1077778 0.415333
+ 1.1080556 0.443556
+ 1.1083333 0.459634
+ 1.1086111 0.461818
+ 1.1088889 0.451296
+ 1.1091667 0.429986
+ 1.1094444 0.399807
+ 1.1097222 0.362680
+ 1.1100000 0.320523
+ 1.1102778 0.275256
+ 1.1105556 0.228798
+ 1.1108333 0.183068
+ 1.1111111 0.139987
+ 1.1113889 0.101246
+ 1.1116667 0.067628
+ 1.1119444 0.050000
+ 1.1122222 0.050000
+ 1.1125000 0.050000
+ 1.1127778 0.050000
+ 1.1130556 0.050000
+ 1.1133333 0.050000
+ 1.1136111 0.050000
+ 1.1138889 0.050000
+ 1.1141667 0.087051
+ 1.1144444 0.131711
+ 1.1147222 0.181454
+ 1.1150000 0.233751
+ 1.1152778 0.286076
+ 1.1155556 0.335902
+ 1.1158333 0.380700
+ 1.1161111 0.417944
+ 1.1163889 0.445107
+ 1.1166667 0.459660
+ 1.1169444 0.459841
+ 1.1172222 0.446944
+ 1.1175000 0.423026
+ 1.1177778 0.390146
+ 1.1180556 0.350361
+ 1.1183333 0.305730
+ 1.1186111 0.258311
+ 1.1188889 0.210161
+ 1.1191667 0.163339
+ 1.1194444 0.119902
+ 1.1197222 0.081634
+ 1.1200000 0.050000
+ 1.1202778 0.050000
+ 1.1205556 0.050000
+ 1.1208333 0.050000
+ 1.1211111 0.050000
+ 1.1213889 0.050000
+ 1.1216667 0.050000
+ 1.1219444 0.050000
+ 1.1222222 0.050000
+ 1.1225000 0.088296
+ 1.1227778 0.133702
+ 1.1230556 0.183774
+ 1.1233333 0.236067
+ 1.1236111 0.288137
+ 1.1238889 0.337542
+ 1.1241667 0.381837
+ 1.1244444 0.418577
+ 1.1247222 0.445320
+ 1.1250000 0.459621
+ 1.1252778 0.459779
+ 1.1255556 0.447062
+ 1.1258333 0.423483
+ 1.1261111 0.391053
+ 1.1263889 0.351784
+ 1.1266667 0.307687
+ 1.1269444 0.260773
+ 1.1272222 0.213055
+ 1.1275000 0.166543
+ 1.1277778 0.123249
+ 1.1280556 0.084926
+ 1.1283333 0.052285
+ 1.1286111 0.050000
+ 1.1288889 0.050000
+ 1.1291667 0.050000
+ 1.1294444 0.050000
+ 1.1297222 0.050000
+ 1.1300000 0.050000
+ 1.1302778 0.050000
+ 1.1305556 0.050000
+ 1.1308333 0.088363
+ 1.1311111 0.133976
+ 1.1313889 0.184338
+ 1.1316667 0.236945
+ 1.1319444 0.289294
+ 1.1322222 0.338883
+ 1.1325000 0.383209
+ 1.1327778 0.419769
+ 1.1330556 0.446061
+ 1.1333333 0.459582
+ 1.1336111 0.458596
+ 1.1338889 0.444443
+ 1.1341667 0.419227
+ 1.1344444 0.385054
+ 1.1347222 0.344031
+ 1.1350000 0.298263
+ 1.1352778 0.249856
+ 1.1355556 0.200916
+ 1.1358333 0.153548
+ 1.1361111 0.109859
+ 1.1363889 0.071666
+ 1.1366667 0.050000
+ 1.1369444 0.050000
+ 1.1372222 0.050000
+ 1.1375000 0.050000
+ 1.1377778 0.050000
+ 1.1380556 0.050000
+ 1.1383333 0.050000
+ 1.1386111 0.050000
+ 1.1388889 0.050000
+ 1.1391667 0.089760
+ 1.1394444 0.136522
+ 1.1397222 0.187761
+ 1.1400000 0.240951
+ 1.1402778 0.293567
+ 1.1405556 0.343082
+ 1.1408333 0.386971
+ 1.1411111 0.422707
+ 1.1413889 0.447766
+ 1.1416667 0.459621
+ 1.1419444 0.456540
+ 1.1422222 0.439964
+ 1.1425000 0.412129
+ 1.1427778 0.375270
+ 1.1430556 0.331622
+ 1.1433333 0.283420
+ 1.1436111 0.232899
+ 1.1438889 0.182295
+ 1.1441667 0.133841
+ 1.1444444 0.089774
+ 1.1447222 0.051997
+ 1.1450000 0.050000
+ 1.1452778 0.050000
+ 1.1455556 0.050000
+ 1.1458333 0.050000
+ 1.1461111 0.050000
+ 1.1463889 0.050000
+ 1.1466667 0.050000
+ 1.1469444 0.050000
+ 1.1472222 0.050000
+ 1.1475000 0.091326
+ 1.1477778 0.139209
+ 1.1480556 0.191161
+ 1.1483333 0.244691
+ 1.1486111 0.297309
+ 1.1488889 0.346527
+ 1.1491667 0.389854
+ 1.1494444 0.424801
+ 1.1497222 0.448878
+ 1.1500000 0.459595
+ 1.1502778 0.455258
+ 1.1505556 0.437354
+ 1.1508333 0.408168
+ 1.1511111 0.369982
+ 1.1513889 0.325080
+ 1.1516667 0.275744
+ 1.1519444 0.224258
+ 1.1522222 0.172905
+ 1.1525000 0.123969
+ 1.1527778 0.079732
+ 1.1530556 0.050000
+ 1.1533333 0.050000
+ 1.1536111 0.050000
+ 1.1538889 0.050000
+ 1.1541667 0.050000
+ 1.1544444 0.050000
+ 1.1547222 0.050000
+ 1.1550000 0.050000
+ 1.1552778 0.050000
+ 1.1555556 0.050000
+ 1.1558333 0.092460
+ 1.1561111 0.141321
+ 1.1563889 0.194057
+ 1.1566667 0.248142
+ 1.1569444 0.301051
+ 1.1572222 0.350257
+ 1.1575000 0.393237
+ 1.1577778 0.427463
+ 1.1580556 0.450412
+ 1.1583333 0.459555
+ 1.1586111 0.453193
+ 1.1588889 0.432917
+ 1.1591667 0.401141
+ 1.1594444 0.360283
+ 1.1597222 0.312756
+ 1.1600000 0.260978
+ 1.1602778 0.207362
+ 1.1605556 0.154324
+ 1.1608333 0.104281
+ 1.1611111 0.059647
+ 1.1613889 0.050000
+ 1.1616667 0.050000
+ 1.1619444 0.050000
+ 1.1622222 0.050000
+ 1.1625000 0.050000
+ 1.1627778 0.050000
+ 1.1630556 0.050000
+ 1.1633333 0.050000
+ 1.1636111 0.050000
+ 1.1638889 0.050000
+ 1.1641667 0.094038
+ 1.1644444 0.144032
+ 1.1647222 0.197493
+ 1.1650000 0.251929
+ 1.1652778 0.304853
+ 1.1655556 0.353772
+ 1.1658333 0.396199
+ 1.1661111 0.429643
+ 1.1663889 0.451613
+ 1.1666667 0.459621
+ 1.1669444 0.452002
+ 1.1672222 0.430396
+ 1.1675000 0.397271
+ 1.1677778 0.355091
+ 1.1680556 0.306325
+ 1.1683333 0.253437
+ 1.1686111 0.198894
+ 1.1688889 0.145163
+ 1.1691667 0.094709
+ 1.1694444 0.050000
+ 1.1697222 0.050000
+ 1.1700000 0.050000
+ 1.1702778 0.050000
+ 1.1705556 0.050000
+ 1.1708333 0.050000
+ 1.1711111 0.050000
+ 1.1713889 0.050000
+ 1.1716667 0.050000
+ 1.1719444 0.050000
+ 1.1722222 0.050000
+ 1.1725000 0.094663
+ 1.1727778 0.145056
+ 1.1730556 0.198722
+ 1.1733333 0.253203
+ 1.1736111 0.306042
+ 1.1738889 0.354781
+ 1.1741667 0.396962
+ 1.1744444 0.430127
+ 1.1747222 0.451820
+ 1.1750000 0.459582
+ 1.1752778 0.451775
+ 1.1755556 0.430039
+ 1.1758333 0.396837
+ 1.1761111 0.354627
+ 1.1763889 0.305870
+ 1.1766667 0.253027
+ 1.1769444 0.198558
+ 1.1772222 0.144924
+ 1.1775000 0.094584
+ 1.1777778 0.050000
+ 1.1780556 0.050000
+ 1.1783333 0.050000
+ 1.1786111 0.050000
+ 1.1788889 0.050000
+ 1.1791667 0.050000
+ 1.1794444 0.050000
+ 1.1797222 0.050000
+ 1.1800000 0.050000
+ 1.1802778 0.050000
+ 1.1805556 0.050000
+ 1.1808333 0.094342
+ 1.1811111 0.144371
+ 1.1813889 0.197670
+ 1.1816667 0.251827
+ 1.1819444 0.304427
+ 1.1822222 0.353054
+ 1.1825000 0.395295
+ 1.1827778 0.428736
+ 1.1830556 0.450960
+ 1.1833333 0.459555
+ 1.1836111 0.452904
+ 1.1838889 0.432584
+ 1.1841667 0.400971
+ 1.1844444 0.360439
+ 1.1847222 0.313365
+ 1.1850000 0.262124
+ 1.1852778 0.209091
+ 1.1855556 0.156641
+ 1.1858333 0.107150
+ 1.1861111 0.062994
+ 1.1863889 0.050000
+ 1.1866667 0.050000
+ 1.1869444 0.050000
+ 1.1872222 0.050000
+ 1.1875000 0.050000
+ 1.1877778 0.050000
+ 1.1880556 0.050000
+ 1.1883333 0.050000
+ 1.1886111 0.050000
+ 1.1888889 0.050000
+ 1.1891667 0.092665
+ 1.1894444 0.141203
+ 1.1897222 0.193271
+ 1.1900000 0.246523
+ 1.1902778 0.298614
+ 1.1905556 0.347200
+ 1.1908333 0.389936
+ 1.1911111 0.424477
+ 1.1913889 0.448478
+ 1.1916667 0.459595
+ 1.1919444 0.456232
+ 1.1922222 0.439796
+ 1.1925000 0.412445
+ 1.1927778 0.376333
+ 1.1930556 0.333618
+ 1.1933333 0.286456
+ 1.1936111 0.237003
+ 1.1938889 0.187417
+ 1.1941667 0.139854
+ 1.1944444 0.096469
+ 1.1947222 0.059104
+ 1.1950000 0.050000
+ 1.1952778 0.050000
+ 1.1955556 0.050000
+ 1.1958333 0.050000
+ 1.1961111 0.050000
+ 1.1963889 0.050000
+ 1.1966667 0.050000
+ 1.1969444 0.050000
+ 1.1972222 0.050000
+ 1.1975000 0.089585
+ 1.1977778 0.135717
+ 1.1980556 0.186056
+ 1.1983333 0.238262
+ 1.1986111 0.289996
+ 1.1988889 0.338920
+ 1.1991667 0.382692
+ 1.1994444 0.418975
+ 1.1997222 0.445428
+ 1.2000000 0.459712
+ 1.2002778 0.460203
+ 1.2005556 0.448134
+ 1.2008333 0.425454
+ 1.2011111 0.394112
+ 1.2013889 0.356057
+ 1.2016667 0.313238
+ 1.2019444 0.267603
+ 1.2022222 0.221101
+ 1.2025000 0.175681
+ 1.2027778 0.133292
+ 1.2030556 0.095632
+ 1.2033333 0.063402
+ 1.2036111 0.050000
+ 1.2038889 0.050000
+ 1.2041667 0.050000
+ 1.2044444 0.050000
+ 1.2047222 0.050000
+ 1.2050000 0.050000
+ 1.2052778 0.050000
+ 1.2055556 0.055057
+ 1.2058333 0.091489
+ 1.2061111 0.135061
+ 1.2063889 0.183432
+ 1.2066667 0.234262
+ 1.2069444 0.285209
+ 1.2072222 0.333932
+ 1.2075000 0.378090
+ 1.2077778 0.415342
+ 1.2080556 0.443347
+ 1.2083333 0.459765
+ 1.2086111 0.462948
+ 1.2088889 0.454032
+ 1.2091667 0.434847
+ 1.2094444 0.407224
+ 1.2097222 0.372993
+ 1.2100000 0.333983
+ 1.2102778 0.292025
+ 1.2105556 0.248950
+ 1.2108333 0.206587
+ 1.2111111 0.166767
+ 1.2113889 0.131094
+ 1.2116667 0.100269
+ 1.2119444 0.074769
+ 1.2122222 0.055068
+ 1.2125000 0.050000
+ 1.2127778 0.050000
+ 1.2130556 0.050000
+ 1.2133333 0.050000
+ 1.2136111 0.060214
+ 1.2138889 0.085302
+ 1.2141667 0.119064
+ 1.2144444 0.159688
+ 1.2147222 0.204911
+ 1.2150000 0.252465
+ 1.2152778 0.300085
+ 1.2155556 0.345504
+ 1.2158333 0.386457
+ 1.2161111 0.420677
+ 1.2163889 0.445899
+ 1.2166667 0.459856
+ 1.2169444 0.460962
+ 1.2172222 0.450343
+ 1.2175000 0.429806
+ 1.2177778 0.401157
+ 1.2180556 0.366203
+ 1.2183333 0.326750
+ 1.2186111 0.284604
+ 1.2188889 0.241571
+ 1.2191667 0.199459
+ 1.2194444 0.160072
+ 1.2197222 0.124989
+ 1.2200000 0.094876
+ 1.2202778 0.070168
+ 1.2205556 0.051303
+ 1.2208333 0.050000
+ 1.2211111 0.050000
+ 1.2213889 0.050000
+ 1.2216667 0.050000
+ 1.2219444 0.059911
+ 1.2222222 0.085276
+ 1.2225000 0.119102
+ 1.2227778 0.159620
+ 1.2230556 0.204626
+ 1.2233333 0.251910
+ 1.2236111 0.299267
+ 1.2238889 0.344488
+ 1.2241667 0.385368
+ 1.2244444 0.419698
+ 1.2247222 0.445272
+ 1.2250000 0.459882
+ 1.2252778 0.461978
+ 1.2255556 0.452633
+ 1.2258333 0.433575
+ 1.2261111 0.406533
+ 1.2263889 0.373238
+ 1.2266667 0.335417
+ 1.2269444 0.294800
+ 1.2272222 0.253115
+ 1.2275000 0.212093
+ 1.2277778 0.173462
+ 1.2280556 0.138744
+ 1.2283333 0.108633
+ 1.2286111 0.083615
+ 1.2288889 0.064179
+ 1.2291667 0.050810
+ 1.2294444 0.050000
+ 1.2297222 0.050000
+ 1.2300000 0.051979
+ 1.2302778 0.067750
+ 1.2305556 0.092024
+ 1.2308333 0.124836
+ 1.2311111 0.164427
+ 1.2313889 0.208586
+ 1.2316667 0.255103
+ 1.2319444 0.301766
+ 1.2322222 0.346365
+ 1.2325000 0.386689
+ 1.2327778 0.420528
+ 1.2330556 0.445672
+ 1.2333333 0.459908
+ 1.2336111 0.461689
+ 1.2338889 0.452106
+ 1.2341667 0.432914
+ 1.2344444 0.405866
+ 1.2347222 0.372715
+ 1.2350000 0.335216
+ 1.2352778 0.295123
+ 1.2355556 0.254188
+ 1.2358333 0.214165
+ 1.2361111 0.176809
+ 1.2363889 0.143647
+ 1.2366667 0.115296
+ 1.2369444 0.092150
+ 1.2372222 0.074600
+ 1.2375000 0.063038
+ 1.2377778 0.057858
+ 1.2380556 0.059451
+ 1.2383333 0.068208
+ 1.2386111 0.084523
+ 1.2388889 0.108787
+ 1.2391667 0.140978
+ 1.2394444 0.179413
+ 1.2397222 0.221994
+ 1.2400000 0.266623
+ 1.2402778 0.311203
+ 1.2405556 0.353637
+ 1.2408333 0.391825
+ 1.2411111 0.423672
+ 1.2413889 0.447079
+ 1.2416667 0.459948
+ 1.2419444 0.460811
+ 1.2422222 0.450716
+ 1.2425000 0.431342
+ 1.2427778 0.404365
+ 1.2430556 0.371464
+ 1.2433333 0.334316
+ 1.2436111 0.294599
+ 1.2438889 0.253990
+ 1.2441667 0.214168
+ 1.2444444 0.176809
+ 1.2447222 0.143387
+ 1.2450000 0.114549
+ 1.2452778 0.090739
+ 1.2455556 0.072400
+ 1.2458333 0.059974
+ 1.2461111 0.053906
+ 1.2463889 0.054638
+ 1.2466667 0.062613
+ 1.2469444 0.078275
+ 1.2472222 0.102066
+ 1.2475000 0.134005
+ 1.2477778 0.172412
+ 1.2480556 0.215182
+ 1.2483333 0.260210
+ 1.2486111 0.305391
+ 1.2488889 0.348621
+ 1.2491667 0.387796
+ 1.2494444 0.420809
+ 1.2497222 0.445557
+ 1.2500000 0.459935
+ 1.2502778 0.462454
+ 1.2505556 0.454092
+ 1.2508333 0.436445
+ 1.2511111 0.411106
+ 1.2513889 0.379671
+ 1.2516667 0.343733
+ 1.2519444 0.304888
+ 1.2522222 0.264730
+ 1.2525000 0.224853
+ 1.2527778 0.186852
+ 1.2530556 0.152153
+ 1.2533333 0.121506
+ 1.2536111 0.095494
+ 1.2538889 0.074698
+ 1.2541667 0.059699
+ 1.2544444 0.051080
+ 1.2547222 0.050000
+ 1.2550000 0.055308
+ 1.2552778 0.069319
+ 1.2555556 0.092037
+ 1.2558333 0.123577
+ 1.2561111 0.162190
+ 1.2563889 0.205661
+ 1.2566667 0.251774
+ 1.2569444 0.298314
+ 1.2572222 0.343066
+ 1.2575000 0.383814
+ 1.2577778 0.418343
+ 1.2580556 0.444438
+ 1.2583333 0.459882
+ 1.2586111 0.463107
+ 1.2588889 0.455125
+ 1.2591667 0.437595
+ 1.2594444 0.412175
+ 1.2597222 0.380524
+ 1.2600000 0.344300
+ 1.2602778 0.305163
+ 1.2605556 0.264770
+ 1.2608333 0.224780
+ 1.2611111 0.186852
+ 1.2613889 0.152457
+ 1.2616667 0.122318
+ 1.2619444 0.096973
+ 1.2622222 0.076955
+ 1.2625000 0.062803
+ 1.2627778 0.055052
+ 1.2630556 0.054239
+ 1.2633333 0.060899
+ 1.2636111 0.075568
+ 1.2638889 0.098784
+ 1.2641667 0.130623
+ 1.2644444 0.169325
+ 1.2647222 0.212675
+ 1.2650000 0.258453
+ 1.2652778 0.304441
+ 1.2655556 0.348423
+ 1.2658333 0.388180
+ 1.2661111 0.421493
+ 1.2663889 0.446147
+ 1.2666667 0.459922
+ 1.2669444 0.461259
+ 1.2672222 0.451234
+ 1.2675000 0.431581
+ 1.2677778 0.404035
+ 1.2680556 0.370330
+ 1.2683333 0.332200
+ 1.2686111 0.291379
+ 1.2688889 0.249602
+ 1.2691667 0.208602
+ 1.2694444 0.170114
+ 1.2697222 0.135660
+ 1.2700000 0.105909
+ 1.2702778 0.081317
+ 1.2705556 0.062342
+ 1.2708333 0.050000
+ 1.2711111 0.050000
+ 1.2713889 0.050000
+ 1.2716667 0.051733
+ 1.2719444 0.067687
+ 1.2722222 0.091997
+ 1.2725000 0.124685
+ 1.2727778 0.164030
+ 1.2730556 0.207877
+ 1.2733333 0.254073
+ 1.2736111 0.300463
+ 1.2738889 0.344891
+ 1.2741667 0.385203
+ 1.2744444 0.419244
+ 1.2747222 0.444860
+ 1.2750000 0.459895
+ 1.2752778 0.462825
+ 1.2755556 0.454640
+ 1.2758333 0.436961
+ 1.2761111 0.411409
+ 1.2763889 0.379604
+ 1.2766667 0.343167
+ 1.2769444 0.303718
+ 1.2772222 0.262877
+ 1.2775000 0.222266
+ 1.2777778 0.183504
+ 1.2780556 0.148044
+ 1.2783333 0.116662
+ 1.2786111 0.089966
+ 1.2788889 0.068563
+ 1.2791667 0.053061
+ 1.2794444 0.050000
+ 1.2797222 0.050000
+ 1.2800000 0.050000
+ 1.2802778 0.062212
+ 1.2805556 0.085329
+ 1.2808333 0.117510
+ 1.2811111 0.156953
+ 1.2813889 0.201375
+ 1.2816667 0.248492
+ 1.2819444 0.296019
+ 1.2822222 0.341672
+ 1.2825000 0.383168
+ 1.2827778 0.418222
+ 1.2830556 0.444551
+ 1.2833333 0.459869
+ 1.2836111 0.462562
+ 1.2838889 0.453688
+ 1.2841667 0.434973
+ 1.2844444 0.408144
+ 1.2847222 0.374928
+ 1.2850000 0.337050
+ 1.2852778 0.296238
+ 1.2855556 0.254219
+ 1.2858333 0.212718
+ 1.2861111 0.173462
+ 1.2863889 0.137979
+ 1.2866667 0.107001
+ 1.2869444 0.081062
+ 1.2872222 0.060693
+ 1.2875000 0.050000
+ 1.2877778 0.050000
+ 1.2880556 0.050000
+ 1.2883333 0.050000
+ 1.2886111 0.061075
+ 1.2888889 0.085329
+ 1.2891667 0.118417
+ 1.2894444 0.158536
+ 1.2897222 0.203412
+ 1.2900000 0.250775
+ 1.2902778 0.298351
+ 1.2905556 0.343867
+ 1.2908333 0.385052
+ 1.2911111 0.419634
+ 1.2913889 0.445339
+ 1.2916667 0.459895
+ 1.2919444 0.461702
+ 1.2922222 0.451842
+ 1.2925000 0.432068
+ 1.2927778 0.404136
+ 1.2930556 0.369798
+ 1.2933333 0.330809
+ 1.2936111 0.288923
+ 1.2938889 0.245893
+ 1.2941667 0.203474
+ 1.2944444 0.163419
+ 1.2947222 0.127280
+ 1.2950000 0.095791
+ 1.2952778 0.069487
+ 1.2955556 0.050000
+ 1.2958333 0.050000
+ 1.2961111 0.050000
+ 1.2963889 0.050000
+ 1.2966667 0.050000
+ 1.2969444 0.050350
+ 1.2972222 0.075247
+ 1.2975000 0.109118
+ 1.2977778 0.150136
+ 1.2980556 0.196004
+ 1.2983333 0.244424
+ 1.2986111 0.293099
+ 1.2988889 0.339730
+ 1.2991667 0.382021
+ 1.2994444 0.417673
+ 1.2997222 0.444388
+ 1.3000000 0.459869
+ 1.3002778 0.462494
+ 1.3005556 0.453342
+ 1.3008333 0.434169
+ 1.3011111 0.406729
+ 1.3013889 0.372777
+ 1.3016667 0.334068
+ 1.3019444 0.292358
+ 1.3022222 0.249401
+ 1.3025000 0.206952
+ 1.3027778 0.166767
+ 1.3030556 0.130400
+ 1.3033333 0.098605
+ 1.3036111 0.071934
+ 1.3038889 0.050943
+ 1.3041667 0.050000
+ 1.3044444 0.050000
+ 1.3047222 0.050000
+ 1.3050000 0.050000
+ 1.3052778 0.050533
+ 1.3055556 0.075234
+ 1.3058333 0.109008
+ 1.3061111 0.150013
+ 1.3063889 0.195928
+ 1.3066667 0.244430
+ 1.3069444 0.293199
+ 1.3072222 0.339913
+ 1.3075000 0.382251
+ 1.3077778 0.417891
+ 1.3080556 0.444511
+ 1.3083333 0.459791
+ 1.3086111 0.462094
+ 1.3088889 0.452524
+ 1.3091667 0.432874
+ 1.3094444 0.404932
+ 1.3097222 0.370489
+ 1.3100000 0.331335
+ 1.3102778 0.289261
+ 1.3105556 0.246057
+ 1.3108333 0.203513
+ 1.3111111 0.163419
+ 1.3113889 0.127354
+ 1.3116667 0.096045
+ 1.3119444 0.070008
+ 1.3122222 0.050000
+ 1.3125000 0.050000
+ 1.3127778 0.050000
+ 1.3130556 0.050000
+ 1.3133333 0.050000
+ 1.3136111 0.053323
+ 1.3138889 0.078607
+ 1.3141667 0.112811
+ 1.3144444 0.154082
+ 1.3147222 0.200098
+ 1.3150000 0.248534
+ 1.3152778 0.297067
+ 1.3155556 0.343371
+ 1.3158333 0.385124
+ 1.3161111 0.420000
+ 1.3163889 0.445677
+ 1.3166667 0.459830
+ 1.3169444 0.460829
+ 1.3172222 0.449818
+ 1.3175000 0.428637
+ 1.3177778 0.399123
+ 1.3180556 0.363116
+ 1.3183333 0.322454
+ 1.3186111 0.278976
+ 1.3188889 0.234520
+ 1.3191667 0.190925
+ 1.3194444 0.150029
+ 1.3197222 0.113446
+ 1.3200000 0.081887
+ 1.3202778 0.055836
+ 1.3205556 0.050000
+ 1.3208333 0.050000
+ 1.3211111 0.050000
+ 1.3213889 0.050000
+ 1.3216667 0.050000
+ 1.3219444 0.050000
+ 1.3222222 0.068473
+ 1.3225000 0.103492
+ 1.3227778 0.145589
+ 1.3230556 0.192454
+ 1.3233333 0.241774
+ 1.3236111 0.291240
+ 1.3238889 0.338539
+ 1.3241667 0.381360
+ 1.3244444 0.417392
+ 1.3247222 0.444324
+ 1.3250000 0.459843
+ 1.3252778 0.462321
+ 1.3255556 0.452851
+ 1.3258333 0.433209
+ 1.3261111 0.405171
+ 1.3263889 0.370513
+ 1.3266667 0.331011
+ 1.3269444 0.288440
+ 1.3272222 0.244576
+ 1.3275000 0.201195
+ 1.3277778 0.160072
+ 1.3280556 0.122785
+ 1.3283333 0.090117
+ 1.3286111 0.062651
+ 1.3288889 0.050000
+ 1.3291667 0.050000
+ 1.3294444 0.050000
+ 1.3297222 0.050000
+ 1.3300000 0.050000
+ 1.3302778 0.050000
+ 1.3305556 0.065152
+ 1.3308333 0.099845
+ 1.3311111 0.142010
+ 1.3313889 0.189242
+ 1.3316667 0.239137
+ 1.3319444 0.289290
+ 1.3322222 0.337296
+ 1.3325000 0.380750
+ 1.3327778 0.417247
+ 1.3330556 0.444382
+ 1.3333333 0.459752
+ 1.3336111 0.461666
+ 1.3338889 0.451301
+ 1.3341667 0.430549
+ 1.3344444 0.401302
+ 1.3347222 0.365452
+ 1.3350000 0.324891
+ 1.3352778 0.281511
+ 1.3355556 0.237204
+ 1.3358333 0.193862
+ 1.3361111 0.153377
+ 1.3363889 0.117398
+ 1.3366667 0.086600
+ 1.3369444 0.061415
+ 1.3372222 0.050000
+ 1.3375000 0.050000
+ 1.3377778 0.050000
+ 1.3380556 0.050000
+ 1.3383333 0.050000
+ 1.3386111 0.052386
+ 1.3388889 0.078594
+ 1.3391667 0.113422
+ 1.3394444 0.155046
+ 1.3397222 0.201192
+ 1.3400000 0.249586
+ 1.3402778 0.297955
+ 1.3405556 0.344023
+ 1.3408333 0.385518
+ 1.3411111 0.420164
+ 1.3413889 0.445689
+ 1.3416667 0.459817
+ 1.3419444 0.460951
+ 1.3422222 0.450197
+ 1.3425000 0.429337
+ 1.3427778 0.400152
+ 1.3430556 0.364426
+ 1.3433333 0.323939
+ 1.3436111 0.280474
+ 1.3438889 0.235813
+ 1.3441667 0.191737
+ 1.3444444 0.150029
+ 1.3447222 0.112271
+ 1.3450000 0.079244
+ 1.3452778 0.051530
+ 1.3455556 0.050000
+ 1.3458333 0.050000
+ 1.3461111 0.050000
+ 1.3463889 0.050000
+ 1.3466667 0.050000
+ 1.3469444 0.050000
+ 1.3472222 0.055110
+ 1.3475000 0.090326
+ 1.3477778 0.133107
+ 1.3480556 0.181054
+ 1.3483333 0.231768
+ 1.3486111 0.282849
+ 1.3488889 0.331900
+ 1.3491667 0.376520
+ 1.3494444 0.414313
+ 1.3497222 0.442878
+ 1.3500000 0.459817
+ 1.3502778 0.463429
+ 1.3505556 0.454806
+ 1.3508333 0.435736
+ 1.3511111 0.408010
+ 1.3513889 0.373417
+ 1.3516667 0.333746
+ 1.3519444 0.290786
+ 1.3522222 0.246328
+ 1.3525000 0.202160
+ 1.3527778 0.160072
+ 1.3530556 0.121661
+ 1.3533333 0.087757
+ 1.3536111 0.058995
+ 1.3538889 0.050000
+ 1.3541667 0.050000
+ 1.3544444 0.050000
+ 1.3547222 0.050000
+ 1.3550000 0.050000
+ 1.3552778 0.050000
+ 1.3555556 0.055162
+ 1.3558333 0.089955
+ 1.3561111 0.132538
+ 1.3563889 0.180461
+ 1.3566667 0.231275
+ 1.3569444 0.282531
+ 1.3572222 0.331782
+ 1.3575000 0.376578
+ 1.3577778 0.414471
+ 1.3580556 0.443012
+ 1.3583333 0.459752
+ 1.3586111 0.462959
+ 1.3588889 0.453773
+ 1.3591667 0.434048
+ 1.3594444 0.405639
+ 1.3597222 0.370401
+ 1.3600000 0.330191
+ 1.3602778 0.286863
+ 1.3605556 0.242272
+ 1.3608333 0.198274
+ 1.3611111 0.156724
+ 1.3613889 0.119259
+ 1.3616667 0.086639
+ 1.3619444 0.059407
+ 1.3622222 0.050000
+ 1.3625000 0.050000
+ 1.3627778 0.050000
+ 1.3630556 0.050000
+ 1.3633333 0.050000
+ 1.3636111 0.050000
+ 1.3638889 0.065204
+ 1.3641667 0.100114
+ 1.3644444 0.142373
+ 1.3647222 0.189605
+ 1.3650000 0.239433
+ 1.3652778 0.289479
+ 1.3655556 0.337366
+ 1.3658333 0.380718
+ 1.3661111 0.417158
+ 1.3663889 0.444308
+ 1.3666667 0.459791
+ 1.3669444 0.461934
+ 1.3672222 0.451876
+ 1.3675000 0.431461
+ 1.3677778 0.402532
+ 1.3680556 0.366932
+ 1.3683333 0.326504
+ 1.3686111 0.283092
+ 1.3688889 0.238537
+ 1.3691667 0.194685
+ 1.3694444 0.153377
+ 1.3697222 0.116236
+ 1.3700000 0.084003
+ 1.3702778 0.057197
+ 1.3705556 0.050000
+ 1.3708333 0.050000
+ 1.3711111 0.050000
+ 1.3713889 0.050000
+ 1.3716667 0.050000
+ 1.3719444 0.050000
+ 1.3722222 0.065152
+ 1.3725000 0.099990
+ 1.3727778 0.142079
+ 1.3730556 0.189084
+ 1.3733333 0.238673
+ 1.3736111 0.288513
+ 1.3738889 0.336269
+ 1.3741667 0.379610
+ 1.3744444 0.416202
+ 1.3747222 0.443711
+ 1.3750000 0.459804
+ 1.3752778 0.462832
+ 1.3755556 0.453881
+ 1.3758333 0.434721
+ 1.3761111 0.407122
+ 1.3763889 0.372853
+ 1.3766667 0.333686
+ 1.3769444 0.291388
+ 1.3772222 0.247732
+ 1.3775000 0.204485
+ 1.3777778 0.163419
+ 1.3780556 0.126107
+ 1.3783333 0.093333
+ 1.3786111 0.065688
+ 1.3788889 0.050000
+ 1.3791667 0.050000
+ 1.3794444 0.050000
+ 1.3797222 0.050000
+ 1.3800000 0.050000
+ 1.3802778 0.050000
+ 1.3805556 0.065191
+ 1.3808333 0.099269
+ 1.3811111 0.140826
+ 1.3813889 0.187508
+ 1.3816667 0.236957
+ 1.3819444 0.286817
+ 1.3822222 0.334730
+ 1.3825000 0.378341
+ 1.3827778 0.415292
+ 1.3830556 0.443228
+ 1.3833333 0.459791
+ 1.3836111 0.463313
+ 1.3838889 0.454881
+ 1.3841667 0.436271
+ 1.3844444 0.409257
+ 1.3847222 0.375615
+ 1.3850000 0.337119
+ 1.3852778 0.295547
+ 1.3855556 0.252671
+ 1.3858333 0.210269
+ 1.3861111 0.170114
+ 1.3863889 0.133779
+ 1.3866667 0.102018
+ 1.3869444 0.075380
+ 1.3872222 0.054416
+ 1.3875000 0.050000
+ 1.3877778 0.050000
+ 1.3880556 0.050000
+ 1.3883333 0.050000
+ 1.3886111 0.053970
+ 1.3888889 0.078607
+ 1.3891667 0.112291
+ 1.3894444 0.153171
+ 1.3897222 0.198919
+ 1.3900000 0.247207
+ 1.3902778 0.295706
+ 1.3905556 0.342086
+ 1.3908333 0.384018
+ 1.3911111 0.419175
+ 1.3913889 0.445226
+ 1.3916667 0.459843
+ 1.3919444 0.461389
+ 1.3922222 0.450995
+ 1.3925000 0.430484
+ 1.3927778 0.401678
+ 1.3930556 0.366400
+ 1.3933333 0.326473
+ 1.3936111 0.283719
+ 1.3938889 0.239961
+ 1.3941667 0.197022
+ 1.3944444 0.156724
+ 1.3947222 0.120666
+ 1.3950000 0.089546
+ 1.3952778 0.063838
+ 1.3955556 0.050000
+ 1.3958333 0.050000
+ 1.3961111 0.050000
+ 1.3963889 0.050000
+ 1.3966667 0.050000
+ 1.3969444 0.050000
+ 1.3972222 0.075181
+ 1.3975000 0.109360
+ 1.3977778 0.150490
+ 1.3980556 0.196321
+ 1.3983333 0.244604
+ 1.3986111 0.293090
+ 1.3988889 0.339529
+ 1.3991667 0.381672
+ 1.3994444 0.417269
+ 1.3997222 0.444072
+ 1.4000000 0.459830
+ 1.4002778 0.462953
+ 1.4005556 0.454482
+ 1.4008333 0.436120
+ 1.4011111 0.409566
+ 1.4013889 0.376521
+ 1.4016667 0.338686
+ 1.4019444 0.297762
+ 1.4022222 0.255450
+ 1.4025000 0.213449
+ 1.4027778 0.173462
+ 1.4030556 0.137005
+ 1.4033333 0.104863
+ 1.4036111 0.077637
+ 1.4038889 0.055929
+ 1.4041667 0.050000
+ 1.4044444 0.050000
+ 1.4047222 0.050000
+ 1.4050000 0.050000
+ 1.4052778 0.051197
+ 1.4055556 0.075221
+ 1.4058333 0.108481
+ 1.4061111 0.149131
+ 1.4063889 0.194831
+ 1.4066667 0.243245
+ 1.4069444 0.292033
+ 1.4072222 0.338859
+ 1.4075000 0.381384
+ 1.4077778 0.417271
+ 1.4080556 0.444181
+ 1.4083333 0.459778
+ 1.4086111 0.462410
+ 1.4088889 0.453178
+ 1.4091667 0.433870
+ 1.4094444 0.406274
+ 1.4097222 0.372177
+ 1.4100000 0.333368
+ 1.4102778 0.291635
+ 1.4105556 0.248765
+ 1.4108333 0.206546
+ 1.4111111 0.166767
+ 1.4113889 0.131000
+ 1.4116667 0.099961
+ 1.4119444 0.074151
+ 1.4122222 0.054071
+ 1.4125000 0.050000
+ 1.4127778 0.050000
+ 1.4130556 0.050000
+ 1.4133333 0.050000
+ 1.4136111 0.057150
+ 1.4138889 0.081968
+ 1.4141667 0.115561
+ 1.4144444 0.156125
+ 1.4147222 0.201396
+ 1.4150000 0.249109
+ 1.4152778 0.296999
+ 1.4155556 0.342802
+ 1.4158333 0.384253
+ 1.4161111 0.419086
+ 1.4163889 0.445038
+ 1.4166667 0.459843
+ 1.4169444 0.461904
+ 1.4172222 0.452290
+ 1.4175000 0.432737
+ 1.4177778 0.404982
+ 1.4180556 0.370760
+ 1.4183333 0.331808
+ 1.4186111 0.289862
+ 1.4188889 0.246657
+ 1.4191667 0.203931
+ 1.4194444 0.163419
+ 1.4197222 0.126665
+ 1.4200000 0.094435
+ 1.4202778 0.067306
+ 1.4205556 0.050000
+ 1.4208333 0.050000
+ 1.4211111 0.050000
+ 1.4213889 0.050000
+ 1.4216667 0.050000
+ 1.4219444 0.050000
+ 1.4222222 0.068513
+ 1.4225000 0.102402
+ 1.4227778 0.143663
+ 1.4230556 0.189970
+ 1.4233333 0.238993
+ 1.4236111 0.288406
+ 1.4238889 0.335881
+ 1.4241667 0.379089
+ 1.4244444 0.415705
+ 1.4247222 0.443398
+ 1.4250000 0.459843
+ 1.4252778 0.463391
+ 1.4255556 0.455115
+ 1.4258333 0.436766
+ 1.4261111 0.410096
+ 1.4263889 0.376858
+ 1.4266667 0.338804
+ 1.4269444 0.297685
+ 1.4272222 0.255254
+ 1.4275000 0.213262
+ 1.4277778 0.173462
+ 1.4280556 0.137406
+ 1.4283333 0.105849
+ 1.4286111 0.079346
+ 1.4288889 0.058453
+ 1.4291667 0.050000
+ 1.4294444 0.050000
+ 1.4297222 0.050000
+ 1.4300000 0.050000
+ 1.4302778 0.057549
+ 1.4305556 0.081968
+ 1.4308333 0.115401
+ 1.4311111 0.156005
+ 1.4313889 0.201452
+ 1.4316667 0.249419
+ 1.4319444 0.297580
+ 1.4322222 0.343609
+ 1.4325000 0.385182
+ 1.4327778 0.419973
+ 1.4330556 0.445657
+ 1.4333333 0.459908
+ 1.4336111 0.461107
+ 1.4338889 0.450450
+ 1.4341667 0.429842
+ 1.4344444 0.401184
+ 1.4347222 0.366380
+ 1.4350000 0.327333
+ 1.4352778 0.285945
+ 1.4355556 0.244120
+ 1.4358333 0.203759
+ 1.4361111 0.166767
+ 1.4363889 0.134767
+ 1.4366667 0.108269
+ 1.4369444 0.087505
+ 1.4372222 0.072706
+ 1.4375000 0.064103
+ 1.4377778 0.061929
+ 1.4380556 0.066413
+ 1.4383333 0.077789
+ 1.4386111 0.096287
+ 1.4388889 0.122138
+ 1.4391667 0.155198
+ 1.4394444 0.193819
+ 1.4397222 0.235976
+ 1.4400000 0.279645
+ 1.4402778 0.322800
+ 1.4405556 0.363419
+ 1.4408333 0.399475
+ 1.4411111 0.428944
+ 1.4413889 0.449803
+ 1.4416667 0.460026
+ 1.4419444 0.458224
+ 1.4422222 0.445547
+ 1.4425000 0.423779
+ 1.4427778 0.394704
+ 1.4430556 0.360109
+ 1.4433333 0.321776
+ 1.4436111 0.281491
+ 1.4438889 0.241038
+ 1.4441667 0.202202
+ 1.4444444 0.166767
+ 1.4447222 0.136255
+ 1.4450000 0.111134
+ 1.4452778 0.091609
+ 1.4455556 0.077885
+ 1.4458333 0.070167
+ 1.4461111 0.068659
+ 1.4463889 0.073567
+ 1.4466667 0.085095
+ 1.4469444 0.103449
+ 1.4472222 0.128833
+ 1.4475000 0.161098
+ 1.4477778 0.198677
+ 1.4480556 0.239650
+ 1.4483333 0.282095
+ 1.4486111 0.324091
+ 1.4488889 0.363717
+ 1.4491667 0.399053
+ 1.4494444 0.428177
+ 1.4497222 0.449168
+ 1.4500000 0.460105
+ 1.4502778 0.459663
+ 1.4505556 0.448904
+ 1.4508333 0.429483
+ 1.4511111 0.403058
+ 1.4513889 0.371286
+ 1.4516667 0.335822
+ 1.4519444 0.298325
+ 1.4522222 0.260451
+ 1.4525000 0.223857
+ 1.4527778 0.190199
+ 1.4530556 0.160901
+ 1.4533333 0.136449
+ 1.4536111 0.117096
+ 1.4538889 0.103093
+ 1.4541667 0.094695
+ 1.4544444 0.092152
+ 1.4547222 0.095719
+ 1.4550000 0.105647
+ 1.4552778 0.122188
+ 1.4555556 0.145597
+ 1.4558333 0.175771
+ 1.4561111 0.211200
+ 1.4563889 0.250020
+ 1.4566667 0.290367
+ 1.4569444 0.330375
+ 1.4572222 0.368182
+ 1.4575000 0.401923
+ 1.4577778 0.429733
+ 1.4580556 0.449748
+ 1.4583333 0.460105
+ 1.4586111 0.459509
+ 1.4588889 0.448954
+ 1.4591667 0.430003
+ 1.4594444 0.404218
+ 1.4597222 0.373163
+ 1.4600000 0.338401
+ 1.4602778 0.301495
+ 1.4605556 0.264008
+ 1.4608333 0.227505
+ 1.4611111 0.193547
+ 1.4613889 0.163496
+ 1.4616667 0.137904
+ 1.4619444 0.117120
+ 1.4622222 0.101495
+ 1.4625000 0.091379
+ 1.4627778 0.087120
+ 1.4630556 0.089068
+ 1.4633333 0.097575
+ 1.4636111 0.112988
+ 1.4638889 0.135659
+ 1.4641667 0.165558
+ 1.4644444 0.201143
+ 1.4647222 0.240494
+ 1.4650000 0.281690
+ 1.4652778 0.322810
+ 1.4655556 0.361935
+ 1.4658333 0.397144
+ 1.4661111 0.426515
+ 1.4663889 0.448129
+ 1.4666667 0.460065
+ 1.4669444 0.460979
+ 1.4672222 0.451827
+ 1.4675000 0.434143
+ 1.4677778 0.409460
+ 1.4680556 0.379311
+ 1.4683333 0.345229
+ 1.4686111 0.308749
+ 1.4688889 0.271402
+ 1.4691667 0.234722
+ 1.4694444 0.200242
+ 1.4697222 0.169311
+ 1.4700000 0.142537
+ 1.4702778 0.120346
+ 1.4705556 0.103161
+ 1.4708333 0.091407
+ 1.4711111 0.085508
+ 1.4713889 0.085888
+ 1.4716667 0.092973
+ 1.4719444 0.107185
+ 1.4722222 0.128951
+ 1.4725000 0.158298
+ 1.4727778 0.193674
+ 1.4730556 0.233133
+ 1.4733333 0.274727
+ 1.4736111 0.316508
+ 1.4738889 0.356529
+ 1.4741667 0.392843
+ 1.4744444 0.423502
+ 1.4747222 0.446558
+ 1.4750000 0.460065
+ 1.4752778 0.462648
+ 1.4755556 0.455218
+ 1.4758333 0.439263
+ 1.4761111 0.416267
+ 1.4763889 0.387716
+ 1.4766667 0.355096
+ 1.4769444 0.319892
+ 1.4772222 0.283590
+ 1.4775000 0.247674
+ 1.4777778 0.213632
+ 1.4780556 0.182780
+ 1.4783333 0.155768
+ 1.4786111 0.133076
+ 1.4788889 0.115187
+ 1.4791667 0.102580
+ 1.4794444 0.095737
+ 1.4797222 0.095140
+ 1.4800000 0.101269
+ 1.4802778 0.114606
+ 1.4805556 0.135633
+ 1.4808333 0.164414
+ 1.4811111 0.199360
+ 1.4813889 0.238464
+ 1.4816667 0.279720
+ 1.4819444 0.321121
+ 1.4822222 0.360663
+ 1.4825000 0.396338
+ 1.4827778 0.426141
+ 1.4830556 0.448065
+ 1.4833333 0.460105
+ 1.4836111 0.460852
+ 1.4838889 0.451290
+ 1.4841667 0.433003
+ 1.4844444 0.407570
+ 1.4847222 0.376576
+ 1.4850000 0.341602
+ 1.4852778 0.304230
+ 1.4855556 0.266042
+ 1.4858333 0.228620
+ 1.4861111 0.193547
+ 1.4863889 0.162210
+ 1.4866667 0.135218
+ 1.4869444 0.112988
+ 1.4872222 0.095934
+ 1.4875000 0.084471
+ 1.4877778 0.079015
+ 1.4880556 0.079981
+ 1.4883333 0.087785
+ 1.4886111 0.102840
+ 1.4888889 0.125564
+ 1.4891667 0.155964
+ 1.4894444 0.192428
+ 1.4897222 0.232934
+ 1.4900000 0.275464
+ 1.4902778 0.317996
+ 1.4905556 0.358511
+ 1.4908333 0.394989
+ 1.4911111 0.425410
+ 1.4913889 0.447753
+ 1.4916667 0.460000
+ 1.4919444 0.460727
+ 1.4922222 0.450901
+ 1.4925000 0.432087
+ 1.4927778 0.405850
+ 1.4930556 0.373754
+ 1.4933333 0.337365
+ 1.4936111 0.298245
+ 1.4938889 0.257961
+ 1.4941667 0.218077
+ 1.4944444 0.180157
+ 1.4947222 0.145601
+ 1.4950000 0.115152
+ 1.4952778 0.089387
+ 1.4955556 0.068883
+ 1.4958333 0.054218
+ 1.4961111 0.050000
+ 1.4963889 0.050000
+ 1.4966667 0.051026
+ 1.4969444 0.065488
+ 1.4972222 0.088676
+ 1.4975000 0.120699
+ 1.4977778 0.159797
+ 1.4980556 0.203741
+ 1.4983333 0.250303
+ 1.4986111 0.297255
+ 1.4988889 0.342370
+ 1.4991667 0.383418
+ 1.4994444 0.418171
+ 1.4997222 0.444402
+ 1.5000000 0.459882
+ 1.5002778 0.463027
+ 1.5005556 0.454826
+ 1.5008333 0.436914
+ 1.5011111 0.410923
+ 1.5013889 0.378487
+ 1.5016667 0.341240
+ 1.5019444 0.300815
+ 1.5022222 0.258846
+ 1.5025000 0.216966
+ 1.5027778 0.176809
+ 1.5030556 0.139848
+ 1.5033333 0.106911
+ 1.5036111 0.078668
+ 1.5038889 0.055787
+ 1.5041667 0.050000
+ 1.5044444 0.050000
+ 1.5047222 0.050000
+ 1.5050000 0.050000
+ 1.5052778 0.050000
+ 1.5055556 0.068539
+ 1.5058333 0.101405
+ 1.5061111 0.141954
+ 1.5063889 0.187826
+ 1.5066667 0.236660
+ 1.5069444 0.286099
+ 1.5072222 0.333781
+ 1.5075000 0.377349
+ 1.5077778 0.414441
+ 1.5080556 0.442700
+ 1.5083333 0.459765
+ 1.5086111 0.463954
+ 1.5088889 0.456298
+ 1.5091667 0.438503
+ 1.5094444 0.412276
+ 1.5097222 0.379325
+ 1.5100000 0.341358
+ 1.5102778 0.300080
+ 1.5105556 0.257200
+ 1.5108333 0.214425
+ 1.5111111 0.173462
+ 1.5113889 0.135844
+ 1.5116667 0.102410
+ 1.5119444 0.073824
+ 1.5122222 0.050750
+ 1.5125000 0.050000
+ 1.5127778 0.050000
+ 1.5130556 0.050000
+ 1.5133333 0.050000
+ 1.5136111 0.050000
+ 1.5138889 0.065270
+ 1.5141667 0.098871
+ 1.5144444 0.140218
+ 1.5147222 0.186894
+ 1.5150000 0.236482
+ 1.5152778 0.286565
+ 1.5155556 0.334725
+ 1.5158333 0.378547
+ 1.5161111 0.415611
+ 1.5163889 0.443503
+ 1.5166667 0.459804
+ 1.5169444 0.462800
+ 1.5172222 0.453591
+ 1.5175000 0.433978
+ 1.5177778 0.405763
+ 1.5180556 0.370747
+ 1.5183333 0.330733
+ 1.5186111 0.287522
+ 1.5188889 0.242916
+ 1.5191667 0.198716
+ 1.5194444 0.156724
+ 1.5197222 0.118544
+ 1.5200000 0.084978
+ 1.5202778 0.056631
+ 1.5205556 0.050000
+ 1.5208333 0.050000
+ 1.5211111 0.050000
+ 1.5213889 0.050000
+ 1.5216667 0.050000
+ 1.5219444 0.050000
+ 1.5222222 0.055123
+ 1.5225000 0.089794
+ 1.5227778 0.132129
+ 1.5230556 0.179737
+ 1.5233333 0.230228
+ 1.5236111 0.281208
+ 1.5238889 0.330288
+ 1.5241667 0.375077
+ 1.5244444 0.413182
+ 1.5247222 0.442213
+ 1.5250000 0.459778
+ 1.5252778 0.464174
+ 1.5255556 0.456450
+ 1.5258333 0.438344
+ 1.5261111 0.411591
+ 1.5263889 0.377929
+ 1.5266667 0.339094
+ 1.5269444 0.296823
+ 1.5272222 0.252854
+ 1.5275000 0.208923
+ 1.5277778 0.166767
+ 1.5280556 0.127949
+ 1.5283333 0.093342
+ 1.5286111 0.063642
+ 1.5288889 0.050000
+ 1.5291667 0.050000
+ 1.5294444 0.050000
+ 1.5297222 0.050000
+ 1.5300000 0.050000
+ 1.5302778 0.050000
+ 1.5305556 0.051814
+ 1.5308333 0.085985
+ 1.5311111 0.128189
+ 1.5313889 0.175964
+ 1.5316667 0.226851
+ 1.5319444 0.278388
+ 1.5322222 0.328115
+ 1.5325000 0.373572
+ 1.5327778 0.412297
+ 1.5330556 0.441831
+ 1.5333333 0.459712
+ 1.5336111 0.464191
+ 1.5338889 0.456359
+ 1.5341667 0.438018
+ 1.5344444 0.410971
+ 1.5347222 0.377019
+ 1.5350000 0.337965
+ 1.5352778 0.295610
+ 1.5355556 0.251758
+ 1.5358333 0.208209
+ 1.5361111 0.166767
+ 1.5363889 0.129033
+ 1.5366667 0.095814
+ 1.5369444 0.067714
+ 1.5372222 0.050000
+ 1.5375000 0.050000
+ 1.5377778 0.050000
+ 1.5380556 0.050000
+ 1.5383333 0.050000
+ 1.5386111 0.050000
+ 1.5388889 0.065217
+ 1.5391667 0.099371
+ 1.5394444 0.141091
+ 1.5397222 0.187984
+ 1.5400000 0.237653
+ 1.5402778 0.287703
+ 1.5405556 0.335737
+ 1.5408333 0.379360
+ 1.5411111 0.416176
+ 1.5413889 0.443789
+ 1.5416667 0.459804
+ 1.5419444 0.462523
+ 1.5422222 0.453042
+ 1.5425000 0.433157
+ 1.5427778 0.404661
+ 1.5430556 0.369350
+ 1.5433333 0.329018
+ 1.5436111 0.285460
+ 1.5438889 0.240471
+ 1.5441667 0.195845
+ 1.5444444 0.153377
+ 1.5447222 0.114671
+ 1.5450000 0.080570
+ 1.5452778 0.051726
+ 1.5455556 0.050000
+ 1.5458333 0.050000
+ 1.5461111 0.050000
+ 1.5463889 0.050000
+ 1.5466667 0.050000
+ 1.5469444 0.050000
+ 1.5472222 0.051775
+ 1.5475000 0.087920
+ 1.5477778 0.131965
+ 1.5480556 0.181333
+ 1.5483333 0.233453
+ 1.5486111 0.285749
+ 1.5488889 0.335647
+ 1.5491667 0.380573
+ 1.5494444 0.417953
+ 1.5497222 0.445213
+ 1.5500000 0.459778
+ 1.5502778 0.459850
+ 1.5505556 0.446733
+ 1.5508333 0.422507
+ 1.5511111 0.389251
+ 1.5513889 0.349046
+ 1.5516667 0.303969
+ 1.5519444 0.256103
+ 1.5522222 0.207525
+ 1.5525000 0.160315
+ 1.5527778 0.116554
+ 1.5530556 0.078045
+ 1.5533333 0.050000
+ 1.5536111 0.050000
+ 1.5538889 0.050000
+ 1.5541667 0.050000
+ 1.5544444 0.050000
+ 1.5547222 0.050000
+ 1.5550000 0.050000
+ 1.5552778 0.050000
+ 1.5555556 0.050000
+ 1.5558333 0.089531
+ 1.5561111 0.136243
+ 1.5563889 0.187562
+ 1.5566667 0.240911
+ 1.5569444 0.293715
+ 1.5572222 0.343400
+ 1.5575000 0.387388
+ 1.5577778 0.423105
+ 1.5580556 0.447976
+ 1.5583333 0.459425
+ 1.5586111 0.455690
+ 1.5588889 0.438266
+ 1.5591667 0.409461
+ 1.5594444 0.371584
+ 1.5597222 0.326943
+ 1.5600000 0.277847
+ 1.5602778 0.226604
+ 1.5605556 0.175523
+ 1.5608333 0.126912
+ 1.5611111 0.083079
+ 1.5613889 0.050000
+ 1.5616667 0.050000
+ 1.5619444 0.050000
+ 1.5622222 0.050000
+ 1.5625000 0.050000
+ 1.5627778 0.050000
+ 1.5630556 0.050000
+ 1.5633333 0.050000
+ 1.5636111 0.050000
+ 1.5638889 0.050000
+ 1.5641667 0.089802
+ 1.5644444 0.135995
+ 1.5647222 0.186722
+ 1.5650000 0.240128
+ 1.5652778 0.294358
+ 1.5655556 0.347557
+ 1.5658333 0.397870
+ 1.5661111 0.443440
+ 1.5663889 0.482413
+ 1.5666667 0.512932
+ 1.5669444 0.533607
+ 1.5672222 0.544895
+ 1.5675000 0.547720
+ 1.5677778 0.543004
+ 1.5680556 0.531669
+ 1.5683333 0.514638
+ 1.5686111 0.492833
+ 1.5688889 0.467176
+ 1.5691667 0.438589
+ 1.5694444 0.407996
+ 1.5697222 0.376364
+ 1.5700000 0.344845
+ 1.5702778 0.314637
+ 1.5705556 0.286937
+ 1.5708333 0.262944
+ 1.5711111 0.243855
+ 1.5713889 0.230867
+ 1.5716667 0.225178
+ 1.5719444 0.227987
+ 1.5722222 0.240490
+ 1.5725000 0.263239
+ 1.5727778 0.294191
+ 1.5730556 0.330660
+ 1.5733333 0.369958
+ 1.5736111 0.409397
+ 1.5738889 0.446288
+ 1.5741667 0.477943
+ 1.5744444 0.501676
+ 1.5747222 0.514797
+ 1.5750000 0.514619
+ 1.5752778 0.499314
+ 1.5755556 0.470494
+ 1.5758333 0.430630
+ 1.5761111 0.382194
+ 1.5763889 0.327659
+ 1.5766667 0.269496
+ 1.5769444 0.210177
+ 1.5772222 0.152173
+ 1.5775000 0.097957
+ 1.5777778 0.050000
+ 1.5780556 0.050000
+ 1.5783333 0.050000
+ 1.5786111 0.050000
+ 1.5788889 0.050000
+ 1.5791667 0.050000
+ 1.5794444 0.050000
+ 1.5797222 0.050000
+ 1.5800000 0.050000
+ 1.5802778 0.050000
+ 1.5805556 0.050000
+ 1.5808333 0.098396
+ 1.5811111 0.153189
+ 1.5813889 0.211836
+ 1.5816667 0.271793
+ 1.5819444 0.330518
+ 1.5822222 0.385468
+ 1.5825000 0.434100
+ 1.5827778 0.473871
+ 1.5830556 0.502238
+ 1.5833333 0.516659
+ 1.5836111 0.515459
+ 1.5838889 0.500442
+ 1.5841667 0.474281
+ 1.5844444 0.439648
+ 1.5847222 0.399215
+ 1.5850000 0.355656
+ 1.5852778 0.311642
+ 1.5855556 0.269847
+ 1.5858333 0.232943
+ 1.5861111 0.203602
+ 1.5863889 0.183887
+ 1.5866667 0.173411
+ 1.5869444 0.171178
+ 1.5872222 0.176192
+ 1.5875000 0.187456
+ 1.5877778 0.203974
+ 1.5880556 0.224749
+ 1.5883333 0.248785
+ 1.5886111 0.275086
+ 1.5888889 0.302654
+ 1.5891667 0.330525
+ 1.5894444 0.357857
+ 1.5897222 0.383839
+ 1.5900000 0.407661
+ 1.5902778 0.428511
+ 1.5905556 0.445580
+ 1.5908333 0.458057
+ 1.5911111 0.465132
+ 1.5913889 0.465993
+ 1.5916667 0.459830
+ 1.5919444 0.446142
+ 1.5922222 0.425669
+ 1.5925000 0.399456
+ 1.5927778 0.368554
+ 1.5930556 0.334009
+ 1.5933333 0.296870
+ 1.5936111 0.258185
+ 1.5938889 0.219002
+ 1.5941667 0.180369
+ 1.5944444 0.143334
+ 1.5947222 0.108904
+ 1.5950000 0.077920
+ 1.5952778 0.051180
+ 1.5955556 0.050000
+ 1.5958333 0.050000
+ 1.5961111 0.050000
+ 1.5963889 0.050000
+ 1.5966667 0.050000
+ 1.5969444 0.050000
+ 1.5972222 0.050000
+ 1.5975000 0.085434
+ 1.5977778 0.128941
+ 1.5980556 0.177955
+ 1.5983333 0.229911
+ 1.5986111 0.282243
+ 1.5988889 0.332384
+ 1.5991667 0.377769
+ 1.5994444 0.415832
+ 1.5997222 0.444006
+ 1.6000000 0.459725
+ 1.6002778 0.461187
+ 1.6005556 0.449638
+ 1.6008333 0.427087
+ 1.6011111 0.395543
+ 1.6013889 0.357016
+ 1.6016667 0.313514
+ 1.6019444 0.267047
+ 1.6022222 0.219623
+ 1.6025000 0.173253
+ 1.6027778 0.129944
+ 1.6030556 0.091450
+ 1.6033333 0.058492
+ 1.6036111 0.050000
+ 1.6038889 0.050000
+ 1.6041667 0.050000
+ 1.6044444 0.050000
+ 1.6047222 0.050000
+ 1.6050000 0.050000
+ 1.6052778 0.050000
+ 1.6055556 0.050000
+ 1.6058333 0.087332
+ 1.6061111 0.131958
+ 1.6063889 0.181445
+ 1.6066667 0.233361
+ 1.6069444 0.285274
+ 1.6072222 0.334752
+ 1.6075000 0.379363
+ 1.6077778 0.416675
+ 1.6080556 0.444256
+ 1.6083333 0.459673
+ 1.6086111 0.461222
+ 1.6088889 0.450105
+ 1.6091667 0.428250
+ 1.6094444 0.397587
+ 1.6097222 0.360043
+ 1.6100000 0.317549
+ 1.6102778 0.272033
+ 1.6105556 0.225423
+ 1.6108333 0.179649
+ 1.6111111 0.136639
+ 1.6113889 0.098090
+ 1.6116667 0.064765
+ 1.6119444 0.050000
+ 1.6122222 0.050000
+ 1.6125000 0.050000
+ 1.6127778 0.050000
+ 1.6130556 0.050000
+ 1.6133333 0.050000
+ 1.6136111 0.050000
+ 1.6138889 0.050000
+ 1.6141667 0.087098
+ 1.6144444 0.131707
+ 1.6147222 0.181334
+ 1.6150000 0.233484
+ 1.6152778 0.285663
+ 1.6155556 0.335378
+ 1.6158333 0.380132
+ 1.6161111 0.417434
+ 1.6163889 0.444787
+ 1.6166667 0.459699
+ 1.6169444 0.460426
+ 1.6172222 0.448227
+ 1.6175000 0.425114
+ 1.6177778 0.393096
+ 1.6180556 0.354185
+ 1.6183333 0.310391
+ 1.6186111 0.263725
+ 1.6188889 0.216196
+ 1.6191667 0.169817
+ 1.6194444 0.126597
+ 1.6197222 0.088286
+ 1.6200000 0.055593
+ 1.6202778 0.050000
+ 1.6205556 0.050000
+ 1.6208333 0.050000
+ 1.6211111 0.050000
+ 1.6213889 0.050000
+ 1.6216667 0.050000
+ 1.6219444 0.050000
+ 1.6222222 0.050000
+ 1.6225000 0.087531
+ 1.6227778 0.132285
+ 1.6230556 0.181841
+ 1.6233333 0.233776
+ 1.6236111 0.285667
+ 1.6238889 0.335092
+ 1.6241667 0.379629
+ 1.6244444 0.416856
+ 1.6247222 0.444349
+ 1.6250000 0.459686
+ 1.6252778 0.461171
+ 1.6255556 0.450005
+ 1.6258333 0.428117
+ 1.6261111 0.397435
+ 1.6263889 0.359888
+ 1.6266667 0.317402
+ 1.6269444 0.271906
+ 1.6272222 0.225329
+ 1.6275000 0.179597
+ 1.6277778 0.136639
+ 1.6280556 0.098150
+ 1.6283333 0.064888
+ 1.6286111 0.050000
+ 1.6288889 0.050000
+ 1.6291667 0.050000
+ 1.6294444 0.050000
+ 1.6297222 0.050000
+ 1.6300000 0.050000
+ 1.6302778 0.050000
+ 1.6305556 0.050000
+ 1.6308333 0.086919
+ 1.6311111 0.131322
+ 1.6313889 0.180739
+ 1.6316667 0.232702
+ 1.6319444 0.284740
+ 1.6322222 0.334384
+ 1.6325000 0.379164
+ 1.6327778 0.416609
+ 1.6330556 0.444252
+ 1.6333333 0.459621
+ 1.6336111 0.460985
+ 1.6338889 0.449567
+ 1.6341667 0.427327
+ 1.6344444 0.396225
+ 1.6347222 0.358222
+ 1.6350000 0.315277
+ 1.6352778 0.269351
+ 1.6355556 0.222405
+ 1.6358333 0.176398
+ 1.6361111 0.133292
+ 1.6363889 0.094803
+ 1.6366667 0.061677
+ 1.6369444 0.050000
+ 1.6372222 0.050000
+ 1.6375000 0.050000
+ 1.6377778 0.050000
+ 1.6380556 0.050000
+ 1.6383333 0.050000
+ 1.6386111 0.050000
+ 1.6388889 0.050000
+ 1.6391667 0.087246
+ 1.6394444 0.131905
+ 1.6397222 0.181508
+ 1.6400000 0.233584
+ 1.6402778 0.285664
+ 1.6405556 0.335278
+ 1.6408333 0.379955
+ 1.6411111 0.417227
+ 1.6413889 0.444623
+ 1.6416667 0.459673
+ 1.6419444 0.460650
+ 1.6422222 0.448794
+ 1.6425000 0.426088
+ 1.6427778 0.394516
+ 1.6430556 0.356061
+ 1.6433333 0.312706
+ 1.6436111 0.266434
+ 1.6438889 0.219227
+ 1.6441667 0.173070
+ 1.6444444 0.129944
+ 1.6447222 0.091583
+ 1.6450000 0.058709
+ 1.6452778 0.050000
+ 1.6455556 0.050000
+ 1.6458333 0.050000
+ 1.6461111 0.050000
+ 1.6463889 0.050000
+ 1.6466667 0.050000
+ 1.6469444 0.050000
+ 1.6472222 0.050000
+ 1.6475000 0.087302
+ 1.6477778 0.131911
+ 1.6480556 0.181392
+ 1.6483333 0.233310
+ 1.6486111 0.285232
+ 1.6488889 0.334721
+ 1.6491667 0.379343
+ 1.6494444 0.416663
+ 1.6497222 0.444247
+ 1.6500000 0.459660
+ 1.6502778 0.461195
+ 1.6505556 0.450056
+ 1.6508333 0.428177
+ 1.6511111 0.397490
+ 1.6513889 0.359928
+ 1.6516667 0.317424
+ 1.6519444 0.271910
+ 1.6522222 0.225320
+ 1.6525000 0.179585
+ 1.6527778 0.136639
+ 1.6530556 0.098179
+ 1.6533333 0.064959
+ 1.6536111 0.050000
+ 1.6538889 0.050000
+ 1.6541667 0.050000
+ 1.6544444 0.050000
+ 1.6547222 0.050000
+ 1.6550000 0.050000
+ 1.6552778 0.050000
+ 1.6555556 0.050000
+ 1.6558333 0.086759
+ 1.6561111 0.130976
+ 1.6563889 0.180203
+ 1.6566667 0.231997
+ 1.6569444 0.283909
+ 1.6572222 0.333496
+ 1.6575000 0.378310
+ 1.6577778 0.415906
+ 1.6580556 0.443838
+ 1.6583333 0.459660
+ 1.6586111 0.461653
+ 1.6588889 0.451001
+ 1.6591667 0.429617
+ 1.6594444 0.399412
+ 1.6597222 0.362297
+ 1.6600000 0.320185
+ 1.6602778 0.274986
+ 1.6605556 0.228612
+ 1.6608333 0.182975
+ 1.6611111 0.139987
+ 1.6613889 0.101332
+ 1.6616667 0.067791
+ 1.6619444 0.050000
+ 1.6622222 0.050000
+ 1.6625000 0.050000
+ 1.6627778 0.050000
+ 1.6630556 0.050000
+ 1.6633333 0.050000
+ 1.6636111 0.050000
+ 1.6638889 0.050000
+ 1.6641667 0.086889
+ 1.6644444 0.131369
+ 1.6647222 0.180933
+ 1.6650000 0.233075
+ 1.6652778 0.285287
+ 1.6655556 0.335064
+ 1.6658333 0.379899
+ 1.6661111 0.417286
+ 1.6663889 0.444717
+ 1.6666667 0.459686
+ 1.6669444 0.460441
+ 1.6672222 0.448246
+ 1.6675000 0.425118
+ 1.6677778 0.393075
+ 1.6680556 0.354135
+ 1.6683333 0.310315
+ 1.6686111 0.263633
+ 1.6688889 0.216108
+ 1.6691667 0.169757
+ 1.6694444 0.126597
+ 1.6697222 0.088382
+ 1.6700000 0.055808
+ 1.6702778 0.050000
+ 1.6705556 0.050000
+ 1.6708333 0.050000
+ 1.6711111 0.050000
+ 1.6713889 0.050000
+ 1.6716667 0.050000
+ 1.6719444 0.050000
+ 1.6722222 0.050000
+ 1.6725000 0.087123
+ 1.6727778 0.131403
+ 1.6730556 0.180476
+ 1.6733333 0.231980
+ 1.6736111 0.283550
+ 1.6738889 0.332824
+ 1.6741667 0.377438
+ 1.6744444 0.415028
+ 1.6747222 0.443232
+ 1.6750000 0.459686
+ 1.6752778 0.462722
+ 1.6755556 0.453453
+ 1.6758333 0.433689
+ 1.6761111 0.405237
+ 1.6763889 0.369906
+ 1.6766667 0.329505
+ 1.6769444 0.285843
+ 1.6772222 0.240729
+ 1.6775000 0.195971
+ 1.6777778 0.153377
+ 1.6780556 0.114562
+ 1.6783333 0.080363
+ 1.6786111 0.051422
+ 1.6788889 0.050000
+ 1.6791667 0.050000
+ 1.6794444 0.050000
+ 1.6797222 0.050000
+ 1.6800000 0.050000
+ 1.6802778 0.050000
+ 1.6805556 0.050000
+ 1.6808333 0.085714
+ 1.6811111 0.129307
+ 1.6813889 0.178262
+ 1.6816667 0.230061
+ 1.6819444 0.282188
+ 1.6822222 0.332126
+ 1.6825000 0.377358
+ 1.6827778 0.415366
+ 1.6830556 0.443635
+ 1.6833333 0.459647
+ 1.6836111 0.461630
+ 1.6838889 0.450790
+ 1.6841667 0.429079
+ 1.6844444 0.398449
+ 1.6847222 0.360851
+ 1.6850000 0.318236
+ 1.6852778 0.272556
+ 1.6855556 0.225763
+ 1.6858333 0.179806
+ 1.6861111 0.136639
+ 1.6863889 0.097975
+ 1.6866667 0.064577
+ 1.6869444 0.050000
+ 1.6872222 0.050000
+ 1.6875000 0.050000
+ 1.6877778 0.050000
+ 1.6880556 0.050000
+ 1.6883333 0.050000
+ 1.6886111 0.050000
+ 1.6888889 0.050000
+ 1.6891667 0.087131
+ 1.6894444 0.131763
+ 1.6897222 0.181403
+ 1.6900000 0.233559
+ 1.6902778 0.285737
+ 1.6905556 0.335446
+ 1.6908333 0.380192
+ 1.6911111 0.417482
+ 1.6913889 0.444824
+ 1.6916667 0.459725
+ 1.6919444 0.460443
+ 1.6922222 0.448238
+ 1.6925000 0.425119
+ 1.6927778 0.393098
+ 1.6930556 0.354185
+ 1.6933333 0.310390
+ 1.6936111 0.263723
+ 1.6938889 0.216195
+ 1.6941667 0.169816
+ 1.6944444 0.126597
+ 1.6947222 0.088287
+ 1.6950000 0.055595
+ 1.6952778 0.050000
+ 1.6955556 0.050000
+ 1.6958333 0.050000
+ 1.6961111 0.050000
+ 1.6963889 0.050000
+ 1.6966667 0.050000
+ 1.6969444 0.050000
+ 1.6972222 0.050000
+ 1.6975000 0.087529
+ 1.6977778 0.132282
+ 1.6980556 0.181835
+ 1.6983333 0.233768
+ 1.6986111 0.285658
+ 1.6988889 0.335081
+ 1.6991667 0.379617
+ 1.6994444 0.416842
+ 1.6997222 0.444335
+ 1.7000000 0.459673
+ 1.7002778 0.461159
+ 1.7005556 0.449995
+ 1.7008333 0.428110
+ 1.7011111 0.397430
+ 1.7013889 0.359885
+ 1.7016667 0.317401
+ 1.7019444 0.271907
+ 1.7022222 0.225330
+ 1.7025000 0.179598
+ 1.7027778 0.136639
+ 1.7030556 0.098147
+ 1.7033333 0.064882
+ 1.7036111 0.050000
+ 1.7038889 0.050000
+ 1.7041667 0.050000
+ 1.7044444 0.050000
+ 1.7047222 0.050000
+ 1.7050000 0.050000
+ 1.7052778 0.050000
+ 1.7055556 0.050000
+ 1.7058333 0.086932
+ 1.7061111 0.131352
+ 1.7063889 0.180787
+ 1.7066667 0.232767
+ 1.7069444 0.284821
+ 1.7072222 0.334476
+ 1.7075000 0.379263
+ 1.7077778 0.416710
+ 1.7080556 0.444346
+ 1.7083333 0.459699
+ 1.7086111 0.461038
+ 1.7088889 0.449587
+ 1.7091667 0.427312
+ 1.7094444 0.396176
+ 1.7097222 0.358143
+ 1.7100000 0.315179
+ 1.7102778 0.269248
+ 1.7105556 0.222313
+ 1.7108333 0.176340
+ 1.7111111 0.133292
+ 1.7113889 0.094890
+ 1.7116667 0.061877
+ 1.7119444 0.050000
+ 1.7122222 0.050000
+ 1.7125000 0.050000
+ 1.7127778 0.050000
+ 1.7130556 0.050000
+ 1.7133333 0.050000
+ 1.7136111 0.050000
+ 1.7138889 0.051697
+ 1.7141667 0.089154
+ 1.7144444 0.134001
+ 1.7147222 0.183745
+ 1.7150000 0.235894
+ 1.7152778 0.287957
+ 1.7155556 0.337439
+ 1.7158333 0.381850
+ 1.7161111 0.418696
+ 1.7163889 0.445485
+ 1.7166667 0.459725
+ 1.7169444 0.459680
+ 1.7172222 0.446639
+ 1.7175000 0.422647
+ 1.7177778 0.389750
+ 1.7180556 0.349993
+ 1.7183333 0.305422
+ 1.7186111 0.258082
+ 1.7188889 0.210018
+ 1.7191667 0.163276
+ 1.7194444 0.119902
+ 1.7197222 0.081669
+ 1.7200000 0.050000
+ 1.7202778 0.050000
+ 1.7205556 0.050000
+ 1.7208333 0.050000
+ 1.7211111 0.050000
+ 1.7213889 0.050000
+ 1.7216667 0.050000
+ 1.7219444 0.050000
+ 1.7222222 0.050000
+ 1.7225000 0.088366
+ 1.7227778 0.133862
+ 1.7230556 0.184030
+ 1.7233333 0.236414
+ 1.7236111 0.288557
+ 1.7238889 0.338003
+ 1.7241667 0.382296
+ 1.7244444 0.418978
+ 1.7247222 0.445594
+ 1.7250000 0.459686
+ 1.7252778 0.459547
+ 1.7255556 0.446463
+ 1.7258333 0.422468
+ 1.7261111 0.389597
+ 1.7263889 0.349884
+ 1.7266667 0.305364
+ 1.7269444 0.258071
+ 1.7272222 0.210040
+ 1.7275000 0.163305
+ 1.7277778 0.119902
+ 1.7280556 0.081597
+ 1.7283333 0.050000
+ 1.7286111 0.050000
+ 1.7288889 0.050000
+ 1.7291667 0.050000
+ 1.7294444 0.050000
+ 1.7297222 0.050000
+ 1.7300000 0.050000
+ 1.7302778 0.050000
+ 1.7305556 0.050000
+ 1.7308333 0.088758
+ 1.7311111 0.134712
+ 1.7313889 0.185348
+ 1.7316667 0.238151
+ 1.7319444 0.290607
+ 1.7322222 0.340200
+ 1.7325000 0.384416
+ 1.7327778 0.420742
+ 1.7330556 0.446661
+ 1.7333333 0.459660
+ 1.7336111 0.458001
+ 1.7338889 0.443057
+ 1.7341667 0.416976
+ 1.7344444 0.381909
+ 1.7347222 0.340005
+ 1.7350000 0.293414
+ 1.7352778 0.244285
+ 1.7355556 0.194767
+ 1.7358333 0.147010
+ 1.7361111 0.103164
+ 1.7363889 0.065076
+ 1.7366667 0.050000
+ 1.7369444 0.050000
+ 1.7372222 0.050000
+ 1.7375000 0.050000
+ 1.7377778 0.050000
+ 1.7380556 0.050000
+ 1.7383333 0.050000
+ 1.7386111 0.050000
+ 1.7388889 0.050000
+ 1.7391667 0.090374
+ 1.7394444 0.137617
+ 1.7397222 0.189202
+ 1.7400000 0.242604
+ 1.7402778 0.295297
+ 1.7405556 0.344754
+ 1.7408333 0.388450
+ 1.7411111 0.423859
+ 1.7413889 0.448455
+ 1.7416667 0.459712
+ 1.7419444 0.455905
+ 1.7422222 0.438507
+ 1.7425000 0.409795
+ 1.7427778 0.372042
+ 1.7430556 0.327524
+ 1.7433333 0.278516
+ 1.7436111 0.227293
+ 1.7438889 0.176129
+ 1.7441667 0.127300
+ 1.7444444 0.083079
+ 1.7447222 0.050000
+ 1.7450000 0.050000
+ 1.7452778 0.050000
+ 1.7455556 0.050000
+ 1.7458333 0.050000
+ 1.7461111 0.050000
+ 1.7463889 0.050000
+ 1.7466667 0.050000
+ 1.7469444 0.050000
+ 1.7472222 0.050000
+ 1.7475000 0.092023
+ 1.7477778 0.140484
+ 1.7480556 0.192881
+ 1.7483333 0.246712
+ 1.7486111 0.299475
+ 1.7488889 0.348666
+ 1.7491667 0.391784
+ 1.7494444 0.426326
+ 1.7497222 0.449790
+ 1.7500000 0.459673
+ 1.7502778 0.454282
+ 1.7505556 0.435157
+ 1.7508333 0.404648
+ 1.7511111 0.365104
+ 1.7513889 0.318876
+ 1.7516667 0.268312
+ 1.7519444 0.215761
+ 1.7522222 0.163575
+ 1.7525000 0.114101
+ 1.7527778 0.069689
+ 1.7530556 0.050000
+ 1.7533333 0.050000
+ 1.7536111 0.050000
+ 1.7538889 0.050000
+ 1.7541667 0.050000
+ 1.7544444 0.050000
+ 1.7547222 0.050000
+ 1.7550000 0.050000
+ 1.7552778 0.050000
+ 1.7555556 0.050000
+ 1.7558333 0.093139
+ 1.7561111 0.142439
+ 1.7563889 0.195409
+ 1.7566667 0.249558
+ 1.7569444 0.302394
+ 1.7572222 0.351426
+ 1.7575000 0.394163
+ 1.7577778 0.428113
+ 1.7580556 0.450784
+ 1.7583333 0.459686
+ 1.7586111 0.453144
+ 1.7588889 0.432747
+ 1.7591667 0.400903
+ 1.7594444 0.360018
+ 1.7597222 0.312500
+ 1.7600000 0.260755
+ 1.7602778 0.207191
+ 1.7605556 0.154213
+ 1.7608333 0.104230
+ 1.7611111 0.059647
+ 1.7613889 0.050000
+ 1.7616667 0.050000
+ 1.7619444 0.050000
+ 1.7622222 0.050000
+ 1.7625000 0.050000
+ 1.7627778 0.050000
+ 1.7630556 0.050000
+ 1.7633333 0.050000
+ 1.7636111 0.050000
+ 1.7638889 0.050000
+ 1.7641667 0.094039
+ 1.7644444 0.144041
+ 1.7647222 0.197513
+ 1.7650000 0.251964
+ 1.7652778 0.304902
+ 1.7655556 0.353837
+ 1.7658333 0.396275
+ 1.7661111 0.429726
+ 1.7663889 0.451698
+ 1.7666667 0.459699
+ 1.7669444 0.452065
+ 1.7672222 0.430438
+ 1.7675000 0.397288
+ 1.7677778 0.355083
+ 1.7680556 0.306293
+ 1.7683333 0.253388
+ 1.7686111 0.198837
+ 1.7688889 0.145109
+ 1.7691667 0.094673
+ 1.7694444 0.050000
+ 1.7697222 0.050000
+ 1.7700000 0.050000
+ 1.7702778 0.050000
+ 1.7705556 0.050000
+ 1.7708333 0.050000
+ 1.7711111 0.050000
+ 1.7713889 0.050000
+ 1.7716667 0.050000
+ 1.7719444 0.050000
+ 1.7722222 0.050000
+ 1.7725000 0.094438
+ 1.7727778 0.144570
+ 1.7730556 0.197972
+ 1.7733333 0.252219
+ 1.7736111 0.304886
+ 1.7738889 0.353550
+ 1.7741667 0.395785
+ 1.7744444 0.429167
+ 1.7747222 0.451271
+ 1.7750000 0.459673
+ 1.7752778 0.452751
+ 1.7755556 0.432095
+ 1.7758333 0.400099
+ 1.7761111 0.359156
+ 1.7763889 0.311660
+ 1.7766667 0.260003
+ 1.7769444 0.206581
+ 1.7772222 0.153785
+ 1.7775000 0.104009
+ 1.7777778 0.059647
+ 1.7780556 0.050000
+ 1.7783333 0.050000
+ 1.7786111 0.050000
+ 1.7788889 0.050000
+ 1.7791667 0.050000
+ 1.7794444 0.050000
+ 1.7797222 0.050000
+ 1.7800000 0.050000
+ 1.7802778 0.050000
+ 1.7805556 0.050000
+ 1.7808333 0.093542
+ 1.7811111 0.142980
+ 1.7813889 0.195888
+ 1.7816667 0.249842
+ 1.7819444 0.302414
+ 1.7822222 0.351181
+ 1.7825000 0.393715
+ 1.7827778 0.427593
+ 1.7830556 0.450387
+ 1.7833333 0.459673
+ 1.7836111 0.453819
+ 1.7838889 0.434367
+ 1.7841667 0.403656
+ 1.7844444 0.364021
+ 1.7847222 0.317800
+ 1.7850000 0.267329
+ 1.7852778 0.214946
+ 1.7855556 0.162987
+ 1.7858333 0.113789
+ 1.7861111 0.069689
+ 1.7863889 0.050000
+ 1.7866667 0.050000
+ 1.7869444 0.050000
+ 1.7872222 0.050000
+ 1.7875000 0.050000
+ 1.7877778 0.050000
+ 1.7880556 0.050000
+ 1.7883333 0.050000
+ 1.7886111 0.050000
+ 1.7888889 0.050000
+ 1.7891667 0.092272
+ 1.7894444 0.140582
+ 1.7897222 0.192559
+ 1.7900000 0.245828
+ 1.7902778 0.298018
+ 1.7905556 0.346756
+ 1.7908333 0.389668
+ 1.7911111 0.424382
+ 1.7913889 0.448526
+ 1.7916667 0.459725
+ 1.7919444 0.456367
+ 1.7922222 0.439872
+ 1.7925000 0.412419
+ 1.7927778 0.376187
+ 1.7930556 0.333355
+ 1.7933333 0.286102
+ 1.7936111 0.236608
+ 1.7938889 0.187052
+ 1.7941667 0.139613
+ 1.7944444 0.096469
+ 1.7947222 0.059476
+ 1.7950000 0.050000
+ 1.7952778 0.050000
+ 1.7955556 0.050000
+ 1.7958333 0.050000
+ 1.7961111 0.050000
+ 1.7963889 0.050000
+ 1.7966667 0.050000
+ 1.7969444 0.050000
+ 1.7972222 0.054900
+ 1.7975000 0.094561
+ 1.7977778 0.140611
+ 1.7980556 0.190724
+ 1.7983333 0.242571
+ 1.7986111 0.293827
+ 1.7988889 0.342164
+ 1.7991667 0.385254
+ 1.7994444 0.420771
+ 1.7997222 0.446388
+ 1.8000000 0.459778
+ 1.8002778 0.459333
+ 1.8005556 0.446332
+ 1.8008333 0.422770
+ 1.8011111 0.390646
+ 1.8013889 0.351957
+ 1.8016667 0.308700
+ 1.8019444 0.262873
+ 1.8022222 0.216473
+ 1.8025000 0.171498
+ 1.8027778 0.129944
+ 1.8030556 0.093537
+ 1.8033333 0.062903
+ 1.8036111 0.050000
+ 1.8038889 0.050000
+ 1.8041667 0.050000
+ 1.8044444 0.050000
+ 1.8047222 0.050000
+ 1.8050000 0.050000
+ 1.8052778 0.050000
+ 1.8055556 0.068395
+ 1.8058333 0.105289
+ 1.8061111 0.148847
+ 1.8063889 0.196756
+ 1.8066667 0.246707
+ 1.8069444 0.296386
+ 1.8072222 0.343484
+ 1.8075000 0.385689
+ 1.8077778 0.420689
+ 1.8080556 0.446173
+ 1.8083333 0.459830
+ 1.8086111 0.460055
+ 1.8088889 0.448065
+ 1.8091667 0.425786
+ 1.8094444 0.395140
+ 1.8097222 0.358053
+ 1.8100000 0.316448
+ 1.8102778 0.272249
+ 1.8105556 0.227382
+ 1.8108333 0.183768
+ 1.8111111 0.143334
+ 1.8113889 0.107745
+ 1.8116667 0.077631
+ 1.8119444 0.053365
+ 1.8122222 0.050000
+ 1.8125000 0.050000
+ 1.8127778 0.050000
+ 1.8130556 0.050000
+ 1.8133333 0.050000
+ 1.8136111 0.051450
+ 1.8138889 0.078555
+ 1.8141667 0.114052
+ 1.8144444 0.156130
+ 1.8147222 0.202540
+ 1.8150000 0.251034
+ 1.8152778 0.299363
+ 1.8155556 0.345281
+ 1.8158333 0.386537
+ 1.8161111 0.420884
+ 1.8163889 0.446073
+ 1.8166667 0.459856
+ 1.8169444 0.460670
+ 1.8172222 0.449686
+ 1.8175000 0.428765
+ 1.8177778 0.399762
+ 1.8180556 0.364535
+ 1.8183333 0.324943
+ 1.8186111 0.282843
+ 1.8188889 0.240093
+ 1.8191667 0.198550
+ 1.8194444 0.160072
+ 1.8197222 0.126263
+ 1.8200000 0.097712
+ 1.8202778 0.074752
+ 1.8205556 0.057718
+ 1.8208333 0.050000
+ 1.8211111 0.050000
+ 1.8213889 0.050000
+ 1.8216667 0.055527
+ 1.8219444 0.073137
+ 1.8222222 0.098679
+ 1.8225000 0.132084
+ 1.8227778 0.171665
+ 1.8230556 0.215334
+ 1.8233333 0.261002
+ 1.8236111 0.306578
+ 1.8238889 0.349975
+ 1.8241667 0.389102
+ 1.8244444 0.421870
+ 1.8247222 0.446191
+ 1.8250000 0.459974
+ 1.8252778 0.461756
+ 1.8255556 0.452571
+ 1.8258333 0.434080
+ 1.8261111 0.407942
+ 1.8263889 0.375818
+ 1.8266667 0.339368
+ 1.8269444 0.300252
+ 1.8272222 0.260129
+ 1.8275000 0.220660
+ 1.8277778 0.183504
+ 1.8280556 0.150124
+ 1.8283333 0.121183
+ 1.8286111 0.097148
+ 1.8288889 0.078485
+ 1.8291667 0.065660
+ 1.8294444 0.059139
+ 1.8297222 0.059387
+ 1.8300000 0.066872
+ 1.8302778 0.082059
+ 1.8305556 0.105414
+ 1.8308333 0.136972
+ 1.8311111 0.175045
+ 1.8313889 0.217515
+ 1.8316667 0.262263
+ 1.8319444 0.307170
+ 1.8322222 0.350117
+ 1.8325000 0.388986
+ 1.8327778 0.421657
+ 1.8330556 0.446013
+ 1.8333333 0.459935
+ 1.8336111 0.461934
+ 1.8338889 0.453047
+ 1.8341667 0.434943
+ 1.8344444 0.409288
+ 1.8347222 0.377751
+ 1.8350000 0.341999
+ 1.8352778 0.303700
+ 1.8355556 0.264522
+ 1.8358333 0.226133
+ 1.8361111 0.190199
+ 1.8363889 0.158179
+ 1.8366667 0.130687
+ 1.8369444 0.108127
+ 1.8372222 0.090902
+ 1.8375000 0.079417
+ 1.8377778 0.074076
+ 1.8380556 0.075283
+ 1.8383333 0.083442
+ 1.8386111 0.098956
+ 1.8388889 0.122229
+ 1.8391667 0.153256
+ 1.8394444 0.190387
+ 1.8397222 0.231561
+ 1.8400000 0.274719
+ 1.8402778 0.317801
+ 1.8405556 0.358747
+ 1.8408333 0.395497
+ 1.8411111 0.425992
+ 1.8413889 0.448171
+ 1.8416667 0.459974
+ 1.8419444 0.459961
+ 1.8422222 0.449168
+ 1.8425000 0.429252
+ 1.8427778 0.401867
+ 1.8430556 0.368671
+ 1.8433333 0.331318
+ 1.8436111 0.291465
+ 1.8438889 0.250767
+ 1.8441667 0.210881
+ 1.8444444 0.173462
+ 1.8447222 0.139965
+ 1.8450000 0.111045
+ 1.8452778 0.087153
+ 1.8455556 0.068743
+ 1.8458333 0.056268
+ 1.8461111 0.050179
+ 1.8463889 0.050931
+ 1.8466667 0.058977
+ 1.8469444 0.074768
+ 1.8472222 0.098758
+ 1.8475000 0.130970
+ 1.8477778 0.169711
+ 1.8480556 0.212859
+ 1.8483333 0.258290
+ 1.8486111 0.303881
+ 1.8488889 0.347510
+ 1.8491667 0.387054
+ 1.8494444 0.420390
+ 1.8497222 0.445396
+ 1.8500000 0.459948
+ 1.8502778 0.462550
+ 1.8505556 0.454214
+ 1.8508333 0.436576
+ 1.8511111 0.411274
+ 1.8513889 0.379945
+ 1.8516667 0.344226
+ 1.8519444 0.305755
+ 1.8522222 0.266168
+ 1.8525000 0.227104
+ 1.8527778 0.190199
+ 1.8530556 0.156900
+ 1.8533333 0.127886
+ 1.8536111 0.103648
+ 1.8538889 0.084674
+ 1.8541667 0.071453
+ 1.8544444 0.064475
+ 1.8547222 0.064229
+ 1.8550000 0.071204
+ 1.8552778 0.085890
+ 1.8555556 0.108774
+ 1.8558333 0.139911
+ 1.8561111 0.177608
+ 1.8563889 0.219737
+ 1.8566667 0.264169
+ 1.8569444 0.308775
+ 1.8572222 0.351428
+ 1.8575000 0.389999
+ 1.8577778 0.422360
+ 1.8580556 0.446381
+ 1.8583333 0.459935
+ 1.8586111 0.461524
+ 1.8588889 0.452182
+ 1.8591667 0.433570
+ 1.8594444 0.407354
+ 1.8597222 0.375196
+ 1.8600000 0.338759
+ 1.8602778 0.299708
+ 1.8605556 0.259706
+ 1.8608333 0.220417
+ 1.8611111 0.183504
+ 1.8613889 0.150429
+ 1.8616667 0.121844
+ 1.8619444 0.098199
+ 1.8622222 0.079945
+ 1.8625000 0.067531
+ 1.8627778 0.061409
+ 1.8630556 0.062029
+ 1.8633333 0.069840
+ 1.8636111 0.085294
+ 1.8638889 0.108839
+ 1.8641667 0.140500
+ 1.8644444 0.178582
+ 1.8647222 0.220966
+ 1.8650000 0.265531
+ 1.8652778 0.310157
+ 1.8655556 0.352724
+ 1.8658333 0.391111
+ 1.8661111 0.423197
+ 1.8663889 0.446863
+ 1.8666667 0.459987
+ 1.8669444 0.461081
+ 1.8672222 0.451184
+ 1.8675000 0.431967
+ 1.8677778 0.405100
+ 1.8680556 0.372254
+ 1.8683333 0.335099
+ 1.8686111 0.295307
+ 1.8688889 0.254547
+ 1.8691667 0.214491
+ 1.8694444 0.176809
+ 1.8697222 0.142973
+ 1.8700000 0.113655
+ 1.8702778 0.089331
+ 1.8705556 0.070473
+ 1.8708333 0.057556
+ 1.8711111 0.051054
+ 1.8713889 0.051442
+ 1.8716667 0.059192
+ 1.8719444 0.074780
+ 1.8722222 0.098679
+ 1.8725000 0.130925
+ 1.8727778 0.169794
+ 1.8730556 0.213128
+ 1.8733333 0.258764
+ 1.8736111 0.304542
+ 1.8738889 0.348302
+ 1.8741667 0.387881
+ 1.8744444 0.421121
+ 1.8747222 0.445859
+ 1.8750000 0.459935
+ 1.8752778 0.461829
+ 1.8755556 0.452587
+ 1.8758333 0.433895
+ 1.8761111 0.407441
+ 1.8763889 0.374911
+ 1.8766667 0.337992
+ 1.8769444 0.298370
+ 1.8772222 0.257732
+ 1.8775000 0.217766
+ 1.8777778 0.180157
+ 1.8780556 0.146390
+ 1.8783333 0.117138
+ 1.8786111 0.092871
+ 1.8788889 0.074060
+ 1.8791667 0.061175
+ 1.8794444 0.054687
+ 1.8797222 0.055065
+ 1.8800000 0.062781
+ 1.8802778 0.078304
+ 1.8805556 0.102105
+ 1.8808333 0.134216
+ 1.8811111 0.172912
+ 1.8813889 0.216029
+ 1.8816667 0.261403
+ 1.8819444 0.306872
+ 1.8822222 0.350272
+ 1.8825000 0.389439
+ 1.8827778 0.422210
+ 1.8830556 0.446421
+ 1.8833333 0.459908
+ 1.8836111 0.461157
+ 1.8838889 0.451242
+ 1.8841667 0.431886
+ 1.8844444 0.404813
+ 1.8847222 0.371746
+ 1.8850000 0.334408
+ 1.8852778 0.294522
+ 1.8855556 0.253811
+ 1.8858333 0.213999
+ 1.8861111 0.176809
+ 1.8863889 0.143745
+ 1.8866667 0.115432
+ 1.8869444 0.092278
+ 1.8872222 0.074688
+ 1.8875000 0.063070
+ 1.8877778 0.057831
+ 1.8880556 0.059376
+ 1.8883333 0.068113
+ 1.8886111 0.084447
+ 1.8888889 0.108787
+ 1.8891667 0.141116
+ 1.8894444 0.179732
+ 1.8897222 0.222509
+ 1.8900000 0.267322
+ 1.8902778 0.312047
+ 1.8905556 0.354557
+ 1.8908333 0.392729
+ 1.8911111 0.424437
+ 1.8913889 0.447556
+ 1.8916667 0.459961
+ 1.8919444 0.460166
+ 1.8922222 0.449244
+ 1.8925000 0.428908
+ 1.8927778 0.400869
+ 1.8930556 0.366840
+ 1.8933333 0.328533
+ 1.8936111 0.287659
+ 1.8938889 0.245933
+ 1.8941667 0.205064
+ 1.8944444 0.166767
+ 1.8947222 0.132542
+ 1.8950000 0.103054
+ 1.8952778 0.078754
+ 1.8955556 0.060097
+ 1.8958333 0.050000
+ 1.8961111 0.050000
+ 1.8963889 0.050000
+ 1.8966667 0.050945
+ 1.8969444 0.067291
+ 1.8972222 0.091997
+ 1.8975000 0.125078
+ 1.8977778 0.164793
+ 1.8980556 0.208963
+ 1.8983333 0.255411
+ 1.8986111 0.301957
+ 1.8988889 0.346424
+ 1.8991667 0.386632
+ 1.8994444 0.420403
+ 1.8997222 0.445559
+ 1.9000000 0.459922
+ 1.9002778 0.461957
+ 1.9005556 0.452720
+ 1.9008333 0.433907
+ 1.9011111 0.407218
+ 1.9013889 0.374351
+ 1.9016667 0.337006
+ 1.9019444 0.296880
+ 1.9022222 0.255673
+ 1.9025000 0.215083
+ 1.9027778 0.176809
+ 1.9030556 0.142350
+ 1.9033333 0.112406
+ 1.9036111 0.087475
+ 1.9038889 0.068058
+ 1.9041667 0.054653
+ 1.9044444 0.050000
+ 1.9047222 0.050000
+ 1.9050000 0.055517
+ 1.9052778 0.071162
+ 1.9055556 0.095319
+ 1.9058333 0.128031
+ 1.9061111 0.167524
+ 1.9063889 0.211567
+ 1.9066667 0.257929
+ 1.9069444 0.304379
+ 1.9072222 0.348686
+ 1.9075000 0.388621
+ 1.9077778 0.421953
+ 1.9080556 0.446450
+ 1.9083333 0.459882
+ 1.9086111 0.460688
+ 1.9088889 0.449978
+ 1.9091667 0.429534
+ 1.9094444 0.401135
+ 1.9097222 0.366564
+ 1.9100000 0.327599
+ 1.9102778 0.286022
+ 1.9105556 0.243612
+ 1.9108333 0.202151
+ 1.9111111 0.163419
+ 1.9113889 0.128971
+ 1.9116667 0.099457
+ 1.9119444 0.075304
+ 1.9122222 0.056934
+ 1.9125000 0.050000
+ 1.9127778 0.050000
+ 1.9130556 0.050000
+ 1.9133333 0.050000
+ 1.9136111 0.066742
+ 1.9138889 0.092010
+ 1.9141667 0.125603
+ 1.9144444 0.165760
+ 1.9147222 0.210288
+ 1.9150000 0.256990
+ 1.9152778 0.303671
+ 1.9155556 0.348136
+ 1.9158333 0.388188
+ 1.9161111 0.421634
+ 1.9163889 0.446277
+ 1.9166667 0.459922
+ 1.9169444 0.461028
+ 1.9172222 0.450674
+ 1.9175000 0.430596
+ 1.9177778 0.402527
+ 1.9180556 0.368201
+ 1.9183333 0.329352
+ 1.9186111 0.287716
+ 1.9188889 0.245025
+ 1.9191667 0.203015
+ 1.9194444 0.163419
+ 1.9197222 0.127769
+ 1.9200000 0.096783
+ 1.9202778 0.070976
+ 1.9205556 0.050862
+ 1.9208333 0.050000
+ 1.9211111 0.050000
+ 1.9213889 0.050000
+ 1.9216667 0.050000
+ 1.9219444 0.053729
+ 1.9222222 0.078594
+ 1.9225000 0.112295
+ 1.9227778 0.153027
+ 1.9230556 0.198522
+ 1.9233333 0.246512
+ 1.9236111 0.294730
+ 1.9238889 0.340908
+ 1.9241667 0.382777
+ 1.9244444 0.418070
+ 1.9247222 0.444519
+ 1.9250000 0.459856
+ 1.9252778 0.462480
+ 1.9255556 0.453459
+ 1.9258333 0.434525
+ 1.9261111 0.407414
+ 1.9263889 0.373858
+ 1.9266667 0.335593
+ 1.9269444 0.294352
+ 1.9272222 0.251870
+ 1.9275000 0.209879
+ 1.9277778 0.170114
+ 1.9280556 0.134112
+ 1.9283333 0.102618
+ 1.9286111 0.076177
+ 1.9288889 0.055339
+ 1.9291667 0.050000
+ 1.9294444 0.050000
+ 1.9297222 0.050000
+ 1.9300000 0.050000
+ 1.9302778 0.054320
+ 1.9305556 0.078581
+ 1.9308333 0.111804
+ 1.9311111 0.152183
+ 1.9313889 0.197443
+ 1.9316667 0.245309
+ 1.9319444 0.293506
+ 1.9322222 0.339758
+ 1.9325000 0.381791
+ 1.9327778 0.417328
+ 1.9330556 0.444095
+ 1.9333333 0.459817
+ 1.9336111 0.462882
+ 1.9338889 0.454338
+ 1.9341667 0.435897
+ 1.9344444 0.409270
+ 1.9347222 0.376169
+ 1.9350000 0.338306
+ 1.9352778 0.297391
+ 1.9355556 0.255138
+ 1.9358333 0.213258
+ 1.9361111 0.173462
+ 1.9363889 0.137274
+ 1.9366667 0.105465
+ 1.9369444 0.078619
+ 1.9372222 0.057319
+ 1.9375000 0.050000
+ 1.9377778 0.050000
+ 1.9380556 0.050000
+ 1.9383333 0.050000
+ 1.9386111 0.054422
+ 1.9388889 0.078647
+ 1.9391667 0.112013
+ 1.9394444 0.152670
+ 1.9397222 0.198281
+ 1.9400000 0.246508
+ 1.9402778 0.295012
+ 1.9405556 0.341457
+ 1.9408333 0.383504
+ 1.9411111 0.418816
+ 1.9413889 0.445054
+ 1.9416667 0.459882
+ 1.9419444 0.461655
+ 1.9422222 0.451505
+ 1.9425000 0.431256
+ 1.9427778 0.402734
+ 1.9430556 0.367764
+ 1.9433333 0.328171
+ 1.9436111 0.285781
+ 1.9438889 0.242417
+ 1.9441667 0.199906
+ 1.9444444 0.160072
+ 1.9447222 0.124512
+ 1.9450000 0.093908
+ 1.9452778 0.068714
+ 1.9455556 0.050000
+ 1.9458333 0.050000
+ 1.9461111 0.050000
+ 1.9463889 0.050000
+ 1.9466667 0.050000
+ 1.9469444 0.056526
+ 1.9472222 0.081890
+ 1.9475000 0.115841
+ 1.9477778 0.156598
+ 1.9480556 0.201928
+ 1.9483333 0.249602
+ 1.9486111 0.297387
+ 1.9488889 0.343053
+ 1.9491667 0.384369
+ 1.9494444 0.419105
+ 1.9497222 0.445028
+ 1.9500000 0.459908
+ 1.9502778 0.462175
+ 1.9505556 0.452893
+ 1.9508333 0.433791
+ 1.9511111 0.406594
+ 1.9513889 0.373029
+ 1.9516667 0.334823
+ 1.9519444 0.293702
+ 1.9522222 0.251393
+ 1.9525000 0.209621
+ 1.9527778 0.170114
+ 1.9530556 0.134401
+ 1.9533333 0.103220
+ 1.9536111 0.077114
+ 1.9538889 0.056623
+ 1.9541667 0.050000
+ 1.9544444 0.050000
+ 1.9547222 0.050000
+ 1.9550000 0.050000
+ 1.9552778 0.057364
+ 1.9555556 0.081942
+ 1.9558333 0.115452
+ 1.9561111 0.156064
+ 1.9563889 0.201469
+ 1.9566667 0.249363
+ 1.9569444 0.297439
+ 1.9572222 0.343391
+ 1.9575000 0.384912
+ 1.9577778 0.419697
+ 1.9580556 0.445438
+ 1.9583333 0.459830
+ 1.9586111 0.461254
+ 1.9588889 0.450844
+ 1.9591667 0.430421
+ 1.9594444 0.401806
+ 1.9597222 0.366820
+ 1.9600000 0.327284
+ 1.9602778 0.285021
+ 1.9605556 0.241850
+ 1.9608333 0.199593
+ 1.9611111 0.160072
+ 1.9613889 0.124877
+ 1.9616667 0.094675
+ 1.9619444 0.069906
+ 1.9622222 0.051005
+ 1.9625000 0.050000
+ 1.9627778 0.050000
+ 1.9630556 0.050000
+ 1.9633333 0.050000
+ 1.9636111 0.059843
+ 1.9638889 0.085342
+ 1.9641667 0.119327
+ 1.9644444 0.160018
+ 1.9647222 0.205189
+ 1.9650000 0.252614
+ 1.9652778 0.300068
+ 1.9655556 0.345326
+ 1.9658333 0.386162
+ 1.9661111 0.420350
+ 1.9663889 0.445665
+ 1.9666667 0.459882
+ 1.9669444 0.461437
+ 1.9672222 0.451410
+ 1.9675000 0.431546
+ 1.9677778 0.403585
+ 1.9680556 0.369273
+ 1.9683333 0.330350
+ 1.9686111 0.288561
+ 1.9688889 0.245647
+ 1.9691667 0.203353
+ 1.9694444 0.163419
+ 1.9697222 0.127388
+ 1.9700000 0.095992
+ 1.9702778 0.069759
+ 1.9705556 0.050000
+ 1.9708333 0.050000
+ 1.9711111 0.050000
+ 1.9713889 0.050000
+ 1.9716667 0.050000
+ 1.9719444 0.050491
+ 1.9722222 0.075247
+ 1.9725000 0.108939
+ 1.9727778 0.149759
+ 1.9730556 0.195432
+ 1.9733333 0.243682
+ 1.9736111 0.292234
+ 1.9738889 0.338811
+ 1.9741667 0.381139
+ 1.9744444 0.416942
+ 1.9747222 0.443944
+ 1.9750000 0.459869
+ 1.9752778 0.463107
+ 1.9755556 0.454702
+ 1.9758333 0.436364
+ 1.9761111 0.409803
+ 1.9763889 0.376727
+ 1.9766667 0.338846
+ 1.9769444 0.297870
+ 1.9772222 0.255507
+ 1.9775000 0.213468
+ 1.9777778 0.173462
+ 1.9780556 0.137012
+ 1.9783333 0.104897
+ 1.9786111 0.077711
+ 1.9788889 0.056047
+ 1.9791667 0.050000
+ 1.9794444 0.050000
+ 1.9797222 0.050000
+ 1.9800000 0.050000
+ 1.9802778 0.051320
+ 1.9805556 0.075247
+ 1.9808333 0.108364
+ 1.9811111 0.148841
+ 1.9813889 0.194363
+ 1.9816667 0.242616
+ 1.9819444 0.291284
+ 1.9822222 0.338053
+ 1.9825000 0.380609
+ 1.9827778 0.416635
+ 1.9830556 0.443818
+ 1.9833333 0.459843
+ 1.9836111 0.463074
+ 1.9838889 0.454595
+ 1.9841667 0.436170
+ 1.9844444 0.409562
+ 1.9847222 0.376533
+ 1.9850000 0.338848
+ 1.9852778 0.298270
+ 1.9855556 0.256562
+ 1.9858333 0.215487
+ 1.9861111 0.176809
+ 1.9863889 0.142077
+ 1.9866667 0.111982
+ 1.9869444 0.087002
+ 1.9872222 0.067612
+ 1.9875000 0.054291
+ 1.9877778 0.050000
+ 1.9880556 0.050000
+ 1.9883333 0.055510
+ 1.9886111 0.071233
+ 1.9888889 0.095410
+ 1.9891667 0.128071
+ 1.9894444 0.167457
+ 1.9897222 0.211362
+ 1.9900000 0.257580
+ 1.9902778 0.303906
+ 1.9905556 0.348133
+ 1.9908333 0.388055
+ 1.9911111 0.421466
+ 1.9913889 0.446162
+ 1.9916667 0.459935
+ 1.9919444 0.461234
+ 1.9922222 0.451131
+ 1.9925000 0.431349
+ 1.9927778 0.403613
+ 1.9930556 0.369649
+ 1.9933333 0.331181
+ 1.9936111 0.289934
+ 1.9938889 0.247632
+ 1.9941667 0.206002
+ 1.9944444 0.166767
+ 1.9947222 0.131449
+ 1.9950000 0.100754
+ 1.9952778 0.075184
+ 1.9955556 0.055243
+ 1.9958333 0.050000
+ 1.9961111 0.050000
+ 1.9963889 0.050000
+ 1.9966667 0.050000
+ 1.9969444 0.057557
+ 1.9972222 0.081942
+ 1.9975000 0.115022
+ 1.9977778 0.155040
+ 1.9980556 0.199787
+ 1.9983333 0.247054
+ 1.9986111 0.294634
+ 1.9988889 0.340316
+ 1.9991667 0.381892
+ 1.9994444 0.417153
+ 1.9997222 0.443890
+ 2.0000000 0.459895
+ 2.0002778 0.463599
+ 2.0005556 0.455991
+ 2.0008333 0.438702
+ 2.0011111 0.413361
+ 2.0013889 0.381598
+ 2.0016667 0.345044
+ 2.0019444 0.305327
+ 2.0022222 0.264078
+ 2.0025000 0.222928
+ 2.0027778 0.183504
+ 2.0030556 0.147275
+ 2.0033333 0.115047
+ 2.0036111 0.087466
+ 2.0038889 0.065177
+ 2.0041667 0.050000
+ 2.0044444 0.050000
+ 2.0047222 0.050000
+ 2.0050000 0.050000
+ 2.0052778 0.055663
+ 2.0055556 0.078660
+ 2.0058333 0.110966
+ 2.0061111 0.150754
+ 2.0063889 0.195703
+ 2.0066667 0.243492
+ 2.0069444 0.291799
+ 2.0072222 0.338302
+ 2.0075000 0.380681
+ 2.0077778 0.416614
+ 2.0080556 0.443780
+ 2.0083333 0.459856
+ 2.0086111 0.463199
+ 2.0088889 0.454871
+ 2.0091667 0.436611
+ 2.0094444 0.410159
+ 2.0097222 0.377254
+ 2.0100000 0.339635
+ 2.0102778 0.299042
+ 2.0105556 0.257214
+ 2.0108333 0.215890
+ 2.0111111 0.176809
+ 2.0113889 0.141509
+ 2.0116667 0.110710
+ 2.0119444 0.084933
+ 2.0122222 0.064696
+ 2.0125000 0.050519
+ 2.0127778 0.050000
+ 2.0130556 0.050000
+ 2.0133333 0.050000
+ 2.0136111 0.064793
+ 2.0138889 0.088702
+ 2.0141667 0.121328
+ 2.0144444 0.160900
+ 2.0147222 0.205186
+ 2.0150000 0.251958
+ 2.0152778 0.298985
+ 2.0155556 0.344038
+ 2.0158333 0.384887
+ 2.0161111 0.419301
+ 2.0163889 0.445052
+ 2.0166667 0.459908
+ 2.0169444 0.462299
+ 2.0172222 0.453285
+ 2.0175000 0.434584
+ 2.0177778 0.407915
+ 2.0180556 0.374997
+ 2.0183333 0.337547
+ 2.0186111 0.297285
+ 2.0188889 0.255929
+ 2.0191667 0.215198
+ 2.0194444 0.176809
+ 2.0197222 0.142278
+ 2.0200000 0.112300
+ 2.0202778 0.087367
+ 2.0205556 0.067969
+ 2.0208333 0.054600
+ 2.0211111 0.050000
+ 2.0213889 0.050000
+ 2.0216667 0.055573
+ 2.0219444 0.071229
+ 2.0222222 0.095371
+ 2.0225000 0.128038
+ 2.0227778 0.167464
+ 2.0230556 0.211430
+ 2.0233333 0.257718
+ 2.0236111 0.304110
+ 2.0238889 0.348387
+ 2.0241667 0.388332
+ 2.0244444 0.421726
+ 2.0247222 0.446350
+ 2.0250000 0.459987
+ 2.0252778 0.461091
+ 2.0255556 0.450807
+ 2.0258333 0.430955
+ 2.0261111 0.403352
+ 2.0263889 0.369817
+ 2.0266667 0.332169
+ 2.0269444 0.292225
+ 2.0272222 0.251805
+ 2.0275000 0.212727
+ 2.0277778 0.176809
+ 2.0280556 0.145608
+ 2.0283333 0.119627
+ 2.0286111 0.099110
+ 2.0288889 0.084300
+ 2.0291667 0.075437
+ 2.0294444 0.072765
+ 2.0297222 0.076526
+ 2.0300000 0.086963
+ 2.0302778 0.104318
+ 2.0305556 0.128833
+ 2.0308333 0.160390
+ 2.0311111 0.197425
+ 2.0313889 0.238014
+ 2.0316667 0.280233
+ 2.0319444 0.322158
+ 2.0322222 0.361865
+ 2.0325000 0.397430
+ 2.0327778 0.426928
+ 2.0330556 0.448434
+ 2.0333333 0.460026
+ 2.0336111 0.460368
+ 2.0338889 0.450484
+ 2.0341667 0.431988
+ 2.0344444 0.406493
+ 2.0347222 0.375612
+ 2.0350000 0.340959
+ 2.0352778 0.304147
+ 2.0355556 0.266790
+ 2.0358333 0.230502
+ 2.0361111 0.196894
+ 2.0363889 0.167365
+ 2.0366667 0.142437
+ 2.0369444 0.122421
+ 2.0372222 0.107623
+ 2.0375000 0.098350
+ 2.0377778 0.094911
+ 2.0380556 0.097614
+ 2.0383333 0.106766
+ 2.0386111 0.122675
+ 2.0388889 0.145649
+ 2.0391667 0.175623
+ 2.0394444 0.211049
+ 2.0397222 0.250005
+ 2.0400000 0.290568
+ 2.0402778 0.330819
+ 2.0405556 0.368836
+ 2.0408333 0.402696
+ 2.0411111 0.430480
+ 2.0413889 0.450265
+ 2.0416667 0.460131
+ 2.0419444 0.458755
+ 2.0422222 0.447215
+ 2.0425000 0.427187
+ 2.0427778 0.400349
+ 2.0430556 0.368377
+ 2.0433333 0.332948
+ 2.0436111 0.295739
+ 2.0438889 0.258427
+ 2.0441667 0.222688
+ 2.0444444 0.190199
+ 2.0447222 0.162384
+ 2.0450000 0.139650
+ 2.0452778 0.122149
+ 2.0455556 0.110035
+ 2.0458333 0.103460
+ 2.0461111 0.102580
+ 2.0463889 0.107545
+ 2.0466667 0.118510
+ 2.0469444 0.135628
+ 2.0472222 0.159052
+ 2.0475000 0.188621
+ 2.0477778 0.222922
+ 2.0480556 0.260224
+ 2.0483333 0.298800
+ 2.0486111 0.336921
+ 2.0488889 0.372860
+ 2.0491667 0.404886
+ 2.0494444 0.431272
+ 2.0497222 0.450289
+ 2.0500000 0.460209
+ 2.0502778 0.459835
+ 2.0505556 0.450096
+ 2.0508333 0.432451
+ 2.0511111 0.408363
+ 2.0513889 0.379290
+ 2.0516667 0.346694
+ 2.0519444 0.312035
+ 2.0522222 0.276773
+ 2.0525000 0.242370
+ 2.0527778 0.210284
+ 2.0530556 0.181792
+ 2.0533333 0.157424
+ 2.0536111 0.137525
+ 2.0538889 0.122441
+ 2.0541667 0.112517
+ 2.0544444 0.108098
+ 2.0547222 0.109530
+ 2.0550000 0.117158
+ 2.0552778 0.131327
+ 2.0555556 0.152383
+ 2.0558333 0.180313
+ 2.0561111 0.213675
+ 2.0563889 0.250669
+ 2.0566667 0.289494
+ 2.0569444 0.328352
+ 2.0572222 0.365441
+ 2.0575000 0.398962
+ 2.0577778 0.427116
+ 2.0580556 0.448101
+ 2.0583333 0.460118
+ 2.0586111 0.461899
+ 2.0588889 0.454308
+ 2.0591667 0.438741
+ 2.0594444 0.416593
+ 2.0597222 0.389260
+ 2.0600000 0.358138
+ 2.0602778 0.324623
+ 2.0605556 0.290110
+ 2.0608333 0.255995
+ 2.0611111 0.223674
+ 2.0613889 0.194386
+ 2.0616667 0.168741
+ 2.0619444 0.147192
+ 2.0622222 0.130193
+ 2.0625000 0.118196
+ 2.0627778 0.111655
+ 2.0630556 0.111023
+ 2.0633333 0.116754
+ 2.0636111 0.129299
+ 2.0638889 0.149114
+ 2.0641667 0.176264
+ 2.0644444 0.209269
+ 2.0647222 0.246264
+ 2.0650000 0.285381
+ 2.0652778 0.324754
+ 2.0655556 0.362516
+ 2.0658333 0.396801
+ 2.0661111 0.425743
+ 2.0663889 0.447475
+ 2.0666667 0.460131
+ 2.0669444 0.462390
+ 2.0672222 0.455121
+ 2.0675000 0.439738
+ 2.0677778 0.417655
+ 2.0680556 0.390287
+ 2.0683333 0.359049
+ 2.0686111 0.325354
+ 2.0688889 0.290617
+ 2.0691667 0.256252
+ 2.0694444 0.223674
+ 2.0697222 0.194140
+ 2.0700000 0.168271
+ 2.0702778 0.146533
+ 2.0705556 0.129391
+ 2.0708333 0.117309
+ 2.0711111 0.110751
+ 2.0713889 0.110183
+ 2.0716667 0.116069
+ 2.0719444 0.128873
+ 2.0722222 0.149062
+ 2.0725000 0.176699
+ 2.0727778 0.210255
+ 2.0730556 0.247800
+ 2.0733333 0.287404
+ 2.0736111 0.327137
+ 2.0738889 0.365071
+ 2.0741667 0.399274
+ 2.0744444 0.427818
+ 2.0747222 0.448773
+ 2.0750000 0.460209
+ 2.0752778 0.460770
+ 2.0755556 0.451396
+ 2.0758333 0.433598
+ 2.0761111 0.408891
+ 2.0763889 0.378785
+ 2.0766667 0.344795
+ 2.0769444 0.308433
+ 2.0772222 0.271212
+ 2.0775000 0.234644
+ 2.0777778 0.200242
+ 2.0780556 0.169340
+ 2.0783333 0.142554
+ 2.0786111 0.120322
+ 2.0788889 0.103080
+ 2.0791667 0.091267
+ 2.0794444 0.085319
+ 2.0797222 0.085673
+ 2.0800000 0.092767
+ 2.0802778 0.107039
+ 2.0805556 0.128924
+ 2.0808333 0.158459
+ 2.0811111 0.194066
+ 2.0813889 0.233766
+ 2.0816667 0.275580
+ 2.0819444 0.317528
+ 2.0822222 0.357632
+ 2.0825000 0.393911
+ 2.0827778 0.424388
+ 2.0830556 0.447081
+ 2.0833333 0.460013
+ 2.0836111 0.461784
+ 2.0838889 0.453313
+ 2.0841667 0.436102
+ 2.0844444 0.411650
+ 2.0847222 0.381458
+ 2.0850000 0.347025
+ 2.0852778 0.309852
+ 2.0855556 0.271439
+ 2.0858333 0.233287
+ 2.0861111 0.196894
+ 2.0863889 0.163608
+ 2.0866667 0.134157
+ 2.0869444 0.109116
+ 2.0872222 0.089058
+ 2.0875000 0.074558
+ 2.0877778 0.066190
+ 2.0880556 0.064529
+ 2.0883333 0.070150
+ 2.0886111 0.083625
+ 2.0888889 0.105531
+ 2.0891667 0.135987
+ 2.0894444 0.173293
+ 2.0897222 0.215296
+ 2.0900000 0.259843
+ 2.0902778 0.304779
+ 2.0905556 0.347952
+ 2.0908333 0.387208
+ 2.0911111 0.420392
+ 2.0913889 0.445353
+ 2.0916667 0.459935
+ 2.0919444 0.462607
+ 2.0922222 0.454329
+ 2.0925000 0.436679
+ 2.0927778 0.411240
+ 2.0930556 0.379590
+ 2.0933333 0.343310
+ 2.0936111 0.303982
+ 2.0938889 0.263184
+ 2.0941667 0.222498
+ 2.0944444 0.183504
+ 2.0947222 0.147627
+ 2.0950000 0.115669
+ 2.0952778 0.088276
+ 2.0955556 0.066095
+ 2.0958333 0.050000
+ 2.0961111 0.050000
+ 2.0963889 0.050000
+ 2.0966667 0.050000
+ 2.0969444 0.055985
+ 2.0972222 0.078647
+ 2.0975000 0.110557
+ 2.0977778 0.149925
+ 2.0980556 0.194472
+ 2.0983333 0.241919
+ 2.0986111 0.289986
+ 2.0988889 0.336396
+ 2.0991667 0.378869
+ 2.0994444 0.415127
+ 2.0997222 0.442891
+ 2.1000000 0.459882
+ 2.1002778 0.464476
+ 2.1005556 0.457665
+ 2.1008333 0.441095
+ 2.1011111 0.416414
+ 2.1013889 0.385268
+ 2.1016667 0.349304
+ 2.1019444 0.310168
+ 2.1022222 0.269508
+ 2.1025000 0.228969
+ 2.1027778 0.190199
+ 2.1030556 0.154672
+ 2.1033333 0.123166
+ 2.1036111 0.096290
+ 2.1038889 0.074649
+ 2.1041667 0.058850
+ 2.1044444 0.050000
+ 2.1047222 0.050000
+ 2.1050000 0.052576
+ 2.1052778 0.066214
+ 2.1055556 0.088728
+ 2.1058333 0.120250
+ 2.1061111 0.159007
+ 2.1063889 0.202752
+ 2.1066667 0.249238
+ 2.1069444 0.296218
+ 2.1072222 0.341443
+ 2.1075000 0.382667
+ 2.1077778 0.417642
+ 2.1080556 0.444121
+ 2.1083333 0.459856
+ 2.1086111 0.463252
+ 2.1088889 0.455320
+ 2.1091667 0.437721
+ 2.1094444 0.412118
+ 2.1097222 0.380174
+ 2.1100000 0.343550
+ 2.1102778 0.303908
+ 2.1105556 0.262912
+ 2.1108333 0.222223
+ 2.1111111 0.183504
+ 2.1113889 0.148236
+ 2.1116667 0.117172
+ 2.1119444 0.090885
+ 2.1122222 0.069947
+ 2.1125000 0.054932
+ 2.1127778 0.050000
+ 2.1130556 0.050000
+ 2.1133333 0.051145
+ 2.1136111 0.065544
+ 2.1138889 0.088728
+ 2.1141667 0.120800
+ 2.1144444 0.159983
+ 2.1147222 0.204031
+ 2.1150000 0.250698
+ 2.1152778 0.297737
+ 2.1155556 0.342902
+ 2.1158333 0.383946
+ 2.1161111 0.418624
+ 2.1163889 0.444689
+ 2.1166667 0.459895
+ 2.1169444 0.462649
+ 2.1172222 0.453968
+ 2.1175000 0.435525
+ 2.1177778 0.408990
+ 2.1180556 0.376035
+ 2.1183333 0.338332
+ 2.1186111 0.297552
+ 2.1188889 0.255366
+ 2.1191667 0.213445
+ 2.1194444 0.173462
+ 2.1197222 0.136911
+ 2.1200000 0.104585
+ 2.1202778 0.077098
+ 2.1205556 0.055067
+ 2.1208333 0.050000
+ 2.1211111 0.050000
+ 2.1213889 0.050000
+ 2.1216667 0.050000
+ 2.1219444 0.050000
+ 2.1222222 0.071939
+ 2.1225000 0.104853
+ 2.1227778 0.145226
+ 2.1230556 0.190751
+ 2.1233333 0.239120
+ 2.1236111 0.288025
+ 2.1238889 0.335160
+ 2.1241667 0.378216
+ 2.1244444 0.414887
+ 2.1247222 0.442865
+ 2.1250000 0.459843
+ 2.1252778 0.464176
+ 2.1255556 0.456873
+ 2.1258333 0.439606
+ 2.1261111 0.414046
+ 2.1263889 0.381865
+ 2.1266667 0.344735
+ 2.1269444 0.304328
+ 2.1272222 0.262314
+ 2.1275000 0.220367
+ 2.1277778 0.180157
+ 2.1280556 0.143187
+ 2.1283333 0.110281
+ 2.1286111 0.082094
+ 2.1288889 0.059281
+ 2.1291667 0.050000
+ 2.1294444 0.050000
+ 2.1297222 0.050000
+ 2.1300000 0.050000
+ 2.1302778 0.050000
+ 2.1305556 0.071925
+ 2.1308333 0.104566
+ 2.1311111 0.144821
+ 2.1313889 0.190347
+ 2.1316667 0.238801
+ 2.1319444 0.287840
+ 2.1322222 0.335121
+ 2.1325000 0.378299
+ 2.1327778 0.415033
+ 2.1330556 0.442978
+ 2.1333333 0.459791
+ 2.1336111 0.463806
+ 2.1338889 0.456062
+ 2.1341667 0.438277
+ 2.1344444 0.412166
+ 2.1347222 0.379448
+ 2.1350000 0.341837
+ 2.1352778 0.301051
+ 2.1355556 0.258807
+ 2.1358333 0.216821
+ 2.1361111 0.176809
+ 2.1363889 0.140305
+ 2.1366667 0.108103
+ 2.1369444 0.080815
+ 2.1372222 0.059051
+ 2.1375000 0.050000
+ 2.1377778 0.050000
+ 2.1380556 0.050000
+ 2.1383333 0.050000
+ 2.1386111 0.054475
+ 2.1388889 0.078686
+ 2.1391667 0.112196
+ 2.1394444 0.153114
+ 2.1397222 0.199045
+ 2.1400000 0.247594
+ 2.1402778 0.296370
+ 2.1405556 0.342977
+ 2.1408333 0.385021
+ 2.1411111 0.420110
+ 2.1413889 0.445848
+ 2.1416667 0.459843
+ 2.1419444 0.460410
+ 2.1422222 0.448701
+ 2.1425000 0.426580
+ 2.1427778 0.395910
+ 2.1430556 0.358551
+ 2.1433333 0.316368
+ 2.1436111 0.271223
+ 2.1438889 0.224978
+ 2.1441667 0.179496
+ 2.1444444 0.136639
+ 2.1447222 0.098058
+ 2.1450000 0.064555
+ 2.1452778 0.050000
+ 2.1455556 0.050000
+ 2.1458333 0.050000
+ 2.1461111 0.050000
+ 2.1463889 0.050000
+ 2.1466667 0.050000
+ 2.1469444 0.050000
+ 2.1472222 0.050000
+ 2.1475000 0.088161
+ 2.1477778 0.134040
+ 2.1480556 0.184976
+ 2.1483333 0.238308
+ 2.1486111 0.291374
+ 2.1488889 0.341513
+ 2.1491667 0.386063
+ 2.1494444 0.422363
+ 2.1497222 0.447752
+ 2.1500000 0.459568
+ 2.1502778 0.455988
+ 2.1505556 0.438537
+ 2.1508333 0.409576
+ 2.1511111 0.371470
+ 2.1513889 0.326581
+ 2.1516667 0.277271
+ 2.1519444 0.225903
+ 2.1522222 0.174840
+ 2.1525000 0.126445
+ 2.1527778 0.083079
+ 2.1530556 0.050000
+ 2.1533333 0.050000
+ 2.1536111 0.050000
+ 2.1538889 0.050000
+ 2.1541667 0.050000
+ 2.1544444 0.050000
+ 2.1547222 0.050000
+ 2.1550000 0.050000
+ 2.1552778 0.050000
+ 2.1555556 0.050000
+ 2.1558333 0.086584
+ 2.1561111 0.128715
+ 2.1563889 0.174677
+ 2.1566667 0.222751
+ 2.1569444 0.271217
+ 2.1572222 0.318357
+ 2.1575000 0.362454
+ 2.1577778 0.401788
+ 2.1580556 0.434641
+ 2.1583333 0.459294
+ 2.1586111 0.474467
+ 2.1588889 0.480628
+ 2.1591667 0.478684
+ 2.1594444 0.469541
+ 2.1597222 0.454105
+ 2.1600000 0.433284
+ 2.1602778 0.407983
+ 2.1605556 0.379109
+ 2.1608333 0.347568
+ 2.1611111 0.314266
+ 2.1613889 0.280156
+ 2.1616667 0.246374
+ 2.1619444 0.214100
+ 2.1622222 0.184515
+ 2.1625000 0.158801
+ 2.1627778 0.138138
+ 2.1630556 0.123709
+ 2.1633333 0.116694
+ 2.1636111 0.118274
+ 2.1638889 0.129631
+ 2.1641667 0.151418
+ 2.1644444 0.182184
+ 2.1647222 0.219949
+ 2.1650000 0.262733
+ 2.1652778 0.308557
+ 2.1655556 0.355443
+ 2.1658333 0.401409
+ 2.1661111 0.444478
+ 2.1663889 0.482670
+ 2.1666667 0.514005
+ 2.1669444 0.537067
+ 2.1672222 0.552699
+ 2.1675000 0.562303
+ 2.1677778 0.567284
+ 2.1680556 0.569046
+ 2.1683333 0.568994
+ 2.1686111 0.568533
+ 2.1688889 0.569065
+ 2.1691667 0.571997
+ 2.1694444 0.578732
+ 2.1697222 0.590236
+ 2.1700000 0.605727
+ 2.1702778 0.623981
+ 2.1705556 0.643778
+ 2.1708333 0.663897
+ 2.1711111 0.683114
+ 2.1713889 0.700209
+ 2.1716667 0.713960
+ 2.1719444 0.723146
+ 2.1722222 0.726545
+ 2.1725000 0.723277
+ 2.1727778 0.713837
+ 2.1730556 0.699059
+ 2.1733333 0.679780
+ 2.1736111 0.656835
+ 2.1738889 0.631061
+ 2.1741667 0.603293
+ 2.1744444 0.574367
+ 2.1747222 0.545119
+ 2.1750000 0.516384
+ 2.1752778 0.488943
+ 2.1755556 0.463347
+ 2.1758333 0.440093
+ 2.1761111 0.419677
+ 2.1763889 0.402596
+ 2.1766667 0.389346
+ 2.1769444 0.380422
+ 2.1772222 0.376322
+ 2.1775000 0.377542
+ 2.1777778 0.384577
+ 2.1780556 0.397631
+ 2.1783333 0.415734
+ 2.1786111 0.437624
+ 2.1788889 0.462038
+ 2.1791667 0.487714
+ 2.1794444 0.513389
+ 2.1797222 0.537800
+ 2.1800000 0.559686
+ 2.1802778 0.577782
+ 2.1805556 0.590827
+ 2.1808333 0.597853
+ 2.1811111 0.599074
+ 2.1813889 0.594997
+ 2.1816667 0.586132
+ 2.1819444 0.572985
+ 2.1822222 0.556067
+ 2.1825000 0.535884
+ 2.1827778 0.512946
+ 2.1830556 0.487761
+ 2.1833333 0.460837
+ 2.1836111 0.432628
+ 2.1838889 0.403370
+ 2.1841667 0.373245
+ 2.1844444 0.342435
+ 2.1847222 0.311122
+ 2.1850000 0.279488
+ 2.1852778 0.247715
+ 2.1855556 0.215984
+ 2.1858333 0.184477
+ 2.1861111 0.153377
+ 2.1863889 0.123010
+ 2.1866667 0.094284
+ 2.1869444 0.068254
+ 2.1872222 0.050000
+ 2.1875000 0.050000
+ 2.1877778 0.050000
+ 2.1880556 0.050000
+ 2.1883333 0.050000
+ 2.1886111 0.050000
+ 2.1888889 0.050000
+ 2.1891667 0.082858
+ 2.1894444 0.124296
+ 2.1897222 0.171773
+ 2.1900000 0.222744
+ 2.1902778 0.274669
+ 2.1905556 0.325004
+ 2.1908333 0.371207
+ 2.1911111 0.410734
+ 2.1913889 0.441045
+ 2.1916667 0.459595
+ 2.1919444 0.464566
+ 2.1922222 0.457040
+ 2.1925000 0.438820
+ 2.1927778 0.411710
+ 2.1930556 0.377515
+ 2.1933333 0.338039
+ 2.1936111 0.295088
+ 2.1938889 0.250464
+ 2.1941667 0.205973
+ 2.1944444 0.163419
+ 2.1947222 0.124417
+ 2.1950000 0.089824
+ 2.1952778 0.060305
+ 2.1955556 0.050000
+ 2.1958333 0.050000
+ 2.1961111 0.050000
+ 2.1963889 0.050000
+ 2.1966667 0.050000
+ 2.1969444 0.050000
+ 2.1972222 0.051775
+ 2.1975000 0.086336
+ 2.1977778 0.128846
+ 2.1980556 0.176842
+ 2.1983333 0.227865
+ 2.1986111 0.279453
+ 2.1988889 0.329146
+ 2.1991667 0.374484
+ 2.1994444 0.413004
+ 2.1997222 0.442247
+ 2.2000000 0.459752
+ 2.2002778 0.463769
+ 2.2005556 0.455401
+ 2.2008333 0.436458
+ 2.2011111 0.408755
+ 2.2013889 0.374104
+ 2.2016667 0.334318
+ 2.2019444 0.291208
+ 2.2022222 0.246589
+ 2.2025000 0.202273
+ 2.2027778 0.160072
+ 2.2030556 0.121601
+ 2.2033333 0.087683
+ 2.2036111 0.058942
+ 2.2038889 0.050000
+ 2.2041667 0.050000
+ 2.2044444 0.050000
+ 2.2047222 0.050000
+ 2.2050000 0.050000
+ 2.2052778 0.050000
+ 2.2055556 0.055123
+ 2.2058333 0.089755
+ 2.2061111 0.132137
+ 2.2063889 0.179848
+ 2.2066667 0.230468
+ 2.2069444 0.281576
+ 2.2072222 0.330753
+ 2.2075000 0.375578
+ 2.2077778 0.413631
+ 2.2080556 0.442491
+ 2.2083333 0.459738
+ 2.2086111 0.463655
+ 2.2088889 0.455333
+ 2.2091667 0.436566
+ 2.2094444 0.409147
+ 2.2097222 0.374871
+ 2.2100000 0.335532
+ 2.2102778 0.292923
+ 2.2105556 0.248839
+ 2.2108333 0.205073
+ 2.2111111 0.163419
+ 2.2113889 0.125476
+ 2.2116667 0.092058
+ 2.2119444 0.063784
+ 2.2122222 0.050000
+ 2.2125000 0.050000
+ 2.2127778 0.050000
+ 2.2130556 0.050000
+ 2.2133333 0.050000
+ 2.2136111 0.050000
+ 2.2138889 0.061896
+ 2.2141667 0.096548
+ 2.2144444 0.138854
+ 2.2147222 0.186372
+ 2.2150000 0.236660
+ 2.2152778 0.287276
+ 2.2155556 0.335778
+ 2.2158333 0.379724
+ 2.2161111 0.416671
+ 2.2163889 0.444179
+ 2.2166667 0.459804
+ 2.2169444 0.461826
+ 2.2172222 0.451411
+ 2.2175000 0.430444
+ 2.2177778 0.400812
+ 2.2180556 0.364401
+ 2.2183333 0.323097
+ 2.2186111 0.278787
+ 2.2188889 0.233357
+ 2.2191667 0.188693
+ 2.2194444 0.146682
+ 2.2197222 0.108981
+ 2.2200000 0.076330
+ 2.2202778 0.050000
+ 2.2205556 0.050000
+ 2.2208333 0.050000
+ 2.2211111 0.050000
+ 2.2213889 0.050000
+ 2.2216667 0.050000
+ 2.2219444 0.050000
+ 2.2222222 0.058431
+ 2.2225000 0.093813
+ 2.2227778 0.136509
+ 2.2230556 0.184173
+ 2.2233333 0.234458
+ 2.2236111 0.285017
+ 2.2238889 0.333503
+ 2.2241667 0.377571
+ 2.2244444 0.414872
+ 2.2247222 0.443061
+ 2.2250000 0.459791
+ 2.2252778 0.463397
+ 2.2255556 0.454949
+ 2.2258333 0.436195
+ 2.2261111 0.408887
+ 2.2263889 0.374774
+ 2.2266667 0.335608
+ 2.2269444 0.293140
+ 2.2272222 0.249118
+ 2.2275000 0.205295
+ 2.2277778 0.163419
+ 2.2280556 0.125061
+ 2.2283333 0.091062
+ 2.2286111 0.062080
+ 2.2288889 0.050000
+ 2.2291667 0.050000
+ 2.2294444 0.050000
+ 2.2297222 0.050000
+ 2.2300000 0.050000
+ 2.2302778 0.050000
+ 2.2305556 0.055123
+ 2.2308333 0.089515
+ 2.2311111 0.131763
+ 2.2313889 0.179425
+ 2.2316667 0.230063
+ 2.2319444 0.281235
+ 2.2322222 0.330503
+ 2.2325000 0.375426
+ 2.2327778 0.413564
+ 2.2330556 0.442477
+ 2.2333333 0.459725
+ 2.2336111 0.463575
+ 2.2338889 0.455118
+ 2.2341667 0.436150
+ 2.2344444 0.408470
+ 2.2347222 0.373874
+ 2.2350000 0.334160
+ 2.2352778 0.291126
+ 2.2355556 0.246568
+ 2.2358333 0.202284
+ 2.2361111 0.160072
+ 2.2363889 0.121536
+ 2.2366667 0.087514
+ 2.2369444 0.058649
+ 2.2372222 0.050000
+ 2.2375000 0.050000
+ 2.2377778 0.050000
+ 2.2380556 0.050000
+ 2.2383333 0.050000
+ 2.2386111 0.050000
+ 2.2388889 0.055162
+ 2.2391667 0.090243
+ 2.2394444 0.133152
+ 2.2397222 0.181401
+ 2.2400000 0.232504
+ 2.2402778 0.283973
+ 2.2405556 0.333323
+ 2.2408333 0.378065
+ 2.2411111 0.415712
+ 2.2413889 0.443779
+ 2.2416667 0.459778
+ 2.2419444 0.461956
+ 2.2422222 0.451498
+ 2.2425000 0.430326
+ 2.2427778 0.400357
+ 2.2430556 0.363512
+ 2.2433333 0.321710
+ 2.2436111 0.276872
+ 2.2438889 0.230917
+ 2.2441667 0.185765
+ 2.2444444 0.143334
+ 2.2447222 0.105310
+ 2.2450000 0.072432
+ 2.2452778 0.050000
+ 2.2455556 0.050000
+ 2.2458333 0.050000
+ 2.2461111 0.050000
+ 2.2463889 0.050000
+ 2.2466667 0.050000
+ 2.2469444 0.050000
+ 2.2472222 0.055070
+ 2.2475000 0.090686
+ 2.2477778 0.133634
+ 2.2480556 0.181569
+ 2.2483333 0.232146
+ 2.2486111 0.283019
+ 2.2488889 0.331844
+ 2.2491667 0.376274
+ 2.2494444 0.413966
+ 2.2497222 0.442574
+ 2.2500000 0.459752
+ 2.2502778 0.463835
+ 2.2505556 0.455877
+ 2.2508333 0.437611
+ 2.2511111 0.410772
+ 2.2513889 0.377093
+ 2.2516667 0.338307
+ 2.2519444 0.296147
+ 2.2522222 0.252349
+ 2.2525000 0.208644
+ 2.2527778 0.166767
+ 2.2530556 0.128276
+ 2.2533333 0.094032
+ 2.2536111 0.064719
+ 2.2538889 0.050000
+ 2.2541667 0.050000
+ 2.2544444 0.050000
+ 2.2547222 0.050000
+ 2.2550000 0.050000
+ 2.2552778 0.050000
+ 2.2555556 0.055149
+ 2.2558333 0.089423
+ 2.2561111 0.131643
+ 2.2563889 0.179346
+ 2.2566667 0.230067
+ 2.2569444 0.281340
+ 2.2572222 0.330702
+ 2.2575000 0.375688
+ 2.2577778 0.413832
+ 2.2580556 0.442670
+ 2.2583333 0.459738
+ 2.2586111 0.463291
+ 2.2588889 0.454459
+ 2.2591667 0.435093
+ 2.2594444 0.407046
+ 2.2597222 0.372166
+ 2.2600000 0.332306
+ 2.2602778 0.289315
+ 2.2605556 0.245045
+ 2.2608333 0.201347
+ 2.2611111 0.160072
+ 2.2613889 0.122851
+ 2.2616667 0.090438
+ 2.2619444 0.063371
+ 2.2622222 0.050000
+ 2.2625000 0.050000
+ 2.2627778 0.050000
+ 2.2630556 0.050000
+ 2.2633333 0.050000
+ 2.2636111 0.050000
+ 2.2638889 0.068552
+ 2.2641667 0.103048
+ 2.2644444 0.144828
+ 2.2647222 0.191547
+ 2.2650000 0.240859
+ 2.2652778 0.290417
+ 2.2655556 0.337875
+ 2.2658333 0.380887
+ 2.2661111 0.417108
+ 2.2663889 0.444191
+ 2.2666667 0.459791
+ 2.2669444 0.462249
+ 2.2672222 0.452664
+ 2.2675000 0.432820
+ 2.2677778 0.404505
+ 2.2680556 0.369505
+ 2.2683333 0.329604
+ 2.2686111 0.286590
+ 2.2688889 0.242248
+ 2.2691667 0.198364
+ 2.2694444 0.156724
+ 2.2697222 0.118917
+ 2.2700000 0.085736
+ 2.2702778 0.057779
+ 2.2705556 0.050000
+ 2.2708333 0.050000
+ 2.2711111 0.050000
+ 2.2713889 0.050000
+ 2.2716667 0.050000
+ 2.2719444 0.050000
+ 2.2722222 0.058470
+ 2.2725000 0.093285
+ 2.2727778 0.135694
+ 2.2730556 0.183291
+ 2.2733333 0.233673
+ 2.2736111 0.284436
+ 2.2738889 0.333174
+ 2.2741667 0.377485
+ 2.2744444 0.414963
+ 2.2747222 0.443204
+ 2.2750000 0.459804
+ 2.2752778 0.463059
+ 2.2755556 0.454064
+ 2.2758333 0.434618
+ 2.2761111 0.406515
+ 2.2763889 0.371553
+ 2.2766667 0.331528
+ 2.2769444 0.288236
+ 2.2772222 0.243473
+ 2.2775000 0.199038
+ 2.2777778 0.156724
+ 2.2780556 0.118137
+ 2.2783333 0.084102
+ 2.2786111 0.055254
+ 2.2788889 0.050000
+ 2.2791667 0.050000
+ 2.2794444 0.050000
+ 2.2797222 0.050000
+ 2.2800000 0.050000
+ 2.2802778 0.050000
+ 2.2805556 0.051775
+ 2.2808333 0.086721
+ 2.2811111 0.129481
+ 2.2813889 0.177612
+ 2.2816667 0.228670
+ 2.2819444 0.280214
+ 2.2822222 0.329800
+ 2.2825000 0.374986
+ 2.2827778 0.413329
+ 2.2830556 0.442385
+ 2.2833333 0.459712
+ 2.2836111 0.463578
+ 2.2838889 0.455086
+ 2.2841667 0.436052
+ 2.2844444 0.408291
+ 2.2847222 0.373617
+ 2.2850000 0.333845
+ 2.2852778 0.290789
+ 2.2855556 0.246266
+ 2.2858333 0.202088
+ 2.2861111 0.160072
+ 2.2863889 0.121832
+ 2.2866667 0.088185
+ 2.2869444 0.059750
+ 2.2872222 0.050000
+ 2.2875000 0.050000
+ 2.2877778 0.050000
+ 2.2880556 0.050000
+ 2.2883333 0.050000
+ 2.2886111 0.050000
+ 2.2888889 0.058496
+ 2.2891667 0.093473
+ 2.2894444 0.136146
+ 2.2897222 0.184057
+ 2.2900000 0.234749
+ 2.2902778 0.285766
+ 2.2905556 0.334651
+ 2.2908333 0.378946
+ 2.2911111 0.416195
+ 2.2913889 0.443940
+ 2.2916667 0.459725
+ 2.2919444 0.461817
+ 2.2922222 0.451380
+ 2.2925000 0.430300
+ 2.2927778 0.400466
+ 2.2930556 0.363766
+ 2.2933333 0.322086
+ 2.2936111 0.277316
+ 2.2938889 0.231342
+ 2.2941667 0.186052
+ 2.2944444 0.143334
+ 2.2947222 0.104853
+ 2.2950000 0.071382
+ 2.2952778 0.050000
+ 2.2955556 0.050000
+ 2.2958333 0.050000
+ 2.2961111 0.050000
+ 2.2963889 0.050000
+ 2.2966667 0.050000
+ 2.2969444 0.050000
+ 2.2972222 0.050000
+ 2.2975000 0.085887
+ 2.2977778 0.129328
+ 2.2980556 0.177914
+ 2.2983333 0.229236
+ 2.2986111 0.280886
+ 2.2988889 0.330455
+ 2.2991667 0.375535
+ 2.2994444 0.413717
+ 2.2997222 0.442592
+ 2.3000000 0.459752
+ 2.3002778 0.463490
+ 2.3005556 0.454914
+ 2.3008333 0.435832
+ 2.3011111 0.408053
+ 2.3013889 0.373388
+ 2.3016667 0.333644
+ 2.3019444 0.290631
+ 2.3022222 0.246159
+ 2.3025000 0.202036
+ 2.3027778 0.160072
+ 2.3030556 0.121877
+ 2.3033333 0.088266
+ 2.3036111 0.059857
+ 2.3038889 0.050000
+ 2.3041667 0.050000
+ 2.3044444 0.050000
+ 2.3047222 0.050000
+ 2.3050000 0.050000
+ 2.3052778 0.050000
+ 2.3055556 0.058444
+ 2.3058333 0.093340
+ 2.3061111 0.135925
+ 2.3063889 0.183752
+ 2.3066667 0.234374
+ 2.3069444 0.285345
+ 2.3072222 0.334218
+ 2.3075000 0.378545
+ 2.3077778 0.415881
+ 2.3080556 0.443779
+ 2.3083333 0.459791
+ 2.3086111 0.462193
+ 2.3088889 0.452149
+ 2.3091667 0.431544
+ 2.3094444 0.402265
+ 2.3097222 0.366197
+ 2.3100000 0.325226
+ 2.3102778 0.281238
+ 2.3105556 0.236119
+ 2.3108333 0.191754
+ 2.3111111 0.150029
+ 2.3113889 0.112603
+ 2.3116667 0.080223
+ 2.3119444 0.053407
+ 2.3122222 0.050000
+ 2.3125000 0.050000
+ 2.3127778 0.050000
+ 2.3130556 0.050000
+ 2.3133333 0.050000
+ 2.3136111 0.050000
+ 2.3138889 0.065126
+ 2.3141667 0.101029
+ 2.3144444 0.144217
+ 2.3147222 0.192253
+ 2.3150000 0.242705
+ 2.3152778 0.293136
+ 2.3155556 0.341113
+ 2.3158333 0.384200
+ 2.3161111 0.419963
+ 2.3163889 0.445967
+ 2.3166667 0.459778
+ 2.3169444 0.459695
+ 2.3172222 0.446958
+ 2.3175000 0.423544
+ 2.3177778 0.391428
+ 2.3180556 0.352584
+ 2.3183333 0.308989
+ 2.3186111 0.262617
+ 2.3188889 0.215445
+ 2.3191667 0.169446
+ 2.3194444 0.126597
+ 2.3197222 0.088619
+ 2.3200000 0.056215
+ 2.3202778 0.050000
+ 2.3205556 0.050000
+ 2.3208333 0.050000
+ 2.3211111 0.050000
+ 2.3213889 0.050000
+ 2.3216667 0.050000
+ 2.3219444 0.050000
+ 2.3222222 0.051618
+ 2.3225000 0.089138
+ 2.3227778 0.133855
+ 2.3230556 0.183343
+ 2.3233333 0.235180
+ 2.3236111 0.286941
+ 2.3238889 0.336201
+ 2.3241667 0.380537
+ 2.3244444 0.417523
+ 2.3247222 0.444736
+ 2.3250000 0.459752
+ 2.3252778 0.460873
+ 2.3255556 0.449313
+ 2.3258333 0.427014
+ 2.3261111 0.395917
+ 2.3263889 0.357963
+ 2.3266667 0.315094
+ 2.3269444 0.269251
+ 2.3272222 0.222376
+ 2.3275000 0.176409
+ 2.3277778 0.133292
+ 2.3280556 0.094730
+ 2.3283333 0.061486
+ 2.3286111 0.050000
+ 2.3288889 0.050000
+ 2.3291667 0.050000
+ 2.3294444 0.050000
+ 2.3297222 0.050000
+ 2.3300000 0.050000
+ 2.3302778 0.050000
+ 2.3305556 0.050000
+ 2.3308333 0.087745
+ 2.3311111 0.132992
+ 2.3313889 0.183197
+ 2.3316667 0.235816
+ 2.3319444 0.288304
+ 2.3322222 0.338117
+ 2.3325000 0.382710
+ 2.3327778 0.419538
+ 2.3330556 0.446058
+ 2.3333333 0.459725
+ 2.3336111 0.458779
+ 2.3338889 0.444591
+ 2.3341667 0.419319
+ 2.3344444 0.385119
+ 2.3347222 0.344149
+ 2.3350000 0.298563
+ 2.3352778 0.250520
+ 2.3355556 0.202175
+ 2.3358333 0.155685
+ 2.3361111 0.113207
+ 2.3363889 0.076582
+ 2.3366667 0.050000
+ 2.3369444 0.050000
+ 2.3372222 0.050000
+ 2.3375000 0.050000
+ 2.3377778 0.050000
+ 2.3380556 0.050000
+ 2.3383333 0.050000
+ 2.3386111 0.050000
+ 2.3388889 0.068356
+ 2.3391667 0.107576
+ 2.3394444 0.153210
+ 2.3397222 0.202845
+ 2.3400000 0.254070
+ 2.3402778 0.304474
+ 2.3405556 0.351644
+ 2.3408333 0.393170
+ 2.3411111 0.426640
+ 2.3413889 0.449642
+ 2.3416667 0.459765
+ 2.3419444 0.455364
+ 2.3422222 0.437868
+ 2.3425000 0.409470
+ 2.3427778 0.372364
+ 2.3430556 0.328746
+ 2.3433333 0.280810
+ 2.3436111 0.230750
+ 2.3438889 0.180762
+ 2.3441667 0.133038
+ 2.3444444 0.089774
+ 2.3447222 0.052835
+ 2.3450000 0.050000
+ 2.3452778 0.050000
+ 2.3455556 0.050000
+ 2.3458333 0.050000
+ 2.3461111 0.050000
+ 2.3463889 0.050000
+ 2.3466667 0.050000
+ 2.3469444 0.050000
+ 2.3472222 0.054848
+ 2.3475000 0.095688
+ 2.3477778 0.142890
+ 2.3480556 0.194040
+ 2.3483333 0.246723
+ 2.3486111 0.298524
+ 2.3488889 0.347029
+ 2.3491667 0.389822
+ 2.3494444 0.424490
+ 2.3497222 0.448618
+ 2.3500000 0.459791
+ 2.3502778 0.456359
+ 2.3505556 0.439735
+ 2.3508333 0.412097
+ 2.3511111 0.375621
+ 2.3513889 0.332486
+ 2.3516667 0.284868
+ 2.3519444 0.234945
+ 2.3522222 0.184895
+ 2.3525000 0.136895
+ 2.3527778 0.093122
+ 2.3530556 0.055437
+ 2.3533333 0.050000
+ 2.3536111 0.050000
+ 2.3538889 0.050000
+ 2.3541667 0.050000
+ 2.3544444 0.050000
+ 2.3547222 0.050000
+ 2.3550000 0.050000
+ 2.3552778 0.050000
+ 2.3555556 0.050000
+ 2.3558333 0.091070
+ 2.3561111 0.138797
+ 2.3563889 0.190677
+ 2.3566667 0.244205
+ 2.3569444 0.296875
+ 2.3572222 0.346183
+ 2.3575000 0.389623
+ 2.3577778 0.424690
+ 2.3580556 0.448880
+ 2.3583333 0.459686
+ 2.3586111 0.455404
+ 2.3588889 0.437524
+ 2.3591667 0.408335
+ 2.3594444 0.370128
+ 2.3597222 0.325192
+ 2.3600000 0.275818
+ 2.3602778 0.224295
+ 2.3605556 0.172913
+ 2.3608333 0.123962
+ 2.3611111 0.079732
+ 2.3613889 0.050000
+ 2.3616667 0.050000
+ 2.3619444 0.050000
+ 2.3622222 0.050000
+ 2.3625000 0.050000
+ 2.3627778 0.050000
+ 2.3630556 0.050000
+ 2.3633333 0.050000
+ 2.3636111 0.050000
+ 2.3638889 0.050000
+ 2.3641667 0.092254
+ 2.3644444 0.140874
+ 2.3647222 0.193365
+ 2.3650000 0.247234
+ 2.3652778 0.299988
+ 2.3655556 0.349132
+ 2.3658333 0.392175
+ 2.3661111 0.426621
+ 2.3663889 0.449978
+ 2.3666667 0.459752
+ 2.3669444 0.454256
+ 2.3672222 0.435038
+ 2.3675000 0.404451
+ 2.3677778 0.364847
+ 2.3680556 0.318581
+ 2.3683333 0.268006
+ 2.3686111 0.215476
+ 2.3688889 0.163344
+ 2.3691667 0.113964
+ 2.3694444 0.069689
+ 2.3697222 0.050000
+ 2.3700000 0.050000
+ 2.3702778 0.050000
+ 2.3705556 0.050000
+ 2.3708333 0.050000
+ 2.3711111 0.050000
+ 2.3713889 0.050000
+ 2.3716667 0.050000
+ 2.3719444 0.050000
+ 2.3722222 0.050000
+ 2.3725000 0.092504
+ 2.3727778 0.141071
+ 2.3730556 0.193298
+ 2.3733333 0.246786
+ 2.3736111 0.299132
+ 2.3738889 0.347937
+ 2.3741667 0.390798
+ 2.3744444 0.425315
+ 2.3747222 0.449087
+ 2.3750000 0.459712
+ 2.3752778 0.455562
+ 2.3755556 0.438095
+ 2.3758333 0.409538
+ 2.3761111 0.372123
+ 2.3763889 0.328077
+ 2.3766667 0.279631
+ 2.3769444 0.229013
+ 2.3772222 0.178454
+ 2.3775000 0.130182
+ 2.3777778 0.086427
+ 2.3780556 0.050000
+ 2.3783333 0.050000
+ 2.3786111 0.050000
+ 2.3788889 0.050000
+ 2.3791667 0.050000
+ 2.3794444 0.050000
+ 2.3797222 0.050000
+ 2.3800000 0.050000
+ 2.3802778 0.050000
+ 2.3805556 0.050000
+ 2.3808333 0.090839
+ 2.3811111 0.138067
+ 2.3813889 0.189299
+ 2.3816667 0.242152
+ 2.3819444 0.294239
+ 2.3822222 0.343176
+ 2.3825000 0.386578
+ 2.3827778 0.422060
+ 2.3830556 0.447238
+ 2.3833333 0.459725
+ 2.3836111 0.457890
+ 2.3838889 0.443102
+ 2.3841667 0.417484
+ 2.3844444 0.383159
+ 2.3847222 0.342249
+ 2.3850000 0.296876
+ 2.3852778 0.249163
+ 2.3855556 0.201232
+ 2.3858333 0.155206
+ 2.3861111 0.113207
+ 2.3863889 0.077044
+ 2.3866667 0.050000
+ 2.3869444 0.050000
+ 2.3872222 0.050000
+ 2.3875000 0.050000
+ 2.3877778 0.050000
+ 2.3880556 0.050000
+ 2.3883333 0.050000
+ 2.3886111 0.050000
+ 2.3888889 0.068395
+ 2.3891667 0.106669
+ 2.3894444 0.151236
+ 2.3897222 0.199808
+ 2.3900000 0.250097
+ 2.3902778 0.299817
+ 2.3905556 0.346680
+ 2.3908333 0.388399
+ 2.3911111 0.422686
+ 2.3913889 0.447254
+ 2.3916667 0.459817
+ 2.3919444 0.458798
+ 2.3922222 0.445466
+ 2.3925000 0.421803
+ 2.3927778 0.389790
+ 2.3930556 0.351408
+ 2.3933333 0.308637
+ 2.3936111 0.263459
+ 2.3938889 0.217855
+ 2.3941667 0.173806
+ 2.3944444 0.133292
+ 2.3947222 0.098015
+ 2.3950000 0.068556
+ 2.3952778 0.050000
+ 2.3955556 0.050000
+ 2.3958333 0.050000
+ 2.3961111 0.050000
+ 2.3963889 0.050000
+ 2.3966667 0.050000
+ 2.3969444 0.050548
+ 2.3972222 0.078477
+ 2.3975000 0.114517
+ 2.3977778 0.156888
+ 2.3980556 0.203390
+ 2.3983333 0.251824
+ 2.3986111 0.299992
+ 2.3988889 0.345694
+ 2.3991667 0.386731
+ 2.3994444 0.420906
+ 2.3997222 0.446018
+ 2.4000000 0.459869
+ 2.4002778 0.460929
+ 2.4005556 0.450338
+ 2.4008333 0.429908
+ 2.4011111 0.401448
+ 2.4013889 0.366768
+ 2.4016667 0.327678
+ 2.4019444 0.285988
+ 2.4022222 0.243508
+ 2.4025000 0.202049
+ 2.4027778 0.163419
+ 2.4030556 0.129195
+ 2.4033333 0.100006
+ 2.4036111 0.076250
+ 2.4038889 0.058322
+ 2.4041667 0.050000
+ 2.4044444 0.050000
+ 2.4047222 0.050000
+ 2.4050000 0.052816
+ 2.4052778 0.069972
+ 2.4055556 0.095332
+ 2.4058333 0.128866
+ 2.4061111 0.168832
+ 2.4063889 0.213062
+ 2.4066667 0.259387
+ 2.4069444 0.305639
+ 2.4072222 0.349648
+ 2.4075000 0.389247
+ 2.4077778 0.422267
+ 2.4080556 0.446540
+ 2.4083333 0.459895
+ 2.4086111 0.460824
+ 2.4088889 0.450444
+ 2.4091667 0.430531
+ 2.4094444 0.402863
+ 2.4097222 0.369216
+ 2.4100000 0.331365
+ 2.4102778 0.291088
+ 2.4105556 0.250161
+ 2.4108333 0.210360
+ 2.4111111 0.173462
+ 2.4113889 0.141003
+ 2.4116667 0.113563
+ 2.4119444 0.091482
+ 2.4122222 0.075098
+ 2.4125000 0.064752
+ 2.4127778 0.060782
+ 2.4130556 0.063530
+ 2.4133333 0.073334
+ 2.4136111 0.090534
+ 2.4138889 0.115469
+ 2.4141667 0.148075
+ 2.4144444 0.186665
+ 2.4147222 0.229150
+ 2.4150000 0.273439
+ 2.4152778 0.317442
+ 2.4155556 0.359068
+ 2.4158333 0.396227
+ 2.4161111 0.426829
+ 2.4163889 0.448784
+ 2.4166667 0.460000
+ 2.4169444 0.459033
+ 2.4172222 0.447018
+ 2.4175000 0.425734
+ 2.4177778 0.396963
+ 2.4180556 0.362483
+ 2.4183333 0.324075
+ 2.4186111 0.283520
+ 2.4188889 0.242597
+ 2.4191667 0.203086
+ 2.4194444 0.166767
+ 2.4197222 0.135169
+ 2.4200000 0.108811
+ 2.4202778 0.087962
+ 2.4205556 0.072889
+ 2.4208333 0.063860
+ 2.4211111 0.061144
+ 2.4213889 0.065008
+ 2.4216667 0.075721
+ 2.4219444 0.093551
+ 2.4222222 0.118764
+ 2.4225000 0.151254
+ 2.4227778 0.189409
+ 2.4230556 0.231241
+ 2.4233333 0.274761
+ 2.4236111 0.317982
+ 2.4238889 0.358916
+ 2.4241667 0.395576
+ 2.4244444 0.425972
+ 2.4247222 0.448118
+ 2.4250000 0.460026
+ 2.4252778 0.460312
+ 2.4255556 0.450013
+ 2.4258333 0.430771
+ 2.4261111 0.404225
+ 2.4263889 0.372018
+ 2.4266667 0.335791
+ 2.4269444 0.297185
+ 2.4272222 0.257841
+ 2.4275000 0.219400
+ 2.4277778 0.183504
+ 2.4280556 0.151588
+ 2.4283333 0.124257
+ 2.4286111 0.101914
+ 2.4288889 0.084959
+ 2.4291667 0.073793
+ 2.4294444 0.068816
+ 2.4297222 0.070429
+ 2.4300000 0.079033
+ 2.4302778 0.095029
+ 2.4305556 0.118817
+ 2.4308333 0.150384
+ 2.4311111 0.188064
+ 2.4313889 0.229778
+ 2.4316667 0.273444
+ 2.4319444 0.316984
+ 2.4322222 0.358317
+ 2.4325000 0.395364
+ 2.4327778 0.426045
+ 2.4330556 0.448279
+ 2.4333333 0.459987
+ 2.4336111 0.459725
+ 2.4338889 0.448595
+ 2.4341667 0.428334
+ 2.4344444 0.400680
+ 2.4347222 0.367370
+ 2.4350000 0.330143
+ 2.4352778 0.290735
+ 2.4355556 0.250885
+ 2.4358333 0.212331
+ 2.4361111 0.176809
+ 2.4363889 0.145817
+ 2.4366667 0.119881
+ 2.4369444 0.099290
+ 2.4372222 0.084329
+ 2.4375000 0.075285
+ 2.4377778 0.072445
+ 2.4380556 0.076096
+ 2.4383333 0.086524
+ 2.4386111 0.104016
+ 2.4388889 0.128859
+ 2.4391667 0.160954
+ 2.4394444 0.198666
+ 2.4397222 0.239973
+ 2.4400000 0.282854
+ 2.4402778 0.325288
+ 2.4405556 0.365255
+ 2.4408333 0.400733
+ 2.4411111 0.429702
+ 2.4413889 0.450140
+ 2.4416667 0.460026
+ 2.4419444 0.457966
+ 2.4422222 0.445069
+ 2.4425000 0.423072
+ 2.4427778 0.393709
+ 2.4430556 0.358717
+ 2.4433333 0.319831
+ 2.4436111 0.278788
+ 2.4438889 0.237324
+ 2.4441667 0.197173
+ 2.4444444 0.160072
+ 2.4447222 0.127523
+ 2.4450000 0.100096
+ 2.4452778 0.078127
+ 2.4455556 0.061950
+ 2.4458333 0.051902
+ 2.4461111 0.050000
+ 2.4463889 0.051536
+ 2.4466667 0.061890
+ 2.4469444 0.079715
+ 2.4472222 0.105348
+ 2.4475000 0.138720
+ 2.4477778 0.178141
+ 2.4480556 0.221517
+ 2.4483333 0.266755
+ 2.4486111 0.311759
+ 2.4488889 0.354436
+ 2.4491667 0.392691
+ 2.4494444 0.424431
+ 2.4497222 0.447561
+ 2.4500000 0.459987
+ 2.4502778 0.460250
+ 2.4505556 0.449432
+ 2.4508333 0.429252
+ 2.4511111 0.401426
+ 2.4513889 0.367673
+ 2.4516667 0.329710
+ 2.4519444 0.289255
+ 2.4522222 0.248026
+ 2.4525000 0.207740
+ 2.4527778 0.170114
+ 2.4530556 0.136652
+ 2.4533333 0.107989
+ 2.4536111 0.084547
+ 2.4538889 0.066748
+ 2.4541667 0.055012
+ 2.4544444 0.050000
+ 2.4547222 0.051415
+ 2.4550000 0.060397
+ 2.4552778 0.077127
+ 2.4555556 0.102027
+ 2.4558333 0.135084
+ 2.4561111 0.174555
+ 2.4563889 0.218262
+ 2.4566667 0.264027
+ 2.4569444 0.309674
+ 2.4572222 0.353025
+ 2.4575000 0.391902
+ 2.4577778 0.424129
+ 2.4580556 0.447528
+ 2.4583333 0.459922
+ 2.4586111 0.459796
+ 2.4588889 0.448294
+ 2.4591667 0.427221
+ 2.4594444 0.398383
+ 2.4597222 0.363585
+ 2.4600000 0.324635
+ 2.4602778 0.283337
+ 2.4605556 0.241498
+ 2.4608333 0.200924
+ 2.4611111 0.163419
+ 2.4613889 0.130546
+ 2.4616667 0.102880
+ 2.4619444 0.080752
+ 2.4622222 0.064495
+ 2.4625000 0.054438
+ 2.4627778 0.050914
+ 2.4630556 0.054253
+ 2.4633333 0.064786
+ 2.4636111 0.082845
+ 2.4638889 0.108761
+ 2.4641667 0.142452
+ 2.4644444 0.182184
+ 2.4647222 0.225812
+ 2.4650000 0.271188
+ 2.4652778 0.316167
+ 2.4655556 0.358602
+ 2.4658333 0.396346
+ 2.4661111 0.427254
+ 2.4663889 0.449179
+ 2.4666667 0.459974
+ 2.4669444 0.458160
+ 2.4672222 0.444922
+ 2.4675000 0.422112
+ 2.4677778 0.391584
+ 2.4680556 0.355188
+ 2.4683333 0.314777
+ 2.4686111 0.272204
+ 2.4688889 0.229320
+ 2.4691667 0.187978
+ 2.4694444 0.150029
+ 2.4697222 0.117064
+ 2.4700000 0.089621
+ 2.4702778 0.067976
+ 2.4705556 0.052403
+ 2.4708333 0.050000
+ 2.4711111 0.050000
+ 2.4713889 0.050000
+ 2.4716667 0.056361
+ 2.4719444 0.075291
+ 2.4722222 0.101948
+ 2.4725000 0.136215
+ 2.4727778 0.176395
+ 2.4730556 0.220398
+ 2.4733333 0.266135
+ 2.4736111 0.311516
+ 2.4738889 0.354451
+ 2.4741667 0.392851
+ 2.4744444 0.424624
+ 2.4747222 0.447682
+ 2.4750000 0.459935
+ 2.4752778 0.459930
+ 2.4755556 0.448771
+ 2.4758333 0.428197
+ 2.4761111 0.399949
+ 2.4763889 0.365768
+ 2.4766667 0.327393
+ 2.4769444 0.286565
+ 2.4772222 0.245024
+ 2.4775000 0.204511
+ 2.4777778 0.166767
+ 2.4780556 0.133308
+ 2.4783333 0.104764
+ 2.4786111 0.081540
+ 2.4788889 0.064042
+ 2.4791667 0.052675
+ 2.4794444 0.050000
+ 2.4797222 0.050000
+ 2.4800000 0.059421
+ 2.4802778 0.076637
+ 2.4805556 0.102014
+ 2.4808333 0.135522
+ 2.4811111 0.175399
+ 2.4813889 0.219446
+ 2.4816667 0.265465
+ 2.4819444 0.311259
+ 2.4822222 0.354629
+ 2.4825000 0.393379
+ 2.4827778 0.425309
+ 2.4830556 0.448223
+ 2.4833333 0.459922
+ 2.4836111 0.458885
+ 2.4838889 0.446299
+ 2.4841667 0.424026
+ 2.4844444 0.393929
+ 2.4847222 0.357872
+ 2.4850000 0.317717
+ 2.4852778 0.275327
+ 2.4855556 0.232565
+ 2.4858333 0.191294
+ 2.4861111 0.153377
+ 2.4863889 0.120414
+ 2.4866667 0.092951
+ 2.4869444 0.071273
+ 2.4872222 0.055663
+ 2.4875000 0.050000
+ 2.4877778 0.050000
+ 2.4880556 0.050000
+ 2.4883333 0.059584
+ 2.4886111 0.078574
+ 2.4888889 0.105335
+ 2.4891667 0.139748
+ 2.4894444 0.180084
+ 2.4897222 0.224207
+ 2.4900000 0.269986
+ 2.4902778 0.315287
+ 2.4905556 0.357976
+ 2.4908333 0.395920
+ 2.4911111 0.426985
+ 2.4913889 0.449039
+ 2.4916667 0.459948
+ 2.4919444 0.458238
+ 2.4922222 0.445076
+ 2.4925000 0.422289
+ 2.4927778 0.391702
+ 2.4930556 0.355143
+ 2.4933333 0.314438
+ 2.4936111 0.271412
+ 2.4938889 0.227894
+ 2.4941667 0.185708
+ 2.4944444 0.146682
+ 2.4947222 0.112398
+ 2.4950000 0.083466
+ 2.4952778 0.060251
+ 2.4955556 0.050000
+ 2.4958333 0.050000
+ 2.4961111 0.050000
+ 2.4963889 0.050000
+ 2.4966667 0.050000
+ 2.4969444 0.061501
+ 2.4972222 0.088545
+ 2.4975000 0.123797
+ 2.4977778 0.165449
+ 2.4980556 0.211257
+ 2.4983333 0.258979
+ 2.4986111 0.306372
+ 2.4988889 0.351192
+ 2.4991667 0.391198
+ 2.4994444 0.424146
+ 2.4997222 0.447792
+ 2.5000000 0.459895
+ 2.5002778 0.458899
+ 2.5005556 0.445998
+ 2.5008333 0.423073
+ 2.5011111 0.392006
+ 2.5013889 0.354678
+ 2.5016667 0.312972
+ 2.5019444 0.268768
+ 2.5022222 0.223948
+ 2.5025000 0.180394
+ 2.5027778 0.139987
+ 2.5030556 0.104361
+ 2.5033333 0.074159
+ 2.5036111 0.050000
+ 2.5038889 0.050000
+ 2.5041667 0.050000
+ 2.5044444 0.050000
+ 2.5047222 0.050000
+ 2.5050000 0.050000
+ 2.5052778 0.050000
+ 2.5055556 0.075155
+ 2.5058333 0.111080
+ 2.5061111 0.153687
+ 2.5063889 0.200683
+ 2.5066667 0.249774
+ 2.5069444 0.298666
+ 2.5072222 0.345066
+ 2.5075000 0.386680
+ 2.5077778 0.421214
+ 2.5080556 0.446375
+ 2.5083333 0.459869
+ 2.5086111 0.460101
+ 2.5088889 0.448266
+ 2.5091667 0.426262
+ 2.5094444 0.395983
+ 2.5097222 0.359325
+ 2.5100000 0.318183
+ 2.5102778 0.274452
+ 2.5105556 0.230028
+ 2.5108333 0.186806
+ 2.5111111 0.146682
+ 2.5113889 0.111300
+ 2.5116667 0.081300
+ 2.5119444 0.057074
+ 2.5122222 0.050000
+ 2.5125000 0.050000
+ 2.5127778 0.050000
+ 2.5130556 0.050000
+ 2.5133333 0.050000
+ 2.5136111 0.054804
+ 2.5138889 0.081916
+ 2.5141667 0.117475
+ 2.5144444 0.159638
+ 2.5147222 0.206116
+ 2.5150000 0.254617
+ 2.5152778 0.302852
+ 2.5155556 0.348530
+ 2.5158333 0.389361
+ 2.5161111 0.423055
+ 2.5163889 0.447321
+ 2.5166667 0.459869
+ 2.5169444 0.459112
+ 2.5172222 0.446275
+ 2.5175000 0.423284
+ 2.5177778 0.392068
+ 2.5180556 0.354554
+ 2.5183333 0.312671
+ 2.5186111 0.268344
+ 2.5188889 0.223503
+ 2.5191667 0.180075
+ 2.5194444 0.139987
+ 2.5197222 0.104902
+ 2.5200000 0.075422
+ 2.5202778 0.051884
+ 2.5205556 0.050000
+ 2.5208333 0.050000
+ 2.5211111 0.050000
+ 2.5213889 0.050000
+ 2.5216667 0.050000
+ 2.5219444 0.054326
+ 2.5222222 0.081824
+ 2.5225000 0.117534
+ 2.5227778 0.159653
+ 2.5230556 0.205954
+ 2.5233333 0.254205
+ 2.5236111 0.302178
+ 2.5238889 0.347644
+ 2.5241667 0.388373
+ 2.5244444 0.422135
+ 2.5247222 0.446702
+ 2.5250000 0.459843
+ 2.5252778 0.460008
+ 2.5255556 0.448354
+ 2.5258333 0.426719
+ 2.5261111 0.396937
+ 2.5263889 0.360847
+ 2.5266667 0.320284
+ 2.5269444 0.277084
+ 2.5272222 0.233085
+ 2.5275000 0.190121
+ 2.5277778 0.150029
+ 2.5280556 0.114414
+ 2.5283333 0.083949
+ 2.5286111 0.059073
+ 2.5288889 0.050000
+ 2.5291667 0.050000
+ 2.5294444 0.050000
+ 2.5297222 0.050000
+ 2.5300000 0.050000
+ 2.5302778 0.051903
+ 2.5305556 0.078503
+ 2.5308333 0.113760
+ 2.5311111 0.155822
+ 2.5313889 0.202376
+ 2.5316667 0.251111
+ 2.5319444 0.299714
+ 2.5322222 0.345874
+ 2.5325000 0.387277
+ 2.5327778 0.421612
+ 2.5330556 0.446567
+ 2.5333333 0.459830
+ 2.5336111 0.459791
+ 2.5338889 0.447651
+ 2.5341667 0.425314
+ 2.5344444 0.394684
+ 2.5347222 0.357663
+ 2.5350000 0.316156
+ 2.5352778 0.272066
+ 2.5355556 0.227297
+ 2.5358333 0.183752
+ 2.5361111 0.143334
+ 2.5363889 0.107697
+ 2.5366667 0.077486
+ 2.5369444 0.053097
+ 2.5372222 0.050000
+ 2.5375000 0.050000
+ 2.5377778 0.050000
+ 2.5380556 0.050000
+ 2.5383333 0.050000
+ 2.5386111 0.051115
+ 2.5388889 0.078529
+ 2.5391667 0.114471
+ 2.5394444 0.157077
+ 2.5397222 0.204031
+ 2.5400000 0.253015
+ 2.5402778 0.301715
+ 2.5405556 0.347813
+ 2.5408333 0.388994
+ 2.5411111 0.422941
+ 2.5413889 0.447338
+ 2.5416667 0.459869
+ 2.5419444 0.458928
+ 2.5422222 0.445750
+ 2.5425000 0.422281
+ 2.5427778 0.390466
+ 2.5430556 0.352253
+ 2.5433333 0.309585
+ 2.5436111 0.264409
+ 2.5438889 0.218671
+ 2.5441667 0.174317
+ 2.5444444 0.133292
+ 2.5447222 0.097279
+ 2.5450000 0.066913
+ 2.5452778 0.050000
+ 2.5455556 0.050000
+ 2.5458333 0.050000
+ 2.5461111 0.050000
+ 2.5463889 0.050000
+ 2.5466667 0.050000
+ 2.5469444 0.050000
+ 2.5472222 0.071755
+ 2.5475000 0.108449
+ 2.5477778 0.151805
+ 2.5480556 0.199502
+ 2.5483333 0.249217
+ 2.5486111 0.298628
+ 2.5488889 0.345413
+ 2.5491667 0.387249
+ 2.5494444 0.421814
+ 2.5497222 0.446786
+ 2.5500000 0.459843
+ 2.5502778 0.459378
+ 2.5505556 0.446647
+ 2.5508333 0.423625
+ 2.5511111 0.392283
+ 2.5513889 0.354593
+ 2.5516667 0.312530
+ 2.5519444 0.268065
+ 2.5522222 0.223171
+ 2.5525000 0.179821
+ 2.5527778 0.139987
+ 2.5530556 0.105362
+ 2.5533333 0.076516
+ 2.5536111 0.053737
+ 2.5538889 0.050000
+ 2.5541667 0.050000
+ 2.5544444 0.050000
+ 2.5547222 0.050000
+ 2.5550000 0.050000
+ 2.5552778 0.060704
+ 2.5555556 0.088506
+ 2.5558333 0.124276
+ 2.5561111 0.166226
+ 2.5563889 0.212152
+ 2.5566667 0.259850
+ 2.5569444 0.307117
+ 2.5572222 0.351749
+ 2.5575000 0.391543
+ 2.5577778 0.424294
+ 2.5580556 0.447800
+ 2.5583333 0.459856
+ 2.5586111 0.458936
+ 2.5588889 0.446225
+ 2.5591667 0.423581
+ 2.5594444 0.392868
+ 2.5597222 0.355946
+ 2.5600000 0.314676
+ 2.5602778 0.270918
+ 2.5605556 0.226535
+ 2.5608333 0.183387
+ 2.5611111 0.143334
+ 2.5613889 0.107995
+ 2.5616667 0.078010
+ 2.5619444 0.053776
+ 2.5622222 0.050000
+ 2.5625000 0.050000
+ 2.5627778 0.050000
+ 2.5630556 0.050000
+ 2.5633333 0.050000
+ 2.5636111 0.051377
+ 2.5638889 0.078516
+ 2.5641667 0.114136
+ 2.5644444 0.156400
+ 2.5647222 0.203028
+ 2.5650000 0.251736
+ 2.5652778 0.300243
+ 2.5655556 0.346266
+ 2.5658333 0.387523
+ 2.5661111 0.421734
+ 2.5663889 0.446614
+ 2.5666667 0.459882
+ 2.5669444 0.459952
+ 2.5672222 0.448014
+ 2.5675000 0.425956
+ 2.5677778 0.395665
+ 2.5680556 0.359027
+ 2.5683333 0.317930
+ 2.5686111 0.274260
+ 2.5688889 0.229904
+ 2.5691667 0.186749
+ 2.5694444 0.146682
+ 2.5697222 0.111340
+ 2.5700000 0.081366
+ 2.5702778 0.057151
+ 2.5705556 0.050000
+ 2.5708333 0.050000
+ 2.5711111 0.050000
+ 2.5713889 0.050000
+ 2.5716667 0.050000
+ 2.5719444 0.054768
+ 2.5722222 0.081850
+ 2.5725000 0.117383
+ 2.5727778 0.159523
+ 2.5730556 0.205984
+ 2.5733333 0.254475
+ 2.5736111 0.302708
+ 2.5738889 0.348394
+ 2.5741667 0.389245
+ 2.5744444 0.422971
+ 2.5747222 0.447284
+ 2.5750000 0.459895
+ 2.5752778 0.459217
+ 2.5755556 0.446466
+ 2.5758333 0.423560
+ 2.5761111 0.392417
+ 2.5763889 0.354955
+ 2.5766667 0.313092
+ 2.5769444 0.268746
+ 2.5772222 0.223834
+ 2.5775000 0.180275
+ 2.5777778 0.139987
+ 2.5780556 0.104627
+ 2.5783333 0.074810
+ 2.5786111 0.050892
+ 2.5788889 0.050000
+ 2.5791667 0.050000
+ 2.5794444 0.050000
+ 2.5797222 0.050000
+ 2.5800000 0.050000
+ 2.5802778 0.051147
+ 2.5805556 0.078464
+ 2.5808333 0.114089
+ 2.5811111 0.156223
+ 2.5813889 0.202634
+ 2.5816667 0.251091
+ 2.5819444 0.299361
+ 2.5822222 0.345215
+ 2.5825000 0.386420
+ 2.5827778 0.420745
+ 2.5830556 0.445959
+ 2.5833333 0.459830
+ 2.5836111 0.460800
+ 2.5838889 0.450002
+ 2.5841667 0.429242
+ 2.5844444 0.400328
+ 2.5847222 0.365063
+ 2.5850000 0.325256
+ 2.5852778 0.282713
+ 2.5855556 0.239239
+ 2.5858333 0.196641
+ 2.5861111 0.156724
+ 2.5863889 0.121076
+ 2.5866667 0.090399
+ 2.5869444 0.065176
+ 2.5872222 0.050000
+ 2.5875000 0.050000
+ 2.5877778 0.050000
+ 2.5880556 0.050000
+ 2.5883333 0.050000
+ 2.5886111 0.055423
+ 2.5888889 0.081903
+ 2.5891667 0.117221
+ 2.5894444 0.159467
+ 2.5897222 0.206249
+ 2.5900000 0.255177
+ 2.5902778 0.303860
+ 2.5905556 0.349907
+ 2.5908333 0.390928
+ 2.5911111 0.424531
+ 2.5913889 0.448326
+ 2.5916667 0.459922
+ 2.5919444 0.457669
+ 2.5922222 0.442881
+ 2.5925000 0.417614
+ 2.5927778 0.383921
+ 2.5930556 0.343858
+ 2.5933333 0.299479
+ 2.5936111 0.252839
+ 2.5938889 0.205993
+ 2.5941667 0.160996
+ 2.5944444 0.119902
+ 2.5947222 0.084466
+ 2.5950000 0.055239
+ 2.5952778 0.050000
+ 2.5955556 0.050000
+ 2.5958333 0.050000
+ 2.5961111 0.050000
+ 2.5963889 0.050000
+ 2.5966667 0.050000
+ 2.5969444 0.050000
+ 2.5972222 0.075090
+ 2.5975000 0.112628
+ 2.5977778 0.156382
+ 2.5980556 0.204100
+ 2.5983333 0.253530
+ 2.5986111 0.302419
+ 2.5988889 0.348515
+ 2.5991667 0.389566
+ 2.5994444 0.423319
+ 2.5997222 0.447522
+ 2.6000000 0.459922
+ 2.6002778 0.458974
+ 2.6005556 0.445964
+ 2.6008333 0.422882
+ 2.6011111 0.391723
+ 2.6013889 0.354477
+ 2.6016667 0.313138
+ 2.6019444 0.269696
+ 2.6022222 0.226145
+ 2.6025000 0.184476
+ 2.6027778 0.146682
+ 2.6030556 0.114450
+ 2.6033333 0.088248
+ 2.6036111 0.068239
+ 2.6038889 0.054587
+ 2.6041667 0.050000
+ 2.6044444 0.050000
+ 2.6047222 0.053398
+ 2.6050000 0.066801
+ 2.6052778 0.087376
+ 2.6055556 0.115286
+ 2.6058333 0.150320
+ 2.6061111 0.190773
+ 2.6063889 0.234566
+ 2.6066667 0.279620
+ 2.6069444 0.323855
+ 2.6072222 0.365193
+ 2.6075000 0.401554
+ 2.6077778 0.430859
+ 2.6080556 0.451030
+ 2.6083333 0.459987
+ 2.6086111 0.456322
+ 2.6088889 0.441313
+ 2.6091667 0.416908
+ 2.6094444 0.385057
+ 2.6097222 0.347706
+ 2.6100000 0.306807
+ 2.6102778 0.264306
+ 2.6105556 0.222152
+ 2.6108333 0.182295
+ 2.6111111 0.146682
+ 2.6113889 0.116945
+ 2.6116667 0.093447
+ 2.6119444 0.076233
+ 2.6122222 0.065347
+ 2.6125000 0.060836
+ 2.6127778 0.062743
+ 2.6130556 0.071114
+ 2.6133333 0.085994
+ 2.6136111 0.107429
+ 2.6138889 0.135463
+ 2.6141667 0.169812
+ 2.6144444 0.208880
+ 2.6147222 0.250740
+ 2.6150000 0.293465
+ 2.6152778 0.335128
+ 2.6155556 0.373804
+ 2.6158333 0.407566
+ 2.6161111 0.434488
+ 2.6163889 0.452643
+ 2.6166667 0.460105
+ 2.6169444 0.455577
+ 2.6172222 0.440287
+ 2.6175000 0.416092
+ 2.6177778 0.384849
+ 2.6180556 0.348414
+ 2.6183333 0.308646
+ 2.6186111 0.267401
+ 2.6188889 0.226536
+ 2.6191667 0.187909
+ 2.6194444 0.153377
+ 2.6197222 0.124497
+ 2.6200000 0.101628
+ 2.6202778 0.084829
+ 2.6205556 0.074159
+ 2.6208333 0.069677
+ 2.6211111 0.071443
+ 2.6213889 0.079514
+ 2.6216667 0.093951
+ 2.6219444 0.114813
+ 2.6222222 0.142158
+ 2.6225000 0.175720
+ 2.6227778 0.213933
+ 2.6230556 0.254907
+ 2.6233333 0.296749
+ 2.6236111 0.337569
+ 2.6238889 0.375476
+ 2.6241667 0.408578
+ 2.6244444 0.434984
+ 2.6247222 0.452803
+ 2.6250000 0.460144
+ 2.6252778 0.455734
+ 2.6255556 0.440777
+ 2.6258333 0.417095
+ 2.6261111 0.386509
+ 2.6263889 0.350843
+ 2.6266667 0.311918
+ 2.6269444 0.271556
+ 2.6272222 0.231580
+ 2.6275000 0.193811
+ 2.6277778 0.160072
+ 2.6280556 0.131888
+ 2.6283333 0.109601
+ 2.6286111 0.093254
+ 2.6288889 0.082891
+ 2.6291667 0.078558
+ 2.6294444 0.080297
+ 2.6297222 0.088153
+ 2.6300000 0.102170
+ 2.6302778 0.122393
+ 2.6305556 0.148866
+ 2.6308333 0.181325
+ 2.6311111 0.218281
+ 2.6313889 0.257936
+ 2.6316667 0.298491
+ 2.6319444 0.338150
+ 2.6322222 0.375115
+ 2.6325000 0.407588
+ 2.6327778 0.433771
+ 2.6330556 0.451867
+ 2.6333333 0.460078
+ 2.6336111 0.457181
+ 2.6338889 0.444246
+ 2.6341667 0.422919
+ 2.6344444 0.394844
+ 2.6347222 0.361666
+ 2.6350000 0.325031
+ 2.6352778 0.286582
+ 2.6355556 0.247966
+ 2.6358333 0.210827
+ 2.6361111 0.176809
+ 2.6363889 0.147328
+ 2.6366667 0.122869
+ 2.6369444 0.103692
+ 2.6372222 0.090052
+ 2.6375000 0.082207
+ 2.6377778 0.080413
+ 2.6380556 0.084927
+ 2.6383333 0.096006
+ 2.6386111 0.113908
+ 2.6388889 0.138889
+ 2.6391667 0.170831
+ 2.6394444 0.208119
+ 2.6397222 0.248762
+ 2.6400000 0.290772
+ 2.6402778 0.332157
+ 2.6405556 0.370928
+ 2.6408333 0.405094
+ 2.6411111 0.432666
+ 2.6413889 0.451653
+ 2.6416667 0.460065
+ 2.6419444 0.456542
+ 2.6422222 0.442235
+ 2.6425000 0.418926
+ 2.6427778 0.388398
+ 2.6430556 0.352431
+ 2.6433333 0.312807
+ 2.6436111 0.271309
+ 2.6438889 0.229716
+ 2.6441667 0.189812
+ 2.6444444 0.153377
+ 2.6447222 0.121937
+ 2.6450000 0.095991
+ 2.6452778 0.075782
+ 2.6455556 0.061554
+ 2.6458333 0.053549
+ 2.6461111 0.052010
+ 2.6463889 0.057180
+ 2.6466667 0.069303
+ 2.6469444 0.088621
+ 2.6472222 0.115378
+ 2.6475000 0.149430
+ 2.6477778 0.189094
+ 2.6480556 0.232300
+ 2.6483333 0.276977
+ 2.6486111 0.321057
+ 2.6488889 0.362469
+ 2.6491667 0.399142
+ 2.6494444 0.429009
+ 2.6497222 0.449998
+ 2.6500000 0.460039
+ 2.6502778 0.457717
+ 2.6505556 0.444231
+ 2.6508333 0.421432
+ 2.6511111 0.391175
+ 2.6513889 0.355310
+ 2.6516667 0.315691
+ 2.6519444 0.274170
+ 2.6522222 0.232601
+ 2.6525000 0.192835
+ 2.6527778 0.156724
+ 2.6530556 0.125844
+ 2.6533333 0.100652
+ 2.6536111 0.081327
+ 2.6538889 0.068050
+ 2.6541667 0.060999
+ 2.6544444 0.060353
+ 2.6547222 0.066293
+ 2.6550000 0.078998
+ 2.6552778 0.098647
+ 2.6555556 0.125420
+ 2.6558333 0.159131
+ 2.6561111 0.198138
+ 2.6563889 0.240434
+ 2.6566667 0.284010
+ 2.6569444 0.326859
+ 2.6572222 0.366975
+ 2.6575000 0.402349
+ 2.6577778 0.430974
+ 2.6580556 0.450843
+ 2.6583333 0.459948
+ 2.6586111 0.456911
+ 2.6588889 0.442872
+ 2.6591667 0.419598
+ 2.6594444 0.388859
+ 2.6597222 0.352423
+ 2.6600000 0.312058
+ 2.6602778 0.269533
+ 2.6605556 0.226616
+ 2.6608333 0.185076
+ 2.6611111 0.146682
+ 2.6613889 0.112969
+ 2.6616667 0.084540
+ 2.6619444 0.061769
+ 2.6622222 0.050000
+ 2.6625000 0.050000
+ 2.6627778 0.050000
+ 2.6630556 0.050000
+ 2.6633333 0.050000
+ 2.6636111 0.064723
+ 2.6638889 0.091945
+ 2.6641667 0.127354
+ 2.6644444 0.169122
+ 2.6647222 0.214979
+ 2.6650000 0.262655
+ 2.6652778 0.309883
+ 2.6655556 0.354393
+ 2.6658333 0.393915
+ 2.6661111 0.426182
+ 2.6663889 0.448923
+ 2.6666667 0.459869
+ 2.6669444 0.457454
+ 2.6672222 0.442917
+ 2.6675000 0.418201
+ 2.6677778 0.385246
+ 2.6680556 0.345994
+ 2.6683333 0.302388
+ 2.6686111 0.256368
+ 2.6688889 0.209878
+ 2.6691667 0.164858
+ 2.6694444 0.123249
+ 2.6697222 0.086735
+ 2.6700000 0.055954
+ 2.6702778 0.050000
+ 2.6705556 0.050000
+ 2.6708333 0.050000
+ 2.6711111 0.050000
+ 2.6713889 0.050000
+ 2.6716667 0.050000
+ 2.6719444 0.050000
+ 2.6722222 0.061687
+ 2.6725000 0.099142
+ 2.6727778 0.143395
+ 2.6730556 0.192094
+ 2.6733333 0.242886
+ 2.6736111 0.293418
+ 2.6738889 0.341338
+ 2.6741667 0.384291
+ 2.6744444 0.419926
+ 2.6747222 0.445890
+ 2.6750000 0.459830
+ 2.6752778 0.460112
+ 2.6755556 0.447983
+ 2.6758333 0.425408
+ 2.6761111 0.394352
+ 2.6763889 0.356781
+ 2.6766667 0.314660
+ 2.6769444 0.269955
+ 2.6772222 0.224631
+ 2.6775000 0.180653
+ 2.6777778 0.139987
+ 2.6780556 0.104329
+ 2.6783333 0.074297
+ 2.6786111 0.050241
+ 2.6788889 0.050000
+ 2.6791667 0.050000
+ 2.6794444 0.050000
+ 2.6797222 0.050000
+ 2.6800000 0.050000
+ 2.6802778 0.050932
+ 2.6805556 0.078477
+ 2.6808333 0.114354
+ 2.6811111 0.156746
+ 2.6813889 0.203395
+ 2.6816667 0.252049
+ 2.6819444 0.300453
+ 2.6822222 0.346353
+ 2.6825000 0.387493
+ 2.6827778 0.421620
+ 2.6830556 0.446480
+ 2.6833333 0.459817
+ 2.6836111 0.460061
+ 2.6838889 0.448372
+ 2.6841667 0.426597
+ 2.6844444 0.396579
+ 2.6847222 0.360163
+ 2.6850000 0.319194
+ 2.6852778 0.275517
+ 2.6855556 0.230976
+ 2.6858333 0.187416
+ 2.6861111 0.146682
+ 2.6863889 0.110389
+ 2.6866667 0.079239
+ 2.6869444 0.053703
+ 2.6872222 0.050000
+ 2.6875000 0.050000
+ 2.6877778 0.050000
+ 2.6880556 0.050000
+ 2.6883333 0.050000
+ 2.6886111 0.050000
+ 2.6888889 0.071795
+ 2.6891667 0.107687
+ 2.6894444 0.150584
+ 2.6897222 0.198101
+ 2.6900000 0.247855
+ 2.6902778 0.297461
+ 2.6905556 0.344533
+ 2.6908333 0.386688
+ 2.6911111 0.421542
+ 2.6913889 0.446708
+ 2.6916667 0.459804
+ 2.6919444 0.459168
+ 2.6922222 0.446039
+ 2.6925000 0.422376
+ 2.6927778 0.390143
+ 2.6930556 0.351300
+ 2.6933333 0.307810
+ 2.6936111 0.261632
+ 2.6938889 0.214730
+ 2.6941667 0.169065
+ 2.6944444 0.126597
+ 2.6947222 0.089035
+ 2.6950000 0.057067
+ 2.6952778 0.050000
+ 2.6955556 0.050000
+ 2.6958333 0.050000
+ 2.6961111 0.050000
+ 2.6963889 0.050000
+ 2.6966667 0.050000
+ 2.6969444 0.050000
+ 2.6972222 0.054992
+ 2.6975000 0.092496
+ 2.6977778 0.137099
+ 2.6980556 0.186387
+ 2.6983333 0.237945
+ 2.6986111 0.289359
+ 2.6988889 0.338215
+ 2.6991667 0.382097
+ 2.6994444 0.418593
+ 2.6997222 0.445287
+ 2.7000000 0.459765
+ 2.7002778 0.460341
+ 2.7005556 0.448243
+ 2.7008333 0.425427
+ 2.7011111 0.393850
+ 2.7013889 0.355467
+ 2.7016667 0.312235
+ 2.7019444 0.266111
+ 2.7022222 0.219050
+ 2.7025000 0.173009
+ 2.7027778 0.129944
+ 2.7030556 0.091568
+ 2.7033333 0.058621
+ 2.7036111 0.050000
+ 2.7038889 0.050000
+ 2.7041667 0.050000
+ 2.7044444 0.050000
+ 2.7047222 0.050000
+ 2.7050000 0.050000
+ 2.7052778 0.050000
+ 2.7055556 0.050000
+ 2.7058333 0.087734
+ 2.7061111 0.132861
+ 2.7063889 0.182876
+ 2.7066667 0.235280
+ 2.7069444 0.287569
+ 2.7072222 0.337243
+ 2.7075000 0.381799
+ 2.7077778 0.418734
+ 2.7080556 0.445548
+ 2.7083333 0.459738
+ 2.7086111 0.459566
+ 2.7088889 0.446344
+ 2.7091667 0.422149
+ 2.7094444 0.389055
+ 2.7097222 0.349141
+ 2.7100000 0.304480
+ 2.7102778 0.257150
+ 2.7105556 0.209226
+ 2.7108333 0.162785
+ 2.7111111 0.119902
+ 2.7113889 0.082368
+ 2.7116667 0.050834
+ 2.7119444 0.050000
+ 2.7122222 0.050000
+ 2.7125000 0.050000
+ 2.7127778 0.050000
+ 2.7130556 0.050000
+ 2.7133333 0.050000
+ 2.7136111 0.050000
+ 2.7138889 0.058379
+ 2.7141667 0.096812
+ 2.7144444 0.142104
+ 2.7147222 0.191823
+ 2.7150000 0.243541
+ 2.7152778 0.294829
+ 2.7155556 0.343257
+ 2.7158333 0.386395
+ 2.7161111 0.421814
+ 2.7163889 0.447085
+ 2.7166667 0.459778
+ 2.7169444 0.458213
+ 2.7172222 0.443708
+ 2.7175000 0.418330
+ 2.7177778 0.384146
+ 2.7180556 0.343222
+ 2.7183333 0.297626
+ 2.7186111 0.249425
+ 2.7188889 0.200685
+ 2.7191667 0.153475
+ 2.7194444 0.109859
+ 2.7197222 0.071631
+ 2.7200000 0.050000
+ 2.7202778 0.050000
+ 2.7205556 0.050000
+ 2.7208333 0.050000
+ 2.7211111 0.050000
+ 2.7213889 0.050000
+ 2.7216667 0.050000
+ 2.7219444 0.050000
+ 2.7222222 0.050000
+ 2.7225000 0.090427
+ 2.7227778 0.137985
+ 2.7230556 0.190045
+ 2.7233333 0.243976
+ 2.7236111 0.297149
+ 2.7238889 0.346936
+ 2.7241667 0.390705
+ 2.7244444 0.425829
+ 2.7247222 0.449677
+ 2.7250000 0.459621
+ 2.7252778 0.453877
+ 2.7255556 0.434052
+ 2.7258333 0.402601
+ 2.7261111 0.361976
+ 2.7263889 0.314632
+ 2.7266667 0.263021
+ 2.7269444 0.209599
+ 2.7272222 0.156818
+ 2.7275000 0.107132
+ 2.7277778 0.062994
+ 2.7280556 0.050000
+ 2.7283333 0.050000
+ 2.7286111 0.050000
+ 2.7288889 0.050000
+ 2.7291667 0.050000
+ 2.7294444 0.050000
+ 2.7297222 0.050000
+ 2.7300000 0.050000
+ 2.7302778 0.050000
+ 2.7305556 0.050000
+ 2.7308333 0.090611
+ 2.7311111 0.136726
+ 2.7313889 0.186309
+ 2.7316667 0.237321
+ 2.7319444 0.287726
+ 2.7322222 0.335485
+ 2.7325000 0.378562
+ 2.7327778 0.414918
+ 2.7330556 0.442517
+ 2.7333333 0.459320
+ 2.7336111 0.463885
+ 2.7338889 0.457149
+ 2.7341667 0.440642
+ 2.7344444 0.415897
+ 2.7347222 0.384443
+ 2.7350000 0.347814
+ 2.7352778 0.307539
+ 2.7355556 0.265150
+ 2.7358333 0.222179
+ 2.7361111 0.180157
+ 2.7363889 0.140516
+ 2.7366667 0.104292
+ 2.7369444 0.072422
+ 2.7372222 0.050000
+ 2.7375000 0.050000
+ 2.7377778 0.050000
+ 2.7380556 0.050000
+ 2.7383333 0.050000
+ 2.7386111 0.050000
+ 2.7388889 0.050000
+ 2.7391667 0.086119
+ 2.7394444 0.131478
+ 2.7397222 0.183467
+ 2.7400000 0.239471
+ 2.7402778 0.296880
+ 2.7405556 0.353081
+ 2.7408333 0.405461
+ 2.7411111 0.451410
+ 2.7413889 0.488313
+ 2.7416667 0.513560
+ 2.7419444 0.525365
+ 2.7422222 0.525256
+ 2.7425000 0.515584
+ 2.7427778 0.498705
+ 2.7430556 0.476971
+ 2.7433333 0.452737
+ 2.7436111 0.428356
+ 2.7438889 0.406182
+ 2.7441667 0.388568
+ 2.7444444 0.377869
+ 2.7447222 0.375796
+ 2.7450000 0.381501
+ 2.7452778 0.393493
+ 2.7455556 0.410281
+ 2.7458333 0.430375
+ 2.7461111 0.452284
+ 2.7463889 0.474517
+ 2.7466667 0.495584
+ 2.7469444 0.513994
+ 2.7472222 0.528258
+ 2.7475000 0.537284
+ 2.7477778 0.541588
+ 2.7480556 0.542085
+ 2.7483333 0.539690
+ 2.7486111 0.535318
+ 2.7488889 0.529886
+ 2.7491667 0.524307
+ 2.7494444 0.519498
+ 2.7497222 0.516373
+ 2.7500000 0.515848
+ 2.7502778 0.518442
+ 2.7505556 0.523086
+ 2.7508333 0.528315
+ 2.7511111 0.532664
+ 2.7513889 0.534667
+ 2.7516667 0.532860
+ 2.7519444 0.525777
+ 2.7522222 0.511953
+ 2.7525000 0.489923
+ 2.7527778 0.458222
+ 2.7530556 0.416147
+ 2.7533333 0.366049
+ 2.7536111 0.311041
+ 2.7538889 0.254235
+ 2.7541667 0.198746
+ 2.7544444 0.147686
+ 2.7547222 0.104168
+ 2.7550000 0.071306
+ 2.7552778 0.052212
+ 2.7555556 0.050000
+ 2.7558333 0.066603
+ 2.7561111 0.099238
+ 2.7563889 0.143939
+ 2.7566667 0.196743
+ 2.7569444 0.253687
+ 2.7572222 0.310805
+ 2.7575000 0.364135
+ 2.7577778 0.409712
+ 2.7580556 0.443572
+ 2.7583333 0.461752
+ 2.7586111 0.461428
+ 2.7588889 0.444342
+ 2.7591667 0.413374
+ 2.7594444 0.371407
+ 2.7597222 0.321323
+ 2.7600000 0.266003
+ 2.7602778 0.208329
+ 2.7605556 0.151183
+ 2.7608333 0.097446
+ 2.7611111 0.050000
+ 2.7613889 0.050000
+ 2.7616667 0.050000
+ 2.7619444 0.050000
+ 2.7622222 0.050000
+ 2.7625000 0.050000
+ 2.7627778 0.050000
+ 2.7630556 0.050000
+ 2.7633333 0.050000
+ 2.7636111 0.050000
+ 2.7638889 0.050000
+ 2.7641667 0.094261
+ 2.7644444 0.143890
+ 2.7647222 0.196598
+ 2.7650000 0.250096
+ 2.7652778 0.302093
+ 2.7655556 0.350301
+ 2.7658333 0.392431
+ 2.7661111 0.426191
+ 2.7663889 0.449295
+ 2.7666667 0.459451
+ 2.7669444 0.455115
+ 2.7672222 0.437720
+ 2.7675000 0.409445
+ 2.7677778 0.372466
+ 2.7680556 0.328961
+ 2.7683333 0.281108
+ 2.7686111 0.231086
+ 2.7688889 0.181071
+ 2.7691667 0.133241
+ 2.7694444 0.089774
+ 2.7697222 0.052524
+ 2.7700000 0.050000
+ 2.7702778 0.050000
+ 2.7705556 0.050000
+ 2.7708333 0.050000
+ 2.7711111 0.050000
+ 2.7713889 0.050000
+ 2.7716667 0.050000
+ 2.7719444 0.050000
+ 2.7722222 0.050000
+ 2.7725000 0.090517
+ 2.7727778 0.137511
+ 2.7730556 0.188591
+ 2.7733333 0.241365
+ 2.7736111 0.293442
+ 2.7738889 0.342433
+ 2.7741667 0.385944
+ 2.7744444 0.421587
+ 2.7747222 0.446969
+ 2.7750000 0.459699
+ 2.7752778 0.458132
+ 2.7755556 0.443600
+ 2.7758333 0.418180
+ 2.7761111 0.383949
+ 2.7763889 0.342984
+ 2.7766667 0.297364
+ 2.7769444 0.249163
+ 2.7772222 0.200461
+ 2.7775000 0.153334
+ 2.7777778 0.109859
+ 2.7780556 0.071831
+ 2.7783333 0.050000
+ 2.7786111 0.050000
+ 2.7788889 0.050000
+ 2.7791667 0.050000
+ 2.7794444 0.050000
+ 2.7797222 0.050000
+ 2.7800000 0.050000
+ 2.7802778 0.050000
+ 2.7805556 0.050000
+ 2.7808333 0.089649
+ 2.7811111 0.136303
+ 2.7813889 0.187446
+ 2.7816667 0.240560
+ 2.7819444 0.293128
+ 2.7822222 0.342631
+ 2.7825000 0.386554
+ 2.7827778 0.422377
+ 2.7830556 0.447585
+ 2.7833333 0.459660
+ 2.7836111 0.456873
+ 2.7838889 0.440651
+ 2.7841667 0.413210
+ 2.7844444 0.376765
+ 2.7847222 0.333534
+ 2.7850000 0.285731
+ 2.7852778 0.235572
+ 2.7855556 0.185274
+ 2.7858333 0.137052
+ 2.7861111 0.093122
+ 2.7863889 0.055372
+ 2.7866667 0.050000
+ 2.7869444 0.050000
+ 2.7872222 0.050000
+ 2.7875000 0.050000
+ 2.7877778 0.050000
+ 2.7880556 0.050000
+ 2.7883333 0.050000
+ 2.7886111 0.050000
+ 2.7888889 0.050000
+ 2.7891667 0.090720
+ 2.7894444 0.138018
+ 2.7897222 0.189448
+ 2.7900000 0.242564
+ 2.7902778 0.294919
+ 2.7905556 0.344068
+ 2.7908333 0.387564
+ 2.7911111 0.422961
+ 2.7913889 0.447813
+ 2.7916667 0.459673
+ 2.7919444 0.456867
+ 2.7922222 0.440802
+ 2.7925000 0.413657
+ 2.7927778 0.377613
+ 2.7930556 0.334847
+ 2.7933333 0.287539
+ 2.7936111 0.237868
+ 2.7938889 0.188013
+ 2.7941667 0.140154
+ 2.7944444 0.096469
+ 2.7947222 0.058820
+ 2.7950000 0.050000
+ 2.7952778 0.050000
+ 2.7955556 0.050000
+ 2.7958333 0.050000
+ 2.7961111 0.050000
+ 2.7963889 0.050000
+ 2.7966667 0.050000
+ 2.7969444 0.050000
+ 2.7972222 0.050000
+ 2.7975000 0.090145
+ 2.7977778 0.136906
+ 2.7980556 0.187871
+ 2.7983333 0.240626
+ 2.7986111 0.292762
+ 2.7988889 0.341865
+ 2.7991667 0.385523
+ 2.7994444 0.421325
+ 2.7997222 0.446859
+ 2.8000000 0.459712
+ 2.8002778 0.458223
+ 2.8005556 0.443728
+ 2.8008333 0.418312
+ 2.8011111 0.384062
+ 2.8013889 0.343064
+ 2.8016667 0.297403
+ 2.8019444 0.249166
+ 2.8022222 0.200440
+ 2.8025000 0.153309
+ 2.8027778 0.109859
+ 2.8030556 0.071891
+ 2.8033333 0.050000
+ 2.8036111 0.050000
+ 2.8038889 0.050000
+ 2.8041667 0.050000
+ 2.8044444 0.050000
+ 2.8047222 0.050000
+ 2.8050000 0.050000
+ 2.8052778 0.050000
+ 2.8055556 0.050000
+ 2.8058333 0.089327
+ 2.8061111 0.135605
+ 2.8063889 0.186364
+ 2.8066667 0.239133
+ 2.8069444 0.291444
+ 2.8072222 0.340826
+ 2.8075000 0.384810
+ 2.8077778 0.420926
+ 2.8080556 0.446703
+ 2.8083333 0.459673
+ 2.8086111 0.458130
+ 2.8088889 0.443429
+ 2.8091667 0.417690
+ 2.8094444 0.383033
+ 2.8097222 0.341577
+ 2.8100000 0.295442
+ 2.8102778 0.246749
+ 2.8105556 0.197616
+ 2.8108333 0.150164
+ 2.8111111 0.106512
+ 2.8113889 0.068485
+ 2.8116667 0.050000
+ 2.8119444 0.050000
+ 2.8122222 0.050000
+ 2.8125000 0.050000
+ 2.8127778 0.050000
+ 2.8130556 0.050000
+ 2.8133333 0.050000
+ 2.8136111 0.050000
+ 2.8138889 0.050000
+ 2.8141667 0.089818
+ 2.8144444 0.136540
+ 2.8147222 0.187672
+ 2.8150000 0.240722
+ 2.8152778 0.293197
+ 2.8155556 0.342604
+ 2.8158333 0.386451
+ 2.8161111 0.422244
+ 2.8163889 0.447491
+ 2.8166667 0.459699
+ 2.8169444 0.457156
+ 2.8172222 0.441270
+ 2.8175000 0.414229
+ 2.8177778 0.378222
+ 2.8180556 0.335439
+ 2.8183333 0.288067
+ 2.8186111 0.238296
+ 2.8188889 0.188313
+ 2.8191667 0.140308
+ 2.8194444 0.096469
+ 2.8197222 0.058667
+ 2.8200000 0.050000
+ 2.8202778 0.050000
+ 2.8205556 0.050000
+ 2.8208333 0.050000
+ 2.8211111 0.050000
+ 2.8213889 0.050000
+ 2.8216667 0.050000
+ 2.8219444 0.050000
+ 2.8222222 0.050000
+ 2.8225000 0.090485
+ 2.8227778 0.137631
+ 2.8230556 0.188979
+ 2.8233333 0.242073
+ 2.8236111 0.294454
+ 2.8238889 0.343666
+ 2.8241667 0.387251
+ 2.8244444 0.422753
+ 2.8247222 0.447712
+ 2.8250000 0.459673
+ 2.8252778 0.456950
+ 2.8255556 0.440950
+ 2.8258333 0.413853
+ 2.8261111 0.377836
+ 2.8263889 0.335079
+ 2.8266667 0.287762
+ 2.8269444 0.238063
+ 2.8272222 0.188162
+ 2.8275000 0.140238
+ 2.8277778 0.096469
+ 2.8280556 0.058719
+ 2.8283333 0.050000
+ 2.8286111 0.050000
+ 2.8288889 0.050000
+ 2.8291667 0.050000
+ 2.8294444 0.050000
+ 2.8297222 0.050000
+ 2.8300000 0.050000
+ 2.8302778 0.050000
+ 2.8305556 0.050000
+ 2.8308333 0.090463
+ 2.8311111 0.137590
+ 2.8313889 0.188923
+ 2.8316667 0.242005
+ 2.8319444 0.294380
+ 2.8322222 0.343589
+ 2.8325000 0.387176
+ 2.8327778 0.422684
+ 2.8330556 0.447656
+ 2.8333333 0.459634
+ 2.8336111 0.456934
+ 2.8338889 0.440960
+ 2.8341667 0.413888
+ 2.8344444 0.377895
+ 2.8347222 0.335158
+ 2.8350000 0.287851
+ 2.8352778 0.238153
+ 2.8355556 0.188239
+ 2.8358333 0.140286
+ 2.8361111 0.096469
+ 2.8363889 0.058652
+ 2.8366667 0.050000
+ 2.8369444 0.050000
+ 2.8372222 0.050000
+ 2.8375000 0.050000
+ 2.8377778 0.050000
+ 2.8380556 0.050000
+ 2.8383333 0.050000
+ 2.8386111 0.050000
+ 2.8388889 0.050000
+ 2.8391667 0.090720
+ 2.8394444 0.138144
+ 2.8397222 0.189779
+ 2.8400000 0.243131
+ 2.8402778 0.295707
+ 2.8405556 0.345012
+ 2.8408333 0.388554
+ 2.8411111 0.423838
+ 2.8413889 0.448372
+ 2.8416667 0.459660
+ 2.8419444 0.456001
+ 2.8422222 0.438855
+ 2.8425000 0.410476
+ 2.8427778 0.373113
+ 2.8430556 0.329021
+ 2.8433333 0.280450
+ 2.8436111 0.229654
+ 2.8438889 0.178883
+ 2.8441667 0.130390
+ 2.8444444 0.086427
+ 2.8447222 0.050000
+ 2.8450000 0.050000
+ 2.8452778 0.050000
+ 2.8455556 0.050000
+ 2.8458333 0.050000
+ 2.8461111 0.050000
+ 2.8463889 0.050000
+ 2.8466667 0.050000
+ 2.8469444 0.050000
+ 2.8472222 0.050000
+ 2.8475000 0.091064
+ 2.8477778 0.138535
+ 2.8480556 0.190003
+ 2.8483333 0.243058
+ 2.8486111 0.295289
+ 2.8488889 0.344284
+ 2.8491667 0.387633
+ 2.8494444 0.422926
+ 2.8497222 0.447752
+ 2.8500000 0.459699
+ 2.8502778 0.457117
+ 2.8505556 0.441391
+ 2.8508333 0.414667
+ 2.8511111 0.379089
+ 2.8513889 0.336802
+ 2.8516667 0.289952
+ 2.8519444 0.240683
+ 2.8522222 0.191141
+ 2.8525000 0.143471
+ 2.8527778 0.099817
+ 2.8530556 0.062019
+ 2.8533333 0.050000
+ 2.8536111 0.050000
+ 2.8538889 0.050000
+ 2.8541667 0.050000
+ 2.8544444 0.050000
+ 2.8547222 0.050000
+ 2.8550000 0.050000
+ 2.8552778 0.050000
+ 2.8555556 0.050000
+ 2.8558333 0.090315
+ 2.8561111 0.137394
+ 2.8563889 0.188754
+ 2.8566667 0.241913
+ 2.8569444 0.294389
+ 2.8572222 0.343700
+ 2.8575000 0.387363
+ 2.8577778 0.422897
+ 2.8580556 0.447819
+ 2.8583333 0.459647
+ 2.8586111 0.456680
+ 2.8588889 0.440344
+ 2.8591667 0.412845
+ 2.8594444 0.376389
+ 2.8597222 0.333183
+ 2.8600000 0.285433
+ 2.8602778 0.235345
+ 2.8605556 0.185126
+ 2.8608333 0.136983
+ 2.8611111 0.093122
+ 2.8613889 0.055424
+ 2.8616667 0.050000
+ 2.8619444 0.050000
+ 2.8622222 0.050000
+ 2.8625000 0.050000
+ 2.8627778 0.050000
+ 2.8630556 0.050000
+ 2.8633333 0.050000
+ 2.8636111 0.050000
+ 2.8638889 0.050000
+ 2.8641667 0.090697
+ 2.8644444 0.137976
+ 2.8647222 0.189390
+ 2.8650000 0.242493
+ 2.8652778 0.294839
+ 2.8655556 0.343984
+ 2.8658333 0.387480
+ 2.8661111 0.422882
+ 2.8663889 0.447744
+ 2.8666667 0.459621
+ 2.8669444 0.456836
+ 2.8672222 0.440796
+ 2.8675000 0.413678
+ 2.8677778 0.377657
+ 2.8680556 0.334910
+ 2.8683333 0.287615
+ 2.8686111 0.237946
+ 2.8688889 0.188082
+ 2.8691667 0.140197
+ 2.8694444 0.096469
+ 2.8697222 0.058758
+ 2.8700000 0.050000
+ 2.8702778 0.050000
+ 2.8705556 0.050000
+ 2.8708333 0.050000
+ 2.8711111 0.050000
+ 2.8713889 0.050000
+ 2.8716667 0.050000
+ 2.8719444 0.050000
+ 2.8722222 0.050000
+ 2.8725000 0.090383
+ 2.8727778 0.137420
+ 2.8730556 0.188663
+ 2.8733333 0.241667
+ 2.8736111 0.293985
+ 2.8738889 0.343170
+ 2.8741667 0.386777
+ 2.8744444 0.422359
+ 2.8747222 0.447468
+ 2.8750000 0.459660
+ 2.8752778 0.457254
+ 2.8755556 0.441639
+ 2.8758333 0.414969
+ 2.8761111 0.379401
+ 2.8763889 0.337090
+ 2.8766667 0.290190
+ 2.8769444 0.240858
+ 2.8772222 0.191248
+ 2.8775000 0.143516
+ 2.8777778 0.099817
+ 2.8780556 0.061997
+ 2.8783333 0.050000
+ 2.8786111 0.050000
+ 2.8788889 0.050000
+ 2.8791667 0.050000
+ 2.8794444 0.050000
+ 2.8797222 0.050000
+ 2.8800000 0.050000
+ 2.8802778 0.050000
+ 2.8805556 0.050000
+ 2.8808333 0.090236
+ 2.8811111 0.137217
+ 2.8813889 0.188473
+ 2.8816667 0.241536
+ 2.8819444 0.293938
+ 2.8822222 0.343209
+ 2.8825000 0.386882
+ 2.8827778 0.422487
+ 2.8830556 0.447556
+ 2.8833333 0.459621
+ 2.8836111 0.456987
+ 2.8838889 0.441058
+ 2.8841667 0.414014
+ 2.8844444 0.378032
+ 2.8847222 0.335292
+ 2.8850000 0.287972
+ 2.8852778 0.238251
+ 2.8855556 0.188308
+ 2.8858333 0.140321
+ 2.8861111 0.096469
+ 2.8863889 0.058617
+ 2.8866667 0.050000
+ 2.8869444 0.050000
+ 2.8872222 0.050000
+ 2.8875000 0.050000
+ 2.8877778 0.050000
+ 2.8880556 0.050000
+ 2.8883333 0.050000
+ 2.8886111 0.050000
+ 2.8888889 0.050000
+ 2.8891667 0.090799
+ 2.8894444 0.138313
+ 2.8897222 0.190037
+ 2.8900000 0.243468
+ 2.8902778 0.296101
+ 2.8905556 0.345432
+ 2.8908333 0.388956
+ 2.8911111 0.424169
+ 2.8913889 0.448568
+ 2.8916667 0.459647
+ 2.8919444 0.455699
+ 2.8922222 0.438199
+ 2.8925000 0.409421
+ 2.8927778 0.371638
+ 2.8930556 0.327121
+ 2.8933333 0.278143
+ 2.8936111 0.226978
+ 2.8938889 0.175897
+ 2.8941667 0.127173
+ 2.8944444 0.083079
+ 2.8947222 0.050000
+ 2.8950000 0.050000
+ 2.8952778 0.050000
+ 2.8955556 0.050000
+ 2.8958333 0.050000
+ 2.8961111 0.050000
+ 2.8963889 0.050000
+ 2.8966667 0.050000
+ 2.8969444 0.050000
+ 2.8972222 0.050000
+ 2.8975000 0.091611
+ 2.8977778 0.139600
+ 2.8980556 0.191521
+ 2.8983333 0.244930
+ 2.8986111 0.297382
+ 2.8988889 0.346430
+ 2.8991667 0.389630
+ 2.8994444 0.424536
+ 2.8997222 0.448703
+ 2.9000000 0.459686
+ 2.9002778 0.455820
+ 2.9005556 0.438559
+ 2.9008333 0.410138
+ 2.9011111 0.372792
+ 2.9013889 0.328755
+ 2.9016667 0.280262
+ 2.9019444 0.229549
+ 2.9022222 0.178848
+ 2.9025000 0.130396
+ 2.9027778 0.086427
+ 2.9030556 0.050000
+ 2.9033333 0.050000
+ 2.9036111 0.050000
+ 2.9038889 0.050000
+ 2.9041667 0.050000
+ 2.9044444 0.050000
+ 2.9047222 0.050000
+ 2.9050000 0.050000
+ 2.9052778 0.050000
+ 2.9055556 0.050000
+ 2.9058333 0.091520
+ 2.9061111 0.139530
+ 2.9063889 0.191549
+ 2.9066667 0.245097
+ 2.9069444 0.297696
+ 2.9072222 0.346864
+ 2.9075000 0.390124
+ 2.9077778 0.424993
+ 2.9080556 0.448995
+ 2.9083333 0.459647
+ 2.9086111 0.455264
+ 2.9088889 0.437333
+ 2.9091667 0.408134
+ 2.9094444 0.369945
+ 2.9097222 0.325049
+ 2.9100000 0.275723
+ 2.9102778 0.224249
+ 2.9105556 0.172905
+ 2.9108333 0.123973
+ 2.9111111 0.079732
+ 2.9113889 0.050000
+ 2.9116667 0.050000
+ 2.9119444 0.050000
+ 2.9122222 0.050000
+ 2.9125000 0.050000
+ 2.9127778 0.050000
+ 2.9130556 0.050000
+ 2.9133333 0.050000
+ 2.9136111 0.050000
+ 2.9138889 0.050000
+ 2.9141667 0.092553
+ 2.9144444 0.141522
+ 2.9147222 0.194371
+ 2.9150000 0.248559
+ 2.9152778 0.301550
+ 2.9155556 0.350803
+ 2.9158333 0.393780
+ 2.9161111 0.427943
+ 2.9163889 0.450754
+ 2.9166667 0.459673
+ 2.9169444 0.452992
+ 2.9172222 0.432323
+ 2.9175000 0.400105
+ 2.9177778 0.358781
+ 2.9180556 0.310792
+ 2.9183333 0.258578
+ 2.9186111 0.204581
+ 2.9188889 0.151241
+ 2.9191667 0.101000
+ 2.9194444 0.056299
+ 2.9197222 0.050000
+ 2.9200000 0.050000
+ 2.9202778 0.050000
+ 2.9205556 0.050000
+ 2.9208333 0.050000
+ 2.9211111 0.050000
+ 2.9213889 0.050000
+ 2.9216667 0.050000
+ 2.9219444 0.050000
+ 2.9222222 0.050000
+ 2.9225000 0.094193
+ 2.9227778 0.144249
+ 2.9230556 0.197700
+ 2.9233333 0.252078
+ 2.9236111 0.304916
+ 2.9238889 0.353746
+ 2.9241667 0.396100
+ 2.9244444 0.429511
+ 2.9247222 0.451512
+ 2.9250000 0.459634
+ 2.9252778 0.452228
+ 2.9255556 0.430918
+ 2.9258333 0.398147
+ 2.9261111 0.356356
+ 2.9263889 0.307987
+ 2.9266667 0.255482
+ 2.9269444 0.201285
+ 2.9272222 0.147835
+ 2.9275000 0.097577
+ 2.9277778 0.052952
+ 2.9280556 0.050000
+ 2.9283333 0.050000
+ 2.9286111 0.050000
+ 2.9288889 0.050000
+ 2.9291667 0.050000
+ 2.9294444 0.050000
+ 2.9297222 0.050000
+ 2.9300000 0.050000
+ 2.9302778 0.050000
+ 2.9305556 0.050000
+ 2.9308333 0.094452
+ 2.9311111 0.144707
+ 2.9313889 0.198297
+ 2.9316667 0.252755
+ 2.9319444 0.305613
+ 2.9322222 0.354404
+ 2.9325000 0.396661
+ 2.9327778 0.429917
+ 2.9330556 0.451704
+ 2.9333333 0.459555
+ 2.9336111 0.451825
+ 2.9338889 0.430150
+ 2.9341667 0.396993
+ 2.9344444 0.354812
+ 2.9347222 0.306068
+ 2.9350000 0.253221
+ 2.9352778 0.198731
+ 2.9355556 0.145057
+ 2.9358333 0.094660
+ 2.9361111 0.050000
+ 2.9363889 0.050000
+ 2.9366667 0.050000
+ 2.9369444 0.050000
+ 2.9372222 0.050000
+ 2.9375000 0.050000
+ 2.9377778 0.050000
+ 2.9380556 0.050000
+ 2.9383333 0.050000
+ 2.9386111 0.050000
+ 2.9388889 0.050000
+ 2.9391667 0.094645
+ 2.9394444 0.145023
+ 2.9397222 0.198676
+ 2.9400000 0.253147
+ 2.9402778 0.305979
+ 2.9405556 0.354715
+ 2.9408333 0.396898
+ 2.9411111 0.430071
+ 2.9413889 0.451775
+ 2.9416667 0.459555
+ 2.9419444 0.451773
+ 2.9422222 0.430065
+ 2.9425000 0.396891
+ 2.9427778 0.354706
+ 2.9430556 0.305969
+ 2.9433333 0.253137
+ 2.9436111 0.198667
+ 2.9438889 0.145015
+ 2.9441667 0.094641
+ 2.9444444 0.050000
+ 2.9447222 0.050000
+ 2.9450000 0.050000
+ 2.9452778 0.050000
+ 2.9455556 0.050000
+ 2.9458333 0.050000
+ 2.9461111 0.050000
+ 2.9463889 0.050000
+ 2.9466667 0.050000
+ 2.9469444 0.050000
+ 2.9472222 0.050000
+ 2.9475000 0.094639
+ 2.9477778 0.145011
+ 2.9480556 0.198660
+ 2.9483333 0.253127
+ 2.9486111 0.305957
+ 2.9488889 0.354690
+ 2.9491667 0.396872
+ 2.9494444 0.430043
+ 2.9497222 0.451748
+ 2.9500000 0.459529
+ 2.9502778 0.451748
+ 2.9505556 0.430043
+ 2.9508333 0.396871
+ 2.9511111 0.354689
+ 2.9513889 0.305955
+ 2.9516667 0.253126
+ 2.9519444 0.198659
+ 2.9522222 0.145011
+ 2.9525000 0.094639
+ 2.9527778 0.050000
+ 2.9530556 0.050000
+ 2.9533333 0.050000
+ 2.9536111 0.050000
+ 2.9538889 0.050000
+ 2.9541667 0.050000
+ 2.9544444 0.050000
+ 2.9547222 0.050000
+ 2.9550000 0.050000
+ 2.9552778 0.050000
+ 2.9555556 0.050000
+ 2.9558333 0.094638
+ 2.9561111 0.145010
+ 2.9563889 0.198658
+ 2.9566667 0.253125
+ 2.9569444 0.305954
+ 2.9572222 0.354688
+ 2.9575000 0.396870
+ 2.9577778 0.430042
+ 2.9580556 0.451747
+ 2.9583333 0.459529
+ 2.9586111 0.451749
+ 2.9588889 0.430046
+ 2.9591667 0.396875
+ 2.9594444 0.354695
+ 2.9597222 0.305962
+ 2.9600000 0.253133
+ 2.9602778 0.198665
+ 2.9605556 0.145016
+ 2.9608333 0.094642
+ 2.9611111 0.050000
+ 2.9613889 0.050000
+ 2.9616667 0.050000
+ 2.9619444 0.050000
+ 2.9622222 0.050000
+ 2.9625000 0.050000
+ 2.9627778 0.050000
+ 2.9630556 0.050000
+ 2.9633333 0.050000
+ 2.9636111 0.050000
+ 2.9638889 0.050000
+ 2.9641667 0.094654
+ 2.9644444 0.145045
+ 2.9647222 0.198712
+ 2.9650000 0.253197
+ 2.9652778 0.306041
+ 2.9655556 0.354784
+ 2.9658333 0.396968
+ 2.9661111 0.430132
+ 2.9663889 0.451819
+ 2.9666667 0.459568
+ 2.9669444 0.451742
+ 2.9672222 0.429983
+ 2.9675000 0.396755
+ 2.9677778 0.354523
+ 2.9680556 0.305749
+ 2.9683333 0.252898
+ 2.9686111 0.198434
+ 2.9688889 0.144821
+ 2.9691667 0.094521
+ 2.9694444 0.050000
+ 2.9697222 0.050000
+ 2.9700000 0.050000
+ 2.9702778 0.050000
+ 2.9705556 0.050000
+ 2.9708333 0.050000
+ 2.9711111 0.050000
+ 2.9713889 0.050000
+ 2.9716667 0.050000
+ 2.9719444 0.050000
+ 2.9722222 0.050000
+ 2.9725000 0.094018
+ 2.9727778 0.143671
+ 2.9730556 0.196591
+ 2.9733333 0.250409
+ 2.9736111 0.302759
+ 2.9738889 0.351271
+ 2.9741667 0.393579
+ 2.9744444 0.427314
+ 2.9747222 0.450109
+ 2.9750000 0.459595
+ 2.9752778 0.454179
+ 2.9755556 0.435368
+ 2.9758333 0.405444
+ 2.9761111 0.366686
+ 2.9763889 0.321376
+ 2.9766667 0.271795
+ 2.9769444 0.220224
+ 2.9772222 0.168945
+ 2.9775000 0.120238
+ 2.9777778 0.076384
+ 2.9780556 0.050000
+ 2.9783333 0.050000
+ 2.9786111 0.050000
+ 2.9788889 0.050000
+ 2.9791667 0.050000
+ 2.9794444 0.050000
+ 2.9797222 0.050000
+ 2.9800000 0.050000
+ 2.9802778 0.050000
+ 2.9805556 0.050000
+ 2.9808333 0.091623
+ 2.9811111 0.139423
+ 2.9813889 0.191030
+ 2.9816667 0.244072
+ 2.9819444 0.296179
+ 2.9822222 0.344980
+ 2.9825000 0.388104
+ 2.9827778 0.423182
+ 2.9830556 0.447841
+ 2.9833333 0.459712
+ 2.9836111 0.457177
+ 2.9838889 0.441630
+ 2.9841667 0.415219
+ 2.9844444 0.380090
+ 2.9847222 0.338392
+ 2.9850000 0.292272
+ 2.9852778 0.243876
+ 2.9855556 0.195352
+ 2.9858333 0.148849
+ 2.9861111 0.106512
+ 2.9863889 0.070170
+ 2.9866667 0.050000
+ 2.9869444 0.050000
+ 2.9872222 0.050000
+ 2.9875000 0.050000
+ 2.9877778 0.050000
+ 2.9880556 0.050000
+ 2.9883333 0.050000
+ 2.9886111 0.050000
+ 2.9888889 0.065021
+ 2.9891667 0.103993
+ 2.9894444 0.149254
+ 2.9897222 0.198486
+ 2.9900000 0.249376
+ 2.9902778 0.299606
+ 2.9905556 0.346860
+ 2.9908333 0.388823
+ 2.9911111 0.423178
+ 2.9913889 0.447611
+ 2.9916667 0.459804
+ 2.9919444 0.458166
+ 2.9922222 0.444002
+ 2.9925000 0.419341
+ 2.9927778 0.386213
+ 2.9930556 0.346645
+ 2.9933333 0.302669
+ 2.9936111 0.256311
+ 2.9938889 0.209603
+ 2.9941667 0.164573
+ 2.9944444 0.123249
+ 2.9947222 0.087374
+ 2.9950000 0.057532
+ 2.9952778 0.050000
+ 2.9955556 0.050000
+ 2.9958333 0.050000
+ 2.9961111 0.050000
+ 2.9963889 0.050000
+ 2.9966667 0.050000
+ 2.9969444 0.050000
+ 2.9972222 0.071742
+ 2.9975000 0.109171
+ 2.9977778 0.153020
+ 2.9980556 0.200998
+ 2.9983333 0.250812
+ 2.9986111 0.300170
+ 2.9988889 0.346779
+ 2.9991667 0.388347
+ 2.9994444 0.422582
+ 2.9997222 0.447191
+ 3.0000000 0.459882
+ 3.0002778 0.459076
+ 3.0005556 0.446045
+ 3.0008333 0.422775
+ 3.0011111 0.391251
+ 3.0013889 0.353460
+ 3.0016667 0.311387
+ 3.0019444 0.267017
+ 3.0022222 0.222337
+ 3.0025000 0.179332
+ 3.0027778 0.139987
+ 3.0030556 0.105999
+ 3.0033333 0.077907
+ 3.0036111 0.055958
+ 3.0038889 0.050000
+ 3.0041667 0.050000
+ 3.0044444 0.050000
+ 3.0047222 0.050000
+ 3.0050000 0.050000
+ 3.0052778 0.067207
+ 3.0055556 0.095227
+ 3.0058333 0.130976
+ 3.0061111 0.172684
+ 3.0063889 0.218175
+ 3.0066667 0.265276
+ 3.0069444 0.311812
+ 3.0072222 0.355609
+ 3.0075000 0.394491
+ 3.0077778 0.426285
+ 3.0080556 0.448816
+ 3.0083333 0.459908
+ 3.0086111 0.458069
+ 3.0088889 0.444523
+ 3.0091667 0.421175
+ 3.0094444 0.389931
+ 3.0097222 0.352695
+ 3.0100000 0.311374
+ 3.0102778 0.267872
+ 3.0105556 0.224094
+ 3.0108333 0.181947
+ 3.0111111 0.143334
+ 3.0113889 0.109890
+ 3.0116667 0.082159
+ 3.0119444 0.060412
+ 3.0122222 0.050000
+ 3.0125000 0.050000
+ 3.0127778 0.050000
+ 3.0130556 0.050000
+ 3.0133333 0.050972
+ 3.0136111 0.070848
+ 3.0138889 0.098614
+ 3.0141667 0.134131
+ 3.0144444 0.175622
+ 3.0147222 0.220896
+ 3.0150000 0.267767
+ 3.0152778 0.314045
+ 3.0155556 0.357541
+ 3.0158333 0.396066
+ 3.0161111 0.427433
+ 3.0163889 0.449452
+ 3.0166667 0.459935
+ 3.0169444 0.457380
+ 3.0172222 0.443039
+ 3.0175000 0.418851
+ 3.0177778 0.386753
+ 3.0180556 0.348685
+ 3.0183333 0.306585
+ 3.0186111 0.262392
+ 3.0188889 0.218044
+ 3.0191667 0.175480
+ 3.0194444 0.136639
+ 3.0197222 0.103176
+ 3.0200000 0.075606
+ 3.0202778 0.054164
+ 3.0205556 0.050000
+ 3.0208333 0.050000
+ 3.0211111 0.050000
+ 3.0213889 0.050000
+ 3.0216667 0.050000
+ 3.0219444 0.067239
+ 3.0222222 0.095214
+ 3.0225000 0.130788
+ 3.0227778 0.172229
+ 3.0230556 0.217411
+ 3.0233333 0.264209
+ 3.0236111 0.310498
+ 3.0238889 0.354154
+ 3.0241667 0.393051
+ 3.0244444 0.425063
+ 3.0247222 0.448066
+ 3.0250000 0.459935
+ 3.0252778 0.459202
+ 3.0255556 0.447032
+ 3.0258333 0.425249
+ 3.0261111 0.395676
+ 3.0263889 0.360135
+ 3.0266667 0.320449
+ 3.0269444 0.278443
+ 3.0272222 0.235937
+ 3.0275000 0.194757
+ 3.0277778 0.156724
+ 3.0280556 0.123414
+ 3.0283333 0.095405
+ 3.0286111 0.073030
+ 3.0288889 0.056619
+ 3.0291667 0.050000
+ 3.0294444 0.050000
+ 3.0297222 0.050000
+ 3.0300000 0.057241
+ 3.0302778 0.075619
+ 3.0305556 0.101948
+ 3.0308333 0.136145
+ 3.0311111 0.176462
+ 3.0313889 0.220738
+ 3.0316667 0.266811
+ 3.0319444 0.312519
+ 3.0322222 0.355701
+ 3.0325000 0.394194
+ 3.0327778 0.425836
+ 3.0330556 0.448466
+ 3.0333333 0.459922
+ 3.0336111 0.458710
+ 3.0338889 0.446016
+ 3.0341667 0.423690
+ 3.0344444 0.393587
+ 3.0347222 0.357558
+ 3.0350000 0.317456
+ 3.0352778 0.275135
+ 3.0355556 0.232446
+ 3.0358333 0.191242
+ 3.0361111 0.153377
+ 3.0363889 0.120441
+ 3.0366667 0.092986
+ 3.0369444 0.071299
+ 3.0372222 0.055670
+ 3.0375000 0.050000
+ 3.0377778 0.050000
+ 3.0380556 0.050000
+ 3.0383333 0.059519
+ 3.0386111 0.078518
+ 3.0388889 0.105309
+ 3.0391667 0.139777
+ 3.0394444 0.180183
+ 3.0397222 0.224383
+ 3.0400000 0.270235
+ 3.0402778 0.315593
+ 3.0405556 0.358315
+ 3.0408333 0.396256
+ 3.0411111 0.427273
+ 3.0413889 0.449223
+ 3.0416667 0.459961
+ 3.0419444 0.458008
+ 3.0422222 0.444541
+ 3.0425000 0.421403
+ 3.0427778 0.390435
+ 3.0430556 0.353478
+ 3.0433333 0.312375
+ 3.0436111 0.268968
+ 3.0438889 0.225097
+ 3.0441667 0.182606
+ 3.0444444 0.143334
+ 3.0447222 0.108878
+ 3.0450000 0.079839
+ 3.0452778 0.056573
+ 3.0455556 0.050000
+ 3.0458333 0.050000
+ 3.0461111 0.050000
+ 3.0463889 0.050000
+ 3.0466667 0.050000
+ 3.0469444 0.058114
+ 3.0472222 0.085211
+ 3.0475000 0.120495
+ 3.0477778 0.162177
+ 3.0480556 0.208041
+ 3.0483333 0.255869
+ 3.0486111 0.303442
+ 3.0488889 0.348545
+ 3.0491667 0.388959
+ 3.0494444 0.422467
+ 3.0497222 0.446852
+ 3.0500000 0.459895
+ 3.0502778 0.460055
+ 3.0505556 0.448487
+ 3.0508333 0.427021
+ 3.0511111 0.397488
+ 3.0513889 0.361718
+ 3.0516667 0.321541
+ 3.0519444 0.278788
+ 3.0522222 0.235290
+ 3.0525000 0.192876
+ 3.0527778 0.153377
+ 3.0530556 0.118387
+ 3.0533333 0.088556
+ 3.0536111 0.064297
+ 3.0538889 0.050000
+ 3.0541667 0.050000
+ 3.0544444 0.050000
+ 3.0547222 0.050000
+ 3.0550000 0.050000
+ 3.0552778 0.058905
+ 3.0555556 0.085224
+ 3.0558333 0.119977
+ 3.0561111 0.161351
+ 3.0563889 0.207090
+ 3.0566667 0.254936
+ 3.0569444 0.302632
+ 3.0572222 0.347920
+ 3.0575000 0.388544
+ 3.0577778 0.422246
+ 3.0580556 0.446769
+ 3.0583333 0.459856
+ 3.0586111 0.459938
+ 3.0588889 0.448198
+ 3.0591667 0.426509
+ 3.0594444 0.396743
+ 3.0597222 0.360773
+ 3.0600000 0.320470
+ 3.0602778 0.277706
+ 3.0605556 0.234355
+ 3.0608333 0.192288
+ 3.0611111 0.153377
+ 3.0613889 0.119240
+ 3.0616667 0.090477
+ 3.0619444 0.067434
+ 3.0622222 0.050455
+ 3.0625000 0.050000
+ 3.0627778 0.050000
+ 3.0630556 0.050000
+ 3.0633333 0.050093
+ 3.0636111 0.068618
+ 3.0638889 0.095280
+ 3.0641667 0.129998
+ 3.0644444 0.170991
+ 3.0647222 0.216051
+ 3.0650000 0.262970
+ 3.0652778 0.309541
+ 3.0655556 0.353555
+ 3.0658333 0.392805
+ 3.0661111 0.425084
+ 3.0663889 0.448183
+ 3.0666667 0.459895
+ 3.0669444 0.458691
+ 3.0672222 0.445754
+ 3.0675000 0.422947
+ 3.0677778 0.392131
+ 3.0680556 0.355169
+ 3.0683333 0.313922
+ 3.0686111 0.270253
+ 3.0688889 0.226024
+ 3.0691667 0.183097
+ 3.0694444 0.143334
+ 3.0697222 0.108350
+ 3.0700000 0.078769
+ 3.0702778 0.054967
+ 3.0705556 0.050000
+ 3.0708333 0.050000
+ 3.0711111 0.050000
+ 3.0713889 0.050000
+ 3.0716667 0.050000
+ 3.0719444 0.054631
+ 3.0722222 0.081837
+ 3.0725000 0.117398
+ 3.0727778 0.159490
+ 3.0730556 0.205851
+ 3.0733333 0.254220
+ 3.0736111 0.302334
+ 3.0738889 0.347930
+ 3.0741667 0.388746
+ 3.0744444 0.422521
+ 3.0747222 0.446991
+ 3.0750000 0.459895
+ 3.0752778 0.459662
+ 3.0755556 0.447488
+ 3.0758333 0.425259
+ 3.0761111 0.394864
+ 3.0763889 0.358189
+ 3.0766667 0.317122
+ 3.0769444 0.273551
+ 3.0772222 0.229362
+ 3.0775000 0.186443
+ 3.0777778 0.146682
+ 3.0780556 0.111712
+ 3.0783333 0.082159
+ 3.0786111 0.058391
+ 3.0788889 0.050000
+ 3.0791667 0.050000
+ 3.0794444 0.050000
+ 3.0797222 0.050000
+ 3.0800000 0.050000
+ 3.0802778 0.058074
+ 3.0805556 0.085198
+ 3.0808333 0.120636
+ 3.0811111 0.162563
+ 3.0813889 0.208715
+ 3.0816667 0.256828
+ 3.0819444 0.304636
+ 3.0822222 0.349875
+ 3.0825000 0.390281
+ 3.0827778 0.423590
+ 3.0830556 0.447536
+ 3.0833333 0.459856
+ 3.0836111 0.458983
+ 3.0838889 0.446141
+ 3.0841667 0.423255
+ 3.0844444 0.392247
+ 3.0847222 0.355040
+ 3.0850000 0.313558
+ 3.0852778 0.269723
+ 3.0855556 0.225458
+ 3.0858333 0.182688
+ 3.0861111 0.143334
+ 3.0863889 0.109052
+ 3.0866667 0.080419
+ 3.0869444 0.057745
+ 3.0872222 0.050000
+ 3.0875000 0.050000
+ 3.0877778 0.050000
+ 3.0880556 0.050000
+ 3.0883333 0.050000
+ 3.0886111 0.064183
+ 3.0888889 0.091893
+ 3.0891667 0.127614
+ 3.0894444 0.169536
+ 3.0897222 0.215423
+ 3.0900000 0.263040
+ 3.0902778 0.310152
+ 3.0905556 0.354523
+ 3.0908333 0.393918
+ 3.0911111 0.426102
+ 3.0913889 0.448840
+ 3.0916667 0.459895
+ 3.0919444 0.457731
+ 3.0922222 0.443597
+ 3.0925000 0.419440
+ 3.0927778 0.387208
+ 3.0930556 0.348848
+ 3.0933333 0.306308
+ 3.0936111 0.261535
+ 3.0938889 0.216477
+ 3.0941667 0.173080
+ 3.0944444 0.133292
+ 3.0947222 0.098783
+ 3.0950000 0.070116
+ 3.0952778 0.050000
+ 3.0955556 0.050000
+ 3.0958333 0.050000
+ 3.0961111 0.050000
+ 3.0963889 0.050000
+ 3.0966667 0.050000
+ 3.0969444 0.056884
+ 3.0972222 0.085185
+ 3.0975000 0.121469
+ 3.0977778 0.163935
+ 3.0980556 0.210363
+ 3.0983333 0.258535
+ 3.0986111 0.306230
+ 3.0988889 0.351229
+ 3.0991667 0.391313
+ 3.0994444 0.424263
+ 3.0997222 0.447859
+ 3.1000000 0.459882
+ 3.1002778 0.458797
+ 3.1005556 0.445809
+ 3.1008333 0.422804
+ 3.1011111 0.391674
+ 3.1013889 0.354304
+ 3.1016667 0.312586
+ 3.1019444 0.268406
+ 3.1022222 0.223654
+ 3.1025000 0.180218
+ 3.1027778 0.139987
+ 3.1030556 0.104598
+ 3.1033333 0.074685
+ 3.1036111 0.050632
+ 3.1038889 0.050000
+ 3.1041667 0.050000
+ 3.1044444 0.050000
+ 3.1047222 0.050000
+ 3.1050000 0.050000
+ 3.1052778 0.050795
+ 3.1055556 0.078477
+ 3.1058333 0.114631
+ 3.1061111 0.157395
+ 3.1063889 0.204454
+ 3.1066667 0.253496
+ 3.1069444 0.302207
+ 3.1072222 0.348273
+ 3.1075000 0.389382
+ 3.1077778 0.423220
+ 3.1080556 0.447474
+ 3.1083333 0.459830
+ 3.1086111 0.458689
+ 3.1088889 0.445302
+ 3.1091667 0.421636
+ 3.1094444 0.389658
+ 3.1097222 0.351331
+ 3.1100000 0.308623
+ 3.1102778 0.263499
+ 3.1105556 0.217926
+ 3.1108333 0.173868
+ 3.1111111 0.133292
+ 3.1113889 0.097891
+ 3.1116667 0.068265
+ 3.1119444 0.050000
+ 3.1122222 0.050000
+ 3.1125000 0.050000
+ 3.1127778 0.050000
+ 3.1130556 0.050000
+ 3.1133333 0.050000
+ 3.1136111 0.050126
+ 3.1138889 0.078503
+ 3.1141667 0.115168
+ 3.1144444 0.158269
+ 3.1147222 0.205513
+ 3.1150000 0.254612
+ 3.1152778 0.303274
+ 3.1155556 0.349208
+ 3.1158333 0.390126
+ 3.1161111 0.423736
+ 3.1163889 0.447747
+ 3.1166667 0.459869
+ 3.1169444 0.458519
+ 3.1172222 0.444939
+ 3.1175000 0.421078
+ 3.1177778 0.388887
+ 3.1180556 0.350313
+ 3.1183333 0.307307
+ 3.1186111 0.261818
+ 3.1188889 0.215795
+ 3.1191667 0.171187
+ 3.1194444 0.129944
+ 3.1197222 0.093753
+ 3.1200000 0.063247
+ 3.1202778 0.050000
+ 3.1205556 0.050000
+ 3.1208333 0.050000
+ 3.1211111 0.050000
+ 3.1213889 0.050000
+ 3.1216667 0.050000
+ 3.1219444 0.050000
+ 3.1222222 0.068434
+ 3.1225000 0.105356
+ 3.1227778 0.148978
+ 3.1230556 0.196972
+ 3.1233333 0.247010
+ 3.1236111 0.296766
+ 3.1238889 0.343912
+ 3.1241667 0.386120
+ 3.1244444 0.421063
+ 3.1247222 0.446413
+ 3.1250000 0.459843
+ 3.1252778 0.459736
+ 3.1255556 0.447315
+ 3.1258333 0.424513
+ 3.1261111 0.393263
+ 3.1263889 0.355500
+ 3.1266667 0.313155
+ 3.1269444 0.268164
+ 3.1272222 0.222458
+ 3.1275000 0.177973
+ 3.1277778 0.136639
+ 3.1280556 0.100139
+ 3.1283333 0.069136
+ 3.1286111 0.050000
+ 3.1288889 0.050000
+ 3.1291667 0.050000
+ 3.1294444 0.050000
+ 3.1297222 0.050000
+ 3.1300000 0.050000
+ 3.1302778 0.050000
+ 3.1305556 0.068434
+ 3.1308333 0.104975
+ 3.1311111 0.148367
+ 3.1313889 0.196256
+ 3.1316667 0.246291
+ 3.1319444 0.296118
+ 3.1322222 0.343387
+ 3.1325000 0.385743
+ 3.1327778 0.420835
+ 3.1330556 0.446311
+ 3.1333333 0.459817
+ 3.1336111 0.459723
+ 3.1338889 0.447280
+ 3.1341667 0.424462
+ 3.1344444 0.393243
+ 3.1347222 0.355595
+ 3.1350000 0.313491
+ 3.1352778 0.268905
+ 3.1355556 0.223811
+ 3.1358333 0.180180
+ 3.1361111 0.139987
+ 3.1363889 0.104929
+ 3.1366667 0.075598
+ 3.1369444 0.052312
+ 3.1372222 0.050000
+ 3.1375000 0.050000
+ 3.1377778 0.050000
+ 3.1380556 0.050000
+ 3.1383333 0.050000
+ 3.1386111 0.057302
+ 3.1388889 0.085211
+ 3.1391667 0.121273
+ 3.1394444 0.163662
+ 3.1397222 0.210121
+ 3.1400000 0.258397
+ 3.1402778 0.306233
+ 3.1405556 0.351375
+ 3.1408333 0.391566
+ 3.1411111 0.424551
+ 3.1413889 0.448075
+ 3.1416667 0.459882
+ 3.1419444 0.458414
+ 3.1422222 0.444894
+ 3.1425000 0.421242
+ 3.1427778 0.389379
+ 3.1430556 0.351225
+ 3.1433333 0.308699
+ 3.1436111 0.263723
+ 3.1438889 0.218217
+ 3.1441667 0.174099
+ 3.1444444 0.133292
+ 3.1447222 0.097456
+ 3.1450000 0.067223
+ 3.1452778 0.050000
+ 3.1455556 0.050000
+ 3.1458333 0.050000
+ 3.1461111 0.050000
+ 3.1463889 0.050000
+ 3.1466667 0.050000
+ 3.1469444 0.050000
+ 3.1472222 0.071755
+ 3.1475000 0.108264
+ 3.1477778 0.151425
+ 3.1480556 0.198937
+ 3.1483333 0.248496
+ 3.1486111 0.297799
+ 3.1488889 0.344545
+ 3.1491667 0.386430
+ 3.1494444 0.421152
+ 3.1497222 0.446408
+ 3.1500000 0.459895
+ 3.1502778 0.460014
+ 3.1505556 0.447973
+ 3.1508333 0.425684
+ 3.1511111 0.395060
+ 3.1513889 0.358012
+ 3.1516667 0.316452
+ 3.1519444 0.272293
+ 3.1522222 0.227445
+ 3.1525000 0.183822
+ 3.1527778 0.143334
+ 3.1530556 0.107642
+ 3.1533333 0.077390
+ 3.1536111 0.052974
+ 3.1538889 0.050000
+ 3.1541667 0.050000
+ 3.1544444 0.050000
+ 3.1547222 0.050000
+ 3.1550000 0.050000
+ 3.1552778 0.051034
+ 3.1555556 0.078477
+ 3.1558333 0.114449
+ 3.1561111 0.157085
+ 3.1563889 0.204065
+ 3.1566667 0.253072
+ 3.1569444 0.301786
+ 3.1572222 0.347890
+ 3.1575000 0.389063
+ 3.1577778 0.422988
+ 3.1580556 0.447345
+ 3.1583333 0.459817
+ 3.1586111 0.458797
+ 3.1588889 0.445529
+ 3.1591667 0.421971
+ 3.1594444 0.390078
+ 3.1597222 0.351808
+ 3.1600000 0.309118
+ 3.1602778 0.263965
+ 3.1605556 0.218305
+ 3.1608333 0.174095
+ 3.1611111 0.133292
+ 3.1613889 0.097585
+ 3.1616667 0.067590
+ 3.1619444 0.050000
+ 3.1622222 0.050000
+ 3.1625000 0.050000
+ 3.1627778 0.050000
+ 3.1630556 0.050000
+ 3.1633333 0.050000
+ 3.1636111 0.050000
+ 3.1638889 0.075155
+ 3.1641667 0.111831
+ 3.1644444 0.155054
+ 3.1647222 0.202517
+ 3.1650000 0.251916
+ 3.1652778 0.300945
+ 3.1655556 0.347297
+ 3.1658333 0.388667
+ 3.1661111 0.422750
+ 3.1663889 0.447240
+ 3.1666667 0.459830
+ 3.1669444 0.458925
+ 3.1672222 0.445765
+ 3.1675000 0.422300
+ 3.1677778 0.390480
+ 3.1680556 0.352255
+ 3.1683333 0.309574
+ 3.1686111 0.264387
+ 3.1688889 0.218645
+ 3.1691667 0.174297
+ 3.1694444 0.133292
+ 3.1697222 0.097317
+ 3.1700000 0.066999
+ 3.1702778 0.050000
+ 3.1705556 0.050000
+ 3.1708333 0.050000
+ 3.1711111 0.050000
+ 3.1713889 0.050000
+ 3.1716667 0.050000
+ 3.1719444 0.050000
+ 3.1722222 0.071782
+ 3.1725000 0.108309
+ 3.1727778 0.151470
+ 3.1730556 0.198967
+ 3.1733333 0.248503
+ 3.1736111 0.297779
+ 3.1738889 0.344499
+ 3.1741667 0.386364
+ 3.1744444 0.421077
+ 3.1747222 0.446341
+ 3.1750000 0.459856
+ 3.1752778 0.460026
+ 3.1755556 0.448053
+ 3.1758333 0.425838
+ 3.1761111 0.395284
+ 3.1763889 0.358292
+ 3.1766667 0.316764
+ 3.1769444 0.272603
+ 3.1772222 0.227709
+ 3.1775000 0.183986
+ 3.1777778 0.143334
+ 3.1780556 0.107408
+ 3.1783333 0.076863
+ 3.1786111 0.052107
+ 3.1788889 0.050000
+ 3.1791667 0.050000
+ 3.1794444 0.050000
+ 3.1797222 0.050000
+ 3.1800000 0.050000
+ 3.1802778 0.050000
+ 3.1805556 0.075142
+ 3.1808333 0.110919
+ 3.1811111 0.153440
+ 3.1813889 0.200401
+ 3.1816667 0.249496
+ 3.1819444 0.298422
+ 3.1822222 0.344873
+ 3.1825000 0.386544
+ 3.1827778 0.421131
+ 3.1830556 0.446328
+ 3.1833333 0.459830
+ 3.1836111 0.460035
+ 3.1838889 0.448149
+ 3.1841667 0.426078
+ 3.1844444 0.395732
+ 3.1847222 0.359017
+ 3.1850000 0.317841
+ 3.1852778 0.274111
+ 3.1855556 0.229737
+ 3.1858333 0.186624
+ 3.1861111 0.146682
+ 3.1863889 0.111561
+ 3.1866667 0.081889
+ 3.1869444 0.058037
+ 3.1872222 0.050000
+ 3.1875000 0.050000
+ 3.1877778 0.050000
+ 3.1880556 0.050000
+ 3.1883333 0.050000
+ 3.1886111 0.057939
+ 3.1888889 0.085224
+ 3.1891667 0.120856
+ 3.1894444 0.162992
+ 3.1897222 0.209345
+ 3.1900000 0.257630
+ 3.1902778 0.305561
+ 3.1905556 0.350850
+ 3.1908333 0.391211
+ 3.1911111 0.424359
+ 3.1913889 0.448007
+ 3.1916667 0.459869
+ 3.1919444 0.458365
+ 3.1922222 0.444737
+ 3.1925000 0.420937
+ 3.1927778 0.388915
+ 3.1930556 0.350619
+ 3.1933333 0.308000
+ 3.1936111 0.263008
+ 3.1938889 0.217593
+ 3.1941667 0.173704
+ 3.1944444 0.133292
+ 3.1947222 0.098035
+ 3.1950000 0.068529
+ 3.1952778 0.050000
+ 3.1955556 0.050000
+ 3.1958333 0.050000
+ 3.1961111 0.050000
+ 3.1963889 0.050000
+ 3.1966667 0.050000
+ 3.1969444 0.050259
+ 3.1972222 0.078437
+ 3.1975000 0.114856
+ 3.1977778 0.157684
+ 3.1980556 0.204663
+ 3.1983333 0.253532
+ 3.1986111 0.302030
+ 3.1988889 0.347899
+ 3.1991667 0.388877
+ 3.1994444 0.422705
+ 3.1997222 0.447122
+ 3.2000000 0.459869
+ 3.2002778 0.459380
+ 3.2005556 0.446871
+ 3.2008333 0.424252
+ 3.2011111 0.393435
+ 3.2013889 0.356328
+ 3.2016667 0.314843
+ 3.2019444 0.270891
+ 3.2022222 0.226382
+ 3.2025000 0.183226
+ 3.2027778 0.143334
+ 3.2030556 0.108358
+ 3.2033333 0.078913
+ 3.2036111 0.055354
+ 3.2038889 0.050000
+ 3.2041667 0.050000
+ 3.2044444 0.050000
+ 3.2047222 0.050000
+ 3.2050000 0.050000
+ 3.2052778 0.057575
+ 3.2055556 0.085198
+ 3.2058333 0.121117
+ 3.2061111 0.163483
+ 3.2063889 0.210009
+ 3.2066667 0.258404
+ 3.2069444 0.306380
+ 3.2072222 0.351649
+ 3.2075000 0.391921
+ 3.2077778 0.424908
+ 3.2080556 0.448320
+ 3.2083333 0.459869
+ 3.2086111 0.457984
+ 3.2088889 0.443961
+ 3.2091667 0.419817
+ 3.2094444 0.387565
+ 3.2097222 0.349221
+ 3.2100000 0.306800
+ 3.2102778 0.262316
+ 3.2105556 0.217785
+ 3.2108333 0.175221
+ 3.2111111 0.136639
+ 3.2113889 0.103747
+ 3.2116667 0.077020
+ 3.2119444 0.056626
+ 3.2122222 0.050000
+ 3.2125000 0.050000
+ 3.2127778 0.050000
+ 3.2130556 0.050000
+ 3.2133333 0.055521
+ 3.2136111 0.076648
+ 3.2138889 0.105283
+ 3.2141667 0.141211
+ 3.2144444 0.182694
+ 3.2147222 0.227610
+ 3.2150000 0.273838
+ 3.2152778 0.319257
+ 3.2155556 0.361747
+ 3.2158333 0.399186
+ 3.2161111 0.429453
+ 3.2163889 0.450427
+ 3.2166667 0.459987
+ 3.2169444 0.456691
+ 3.2172222 0.441812
+ 3.2175000 0.417301
+ 3.2177778 0.385111
+ 3.2180556 0.347192
+ 3.2183333 0.305497
+ 3.2186111 0.261978
+ 3.2188889 0.218585
+ 3.2191667 0.177271
+ 3.2194444 0.139987
+ 3.2197222 0.108382
+ 3.2200000 0.082894
+ 3.2202778 0.063656
+ 3.2205556 0.050804
+ 3.2208333 0.050000
+ 3.2211111 0.050000
+ 3.2213889 0.051900
+ 3.2216667 0.065931
+ 3.2219444 0.087020
+ 3.2222222 0.115299
+ 3.2225000 0.150541
+ 3.2227778 0.191064
+ 3.2230556 0.234824
+ 3.2233333 0.279777
+ 3.2236111 0.323878
+ 3.2238889 0.365082
+ 3.2241667 0.401346
+ 3.2244444 0.430626
+ 3.2247222 0.450876
+ 3.2250000 0.460052
+ 3.2252778 0.456768
+ 3.2255556 0.442263
+ 3.2258333 0.418436
+ 3.2261111 0.387185
+ 3.2263889 0.350406
+ 3.2266667 0.309998
+ 3.2269444 0.267859
+ 3.2272222 0.225886
+ 3.2275000 0.185977
+ 3.2277778 0.150029
+ 3.2280556 0.119644
+ 3.2283333 0.095233
+ 3.2286111 0.076911
+ 3.2288889 0.064791
+ 3.2291667 0.058990
+ 3.2294444 0.059620
+ 3.2297222 0.066797
+ 3.2300000 0.080636
+ 3.2302778 0.101250
+ 3.2305556 0.128754
+ 3.2308333 0.162916
+ 3.2311111 0.202110
+ 3.2313889 0.244362
+ 3.2316667 0.287701
+ 3.2319444 0.330154
+ 3.2322222 0.369747
+ 3.2325000 0.404507
+ 3.2327778 0.432462
+ 3.2330556 0.451639
+ 3.2333333 0.460065
+ 3.2336111 0.456409
+ 3.2338889 0.441901
+ 3.2341667 0.418418
+ 3.2344444 0.387831
+ 3.2347222 0.352015
+ 3.2350000 0.312843
+ 3.2352778 0.272189
+ 3.2355556 0.231927
+ 3.2358333 0.193930
+ 3.2361111 0.160072
+ 3.2363889 0.131917
+ 3.2366667 0.109794
+ 3.2369444 0.093722
+ 3.2372222 0.083721
+ 3.2375000 0.079809
+ 3.2377778 0.082006
+ 3.2380556 0.090330
+ 3.2383333 0.104802
+ 3.2386111 0.125441
+ 3.2388889 0.152265
+ 3.2391667 0.184990
+ 3.2394444 0.222110
+ 3.2397222 0.261816
+ 3.2400000 0.302298
+ 3.2402778 0.341746
+ 3.2405556 0.378351
+ 3.2408333 0.410303
+ 3.2411111 0.435792
+ 3.2413889 0.453009
+ 3.2416667 0.460144
+ 3.2419444 0.455975
+ 3.2422222 0.441633
+ 3.2425000 0.418834
+ 3.2427778 0.389297
+ 3.2430556 0.354740
+ 3.2433333 0.316879
+ 3.2436111 0.277434
+ 3.2438889 0.238122
+ 3.2441667 0.200660
+ 3.2444444 0.166767
+ 3.2447222 0.137900
+ 3.2450000 0.114478
+ 3.2452778 0.096660
+ 3.2455556 0.084604
+ 3.2458333 0.078470
+ 3.2461111 0.078417
+ 3.2463889 0.084603
+ 3.2466667 0.097186
+ 3.2469444 0.116327
+ 3.2472222 0.142184
+ 3.2475000 0.174570
+ 3.2477778 0.211920
+ 3.2480556 0.252322
+ 3.2483333 0.293867
+ 3.2486111 0.334643
+ 3.2488889 0.372738
+ 3.2491667 0.406243
+ 3.2494444 0.433247
+ 3.2497222 0.451837
+ 3.2500000 0.460105
+ 3.2502778 0.456750
+ 3.2505556 0.442922
+ 3.2508333 0.420385
+ 3.2511111 0.390900
+ 3.2513889 0.356230
+ 3.2516667 0.318135
+ 3.2519444 0.278380
+ 3.2522222 0.238725
+ 3.2525000 0.200933
+ 3.2527778 0.166767
+ 3.2530556 0.137718
+ 3.2533333 0.114199
+ 3.2536111 0.096352
+ 3.2538889 0.084319
+ 3.2541667 0.078244
+ 3.2544444 0.078268
+ 3.2547222 0.084535
+ 3.2550000 0.097185
+ 3.2552778 0.116363
+ 3.2555556 0.142210
+ 3.2558333 0.174530
+ 3.2561111 0.211771
+ 3.2563889 0.252045
+ 3.2566667 0.293459
+ 3.2569444 0.334126
+ 3.2572222 0.372154
+ 3.2575000 0.405653
+ 3.2577778 0.432733
+ 3.2580556 0.451505
+ 3.2583333 0.460078
+ 3.2586111 0.457167
+ 3.2588889 0.443903
+ 3.2591667 0.422023
+ 3.2594444 0.393264
+ 3.2597222 0.359360
+ 3.2600000 0.322050
+ 3.2602778 0.283068
+ 3.2605556 0.244152
+ 3.2608333 0.207038
+ 3.2611111 0.173462
+ 3.2613889 0.144895
+ 3.2616667 0.121747
+ 3.2619444 0.104162
+ 3.2622222 0.092284
+ 3.2625000 0.086259
+ 3.2627778 0.086230
+ 3.2630556 0.092343
+ 3.2633333 0.104741
+ 3.2636111 0.123568
+ 3.2638889 0.148970
+ 3.2641667 0.180755
+ 3.2644444 0.217385
+ 3.2647222 0.256988
+ 3.2650000 0.297690
+ 3.2652778 0.337619
+ 3.2655556 0.374901
+ 3.2658333 0.407664
+ 3.2661111 0.434034
+ 3.2663889 0.452139
+ 3.2666667 0.460105
+ 3.2669444 0.456655
+ 3.2672222 0.442902
+ 3.2675000 0.420550
+ 3.2677778 0.391309
+ 3.2680556 0.356884
+ 3.2683333 0.318984
+ 3.2686111 0.279315
+ 3.2688889 0.239584
+ 3.2691667 0.201499
+ 3.2694444 0.166767
+ 3.2697222 0.136847
+ 3.2700000 0.112211
+ 3.2702778 0.093082
+ 3.2705556 0.079684
+ 3.2708333 0.072240
+ 3.2711111 0.070973
+ 3.2713889 0.076108
+ 3.2716667 0.087867
+ 3.2719444 0.106475
+ 3.2722222 0.132154
+ 3.2725000 0.164762
+ 3.2727778 0.202687
+ 3.2730556 0.243952
+ 3.2733333 0.286577
+ 3.2736111 0.328585
+ 3.2738889 0.367997
+ 3.2741667 0.402836
+ 3.2744444 0.431124
+ 3.2747222 0.450881
+ 3.2750000 0.460131
+ 3.2752778 0.457522
+ 3.2755556 0.444212
+ 3.2758333 0.421987
+ 3.2761111 0.392632
+ 3.2763889 0.357933
+ 3.2766667 0.319676
+ 3.2769444 0.279645
+ 3.2772222 0.239626
+ 3.2775000 0.201405
+ 3.2777778 0.166767
+ 3.2780556 0.137226
+ 3.2783333 0.113211
+ 3.2786111 0.094877
+ 3.2788889 0.082383
+ 3.2791667 0.075885
+ 3.2794444 0.075540
+ 3.2797222 0.081504
+ 3.2800000 0.093935
+ 3.2802778 0.112989
+ 3.2805556 0.138823
+ 3.2808333 0.171250
+ 3.2811111 0.208703
+ 3.2813889 0.249272
+ 3.2816667 0.291045
+ 3.2819444 0.332114
+ 3.2822222 0.370566
+ 3.2825000 0.404491
+ 3.2827778 0.431979
+ 3.2830556 0.451119
+ 3.2833333 0.460000
+ 3.2836111 0.457308
+ 3.2838889 0.444110
+ 3.2841667 0.422072
+ 3.2844444 0.392858
+ 3.2847222 0.358132
+ 3.2850000 0.319558
+ 3.2852778 0.278800
+ 3.2855556 0.237524
+ 3.2858333 0.197393
+ 3.2861111 0.160072
+ 3.2863889 0.127016
+ 3.2866667 0.098845
+ 3.2869444 0.075970
+ 3.2872222 0.058802
+ 3.2875000 0.050000
+ 3.2877778 0.050000
+ 3.2880556 0.050000
+ 3.2883333 0.055424
+ 3.2886111 0.072959
+ 3.2888889 0.098666
+ 3.2891667 0.132523
+ 3.2894444 0.172760
+ 3.2897222 0.217173
+ 3.2900000 0.263560
+ 3.2902778 0.309715
+ 3.2905556 0.353435
+ 3.2908333 0.392516
+ 3.2911111 0.424753
+ 3.2913889 0.447943
+ 3.2916667 0.459882
+ 3.2919444 0.459034
+ 3.2922222 0.446533
+ 3.2925000 0.424182
+ 3.2927778 0.393784
+ 3.2930556 0.357140
+ 3.2933333 0.316054
+ 3.2936111 0.272328
+ 3.2938889 0.227764
+ 3.2941667 0.184165
+ 3.2944444 0.143334
+ 3.2947222 0.106855
+ 3.2950000 0.075436
+ 3.2952778 0.050000
+ 3.2955556 0.050000
+ 3.2958333 0.050000
+ 3.2961111 0.050000
+ 3.2963889 0.050000
+ 3.2966667 0.050000
+ 3.2969444 0.050000
+ 3.2972222 0.065126
+ 3.2975000 0.100851
+ 3.2977778 0.143693
+ 3.2980556 0.191297
+ 3.2983333 0.241305
+ 3.2986111 0.291359
+ 3.2988889 0.339103
+ 3.2991667 0.382179
+ 3.2994444 0.418230
+ 3.2997222 0.444900
+ 3.3000000 0.459830
+ 3.3002778 0.461369
+ 3.3005556 0.450686
+ 3.3008333 0.429654
+ 3.3011111 0.400146
+ 3.3013889 0.364036
+ 3.3016667 0.323197
+ 3.3019444 0.279504
+ 3.3022222 0.234829
+ 3.3025000 0.191046
+ 3.3027778 0.150029
+ 3.3030556 0.113419
+ 3.3033333 0.081928
+ 3.3036111 0.056034
+ 3.3038889 0.050000
+ 3.3041667 0.050000
+ 3.3044444 0.050000
+ 3.3047222 0.050000
+ 3.3050000 0.050000
+ 3.3052778 0.050000
+ 3.3055556 0.071795
+ 3.3058333 0.107467
+ 3.3061111 0.150190
+ 3.3063889 0.197581
+ 3.3066667 0.247256
+ 3.3069444 0.296833
+ 3.3072222 0.343929
+ 3.3075000 0.386161
+ 3.3077778 0.421146
+ 3.3080556 0.446501
+ 3.3083333 0.459843
+ 3.3086111 0.459518
+ 3.3088889 0.446784
+ 3.3091667 0.423628
+ 3.3094444 0.392038
+ 3.3097222 0.354000
+ 3.3100000 0.311501
+ 3.3102778 0.266529
+ 3.3105556 0.221070
+ 3.3108333 0.177111
+ 3.3111111 0.136639
+ 3.3113889 0.101363
+ 3.3116667 0.071874
+ 3.3119444 0.050000
+ 3.3122222 0.050000
+ 3.3125000 0.050000
+ 3.3127778 0.050000
+ 3.3130556 0.050000
+ 3.3133333 0.050000
+ 3.3136111 0.053786
+ 3.3138889 0.081863
+ 3.3141667 0.118117
+ 3.3144444 0.160722
+ 3.3147222 0.207425
+ 3.3150000 0.255975
+ 3.3152778 0.304118
+ 3.3155556 0.349601
+ 3.3158333 0.390171
+ 3.3161111 0.423577
+ 3.3163889 0.447565
+ 3.3166667 0.459882
+ 3.3169444 0.458967
+ 3.3172222 0.446023
+ 3.3175000 0.422942
+ 3.3177778 0.391619
+ 3.3180556 0.353947
+ 3.3183333 0.311821
+ 3.3186111 0.267133
+ 3.3188889 0.221778
+ 3.3191667 0.177649
+ 3.3194444 0.136639
+ 3.3197222 0.100397
+ 3.3200000 0.069584
+ 3.3202778 0.050000
+ 3.3205556 0.050000
+ 3.3208333 0.050000
+ 3.3211111 0.050000
+ 3.3213889 0.050000
+ 3.3216667 0.050000
+ 3.3219444 0.050000
+ 3.3222222 0.068421
+ 3.3225000 0.104722
+ 3.3227778 0.147864
+ 3.3230556 0.195520
+ 3.3233333 0.245360
+ 3.3236111 0.295055
+ 3.3238889 0.342276
+ 3.3241667 0.384694
+ 3.3244444 0.419981
+ 3.3247222 0.445807
+ 3.3250000 0.459843
+ 3.3252778 0.460465
+ 3.3255556 0.448863
+ 3.3258333 0.426932
+ 3.3261111 0.396566
+ 3.3263889 0.359659
+ 3.3266667 0.318107
+ 3.3269444 0.273804
+ 3.3272222 0.228645
+ 3.3275000 0.184523
+ 3.3277778 0.143334
+ 3.3280556 0.106732
+ 3.3283333 0.075404
+ 3.3286111 0.050000
+ 3.3288889 0.050000
+ 3.3291667 0.050000
+ 3.3294444 0.050000
+ 3.3297222 0.050000
+ 3.3300000 0.050000
+ 3.3302778 0.050000
+ 3.3305556 0.068447
+ 3.3308333 0.104291
+ 3.3311111 0.147102
+ 3.3313889 0.194542
+ 3.3316667 0.244271
+ 3.3319444 0.293951
+ 3.3322222 0.341243
+ 3.3325000 0.383806
+ 3.3327778 0.419303
+ 3.3330556 0.445393
+ 3.3333333 0.459738
+ 3.3336111 0.460704
+ 3.3338889 0.449470
+ 3.3341667 0.427922
+ 3.3344444 0.397947
+ 3.3347222 0.361429
+ 3.3350000 0.320253
+ 3.3352778 0.276305
+ 3.3355556 0.231470
+ 3.3358333 0.187634
+ 3.3361111 0.146682
+ 3.3363889 0.110260
+ 3.3366667 0.079061
+ 3.3369444 0.053538
+ 3.3372222 0.050000
+ 3.3375000 0.050000
+ 3.3377778 0.050000
+ 3.3380556 0.050000
+ 3.3383333 0.050000
+ 3.3386111 0.050000
+ 3.3388889 0.071847
+ 3.3391667 0.107571
+ 3.3394444 0.150246
+ 3.3397222 0.197520
+ 3.3400000 0.247045
+ 3.3402778 0.296469
+ 3.3405556 0.343442
+ 3.3408333 0.385615
+ 3.3411111 0.420638
+ 3.3413889 0.446159
+ 3.3416667 0.459830
+ 3.3419444 0.460009
+ 3.3422222 0.447890
+ 3.3425000 0.425377
+ 3.3427778 0.394373
+ 3.3430556 0.356783
+ 3.3433333 0.314508
+ 3.3436111 0.269453
+ 3.3438889 0.223521
+ 3.3441667 0.178615
+ 3.3444444 0.136639
+ 3.3447222 0.099262
+ 3.3450000 0.067211
+ 3.3452778 0.050000
+ 3.3455556 0.050000
+ 3.3458333 0.050000
+ 3.3461111 0.050000
+ 3.3463889 0.050000
+ 3.3466667 0.050000
+ 3.3469444 0.050000
+ 3.3472222 0.061713
+ 3.3475000 0.099282
+ 3.3477778 0.144087
+ 3.3480556 0.193601
+ 3.3483333 0.245297
+ 3.3486111 0.296648
+ 3.3488889 0.345127
+ 3.3491667 0.388207
+ 3.3494444 0.423360
+ 3.3497222 0.448059
+ 3.3500000 0.459778
+ 3.3502778 0.456774
+ 3.3505556 0.440452
+ 3.3508333 0.413001
+ 3.3511111 0.376610
+ 3.3513889 0.333467
+ 3.3516667 0.285764
+ 3.3519444 0.235688
+ 3.3522222 0.185430
+ 3.3525000 0.137178
+ 3.3527778 0.093122
+ 3.3530556 0.055136
+ 3.3533333 0.050000
+ 3.3536111 0.050000
+ 3.3538889 0.050000
+ 3.3541667 0.050000
+ 3.3544444 0.050000
+ 3.3547222 0.050000
+ 3.3550000 0.050000
+ 3.3552778 0.050000
+ 3.3555556 0.050000
+ 3.3558333 0.091849
+ 3.3561111 0.140464
+ 3.3563889 0.193234
+ 3.3566667 0.247546
+ 3.3569444 0.300788
+ 3.3572222 0.350347
+ 3.3575000 0.393610
+ 3.3577778 0.427965
+ 3.3580556 0.450801
+ 3.3583333 0.459503
+ 3.3586111 0.452319
+ 3.3588889 0.430928
+ 3.3591667 0.397868
+ 3.3594444 0.355678
+ 3.3597222 0.306897
+ 3.3600000 0.254061
+ 3.3602778 0.199711
+ 3.3605556 0.146384
+ 3.3608333 0.096618
+ 3.3611111 0.052952
+ 3.3613889 0.050000
+ 3.3616667 0.050000
+ 3.3619444 0.050000
+ 3.3622222 0.050000
+ 3.3625000 0.050000
+ 3.3627778 0.050000
+ 3.3630556 0.050000
+ 3.3633333 0.050000
+ 3.3636111 0.050000
+ 3.3638889 0.050000
+ 3.3641667 0.088402
+ 3.3644444 0.131619
+ 3.3647222 0.178055
+ 3.3650000 0.226116
+ 3.3652778 0.274209
+ 3.3655556 0.320738
+ 3.3658333 0.364110
+ 3.3661111 0.402729
+ 3.3663889 0.435001
+ 3.3666667 0.459333
+ 3.3669444 0.474552
+ 3.3672222 0.481176
+ 3.3675000 0.480148
+ 3.3677778 0.472406
+ 3.3680556 0.458894
+ 3.3683333 0.440551
+ 3.3686111 0.418319
+ 3.3688889 0.393139
+ 3.3691667 0.365952
+ 3.3694444 0.337699
+ 3.3697222 0.309293
+ 3.3700000 0.281542
+ 3.3702778 0.255225
+ 3.3705556 0.231122
+ 3.3708333 0.210011
+ 3.3711111 0.192674
+ 3.3713889 0.179888
+ 3.3716667 0.172434
+ 3.3719444 0.171091
+ 3.3722222 0.176639
+ 3.3725000 0.189589
+ 3.3727778 0.209379
+ 3.3730556 0.235178
+ 3.3733333 0.266156
+ 3.3736111 0.301482
+ 3.3738889 0.340325
+ 3.3741667 0.381856
+ 3.3744444 0.425244
+ 3.3747222 0.469657
+ 3.3750000 0.514266
+ 3.3752778 0.558104
+ 3.3755556 0.599661
+ 3.3758333 0.637289
+ 3.3761111 0.669342
+ 3.3763889 0.694174
+ 3.3766667 0.710137
+ 3.3769444 0.715586
+ 3.3772222 0.708873
+ 3.3775000 0.688352
+ 3.3777778 0.652377
+ 3.3780556 0.600269
+ 3.3783333 0.535231
+ 3.3786111 0.461435
+ 3.3788889 0.383051
+ 3.3791667 0.304251
+ 3.3794444 0.229205
+ 3.3797222 0.162086
+ 3.3800000 0.107065
+ 3.3802778 0.068312
+ 3.3805556 0.050000
+ 3.3808333 0.054907
+ 3.3811111 0.080243
+ 3.3813889 0.121827
+ 3.3816667 0.175476
+ 3.3819444 0.237009
+ 3.3822222 0.302243
+ 3.3825000 0.366997
+ 3.3827778 0.427088
+ 3.3830556 0.478335
+ 3.3833333 0.516554
+ 3.3836111 0.538732
+ 3.3838889 0.546513
+ 3.3841667 0.542712
+ 3.3844444 0.530142
+ 3.3847222 0.511615
+ 3.3850000 0.489945
+ 3.3852778 0.467945
+ 3.3855556 0.448428
+ 3.3858333 0.434207
+ 3.3861111 0.428094
+ 3.3863889 0.432113
+ 3.3866667 0.445124
+ 3.3869444 0.465194
+ 3.3872222 0.490395
+ 3.3875000 0.518796
+ 3.3877778 0.548464
+ 3.3880556 0.577471
+ 3.3883333 0.603884
+ 3.3886111 0.625774
+ 3.3888889 0.641210
+ 3.3891667 0.648705
+ 3.3894444 0.648556
+ 3.3897222 0.641503
+ 3.3900000 0.628285
+ 3.3902778 0.609644
+ 3.3905556 0.586320
+ 3.3908333 0.559052
+ 3.3911111 0.528582
+ 3.3913889 0.495649
+ 3.3916667 0.460994
+ 3.3919444 0.425284
+ 3.3922222 0.388897
+ 3.3925000 0.352135
+ 3.3927778 0.315304
+ 3.3930556 0.278706
+ 3.3933333 0.242646
+ 3.3936111 0.207427
+ 3.3938889 0.173354
+ 3.3941667 0.140730
+ 3.3944444 0.109859
+ 3.3947222 0.081131
+ 3.3950000 0.055278
+ 3.3952778 0.050000
+ 3.3955556 0.050000
+ 3.3958333 0.050000
+ 3.3961111 0.050000
+ 3.3963889 0.050000
+ 3.3966667 0.050000
+ 3.3969444 0.050000
+ 3.3972222 0.050000
+ 3.3975000 0.086240
+ 3.3977778 0.130206
+ 3.3980556 0.179393
+ 3.3983333 0.231299
+ 3.3986111 0.283418
+ 3.3988889 0.333248
+ 3.3991667 0.378283
+ 3.3994444 0.416019
+ 3.3997222 0.443954
+ 3.4000000 0.459582
+ 3.4002778 0.461144
+ 3.4005556 0.449864
+ 3.4008333 0.427707
+ 3.4011111 0.396640
+ 3.4013889 0.358631
+ 3.4016667 0.315647
+ 3.4019444 0.269654
+ 3.4022222 0.222619
+ 3.4025000 0.176509
+ 3.4027778 0.133292
+ 3.4030556 0.094691
+ 3.4033333 0.061459
+ 3.4036111 0.050000
+ 3.4038889 0.050000
+ 3.4041667 0.050000
+ 3.4044444 0.050000
+ 3.4047222 0.050000
+ 3.4050000 0.050000
+ 3.4052778 0.050000
+ 3.4055556 0.050000
+ 3.4058333 0.087507
+ 3.4061111 0.132462
+ 3.4063889 0.182362
+ 3.4066667 0.234700
+ 3.4069444 0.286974
+ 3.4072222 0.336678
+ 3.4075000 0.381307
+ 3.4077778 0.418356
+ 3.4080556 0.445322
+ 3.4083333 0.459699
+ 3.4086111 0.459743
+ 3.4088889 0.446748
+ 3.4091667 0.422768
+ 3.4094444 0.389858
+ 3.4097222 0.350071
+ 3.4100000 0.305464
+ 3.4102778 0.258088
+ 3.4105556 0.210000
+ 3.4108333 0.163253
+ 3.4111111 0.119902
+ 3.4113889 0.081727
+ 3.4116667 0.050000
+ 3.4119444 0.050000
+ 3.4122222 0.050000
+ 3.4125000 0.050000
+ 3.4127778 0.050000
+ 3.4130556 0.050000
+ 3.4133333 0.050000
+ 3.4136111 0.050000
+ 3.4138889 0.051670
+ 3.4141667 0.090269
+ 3.4144444 0.135974
+ 3.4147222 0.186304
+ 3.4150000 0.238779
+ 3.4152778 0.290916
+ 3.4155556 0.340236
+ 3.4158333 0.384256
+ 3.4161111 0.420497
+ 3.4163889 0.446476
+ 3.4166667 0.459712
+ 3.4169444 0.458490
+ 3.4172222 0.444150
+ 3.4175000 0.418797
+ 3.4177778 0.384538
+ 3.4180556 0.343478
+ 3.4183333 0.297723
+ 3.4186111 0.249378
+ 3.4188889 0.200548
+ 3.4191667 0.153340
+ 3.4194444 0.109859
+ 3.4197222 0.071918
+ 3.4200000 0.050000
+ 3.4202778 0.050000
+ 3.4205556 0.050000
+ 3.4208333 0.050000
+ 3.4211111 0.050000
+ 3.4213889 0.050000
+ 3.4216667 0.050000
+ 3.4219444 0.050000
+ 3.4222222 0.050000
+ 3.4225000 0.088954
+ 3.4227778 0.134789
+ 3.4230556 0.185093
+ 3.4233333 0.237452
+ 3.4236111 0.289457
+ 3.4238889 0.338694
+ 3.4241667 0.382751
+ 3.4244444 0.419217
+ 3.4247222 0.445679
+ 3.4250000 0.459725
+ 3.4252778 0.459681
+ 3.4255556 0.446816
+ 3.4258333 0.423139
+ 3.4261111 0.390656
+ 3.4263889 0.351374
+ 3.4266667 0.307302
+ 3.4269444 0.260446
+ 3.4272222 0.212814
+ 3.4275000 0.166412
+ 3.4277778 0.123249
+ 3.4280556 0.085071
+ 3.4283333 0.052577
+ 3.4286111 0.050000
+ 3.4288889 0.050000
+ 3.4291667 0.050000
+ 3.4294444 0.050000
+ 3.4297222 0.050000
+ 3.4300000 0.050000
+ 3.4302778 0.050000
+ 3.4305556 0.050000
+ 3.4308333 0.087958
+ 3.4311111 0.133108
+ 3.4313889 0.183005
+ 3.4316667 0.235201
+ 3.4319444 0.287251
+ 3.4322222 0.336709
+ 3.4325000 0.381127
+ 3.4327778 0.418060
+ 3.4330556 0.445062
+ 3.4333333 0.459686
+ 3.4336111 0.460226
+ 3.4338889 0.447933
+ 3.4341667 0.424800
+ 3.4344444 0.392817
+ 3.4347222 0.353975
+ 3.4350000 0.310267
+ 3.4352778 0.263684
+ 3.4355556 0.216217
+ 3.4358333 0.169857
+ 3.4361111 0.126597
+ 3.4363889 0.088174
+ 3.4366667 0.055319
+ 3.4369444 0.050000
+ 3.4372222 0.050000
+ 3.4375000 0.050000
+ 3.4377778 0.050000
+ 3.4380556 0.050000
+ 3.4383333 0.050000
+ 3.4386111 0.050000
+ 3.4388889 0.050000
+ 3.4391667 0.088169
+ 3.4394444 0.133672
+ 3.4397222 0.183993
+ 3.4400000 0.236614
+ 3.4402778 0.289019
+ 3.4405556 0.338692
+ 3.4408333 0.383114
+ 3.4411111 0.419769
+ 3.4413889 0.446141
+ 3.4416667 0.459712
+ 3.4419444 0.458738
+ 3.4422222 0.444563
+ 3.4425000 0.419302
+ 3.4427778 0.385073
+ 3.4430556 0.343991
+ 3.4433333 0.298173
+ 3.4436111 0.249734
+ 3.4438889 0.200791
+ 3.4441667 0.153461
+ 3.4444444 0.109859
+ 3.4447222 0.071808
+ 3.4450000 0.050000
+ 3.4452778 0.050000
+ 3.4455556 0.050000
+ 3.4458333 0.050000
+ 3.4461111 0.050000
+ 3.4463889 0.050000
+ 3.4466667 0.050000
+ 3.4469444 0.050000
+ 3.4472222 0.050000
+ 3.4475000 0.089146
+ 3.4477778 0.135195
+ 3.4480556 0.185709
+ 3.4483333 0.238254
+ 3.4486111 0.290393
+ 3.4488889 0.339690
+ 3.4491667 0.383709
+ 3.4494444 0.420014
+ 3.4497222 0.446169
+ 3.4500000 0.459738
+ 3.4502778 0.459035
+ 3.4505556 0.445369
+ 3.4508333 0.420800
+ 3.4511111 0.387388
+ 3.4513889 0.347192
+ 3.4516667 0.302273
+ 3.4519444 0.254690
+ 3.4522222 0.206503
+ 3.4525000 0.159771
+ 3.4527778 0.116554
+ 3.4530556 0.078633
+ 3.4533333 0.050000
+ 3.4536111 0.050000
+ 3.4538889 0.050000
+ 3.4541667 0.050000
+ 3.4544444 0.050000
+ 3.4547222 0.050000
+ 3.4550000 0.050000
+ 3.4552778 0.050000
+ 3.4555556 0.051618
+ 3.4558333 0.090113
+ 3.4561111 0.135597
+ 3.4563889 0.185643
+ 3.4566667 0.237822
+ 3.4569444 0.289706
+ 3.4572222 0.338866
+ 3.4575000 0.382876
+ 3.4577778 0.419305
+ 3.4580556 0.445727
+ 3.4583333 0.459712
+ 3.4586111 0.459575
+ 3.4588889 0.446597
+ 3.4591667 0.422801
+ 3.4594444 0.390209
+ 3.4597222 0.350845
+ 3.4600000 0.306732
+ 3.4602778 0.259893
+ 3.4605556 0.212351
+ 3.4608333 0.166129
+ 3.4611111 0.123249
+ 3.4613889 0.085468
+ 3.4616667 0.053465
+ 3.4619444 0.050000
+ 3.4622222 0.050000
+ 3.4625000 0.050000
+ 3.4627778 0.050000
+ 3.4630556 0.050000
+ 3.4633333 0.050000
+ 3.4636111 0.050000
+ 3.4638889 0.055044
+ 3.4641667 0.093160
+ 3.4644444 0.138324
+ 3.4647222 0.188090
+ 3.4650000 0.240011
+ 3.4652778 0.291640
+ 3.4655556 0.340531
+ 3.4658333 0.384235
+ 3.4661111 0.420307
+ 3.4663889 0.446299
+ 3.4666667 0.459765
+ 3.4669444 0.459006
+ 3.4672222 0.445324
+ 3.4675000 0.420767
+ 3.4677778 0.387385
+ 3.4680556 0.347229
+ 3.4683333 0.302347
+ 3.4686111 0.254788
+ 3.4688889 0.206604
+ 3.4691667 0.159843
+ 3.4694444 0.116554
+ 3.4697222 0.078513
+ 3.4700000 0.050000
+ 3.4702778 0.050000
+ 3.4705556 0.050000
+ 3.4708333 0.050000
+ 3.4711111 0.050000
+ 3.4713889 0.050000
+ 3.4716667 0.050000
+ 3.4719444 0.050000
+ 3.4722222 0.050000
+ 3.4725000 0.088494
+ 3.4727778 0.134036
+ 3.4730556 0.184188
+ 3.4733333 0.236516
+ 3.4736111 0.288582
+ 3.4738889 0.337952
+ 3.4741667 0.382188
+ 3.4744444 0.418855
+ 3.4747222 0.445517
+ 3.4750000 0.459738
+ 3.4752778 0.459824
+ 3.4755556 0.447045
+ 3.4758333 0.423415
+ 3.4761111 0.390946
+ 3.4763889 0.351652
+ 3.4766667 0.307545
+ 3.4769444 0.260638
+ 3.4772222 0.212945
+ 3.4775000 0.166478
+ 3.4777778 0.123249
+ 3.4780556 0.085011
+ 3.4783333 0.052466
+ 3.4786111 0.050000
+ 3.4788889 0.050000
+ 3.4791667 0.050000
+ 3.4794444 0.050000
+ 3.4797222 0.050000
+ 3.4800000 0.050000
+ 3.4802778 0.050000
+ 3.4805556 0.050000
+ 3.4808333 0.088063
+ 3.4811111 0.133330
+ 3.4813889 0.183343
+ 3.4816667 0.235641
+ 3.4819444 0.287766
+ 3.4822222 0.337258
+ 3.4825000 0.381658
+ 3.4827778 0.418507
+ 3.4830556 0.445345
+ 3.4833333 0.459712
+ 3.4836111 0.459897
+ 3.4838889 0.447174
+ 3.4841667 0.423564
+ 3.4844444 0.391088
+ 3.4847222 0.351768
+ 3.4850000 0.307626
+ 3.4852778 0.260681
+ 3.4855556 0.212956
+ 3.4858333 0.166472
+ 3.4861111 0.123249
+ 3.4863889 0.085047
+ 3.4866667 0.052569
+ 3.4869444 0.050000
+ 3.4872222 0.050000
+ 3.4875000 0.050000
+ 3.4877778 0.050000
+ 3.4880556 0.050000
+ 3.4883333 0.050000
+ 3.4886111 0.050000
+ 3.4888889 0.051657
+ 3.4891667 0.090026
+ 3.4894444 0.135588
+ 3.4897222 0.185850
+ 3.4900000 0.238317
+ 3.4902778 0.290496
+ 3.4905556 0.339892
+ 3.4908333 0.384011
+ 3.4911111 0.420359
+ 3.4913889 0.446441
+ 3.4916667 0.459765
+ 3.4919444 0.458602
+ 3.4922222 0.444295
+ 3.4925000 0.418954
+ 3.4927778 0.384690
+ 3.4930556 0.343612
+ 3.4933333 0.297830
+ 3.4936111 0.249453
+ 3.4938889 0.200593
+ 3.4941667 0.153358
+ 3.4944444 0.109859
+ 3.4947222 0.071912
+ 3.4950000 0.050000
+ 3.4952778 0.050000
+ 3.4955556 0.050000
+ 3.4958333 0.050000
+ 3.4961111 0.050000
+ 3.4963889 0.050000
+ 3.4966667 0.050000
+ 3.4969444 0.050000
+ 3.4972222 0.050000
+ 3.4975000 0.088906
+ 3.4977778 0.134682
+ 3.4980556 0.184924
+ 3.4983333 0.237228
+ 3.4986111 0.289190
+ 3.4988889 0.338407
+ 3.4991667 0.382474
+ 3.4994444 0.418988
+ 3.4997222 0.445544
+ 3.5000000 0.459738
+ 3.5002778 0.459902
+ 3.5005556 0.447297
+ 3.5008333 0.423924
+ 3.5011111 0.391779
+ 3.5013889 0.352861
+ 3.5016667 0.309167
+ 3.5019444 0.262696
+ 3.5022222 0.215445
+ 3.5025000 0.169413
+ 3.5027778 0.126597
+ 3.5030556 0.088736
+ 3.5033333 0.056527
+ 3.5036111 0.050000
+ 3.5038889 0.050000
+ 3.5041667 0.050000
+ 3.5044444 0.050000
+ 3.5047222 0.050000
+ 3.5050000 0.050000
+ 3.5052778 0.050000
+ 3.5055556 0.054966
+ 3.5058333 0.092876
+ 3.5061111 0.137923
+ 3.5063889 0.187643
+ 3.5066667 0.239574
+ 3.5069444 0.291255
+ 3.5072222 0.340222
+ 3.5075000 0.384014
+ 3.5077778 0.420168
+ 3.5080556 0.446221
+ 3.5083333 0.459712
+ 3.5086111 0.458933
+ 3.5088889 0.445195
+ 3.5091667 0.420561
+ 3.5094444 0.387099
+ 3.5097222 0.346872
+ 3.5100000 0.301946
+ 3.5102778 0.254386
+ 3.5105556 0.206258
+ 3.5108333 0.159625
+ 3.5111111 0.116554
+ 3.5113889 0.078829
+ 3.5116667 0.050000
+ 3.5119444 0.050000
+ 3.5122222 0.050000
+ 3.5125000 0.050000
+ 3.5127778 0.050000
+ 3.5130556 0.050000
+ 3.5133333 0.050000
+ 3.5136111 0.050000
+ 3.5138889 0.054966
+ 3.5141667 0.093854
+ 3.5144444 0.139684
+ 3.5147222 0.189986
+ 3.5150000 0.242289
+ 3.5152778 0.294122
+ 3.5155556 0.343015
+ 3.5158333 0.386498
+ 3.5161111 0.422100
+ 3.5163889 0.447350
+ 3.5166667 0.459778
+ 3.5169444 0.457681
+ 3.5172222 0.442428
+ 3.5175000 0.416155
+ 3.5177778 0.381000
+ 3.5180556 0.339097
+ 3.5183333 0.292585
+ 3.5186111 0.243599
+ 3.5188889 0.194276
+ 3.5191667 0.146752
+ 3.5194444 0.103164
+ 3.5197222 0.065345
+ 3.5200000 0.050000
+ 3.5202778 0.050000
+ 3.5205556 0.050000
+ 3.5208333 0.050000
+ 3.5211111 0.050000
+ 3.5213889 0.050000
+ 3.5216667 0.050000
+ 3.5219444 0.050000
+ 3.5222222 0.050000
+ 3.5225000 0.089703
+ 3.5227778 0.136182
+ 3.5230556 0.187001
+ 3.5233333 0.239726
+ 3.5236111 0.291921
+ 3.5238889 0.341152
+ 3.5241667 0.384984
+ 3.5244444 0.420982
+ 3.5247222 0.446712
+ 3.5250000 0.459738
+ 3.5252778 0.458381
+ 3.5255556 0.443975
+ 3.5258333 0.418612
+ 3.5261111 0.384382
+ 3.5263889 0.343376
+ 3.5266667 0.297683
+ 3.5269444 0.249395
+ 3.5272222 0.200601
+ 3.5275000 0.153392
+ 3.5277778 0.109859
+ 3.5280556 0.071806
+ 3.5283333 0.050000
+ 3.5286111 0.050000
+ 3.5288889 0.050000
+ 3.5291667 0.050000
+ 3.5294444 0.050000
+ 3.5297222 0.050000
+ 3.5300000 0.050000
+ 3.5302778 0.050000
+ 3.5305556 0.050000
+ 3.5308333 0.089531
+ 3.5311111 0.136040
+ 3.5313889 0.187031
+ 3.5316667 0.240008
+ 3.5319444 0.292472
+ 3.5322222 0.341927
+ 3.5325000 0.385877
+ 3.5327778 0.421825
+ 3.5330556 0.447273
+ 3.5333333 0.459725
+ 3.5336111 0.457464
+ 3.5338889 0.441891
+ 3.5341667 0.415188
+ 3.5344444 0.379534
+ 3.5347222 0.337112
+ 3.5350000 0.290103
+ 3.5352778 0.240688
+ 3.5355556 0.191048
+ 3.5358333 0.143364
+ 3.5361111 0.099817
+ 3.5363889 0.062272
+ 3.5366667 0.050000
+ 3.5369444 0.050000
+ 3.5372222 0.050000
+ 3.5375000 0.050000
+ 3.5377778 0.050000
+ 3.5380556 0.050000
+ 3.5383333 0.050000
+ 3.5386111 0.050000
+ 3.5388889 0.054913
+ 3.5391667 0.095497
+ 3.5394444 0.142708
+ 3.5397222 0.194052
+ 3.5400000 0.247036
+ 3.5402778 0.299167
+ 3.5405556 0.347952
+ 3.5408333 0.390897
+ 3.5411111 0.425510
+ 3.5413889 0.449297
+ 3.5416667 0.459765
+ 3.5419444 0.455216
+ 3.5422222 0.437141
+ 3.5425000 0.407823
+ 3.5427778 0.369547
+ 3.5430556 0.324598
+ 3.5433333 0.275261
+ 3.5436111 0.223821
+ 3.5438889 0.172563
+ 3.5441667 0.123772
+ 3.5444444 0.079732
+ 3.5447222 0.050000
+ 3.5450000 0.050000
+ 3.5452778 0.050000
+ 3.5455556 0.050000
+ 3.5458333 0.050000
+ 3.5461111 0.050000
+ 3.5463889 0.050000
+ 3.5466667 0.050000
+ 3.5469444 0.050000
+ 3.5472222 0.051474
+ 3.5475000 0.093596
+ 3.5477778 0.142019
+ 3.5480556 0.194274
+ 3.5483333 0.247890
+ 3.5486111 0.300395
+ 3.5488889 0.349319
+ 3.5491667 0.392190
+ 3.5494444 0.426537
+ 3.5497222 0.449890
+ 3.5500000 0.459778
+ 3.5502778 0.454527
+ 3.5505556 0.435661
+ 3.5508333 0.405499
+ 3.5511111 0.366363
+ 3.5513889 0.320573
+ 3.5516667 0.270450
+ 3.5519444 0.218314
+ 3.5522222 0.166486
+ 3.5525000 0.117287
+ 3.5527778 0.073037
+ 3.5530556 0.050000
+ 3.5533333 0.050000
+ 3.5536111 0.050000
+ 3.5538889 0.050000
+ 3.5541667 0.050000
+ 3.5544444 0.050000
+ 3.5547222 0.050000
+ 3.5550000 0.050000
+ 3.5552778 0.050000
+ 3.5555556 0.051383
+ 3.5558333 0.094500
+ 3.5561111 0.143850
+ 3.5563889 0.196907
+ 3.5566667 0.251141
+ 3.5569444 0.304026
+ 3.5572222 0.353031
+ 3.5575000 0.395631
+ 3.5577778 0.429296
+ 3.5580556 0.451500
+ 3.5583333 0.459712
+ 3.5586111 0.452241
+ 3.5588889 0.430725
+ 3.5591667 0.397641
+ 3.5594444 0.355463
+ 3.5597222 0.306665
+ 3.5600000 0.253722
+ 3.5602778 0.199110
+ 3.5605556 0.145302
+ 3.5608333 0.094774
+ 3.5611111 0.050000
+ 3.5613889 0.050000
+ 3.5616667 0.050000
+ 3.5619444 0.050000
+ 3.5622222 0.050000
+ 3.5625000 0.050000
+ 3.5627778 0.050000
+ 3.5630556 0.050000
+ 3.5633333 0.050000
+ 3.5636111 0.050000
+ 3.5638889 0.050000
+ 3.5641667 0.094682
+ 3.5644444 0.145093
+ 3.5647222 0.198774
+ 3.5650000 0.253269
+ 3.5652778 0.306121
+ 3.5655556 0.354872
+ 3.5658333 0.397065
+ 3.5661111 0.430243
+ 3.5663889 0.451949
+ 3.5666667 0.459725
+ 3.5669444 0.451935
+ 3.5672222 0.430215
+ 3.5675000 0.397025
+ 3.5677778 0.354823
+ 3.5680556 0.306066
+ 3.5683333 0.253213
+ 3.5686111 0.198722
+ 3.5688889 0.145051
+ 3.5691667 0.094657
+ 3.5694444 0.050000
+ 3.5697222 0.050000
+ 3.5700000 0.050000
+ 3.5702778 0.050000
+ 3.5705556 0.050000
+ 3.5708333 0.050000
+ 3.5711111 0.050000
+ 3.5713889 0.050000
+ 3.5716667 0.050000
+ 3.5719444 0.050000
+ 3.5722222 0.050000
+ 3.5725000 0.094657
+ 3.5727778 0.145050
+ 3.5730556 0.198721
+ 3.5733333 0.253211
+ 3.5736111 0.306063
+ 3.5738889 0.354817
+ 3.5741667 0.397016
+ 3.5744444 0.430201
+ 3.5747222 0.451915
+ 3.5750000 0.459699
+ 3.5752778 0.451915
+ 3.5755556 0.430200
+ 3.5758333 0.397014
+ 3.5761111 0.354815
+ 3.5763889 0.306060
+ 3.5766667 0.253209
+ 3.5769444 0.198719
+ 3.5772222 0.145049
+ 3.5775000 0.094656
+ 3.5777778 0.050000
+ 3.5780556 0.050000
+ 3.5783333 0.050000
+ 3.5786111 0.050000
+ 3.5788889 0.050000
+ 3.5791667 0.050000
+ 3.5794444 0.050000
+ 3.5797222 0.050000
+ 3.5800000 0.050000
+ 3.5802778 0.050000
+ 3.5805556 0.050000
+ 3.5808333 0.094652
+ 3.5811111 0.145039
+ 3.5813889 0.198703
+ 3.5816667 0.253185
+ 3.5819444 0.306029
+ 3.5822222 0.354777
+ 3.5825000 0.396970
+ 3.5827778 0.430152
+ 3.5830556 0.451863
+ 3.5833333 0.459647
+ 3.5836111 0.451865
+ 3.5838889 0.430155
+ 3.5841667 0.396975
+ 3.5844444 0.354782
+ 3.5847222 0.306035
+ 3.5850000 0.253192
+ 3.5852778 0.198708
+ 3.5855556 0.145044
+ 3.5858333 0.094655
+ 3.5861111 0.050000
+ 3.5863889 0.050000
+ 3.5866667 0.050000
+ 3.5869444 0.050000
+ 3.5872222 0.050000
+ 3.5875000 0.050000
+ 3.5877778 0.050000
+ 3.5880556 0.050000
+ 3.5883333 0.050000
+ 3.5886111 0.050000
+ 3.5888889 0.050000
+ 3.5891667 0.094669
+ 3.5894444 0.145077
+ 3.5897222 0.198763
+ 3.5900000 0.253267
+ 3.5902778 0.306129
+ 3.5905556 0.354889
+ 3.5908333 0.397088
+ 3.5911111 0.430264
+ 3.5913889 0.451959
+ 3.5916667 0.459712
+ 3.5919444 0.451884
+ 3.5922222 0.430119
+ 3.5925000 0.396880
+ 3.5927778 0.354634
+ 3.5930556 0.305844
+ 3.5933333 0.252975
+ 3.5936111 0.198491
+ 3.5938889 0.144858
+ 3.5941667 0.094539
+ 3.5944444 0.050000
+ 3.5947222 0.050000
+ 3.5950000 0.050000
+ 3.5952778 0.050000
+ 3.5955556 0.050000
+ 3.5958333 0.050000
+ 3.5961111 0.050000
+ 3.5963889 0.050000
+ 3.5966667 0.050000
+ 3.5969444 0.050000
+ 3.5972222 0.050000
+ 3.5975000 0.094047
+ 3.5977778 0.143732
+ 3.5980556 0.196685
+ 3.5983333 0.250535
+ 3.5986111 0.302912
+ 3.5988889 0.351444
+ 3.5991667 0.393760
+ 3.5994444 0.427491
+ 3.5997222 0.450266
+ 3.6000000 0.459712
+ 3.6002778 0.454241
+ 3.6005556 0.435382
+ 3.6008333 0.405444
+ 3.6011111 0.366738
+ 3.6013889 0.321575
+ 3.6016667 0.272262
+ 3.6019444 0.221112
+ 3.6022222 0.170434
+ 3.6025000 0.122537
+ 3.6027778 0.079732
+ 3.6030556 0.050000
+ 3.6033333 0.050000
+ 3.6036111 0.050000
+ 3.6038889 0.050000
+ 3.6041667 0.050000
+ 3.6044444 0.050000
+ 3.6047222 0.050000
+ 3.6050000 0.050000
+ 3.6052778 0.050000
+ 3.6055556 0.064890
+ 3.6058333 0.106027
+ 3.6061111 0.152881
+ 3.6063889 0.203173
+ 3.6066667 0.254620
+ 3.6069444 0.304941
+ 3.6072222 0.351855
+ 3.6075000 0.393081
+ 3.6077778 0.426338
+ 3.6080556 0.449343
+ 3.6083333 0.459817
+ 3.6086111 0.456217
+ 3.6088889 0.439961
+ 3.6091667 0.413207
+ 3.6094444 0.378112
+ 3.6097222 0.336834
+ 3.6100000 0.291530
+ 3.6102778 0.244358
+ 3.6105556 0.197475
+ 3.6108333 0.153039
+ 3.6111111 0.113207
+ 3.6113889 0.079789
+ 3.6116667 0.053205
+ 3.6119444 0.050000
+ 3.6122222 0.050000
+ 3.6125000 0.050000
+ 3.6127778 0.050000
+ 3.6130556 0.050000
+ 3.6133333 0.050000
+ 3.6136111 0.064529
+ 3.6138889 0.095214
+ 3.6141667 0.133017
+ 3.6144444 0.176181
+ 3.6147222 0.222585
+ 3.6150000 0.270108
+ 3.6152778 0.316627
+ 3.6155556 0.360022
+ 3.6158333 0.398170
+ 3.6161111 0.428951
+ 3.6163889 0.450242
+ 3.6166667 0.459922
+ 3.6169444 0.456551
+ 3.6172222 0.441417
+ 3.6175000 0.416490
+ 3.6177778 0.383741
+ 3.6180556 0.345140
+ 3.6183333 0.302655
+ 3.6186111 0.258258
+ 3.6188889 0.213919
+ 3.6191667 0.171607
+ 3.6194444 0.133292
+ 3.6197222 0.100643
+ 3.6200000 0.074123
+ 3.6202778 0.053893
+ 3.6205556 0.050000
+ 3.6208333 0.050000
+ 3.6211111 0.050000
+ 3.6213889 0.050000
+ 3.6216667 0.052730
+ 3.6219444 0.073624
+ 3.6222222 0.101935
+ 3.6225000 0.137457
+ 3.6227778 0.178509
+ 3.6230556 0.223039
+ 3.6233333 0.268998
+ 3.6236111 0.314335
+ 3.6238889 0.357001
+ 3.6241667 0.394946
+ 3.6244444 0.426118
+ 3.6247222 0.448469
+ 3.6250000 0.459948
+ 3.6252778 0.459142
+ 3.6255556 0.447190
+ 3.6258333 0.425867
+ 3.6261111 0.396950
+ 3.6263889 0.362215
+ 3.6266667 0.323437
+ 3.6269444 0.282393
+ 3.6272222 0.240858
+ 3.6275000 0.200608
+ 3.6277778 0.163419
+ 3.6280556 0.130826
+ 3.6283333 0.103394
+ 3.6286111 0.081448
+ 3.6288889 0.065313
+ 3.6291667 0.055312
+ 3.6294444 0.051770
+ 3.6297222 0.055012
+ 3.6300000 0.065362
+ 3.6302778 0.083144
+ 3.6305556 0.108683
+ 3.6308333 0.141900
+ 3.6311111 0.181111
+ 3.6313889 0.224226
+ 3.6316667 0.269158
+ 3.6319444 0.313819
+ 3.6322222 0.356119
+ 3.6325000 0.393972
+ 3.6327778 0.425289
+ 3.6330556 0.447981
+ 3.6333333 0.459961
+ 3.6336111 0.459782
+ 3.6338889 0.448569
+ 3.6341667 0.428086
+ 3.6344444 0.400099
+ 3.6347222 0.366373
+ 3.6350000 0.328675
+ 3.6352778 0.288769
+ 3.6355556 0.248421
+ 3.6358333 0.209397
+ 3.6361111 0.173462
+ 3.6363889 0.142135
+ 3.6366667 0.115946
+ 3.6369444 0.095181
+ 3.6372222 0.080123
+ 3.6375000 0.071056
+ 3.6377778 0.068265
+ 3.6380556 0.072033
+ 3.6383333 0.082645
+ 3.6386111 0.100386
+ 3.6388889 0.125538
+ 3.6391667 0.157999
+ 3.6394444 0.196118
+ 3.6397222 0.237854
+ 3.6400000 0.281169
+ 3.6402778 0.324024
+ 3.6405556 0.364380
+ 3.6408333 0.400197
+ 3.6411111 0.429437
+ 3.6413889 0.450059
+ 3.6416667 0.460026
+ 3.6419444 0.457936
+ 3.6422222 0.444943
+ 3.6425000 0.422837
+ 3.6427778 0.393410
+ 3.6430556 0.358453
+ 3.6433333 0.319757
+ 3.6436111 0.279115
+ 3.6438889 0.238317
+ 3.6441667 0.199155
+ 3.6444444 0.163419
+ 3.6447222 0.132639
+ 3.6450000 0.107289
+ 3.6452778 0.087583
+ 3.6455556 0.073731
+ 3.6458333 0.065947
+ 3.6461111 0.064443
+ 3.6463889 0.069431
+ 3.6466667 0.081124
+ 3.6469444 0.099734
+ 3.6472222 0.125472
+ 3.6475000 0.158191
+ 3.6477778 0.196294
+ 3.6480556 0.237824
+ 3.6483333 0.280823
+ 3.6486111 0.323334
+ 3.6488889 0.363400
+ 3.6491667 0.399064
+ 3.6494444 0.428367
+ 3.6497222 0.449354
+ 3.6500000 0.460065
+ 3.6502778 0.459150
+ 3.6505556 0.447678
+ 3.6508333 0.427324
+ 3.6511111 0.399761
+ 3.6513889 0.366666
+ 3.6516667 0.329712
+ 3.6519444 0.290575
+ 3.6522222 0.250929
+ 3.6525000 0.212449
+ 3.6527778 0.176809
+ 3.6530556 0.145462
+ 3.6533333 0.118968
+ 3.6536111 0.097663
+ 3.6538889 0.081885
+ 3.6541667 0.071970
+ 3.6544444 0.068256
+ 3.6547222 0.071080
+ 3.6550000 0.080780
+ 3.6552778 0.097691
+ 3.6555556 0.122151
+ 3.6558333 0.154101
+ 3.6561111 0.191898
+ 3.6563889 0.233502
+ 3.6566667 0.276873
+ 3.6569444 0.319972
+ 3.6572222 0.360758
+ 3.6575000 0.397192
+ 3.6577778 0.427235
+ 3.6580556 0.448846
+ 3.6583333 0.459987
+ 3.6586111 0.459243
+ 3.6588889 0.447710
+ 3.6591667 0.427107
+ 3.6594444 0.399154
+ 3.6597222 0.365574
+ 3.6600000 0.328085
+ 3.6602778 0.288409
+ 3.6605556 0.248266
+ 3.6608333 0.209377
+ 3.6611111 0.173462
+ 3.6613889 0.142007
+ 3.6616667 0.115563
+ 3.6619444 0.094443
+ 3.6622222 0.078963
+ 3.6625000 0.069437
+ 3.6627778 0.066181
+ 3.6630556 0.069509
+ 3.6633333 0.079737
+ 3.6636111 0.097179
+ 3.6638889 0.122151
+ 3.6641667 0.154572
+ 3.6644444 0.192780
+ 3.6647222 0.234720
+ 3.6650000 0.278335
+ 3.6652778 0.321568
+ 3.6655556 0.362362
+ 3.6658333 0.398662
+ 3.6661111 0.428410
+ 3.6663889 0.449550
+ 3.6666667 0.460026
+ 3.6669444 0.458418
+ 3.6672222 0.445859
+ 3.6675000 0.424117
+ 3.6677778 0.394961
+ 3.6680556 0.360161
+ 3.6683333 0.321486
+ 3.6686111 0.280705
+ 3.6688889 0.239588
+ 3.6691667 0.199903
+ 3.6694444 0.163419
+ 3.6697222 0.131658
+ 3.6700000 0.105146
+ 3.6702778 0.084161
+ 3.6705556 0.068982
+ 3.6708333 0.059886
+ 3.6711111 0.057151
+ 3.6713889 0.061056
+ 3.6716667 0.071879
+ 3.6719444 0.089898
+ 3.6722222 0.115391
+ 3.6725000 0.148253
+ 3.6727778 0.186851
+ 3.6730556 0.229167
+ 3.6733333 0.273184
+ 3.6736111 0.316885
+ 3.6738889 0.358253
+ 3.6741667 0.395271
+ 3.6744444 0.425921
+ 3.6747222 0.448187
+ 3.6750000 0.460052
+ 3.6752778 0.460116
+ 3.6755556 0.449448
+ 3.6758333 0.429735
+ 3.6761111 0.402663
+ 3.6763889 0.369919
+ 3.6766667 0.333191
+ 3.6769444 0.294163
+ 3.6772222 0.254524
+ 3.6775000 0.215960
+ 3.6777778 0.180157
+ 3.6780556 0.148579
+ 3.6783333 0.121799
+ 3.6786111 0.100164
+ 3.6788889 0.084026
+ 3.6791667 0.073731
+ 3.6794444 0.069631
+ 3.6797222 0.072074
+ 3.6800000 0.081409
+ 3.6802778 0.097985
+ 3.6805556 0.122151
+ 3.6808333 0.153859
+ 3.6811111 0.191467
+ 3.6813889 0.232935
+ 3.6816667 0.276223
+ 3.6819444 0.319293
+ 3.6822222 0.360105
+ 3.6825000 0.396618
+ 3.6827778 0.426794
+ 3.6830556 0.448592
+ 3.6833333 0.459974
+ 3.6836111 0.459520
+ 3.6838889 0.448298
+ 3.6841667 0.427997
+ 3.6844444 0.400303
+ 3.6847222 0.366907
+ 3.6850000 0.329495
+ 3.6852778 0.289756
+ 3.6855556 0.249379
+ 3.6858333 0.210051
+ 3.6861111 0.173462
+ 3.6863889 0.141081
+ 3.6866667 0.113510
+ 3.6869444 0.091132
+ 3.6872222 0.074331
+ 3.6875000 0.063490
+ 3.6877778 0.058993
+ 3.6880556 0.061223
+ 3.6883333 0.070563
+ 3.6886111 0.087397
+ 3.6888889 0.112109
+ 3.6891667 0.144664
+ 3.6894444 0.183363
+ 3.6897222 0.226087
+ 3.6900000 0.270720
+ 3.6902778 0.315142
+ 3.6905556 0.357237
+ 3.6908333 0.394886
+ 3.6911111 0.425973
+ 3.6913889 0.448379
+ 3.6916667 0.459987
+ 3.6919444 0.459326
+ 3.6922222 0.447514
+ 3.6925000 0.426317
+ 3.6927778 0.397499
+ 3.6930556 0.362827
+ 3.6933333 0.324064
+ 3.6936111 0.282977
+ 3.6938889 0.241330
+ 3.6941667 0.200889
+ 3.6944444 0.163419
+ 3.6947222 0.130451
+ 3.6950000 0.102572
+ 3.6952778 0.080139
+ 3.6955556 0.063506
+ 3.6958333 0.053026
+ 3.6961111 0.050000
+ 3.6963889 0.051948
+ 3.6966667 0.062058
+ 3.6969444 0.079740
+ 3.6972222 0.105348
+ 3.6975000 0.138822
+ 3.6977778 0.178439
+ 3.6980556 0.222062
+ 3.6983333 0.267552
+ 3.6986111 0.312771
+ 3.6988889 0.355583
+ 3.6991667 0.393848
+ 3.6994444 0.425429
+ 3.6997222 0.448188
+ 3.7000000 0.459987
+ 3.7002778 0.459344
+ 3.7005556 0.447396
+ 3.7008333 0.425938
+ 3.7011111 0.396762
+ 3.7013889 0.361663
+ 3.7016667 0.322432
+ 3.7019444 0.280864
+ 3.7022222 0.238753
+ 3.7025000 0.197891
+ 3.7027778 0.160072
+ 3.7030556 0.126847
+ 3.7033333 0.098802
+ 3.7036111 0.076279
+ 3.7038889 0.059620
+ 3.7041667 0.050000
+ 3.7044444 0.050000
+ 3.7047222 0.050000
+ 3.7050000 0.058490
+ 3.7052778 0.076298
+ 3.7055556 0.102027
+ 3.7058333 0.135610
+ 3.7061111 0.175337
+ 3.7063889 0.219089
+ 3.7066667 0.264745
+ 3.7069444 0.310184
+ 3.7072222 0.353288
+ 3.7075000 0.391934
+ 3.7077778 0.424005
+ 3.7080556 0.447378
+ 3.7083333 0.459935
+ 3.7086111 0.460197
+ 3.7088889 0.449257
+ 3.7091667 0.428852
+ 3.7094444 0.400717
+ 3.7097222 0.366587
+ 3.7100000 0.328199
+ 3.7102778 0.287287
+ 3.7105556 0.245587
+ 3.7108333 0.204835
+ 3.7111111 0.166767
+ 3.7113889 0.132901
+ 3.7116667 0.103889
+ 3.7119444 0.080166
+ 3.7122222 0.062165
+ 3.7125000 0.050322
+ 3.7127778 0.050000
+ 3.7130556 0.050000
+ 3.7133333 0.056083
+ 3.7136111 0.073216
+ 3.7138889 0.098679
+ 3.7141667 0.132460
+ 3.7144444 0.172758
+ 3.7147222 0.217324
+ 3.7150000 0.263911
+ 3.7152778 0.310269
+ 3.7155556 0.354151
+ 3.7158333 0.393308
+ 3.7161111 0.425492
+ 3.7163889 0.448455
+ 3.7166667 0.459948
+ 3.7169444 0.458417
+ 3.7172222 0.445083
+ 3.7175000 0.421862
+ 3.7177778 0.390668
+ 3.7180556 0.353418
+ 3.7183333 0.312024
+ 3.7186111 0.268405
+ 3.7188889 0.224473
+ 3.7191667 0.182144
+ 3.7194444 0.143334
+ 3.7197222 0.109683
+ 3.7200000 0.081732
+ 3.7202778 0.059746
+ 3.7205556 0.050000
+ 3.7208333 0.050000
+ 3.7211111 0.050000
+ 3.7213889 0.050000
+ 3.7216667 0.050000
+ 3.7219444 0.068015
+ 3.7222222 0.095240
+ 3.7225000 0.130163
+ 3.7227778 0.171067
+ 3.7230556 0.215837
+ 3.7233333 0.262360
+ 3.7236111 0.308522
+ 3.7238889 0.352209
+ 3.7241667 0.391308
+ 3.7244444 0.423705
+ 3.7247222 0.447285
+ 3.7250000 0.459935
+ 3.7252778 0.460184
+ 3.7255556 0.449135
+ 3.7258333 0.428532
+ 3.7261111 0.400121
+ 3.7263889 0.365647
+ 3.7266667 0.326856
+ 3.7269444 0.285492
+ 3.7272222 0.243301
+ 3.7275000 0.202029
+ 3.7277778 0.163419
+ 3.7280556 0.129003
+ 3.7283333 0.099446
+ 3.7286111 0.075198
+ 3.7288889 0.056709
+ 3.7291667 0.050000
+ 3.7294444 0.050000
+ 3.7297222 0.050000
+ 3.7300000 0.050000
+ 3.7302778 0.066411
+ 3.7305556 0.091932
+ 3.7308333 0.125912
+ 3.7311111 0.166544
+ 3.7313889 0.211568
+ 3.7316667 0.258724
+ 3.7319444 0.305754
+ 3.7322222 0.350397
+ 3.7325000 0.390395
+ 3.7327778 0.423488
+ 3.7330556 0.447417
+ 3.7333333 0.459922
+ 3.7336111 0.459434
+ 3.7338889 0.447146
+ 3.7341667 0.424942
+ 3.7344444 0.394704
+ 3.7347222 0.358316
+ 3.7350000 0.317661
+ 3.7352778 0.274621
+ 3.7355556 0.231081
+ 3.7358333 0.188922
+ 3.7361111 0.150029
+ 3.7363889 0.116025
+ 3.7366667 0.087495
+ 3.7369444 0.064762
+ 3.7372222 0.050000
+ 3.7375000 0.050000
+ 3.7377778 0.050000
+ 3.7380556 0.050000
+ 3.7383333 0.050000
+ 3.7386111 0.068327
+ 3.7388889 0.095280
+ 3.7391667 0.130209
+ 3.7394444 0.171340
+ 3.7397222 0.216473
+ 3.7400000 0.263413
+ 3.7402778 0.309961
+ 3.7405556 0.353921
+ 3.7408333 0.393095
+ 3.7411111 0.425287
+ 3.7413889 0.448299
+ 3.7416667 0.459935
+ 3.7419444 0.458672
+ 3.7422222 0.445695
+ 3.7425000 0.422863
+ 3.7427778 0.392037
+ 3.7430556 0.355076
+ 3.7433333 0.313839
+ 3.7436111 0.270187
+ 3.7438889 0.225979
+ 3.7441667 0.183075
+ 3.7444444 0.143334
+ 3.7447222 0.108370
+ 3.7450000 0.078806
+ 3.7452778 0.055018
+ 3.7455556 0.050000
+ 3.7458333 0.050000
+ 3.7461111 0.050000
+ 3.7463889 0.050000
+ 3.7466667 0.050000
+ 3.7469444 0.054667
+ 3.7472222 0.081850
+ 3.7475000 0.117382
+ 3.7477778 0.159441
+ 3.7480556 0.205770
+ 3.7483333 0.254109
+ 3.7486111 0.302200
+ 3.7488889 0.347783
+ 3.7491667 0.388601
+ 3.7494444 0.422394
+ 3.7497222 0.446903
+ 3.7500000 0.459869
+ 3.7502778 0.459723
+ 3.7505556 0.447650
+ 3.7508333 0.425526
+ 3.7511111 0.395224
+ 3.7513889 0.358620
+ 3.7516667 0.317588
+ 3.7519444 0.274004
+ 3.7522222 0.229741
+ 3.7525000 0.186676
+ 3.7527778 0.146682
+ 3.7530556 0.111388
+ 3.7533333 0.081438
+ 3.7536111 0.057228
+ 3.7538889 0.050000
+ 3.7541667 0.050000
+ 3.7544444 0.050000
+ 3.7547222 0.050000
+ 3.7550000 0.050000
+ 3.7552778 0.054767
+ 3.7555556 0.081863
+ 3.7558333 0.117429
+ 3.7561111 0.159616
+ 3.7563889 0.206127
+ 3.7566667 0.254665
+ 3.7569444 0.302934
+ 3.7572222 0.348636
+ 3.7575000 0.389475
+ 3.7577778 0.423154
+ 3.7580556 0.447376
+ 3.7583333 0.459843
+ 3.7586111 0.458967
+ 3.7588889 0.445986
+ 3.7591667 0.422848
+ 3.7594444 0.391498
+ 3.7597222 0.353885
+ 3.7600000 0.311953
+ 3.7602778 0.267651
+ 3.7605556 0.222925
+ 3.7608333 0.179721
+ 3.7611111 0.139987
+ 3.7613889 0.105395
+ 3.7616667 0.076527
+ 3.7619444 0.053691
+ 3.7622222 0.050000
+ 3.7625000 0.050000
+ 3.7627778 0.050000
+ 3.7630556 0.050000
+ 3.7633333 0.050000
+ 3.7636111 0.060570
+ 3.7638889 0.088571
+ 3.7641667 0.124640
+ 3.7644444 0.166951
+ 3.7647222 0.213251
+ 3.7650000 0.261290
+ 3.7652778 0.308813
+ 3.7655556 0.353571
+ 3.7658333 0.393309
+ 3.7661111 0.425778
+ 3.7663889 0.448724
+ 3.7666667 0.459895
+ 3.7669444 0.457742
+ 3.7672222 0.443518
+ 3.7675000 0.419180
+ 3.7677778 0.386684
+ 3.7680556 0.347987
+ 3.7683333 0.305044
+ 3.7686111 0.259812
+ 3.7688889 0.214248
+ 3.7691667 0.170306
+ 3.7694444 0.129944
+ 3.7697222 0.094843
+ 3.7700000 0.065584
+ 3.7702778 0.050000
+ 3.7705556 0.050000
+ 3.7708333 0.050000
+ 3.7711111 0.050000
+ 3.7713889 0.050000
+ 3.7716667 0.050000
+ 3.7719444 0.050001
+ 3.7722222 0.078477
+ 3.7725000 0.115118
+ 3.7727778 0.158099
+ 3.7730556 0.205167
+ 3.7733333 0.254069
+ 3.7736111 0.302552
+ 3.7738889 0.348364
+ 3.7741667 0.389252
+ 3.7744444 0.422963
+ 3.7747222 0.447244
+ 3.7750000 0.459843
+ 3.7752778 0.459202
+ 3.7755556 0.446547
+ 3.7758333 0.423800
+ 3.7761111 0.392880
+ 3.7763889 0.355709
+ 3.7766667 0.314209
+ 3.7769444 0.270301
+ 3.7772222 0.225905
+ 3.7775000 0.182942
+ 3.7777778 0.143334
+ 3.7780556 0.108737
+ 3.7783333 0.079741
+ 3.7786111 0.056672
+ 3.7788889 0.050000
+ 3.7791667 0.050000
+ 3.7794444 0.050000
+ 3.7797222 0.050000
+ 3.7800000 0.050000
+ 3.7802778 0.060985
+ 3.7805556 0.088532
+ 3.7808333 0.124186
+ 3.7811111 0.166136
+ 3.7813889 0.212144
+ 3.7816667 0.259973
+ 3.7819444 0.307385
+ 3.7822222 0.352141
+ 3.7825000 0.392004
+ 3.7827778 0.424736
+ 3.7830556 0.448099
+ 3.7833333 0.459856
+ 3.7836111 0.458462
+ 3.7838889 0.445144
+ 3.7841667 0.421826
+ 3.7844444 0.390428
+ 3.7847222 0.352872
+ 3.7850000 0.311081
+ 3.7852778 0.266974
+ 3.7855556 0.222476
+ 3.7858333 0.179506
+ 3.7861111 0.139987
+ 3.7863889 0.105571
+ 3.7866667 0.076837
+ 3.7869444 0.054093
+ 3.7872222 0.050000
+ 3.7875000 0.050000
+ 3.7877778 0.050000
+ 3.7880556 0.050000
+ 3.7883333 0.050000
+ 3.7886111 0.060712
+ 3.7888889 0.088545
+ 3.7891667 0.124416
+ 3.7894444 0.166516
+ 3.7897222 0.212615
+ 3.7900000 0.260484
+ 3.7902778 0.307890
+ 3.7905556 0.352604
+ 3.7908333 0.392395
+ 3.7911111 0.425032
+ 3.7913889 0.448284
+ 3.7916667 0.459922
+ 3.7919444 0.458403
+ 3.7922222 0.444948
+ 3.7925000 0.421465
+ 3.7927778 0.389862
+ 3.7930556 0.352050
+ 3.7933333 0.309935
+ 3.7936111 0.265428
+ 3.7938889 0.220438
+ 3.7941667 0.176872
+ 3.7944444 0.136639
+ 3.7947222 0.101391
+ 3.7950000 0.071739
+ 3.7952778 0.050000
+ 3.7955556 0.050000
+ 3.7958333 0.050000
+ 3.7961111 0.050000
+ 3.7963889 0.050000
+ 3.7966667 0.050000
+ 3.7969444 0.050622
+ 3.7972222 0.078490
+ 3.7975000 0.114702
+ 3.7977778 0.157418
+ 3.7980556 0.204361
+ 3.7983333 0.253251
+ 3.7986111 0.301810
+ 3.7988889 0.347758
+ 3.7991667 0.388819
+ 3.7994444 0.422712
+ 3.7997222 0.447159
+ 3.8000000 0.459882
+ 3.8002778 0.459301
+ 3.8005556 0.446633
+ 3.8008333 0.423792
+ 3.8011111 0.392695
+ 3.8013889 0.355256
+ 3.8016667 0.313392
+ 3.8019444 0.269018
+ 3.8022222 0.224048
+ 3.8025000 0.180400
+ 3.8027778 0.139987
+ 3.8030556 0.104469
+ 3.8033333 0.074478
+ 3.8036111 0.050388
+ 3.8038889 0.050000
+ 3.8041667 0.050000
+ 3.8044444 0.050000
+ 3.8047222 0.050000
+ 3.8050000 0.050000
+ 3.8052778 0.050782
+ 3.8055556 0.078503
+ 3.8058333 0.114678
+ 3.8061111 0.157446
+ 3.8063889 0.204497
+ 3.8066667 0.253522
+ 3.8069444 0.302213
+ 3.8072222 0.348260
+ 3.8075000 0.389354
+ 3.8077778 0.423187
+ 3.8080556 0.447448
+ 3.8083333 0.459830
+ 3.8086111 0.458737
+ 3.8088889 0.445432
+ 3.8091667 0.421893
+ 3.8094444 0.390097
+ 3.8097222 0.352020
+ 3.8100000 0.309641
+ 3.8102778 0.264936
+ 3.8105556 0.219882
+ 3.8108333 0.176458
+ 3.8111111 0.136639
+ 3.8113889 0.102121
+ 3.8116667 0.073464
+ 3.8119444 0.050946
+ 3.8122222 0.050000
+ 3.8125000 0.050000
+ 3.8127778 0.050000
+ 3.8130556 0.050000
+ 3.8133333 0.050000
+ 3.8136111 0.060321
+ 3.8138889 0.088558
+ 3.8141667 0.124741
+ 3.8144444 0.167063
+ 3.8147222 0.213301
+ 3.8150000 0.261233
+ 3.8152778 0.308636
+ 3.8155556 0.353286
+ 3.8158333 0.392962
+ 3.8161111 0.425439
+ 3.8163889 0.448496
+ 3.8166667 0.459908
+ 3.8169444 0.458147
+ 3.8172222 0.444448
+ 3.8175000 0.420741
+ 3.8177778 0.388955
+ 3.8180556 0.351021
+ 3.8183333 0.308866
+ 3.8186111 0.264422
+ 3.8188889 0.219616
+ 3.8191667 0.176379
+ 3.8194444 0.136639
+ 3.8197222 0.102056
+ 3.8200000 0.073204
+ 3.8202778 0.050388
+ 3.8205556 0.050000
+ 3.8208333 0.050000
+ 3.8211111 0.050000
+ 3.8213889 0.050000
+ 3.8216667 0.050000
+ 3.8219444 0.057254
+ 3.8222222 0.085198
+ 3.8225000 0.121188
+ 3.8227778 0.163426
+ 3.8230556 0.209693
+ 3.8233333 0.257768
+ 3.8236111 0.305432
+ 3.8238889 0.350465
+ 3.8241667 0.390648
+ 3.8244444 0.423760
+ 3.8247222 0.447583
+ 3.8250000 0.459895
+ 3.8252778 0.459164
+ 3.8255556 0.446594
+ 3.8258333 0.424075
+ 3.8261111 0.393498
+ 3.8263889 0.356753
+ 3.8266667 0.315732
+ 3.8269444 0.272323
+ 3.8272222 0.228419
+ 3.8275000 0.185908
+ 3.8277778 0.146682
+ 3.8280556 0.112372
+ 3.8283333 0.083572
+ 3.8286111 0.060620
+ 3.8288889 0.050000
+ 3.8291667 0.050000
+ 3.8294444 0.050000
+ 3.8297222 0.050000
+ 3.8300000 0.050000
+ 3.8302778 0.064499
+ 3.8305556 0.091880
+ 3.8308333 0.127364
+ 3.8311111 0.169135
+ 3.8313889 0.214945
+ 3.8316667 0.262545
+ 3.8319444 0.309688
+ 3.8322222 0.354126
+ 3.8325000 0.393611
+ 3.8327778 0.425895
+ 3.8330556 0.448730
+ 3.8333333 0.459869
+ 3.8336111 0.457767
+ 3.8338889 0.443692
+ 3.8341667 0.419615
+ 3.8344444 0.387508
+ 3.8347222 0.349343
+ 3.8350000 0.307091
+ 3.8352778 0.262723
+ 3.8355556 0.218210
+ 3.8358333 0.175526
+ 3.8361111 0.136639
+ 3.8363889 0.103232
+ 3.8366667 0.075815
+ 3.8369444 0.054609
+ 3.8372222 0.050000
+ 3.8375000 0.050000
+ 3.8377778 0.050000
+ 3.8380556 0.050000
+ 3.8383333 0.050000
+ 3.8386111 0.070155
+ 3.8388889 0.098601
+ 3.8391667 0.134623
+ 3.8394444 0.176453
+ 3.8397222 0.221920
+ 3.8400000 0.268857
+ 3.8402778 0.315095
+ 3.8405556 0.358466
+ 3.8408333 0.396801
+ 3.8411111 0.427932
+ 3.8413889 0.449691
+ 3.8416667 0.459908
+ 3.8419444 0.457099
+ 3.8422222 0.442511
+ 3.8425000 0.418072
+ 3.8427778 0.385712
+ 3.8430556 0.347363
+ 3.8433333 0.304952
+ 3.8436111 0.260409
+ 3.8438889 0.215665
+ 3.8441667 0.172650
+ 3.8444444 0.133292
+ 3.8447222 0.099245
+ 3.8450000 0.071053
+ 3.8452778 0.050000
+ 3.8455556 0.050000
+ 3.8458333 0.050000
+ 3.8461111 0.050000
+ 3.8463889 0.050000
+ 3.8466667 0.050000
+ 3.8469444 0.060207
+ 3.8472222 0.088519
+ 3.8475000 0.124690
+ 3.8477778 0.166934
+ 3.8480556 0.213055
+ 3.8483333 0.260856
+ 3.8486111 0.308141
+ 3.8488889 0.352713
+ 3.8491667 0.392374
+ 3.8494444 0.424930
+ 3.8497222 0.448182
+ 3.8500000 0.459935
+ 3.8502778 0.458676
+ 3.8505556 0.445634
+ 3.8508333 0.422722
+ 3.8511111 0.391854
+ 3.8513889 0.354941
+ 3.8516667 0.313898
+ 3.8519444 0.270637
+ 3.8522222 0.227072
+ 3.8525000 0.185116
+ 3.8527778 0.146682
+ 3.8530556 0.113408
+ 3.8533333 0.085831
+ 3.8536111 0.064216
+ 3.8538889 0.050000
+ 3.8541667 0.050000
+ 3.8544444 0.050000
+ 3.8547222 0.050000
+ 3.8550000 0.054760
+ 3.8552778 0.074434
+ 3.8555556 0.101909
+ 3.8558333 0.137046
+ 3.8561111 0.178089
+ 3.8563889 0.222879
+ 3.8566667 0.269257
+ 3.8569444 0.315065
+ 3.8572222 0.358144
+ 3.8575000 0.396334
+ 3.8577778 0.427477
+ 3.8580556 0.449415
+ 3.8583333 0.459987
+ 3.8586111 0.457720
+ 3.8588889 0.443877
+ 3.8591667 0.420404
+ 3.8594444 0.389248
+ 3.8597222 0.352358
+ 3.8600000 0.311680
+ 3.8602778 0.269161
+ 3.8605556 0.226748
+ 3.8608333 0.186388
+ 3.8611111 0.150029
+ 3.8613889 0.119312
+ 3.8616667 0.094653
+ 3.8619444 0.076163
+ 3.8622222 0.063952
+ 3.8625000 0.058132
+ 3.8627778 0.058812
+ 3.8630556 0.066104
+ 3.8633333 0.080118
+ 3.8636111 0.100965
+ 3.8638889 0.128754
+ 3.8641667 0.163245
+ 3.8644444 0.202784
+ 3.8647222 0.245364
+ 3.8650000 0.288979
+ 3.8652778 0.331623
+ 3.8655556 0.371289
+ 3.8658333 0.405971
+ 3.8661111 0.433663
+ 3.8663889 0.452359
+ 3.8666667 0.460052
+ 3.8669444 0.455393
+ 3.8672222 0.439655
+ 3.8675000 0.414771
+ 3.8677778 0.382671
+ 3.8680556 0.345286
+ 3.8683333 0.304548
+ 3.8686111 0.262387
+ 3.8688889 0.220735
+ 3.8691667 0.181523
+ 3.8694444 0.146682
+ 3.8697222 0.117821
+ 3.8700000 0.095265
+ 3.8702778 0.079016
+ 3.8705556 0.069077
+ 3.8708333 0.065451
+ 3.8711111 0.068140
+ 3.8713889 0.077148
+ 3.8716667 0.092476
+ 3.8719444 0.114127
+ 3.8722222 0.142105
+ 3.8725000 0.176102
+ 3.8727778 0.214568
+ 3.8730556 0.255644
+ 3.8733333 0.297472
+ 3.8736111 0.338192
+ 3.8738889 0.375945
+ 3.8741667 0.408872
+ 3.8744444 0.435114
+ 3.8747222 0.452811
+ 3.8750000 0.460105
+ 3.8752778 0.455747
+ 3.8755556 0.440937
+ 3.8758333 0.417484
+ 3.8761111 0.387201
+ 3.8763889 0.351896
+ 3.8766667 0.313380
+ 3.8769444 0.273464
+ 3.8772222 0.233959
+ 3.8775000 0.196674
+ 3.8777778 0.163419
+ 3.8780556 0.135711
+ 3.8783333 0.113883
+ 3.8786111 0.097974
+ 3.8788889 0.088022
+ 3.8791667 0.084066
+ 3.8794444 0.086144
+ 3.8797222 0.094295
+ 3.8800000 0.108558
+ 3.8802778 0.128972
+ 3.8805556 0.155574
+ 3.8808333 0.188093
+ 3.8811111 0.225016
+ 3.8813889 0.264520
+ 3.8816667 0.304781
+ 3.8819444 0.343976
+ 3.8822222 0.380281
+ 3.8825000 0.411872
+ 3.8827778 0.436926
+ 3.8830556 0.453620
+ 3.8833333 0.460131
+ 3.8836111 0.455233
+ 3.8838889 0.440102
+ 3.8841667 0.416509
+ 3.8844444 0.386230
+ 3.8847222 0.351036
+ 3.8850000 0.312701
+ 3.8852778 0.272999
+ 3.8855556 0.233702
+ 3.8858333 0.196585
+ 3.8861111 0.163419
+ 3.8863889 0.135693
+ 3.8866667 0.113743
+ 3.8869444 0.097621
+ 3.8872222 0.087379
+ 3.8875000 0.083067
+ 3.8877778 0.084738
+ 3.8880556 0.092441
+ 3.8883333 0.106230
+ 3.8886111 0.126154
+ 3.8888889 0.152265
+ 3.8891667 0.184311
+ 3.8894444 0.220816
+ 3.8897222 0.260005
+ 3.8900000 0.300100
+ 3.8902778 0.339322
+ 3.8905556 0.375894
+ 3.8908333 0.408039
+ 3.8911111 0.433979
+ 3.8913889 0.451935
+ 3.8916667 0.460131
+ 3.8919444 0.457354
+ 3.8922222 0.444658
+ 3.8925000 0.423659
+ 3.8927778 0.395978
+ 3.8930556 0.363230
+ 3.8933333 0.327037
+ 3.8936111 0.289014
+ 3.8938889 0.250781
+ 3.8941667 0.213956
+ 3.8944444 0.180157
+ 3.8947222 0.150777
+ 3.8950000 0.126305
+ 3.8952778 0.107005
+ 3.8955556 0.093142
+ 3.8958333 0.084979
+ 3.8961111 0.082780
+ 3.8963889 0.086809
+ 3.8966667 0.097329
+ 3.8969444 0.114606
+ 3.8972222 0.138902
+ 3.8975000 0.170115
+ 3.8977778 0.206682
+ 3.8980556 0.246669
+ 3.8983333 0.288147
+ 3.8986111 0.329183
+ 3.8988889 0.367847
+ 3.8991667 0.402208
+ 3.8994444 0.430334
+ 3.8997222 0.450294
+ 3.9000000 0.460157
+ 3.9002778 0.458593
+ 3.9005556 0.446680
+ 3.9008333 0.426095
+ 3.9011111 0.398516
+ 3.9013889 0.365622
+ 3.9016667 0.329090
+ 3.9019444 0.290600
+ 3.9022222 0.251829
+ 3.9025000 0.214455
+ 3.9027778 0.180157
+ 3.9030556 0.150376
+ 3.9033333 0.125607
+ 3.9036111 0.106109
+ 3.9038889 0.092140
+ 3.9041667 0.083958
+ 3.9044444 0.081822
+ 3.9047222 0.085990
+ 3.9050000 0.096720
+ 3.9052778 0.114271
+ 3.9055556 0.138902
+ 3.9058333 0.170498
+ 3.9061111 0.207462
+ 3.9063889 0.247825
+ 3.9066667 0.289618
+ 3.9069444 0.330870
+ 3.9072222 0.369614
+ 3.9075000 0.403878
+ 3.9077778 0.431694
+ 3.9080556 0.451093
+ 3.9083333 0.460105
+ 3.9086111 0.457391
+ 3.9088889 0.444139
+ 3.9091667 0.422165
+ 3.9094444 0.393288
+ 3.9097222 0.359323
+ 3.9100000 0.322090
+ 3.9102778 0.283404
+ 3.9105556 0.245084
+ 3.9108333 0.208946
+ 3.9111111 0.176809
+ 3.9113889 0.150187
+ 3.9116667 0.129382
+ 3.9119444 0.114395
+ 3.9122222 0.105226
+ 3.9125000 0.101874
+ 3.9127778 0.104339
+ 3.9130556 0.112623
+ 3.9133333 0.126723
+ 3.9136111 0.146641
+ 3.9138889 0.172377
+ 3.9141667 0.203640
+ 3.9144444 0.238983
+ 3.9147222 0.276670
+ 3.9150000 0.314962
+ 3.9152778 0.352122
+ 3.9155556 0.386413
+ 3.9158333 0.416098
+ 3.9161111 0.439440
+ 3.9163889 0.454701
+ 3.9166667 0.460144
+ 3.9169444 0.454592
+ 3.9172222 0.439114
+ 3.9175000 0.415339
+ 3.9177778 0.384893
+ 3.9180556 0.349408
+ 3.9183333 0.310510
+ 3.9186111 0.269830
+ 3.9188889 0.228995
+ 3.9191667 0.189635
+ 3.9194444 0.153377
+ 3.9197222 0.121637
+ 3.9200000 0.094970
+ 3.9202778 0.073718
+ 3.9205556 0.058224
+ 3.9208333 0.050000
+ 3.9211111 0.050000
+ 3.9213889 0.050000
+ 3.9216667 0.060659
+ 3.9219444 0.079080
+ 3.9222222 0.105309
+ 3.9225000 0.139276
+ 3.9227778 0.179262
+ 3.9230556 0.223134
+ 3.9233333 0.268760
+ 3.9236111 0.314007
+ 3.9238889 0.356745
+ 3.9241667 0.394840
+ 3.9244444 0.426160
+ 3.9247222 0.448573
+ 3.9250000 0.459948
+ 3.9252778 0.458804
+ 3.9255556 0.446272
+ 3.9258333 0.424135
+ 3.9261111 0.394177
+ 3.9263889 0.358180
+ 3.9266667 0.317928
+ 3.9269444 0.275203
+ 3.9272222 0.231790
+ 3.9275000 0.189471
+ 3.9277778 0.150029
+ 3.9280556 0.115024
+ 3.9283333 0.085117
+ 3.9286111 0.060745
+ 3.9288889 0.050000
+ 3.9291667 0.050000
+ 3.9294444 0.050000
+ 3.9297222 0.050000
+ 3.9300000 0.050000
+ 3.9302778 0.055262
+ 3.9305556 0.081890
+ 3.9308333 0.117096
+ 3.9311111 0.159030
+ 3.9313889 0.205385
+ 3.9316667 0.253854
+ 3.9319444 0.302129
+ 3.9322222 0.347902
+ 3.9325000 0.388866
+ 3.9327778 0.422714
+ 3.9330556 0.447137
+ 3.9333333 0.459830
+ 3.9336111 0.459190
+ 3.9338889 0.446440
+ 3.9341667 0.423510
+ 3.9344444 0.392328
+ 3.9347222 0.354824
+ 3.9350000 0.312926
+ 3.9352778 0.268565
+ 3.9355556 0.223668
+ 3.9358333 0.180166
+ 3.9361111 0.139987
+ 3.9363889 0.104797
+ 3.9366667 0.075207
+ 3.9369444 0.051566
+ 3.9372222 0.050000
+ 3.9375000 0.050000
+ 3.9377778 0.050000
+ 3.9380556 0.050000
+ 3.9383333 0.050000
+ 3.9386111 0.054122
+ 3.9388889 0.081863
+ 3.9391667 0.117900
+ 3.9394444 0.160394
+ 3.9397222 0.207071
+ 3.9400000 0.255656
+ 3.9402778 0.303873
+ 3.9405556 0.349449
+ 3.9408333 0.390107
+ 3.9411111 0.423573
+ 3.9413889 0.447572
+ 3.9416667 0.459830
+ 3.9419444 0.458768
+ 3.9422222 0.445598
+ 3.9425000 0.422227
+ 3.9427778 0.390563
+ 3.9430556 0.352515
+ 3.9433333 0.309991
+ 3.9436111 0.264898
+ 3.9438889 0.219146
+ 3.9441667 0.174641
+ 3.9444444 0.133292
+ 3.9447222 0.096759
+ 3.9450000 0.065710
+ 3.9452778 0.050000
+ 3.9455556 0.050000
+ 3.9458333 0.050000
+ 3.9461111 0.050000
+ 3.9463889 0.050000
+ 3.9466667 0.050000
+ 3.9469444 0.050000
+ 3.9472222 0.065047
+ 3.9475000 0.101760
+ 3.9477778 0.145373
+ 3.9480556 0.193529
+ 3.9483333 0.243872
+ 3.9486111 0.294043
+ 3.9488889 0.341685
+ 3.9491667 0.384441
+ 3.9494444 0.419953
+ 3.9497222 0.445864
+ 3.9500000 0.459817
+ 3.9502778 0.460168
+ 3.9505556 0.448127
+ 3.9508333 0.425619
+ 3.9511111 0.394569
+ 3.9513889 0.356900
+ 3.9516667 0.314538
+ 3.9519444 0.269406
+ 3.9522222 0.223430
+ 3.9525000 0.178533
+ 3.9527778 0.136639
+ 3.9530556 0.099430
+ 3.9533333 0.067606
+ 3.9536111 0.050000
+ 3.9538889 0.050000
+ 3.9541667 0.050000
+ 3.9544444 0.050000
+ 3.9547222 0.050000
+ 3.9550000 0.050000
+ 3.9552778 0.050000
+ 3.9555556 0.061713
+ 3.9558333 0.098441
+ 3.9561111 0.142262
+ 3.9563889 0.190774
+ 3.9566667 0.241573
+ 3.9569444 0.292254
+ 3.9572222 0.340415
+ 3.9575000 0.383651
+ 3.9577778 0.419560
+ 3.9580556 0.445736
+ 3.9583333 0.459778
+ 3.9586111 0.460010
+ 3.9588889 0.447675
+ 3.9591667 0.424746
+ 3.9594444 0.393196
+ 3.9597222 0.354996
+ 3.9600000 0.312119
+ 3.9602778 0.266538
+ 3.9605556 0.220225
+ 3.9608333 0.175152
+ 3.9611111 0.133292
+ 3.9613889 0.096357
+ 3.9616667 0.065018
+ 3.9619444 0.050000
+ 3.9622222 0.050000
+ 3.9625000 0.050000
+ 3.9627778 0.050000
+ 3.9630556 0.050000
+ 3.9633333 0.050000
+ 3.9636111 0.050000
+ 3.9638889 0.065139
+ 3.9641667 0.102211
+ 3.9644444 0.146191
+ 3.9647222 0.194687
+ 3.9650000 0.245310
+ 3.9652778 0.295669
+ 3.9655556 0.343372
+ 3.9658333 0.386029
+ 3.9661111 0.421249
+ 3.9663889 0.446642
+ 3.9666667 0.459817
+ 3.9669444 0.459116
+ 3.9672222 0.445813
+ 3.9675000 0.421916
+ 3.9677778 0.389431
+ 3.9680556 0.350367
+ 3.9683333 0.306729
+ 3.9686111 0.260527
+ 3.9688889 0.213765
+ 3.9691667 0.168453
+ 3.9694444 0.126597
+ 3.9697222 0.089929
+ 3.9700000 0.059084
+ 3.9702778 0.050000
+ 3.9705556 0.050000
+ 3.9708333 0.050000
+ 3.9711111 0.050000
+ 3.9713889 0.050000
+ 3.9716667 0.050000
+ 3.9719444 0.050000
+ 3.9722222 0.065021
+ 3.9725000 0.102288
+ 3.9727778 0.146273
+ 3.9730556 0.194642
+ 3.9733333 0.245060
+ 3.9736111 0.295190
+ 3.9738889 0.342699
+ 3.9741667 0.385249
+ 3.9744444 0.420507
+ 3.9747222 0.446137
+ 3.9750000 0.459804
+ 3.9752778 0.459880
+ 3.9755556 0.447574
+ 3.9758333 0.424802
+ 3.9761111 0.393479
+ 3.9763889 0.355523
+ 3.9766667 0.312848
+ 3.9769444 0.267371
+ 3.9772222 0.221009
+ 3.9775000 0.175677
+ 3.9777778 0.133292
+ 3.9780556 0.095535
+ 3.9783333 0.063148
+ 3.9786111 0.050000
+ 3.9788889 0.050000
+ 3.9791667 0.050000
+ 3.9794444 0.050000
+ 3.9797222 0.050000
+ 3.9800000 0.050000
+ 3.9802778 0.050000
+ 3.9805556 0.058313
+ 3.9808333 0.096590
+ 3.9811111 0.142208
+ 3.9813889 0.192570
+ 3.9816667 0.245078
+ 3.9819444 0.297134
+ 3.9822222 0.346140
+ 3.9825000 0.389497
+ 3.9827778 0.424608
+ 3.9830556 0.448875
+ 3.9833333 0.459699
+ 3.9836111 0.455303
+ 3.9838889 0.437184
+ 3.9841667 0.407661
+ 3.9844444 0.369051
+ 3.9847222 0.323673
+ 3.9850000 0.273844
+ 3.9852778 0.221883
+ 3.9855556 0.170108
+ 3.9858333 0.120835
+ 3.9861111 0.076384
+ 3.9863889 0.050000
+ 3.9866667 0.050000
+ 3.9869444 0.050000
+ 3.9872222 0.050000
+ 3.9875000 0.050000
+ 3.9877778 0.050000
+ 3.9880556 0.050000
+ 3.9883333 0.050000
+ 3.9886111 0.050000
+ 3.9888889 0.050000
+ 3.9891667 0.092948
+ 3.9894444 0.142246
+ 3.9897222 0.195347
+ 3.9900000 0.249704
+ 3.9902778 0.302766
+ 3.9905556 0.351988
+ 3.9908333 0.394821
+ 3.9911111 0.428716
+ 3.9913889 0.451126
+ 3.9916667 0.459503
+ 3.9919444 0.452138
+ 3.9922222 0.430679
+ 3.9925000 0.397611
+ 3.9927778 0.355423
+ 3.9930556 0.306600
+ 3.9933333 0.253629
+ 3.9936111 0.198997
+ 3.9938889 0.145190
+ 3.9941667 0.094696
+ 3.9944444 0.050000
+ 3.9947222 0.050000
+ 3.9950000 0.050000
+ 3.9952778 0.050000
+ 3.9955556 0.050000
+ 3.9958333 0.050000
+ 3.9961111 0.050000
+ 3.9963889 0.050000
+ 3.9966667 0.050000
+ 3.9969444 0.050000
+ 3.9972222 0.050000
+ 3.9975000 0.094116
+ 3.9977778 0.143865
+ 3.9980556 0.196869
+ 3.9983333 0.250751
+ 3.9986111 0.303133
+ 3.9988889 0.351638
+ 3.9991667 0.393890
+ 3.9994444 0.427510
+ 3.9997222 0.450121
+ 4.0000000 0.459346
+ 4.0002778 0.453589
+ 4.0005556 0.434375
+ 4.0008333 0.404012
+ 4.0011111 0.364805
+ 4.0013889 0.319062
+ 4.0016667 0.269089
+ 4.0019444 0.217194
+ 4.0022222 0.165682
+ 4.0025000 0.116861
+ 4.0027778 0.073037
+ 4.0030556 0.050000
+ 4.0033333 0.050000
+ 4.0036111 0.050000
+ 4.0038889 0.050000
+ 4.0041667 0.050000
+ 4.0044444 0.050000
+ 4.0047222 0.050000
+ 4.0050000 0.050000
+ 4.0052778 0.050000
+ 4.0055556 0.050000
+ 4.0058333 0.091523
+ 4.0061111 0.139403
+ 4.0063889 0.191655
+ 4.0066667 0.246292
+ 4.0069444 0.301327
+ 4.0072222 0.354774
+ 4.0075000 0.404647
+ 4.0077778 0.448960
+ 4.0080556 0.485726
+ 4.0083333 0.512958
+ 4.0086111 0.529213
+ 4.0088889 0.535204
+ 4.0091667 0.532189
+ 4.0094444 0.521425
+ 4.0097222 0.504169
+ 4.0100000 0.481676
+ 4.0102778 0.455204
+ 4.0105556 0.426009
+ 4.0108333 0.395349
+ 4.0111111 0.364479
+ 4.0113889 0.334542
+ 4.0116667 0.306225
+ 4.0119444 0.280103
+ 4.0122222 0.256747
+ 4.0125000 0.236730
+ 4.0127778 0.220627
+ 4.0130556 0.209010
+ 4.0133333 0.202452
+ 4.0136111 0.201526
+ 4.0138889 0.206806
+ 4.0141667 0.218652
+ 4.0144444 0.236574
+ 4.0147222 0.259870
+ 4.0150000 0.287837
+ 4.0152778 0.319773
+ 4.0155556 0.354975
+ 4.0158333 0.392741
+ 4.0161111 0.432368
+ 4.0163889 0.473154
+ 4.0166667 0.514397
+ 4.0169444 0.555235
+ 4.0172222 0.594174
+ 4.0175000 0.629562
+ 4.0177778 0.659745
+ 4.0180556 0.683071
+ 4.0183333 0.697886
+ 4.0186111 0.702538
+ 4.0188889 0.695374
+ 4.0191667 0.674741
+ 4.0194444 0.638987
+ 4.0197222 0.587421
+ 4.0200000 0.523212
+ 4.0202778 0.450489
+ 4.0205556 0.373382
+ 4.0208333 0.296023
+ 4.0211111 0.222541
+ 4.0213889 0.157068
+ 4.0216667 0.103733
+ 4.0219444 0.066667
+ 4.0222222 0.050000
+ 4.0225000 0.056466
+ 4.0227778 0.083207
+ 4.0230556 0.125968
+ 4.0233333 0.180496
+ 4.0236111 0.242535
+ 4.0238889 0.307830
+ 4.0241667 0.372128
+ 4.0244444 0.431174
+ 4.0247222 0.480712
+ 4.0250000 0.516489
+ 4.0252778 0.535446
+ 4.0255556 0.539312
+ 4.0258333 0.531010
+ 4.0261111 0.513466
+ 4.0263889 0.489603
+ 4.0266667 0.462348
+ 4.0269444 0.434623
+ 4.0272222 0.409354
+ 4.0275000 0.389466
+ 4.0277778 0.377882
+ 4.0280556 0.376739
+ 4.0283333 0.385021
+ 4.0286111 0.400924
+ 4.0288889 0.422644
+ 4.0291667 0.448375
+ 4.0294444 0.476315
+ 4.0297222 0.504657
+ 4.0300000 0.531599
+ 4.0302778 0.555336
+ 4.0305556 0.574063
+ 4.0308333 0.586349
+ 4.0311111 0.592247
+ 4.0313889 0.592185
+ 4.0316667 0.586590
+ 4.0319444 0.575888
+ 4.0322222 0.560507
+ 4.0325000 0.540872
+ 4.0327778 0.517412
+ 4.0330556 0.490552
+ 4.0333333 0.460719
+ 4.0336111 0.428355
+ 4.0338889 0.393953
+ 4.0341667 0.358025
+ 4.0344444 0.321077
+ 4.0347222 0.283620
+ 4.0350000 0.246163
+ 4.0352778 0.209215
+ 4.0355556 0.173284
+ 4.0358333 0.138880
+ 4.0361111 0.106512
+ 4.0363889 0.076732
+ 4.0366667 0.050265
+ 4.0369444 0.050000
+ 4.0372222 0.050000
+ 4.0375000 0.050000
+ 4.0377778 0.050000
+ 4.0380556 0.050000
+ 4.0383333 0.050000
+ 4.0386111 0.050000
+ 4.0388889 0.050000
+ 4.0391667 0.087368
+ 4.0394444 0.132391
+ 4.0397222 0.182498
+ 4.0400000 0.235117
+ 4.0402778 0.287676
+ 4.0405556 0.337602
+ 4.0408333 0.382323
+ 4.0411111 0.419269
+ 4.0413889 0.445866
+ 4.0416667 0.459542
+ 4.0419444 0.458513
+ 4.0422222 0.444140
+ 4.0425000 0.418570
+ 4.0427778 0.383952
+ 4.0430556 0.342433
+ 4.0433333 0.296162
+ 4.0436111 0.247286
+ 4.0438889 0.197954
+ 4.0441667 0.150313
+ 4.0444444 0.106512
+ 4.0447222 0.068396
+ 4.0450000 0.050000
+ 4.0452778 0.050000
+ 4.0455556 0.050000
+ 4.0458333 0.050000
+ 4.0461111 0.050000
+ 4.0463889 0.050000
+ 4.0466667 0.050000
+ 4.0469444 0.050000
+ 4.0472222 0.050000
+ 4.0475000 0.089696
+ 4.0477778 0.136257
+ 4.0480556 0.187216
+ 4.0483333 0.240103
+ 4.0486111 0.292451
+ 4.0488889 0.341792
+ 4.0491667 0.385657
+ 4.0494444 0.421577
+ 4.0497222 0.447085
+ 4.0500000 0.459712
+ 4.0502778 0.457759
+ 4.0505556 0.442601
+ 4.0508333 0.416380
+ 4.0511111 0.381242
+ 4.0513889 0.339328
+ 4.0516667 0.292784
+ 4.0519444 0.243751
+ 4.0522222 0.194375
+ 4.0525000 0.146798
+ 4.0527778 0.103164
+ 4.0530556 0.065312
+ 4.0533333 0.050000
+ 4.0536111 0.050000
+ 4.0538889 0.050000
+ 4.0541667 0.050000
+ 4.0544444 0.050000
+ 4.0547222 0.050000
+ 4.0550000 0.050000
+ 4.0552778 0.050000
+ 4.0555556 0.050000
+ 4.0558333 0.089710
+ 4.0561111 0.136192
+ 4.0563889 0.187011
+ 4.0566667 0.239733
+ 4.0569444 0.291924
+ 4.0572222 0.341149
+ 4.0575000 0.384975
+ 4.0577778 0.420967
+ 4.0580556 0.446691
+ 4.0583333 0.459712
+ 4.0586111 0.458352
+ 4.0588889 0.443945
+ 4.0591667 0.418582
+ 4.0594444 0.384353
+ 4.0597222 0.343349
+ 4.0600000 0.297660
+ 4.0602778 0.249377
+ 4.0605556 0.200588
+ 4.0608333 0.153386
+ 4.0611111 0.109859
+ 4.0613889 0.071813
+ 4.0616667 0.050000
+ 4.0619444 0.050000
+ 4.0622222 0.050000
+ 4.0625000 0.050000
+ 4.0627778 0.050000
+ 4.0630556 0.050000
+ 4.0633333 0.050000
+ 4.0636111 0.050000
+ 4.0638889 0.050000
+ 4.0641667 0.089513
+ 4.0644444 0.136003
+ 4.0647222 0.186974
+ 4.0650000 0.239933
+ 4.0652778 0.292385
+ 4.0655556 0.341834
+ 4.0658333 0.385788
+ 4.0661111 0.421750
+ 4.0663889 0.447228
+ 4.0666667 0.459725
+ 4.0669444 0.457527
+ 4.0672222 0.442026
+ 4.0675000 0.415395
+ 4.0677778 0.379807
+ 4.0680556 0.337434
+ 4.0683333 0.290448
+ 4.0686111 0.241020
+ 4.0688889 0.191325
+ 4.0691667 0.143533
+ 4.0694444 0.099817
+ 4.0697222 0.062034
+ 4.0700000 0.050000
+ 4.0702778 0.050000
+ 4.0705556 0.050000
+ 4.0708333 0.050000
+ 4.0711111 0.050000
+ 4.0713889 0.050000
+ 4.0716667 0.050000
+ 4.0719444 0.050000
+ 4.0722222 0.050000
+ 4.0725000 0.089863
+ 4.0727778 0.136402
+ 4.0730556 0.187206
+ 4.0733333 0.239865
+ 4.0736111 0.291966
+ 4.0738889 0.341100
+ 4.0741667 0.384855
+ 4.0744444 0.420820
+ 4.0747222 0.446585
+ 4.0750000 0.459738
+ 4.0752778 0.458616
+ 4.0755556 0.444535
+ 4.0758333 0.419562
+ 4.0761111 0.385761
+ 4.0763889 0.345198
+ 4.0766667 0.299936
+ 4.0769444 0.252041
+ 4.0772222 0.203578
+ 4.0775000 0.156612
+ 4.0777778 0.113207
+ 4.0780556 0.075149
+ 4.0783333 0.050000
+ 4.0786111 0.050000
+ 4.0788889 0.050000
+ 4.0791667 0.050000
+ 4.0794444 0.050000
+ 4.0797222 0.050000
+ 4.0800000 0.050000
+ 4.0802778 0.050000
+ 4.0805556 0.050000
+ 4.0808333 0.089122
+ 4.0811111 0.135276
+ 4.0813889 0.185981
+ 4.0816667 0.238751
+ 4.0819444 0.291103
+ 4.0822222 0.340555
+ 4.0825000 0.384623
+ 4.0827778 0.420823
+ 4.0830556 0.446672
+ 4.0833333 0.459686
+ 4.0836111 0.458152
+ 4.0838889 0.443429
+ 4.0841667 0.417649
+ 4.0844444 0.382942
+ 4.0847222 0.341437
+ 4.0850000 0.295265
+ 4.0852778 0.246557
+ 4.0855556 0.197442
+ 4.0858333 0.150050
+ 4.0861111 0.106512
+ 4.0863889 0.068658
+ 4.0866667 0.050000
+ 4.0869444 0.050000
+ 4.0872222 0.050000
+ 4.0875000 0.050000
+ 4.0877778 0.050000
+ 4.0880556 0.050000
+ 4.0883333 0.050000
+ 4.0886111 0.050000
+ 4.0888889 0.051592
+ 4.0891667 0.091228
+ 4.0894444 0.137683
+ 4.0897222 0.188498
+ 4.0900000 0.241214
+ 4.0902778 0.293372
+ 4.0905556 0.342514
+ 4.0908333 0.386180
+ 4.0911111 0.421912
+ 4.0913889 0.447251
+ 4.0916667 0.459738
+ 4.0919444 0.457681
+ 4.0922222 0.442452
+ 4.0925000 0.416191
+ 4.0927778 0.381037
+ 4.0930556 0.339130
+ 4.0933333 0.292608
+ 4.0936111 0.243611
+ 4.0938889 0.194279
+ 4.0941667 0.146750
+ 4.0944444 0.103164
+ 4.0947222 0.065356
+ 4.0950000 0.050000
+ 4.0952778 0.050000
+ 4.0955556 0.050000
+ 4.0958333 0.050000
+ 4.0961111 0.050000
+ 4.0963889 0.050000
+ 4.0966667 0.050000
+ 4.0969444 0.050000
+ 4.0972222 0.050000
+ 4.0975000 0.089631
+ 4.0977778 0.136025
+ 4.0980556 0.186757
+ 4.0983333 0.239403
+ 4.0986111 0.291541
+ 4.0988889 0.340745
+ 4.0991667 0.384592
+ 4.0994444 0.420658
+ 4.0997222 0.446519
+ 4.1000000 0.459752
+ 4.1002778 0.458680
+ 4.1005556 0.444626
+ 4.1008333 0.419659
+ 4.1011111 0.385849
+ 4.1013889 0.345266
+ 4.1016667 0.299980
+ 4.1019444 0.252061
+ 4.1022222 0.203579
+ 4.1025000 0.156605
+ 4.1027778 0.113207
+ 4.1030556 0.075175
+ 4.1033333 0.050000
+ 4.1036111 0.050000
+ 4.1038889 0.050000
+ 4.1041667 0.050000
+ 4.1044444 0.050000
+ 4.1047222 0.050000
+ 4.1050000 0.050000
+ 4.1052778 0.050000
+ 4.1055556 0.050000
+ 4.1058333 0.088965
+ 4.1061111 0.134935
+ 4.1063889 0.185450
+ 4.1066667 0.238051
+ 4.1069444 0.290277
+ 4.1072222 0.339668
+ 4.1075000 0.383765
+ 4.1077778 0.420107
+ 4.1080556 0.446234
+ 4.1083333 0.459686
+ 4.1086111 0.458761
+ 4.1088889 0.444785
+ 4.1091667 0.419843
+ 4.1094444 0.386016
+ 4.1097222 0.345391
+ 4.1100000 0.300050
+ 4.1102778 0.252077
+ 4.1105556 0.203556
+ 4.1108333 0.156572
+ 4.1111111 0.113207
+ 4.1113889 0.075260
+ 4.1116667 0.050000
+ 4.1119444 0.050000
+ 4.1122222 0.050000
+ 4.1125000 0.050000
+ 4.1127778 0.050000
+ 4.1130556 0.050000
+ 4.1133333 0.050000
+ 4.1136111 0.050000
+ 4.1138889 0.051618
+ 4.1141667 0.090641
+ 4.1144444 0.136619
+ 4.1147222 0.187092
+ 4.1150000 0.239602
+ 4.1152778 0.291689
+ 4.1155556 0.340895
+ 4.1158333 0.384761
+ 4.1161111 0.420827
+ 4.1163889 0.446635
+ 4.1166667 0.459725
+ 4.1169444 0.458399
+ 4.1172222 0.443995
+ 4.1175000 0.418613
+ 4.1177778 0.384351
+ 4.1180556 0.343309
+ 4.1183333 0.297586
+ 4.1186111 0.249280
+ 4.1188889 0.200491
+ 4.1191667 0.153318
+ 4.1194444 0.109859
+ 4.1197222 0.071923
+ 4.1200000 0.050000
+ 4.1202778 0.050000
+ 4.1205556 0.050000
+ 4.1208333 0.050000
+ 4.1211111 0.050000
+ 4.1213889 0.050000
+ 4.1216667 0.050000
+ 4.1219444 0.050000
+ 4.1222222 0.050000
+ 4.1225000 0.089033
+ 4.1227778 0.134964
+ 4.1230556 0.185367
+ 4.1233333 0.237818
+ 4.1236111 0.289892
+ 4.1238889 0.339165
+ 4.1241667 0.383212
+ 4.1244444 0.419609
+ 4.1247222 0.445930
+ 4.1250000 0.459752
+ 4.1252778 0.459391
+ 4.1255556 0.446139
+ 4.1258333 0.422028
+ 4.1261111 0.389089
+ 4.1263889 0.349355
+ 4.1266667 0.304859
+ 4.1269444 0.257634
+ 4.1272222 0.209711
+ 4.1275000 0.163123
+ 4.1277778 0.119902
+ 4.1280556 0.081813
+ 4.1283333 0.050000
+ 4.1286111 0.050000
+ 4.1288889 0.050000
+ 4.1291667 0.050000
+ 4.1294444 0.050000
+ 4.1297222 0.050000
+ 4.1300000 0.050000
+ 4.1302778 0.050000
+ 4.1305556 0.051592
+ 4.1308333 0.090212
+ 4.1311111 0.135960
+ 4.1313889 0.186345
+ 4.1316667 0.238877
+ 4.1319444 0.291067
+ 4.1322222 0.340424
+ 4.1325000 0.384458
+ 4.1327778 0.420680
+ 4.1330556 0.446599
+ 4.1333333 0.459725
+ 4.1336111 0.458339
+ 4.1338889 0.443803
+ 4.1341667 0.418246
+ 4.1344444 0.383802
+ 4.1347222 0.342601
+ 4.1350000 0.296776
+ 4.1352778 0.248458
+ 4.1355556 0.199778
+ 4.1358333 0.152868
+ 4.1361111 0.109859
+ 4.1363889 0.072579
+ 4.1366667 0.050000
+ 4.1369444 0.050000
+ 4.1372222 0.050000
+ 4.1375000 0.050000
+ 4.1377778 0.050000
+ 4.1380556 0.050000
+ 4.1383333 0.050000
+ 4.1386111 0.050000
+ 4.1388889 0.058326
+ 4.1391667 0.097517
+ 4.1394444 0.143348
+ 4.1397222 0.193407
+ 4.1400000 0.245286
+ 4.1402778 0.296573
+ 4.1405556 0.344858
+ 4.1408333 0.387732
+ 4.1411111 0.422783
+ 4.1413889 0.447602
+ 4.1416667 0.459778
+ 4.1419444 0.457651
+ 4.1422222 0.442565
+ 4.1425000 0.416611
+ 4.1427778 0.381885
+ 4.1430556 0.340479
+ 4.1433333 0.294486
+ 4.1436111 0.245999
+ 4.1438889 0.197113
+ 4.1441667 0.149919
+ 4.1444444 0.106512
+ 4.1447222 0.068693
+ 4.1450000 0.050000
+ 4.1452778 0.050000
+ 4.1455556 0.050000
+ 4.1458333 0.050000
+ 4.1461111 0.050000
+ 4.1463889 0.050000
+ 4.1466667 0.050000
+ 4.1469444 0.050000
+ 4.1472222 0.050000
+ 4.1475000 0.089540
+ 4.1477778 0.135959
+ 4.1480556 0.186798
+ 4.1483333 0.239596
+ 4.1486111 0.291892
+ 4.1488889 0.341227
+ 4.1491667 0.385141
+ 4.1494444 0.421173
+ 4.1497222 0.446863
+ 4.1500000 0.459752
+ 4.1502778 0.458141
+ 4.1505556 0.443387
+ 4.1508333 0.417609
+ 4.1511111 0.382927
+ 4.1513889 0.341459
+ 4.1516667 0.295325
+ 4.1519444 0.246644
+ 4.1522222 0.197536
+ 4.1525000 0.150119
+ 4.1527778 0.106512
+ 4.1530556 0.068539
+ 4.1533333 0.050000
+ 4.1536111 0.050000
+ 4.1538889 0.050000
+ 4.1541667 0.050000
+ 4.1544444 0.050000
+ 4.1547222 0.050000
+ 4.1550000 0.050000
+ 4.1552778 0.050000
+ 4.1555556 0.050000
+ 4.1558333 0.089649
+ 4.1561111 0.136175
+ 4.1563889 0.187110
+ 4.1566667 0.239985
+ 4.1569444 0.292331
+ 4.1572222 0.341679
+ 4.1575000 0.385560
+ 4.1577778 0.421505
+ 4.1580556 0.447046
+ 4.1583333 0.459712
+ 4.1586111 0.457805
+ 4.1588889 0.442693
+ 4.1591667 0.416518
+ 4.1594444 0.381417
+ 4.1597222 0.339529
+ 4.1600000 0.292995
+ 4.1602778 0.243952
+ 4.1605556 0.194540
+ 4.1608333 0.146898
+ 4.1611111 0.103164
+ 4.1613889 0.065178
+ 4.1616667 0.050000
+ 4.1619444 0.050000
+ 4.1622222 0.050000
+ 4.1625000 0.050000
+ 4.1627778 0.050000
+ 4.1630556 0.050000
+ 4.1633333 0.050000
+ 4.1636111 0.050000
+ 4.1638889 0.050000
+ 4.1641667 0.090202
+ 4.1644444 0.137253
+ 4.1647222 0.188650
+ 4.1650000 0.241887
+ 4.1652778 0.294461
+ 4.1655556 0.343867
+ 4.1658333 0.387600
+ 4.1661111 0.423158
+ 4.1663889 0.448034
+ 4.1666667 0.459725
+ 4.1669444 0.456517
+ 4.1672222 0.439850
+ 4.1675000 0.411956
+ 4.1677778 0.375067
+ 4.1680556 0.331413
+ 4.1683333 0.283226
+ 4.1686111 0.232738
+ 4.1688889 0.182179
+ 4.1691667 0.133781
+ 4.1694444 0.089774
+ 4.1697222 0.052059
+ 4.1700000 0.050000
+ 4.1702778 0.050000
+ 4.1705556 0.050000
+ 4.1708333 0.050000
+ 4.1711111 0.050000
+ 4.1713889 0.050000
+ 4.1716667 0.050000
+ 4.1719444 0.050000
+ 4.1722222 0.050000
+ 4.1725000 0.091176
+ 4.1727778 0.138891
+ 4.1730556 0.190675
+ 4.1733333 0.244061
+ 4.1736111 0.296578
+ 4.1738889 0.345760
+ 4.1741667 0.389137
+ 4.1744444 0.424240
+ 4.1747222 0.448601
+ 4.1750000 0.459752
+ 4.1752778 0.456008
+ 4.1755556 0.438825
+ 4.1758333 0.410444
+ 4.1761111 0.373105
+ 4.1763889 0.329049
+ 4.1766667 0.280516
+ 4.1769444 0.229747
+ 4.1772222 0.178982
+ 4.1775000 0.130462
+ 4.1777778 0.086427
+ 4.1780556 0.050000
+ 4.1783333 0.050000
+ 4.1786111 0.050000
+ 4.1788889 0.050000
+ 4.1791667 0.050000
+ 4.1794444 0.050000
+ 4.1797222 0.050000
+ 4.1800000 0.050000
+ 4.1802778 0.050000
+ 4.1805556 0.050000
+ 4.1808333 0.091613
+ 4.1811111 0.139726
+ 4.1813889 0.191846
+ 4.1816667 0.245484
+ 4.1819444 0.298147
+ 4.1822222 0.347346
+ 4.1825000 0.390589
+ 4.1827778 0.425385
+ 4.1830556 0.449243
+ 4.1833333 0.459673
+ 4.1836111 0.454982
+ 4.1838889 0.436674
+ 4.1841667 0.407053
+ 4.1844444 0.368422
+ 4.1847222 0.323083
+ 4.1850000 0.273339
+ 4.1852778 0.221495
+ 4.1855556 0.169852
+ 4.1858333 0.120714
+ 4.1861111 0.076384
+ 4.1863889 0.050000
+ 4.1866667 0.050000
+ 4.1869444 0.050000
+ 4.1872222 0.050000
+ 4.1875000 0.050000
+ 4.1877778 0.050000
+ 4.1880556 0.050000
+ 4.1883333 0.050000
+ 4.1886111 0.050000
+ 4.1888889 0.050000
+ 4.1891667 0.092867
+ 4.1894444 0.142085
+ 4.1897222 0.195114
+ 4.1900000 0.249416
+ 4.1902778 0.302449
+ 4.1905556 0.351677
+ 4.1908333 0.394559
+ 4.1911111 0.428556
+ 4.1913889 0.451129
+ 4.1916667 0.459738
+ 4.1919444 0.452679
+ 4.1922222 0.431581
+ 4.1925000 0.398906
+ 4.1927778 0.357118
+ 4.1930556 0.308680
+ 4.1933333 0.256055
+ 4.1936111 0.201707
+ 4.1938889 0.148098
+ 4.1941667 0.097692
+ 4.1944444 0.052952
+ 4.1947222 0.050000
+ 4.1950000 0.050000
+ 4.1952778 0.050000
+ 4.1955556 0.050000
+ 4.1958333 0.050000
+ 4.1961111 0.050000
+ 4.1963889 0.050000
+ 4.1966667 0.050000
+ 4.1969444 0.050000
+ 4.1972222 0.050000
+ 4.1975000 0.094343
+ 4.1977778 0.144457
+ 4.1980556 0.197897
+ 4.1983333 0.252220
+ 4.1986111 0.304979
+ 4.1988889 0.353730
+ 4.1991667 0.396028
+ 4.1994444 0.429427
+ 4.1997222 0.451483
+ 4.2000000 0.459752
+ 4.2002778 0.452597
+ 4.2005556 0.431625
+ 4.2008333 0.399251
+ 4.2011111 0.357891
+ 4.2013889 0.309960
+ 4.2016667 0.257875
+ 4.2019444 0.204051
+ 4.2022222 0.150903
+ 4.2025000 0.100847
+ 4.2027778 0.056299
+ 4.2030556 0.050000
+ 4.2033333 0.050000
+ 4.2036111 0.050000
+ 4.2038889 0.050000
+ 4.2041667 0.050000
+ 4.2044444 0.050000
+ 4.2047222 0.050000
+ 4.2050000 0.050000
+ 4.2052778 0.050000
+ 4.2055556 0.050000
+ 4.2058333 0.094240
+ 4.2061111 0.144368
+ 4.2063889 0.197903
+ 4.2066667 0.252366
+ 4.2069444 0.305275
+ 4.2072222 0.354151
+ 4.2075000 0.396513
+ 4.2077778 0.429881
+ 4.2080556 0.451774
+ 4.2083333 0.459712
+ 4.2086111 0.452040
+ 4.2088889 0.430396
+ 4.2091667 0.397246
+ 4.2094444 0.355053
+ 4.2097222 0.306282
+ 4.2100000 0.253397
+ 4.2102778 0.198862
+ 4.2105556 0.145142
+ 4.2108333 0.094699
+ 4.2111111 0.050000
+ 4.2113889 0.050000
+ 4.2116667 0.050000
+ 4.2119444 0.050000
+ 4.2122222 0.050000
+ 4.2125000 0.050000
+ 4.2127778 0.050000
+ 4.2130556 0.050000
+ 4.2133333 0.050000
+ 4.2136111 0.050000
+ 4.2138889 0.050000
+ 4.2141667 0.094664
+ 4.2144444 0.145061
+ 4.2147222 0.198733
+ 4.2150000 0.253221
+ 4.2152778 0.306070
+ 4.2155556 0.354820
+ 4.2158333 0.397014
+ 4.2161111 0.430195
+ 4.2163889 0.451905
+ 4.2166667 0.459686
+ 4.2169444 0.451900
+ 4.2172222 0.430185
+ 4.2175000 0.397000
+ 4.2177778 0.354803
+ 4.2180556 0.306050
+ 4.2183333 0.253202
+ 4.2186111 0.198714
+ 4.2188889 0.145046
+ 4.2191667 0.094655
+ 4.2194444 0.050000
+ 4.2197222 0.050000
+ 4.2200000 0.050000
+ 4.2202778 0.050000
+ 4.2205556 0.050000
+ 4.2208333 0.050000
+ 4.2211111 0.050000
+ 4.2213889 0.050000
+ 4.2216667 0.050000
+ 4.2219444 0.050000
+ 4.2222222 0.050000
+ 4.2225000 0.094658
+ 4.2227778 0.145052
+ 4.2230556 0.198724
+ 4.2233333 0.253216
+ 4.2236111 0.306069
+ 4.2238889 0.354825
+ 4.2241667 0.397025
+ 4.2244444 0.430212
+ 4.2247222 0.451927
+ 4.2250000 0.459712
+ 4.2252778 0.451928
+ 4.2255556 0.430214
+ 4.2258333 0.397027
+ 4.2261111 0.354827
+ 4.2263889 0.306072
+ 4.2266667 0.253219
+ 4.2269444 0.198727
+ 4.2272222 0.145054
+ 4.2275000 0.094659
+ 4.2277778 0.050000
+ 4.2280556 0.050000
+ 4.2283333 0.050000
+ 4.2286111 0.050000
+ 4.2288889 0.050000
+ 4.2291667 0.050000
+ 4.2294444 0.050000
+ 4.2297222 0.050000
+ 4.2300000 0.050000
+ 4.2302778 0.050000
+ 4.2305556 0.050000
+ 4.2308333 0.094662
+ 4.2311111 0.145059
+ 4.2313889 0.198734
+ 4.2316667 0.253227
+ 4.2319444 0.306079
+ 4.2322222 0.354831
+ 4.2325000 0.397024
+ 4.2327778 0.430199
+ 4.2330556 0.451898
+ 4.2333333 0.459660
+ 4.2336111 0.451848
+ 4.2338889 0.430103
+ 4.2341667 0.396887
+ 4.2344444 0.354662
+ 4.2347222 0.305890
+ 4.2350000 0.253034
+ 4.2352778 0.198554
+ 4.2355556 0.144914
+ 4.2358333 0.094575
+ 4.2361111 0.050000
+ 4.2363889 0.050000
+ 4.2366667 0.050000
+ 4.2369444 0.050000
+ 4.2372222 0.050000
+ 4.2375000 0.050000
+ 4.2377778 0.050000
+ 4.2380556 0.050000
+ 4.2383333 0.050000
+ 4.2386111 0.050000
+ 4.2388889 0.051304
+ 4.2391667 0.095982
+ 4.2394444 0.146355
+ 4.2397222 0.199969
+ 4.2400000 0.254368
+ 4.2402778 0.307095
+ 4.2405556 0.355697
+ 4.2408333 0.397716
+ 4.2411111 0.430698
+ 4.2413889 0.452186
+ 4.2416667 0.459725
+ 4.2419444 0.451683
+ 4.2422222 0.429714
+ 4.2425000 0.396297
+ 4.2427778 0.353910
+ 4.2430556 0.305032
+ 4.2433333 0.252140
+ 4.2436111 0.197712
+ 4.2438889 0.144228
+ 4.2441667 0.094164
+ 4.2444444 0.050000
+ 4.2447222 0.050000
+ 4.2450000 0.050000
+ 4.2452778 0.050000
+ 4.2455556 0.050000
+ 4.2458333 0.050000
+ 4.2461111 0.050000
+ 4.2463889 0.050000
+ 4.2466667 0.050000
+ 4.2469444 0.050000
+ 4.2472222 0.054704
+ 4.2475000 0.098500
+ 4.2477778 0.147741
+ 4.2480556 0.200111
+ 4.2483333 0.253294
+ 4.2486111 0.304975
+ 4.2488889 0.352838
+ 4.2491667 0.394566
+ 4.2494444 0.427845
+ 4.2497222 0.450359
+ 4.2500000 0.459791
+ 4.2502778 0.454590
+ 4.2505556 0.436265
+ 4.2508333 0.407086
+ 4.2511111 0.369325
+ 4.2513889 0.325255
+ 4.2516667 0.277147
+ 4.2519444 0.227273
+ 4.2522222 0.177905
+ 4.2525000 0.131315
+ 4.2527778 0.089774
+ 4.2530556 0.055182
+ 4.2533333 0.050000
+ 4.2536111 0.050000
+ 4.2538889 0.050000
+ 4.2541667 0.050000
+ 4.2544444 0.050000
+ 4.2547222 0.050000
+ 4.2550000 0.050000
+ 4.2552778 0.050000
+ 4.2555556 0.078372
+ 4.2558333 0.118310
+ 4.2561111 0.163687
+ 4.2563889 0.212314
+ 4.2566667 0.262003
+ 4.2569444 0.310563
+ 4.2572222 0.355806
+ 4.2575000 0.395543
+ 4.2577778 0.427586
+ 4.2580556 0.449744
+ 4.2583333 0.459830
+ 4.2586111 0.456362
+ 4.2588889 0.440692
+ 4.2591667 0.414880
+ 4.2594444 0.380985
+ 4.2597222 0.341069
+ 4.2600000 0.297190
+ 4.2602778 0.251409
+ 4.2605556 0.205785
+ 4.2608333 0.162379
+ 4.2611111 0.123249
+ 4.2613889 0.090136
+ 4.2616667 0.063488
+ 4.2619444 0.050000
+ 4.2622222 0.050000
+ 4.2625000 0.050000
+ 4.2627778 0.050000
+ 4.2630556 0.050000
+ 4.2633333 0.050000
+ 4.2636111 0.068829
+ 4.2638889 0.098549
+ 4.2641667 0.135518
+ 4.2644444 0.177982
+ 4.2647222 0.223812
+ 4.2650000 0.270878
+ 4.2652778 0.317048
+ 4.2655556 0.360194
+ 4.2658333 0.398184
+ 4.2661111 0.428889
+ 4.2663889 0.450178
+ 4.2666667 0.459922
+ 4.2669444 0.456672
+ 4.2672222 0.441714
+ 4.2675000 0.417015
+ 4.2677778 0.384542
+ 4.2680556 0.346264
+ 4.2683333 0.304146
+ 4.2686111 0.260158
+ 4.2688889 0.216266
+ 4.2691667 0.174437
+ 4.2694444 0.136639
+ 4.2697222 0.104536
+ 4.2700000 0.078571
+ 4.2702778 0.058884
+ 4.2705556 0.050000
+ 4.2708333 0.050000
+ 4.2711111 0.050000
+ 4.2713889 0.050000
+ 4.2716667 0.059526
+ 4.2719444 0.080449
+ 4.2722222 0.108630
+ 4.2725000 0.143849
+ 4.2727778 0.184442
+ 4.2730556 0.228389
+ 4.2733333 0.273665
+ 4.2736111 0.318249
+ 4.2738889 0.360118
+ 4.2741667 0.397249
+ 4.2744444 0.427619
+ 4.2747222 0.449206
+ 4.2750000 0.459987
+ 4.2752778 0.458571
+ 4.2755556 0.446094
+ 4.2758333 0.424322
+ 4.2761111 0.395021
+ 4.2763889 0.359960
+ 4.2766667 0.320904
+ 4.2769444 0.279620
+ 4.2772222 0.237876
+ 4.2775000 0.197438
+ 4.2777778 0.160072
+ 4.2780556 0.127307
+ 4.2783333 0.099716
+ 4.2786111 0.077631
+ 4.2788889 0.061388
+ 4.2791667 0.051320
+ 4.2794444 0.050000
+ 4.2797222 0.051043
+ 4.2800000 0.061501
+ 4.2802778 0.079470
+ 4.2805556 0.105283
+ 4.2808333 0.138865
+ 4.2811111 0.178508
+ 4.2813889 0.222097
+ 4.2816667 0.267516
+ 4.2819444 0.312649
+ 4.2822222 0.355379
+ 4.2825000 0.393592
+ 4.2827778 0.425170
+ 4.2830556 0.447998
+ 4.2833333 0.459961
+ 4.2836111 0.459592
+ 4.2838889 0.448026
+ 4.2841667 0.427051
+ 4.2844444 0.398452
+ 4.2847222 0.364015
+ 4.2850000 0.325526
+ 4.2852778 0.284770
+ 4.2855556 0.243535
+ 4.2858333 0.203605
+ 4.2861111 0.166767
+ 4.2863889 0.134561
+ 4.2866667 0.107543
+ 4.2869444 0.086023
+ 4.2872222 0.070313
+ 4.2875000 0.060722
+ 4.2877778 0.057560
+ 4.2880556 0.061138
+ 4.2883333 0.071767
+ 4.2886111 0.089756
+ 4.2888889 0.115417
+ 4.2891667 0.148657
+ 4.2894444 0.187775
+ 4.2897222 0.230669
+ 4.2900000 0.275235
+ 4.2902778 0.319371
+ 4.2905556 0.360973
+ 4.2908333 0.397939
+ 4.2911111 0.428165
+ 4.2913889 0.449549
+ 4.2916667 0.459987
+ 4.2919444 0.458030
+ 4.2922222 0.444844
+ 4.2925000 0.422248
+ 4.2927778 0.392060
+ 4.2930556 0.356099
+ 4.2933333 0.316185
+ 4.2936111 0.274137
+ 4.2938889 0.231774
+ 4.2941667 0.190914
+ 4.2944444 0.153377
+ 4.2947222 0.120726
+ 4.2950000 0.093502
+ 4.2952778 0.071991
+ 4.2955556 0.056477
+ 4.2958333 0.050000
+ 4.2961111 0.050000
+ 4.2963889 0.050000
+ 4.2966667 0.060105
+ 4.2969444 0.078859
+ 4.2972222 0.105322
+ 4.2975000 0.139383
+ 4.2977778 0.179344
+ 4.2980556 0.223110
+ 4.2983333 0.268585
+ 4.2986111 0.313675
+ 4.2988889 0.356284
+ 4.2991667 0.394317
+ 4.2994444 0.425680
+ 4.2997222 0.448277
+ 4.3000000 0.460013
+ 4.3002778 0.459441
+ 4.3005556 0.447704
+ 4.3008333 0.426592
+ 4.3011111 0.397898
+ 4.3013889 0.363410
+ 4.3016667 0.324921
+ 4.3019444 0.284222
+ 4.3022222 0.243102
+ 4.3025000 0.203354
+ 4.3027778 0.166767
+ 4.3030556 0.134883
+ 4.3033333 0.108242
+ 4.3036111 0.087134
+ 4.3038889 0.071851
+ 4.3041667 0.062682
+ 4.3044444 0.059919
+ 4.3047222 0.063851
+ 4.3050000 0.074769
+ 4.3052778 0.092963
+ 4.3055556 0.118725
+ 4.3058333 0.151948
+ 4.3061111 0.190940
+ 4.3063889 0.233613
+ 4.3066667 0.277880
+ 4.3069444 0.321651
+ 4.3072222 0.362840
+ 4.3075000 0.399357
+ 4.3077778 0.429115
+ 4.3080556 0.450025
+ 4.3083333 0.460000
+ 4.3086111 0.457605
+ 4.3088889 0.444026
+ 4.3091667 0.421100
+ 4.3094444 0.390667
+ 4.3097222 0.354564
+ 4.3100000 0.314632
+ 4.3102778 0.272708
+ 4.3105556 0.230632
+ 4.3108333 0.190242
+ 4.3111111 0.153377
+ 4.3113889 0.121608
+ 4.3116667 0.095434
+ 4.3119444 0.075089
+ 4.3122222 0.060804
+ 4.3125000 0.052813
+ 4.3127778 0.051346
+ 4.3130556 0.056637
+ 4.3133333 0.068917
+ 4.3136111 0.088420
+ 4.3138889 0.115378
+ 4.3141667 0.149636
+ 4.3144444 0.189496
+ 4.3147222 0.232875
+ 4.3150000 0.277689
+ 4.3152778 0.321853
+ 4.3155556 0.363284
+ 4.3158333 0.399896
+ 4.3161111 0.429607
+ 4.3163889 0.450332
+ 4.3166667 0.459987
+ 4.3169444 0.457142
+ 4.3172222 0.442984
+ 4.3175000 0.419353
+ 4.3177778 0.388090
+ 4.3180556 0.351037
+ 4.3183333 0.310033
+ 4.3186111 0.266921
+ 4.3188889 0.223539
+ 4.3191667 0.181730
+ 4.3194444 0.143334
+ 4.3197222 0.109936
+ 4.3200000 0.082091
+ 4.3202778 0.060099
+ 4.3205556 0.050000
+ 4.3208333 0.050000
+ 4.3211111 0.050000
+ 4.3213889 0.050000
+ 4.3216667 0.050000
+ 4.3219444 0.067872
+ 4.3222222 0.095253
+ 4.3225000 0.130475
+ 4.3227778 0.171774
+ 4.3230556 0.216975
+ 4.3233333 0.263905
+ 4.3236111 0.310387
+ 4.3238889 0.354247
+ 4.3241667 0.393309
+ 4.3244444 0.425399
+ 4.3247222 0.448341
+ 4.3250000 0.459961
+ 4.3252778 0.458758
+ 4.3255556 0.445934
+ 4.3258333 0.423363
+ 4.3261111 0.392922
+ 4.3263889 0.356486
+ 4.3266667 0.315931
+ 4.3269444 0.273132
+ 4.3272222 0.229965
+ 4.3275000 0.188305
+ 4.3277778 0.150029
+ 4.3280556 0.116748
+ 4.3283333 0.089017
+ 4.3286111 0.067128
+ 4.3288889 0.051371
+ 4.3291667 0.050000
+ 4.3294444 0.050000
+ 4.3297222 0.050000
+ 4.3300000 0.055500
+ 4.3302778 0.074777
+ 4.3305556 0.101935
+ 4.3308333 0.136854
+ 4.3311111 0.177770
+ 4.3313889 0.222507
+ 4.3316667 0.268890
+ 4.3319444 0.314744
+ 4.3322222 0.357893
+ 4.3325000 0.396162
+ 4.3327778 0.427375
+ 4.3330556 0.449358
+ 4.3333333 0.459935
+ 4.3336111 0.457613
+ 4.3338889 0.443636
+ 4.3341667 0.419930
+ 4.3344444 0.388420
+ 4.3347222 0.351032
+ 4.3350000 0.309692
+ 4.3352778 0.266326
+ 4.3355556 0.222861
+ 4.3358333 0.181222
+ 4.3361111 0.143334
+ 4.3363889 0.110839
+ 4.3366667 0.084233
+ 4.3369444 0.063726
+ 4.3372222 0.050000
+ 4.3375000 0.050000
+ 4.3377778 0.050000
+ 4.3380556 0.050000
+ 4.3383333 0.060068
+ 4.3386111 0.080587
+ 4.3388889 0.108683
+ 4.3391667 0.144171
+ 4.3394444 0.185301
+ 4.3397222 0.229926
+ 4.3400000 0.275901
+ 4.3402778 0.321080
+ 4.3405556 0.363317
+ 4.3408333 0.400466
+ 4.3411111 0.430383
+ 4.3413889 0.450921
+ 4.3416667 0.459935
+ 4.3419444 0.455961
+ 4.3422222 0.440266
+ 4.3425000 0.414798
+ 4.3427778 0.381508
+ 4.3430556 0.342342
+ 4.3433333 0.299250
+ 4.3436111 0.254181
+ 4.3438889 0.209083
+ 4.3441667 0.165905
+ 4.3444444 0.126597
+ 4.3447222 0.092820
+ 4.3450000 0.065090
+ 4.3452778 0.050000
+ 4.3455556 0.050000
+ 4.3458333 0.050000
+ 4.3461111 0.050000
+ 4.3463889 0.050000
+ 4.3466667 0.050000
+ 4.3469444 0.059573
+ 4.3472222 0.088480
+ 4.3475000 0.125097
+ 4.3477778 0.167646
+ 4.3480556 0.213946
+ 4.3483333 0.261817
+ 4.3486111 0.309078
+ 4.3488889 0.353549
+ 4.3491667 0.393049
+ 4.3494444 0.425398
+ 4.3497222 0.448416
+ 4.3500000 0.459922
+ 4.3502778 0.458416
+ 4.3505556 0.445124
+ 4.3508333 0.421954
+ 4.3511111 0.390812
+ 4.3513889 0.353605
+ 4.3516667 0.312240
+ 4.3519444 0.268624
+ 4.3522222 0.224662
+ 4.3525000 0.182264
+ 4.3527778 0.143334
+ 4.3530556 0.109512
+ 4.3533333 0.081358
+ 4.3536111 0.059164
+ 4.3538889 0.050000
+ 4.3541667 0.050000
+ 4.3544444 0.050000
+ 4.3547222 0.050000
+ 4.3550000 0.050000
+ 4.3552778 0.067531
+ 4.3555556 0.095240
+ 4.3558333 0.130830
+ 4.3561111 0.172508
+ 4.3563889 0.218063
+ 4.3566667 0.265285
+ 4.3569444 0.311965
+ 4.3572222 0.355892
+ 4.3575000 0.394856
+ 4.3577778 0.426647
+ 4.3580556 0.449055
+ 4.3583333 0.459869
+ 4.3586111 0.457573
+ 4.3588889 0.443418
+ 4.3591667 0.419349
+ 4.3594444 0.387312
+ 4.3597222 0.349250
+ 4.3600000 0.307108
+ 4.3602778 0.262831
+ 4.3605556 0.218364
+ 4.3608333 0.175652
+ 4.3611111 0.136639
+ 4.3613889 0.102988
+ 4.3616667 0.075230
+ 4.3619444 0.053614
+ 4.3622222 0.050000
+ 4.3625000 0.050000
+ 4.3627778 0.050000
+ 4.3630556 0.050000
+ 4.3633333 0.050000
+ 4.3636111 0.066868
+ 4.3638889 0.095227
+ 4.3641667 0.131315
+ 4.3644444 0.173343
+ 4.3647222 0.219116
+ 4.3650000 0.266438
+ 4.3652778 0.313113
+ 4.3655556 0.356945
+ 4.3658333 0.395739
+ 4.3661111 0.427299
+ 4.3663889 0.449430
+ 4.3666667 0.459935
+ 4.3669444 0.457306
+ 4.3672222 0.442784
+ 4.3675000 0.418299
+ 4.3677778 0.385780
+ 4.3680556 0.347154
+ 4.3683333 0.304351
+ 4.3686111 0.259300
+ 4.3688889 0.213929
+ 4.3691667 0.170168
+ 4.3694444 0.129944
+ 4.3697222 0.094920
+ 4.3700000 0.065681
+ 4.3702778 0.050000
+ 4.3705556 0.050000
+ 4.3708333 0.050000
+ 4.3711111 0.050000
+ 4.3713889 0.050000
+ 4.3716667 0.050000
+ 4.3719444 0.050000
+ 4.3722222 0.078424
+ 4.3725000 0.115208
+ 4.3727778 0.158374
+ 4.3730556 0.205641
+ 4.3733333 0.254732
+ 4.3736111 0.303364
+ 4.3738889 0.349260
+ 4.3741667 0.390138
+ 4.3744444 0.423718
+ 4.3747222 0.447722
+ 4.3750000 0.459869
+ 4.3752778 0.458585
+ 4.3755556 0.445118
+ 4.3758333 0.421423
+ 4.3761111 0.389453
+ 4.3763889 0.351162
+ 4.3766667 0.308505
+ 4.3769444 0.263435
+ 4.3772222 0.217907
+ 4.3775000 0.173875
+ 4.3777778 0.133292
+ 4.3780556 0.097844
+ 4.3783333 0.068142
+ 4.3786111 0.050000
+ 4.3788889 0.050000
+ 4.3791667 0.050000
+ 4.3794444 0.050000
+ 4.3797222 0.050000
+ 4.3800000 0.050000
+ 4.3802778 0.050000
+ 4.3805556 0.078424
+ 4.3808333 0.115382
+ 4.3811111 0.158829
+ 4.3813889 0.206430
+ 4.3816667 0.255850
+ 4.3819444 0.304755
+ 4.3822222 0.350809
+ 4.3825000 0.391678
+ 4.3827778 0.425025
+ 4.3830556 0.448516
+ 4.3833333 0.459817
+ 4.3836111 0.457323
+ 4.3838889 0.442355
+ 4.3841667 0.416967
+ 4.3844444 0.383211
+ 4.3847222 0.343140
+ 4.3850000 0.298806
+ 4.3852778 0.252263
+ 4.3855556 0.205562
+ 4.3858333 0.160758
+ 4.3861111 0.119902
+ 4.3863889 0.084746
+ 4.3866667 0.055833
+ 4.3869444 0.050000
+ 4.3872222 0.050000
+ 4.3875000 0.050000
+ 4.3877778 0.050000
+ 4.3880556 0.050000
+ 4.3883333 0.050000
+ 4.3886111 0.050000
+ 4.3888889 0.078464
+ 4.3891667 0.116256
+ 4.3894444 0.160200
+ 4.3897222 0.208018
+ 4.3900000 0.257431
+ 4.3902778 0.306162
+ 4.3905556 0.351932
+ 4.3908333 0.392463
+ 4.3911111 0.425477
+ 4.3913889 0.448697
+ 4.3916667 0.459843
+ 4.3919444 0.457352
+ 4.3922222 0.442515
+ 4.3925000 0.417336
+ 4.3927778 0.383820
+ 4.3930556 0.343971
+ 4.3933333 0.299795
+ 4.3936111 0.253295
+ 4.3938889 0.206476
+ 4.3941667 0.161344
+ 4.3944444 0.119902
+ 4.3947222 0.083874
+ 4.3950000 0.053860
+ 4.3952778 0.050000
+ 4.3955556 0.050000
+ 4.3958333 0.050000
+ 4.3961111 0.050000
+ 4.3963889 0.050000
+ 4.3966667 0.050000
+ 4.3969444 0.050000
+ 4.3972222 0.068369
+ 4.3975000 0.106335
+ 4.3977778 0.150827
+ 4.3980556 0.199496
+ 4.3983333 0.249993
+ 4.3986111 0.299969
+ 4.3988889 0.347076
+ 4.3991667 0.388964
+ 4.3994444 0.423285
+ 4.3997222 0.447690
+ 4.4000000 0.459830
+ 4.4002778 0.458090
+ 4.4005556 0.443787
+ 4.4008333 0.418972
+ 4.4011111 0.385698
+ 4.4013889 0.346014
+ 4.4016667 0.301973
+ 4.4019444 0.255624
+ 4.4022222 0.209020
+ 4.4025000 0.164211
+ 4.4027778 0.123249
+ 4.4030556 0.087887
+ 4.4033333 0.058686
+ 4.4036111 0.050000
+ 4.4038889 0.050000
+ 4.4041667 0.050000
+ 4.4044444 0.050000
+ 4.4047222 0.050000
+ 4.4050000 0.050000
+ 4.4052778 0.050000
+ 4.4055556 0.078437
+ 4.4058333 0.116096
+ 4.4061111 0.159987
+ 4.4063889 0.207812
+ 4.4066667 0.257275
+ 4.4069444 0.306078
+ 4.4072222 0.351924
+ 4.4075000 0.392517
+ 4.4077778 0.425560
+ 4.4080556 0.448754
+ 4.4083333 0.459804
+ 4.4086111 0.457135
+ 4.4088889 0.442064
+ 4.4091667 0.416633
+ 4.4094444 0.382880
+ 4.4097222 0.342848
+ 4.4100000 0.298577
+ 4.4102778 0.252106
+ 4.4105556 0.205476
+ 4.4108333 0.160728
+ 4.4111111 0.119902
+ 4.4113889 0.084741
+ 4.4116667 0.055795
+ 4.4119444 0.050000
+ 4.4122222 0.050000
+ 4.4125000 0.050000
+ 4.4127778 0.050000
+ 4.4130556 0.050000
+ 4.4133333 0.050000
+ 4.4136111 0.050000
+ 4.4138889 0.078411
+ 4.4141667 0.116384
+ 4.4144444 0.160547
+ 4.4147222 0.208592
+ 4.4150000 0.258214
+ 4.4152778 0.307105
+ 4.4155556 0.352959
+ 4.4158333 0.393469
+ 4.4161111 0.426329
+ 4.4163889 0.449231
+ 4.4166667 0.459869
+ 4.4169444 0.456666
+ 4.4172222 0.440959
+ 4.4175000 0.414815
+ 4.4177778 0.380302
+ 4.4180556 0.339486
+ 4.4183333 0.294434
+ 4.4186111 0.247213
+ 4.4188889 0.199890
+ 4.4191667 0.154532
+ 4.4194444 0.113207
+ 4.4197222 0.077676
+ 4.4200000 0.050000
+ 4.4202778 0.050000
+ 4.4205556 0.050000
+ 4.4208333 0.050000
+ 4.4211111 0.050000
+ 4.4213889 0.050000
+ 4.4216667 0.050000
+ 4.4219444 0.050000
+ 4.4222222 0.071716
+ 4.4225000 0.109878
+ 4.4227778 0.154251
+ 4.4230556 0.202558
+ 4.4233333 0.252527
+ 4.4236111 0.301881
+ 4.4238889 0.348347
+ 4.4241667 0.389650
+ 4.4244444 0.423514
+ 4.4247222 0.447666
+ 4.4250000 0.459830
+ 4.4252778 0.458440
+ 4.4255556 0.444763
+ 4.4258333 0.420773
+ 4.4261111 0.388445
+ 4.4263889 0.349752
+ 4.4266667 0.306671
+ 4.4269444 0.261175
+ 4.4272222 0.215238
+ 4.4275000 0.170837
+ 4.4277778 0.129944
+ 4.4280556 0.094262
+ 4.4283333 0.064399
+ 4.4286111 0.050000
+ 4.4288889 0.050000
+ 4.4291667 0.050000
+ 4.4294444 0.050000
+ 4.4297222 0.050000
+ 4.4300000 0.050000
+ 4.4302778 0.050000
+ 4.4305556 0.075090
+ 4.4308333 0.112201
+ 4.4311111 0.155816
+ 4.4313889 0.203609
+ 4.4316667 0.253255
+ 4.4319444 0.302428
+ 4.4322222 0.348804
+ 4.4325000 0.390056
+ 4.4327778 0.423859
+ 4.4330556 0.447888
+ 4.4333333 0.459817
+ 4.4336111 0.458046
+ 4.4338889 0.443871
+ 4.4341667 0.419316
+ 4.4344444 0.386401
+ 4.4347222 0.347149
+ 4.4350000 0.303581
+ 4.4352778 0.257721
+ 4.4355556 0.211588
+ 4.4358333 0.167206
+ 4.4361111 0.126597
+ 4.4363889 0.091491
+ 4.4366667 0.062455
+ 4.4369444 0.050000
+ 4.4372222 0.050000
+ 4.4375000 0.050000
+ 4.4377778 0.050000
+ 4.4380556 0.050000
+ 4.4383333 0.050000
+ 4.4386111 0.052332
+ 4.4388889 0.081785
+ 4.4391667 0.119358
+ 4.4394444 0.163164
+ 4.4397222 0.210886
+ 4.4400000 0.260205
+ 4.4402778 0.308802
+ 4.4405556 0.354359
+ 4.4408333 0.394557
+ 4.4411111 0.427079
+ 4.4413889 0.449605
+ 4.4416667 0.459817
+ 4.4419444 0.456129
+ 4.4422222 0.439881
+ 4.4425000 0.413147
+ 4.4427778 0.377999
+ 4.4430556 0.336511
+ 4.4433333 0.290755
+ 4.4436111 0.242804
+ 4.4438889 0.194731
+ 4.4441667 0.148610
+ 4.4444444 0.106512
+ 4.4447222 0.070210
+ 4.4450000 0.050000
+ 4.4452778 0.050000
+ 4.4455556 0.050000
+ 4.4458333 0.050000
+ 4.4461111 0.050000
+ 4.4463889 0.050000
+ 4.4466667 0.050000
+ 4.4469444 0.050000
+ 4.4472222 0.061621
+ 4.4475000 0.100446
+ 4.4477778 0.145695
+ 4.4480556 0.195041
+ 4.4483333 0.246159
+ 4.4486111 0.296723
+ 4.4488889 0.344406
+ 4.4491667 0.386883
+ 4.4494444 0.421828
+ 4.4497222 0.446915
+ 4.4500000 0.459817
+ 4.4502778 0.458929
+ 4.4505556 0.445522
+ 4.4508333 0.421588
+ 4.4511111 0.389120
+ 4.4513889 0.350107
+ 4.4516667 0.306542
+ 4.4519444 0.260418
+ 4.4522222 0.213724
+ 4.4525000 0.168453
+ 4.4527778 0.126597
+ 4.4530556 0.089878
+ 4.4533333 0.058943
+ 4.4536111 0.050000
+ 4.4538889 0.050000
+ 4.4541667 0.050000
+ 4.4544444 0.050000
+ 4.4547222 0.050000
+ 4.4550000 0.050000
+ 4.4552778 0.050000
+ 4.4555556 0.065034
+ 4.4558333 0.102698
+ 4.4561111 0.147152
+ 4.4563889 0.196000
+ 4.4566667 0.246849
+ 4.4569444 0.297301
+ 4.4572222 0.344963
+ 4.4575000 0.387440
+ 4.4577778 0.422335
+ 4.4580556 0.447255
+ 4.4583333 0.459804
+ 4.4586111 0.458332
+ 4.4588889 0.444170
+ 4.4591667 0.419395
+ 4.4594444 0.386085
+ 4.4597222 0.346314
+ 4.4600000 0.302161
+ 4.4602778 0.255701
+ 4.4605556 0.209011
+ 4.4608333 0.164169
+ 4.4611111 0.123249
+ 4.4613889 0.088025
+ 4.4616667 0.059049
+ 4.4619444 0.050000
+ 4.4622222 0.050000
+ 4.4625000 0.050000
+ 4.4627778 0.050000
+ 4.4630556 0.050000
+ 4.4633333 0.050000
+ 4.4636111 0.051898
+ 4.4638889 0.081798
+ 4.4641667 0.119742
+ 4.4644444 0.163839
+ 4.4647222 0.211770
+ 4.4650000 0.261216
+ 4.4652778 0.309859
+ 4.4655556 0.355379
+ 4.4658333 0.395457
+ 4.4661111 0.427776
+ 4.4663889 0.450015
+ 4.4666667 0.459856
+ 4.4669444 0.455721
+ 4.4672222 0.438991
+ 4.4675000 0.411791
+ 4.4677778 0.376242
+ 4.4680556 0.334468
+ 4.4683333 0.288591
+ 4.4686111 0.240734
+ 4.4688889 0.193020
+ 4.4691667 0.147571
+ 4.4694444 0.106512
+ 4.4697222 0.071638
+ 4.4700000 0.050000
+ 4.4702778 0.050000
+ 4.4705556 0.050000
+ 4.4708333 0.050000
+ 4.4711111 0.050000
+ 4.4713889 0.050000
+ 4.4716667 0.050000
+ 4.4719444 0.050000
+ 4.4722222 0.078385
+ 4.4725000 0.117416
+ 4.4727778 0.162345
+ 4.4730556 0.210888
+ 4.4733333 0.260758
+ 4.4736111 0.309672
+ 4.4738889 0.355343
+ 4.4741667 0.395486
+ 4.4744444 0.427816
+ 4.4747222 0.450047
+ 4.4750000 0.459895
+ 4.4752778 0.455816
+ 4.4755556 0.439235
+ 4.4758333 0.412319
+ 4.4761111 0.377235
+ 4.4763889 0.336150
+ 4.4766667 0.291231
+ 4.4769444 0.244645
+ 4.4772222 0.198559
+ 4.4775000 0.155140
+ 4.4777778 0.116554
+ 4.4780556 0.084609
+ 4.4783333 0.059662
+ 4.4786111 0.050000
+ 4.4788889 0.050000
+ 4.4791667 0.050000
+ 4.4794444 0.050000
+ 4.4797222 0.050000
+ 4.4800000 0.056885
+ 4.4802778 0.080892
+ 4.4805556 0.111886
+ 4.4808333 0.149520
+ 4.4811111 0.192064
+ 4.4813889 0.237440
+ 4.4816667 0.283574
+ 4.4819444 0.328388
+ 4.4822222 0.369807
+ 4.4825000 0.405753
+ 4.4827778 0.434152
+ 4.4830556 0.452926
+ 4.4833333 0.460000
+ 4.4836111 0.453986
+ 4.4838889 0.436256
+ 4.4841667 0.408870
+ 4.4844444 0.373890
+ 4.4847222 0.333374
+ 4.4850000 0.289385
+ 4.4852778 0.243983
+ 4.4855556 0.199228
+ 4.4858333 0.157180
+ 4.4861111 0.119902
+ 4.4863889 0.089108
+ 4.4866667 0.065140
+ 4.4869444 0.050000
+ 4.4872222 0.050000
+ 4.4875000 0.050000
+ 4.4877778 0.050000
+ 4.4880556 0.050000
+ 4.4883333 0.064442
+ 4.4886111 0.088141
+ 4.4888889 0.118634
+ 4.4891667 0.155580
+ 4.4894444 0.197294
+ 4.4897222 0.241754
+ 4.4900000 0.286938
+ 4.4902778 0.330823
+ 4.4905556 0.371388
+ 4.4908333 0.406610
+ 4.4911111 0.434467
+ 4.4913889 0.452938
+ 4.4916667 0.460000
+ 4.4919444 0.454303
+ 4.4922222 0.437182
+ 4.4925000 0.410647
+ 4.4927778 0.376704
+ 4.4930556 0.337362
+ 4.4933333 0.294629
+ 4.4936111 0.250513
+ 4.4938889 0.207021
+ 4.4941667 0.166163
+ 4.4944444 0.129944
+ 4.4947222 0.100039
+ 4.4950000 0.076773
+ 4.4952778 0.060139
+ 4.4955556 0.050128
+ 4.4958333 0.050000
+ 4.4961111 0.050000
+ 4.4963889 0.059746
+ 4.4966667 0.076141
+ 4.4969444 0.099116
+ 4.4972222 0.128663
+ 4.4975000 0.164449
+ 4.4977778 0.204848
+ 4.4980556 0.247910
+ 4.4983333 0.291684
+ 4.4986111 0.334221
+ 4.4988889 0.373569
+ 4.4991667 0.407779
+ 4.4994444 0.434901
+ 4.4997222 0.452984
+ 4.5000000 0.460078
+ 4.5002778 0.454879
+ 4.5005556 0.438666
+ 4.5008333 0.413361
+ 4.5011111 0.380890
+ 4.5013889 0.343178
+ 4.5016667 0.302147
+ 4.5019444 0.259724
+ 4.5022222 0.217831
+ 4.5025000 0.178393
+ 4.5027778 0.143334
+ 4.5030556 0.114261
+ 4.5033333 0.091507
+ 4.5036111 0.075085
+ 4.5038889 0.065012
+ 4.5041667 0.061301
+ 4.5044444 0.063968
+ 4.5047222 0.073027
+ 4.5050000 0.088493
+ 4.5052778 0.110381
+ 4.5055556 0.138705
+ 4.5058333 0.173162
+ 4.5061111 0.212170
+ 4.5063889 0.253829
+ 4.5066667 0.296239
+ 4.5069444 0.337500
+ 4.5072222 0.375712
+ 4.5075000 0.408975
+ 4.5077778 0.435388
+ 4.5080556 0.453051
+ 4.5083333 0.460065
+ 4.5086111 0.455153
+ 4.5088889 0.439533
+ 4.5091667 0.415045
+ 4.5094444 0.383532
+ 4.5097222 0.346835
+ 4.5100000 0.306794
+ 4.5102778 0.265252
+ 4.5105556 0.224050
+ 4.5108333 0.185028
+ 4.5111111 0.150029
+ 4.5113889 0.120603
+ 4.5116667 0.097137
+ 4.5119444 0.079725
+ 4.5122222 0.068465
+ 4.5125000 0.063451
+ 4.5127778 0.064780
+ 4.5130556 0.072547
+ 4.5133333 0.086848
+ 4.5136111 0.107780
+ 4.5138889 0.135436
+ 4.5141667 0.169572
+ 4.5144444 0.208567
+ 4.5147222 0.250460
+ 4.5150000 0.293290
+ 4.5152778 0.335095
+ 4.5155556 0.373914
+ 4.5158333 0.407784
+ 4.5161111 0.434745
+ 4.5163889 0.452835
+ 4.5166667 0.460092
+ 4.5169444 0.455195
+ 4.5172222 0.439392
+ 4.5175000 0.414567
+ 4.5177778 0.382607
+ 4.5180556 0.345400
+ 4.5183333 0.304832
+ 4.5186111 0.262790
+ 4.5188889 0.221159
+ 4.5191667 0.181828
+ 4.5194444 0.146682
+ 4.5197222 0.117303
+ 4.5200000 0.094052
+ 4.5202778 0.076986
+ 4.5205556 0.066159
+ 4.5208333 0.061629
+ 4.5211111 0.063452
+ 4.5213889 0.071682
+ 4.5216667 0.086377
+ 4.5219444 0.107592
+ 4.5222222 0.135384
+ 4.5225000 0.169481
+ 4.5227778 0.208303
+ 4.5230556 0.249942
+ 4.5233333 0.292490
+ 4.5236111 0.334041
+ 4.5238889 0.372687
+ 4.5241667 0.406520
+ 4.5244444 0.433632
+ 4.5247222 0.452116
+ 4.5250000 0.460065
+ 4.5252778 0.456184
+ 4.5255556 0.441630
+ 4.5258333 0.418173
+ 4.5261111 0.387583
+ 4.5263889 0.351630
+ 4.5266667 0.312085
+ 4.5269444 0.270716
+ 4.5272222 0.229296
+ 4.5275000 0.189593
+ 4.5277778 0.153377
+ 4.5280556 0.122165
+ 4.5283333 0.096458
+ 4.5286111 0.076504
+ 4.5288889 0.062550
+ 4.5291667 0.054842
+ 4.5294444 0.053630
+ 4.5297222 0.059159
+ 4.5300000 0.071678
+ 4.5302778 0.091433
+ 4.5305556 0.118673
+ 4.5308333 0.153247
+ 4.5311111 0.193418
+ 4.5313889 0.237050
+ 4.5316667 0.282009
+ 4.5319444 0.326160
+ 4.5322222 0.367368
+ 4.5325000 0.403497
+ 4.5327778 0.432413
+ 4.5330556 0.451981
+ 4.5333333 0.460065
+ 4.5336111 0.455229
+ 4.5338889 0.438821
+ 4.5341667 0.412890
+ 4.5344444 0.379481
+ 4.5347222 0.340642
+ 4.5350000 0.298420
+ 4.5352778 0.254861
+ 4.5355556 0.212014
+ 4.5358333 0.171924
+ 4.5361111 0.136639
+ 4.5363889 0.107853
+ 4.5366667 0.085848
+ 4.5369444 0.070554
+ 4.5372222 0.061898
+ 4.5375000 0.059811
+ 4.5377778 0.064222
+ 4.5380556 0.075060
+ 4.5383333 0.092254
+ 4.5386111 0.115733
+ 4.5388889 0.145427
+ 4.5391667 0.180955
+ 4.5394444 0.220706
+ 4.5397222 0.262756
+ 4.5400000 0.305184
+ 4.5402778 0.346067
+ 4.5405556 0.383485
+ 4.5408333 0.415514
+ 4.5411111 0.440233
+ 4.5413889 0.455720
+ 4.5416667 0.460052
+ 4.5419444 0.451955
+ 4.5422222 0.432737
+ 4.5425000 0.404352
+ 4.5427778 0.368755
+ 4.5430556 0.327902
+ 4.5433333 0.283747
+ 4.5436111 0.238246
+ 4.5438889 0.193352
+ 4.5441667 0.151021
+ 4.5444444 0.113207
+ 4.5447222 0.081554
+ 4.5450000 0.056458
+ 4.5452778 0.050000
+ 4.5455556 0.050000
+ 4.5458333 0.050000
+ 4.5461111 0.050000
+ 4.5463889 0.050000
+ 4.5466667 0.050000
+ 4.5469444 0.071424
+ 4.5472222 0.101805
+ 4.5475000 0.139137
+ 4.5477778 0.181695
+ 4.5480556 0.227394
+ 4.5483333 0.274147
+ 4.5486111 0.319868
+ 4.5488889 0.362471
+ 4.5491667 0.399869
+ 4.5494444 0.429976
+ 4.5497222 0.450707
+ 4.5500000 0.459974
+ 4.5502778 0.456355
+ 4.5505556 0.441081
+ 4.5508333 0.416045
+ 4.5511111 0.383143
+ 4.5513889 0.344268
+ 4.5516667 0.301314
+ 4.5519444 0.256176
+ 4.5522222 0.210747
+ 4.5525000 0.166923
+ 4.5527778 0.126597
+ 4.5530556 0.091406
+ 4.5533333 0.061957
+ 4.5536111 0.050000
+ 4.5538889 0.050000
+ 4.5541667 0.050000
+ 4.5544444 0.050000
+ 4.5547222 0.050000
+ 4.5550000 0.050000
+ 4.5552778 0.050000
+ 4.5555556 0.075064
+ 4.5558333 0.112584
+ 4.5561111 0.156629
+ 4.5563889 0.204830
+ 4.5566667 0.254821
+ 4.5569444 0.304235
+ 4.5572222 0.350705
+ 4.5575000 0.391863
+ 4.5577778 0.425344
+ 4.5580556 0.448780
+ 4.5583333 0.459804
+ 4.5586111 0.456792
+ 4.5588889 0.441094
+ 4.5591667 0.414801
+ 4.5594444 0.380006
+ 4.5597222 0.338801
+ 4.5600000 0.293279
+ 4.5602778 0.245532
+ 4.5605556 0.197651
+ 4.5608333 0.151729
+ 4.5611111 0.109859
+ 4.5613889 0.073827
+ 4.5616667 0.050000
+ 4.5619444 0.050000
+ 4.5622222 0.050000
+ 4.5625000 0.050000
+ 4.5627778 0.050000
+ 4.5630556 0.050000
+ 4.5633333 0.050000
+ 4.5636111 0.050000
+ 4.5638889 0.068356
+ 4.5641667 0.107440
+ 4.5644444 0.152862
+ 4.5647222 0.202251
+ 4.5650000 0.253235
+ 4.5652778 0.303442
+ 4.5655556 0.350500
+ 4.5658333 0.392037
+ 4.5661111 0.425681
+ 4.5663889 0.449061
+ 4.5666667 0.459804
+ 4.5669444 0.456288
+ 4.5672222 0.439888
+ 4.5675000 0.412728
+ 4.5677778 0.376934
+ 4.5680556 0.334630
+ 4.5683333 0.287940
+ 4.5686111 0.238990
+ 4.5688889 0.189902
+ 4.5691667 0.142803
+ 4.5694444 0.099817
+ 4.5697222 0.062759
+ 4.5700000 0.050000
+ 4.5702778 0.050000
+ 4.5705556 0.050000
+ 4.5708333 0.050000
+ 4.5711111 0.050000
+ 4.5713889 0.050000
+ 4.5716667 0.050000
+ 4.5719444 0.050000
+ 4.5722222 0.054874
+ 4.5725000 0.094729
+ 4.5727778 0.141139
+ 4.5730556 0.191700
+ 4.5733333 0.244006
+ 4.5736111 0.295651
+ 4.5738889 0.344230
+ 4.5741667 0.387336
+ 4.5744444 0.422565
+ 4.5747222 0.447509
+ 4.5750000 0.459765
+ 4.5752778 0.457676
+ 4.5755556 0.442595
+ 4.5758333 0.416624
+ 4.5761111 0.381865
+ 4.5763889 0.340422
+ 4.5766667 0.294395
+ 4.5769444 0.245888
+ 4.5772222 0.197004
+ 4.5775000 0.149844
+ 4.5777778 0.106512
+ 4.5780556 0.068815
+ 4.5783333 0.050000
+ 4.5786111 0.050000
+ 4.5788889 0.050000
+ 4.5791667 0.050000
+ 4.5794444 0.050000
+ 4.5797222 0.050000
+ 4.5800000 0.050000
+ 4.5802778 0.050000
+ 4.5805556 0.051579
+ 4.5808333 0.091115
+ 4.5811111 0.137474
+ 4.5813889 0.188204
+ 4.5816667 0.240853
+ 4.5819444 0.292969
+ 4.5822222 0.342100
+ 4.5825000 0.385793
+ 4.5827778 0.421596
+ 4.5830556 0.447058
+ 4.5833333 0.459725
+ 4.5836111 0.457911
+ 4.5838889 0.442977
+ 4.5841667 0.417052
+ 4.5844444 0.382263
+ 4.5847222 0.340737
+ 4.5850000 0.294602
+ 4.5852778 0.245985
+ 4.5855556 0.197012
+ 4.5858333 0.149812
+ 4.5861111 0.106512
+ 4.5863889 0.068937
+ 4.5866667 0.050000
+ 4.5869444 0.050000
+ 4.5872222 0.050000
+ 4.5875000 0.050000
+ 4.5877778 0.050000
+ 4.5880556 0.050000
+ 4.5883333 0.050000
+ 4.5886111 0.050000
+ 4.5888889 0.054940
+ 4.5891667 0.094820
+ 4.5894444 0.141455
+ 4.5897222 0.192362
+ 4.5900000 0.245058
+ 4.5902778 0.297061
+ 4.5905556 0.345888
+ 4.5908333 0.389057
+ 4.5911111 0.424085
+ 4.5913889 0.448491
+ 4.5916667 0.459791
+ 4.5919444 0.456287
+ 4.5922222 0.439416
+ 4.5925000 0.411400
+ 4.5927778 0.374458
+ 4.5930556 0.330814
+ 4.5933333 0.282687
+ 4.5936111 0.232298
+ 4.5938889 0.181869
+ 4.5941667 0.133621
+ 4.5944444 0.089774
+ 4.5947222 0.052219
+ 4.5950000 0.050000
+ 4.5952778 0.050000
+ 4.5955556 0.050000
+ 4.5958333 0.050000
+ 4.5961111 0.050000
+ 4.5963889 0.050000
+ 4.5966667 0.050000
+ 4.5969444 0.050000
+ 4.5972222 0.050000
+ 4.5975000 0.090815
+ 4.5977778 0.138121
+ 4.5980556 0.189496
+ 4.5983333 0.242520
+ 4.5986111 0.294774
+ 4.5988889 0.343835
+ 4.5991667 0.387284
+ 4.5994444 0.422700
+ 4.5997222 0.447663
+ 4.6000000 0.459752
+ 4.6002778 0.457306
+ 4.6005556 0.441704
+ 4.6008333 0.415083
+ 4.6011111 0.379582
+ 4.6013889 0.337339
+ 4.6016667 0.290491
+ 4.6019444 0.241177
+ 4.6022222 0.191535
+ 4.6025000 0.143702
+ 4.6027778 0.099817
+ 4.6030556 0.061719
+ 4.6033333 0.050000
+ 4.6036111 0.050000
+ 4.6038889 0.050000
+ 4.6041667 0.050000
+ 4.6044444 0.050000
+ 4.6047222 0.050000
+ 4.6050000 0.050000
+ 4.6052778 0.050000
+ 4.6055556 0.050000
+ 4.6058333 0.091365
+ 4.6061111 0.139657
+ 4.6063889 0.192246
+ 4.6066667 0.246501
+ 4.6069444 0.299791
+ 4.6072222 0.349484
+ 4.6075000 0.392950
+ 4.6077778 0.427558
+ 4.6080556 0.450676
+ 4.6083333 0.459673
+ 4.6086111 0.452775
+ 4.6088889 0.431629
+ 4.6091667 0.398739
+ 4.6094444 0.356609
+ 4.6097222 0.307743
+ 4.6100000 0.254644
+ 4.6102778 0.199817
+ 4.6105556 0.145765
+ 4.6108333 0.094991
+ 4.6111111 0.050000
+ 4.6113889 0.050000
+ 4.6116667 0.050000
+ 4.6119444 0.050000
+ 4.6122222 0.050000
+ 4.6125000 0.050000
+ 4.6127778 0.050000
+ 4.6130556 0.050000
+ 4.6133333 0.050000
+ 4.6136111 0.050000
+ 4.6138889 0.050000
+ 4.6141667 0.094780
+ 4.6144444 0.145281
+ 4.6147222 0.199037
+ 4.6150000 0.253584
+ 4.6152778 0.306455
+ 4.6155556 0.355186
+ 4.6158333 0.397311
+ 4.6161111 0.430365
+ 4.6163889 0.451883
+ 4.6166667 0.459398
+ 4.6169444 0.451275
+ 4.6172222 0.429187
+ 4.6175000 0.395636
+ 4.6177778 0.353125
+ 4.6180556 0.304155
+ 4.6183333 0.251228
+ 4.6186111 0.196847
+ 4.6188889 0.143514
+ 4.6191667 0.093731
+ 4.6194444 0.050000
+ 4.6197222 0.050000
+ 4.6200000 0.050000
+ 4.6202778 0.050000
+ 4.6205556 0.050000
+ 4.6208333 0.050000
+ 4.6211111 0.050000
+ 4.6213889 0.050000
+ 4.6216667 0.050000
+ 4.6219444 0.050000
+ 4.6222222 0.050000
+ 4.6225000 0.090077
+ 4.6227778 0.135162
+ 4.6230556 0.183449
+ 4.6233333 0.233133
+ 4.6236111 0.282406
+ 4.6238889 0.329463
+ 4.6241667 0.372498
+ 4.6244444 0.409706
+ 4.6247222 0.439279
+ 4.6250000 0.459412
+ 4.6252778 0.468835
+ 4.6255556 0.468424
+ 4.6258333 0.459591
+ 4.6261111 0.443749
+ 4.6263889 0.422310
+ 4.6266667 0.396685
+ 4.6269444 0.368288
+ 4.6272222 0.338530
+ 4.6275000 0.308824
+ 4.6277778 0.280582
+ 4.6280556 0.255030
+ 4.6283333 0.232648
+ 4.6286111 0.213731
+ 4.6288889 0.198573
+ 4.6291667 0.187469
+ 4.6294444 0.180712
+ 4.6297222 0.178598
+ 4.6300000 0.181421
+ 4.6302778 0.189474
+ 4.6305556 0.203053
+ 4.6308333 0.222259
+ 4.6311111 0.246420
+ 4.6313889 0.274674
+ 4.6316667 0.306156
+ 4.6319444 0.340003
+ 4.6322222 0.375350
+ 4.6325000 0.411335
+ 4.6327778 0.447094
+ 4.6330556 0.481761
+ 4.6333333 0.514475
+ 4.6336111 0.544356
+ 4.6338889 0.570461
+ 4.6341667 0.591834
+ 4.6344444 0.607517
+ 4.6347222 0.616553
+ 4.6350000 0.617984
+ 4.6352778 0.610854
+ 4.6355556 0.594204
+ 4.6358333 0.567079
+ 4.6361111 0.528519
+ 4.6363889 0.478315
+ 4.6366667 0.419242
+ 4.6369444 0.354822
+ 4.6372222 0.288577
+ 4.6375000 0.224028
+ 4.6377778 0.164697
+ 4.6380556 0.114108
+ 4.6383333 0.075780
+ 4.6386111 0.053237
+ 4.6388889 0.050000
+ 4.6391667 0.068253
+ 4.6394444 0.104828
+ 4.6397222 0.155220
+ 4.6400000 0.214922
+ 4.6402778 0.279428
+ 4.6405556 0.344233
+ 4.6408333 0.404830
+ 4.6411111 0.456715
+ 4.6413889 0.495379
+ 4.6416667 0.516319
+ 4.6419444 0.516405
+ 4.6422222 0.498016
+ 4.6425000 0.464910
+ 4.6427778 0.420844
+ 4.6430556 0.369573
+ 4.6433333 0.314856
+ 4.6436111 0.260448
+ 4.6438889 0.210107
+ 4.6441667 0.167590
+ 4.6444444 0.136653
+ 4.6447222 0.120114
+ 4.6450000 0.117041
+ 4.6452778 0.125560
+ 4.6455556 0.143799
+ 4.6458333 0.169886
+ 4.6461111 0.201949
+ 4.6463889 0.238116
+ 4.6466667 0.276514
+ 4.6469444 0.315271
+ 4.6472222 0.352514
+ 4.6475000 0.386602
+ 4.6477778 0.416815
+ 4.6480556 0.442662
+ 4.6483333 0.463653
+ 4.6486111 0.479299
+ 4.6488889 0.489109
+ 4.6491667 0.492594
+ 4.6494444 0.489264
+ 4.6497222 0.478628
+ 4.6500000 0.460196
+ 4.6502778 0.433796
+ 4.6505556 0.400523
+ 4.6508333 0.361787
+ 4.6511111 0.319002
+ 4.6513889 0.273578
+ 4.6516667 0.226928
+ 4.6519444 0.180463
+ 4.6522222 0.135596
+ 4.6525000 0.093737
+ 4.6527778 0.056299
+ 4.6530556 0.050000
+ 4.6533333 0.050000
+ 4.6536111 0.050000
+ 4.6538889 0.050000
+ 4.6541667 0.050000
+ 4.6544444 0.050000
+ 4.6547222 0.050000
+ 4.6550000 0.050000
+ 4.6552778 0.050000
+ 4.6555556 0.050000
+ 4.6558333 0.092451
+ 4.6561111 0.141218
+ 4.6563889 0.193808
+ 4.6566667 0.247727
+ 4.6569444 0.300479
+ 4.6572222 0.349571
+ 4.6575000 0.392508
+ 4.6577778 0.426797
+ 4.6580556 0.449943
+ 4.6583333 0.459451
+ 4.6586111 0.453638
+ 4.6588889 0.434063
+ 4.6591667 0.403095
+ 4.6594444 0.363104
+ 4.6597222 0.316458
+ 4.6600000 0.265528
+ 4.6602778 0.212681
+ 4.6605556 0.160289
+ 4.6608333 0.110719
+ 4.6611111 0.066342
+ 4.6613889 0.050000
+ 4.6616667 0.050000
+ 4.6619444 0.050000
+ 4.6622222 0.050000
+ 4.6625000 0.050000
+ 4.6627778 0.050000
+ 4.6630556 0.050000
+ 4.6633333 0.050000
+ 4.6636111 0.050000
+ 4.6638889 0.050000
+ 4.6641667 0.093109
+ 4.6644444 0.142264
+ 4.6647222 0.195017
+ 4.6650000 0.248924
+ 4.6652778 0.301537
+ 4.6655556 0.350413
+ 4.6658333 0.393103
+ 4.6661111 0.427163
+ 4.6663889 0.450147
+ 4.6666667 0.459608
+ 4.6669444 0.453898
+ 4.6672222 0.434558
+ 4.6675000 0.403925
+ 4.6677778 0.364338
+ 4.6680556 0.318134
+ 4.6683333 0.267651
+ 4.6686111 0.215227
+ 4.6688889 0.163201
+ 4.6691667 0.113909
+ 4.6694444 0.069689
+ 4.6697222 0.050000
+ 4.6700000 0.050000
+ 4.6702778 0.050000
+ 4.6705556 0.050000
+ 4.6708333 0.050000
+ 4.6711111 0.050000
+ 4.6713889 0.050000
+ 4.6716667 0.050000
+ 4.6719444 0.050000
+ 4.6722222 0.050000
+ 4.6725000 0.092711
+ 4.6727778 0.141527
+ 4.6730556 0.194012
+ 4.6733333 0.247733
+ 4.6736111 0.300254
+ 4.6738889 0.349140
+ 4.6741667 0.391958
+ 4.6744444 0.426271
+ 4.6747222 0.449646
+ 4.6750000 0.459647
+ 4.6752778 0.454628
+ 4.6755556 0.436093
+ 4.6758333 0.406335
+ 4.6761111 0.367648
+ 4.6763889 0.322323
+ 4.6766667 0.272653
+ 4.6769444 0.220932
+ 4.6772222 0.169452
+ 4.6775000 0.120505
+ 4.6777778 0.076384
+ 4.6780556 0.050000
+ 4.6783333 0.050000
+ 4.6786111 0.050000
+ 4.6788889 0.050000
+ 4.6791667 0.050000
+ 4.6794444 0.050000
+ 4.6797222 0.050000
+ 4.6800000 0.050000
+ 4.6802778 0.050000
+ 4.6805556 0.050000
+ 4.6808333 0.092336
+ 4.6811111 0.140947
+ 4.6813889 0.193366
+ 4.6816667 0.247125
+ 4.6819444 0.299755
+ 4.6822222 0.348788
+ 4.6825000 0.391755
+ 4.6827778 0.426189
+ 4.6830556 0.449620
+ 4.6833333 0.459582
+ 4.6836111 0.454402
+ 4.6838889 0.435601
+ 4.6841667 0.405499
+ 4.6844444 0.366412
+ 4.6847222 0.320659
+ 4.6850000 0.270558
+ 4.6852778 0.218427
+ 4.6855556 0.166584
+ 4.6858333 0.117348
+ 4.6861111 0.073037
+ 4.6863889 0.050000
+ 4.6866667 0.050000
+ 4.6869444 0.050000
+ 4.6872222 0.050000
+ 4.6875000 0.050000
+ 4.6877778 0.050000
+ 4.6880556 0.050000
+ 4.6883333 0.050000
+ 4.6886111 0.050000
+ 4.6888889 0.050000
+ 4.6891667 0.092998
+ 4.6894444 0.142256
+ 4.6897222 0.195259
+ 4.6900000 0.249487
+ 4.6902778 0.302425
+ 4.6905556 0.351555
+ 4.6908333 0.394359
+ 4.6911111 0.428321
+ 4.6913889 0.450922
+ 4.6916667 0.459647
+ 4.6919444 0.452804
+ 4.6922222 0.432007
+ 4.6925000 0.399699
+ 4.6927778 0.358321
+ 4.6930556 0.310314
+ 4.6933333 0.258120
+ 4.6936111 0.204180
+ 4.6938889 0.150936
+ 4.6941667 0.100828
+ 4.6944444 0.056299
+ 4.6947222 0.050000
+ 4.6950000 0.050000
+ 4.6952778 0.050000
+ 4.6955556 0.050000
+ 4.6958333 0.050000
+ 4.6961111 0.050000
+ 4.6963889 0.050000
+ 4.6966667 0.050000
+ 4.6969444 0.050000
+ 4.6972222 0.050000
+ 4.6975000 0.093536
+ 4.6977778 0.142834
+ 4.6980556 0.195519
+ 4.6983333 0.249217
+ 4.6986111 0.301550
+ 4.6988889 0.350146
+ 4.6991667 0.392627
+ 4.6994444 0.426619
+ 4.6997222 0.449746
+ 4.7000000 0.459634
+ 4.7002778 0.454678
+ 4.7005556 0.436364
+ 4.7008333 0.406947
+ 4.7011111 0.368686
+ 4.7013889 0.323835
+ 4.7016667 0.274653
+ 4.7019444 0.223394
+ 4.7022222 0.172317
+ 4.7025000 0.123677
+ 4.7027778 0.079732
+ 4.7030556 0.050000
+ 4.7033333 0.050000
+ 4.7036111 0.050000
+ 4.7038889 0.050000
+ 4.7041667 0.050000
+ 4.7044444 0.050000
+ 4.7047222 0.050000
+ 4.7050000 0.050000
+ 4.7052778 0.050000
+ 4.7055556 0.050000
+ 4.7058333 0.092018
+ 4.7061111 0.140388
+ 4.7063889 0.192640
+ 4.7066667 0.246303
+ 4.7069444 0.298909
+ 4.7072222 0.347986
+ 4.7075000 0.391064
+ 4.7077778 0.425674
+ 4.7080556 0.449345
+ 4.7083333 0.459608
+ 4.7086111 0.454786
+ 4.7088889 0.436386
+ 4.7091667 0.406708
+ 4.7094444 0.368052
+ 4.7097222 0.322717
+ 4.7100000 0.273005
+ 4.7102778 0.221215
+ 4.7105556 0.169649
+ 4.7108333 0.120605
+ 4.7111111 0.076384
+ 4.7113889 0.050000
+ 4.7116667 0.050000
+ 4.7119444 0.050000
+ 4.7122222 0.050000
+ 4.7125000 0.050000
+ 4.7127778 0.050000
+ 4.7130556 0.050000
+ 4.7133333 0.050000
+ 4.7136111 0.050000
+ 4.7138889 0.050000
+ 4.7141667 0.092533
+ 4.7144444 0.141368
+ 4.7147222 0.194011
+ 4.7150000 0.247968
+ 4.7152778 0.300745
+ 4.7155556 0.349849
+ 4.7158333 0.392786
+ 4.7161111 0.427063
+ 4.7163889 0.450185
+ 4.7166667 0.459660
+ 4.7169444 0.453804
+ 4.7172222 0.434180
+ 4.7175000 0.403161
+ 4.7177778 0.363121
+ 4.7180556 0.316433
+ 4.7183333 0.265470
+ 4.7186111 0.212607
+ 4.7188889 0.160215
+ 4.7191667 0.110669
+ 4.7194444 0.066342
+ 4.7197222 0.050000
+ 4.7200000 0.050000
+ 4.7202778 0.050000
+ 4.7205556 0.050000
+ 4.7208333 0.050000
+ 4.7211111 0.050000
+ 4.7213889 0.050000
+ 4.7216667 0.050000
+ 4.7219444 0.050000
+ 4.7222222 0.050000
+ 4.7225000 0.092783
+ 4.7227778 0.141559
+ 4.7230556 0.193928
+ 4.7233333 0.247491
+ 4.7236111 0.299852
+ 4.7238889 0.348611
+ 4.7241667 0.391370
+ 4.7244444 0.425730
+ 4.7247222 0.449293
+ 4.7250000 0.459660
+ 4.7252778 0.455207
+ 4.7255556 0.437400
+ 4.7258333 0.408480
+ 4.7261111 0.370688
+ 4.7263889 0.326264
+ 4.7266667 0.277448
+ 4.7269444 0.226481
+ 4.7272222 0.175604
+ 4.7275000 0.127056
+ 4.7277778 0.083079
+ 4.7280556 0.050000
+ 4.7283333 0.050000
+ 4.7286111 0.050000
+ 4.7288889 0.050000
+ 4.7291667 0.050000
+ 4.7294444 0.050000
+ 4.7297222 0.050000
+ 4.7300000 0.050000
+ 4.7302778 0.050000
+ 4.7305556 0.050000
+ 4.7308333 0.091974
+ 4.7311111 0.140403
+ 4.7313889 0.192782
+ 4.7316667 0.246606
+ 4.7319444 0.299369
+ 4.7322222 0.348568
+ 4.7325000 0.391696
+ 4.7327778 0.426249
+ 4.7330556 0.449721
+ 4.7333333 0.459608
+ 4.7336111 0.454213
+ 4.7338889 0.435080
+ 4.7341667 0.404561
+ 4.7344444 0.365007
+ 4.7347222 0.318771
+ 4.7350000 0.268206
+ 4.7352778 0.215663
+ 4.7355556 0.163494
+ 4.7358333 0.114052
+ 4.7361111 0.069689
+ 4.7363889 0.050000
+ 4.7366667 0.050000
+ 4.7369444 0.050000
+ 4.7372222 0.050000
+ 4.7375000 0.050000
+ 4.7377778 0.050000
+ 4.7380556 0.050000
+ 4.7383333 0.050000
+ 4.7386111 0.050000
+ 4.7388889 0.050000
+ 4.7391667 0.092897
+ 4.7394444 0.141917
+ 4.7397222 0.194602
+ 4.7400000 0.248495
+ 4.7402778 0.301139
+ 4.7405556 0.350077
+ 4.7408333 0.392852
+ 4.7411111 0.427005
+ 4.7413889 0.450081
+ 4.7416667 0.459621
+ 4.7419444 0.453968
+ 4.7422222 0.434663
+ 4.7425000 0.404048
+ 4.7427778 0.364463
+ 4.7430556 0.318249
+ 4.7433333 0.267748
+ 4.7436111 0.215301
+ 4.7438889 0.163248
+ 4.7441667 0.113930
+ 4.7444444 0.069689
+ 4.7447222 0.050000
+ 4.7450000 0.050000
+ 4.7452778 0.050000
+ 4.7455556 0.050000
+ 4.7458333 0.050000
+ 4.7461111 0.050000
+ 4.7463889 0.050000
+ 4.7466667 0.050000
+ 4.7469444 0.050000
+ 4.7472222 0.050000
+ 4.7475000 0.092712
+ 4.7477778 0.141526
+ 4.7480556 0.194008
+ 4.7483333 0.247723
+ 4.7486111 0.300238
+ 4.7488889 0.349117
+ 4.7491667 0.391927
+ 4.7494444 0.426233
+ 4.7497222 0.449600
+ 4.7500000 0.459595
+ 4.7502778 0.454570
+ 4.7505556 0.436031
+ 4.7508333 0.406271
+ 4.7511111 0.367584
+ 4.7513889 0.322261
+ 4.7516667 0.272597
+ 4.7519444 0.220884
+ 4.7522222 0.169416
+ 4.7525000 0.120485
+ 4.7527778 0.076384
+ 4.7530556 0.050000
+ 4.7533333 0.050000
+ 4.7536111 0.050000
+ 4.7538889 0.050000
+ 4.7541667 0.050000
+ 4.7544444 0.050000
+ 4.7547222 0.050000
+ 4.7550000 0.050000
+ 4.7552778 0.050000
+ 4.7555556 0.050000
+ 4.7558333 0.092259
+ 4.7561111 0.140782
+ 4.7563889 0.193111
+ 4.7566667 0.246790
+ 4.7569444 0.299360
+ 4.7572222 0.348364
+ 4.7575000 0.391345
+ 4.7577778 0.425844
+ 4.7580556 0.449405
+ 4.7583333 0.459568
+ 4.7586111 0.454671
+ 4.7588889 0.436218
+ 4.7591667 0.406507
+ 4.7594444 0.367838
+ 4.7597222 0.322507
+ 4.7600000 0.272814
+ 4.7602778 0.221057
+ 4.7605556 0.169534
+ 4.7608333 0.120544
+ 4.7611111 0.076384
+ 4.7613889 0.050000
+ 4.7616667 0.050000
+ 4.7619444 0.050000
+ 4.7622222 0.050000
+ 4.7625000 0.050000
+ 4.7627778 0.050000
+ 4.7630556 0.050000
+ 4.7633333 0.050000
+ 4.7636111 0.050000
+ 4.7638889 0.050000
+ 4.7641667 0.092356
+ 4.7644444 0.140989
+ 4.7647222 0.193427
+ 4.7650000 0.247201
+ 4.7652778 0.299843
+ 4.7655556 0.348881
+ 4.7658333 0.391846
+ 4.7661111 0.426269
+ 4.7663889 0.449679
+ 4.7666667 0.459608
+ 4.7669444 0.454383
+ 4.7672222 0.435532
+ 4.7675000 0.405376
+ 4.7677778 0.366242
+ 4.7680556 0.320454
+ 4.7683333 0.270334
+ 4.7686111 0.218209
+ 4.7688889 0.166401
+ 4.7691667 0.117236
+ 4.7694444 0.073037
+ 4.7697222 0.050000
+ 4.7700000 0.050000
+ 4.7702778 0.050000
+ 4.7705556 0.050000
+ 4.7708333 0.050000
+ 4.7711111 0.050000
+ 4.7713889 0.050000
+ 4.7716667 0.050000
+ 4.7719444 0.050000
+ 4.7722222 0.050000
+ 4.7725000 0.092411
+ 4.7727778 0.140990
+ 4.7730556 0.193302
+ 4.7733333 0.246915
+ 4.7736111 0.299393
+ 4.7738889 0.348305
+ 4.7741667 0.391216
+ 4.7744444 0.425692
+ 4.7747222 0.449301
+ 4.7750000 0.459608
+ 4.7752778 0.454964
+ 4.7755556 0.436855
+ 4.7758333 0.407553
+ 4.7761111 0.369327
+ 4.7763889 0.324449
+ 4.7766667 0.275188
+ 4.7769444 0.223815
+ 4.7772222 0.172601
+ 4.7775000 0.123817
+ 4.7777778 0.079732
+ 4.7780556 0.050000
+ 4.7783333 0.050000
+ 4.7786111 0.050000
+ 4.7788889 0.050000
+ 4.7791667 0.050000
+ 4.7794444 0.050000
+ 4.7797222 0.050000
+ 4.7800000 0.050000
+ 4.7802778 0.050000
+ 4.7805556 0.050000
+ 4.7808333 0.092199
+ 4.7811111 0.140768
+ 4.7813889 0.193215
+ 4.7816667 0.247046
+ 4.7819444 0.299771
+ 4.7822222 0.348897
+ 4.7825000 0.391932
+ 4.7827778 0.426384
+ 4.7830556 0.449760
+ 4.7833333 0.459568
+ 4.7836111 0.454124
+ 4.7838889 0.434966
+ 4.7841667 0.404443
+ 4.7844444 0.364901
+ 4.7847222 0.318687
+ 4.7850000 0.268149
+ 4.7852778 0.215633
+ 4.7855556 0.163486
+ 4.7858333 0.114056
+ 4.7861111 0.069689
+ 4.7863889 0.050000
+ 4.7866667 0.050000
+ 4.7869444 0.050000
+ 4.7872222 0.050000
+ 4.7875000 0.050000
+ 4.7877778 0.050000
+ 4.7880556 0.050000
+ 4.7883333 0.050000
+ 4.7886111 0.050000
+ 4.7888889 0.050000
+ 4.7891667 0.093048
+ 4.7894444 0.142245
+ 4.7897222 0.195112
+ 4.7900000 0.249168
+ 4.7902778 0.301934
+ 4.7905556 0.350931
+ 4.7908333 0.393678
+ 4.7911111 0.427695
+ 4.7913889 0.450503
+ 4.7916667 0.459621
+ 4.7919444 0.453381
+ 4.7922222 0.433355
+ 4.7925000 0.401929
+ 4.7927778 0.361486
+ 4.7930556 0.314411
+ 4.7933333 0.263088
+ 4.7936111 0.209900
+ 4.7938889 0.157233
+ 4.7941667 0.107469
+ 4.7944444 0.062994
+ 4.7947222 0.050000
+ 4.7950000 0.050000
+ 4.7952778 0.050000
+ 4.7955556 0.050000
+ 4.7958333 0.050000
+ 4.7961111 0.050000
+ 4.7963889 0.050000
+ 4.7966667 0.050000
+ 4.7969444 0.050000
+ 4.7972222 0.050000
+ 4.7975000 0.093645
+ 4.7977778 0.143308
+ 4.7980556 0.196506
+ 4.7983333 0.250762
+ 4.7986111 0.303594
+ 4.7988889 0.352523
+ 4.7991667 0.395069
+ 4.7994444 0.428752
+ 4.7997222 0.451091
+ 4.8000000 0.459608
+ 4.8002778 0.452638
+ 4.8005556 0.431790
+ 4.8008333 0.399488
+ 4.8011111 0.358155
+ 4.8013889 0.310218
+ 4.8016667 0.258099
+ 4.8019444 0.204223
+ 4.8022222 0.151015
+ 4.8025000 0.100899
+ 4.8027778 0.056299
+ 4.8030556 0.050000
+ 4.8033333 0.050000
+ 4.8036111 0.050000
+ 4.8038889 0.050000
+ 4.8041667 0.050000
+ 4.8044444 0.050000
+ 4.8047222 0.050000
+ 4.8050000 0.050000
+ 4.8052778 0.050000
+ 4.8055556 0.050000
+ 4.8058333 0.094239
+ 4.8061111 0.144359
+ 4.8063889 0.197881
+ 4.8066667 0.252327
+ 4.8069444 0.305217
+ 4.8072222 0.354074
+ 4.8075000 0.396417
+ 4.8077778 0.429769
+ 4.8080556 0.451650
+ 4.8083333 0.459582
+ 4.8086111 0.451909
+ 4.8088889 0.430270
+ 4.8091667 0.397130
+ 4.8094444 0.354951
+ 4.8097222 0.306197
+ 4.8100000 0.253330
+ 4.8102778 0.198813
+ 4.8105556 0.145111
+ 4.8108333 0.094685
+ 4.8111111 0.050000
+ 4.8113889 0.050000
+ 4.8116667 0.050000
+ 4.8119444 0.050000
+ 4.8122222 0.050000
+ 4.8125000 0.050000
+ 4.8127778 0.050000
+ 4.8130556 0.050000
+ 4.8133333 0.050000
+ 4.8136111 0.050000
+ 4.8138889 0.050000
+ 4.8141667 0.094657
+ 4.8144444 0.145046
+ 4.8147222 0.198711
+ 4.8150000 0.253193
+ 4.8152778 0.306035
+ 4.8155556 0.354779
+ 4.8158333 0.396969
+ 4.8161111 0.430146
+ 4.8163889 0.451854
+ 4.8166667 0.459634
+ 4.8169444 0.451849
+ 4.8172222 0.430137
+ 4.8175000 0.396955
+ 4.8177778 0.354763
+ 4.8180556 0.306016
+ 4.8183333 0.253174
+ 4.8186111 0.198694
+ 4.8188889 0.145033
+ 4.8191667 0.094649
+ 4.8194444 0.050000
+ 4.8197222 0.050000
+ 4.8200000 0.050000
+ 4.8202778 0.050000
+ 4.8205556 0.050000
+ 4.8208333 0.050000
+ 4.8211111 0.050000
+ 4.8213889 0.050000
+ 4.8216667 0.050000
+ 4.8219444 0.050000
+ 4.8222222 0.050000
+ 4.8225000 0.094647
+ 4.8227778 0.145027
+ 4.8230556 0.198684
+ 4.8233333 0.253161
+ 4.8236111 0.305999
+ 4.8238889 0.354740
+ 4.8241667 0.396928
+ 4.8244444 0.430105
+ 4.8247222 0.451813
+ 4.8250000 0.459595
+ 4.8252778 0.451812
+ 4.8255556 0.430102
+ 4.8258333 0.396924
+ 4.8261111 0.354735
+ 4.8263889 0.305993
+ 4.8266667 0.253155
+ 4.8269444 0.198679
+ 4.8272222 0.145023
+ 4.8275000 0.094644
+ 4.8277778 0.050000
+ 4.8280556 0.050000
+ 4.8283333 0.050000
+ 4.8286111 0.050000
+ 4.8288889 0.050000
+ 4.8291667 0.050000
+ 4.8294444 0.050000
+ 4.8297222 0.050000
+ 4.8300000 0.050000
+ 4.8302778 0.050000
+ 4.8305556 0.050000
+ 4.8308333 0.094637
+ 4.8311111 0.145007
+ 4.8313889 0.198653
+ 4.8316667 0.253117
+ 4.8319444 0.305942
+ 4.8322222 0.354673
+ 4.8325000 0.396851
+ 4.8327778 0.430020
+ 4.8330556 0.451723
+ 4.8333333 0.459503
+ 4.8336111 0.451722
+ 4.8338889 0.430019
+ 4.8341667 0.396849
+ 4.8344444 0.354671
+ 4.8347222 0.305940
+ 4.8350000 0.253114
+ 4.8352778 0.198650
+ 4.8355556 0.145006
+ 4.8358333 0.094636
+ 4.8361111 0.050000
+ 4.8363889 0.050000
+ 4.8366667 0.050000
+ 4.8369444 0.050000
+ 4.8372222 0.050000
+ 4.8375000 0.050000
+ 4.8377778 0.050000
+ 4.8380556 0.050000
+ 4.8383333 0.050000
+ 4.8386111 0.050000
+ 4.8388889 0.050000
+ 4.8391667 0.094639
+ 4.8394444 0.145013
+ 4.8397222 0.198663
+ 4.8400000 0.253132
+ 4.8402778 0.305963
+ 4.8405556 0.354698
+ 4.8408333 0.396882
+ 4.8411111 0.430055
+ 4.8413889 0.451761
+ 4.8416667 0.459542
+ 4.8419444 0.451761
+ 4.8422222 0.430055
+ 4.8425000 0.396882
+ 4.8427778 0.354700
+ 4.8430556 0.305964
+ 4.8433333 0.253133
+ 4.8436111 0.198664
+ 4.8438889 0.145014
+ 4.8441667 0.094640
+ 4.8444444 0.050000
+ 4.8447222 0.050000
+ 4.8450000 0.050000
+ 4.8452778 0.050000
+ 4.8455556 0.050000
+ 4.8458333 0.050000
+ 4.8461111 0.050000
+ 4.8463889 0.050000
+ 4.8466667 0.050000
+ 4.8469444 0.050000
+ 4.8472222 0.050000
+ 4.8475000 0.094639
+ 4.8477778 0.145011
+ 4.8480556 0.198660
+ 4.8483333 0.253127
+ 4.8486111 0.305956
+ 4.8488889 0.354690
+ 4.8491667 0.396872
+ 4.8494444 0.430043
+ 4.8497222 0.451748
+ 4.8500000 0.459529
+ 4.8502778 0.451748
+ 4.8505556 0.430043
+ 4.8508333 0.396871
+ 4.8511111 0.354689
+ 4.8513889 0.305955
+ 4.8516667 0.253126
+ 4.8519444 0.198659
+ 4.8522222 0.145010
+ 4.8525000 0.094638
+ 4.8527778 0.050000
+ 4.8530556 0.050000
+ 4.8533333 0.050000
+ 4.8536111 0.050000
+ 4.8538889 0.050000
+ 4.8541667 0.050000
+ 4.8544444 0.050000
+ 4.8547222 0.050000
+ 4.8550000 0.050000
+ 4.8552778 0.050000
+ 4.8555556 0.050000
+ 4.8558333 0.094637
+ 4.8561111 0.145008
+ 4.8563889 0.198654
+ 4.8566667 0.253120
+ 4.8569444 0.305947
+ 4.8572222 0.354679
+ 4.8575000 0.396859
+ 4.8577778 0.430030
+ 4.8580556 0.451735
+ 4.8583333 0.459516
+ 4.8586111 0.451736
+ 4.8588889 0.430033
+ 4.8591667 0.396863
+ 4.8594444 0.354683
+ 4.8597222 0.305952
+ 4.8600000 0.253124
+ 4.8602778 0.198659
+ 4.8605556 0.145011
+ 4.8608333 0.094639
+ 4.8611111 0.050000
+ 4.8613889 0.050000
+ 4.8616667 0.050000
+ 4.8619444 0.050000
+ 4.8622222 0.050000
+ 4.8625000 0.050000
+ 4.8627778 0.050000
+ 4.8630556 0.050000
+ 4.8633333 0.050000
+ 4.8636111 0.050000
+ 4.8638889 0.050000
+ 4.8641667 0.094648
+ 4.8644444 0.145032
+ 4.8647222 0.198694
+ 4.8650000 0.253174
+ 4.8652778 0.306015
+ 4.8655556 0.354758
+ 4.8658333 0.396946
+ 4.8661111 0.430121
+ 4.8663889 0.451823
+ 4.8666667 0.459595
+ 4.8669444 0.451798
+ 4.8672222 0.430072
+ 4.8675000 0.396877
+ 4.8677778 0.354673
+ 4.8680556 0.305920
+ 4.8683333 0.253076
+ 4.8686111 0.198603
+ 4.8688889 0.144959
+ 4.8691667 0.094605
+ 4.8694444 0.050000
+ 4.8697222 0.050000
+ 4.8700000 0.050000
+ 4.8702778 0.050000
+ 4.8705556 0.050000
+ 4.8708333 0.050000
+ 4.8711111 0.050000
+ 4.8713889 0.050000
+ 4.8716667 0.050000
+ 4.8719444 0.050000
+ 4.8722222 0.050000
+ 4.8725000 0.094436
+ 4.8727778 0.144574
+ 4.8730556 0.197986
+ 4.8733333 0.252246
+ 4.8736111 0.304927
+ 4.8738889 0.353602
+ 4.8741667 0.395843
+ 4.8744444 0.429225
+ 4.8747222 0.451319
+ 4.8750000 0.459699
+ 4.8752778 0.452743
+ 4.8755556 0.432045
+ 4.8758333 0.400004
+ 4.8761111 0.359020
+ 4.8763889 0.311491
+ 4.8766667 0.259817
+ 4.8769444 0.206396
+ 4.8772222 0.153628
+ 4.8775000 0.103912
+ 4.8777778 0.059647
+ 4.8780556 0.050000
+ 4.8783333 0.050000
+ 4.8786111 0.050000
+ 4.8788889 0.050000
+ 4.8791667 0.050000
+ 4.8794444 0.050000
+ 4.8797222 0.050000
+ 4.8800000 0.050000
+ 4.8802778 0.050000
+ 4.8805556 0.050000
+ 4.8808333 0.093027
+ 4.8811111 0.141868
+ 4.8813889 0.194171
+ 4.8816667 0.247586
+ 4.8819444 0.299761
+ 4.8822222 0.348345
+ 4.8825000 0.390985
+ 4.8827778 0.425332
+ 4.8830556 0.449034
+ 4.8833333 0.459738
+ 4.8836111 0.455860
+ 4.8838889 0.438874
+ 4.8841667 0.411019
+ 4.8844444 0.374534
+ 4.8847222 0.331659
+ 4.8850000 0.284633
+ 4.8852778 0.235697
+ 4.8855556 0.187089
+ 4.8858333 0.141049
+ 4.8861111 0.099817
+ 4.8863889 0.065272
+ 4.8866667 0.050000
+ 4.8869444 0.050000
+ 4.8872222 0.050000
+ 4.8875000 0.050000
+ 4.8877778 0.050000
+ 4.8880556 0.050000
+ 4.8883333 0.050000
+ 4.8886111 0.052465
+ 4.8888889 0.085041
+ 4.8891667 0.125088
+ 4.8894444 0.170702
+ 4.8897222 0.219582
+ 4.8900000 0.269427
+ 4.8902778 0.317935
+ 4.8905556 0.362804
+ 4.8908333 0.401733
+ 4.8911111 0.432422
+ 4.8913889 0.452567
+ 4.8916667 0.459869
+ 4.8919444 0.452785
+ 4.8922222 0.432812
+ 4.8925000 0.402205
+ 4.8927778 0.363221
+ 4.8930556 0.318116
+ 4.8933333 0.269145
+ 4.8936111 0.218565
+ 4.8938889 0.168633
+ 4.8941667 0.121603
+ 4.8944444 0.079732
+ 4.8947222 0.050000
+ 4.8950000 0.050000
+ 4.8952778 0.050000
+ 4.8955556 0.050000
+ 4.8958333 0.050000
+ 4.8961111 0.050000
+ 4.8963889 0.050000
+ 4.8966667 0.050000
+ 4.8969444 0.050000
+ 4.8972222 0.071572
+ 4.8975000 0.112653
+ 4.8977778 0.159273
+ 4.8980556 0.209167
+ 4.8983333 0.260070
+ 4.8986111 0.309718
+ 4.8988889 0.355846
+ 4.8991667 0.396188
+ 4.8994444 0.428481
+ 4.8997222 0.450458
+ 4.9000000 0.459856
+ 4.9002778 0.455145
+ 4.9005556 0.437742
+ 4.9008333 0.409798
+ 4.9011111 0.373465
+ 4.9013889 0.330896
+ 4.9016667 0.284241
+ 4.9019444 0.235654
+ 4.9022222 0.187287
+ 4.9025000 0.141290
+ 4.9027778 0.099817
+ 4.9030556 0.064687
+ 4.9033333 0.050000
+ 4.9036111 0.050000
+ 4.9038889 0.050000
+ 4.9041667 0.050000
+ 4.9044444 0.050000
+ 4.9047222 0.050000
+ 4.9050000 0.050000
+ 4.9052778 0.050000
+ 4.9055556 0.075011
+ 4.9058333 0.114921
+ 4.9061111 0.160750
+ 4.9063889 0.210159
+ 4.9066667 0.260810
+ 4.9069444 0.310363
+ 4.9072222 0.356481
+ 4.9075000 0.396824
+ 4.9077778 0.429053
+ 4.9080556 0.450830
+ 4.9083333 0.459817
+ 4.9086111 0.454435
+ 4.9088889 0.436154
+ 4.9091667 0.407203
+ 4.9094444 0.369813
+ 4.9097222 0.326213
+ 4.9100000 0.278634
+ 4.9102778 0.229305
+ 4.9105556 0.180457
+ 4.9108333 0.134319
+ 4.9111111 0.093122
+ 4.9113889 0.058734
+ 4.9116667 0.050000
+ 4.9119444 0.050000
+ 4.9122222 0.050000
+ 4.9125000 0.050000
+ 4.9127778 0.050000
+ 4.9130556 0.050000
+ 4.9133333 0.050000
+ 4.9136111 0.050000
+ 4.9138889 0.081693
+ 4.9141667 0.121883
+ 4.9144444 0.167575
+ 4.9147222 0.216508
+ 4.9150000 0.266421
+ 4.9152778 0.315054
+ 4.9155556 0.360144
+ 4.9158333 0.399432
+ 4.9161111 0.430656
+ 4.9163889 0.451556
+ 4.9166667 0.459869
+ 4.9169444 0.454076
+ 4.9172222 0.435613
+ 4.9175000 0.406659
+ 4.9177778 0.369391
+ 4.9180556 0.325986
+ 4.9183333 0.278621
+ 4.9186111 0.229475
+ 4.9188889 0.180725
+ 4.9191667 0.134548
+ 4.9194444 0.093122
+ 4.9197222 0.058280
+ 4.9200000 0.050000
+ 4.9202778 0.050000
+ 4.9205556 0.050000
+ 4.9208333 0.050000
+ 4.9211111 0.050000
+ 4.9213889 0.050000
+ 4.9216667 0.050000
+ 4.9219444 0.050000
+ 4.9222222 0.074933
+ 4.9225000 0.115125
+ 4.9227778 0.161067
+ 4.9230556 0.210461
+ 4.9233333 0.261009
+ 4.9236111 0.310414
+ 4.9238889 0.356379
+ 4.9241667 0.396606
+ 4.9244444 0.428797
+ 4.9247222 0.450655
+ 4.9250000 0.459882
+ 4.9252778 0.454929
+ 4.9255556 0.437238
+ 4.9258333 0.408996
+ 4.9261111 0.372395
+ 4.9263889 0.329622
+ 4.9266667 0.282868
+ 4.9269444 0.234321
+ 4.9272222 0.186170
+ 4.9275000 0.140606
+ 4.9277778 0.099817
+ 4.9280556 0.065641
+ 4.9283333 0.050000
+ 4.9286111 0.050000
+ 4.9288889 0.050000
+ 4.9291667 0.050000
+ 4.9294444 0.050000
+ 4.9297222 0.050000
+ 4.9300000 0.050000
+ 4.9302778 0.052814
+ 4.9305556 0.085015
+ 4.9308333 0.124612
+ 4.9311111 0.169744
+ 4.9313889 0.218159
+ 4.9316667 0.267605
+ 4.9319444 0.315830
+ 4.9322222 0.360583
+ 4.9325000 0.399612
+ 4.9327778 0.430667
+ 4.9330556 0.451494
+ 4.9333333 0.459843
+ 4.9336111 0.454197
+ 4.9338889 0.435978
+ 4.9341667 0.407344
+ 4.9344444 0.370451
+ 4.9347222 0.327457
+ 4.9350000 0.280519
+ 4.9352778 0.231794
+ 4.9355556 0.183439
+ 4.9358333 0.137612
+ 4.9361111 0.096469
+ 4.9363889 0.061830
+ 4.9366667 0.050000
+ 4.9369444 0.050000
+ 4.9372222 0.050000
+ 4.9375000 0.050000
+ 4.9377778 0.050000
+ 4.9380556 0.050000
+ 4.9383333 0.050000
+ 4.9386111 0.050000
+ 4.9388889 0.078346
+ 4.9391667 0.118513
+ 4.9394444 0.164433
+ 4.9397222 0.213780
+ 4.9400000 0.264229
+ 4.9402778 0.313456
+ 4.9405556 0.359135
+ 4.9408333 0.398940
+ 4.9411111 0.430548
+ 4.9413889 0.451633
+ 4.9416667 0.459869
+ 4.9419444 0.453691
+ 4.9422222 0.434569
+ 4.9425000 0.404732
+ 4.9427778 0.366408
+ 4.9430556 0.321827
+ 4.9433333 0.273218
+ 4.9436111 0.222810
+ 4.9438889 0.172831
+ 4.9441667 0.125511
+ 4.9444444 0.083079
+ 4.9447222 0.050000
+ 4.9450000 0.050000
+ 4.9452778 0.050000
+ 4.9455556 0.050000
+ 4.9458333 0.050000
+ 4.9461111 0.050000
+ 4.9463889 0.050000
+ 4.9466667 0.050000
+ 4.9469444 0.050000
+ 4.9472222 0.064864
+ 4.9475000 0.106026
+ 4.9477778 0.153065
+ 4.9480556 0.203639
+ 4.9483333 0.255405
+ 4.9486111 0.306021
+ 4.9488889 0.353143
+ 4.9491667 0.394429
+ 4.9494444 0.427536
+ 4.9497222 0.450122
+ 4.9500000 0.459843
+ 4.9502778 0.455116
+ 4.9505556 0.437393
+ 4.9508333 0.408886
+ 4.9511111 0.371805
+ 4.9513889 0.328363
+ 4.9516667 0.280770
+ 4.9519444 0.231239
+ 4.9522222 0.181979
+ 4.9525000 0.135203
+ 4.9527778 0.093122
+ 4.9530556 0.057602
+ 4.9533333 0.050000
+ 4.9536111 0.050000
+ 4.9538889 0.050000
+ 4.9541667 0.050000
+ 4.9544444 0.050000
+ 4.9547222 0.050000
+ 4.9550000 0.050000
+ 4.9552778 0.050000
+ 4.9555556 0.071599
+ 4.9558333 0.112354
+ 4.9561111 0.159023
+ 4.9563889 0.209229
+ 4.9566667 0.260591
+ 4.9569444 0.310730
+ 4.9572222 0.357267
+ 4.9575000 0.397824
+ 4.9577778 0.430021
+ 4.9580556 0.451478
+ 4.9583333 0.459817
+ 4.9586111 0.453443
+ 4.9588889 0.433902
+ 4.9591667 0.403522
+ 4.9594444 0.364633
+ 4.9597222 0.319566
+ 4.9600000 0.270649
+ 4.9602778 0.220212
+ 4.9605556 0.170585
+ 4.9608333 0.124098
+ 4.9611111 0.083079
+ 4.9613889 0.050000
+ 4.9616667 0.050000
+ 4.9619444 0.050000
+ 4.9622222 0.050000
+ 4.9625000 0.050000
+ 4.9627778 0.050000
+ 4.9630556 0.050000
+ 4.9633333 0.050000
+ 4.9636111 0.054358
+ 4.9638889 0.088336
+ 4.9641667 0.129181
+ 4.9644444 0.175054
+ 4.9647222 0.223764
+ 4.9650000 0.273116
+ 4.9652778 0.320918
+ 4.9655556 0.364975
+ 4.9658333 0.403095
+ 4.9661111 0.433084
+ 4.9663889 0.452748
+ 4.9666667 0.459895
+ 4.9669444 0.453057
+ 4.9672222 0.433672
+ 4.9675000 0.403901
+ 4.9677778 0.365908
+ 4.9680556 0.321857
+ 4.9683333 0.273910
+ 4.9686111 0.224230
+ 4.9688889 0.174981
+ 4.9691667 0.128326
+ 4.9694444 0.086427
+ 4.9697222 0.051111
+ 4.9700000 0.050000
+ 4.9702778 0.050000
+ 4.9705556 0.050000
+ 4.9708333 0.050000
+ 4.9711111 0.050000
+ 4.9713889 0.050000
+ 4.9716667 0.050000
+ 4.9719444 0.050000
+ 4.9722222 0.068212
+ 4.9725000 0.109521
+ 4.9727778 0.156771
+ 4.9730556 0.207555
+ 4.9733333 0.259466
+ 4.9736111 0.310099
+ 4.9738889 0.357046
+ 4.9741667 0.397900
+ 4.9744444 0.430256
+ 4.9747222 0.451706
+ 4.9750000 0.459843
+ 4.9752778 0.453052
+ 4.9755556 0.432875
+ 4.9758333 0.401648
+ 4.9761111 0.361704
+ 4.9763889 0.315377
+ 4.9766667 0.265001
+ 4.9769444 0.212910
+ 4.9772222 0.161439
+ 4.9775000 0.112920
+ 4.9777778 0.069689
+ 4.9780556 0.050000
+ 4.9783333 0.050000
+ 4.9786111 0.050000
+ 4.9788889 0.050000
+ 4.9791667 0.050000
+ 4.9794444 0.050000
+ 4.9797222 0.050000
+ 4.9800000 0.050000
+ 4.9802778 0.050000
+ 4.9805556 0.061478
+ 4.9808333 0.104201
+ 4.9811111 0.152677
+ 4.9813889 0.204506
+ 4.9816667 0.257290
+ 4.9819444 0.308632
+ 4.9822222 0.356132
+ 4.9825000 0.397392
+ 4.9827778 0.430014
+ 4.9830556 0.451600
+ 4.9833333 0.459752
+ 4.9836111 0.452862
+ 4.9838889 0.432490
+ 4.9841667 0.400989
+ 4.9844444 0.360708
+ 4.9847222 0.314000
+ 4.9850000 0.263215
+ 4.9852778 0.210706
+ 4.9855556 0.158823
+ 4.9858333 0.109918
+ 4.9861111 0.066342
+ 4.9863889 0.050000
+ 4.9866667 0.050000
+ 4.9869444 0.050000
+ 4.9872222 0.050000
+ 4.9875000 0.050000
+ 4.9877778 0.050000
+ 4.9880556 0.050000
+ 4.9883333 0.050000
+ 4.9886111 0.050000
+ 4.9888889 0.058169
+ 4.9891667 0.101280
+ 4.9894444 0.150194
+ 4.9897222 0.202489
+ 4.9900000 0.255744
+ 4.9902778 0.307535
+ 4.9905556 0.355442
+ 4.9908333 0.397042
+ 4.9911111 0.429912
+ 4.9913889 0.451632
+ 4.9916667 0.459778
+ 4.9919444 0.452730
+ 4.9922222 0.432071
+ 4.9925000 0.400187
+ 4.9927778 0.359461
+ 4.9930556 0.312280
+ 4.9933333 0.261026
+ 4.9936111 0.208087
+ 4.9938889 0.155845
+ 4.9941667 0.106686
+ 4.9944444 0.062994
+ 4.9947222 0.050000
+ 4.9950000 0.050000
+ 4.9952778 0.050000
+ 4.9955556 0.050000
+ 4.9958333 0.050000
+ 4.9961111 0.050000
+ 4.9963889 0.050000
+ 4.9966667 0.050000
+ 4.9969444 0.050000
+ 4.9972222 0.058091
+ 4.9975000 0.101333
+ 4.9977778 0.150279
+ 4.9980556 0.202534
+ 4.9983333 0.255703
+ 4.9986111 0.307391
+ 4.9988889 0.355202
+ 4.9991667 0.396743
+ 4.9994444 0.429618
+ 4.9997222 0.451432
+ 5.0000000 0.459791
+ 5.0002778 0.453089
+ 5.0005556 0.432880
+ 5.0008333 0.401511
+ 5.0011111 0.361324
+ 5.0013889 0.314665
+ 5.0016667 0.263878
+ 5.0019444 0.211307
+ 5.0022222 0.159298
+ 5.0025000 0.110195
+ 5.0027778 0.066342
+ 5.0030556 0.050000
+ 5.0033333 0.050000
+ 5.0036111 0.050000
+ 5.0038889 0.050000
+ 5.0041667 0.050000
+ 5.0044444 0.050000
+ 5.0047222 0.050000
+ 5.0050000 0.050000
+ 5.0052778 0.050000
+ 5.0055556 0.054770
+ 5.0058333 0.097999
+ 5.0061111 0.147161
+ 5.0063889 0.199803
+ 5.0066667 0.253472
+ 5.0069444 0.305717
+ 5.0072222 0.354087
+ 5.0075000 0.396128
+ 5.0077778 0.429390
+ 5.0080556 0.451419
+ 5.0083333 0.459765
+ 5.0086111 0.452786
+ 5.0088889 0.432091
+ 5.0091667 0.400098
+ 5.0094444 0.359226
+ 5.0097222 0.311893
+ 5.0100000 0.260520
+ 5.0102778 0.207525
+ 5.0105556 0.155326
+ 5.0108333 0.106343
+ 5.0111111 0.062994
+ 5.0113889 0.050000
+ 5.0116667 0.050000
+ 5.0119444 0.050000
+ 5.0122222 0.050000
+ 5.0125000 0.050000
+ 5.0127778 0.050000
+ 5.0130556 0.050000
+ 5.0133333 0.050000
+ 5.0136111 0.050000
+ 5.0138889 0.064851
+ 5.0141667 0.108115
+ 5.0144444 0.156852
+ 5.0147222 0.208694
+ 5.0150000 0.261277
+ 5.0152778 0.312233
+ 5.0155556 0.359196
+ 5.0158333 0.399800
+ 5.0161111 0.431678
+ 5.0163889 0.452464
+ 5.0166667 0.459791
+ 5.0169444 0.452080
+ 5.0172222 0.430903
+ 5.0175000 0.398616
+ 5.0177778 0.357579
+ 5.0180556 0.310150
+ 5.0183333 0.258685
+ 5.0186111 0.205545
+ 5.0188889 0.153086
+ 5.0191667 0.103668
+ 5.0194444 0.059647
+ 5.0197222 0.050000
+ 5.0200000 0.050000
+ 5.0202778 0.050000
+ 5.0205556 0.050000
+ 5.0208333 0.050000
+ 5.0211111 0.050000
+ 5.0213889 0.050000
+ 5.0216667 0.050000
+ 5.0219444 0.050000
+ 5.0222222 0.051396
+ 5.0225000 0.094962
+ 5.0227778 0.144410
+ 5.0230556 0.197306
+ 5.0233333 0.251216
+ 5.0236111 0.303709
+ 5.0238889 0.352351
+ 5.0241667 0.394709
+ 5.0244444 0.428351
+ 5.0247222 0.450843
+ 5.0250000 0.459752
+ 5.0252778 0.453445
+ 5.0255556 0.433488
+ 5.0258333 0.402247
+ 5.0261111 0.362089
+ 5.0263889 0.315378
+ 5.0266667 0.264480
+ 5.0269444 0.211762
+ 5.0272222 0.159589
+ 5.0275000 0.110327
+ 5.0277778 0.066342
+ 5.0280556 0.050000
+ 5.0283333 0.050000
+ 5.0286111 0.050000
+ 5.0288889 0.050000
+ 5.0291667 0.050000
+ 5.0294444 0.050000
+ 5.0297222 0.050000
+ 5.0300000 0.050000
+ 5.0302778 0.050000
+ 5.0305556 0.054743
+ 5.0308333 0.097936
+ 5.0311111 0.147041
+ 5.0313889 0.199617
+ 5.0316667 0.253221
+ 5.0319444 0.305414
+ 5.0322222 0.353752
+ 5.0325000 0.395795
+ 5.0327778 0.429102
+ 5.0330556 0.451230
+ 5.0333333 0.459738
+ 5.0336111 0.452990
+ 5.0338889 0.432566
+ 5.0341667 0.400850
+ 5.0344444 0.360227
+ 5.0347222 0.313082
+ 5.0350000 0.261800
+ 5.0352778 0.208765
+ 5.0355556 0.156363
+ 5.0358333 0.106978
+ 5.0361111 0.062994
+ 5.0363889 0.050000
+ 5.0366667 0.050000
+ 5.0369444 0.050000
+ 5.0372222 0.050000
+ 5.0375000 0.050000
+ 5.0377778 0.050000
+ 5.0380556 0.050000
+ 5.0383333 0.050000
+ 5.0386111 0.050000
+ 5.0388889 0.054796
+ 5.0391667 0.098089
+ 5.0394444 0.147196
+ 5.0397222 0.199704
+ 5.0400000 0.253199
+ 5.0402778 0.305269
+ 5.0405556 0.353499
+ 5.0408333 0.395477
+ 5.0411111 0.428790
+ 5.0413889 0.451023
+ 5.0416667 0.459765
+ 5.0419444 0.453393
+ 5.0422222 0.433455
+ 5.0425000 0.402292
+ 5.0427778 0.362241
+ 5.0430556 0.315644
+ 5.0433333 0.264840
+ 5.0436111 0.212168
+ 5.0438889 0.159968
+ 5.0441667 0.110579
+ 5.0444444 0.066342
+ 5.0447222 0.050000
+ 5.0450000 0.050000
+ 5.0452778 0.050000
+ 5.0455556 0.050000
+ 5.0458333 0.050000
+ 5.0461111 0.050000
+ 5.0463889 0.050000
+ 5.0466667 0.050000
+ 5.0469444 0.050000
+ 5.0472222 0.050000
+ 5.0475000 0.093278
+ 5.0477778 0.142646
+ 5.0480556 0.195630
+ 5.0483333 0.249753
+ 5.0486111 0.302540
+ 5.0488889 0.351514
+ 5.0491667 0.394199
+ 5.0494444 0.428120
+ 5.0497222 0.450800
+ 5.0500000 0.459765
+ 5.0502778 0.453350
+ 5.0505556 0.433142
+ 5.0508333 0.401544
+ 5.0511111 0.360953
+ 5.0513889 0.313771
+ 5.0516667 0.262398
+ 5.0519444 0.209233
+ 5.0522222 0.156678
+ 5.0525000 0.107131
+ 5.0527778 0.062994
+ 5.0530556 0.050000
+ 5.0533333 0.050000
+ 5.0536111 0.050000
+ 5.0538889 0.050000
+ 5.0541667 0.050000
+ 5.0544444 0.050000
+ 5.0547222 0.050000
+ 5.0550000 0.050000
+ 5.0552778 0.050000
+ 5.0555556 0.054756
+ 5.0558333 0.098229
+ 5.0561111 0.147534
+ 5.0563889 0.200236
+ 5.0566667 0.253900
+ 5.0569444 0.306093
+ 5.0572222 0.354380
+ 5.0575000 0.396326
+ 5.0577778 0.429498
+ 5.0580556 0.451460
+ 5.0583333 0.459778
+ 5.0586111 0.452824
+ 5.0588889 0.432193
+ 5.0591667 0.400287
+ 5.0594444 0.359509
+ 5.0597222 0.312259
+ 5.0600000 0.260939
+ 5.0602778 0.207951
+ 5.0605556 0.155696
+ 5.0608333 0.106577
+ 5.0611111 0.062994
+ 5.0613889 0.050000
+ 5.0616667 0.050000
+ 5.0619444 0.050000
+ 5.0622222 0.050000
+ 5.0625000 0.050000
+ 5.0627778 0.050000
+ 5.0630556 0.050000
+ 5.0633333 0.050000
+ 5.0636111 0.050000
+ 5.0638889 0.061451
+ 5.0641667 0.104939
+ 5.0644444 0.154050
+ 5.0647222 0.206373
+ 5.0650000 0.259493
+ 5.0652778 0.310996
+ 5.0655556 0.358470
+ 5.0658333 0.399500
+ 5.0661111 0.431672
+ 5.0663889 0.452574
+ 5.0666667 0.459791
+ 5.0669444 0.451714
+ 5.0672222 0.429954
+ 5.0675000 0.396924
+ 5.0677778 0.355038
+ 5.0680556 0.306711
+ 5.0683333 0.254357
+ 5.0686111 0.200389
+ 5.0688889 0.147223
+ 5.0691667 0.097273
+ 5.0694444 0.052952
+ 5.0697222 0.050000
+ 5.0700000 0.050000
+ 5.0702778 0.050000
+ 5.0705556 0.050000
+ 5.0708333 0.050000
+ 5.0711111 0.050000
+ 5.0713889 0.050000
+ 5.0716667 0.050000
+ 5.0719444 0.050000
+ 5.0722222 0.050000
+ 5.0725000 0.093975
+ 5.0727778 0.143700
+ 5.0730556 0.196769
+ 5.0733333 0.250775
+ 5.0736111 0.303313
+ 5.0738889 0.351977
+ 5.0741667 0.394360
+ 5.0744444 0.428056
+ 5.0747222 0.450660
+ 5.0750000 0.459765
+ 5.0752778 0.453755
+ 5.0755556 0.434178
+ 5.0758333 0.403372
+ 5.0761111 0.363675
+ 5.0763889 0.317424
+ 5.0766667 0.266957
+ 5.0769444 0.214612
+ 5.0772222 0.162727
+ 5.0775000 0.113641
+ 5.0777778 0.069689
+ 5.0780556 0.050000
+ 5.0783333 0.050000
+ 5.0786111 0.050000
+ 5.0788889 0.050000
+ 5.0791667 0.050000
+ 5.0794444 0.050000
+ 5.0797222 0.050000
+ 5.0800000 0.050000
+ 5.0802778 0.050000
+ 5.0805556 0.054730
+ 5.0808333 0.097927
+ 5.0811111 0.147156
+ 5.0813889 0.199930
+ 5.0816667 0.253763
+ 5.0819444 0.306168
+ 5.0822222 0.354660
+ 5.0825000 0.396752
+ 5.0827778 0.429958
+ 5.0830556 0.451790
+ 5.0833333 0.459765
+ 5.0836111 0.452220
+ 5.0838889 0.430799
+ 5.0841667 0.397973
+ 5.0844444 0.356212
+ 5.0847222 0.307984
+ 5.0850000 0.255760
+ 5.0852778 0.202010
+ 5.0855556 0.149203
+ 5.0858333 0.099810
+ 5.0861111 0.056299
+ 5.0863889 0.050000
+ 5.0866667 0.050000
+ 5.0869444 0.050000
+ 5.0872222 0.050000
+ 5.0875000 0.050000
+ 5.0877778 0.050000
+ 5.0880556 0.050000
+ 5.0883333 0.050000
+ 5.0886111 0.050000
+ 5.0888889 0.064812
+ 5.0891667 0.108529
+ 5.0894444 0.157556
+ 5.0897222 0.209550
+ 5.0900000 0.262169
+ 5.0902778 0.313070
+ 5.0905556 0.359910
+ 5.0908333 0.400348
+ 5.0911111 0.432040
+ 5.0913889 0.452644
+ 5.0916667 0.459817
+ 5.0919444 0.451999
+ 5.0922222 0.430758
+ 5.0925000 0.398444
+ 5.0927778 0.357408
+ 5.0930556 0.310000
+ 5.0933333 0.258571
+ 5.0936111 0.205470
+ 5.0938889 0.153049
+ 5.0941667 0.103658
+ 5.0944444 0.059647
+ 5.0947222 0.050000
+ 5.0950000 0.050000
+ 5.0952778 0.050000
+ 5.0955556 0.050000
+ 5.0958333 0.050000
+ 5.0961111 0.050000
+ 5.0963889 0.050000
+ 5.0966667 0.050000
+ 5.0969444 0.050000
+ 5.0972222 0.051383
+ 5.0975000 0.095100
+ 5.0977778 0.144727
+ 5.0980556 0.197808
+ 5.0983333 0.251888
+ 5.0986111 0.304510
+ 5.0988889 0.353220
+ 5.0991667 0.395561
+ 5.0994444 0.429078
+ 5.0997222 0.451315
+ 5.1000000 0.459817
+ 5.1002778 0.452944
+ 5.1005556 0.432328
+ 5.1008333 0.400416
+ 5.1011111 0.359655
+ 5.1013889 0.312493
+ 5.1016667 0.261379
+ 5.1019444 0.208758
+ 5.1022222 0.157081
+ 5.1025000 0.108793
+ 5.1027778 0.066342
+ 5.1030556 0.050000
+ 5.1033333 0.050000
+ 5.1036111 0.050000
+ 5.1038889 0.050000
+ 5.1041667 0.050000
+ 5.1044444 0.050000
+ 5.1047222 0.050000
+ 5.1050000 0.050000
+ 5.1052778 0.050000
+ 5.1055556 0.078176
+ 5.1058333 0.121035
+ 5.1061111 0.168969
+ 5.1063889 0.219683
+ 5.1066667 0.270885
+ 5.1069444 0.320279
+ 5.1072222 0.365572
+ 5.1075000 0.404469
+ 5.1077778 0.434676
+ 5.1080556 0.453899
+ 5.1083333 0.459843
+ 5.1086111 0.451000
+ 5.1088889 0.429004
+ 5.1091667 0.396271
+ 5.1094444 0.355221
+ 5.1097222 0.308273
+ 5.1100000 0.257844
+ 5.1102778 0.206352
+ 5.1105556 0.156217
+ 5.1108333 0.109857
+ 5.1111111 0.069689
+ 5.1113889 0.050000
+ 5.1116667 0.050000
+ 5.1119444 0.050000
+ 5.1122222 0.050000
+ 5.1125000 0.050000
+ 5.1127778 0.050000
+ 5.1130556 0.050000
+ 5.1133333 0.050000
+ 5.1136111 0.065879
+ 5.1138889 0.101687
+ 5.1141667 0.143631
+ 5.1144444 0.189899
+ 5.1147222 0.238360
+ 5.1150000 0.286884
+ 5.1152778 0.333339
+ 5.1155556 0.375594
+ 5.1158333 0.411517
+ 5.1161111 0.438978
+ 5.1163889 0.455845
+ 5.1166667 0.459987
+ 5.1169444 0.450017
+ 5.1172222 0.427522
+ 5.1175000 0.394833
+ 5.1177778 0.354281
+ 5.1180556 0.308197
+ 5.1183333 0.258912
+ 5.1186111 0.208758
+ 5.1188889 0.160064
+ 5.1191667 0.115163
+ 5.1194444 0.076384
+ 5.1197222 0.050000
+ 5.1200000 0.050000
+ 5.1202778 0.050000
+ 5.1205556 0.050000
+ 5.1208333 0.050000
+ 5.1211111 0.050000
+ 5.1213889 0.050000
+ 5.1216667 0.050000
+ 5.1219444 0.076624
+ 5.1222222 0.111703
+ 5.1225000 0.152652
+ 5.1227778 0.197721
+ 5.1230556 0.244856
+ 5.1233333 0.292002
+ 5.1236111 0.337105
+ 5.1238889 0.378110
+ 5.1241667 0.412963
+ 5.1244444 0.439610
+ 5.1247222 0.455995
+ 5.1250000 0.460065
+ 5.1252778 0.450484
+ 5.1255556 0.428788
+ 5.1258333 0.397234
+ 5.1261111 0.358076
+ 5.1263889 0.313571
+ 5.1266667 0.265974
+ 5.1269444 0.217540
+ 5.1272222 0.170525
+ 5.1275000 0.127185
+ 5.1277778 0.089774
+ 5.1280556 0.060137
+ 5.1283333 0.050000
+ 5.1286111 0.050000
+ 5.1288889 0.050000
+ 5.1291667 0.050000
+ 5.1294444 0.050000
+ 5.1297222 0.050000
+ 5.1300000 0.063229
+ 5.1302778 0.091087
+ 5.1305556 0.125132
+ 5.1308333 0.164847
+ 5.1311111 0.208523
+ 5.1313889 0.254157
+ 5.1316667 0.299743
+ 5.1319444 0.343277
+ 5.1322222 0.382755
+ 5.1325000 0.416172
+ 5.1327778 0.441524
+ 5.1330556 0.456805
+ 5.1333333 0.460013
+ 5.1336111 0.449845
+ 5.1338889 0.427810
+ 5.1341667 0.396120
+ 5.1344444 0.356987
+ 5.1347222 0.312624
+ 5.1350000 0.265243
+ 5.1352778 0.217055
+ 5.1355556 0.170273
+ 5.1358333 0.127109
+ 5.1361111 0.089774
+ 5.1363889 0.060080
+ 5.1366667 0.050000
+ 5.1369444 0.050000
+ 5.1372222 0.050000
+ 5.1375000 0.050000
+ 5.1377778 0.050000
+ 5.1380556 0.050000
+ 5.1383333 0.060661
+ 5.1386111 0.088131
+ 5.1388889 0.121850
+ 5.1391667 0.161321
+ 5.1394444 0.204849
+ 5.1397222 0.250442
+ 5.1400000 0.296107
+ 5.1402778 0.339850
+ 5.1405556 0.379681
+ 5.1408333 0.413605
+ 5.1411111 0.439630
+ 5.1413889 0.455764
+ 5.1416667 0.460013
+ 5.1419444 0.451068
+ 5.1422222 0.430349
+ 5.1425000 0.399959
+ 5.1427778 0.362001
+ 5.1430556 0.318580
+ 5.1433333 0.271797
+ 5.1436111 0.223757
+ 5.1438889 0.176562
+ 5.1441667 0.132316
+ 5.1444444 0.093122
+ 5.1447222 0.060736
+ 5.1450000 0.050000
+ 5.1452778 0.050000
+ 5.1455556 0.050000
+ 5.1458333 0.050000
+ 5.1461111 0.050000
+ 5.1463889 0.050000
+ 5.1466667 0.050000
+ 5.1469444 0.061988
+ 5.1472222 0.095031
+ 5.1475000 0.135083
+ 5.1477778 0.180290
+ 5.1480556 0.228422
+ 5.1483333 0.277249
+ 5.1486111 0.324542
+ 5.1488889 0.368070
+ 5.1491667 0.405605
+ 5.1494444 0.434916
+ 5.1497222 0.453773
+ 5.1500000 0.459948
+ 5.1502778 0.451965
+ 5.1505556 0.431377
+ 5.1508333 0.400491
+ 5.1511111 0.361615
+ 5.1513889 0.317056
+ 5.1516667 0.269121
+ 5.1519444 0.220117
+ 5.1522222 0.172354
+ 5.1525000 0.128137
+ 5.1527778 0.089774
+ 5.1530556 0.059156
+ 5.1533333 0.050000
+ 5.1536111 0.050000
+ 5.1538889 0.050000
+ 5.1541667 0.050000
+ 5.1544444 0.050000
+ 5.1547222 0.050000
+ 5.1550000 0.056854
+ 5.1552778 0.084456
+ 5.1555556 0.118450
+ 5.1558333 0.158335
+ 5.1561111 0.202379
+ 5.1563889 0.248545
+ 5.1566667 0.294796
+ 5.1569444 0.339095
+ 5.1572222 0.379404
+ 5.1575000 0.413686
+ 5.1577778 0.439905
+ 5.1580556 0.456022
+ 5.1583333 0.460000
+ 5.1586111 0.450502
+ 5.1588889 0.428985
+ 5.1591667 0.397607
+ 5.1594444 0.358526
+ 5.1597222 0.313899
+ 5.1600000 0.265883
+ 5.1602778 0.216636
+ 5.1605556 0.168314
+ 5.1608333 0.123076
+ 5.1611111 0.083079
+ 5.1613889 0.050123
+ 5.1616667 0.050000
+ 5.1619444 0.050000
+ 5.1622222 0.050000
+ 5.1625000 0.050000
+ 5.1627778 0.050000
+ 5.1630556 0.050000
+ 5.1633333 0.050000
+ 5.1636111 0.054190
+ 5.1638889 0.088336
+ 5.1641667 0.129610
+ 5.1644444 0.176098
+ 5.1647222 0.225503
+ 5.1650000 0.275524
+ 5.1652778 0.323864
+ 5.1655556 0.368223
+ 5.1658333 0.406303
+ 5.1661111 0.435806
+ 5.1663889 0.454432
+ 5.1666667 0.459882
+ 5.1669444 0.450631
+ 5.1672222 0.428241
+ 5.1675000 0.395047
+ 5.1677778 0.353383
+ 5.1680556 0.305585
+ 5.1683333 0.253988
+ 5.1686111 0.200926
+ 5.1688889 0.148734
+ 5.1691667 0.099747
+ 5.1694444 0.056299
+ 5.1697222 0.050000
+ 5.1700000 0.050000
+ 5.1702778 0.050000
+ 5.1705556 0.050000
+ 5.1708333 0.050000
+ 5.1711111 0.050000
+ 5.1713889 0.050000
+ 5.1716667 0.050000
+ 5.1719444 0.050000
+ 5.1722222 0.054756
+ 5.1725000 0.098366
+ 5.1727778 0.147676
+ 5.1730556 0.200290
+ 5.1733333 0.253810
+ 5.1736111 0.305841
+ 5.1738889 0.353986
+ 5.1741667 0.395847
+ 5.1744444 0.429028
+ 5.1747222 0.451133
+ 5.1750000 0.459765
+ 5.1752778 0.453315
+ 5.1755556 0.433329
+ 5.1758333 0.402144
+ 5.1761111 0.362092
+ 5.1763889 0.315509
+ 5.1766667 0.264730
+ 5.1769444 0.212089
+ 5.1772222 0.159921
+ 5.1775000 0.110560
+ 5.1777778 0.066342
+ 5.1780556 0.050000
+ 5.1783333 0.050000
+ 5.1786111 0.050000
+ 5.1788889 0.050000
+ 5.1791667 0.050000
+ 5.1794444 0.050000
+ 5.1797222 0.050000
+ 5.1800000 0.050000
+ 5.1802778 0.050000
+ 5.1805556 0.050000
+ 5.1808333 0.093329
+ 5.1811111 0.142760
+ 5.1813889 0.195808
+ 5.1816667 0.249988
+ 5.1819444 0.302817
+ 5.1822222 0.351808
+ 5.1825000 0.394478
+ 5.1827778 0.428342
+ 5.1830556 0.450915
+ 5.1833333 0.459712
+ 5.1836111 0.453066
+ 5.1838889 0.432571
+ 5.1841667 0.400643
+ 5.1844444 0.359692
+ 5.1847222 0.312132
+ 5.1850000 0.260376
+ 5.1852778 0.206837
+ 5.1855556 0.153927
+ 5.1858333 0.104059
+ 5.1861111 0.059647
+ 5.1863889 0.050000
+ 5.1866667 0.050000
+ 5.1869444 0.050000
+ 5.1872222 0.050000
+ 5.1875000 0.050000
+ 5.1877778 0.050000
+ 5.1880556 0.050000
+ 5.1883333 0.050000
+ 5.1886111 0.050000
+ 5.1888889 0.051409
+ 5.1891667 0.095103
+ 5.1894444 0.144658
+ 5.1897222 0.197638
+ 5.1900000 0.251607
+ 5.1902778 0.304128
+ 5.1905556 0.352764
+ 5.1908333 0.395078
+ 5.1911111 0.428634
+ 5.1913889 0.450995
+ 5.1916667 0.459725
+ 5.1919444 0.453189
+ 5.1922222 0.432959
+ 5.1925000 0.401408
+ 5.1927778 0.360911
+ 5.1930556 0.313842
+ 5.1933333 0.262574
+ 5.1936111 0.209481
+ 5.1938889 0.156938
+ 5.1941667 0.107318
+ 5.1944444 0.062994
+ 5.1947222 0.050000
+ 5.1950000 0.050000
+ 5.1952778 0.050000
+ 5.1955556 0.050000
+ 5.1958333 0.050000
+ 5.1961111 0.050000
+ 5.1963889 0.050000
+ 5.1966667 0.050000
+ 5.1969444 0.050000
+ 5.1972222 0.050000
+ 5.1975000 0.093312
+ 5.1977778 0.142597
+ 5.1980556 0.195420
+ 5.1983333 0.249346
+ 5.1986111 0.301940
+ 5.1988889 0.350767
+ 5.1991667 0.393391
+ 5.1994444 0.427378
+ 5.1997222 0.450293
+ 5.2000000 0.459699
+ 5.2002778 0.453958
+ 5.2005556 0.434605
+ 5.2008333 0.403975
+ 5.2011111 0.364399
+ 5.2013889 0.318209
+ 5.2016667 0.267738
+ 5.2019444 0.215318
+ 5.2022222 0.163282
+ 5.2025000 0.113962
+ 5.2027778 0.069689
+ 5.2030556 0.050000
+ 5.2033333 0.050000
+ 5.2036111 0.050000
+ 5.2038889 0.050000
+ 5.2041667 0.050000
+ 5.2044444 0.050000
+ 5.2047222 0.050000
+ 5.2050000 0.050000
+ 5.2052778 0.050000
+ 5.2055556 0.050000
+ 5.2058333 0.093039
+ 5.2061111 0.142235
+ 5.2063889 0.195108
+ 5.2066667 0.249175
+ 5.2069444 0.301954
+ 5.2072222 0.350963
+ 5.2075000 0.393720
+ 5.2077778 0.427743
+ 5.2080556 0.450551
+ 5.2083333 0.459660
+ 5.2086111 0.453401
+ 5.2088889 0.433350
+ 5.2091667 0.401895
+ 5.2094444 0.361425
+ 5.2097222 0.314326
+ 5.2100000 0.262987
+ 5.2102778 0.209797
+ 5.2105556 0.157143
+ 5.2108333 0.107412
+ 5.2111111 0.062994
+ 5.2113889 0.050000
+ 5.2116667 0.050000
+ 5.2119444 0.050000
+ 5.2122222 0.050000
+ 5.2125000 0.050000
+ 5.2127778 0.050000
+ 5.2130556 0.050000
+ 5.2133333 0.050000
+ 5.2136111 0.050000
+ 5.2138889 0.050000
+ 5.2141667 0.093327
+ 5.2144444 0.142620
+ 5.2147222 0.195445
+ 5.2150000 0.249370
+ 5.2152778 0.301959
+ 5.2155556 0.350781
+ 5.2158333 0.393400
+ 5.2161111 0.427384
+ 5.2163889 0.450300
+ 5.2166667 0.459712
+ 5.2169444 0.453983
+ 5.2172222 0.434647
+ 5.2175000 0.404034
+ 5.2177778 0.364474
+ 5.2180556 0.318297
+ 5.2183333 0.267832
+ 5.2186111 0.215409
+ 5.2188889 0.163358
+ 5.2191667 0.114008
+ 5.2194444 0.069689
+ 5.2197222 0.050000
+ 5.2200000 0.050000
+ 5.2202778 0.050000
+ 5.2205556 0.050000
+ 5.2208333 0.050000
+ 5.2211111 0.050000
+ 5.2213889 0.050000
+ 5.2216667 0.050000
+ 5.2219444 0.050000
+ 5.2222222 0.050000
+ 5.2225000 0.093281
+ 5.2227778 0.142758
+ 5.2230556 0.195916
+ 5.2233333 0.250238
+ 5.2236111 0.303208
+ 5.2238889 0.352309
+ 5.2241667 0.395025
+ 5.2244444 0.428840
+ 5.2247222 0.451237
+ 5.2250000 0.459699
+ 5.2252778 0.452540
+ 5.2255556 0.431385
+ 5.2258333 0.398691
+ 5.2261111 0.356911
+ 5.2263889 0.308502
+ 5.2266667 0.255919
+ 5.2269444 0.201618
+ 5.2272222 0.148052
+ 5.2275000 0.097679
+ 5.2277778 0.052952
+ 5.2280556 0.050000
+ 5.2283333 0.050000
+ 5.2286111 0.050000
+ 5.2288889 0.050000
+ 5.2291667 0.050000
+ 5.2294444 0.050000
+ 5.2297222 0.050000
+ 5.2300000 0.050000
+ 5.2302778 0.050000
+ 5.2305556 0.050000
+ 5.2308333 0.094495
+ 5.2311111 0.144789
+ 5.2313889 0.198412
+ 5.2316667 0.252895
+ 5.2319444 0.305766
+ 5.2322222 0.354557
+ 5.2325000 0.396798
+ 5.2327778 0.430018
+ 5.2330556 0.451747
+ 5.2333333 0.459516
+ 5.2336111 0.451679
+ 5.2338889 0.429885
+ 5.2341667 0.396610
+ 5.2344444 0.354326
+ 5.2347222 0.305508
+ 5.2350000 0.252630
+ 5.2352778 0.198166
+ 5.2355556 0.144590
+ 5.2358333 0.094377
+ 5.2361111 0.050000
+ 5.2363889 0.050000
+ 5.2366667 0.050000
+ 5.2369444 0.050000
+ 5.2372222 0.050000
+ 5.2375000 0.050000
+ 5.2377778 0.050000
+ 5.2380556 0.050000
+ 5.2383333 0.050000
+ 5.2386111 0.050000
+ 5.2388889 0.050000
+ 5.2391667 0.093220
+ 5.2394444 0.141945
+ 5.2397222 0.193920
+ 5.2400000 0.246889
+ 5.2402778 0.298598
+ 5.2405556 0.346791
+ 5.2408333 0.389213
+ 5.2411111 0.423610
+ 5.2413889 0.447726
+ 5.2416667 0.459307
+ 5.2419444 0.456814
+ 5.2422222 0.441577
+ 5.2425000 0.415642
+ 5.2427778 0.381057
+ 5.2430556 0.339869
+ 5.2433333 0.294124
+ 5.2436111 0.245869
+ 5.2438889 0.197151
+ 5.2441667 0.150016
+ 5.2444444 0.106512
+ 5.2447222 0.068413
+ 5.2450000 0.050000
+ 5.2452778 0.050000
+ 5.2455556 0.050000
+ 5.2458333 0.050000
+ 5.2461111 0.050000
+ 5.2463889 0.050000
+ 5.2466667 0.050000
+ 5.2469444 0.050000
+ 5.2472222 0.050000
+ 5.2475000 0.091207
+ 5.2477778 0.139895
+ 5.2480556 0.193687
+ 5.2483333 0.250204
+ 5.2486111 0.307069
+ 5.2488889 0.361904
+ 5.2491667 0.412332
+ 5.2494444 0.455974
+ 5.2497222 0.490452
+ 5.2500000 0.513390
+ 5.2502778 0.523165
+ 5.2505556 0.521180
+ 5.2508333 0.509595
+ 5.2511111 0.490568
+ 5.2513889 0.466259
+ 5.2516667 0.438826
+ 5.2519444 0.410429
+ 5.2522222 0.383228
+ 5.2525000 0.359380
+ 5.2527778 0.341046
+ 5.2530556 0.329859
+ 5.2533333 0.325354
+ 5.2536111 0.326539
+ 5.2538889 0.332424
+ 5.2541667 0.342018
+ 5.2544444 0.354329
+ 5.2547222 0.368368
+ 5.2550000 0.383143
+ 5.2552778 0.397663
+ 5.2555556 0.410938
+ 5.2558333 0.422235
+ 5.2561111 0.431853
+ 5.2563889 0.440351
+ 5.2566667 0.448287
+ 5.2569444 0.456220
+ 5.2572222 0.464707
+ 5.2575000 0.474307
+ 5.2577778 0.485578
+ 5.2580556 0.499078
+ 5.2583333 0.515364
+ 5.2586111 0.534601
+ 5.2588889 0.555367
+ 5.2591667 0.575847
+ 5.2594444 0.594225
+ 5.2597222 0.608684
+ 5.2600000 0.617409
+ 5.2602778 0.618583
+ 5.2605556 0.610392
+ 5.2608333 0.591018
+ 5.2611111 0.558647
+ 5.2613889 0.512391
+ 5.2616667 0.455082
+ 5.2619444 0.390480
+ 5.2622222 0.322347
+ 5.2625000 0.254444
+ 5.2627778 0.190531
+ 5.2630556 0.134370
+ 5.2633333 0.089720
+ 5.2636111 0.060343
+ 5.2638889 0.050000
+ 5.2641667 0.061093
+ 5.2644444 0.090593
+ 5.2647222 0.134111
+ 5.2650000 0.187259
+ 5.2652778 0.245649
+ 5.2655556 0.304893
+ 5.2658333 0.360602
+ 5.2661111 0.408389
+ 5.2663889 0.443865
+ 5.2666667 0.462641
+ 5.2669444 0.461615
+ 5.2672222 0.442813
+ 5.2675000 0.409549
+ 5.2677778 0.365135
+ 5.2680556 0.312884
+ 5.2683333 0.256108
+ 5.2686111 0.198119
+ 5.2688889 0.142230
+ 5.2691667 0.091752
+ 5.2694444 0.050000
+ 5.2697222 0.050000
+ 5.2700000 0.050000
+ 5.2702778 0.050000
+ 5.2705556 0.050000
+ 5.2708333 0.050000
+ 5.2711111 0.050000
+ 5.2713889 0.050000
+ 5.2716667 0.072784
+ 5.2719444 0.108249
+ 5.2722222 0.148146
+ 5.2725000 0.191485
+ 5.2727778 0.236693
+ 5.2730556 0.282053
+ 5.2733333 0.325851
+ 5.2736111 0.366368
+ 5.2738889 0.401887
+ 5.2741667 0.430693
+ 5.2744444 0.451068
+ 5.2747222 0.461296
+ 5.2750000 0.459660
+ 5.2752778 0.445080
+ 5.2755556 0.419024
+ 5.2758333 0.383597
+ 5.2761111 0.340903
+ 5.2763889 0.293047
+ 5.2766667 0.242133
+ 5.2769444 0.190267
+ 5.2772222 0.139553
+ 5.2775000 0.092096
+ 5.2777778 0.050000
+ 5.2780556 0.050000
+ 5.2783333 0.050000
+ 5.2786111 0.050000
+ 5.2788889 0.050000
+ 5.2791667 0.050000
+ 5.2794444 0.050000
+ 5.2797222 0.050000
+ 5.2800000 0.050000
+ 5.2802778 0.050000
+ 5.2805556 0.050000
+ 5.2808333 0.093839
+ 5.2811111 0.143537
+ 5.2813889 0.196655
+ 5.2816667 0.250757
+ 5.2819444 0.303404
+ 5.2822222 0.352159
+ 5.2825000 0.394584
+ 5.2827778 0.428241
+ 5.2830556 0.450694
+ 5.2833333 0.459503
+ 5.2836111 0.453034
+ 5.2838889 0.432859
+ 5.2841667 0.401353
+ 5.2844444 0.360890
+ 5.2847222 0.313844
+ 5.2850000 0.262591
+ 5.2852778 0.209505
+ 5.2855556 0.156961
+ 5.2858333 0.107332
+ 5.2861111 0.062994
+ 5.2863889 0.050000
+ 5.2866667 0.050000
+ 5.2869444 0.050000
+ 5.2872222 0.050000
+ 5.2875000 0.050000
+ 5.2877778 0.050000
+ 5.2880556 0.050000
+ 5.2883333 0.050000
+ 5.2886111 0.050000
+ 5.2888889 0.050000
+ 5.2891667 0.093385
+ 5.2894444 0.142754
+ 5.2897222 0.195661
+ 5.2900000 0.249660
+ 5.2902778 0.302305
+ 5.2905556 0.351149
+ 5.2908333 0.393746
+ 5.2911111 0.427650
+ 5.2913889 0.450415
+ 5.2916667 0.459595
+ 5.2919444 0.453543
+ 5.2922222 0.433815
+ 5.2925000 0.402768
+ 5.2927778 0.362755
+ 5.2930556 0.316134
+ 5.2933333 0.265259
+ 5.2936111 0.212487
+ 5.2938889 0.160173
+ 5.2941667 0.110673
+ 5.2944444 0.066342
+ 5.2947222 0.050000
+ 5.2950000 0.050000
+ 5.2952778 0.050000
+ 5.2955556 0.050000
+ 5.2958333 0.050000
+ 5.2961111 0.050000
+ 5.2963889 0.050000
+ 5.2966667 0.050000
+ 5.2969444 0.050000
+ 5.2972222 0.050000
+ 5.2975000 0.093255
+ 5.2977778 0.142587
+ 5.2980556 0.195526
+ 5.2983333 0.249602
+ 5.2986111 0.302346
+ 5.2988889 0.351287
+ 5.2991667 0.393958
+ 5.2994444 0.427888
+ 5.2997222 0.450607
+ 5.3000000 0.459647
+ 5.3002778 0.453346
+ 5.3005556 0.433277
+ 5.3008333 0.401824
+ 5.3011111 0.361368
+ 5.3013889 0.314293
+ 5.3016667 0.262979
+ 5.3019444 0.209810
+ 5.3022222 0.157168
+ 5.3025000 0.107436
+ 5.3027778 0.062994
+ 5.3030556 0.050000
+ 5.3033333 0.050000
+ 5.3036111 0.050000
+ 5.3038889 0.050000
+ 5.3041667 0.050000
+ 5.3044444 0.050000
+ 5.3047222 0.050000
+ 5.3050000 0.050000
+ 5.3052778 0.050000
+ 5.3055556 0.050000
+ 5.3058333 0.093560
+ 5.3061111 0.143124
+ 5.3063889 0.196224
+ 5.3066667 0.250392
+ 5.3069444 0.303159
+ 5.3072222 0.352057
+ 5.3075000 0.394616
+ 5.3077778 0.428369
+ 5.3080556 0.450847
+ 5.3083333 0.459582
+ 5.3086111 0.452915
+ 5.3088889 0.432439
+ 5.3091667 0.400553
+ 5.3094444 0.359661
+ 5.3097222 0.312163
+ 5.3100000 0.260461
+ 5.3102778 0.206956
+ 5.3105556 0.154052
+ 5.3108333 0.104148
+ 5.3111111 0.059647
+ 5.3113889 0.050000
+ 5.3116667 0.050000
+ 5.3119444 0.050000
+ 5.3122222 0.050000
+ 5.3125000 0.050000
+ 5.3127778 0.050000
+ 5.3130556 0.050000
+ 5.3133333 0.050000
+ 5.3136111 0.050000
+ 5.3138889 0.050000
+ 5.3141667 0.093876
+ 5.3144444 0.143693
+ 5.3147222 0.196980
+ 5.3150000 0.251267
+ 5.3152778 0.304083
+ 5.3155556 0.352957
+ 5.3158333 0.395419
+ 5.3161111 0.428997
+ 5.3163889 0.451221
+ 5.3166667 0.459621
+ 5.3169444 0.452542
+ 5.3172222 0.431596
+ 5.3175000 0.399212
+ 5.3177778 0.357820
+ 5.3180556 0.309848
+ 5.3183333 0.257725
+ 5.3186111 0.203880
+ 5.3188889 0.150741
+ 5.3191667 0.100738
+ 5.3194444 0.056299
+ 5.3197222 0.050000
+ 5.3200000 0.050000
+ 5.3202778 0.050000
+ 5.3205556 0.050000
+ 5.3208333 0.050000
+ 5.3211111 0.050000
+ 5.3213889 0.050000
+ 5.3216667 0.050000
+ 5.3219444 0.050000
+ 5.3222222 0.050000
+ 5.3225000 0.093513
+ 5.3227778 0.142793
+ 5.3230556 0.195466
+ 5.3233333 0.249155
+ 5.3236111 0.301486
+ 5.3238889 0.350082
+ 5.3241667 0.392567
+ 5.3244444 0.426567
+ 5.3247222 0.449706
+ 5.3250000 0.459608
+ 5.3252778 0.454669
+ 5.3255556 0.436372
+ 5.3258333 0.406973
+ 5.3261111 0.368727
+ 5.3263889 0.323888
+ 5.3266667 0.274711
+ 5.3269444 0.223453
+ 5.3272222 0.172366
+ 5.3275000 0.123708
+ 5.3277778 0.079732
+ 5.3280556 0.050000
+ 5.3283333 0.050000
+ 5.3286111 0.050000
+ 5.3288889 0.050000
+ 5.3291667 0.050000
+ 5.3294444 0.050000
+ 5.3297222 0.050000
+ 5.3300000 0.050000
+ 5.3302778 0.050000
+ 5.3305556 0.050000
+ 5.3308333 0.092178
+ 5.3311111 0.140732
+ 5.3313889 0.193170
+ 5.3316667 0.246999
+ 5.3319444 0.299724
+ 5.3322222 0.348852
+ 5.3325000 0.391890
+ 5.3327778 0.426345
+ 5.3330556 0.449722
+ 5.3333333 0.459529
+ 5.3336111 0.454079
+ 5.3338889 0.434914
+ 5.3341667 0.404383
+ 5.3344444 0.364834
+ 5.3347222 0.318615
+ 5.3350000 0.268076
+ 5.3352778 0.215565
+ 5.3355556 0.163432
+ 5.3358333 0.114023
+ 5.3361111 0.069689
+ 5.3363889 0.050000
+ 5.3366667 0.050000
+ 5.3369444 0.050000
+ 5.3372222 0.050000
+ 5.3375000 0.050000
+ 5.3377778 0.050000
+ 5.3380556 0.050000
+ 5.3383333 0.050000
+ 5.3386111 0.050000
+ 5.3388889 0.050000
+ 5.3391667 0.092887
+ 5.3394444 0.141898
+ 5.3397222 0.194575
+ 5.3400000 0.248460
+ 5.3402778 0.301098
+ 5.3405556 0.350030
+ 5.3408333 0.392799
+ 5.3411111 0.426948
+ 5.3413889 0.450019
+ 5.3416667 0.459555
+ 5.3419444 0.453899
+ 5.3422222 0.434592
+ 5.3425000 0.403976
+ 5.3427778 0.364392
+ 5.3430556 0.318182
+ 5.3433333 0.267687
+ 5.3436111 0.215249
+ 5.3438889 0.163209
+ 5.3441667 0.113908
+ 5.3444444 0.069689
+ 5.3447222 0.050000
+ 5.3450000 0.050000
+ 5.3452778 0.050000
+ 5.3455556 0.050000
+ 5.3458333 0.050000
+ 5.3461111 0.050000
+ 5.3463889 0.050000
+ 5.3466667 0.050000
+ 5.3469444 0.050000
+ 5.3472222 0.050000
+ 5.3475000 0.092627
+ 5.3477778 0.141343
+ 5.3480556 0.193726
+ 5.3483333 0.247353
+ 5.3486111 0.299802
+ 5.3488889 0.348650
+ 5.3491667 0.391474
+ 5.3494444 0.425853
+ 5.3497222 0.449363
+ 5.3500000 0.459582
+ 5.3502778 0.454869
+ 5.3505556 0.436712
+ 5.3508333 0.407379
+ 5.3511111 0.369140
+ 5.3513889 0.324263
+ 5.3516667 0.275017
+ 5.3519444 0.223673
+ 5.3522222 0.172498
+ 5.3525000 0.123761
+ 5.3527778 0.079732
+ 5.3530556 0.050000
+ 5.3533333 0.050000
+ 5.3536111 0.050000
+ 5.3538889 0.050000
+ 5.3541667 0.050000
+ 5.3544444 0.050000
+ 5.3547222 0.050000
+ 5.3550000 0.050000
+ 5.3552778 0.050000
+ 5.3555556 0.050000
+ 5.3558333 0.092031
+ 5.3561111 0.140407
+ 5.3563889 0.192659
+ 5.3566667 0.246319
+ 5.3569444 0.298917
+ 5.3572222 0.347984
+ 5.3575000 0.391052
+ 5.3577778 0.425651
+ 5.3580556 0.449313
+ 5.3583333 0.459568
+ 5.3586111 0.454743
+ 5.3588889 0.436342
+ 5.3591667 0.406666
+ 5.3594444 0.368013
+ 5.3597222 0.322683
+ 5.3600000 0.272978
+ 5.3602778 0.221195
+ 5.3605556 0.169636
+ 5.3608333 0.120599
+ 5.3611111 0.076384
+ 5.3613889 0.050000
+ 5.3616667 0.050000
+ 5.3619444 0.050000
+ 5.3622222 0.050000
+ 5.3625000 0.050000
+ 5.3627778 0.050000
+ 5.3630556 0.050000
+ 5.3633333 0.050000
+ 5.3636111 0.050000
+ 5.3638889 0.050000
+ 5.3641667 0.092528
+ 5.3644444 0.141356
+ 5.3647222 0.193992
+ 5.3650000 0.247942
+ 5.3652778 0.300713
+ 5.3655556 0.349811
+ 5.3658333 0.392743
+ 5.3661111 0.427015
+ 5.3663889 0.450134
+ 5.3666667 0.459608
+ 5.3669444 0.453752
+ 5.3672222 0.434131
+ 5.3675000 0.403115
+ 5.3677778 0.363080
+ 5.3680556 0.316398
+ 5.3683333 0.265442
+ 5.3686111 0.212585
+ 5.3688889 0.160200
+ 5.3691667 0.110662
+ 5.3694444 0.066342
+ 5.3697222 0.050000
+ 5.3700000 0.050000
+ 5.3702778 0.050000
+ 5.3705556 0.050000
+ 5.3708333 0.050000
+ 5.3711111 0.050000
+ 5.3713889 0.050000
+ 5.3716667 0.050000
+ 5.3719444 0.050000
+ 5.3722222 0.050000
+ 5.3725000 0.092770
+ 5.3727778 0.141530
+ 5.3730556 0.193883
+ 5.3733333 0.247432
+ 5.3736111 0.299779
+ 5.3738889 0.348528
+ 5.3741667 0.391281
+ 5.3744444 0.425641
+ 5.3747222 0.449211
+ 5.3750000 0.459595
+ 5.3752778 0.455166
+ 5.3755556 0.437390
+ 5.3758333 0.408503
+ 5.3761111 0.370742
+ 5.3763889 0.326344
+ 5.3766667 0.277546
+ 5.3769444 0.226583
+ 5.3772222 0.175693
+ 5.3775000 0.127113
+ 5.3777778 0.083079
+ 5.3780556 0.050000
+ 5.3783333 0.050000
+ 5.3786111 0.050000
+ 5.3788889 0.050000
+ 5.3791667 0.050000
+ 5.3794444 0.050000
+ 5.3797222 0.050000
+ 5.3800000 0.050000
+ 5.3802778 0.050000
+ 5.3805556 0.050000
+ 5.3808333 0.092295
+ 5.3811111 0.141097
+ 5.3813889 0.193854
+ 5.3816667 0.248014
+ 5.3819444 0.301026
+ 5.3822222 0.350338
+ 5.3825000 0.393399
+ 5.3827778 0.427656
+ 5.3830556 0.450559
+ 5.3833333 0.459555
+ 5.3836111 0.452927
+ 5.3838889 0.432286
+ 5.3841667 0.400081
+ 5.3844444 0.358756
+ 5.3847222 0.310758
+ 5.3850000 0.258534
+ 5.3852778 0.204530
+ 5.3855556 0.151192
+ 5.3858333 0.100966
+ 5.3861111 0.056299
+ 5.3863889 0.050000
+ 5.3866667 0.050000
+ 5.3869444 0.050000
+ 5.3872222 0.050000
+ 5.3875000 0.050000
+ 5.3877778 0.050000
+ 5.3880556 0.050000
+ 5.3883333 0.050000
+ 5.3886111 0.050000
+ 5.3888889 0.050000
+ 5.3891667 0.093951
+ 5.3894444 0.143724
+ 5.3897222 0.196887
+ 5.3900000 0.251006
+ 5.3902778 0.303650
+ 5.3905556 0.352385
+ 5.3908333 0.394778
+ 5.3911111 0.428397
+ 5.3913889 0.450809
+ 5.3916667 0.459582
+ 5.3919444 0.453082
+ 5.3922222 0.432885
+ 5.3925000 0.401362
+ 5.3927778 0.360888
+ 5.3930556 0.313836
+ 5.3933333 0.262580
+ 5.3936111 0.209495
+ 5.3938889 0.156953
+ 5.3941667 0.107328
+ 5.3944444 0.062994
+ 5.3947222 0.050000
+ 5.3950000 0.050000
+ 5.3952778 0.050000
+ 5.3955556 0.050000
+ 5.3958333 0.050000
+ 5.3961111 0.050000
+ 5.3963889 0.050000
+ 5.3966667 0.050000
+ 5.3969444 0.050000
+ 5.3972222 0.050000
+ 5.3975000 0.093377
+ 5.3977778 0.142738
+ 5.3980556 0.195636
+ 5.3983333 0.249627
+ 5.3986111 0.302265
+ 5.3988889 0.351104
+ 5.3991667 0.393699
+ 5.3994444 0.427605
+ 5.3997222 0.450377
+ 5.4000000 0.459568
+ 5.4002778 0.453534
+ 5.4005556 0.433828
+ 5.4008333 0.402802
+ 5.4011111 0.362810
+ 5.4013889 0.316205
+ 5.4016667 0.265340
+ 5.4019444 0.212568
+ 5.4022222 0.160242
+ 5.4025000 0.110716
+ 5.4027778 0.066342
+ 5.4030556 0.050000
+ 5.4033333 0.050000
+ 5.4036111 0.050000
+ 5.4038889 0.050000
+ 5.4041667 0.050000
+ 5.4044444 0.050000
+ 5.4047222 0.050000
+ 5.4050000 0.050000
+ 5.4052778 0.050000
+ 5.4055556 0.050000
+ 5.4058333 0.093487
+ 5.4061111 0.143088
+ 5.4063889 0.196297
+ 5.4066667 0.250612
+ 5.4069444 0.303530
+ 5.4072222 0.352546
+ 5.4075000 0.395158
+ 5.4077778 0.428862
+ 5.4080556 0.451153
+ 5.4083333 0.459529
+ 5.4086111 0.452312
+ 5.4088889 0.431128
+ 5.4091667 0.398427
+ 5.4094444 0.356660
+ 5.4097222 0.308279
+ 5.4100000 0.255735
+ 5.4102778 0.201479
+ 5.4105556 0.147963
+ 5.4108333 0.097637
+ 5.4111111 0.052952
+ 5.4113889 0.050000
+ 5.4116667 0.050000
+ 5.4119444 0.050000
+ 5.4122222 0.050000
+ 5.4125000 0.050000
+ 5.4127778 0.050000
+ 5.4130556 0.050000
+ 5.4133333 0.050000
+ 5.4136111 0.050000
+ 5.4138889 0.050000
+ 5.4141667 0.094466
+ 5.4144444 0.144731
+ 5.4147222 0.198328
+ 5.4150000 0.252790
+ 5.4152778 0.305650
+ 5.4155556 0.354441
+ 5.4158333 0.396697
+ 5.4161111 0.429950
+ 5.4163889 0.451734
+ 5.4166667 0.459582
+ 5.4169444 0.451847
+ 5.4172222 0.430170
+ 5.4175000 0.397009
+ 5.4177778 0.354825
+ 5.4180556 0.306079
+ 5.4183333 0.253229
+ 5.4186111 0.198736
+ 5.4188889 0.145060
+ 5.4191667 0.094662
+ 5.4194444 0.050000
+ 5.4197222 0.050000
+ 5.4200000 0.050000
+ 5.4202778 0.050000
+ 5.4205556 0.050000
+ 5.4208333 0.050000
+ 5.4211111 0.050000
+ 5.4213889 0.050000
+ 5.4216667 0.050000
+ 5.4219444 0.050000
+ 5.4222222 0.050000
+ 5.4225000 0.094647
+ 5.4227778 0.145026
+ 5.4230556 0.198681
+ 5.4233333 0.253153
+ 5.4236111 0.305987
+ 5.4238889 0.354725
+ 5.4241667 0.396909
+ 5.4244444 0.430082
+ 5.4247222 0.451788
+ 5.4250000 0.459568
+ 5.4252778 0.451786
+ 5.4255556 0.430078
+ 5.4258333 0.396903
+ 5.4261111 0.354717
+ 5.4263889 0.305978
+ 5.4266667 0.253144
+ 5.4269444 0.198672
+ 5.4272222 0.145019
+ 5.4275000 0.094643
+ 5.4277778 0.050000
+ 5.4280556 0.050000
+ 5.4283333 0.050000
+ 5.4286111 0.050000
+ 5.4288889 0.050000
+ 5.4291667 0.050000
+ 5.4294444 0.050000
+ 5.4297222 0.050000
+ 5.4300000 0.050000
+ 5.4302778 0.050000
+ 5.4305556 0.050000
+ 5.4308333 0.094643
+ 5.4311111 0.145020
+ 5.4313889 0.198673
+ 5.4316667 0.253146
+ 5.4319444 0.305980
+ 5.4322222 0.354719
+ 5.4325000 0.396904
+ 5.4327778 0.430079
+ 5.4330556 0.451787
+ 5.4333333 0.459568
+ 5.4336111 0.451787
+ 5.4338889 0.430080
+ 5.4341667 0.396905
+ 5.4344444 0.354719
+ 5.4347222 0.305981
+ 5.4350000 0.253146
+ 5.4352778 0.198674
+ 5.4355556 0.145020
+ 5.4358333 0.094643
+ 5.4361111 0.050000
+ 5.4363889 0.050000
+ 5.4366667 0.050000
+ 5.4369444 0.050000
+ 5.4372222 0.050000
+ 5.4375000 0.050000
+ 5.4377778 0.050000
+ 5.4380556 0.050000
+ 5.4383333 0.050000
+ 5.4386111 0.050000
+ 5.4388889 0.050000
+ 5.4391667 0.094644
+ 5.4394444 0.145023
+ 5.4397222 0.198678
+ 5.4400000 0.253152
+ 5.4402778 0.305988
+ 5.4405556 0.354728
+ 5.4408333 0.396915
+ 5.4411111 0.430091
+ 5.4413889 0.451799
+ 5.4416667 0.459582
+ 5.4419444 0.451800
+ 5.4422222 0.430092
+ 5.4425000 0.396916
+ 5.4427778 0.354729
+ 5.4430556 0.305989
+ 5.4433333 0.253153
+ 5.4436111 0.198678
+ 5.4438889 0.145023
+ 5.4441667 0.094644
+ 5.4444444 0.050000
+ 5.4447222 0.050000
+ 5.4450000 0.050000
+ 5.4452778 0.050000
+ 5.4455556 0.050000
+ 5.4458333 0.050000
+ 5.4461111 0.050000
+ 5.4463889 0.050000
+ 5.4466667 0.050000
+ 5.4469444 0.050000
+ 5.4472222 0.050000
+ 5.4475000 0.094645
+ 5.4477778 0.145023
+ 5.4480556 0.198679
+ 5.4483333 0.253153
+ 5.4486111 0.305990
+ 5.4488889 0.354730
+ 5.4491667 0.396917
+ 5.4494444 0.430093
+ 5.4497222 0.451800
+ 5.4500000 0.459582
+ 5.4502778 0.451799
+ 5.4505556 0.430090
+ 5.4508333 0.396913
+ 5.4511111 0.354725
+ 5.4513889 0.305985
+ 5.4516667 0.253148
+ 5.4519444 0.198674
+ 5.4522222 0.145020
+ 5.4525000 0.094642
+ 5.4527778 0.050000
+ 5.4530556 0.050000
+ 5.4533333 0.050000
+ 5.4536111 0.050000
+ 5.4538889 0.050000
+ 5.4541667 0.050000
+ 5.4544444 0.050000
+ 5.4547222 0.050000
+ 5.4550000 0.050000
+ 5.4552778 0.050000
+ 5.4555556 0.050000
+ 5.4558333 0.094634
+ 5.4561111 0.144999
+ 5.4563889 0.198639
+ 5.4566667 0.253098
+ 5.4569444 0.305919
+ 5.4572222 0.354644
+ 5.4575000 0.396818
+ 5.4577778 0.429984
+ 5.4580556 0.451685
+ 5.4583333 0.459464
+ 5.4586111 0.451684
+ 5.4588889 0.429982
+ 5.4591667 0.396815
+ 5.4594444 0.354640
+ 5.4597222 0.305914
+ 5.4600000 0.253093
+ 5.4602778 0.198635
+ 5.4605556 0.144995
+ 5.4608333 0.094631
+ 5.4611111 0.050000
+ 5.4613889 0.050000
+ 5.4616667 0.050000
+ 5.4619444 0.050000
+ 5.4622222 0.050000
+ 5.4625000 0.050000
+ 5.4627778 0.050000
+ 5.4630556 0.050000
+ 5.4633333 0.050000
+ 5.4636111 0.050000
+ 5.4638889 0.050000
+ 5.4641667 0.094632
+ 5.4644444 0.144996
+ 5.4647222 0.198635
+ 5.4650000 0.253094
+ 5.4652778 0.305915
+ 5.4655556 0.354641
+ 5.4658333 0.396816
+ 5.4661111 0.429982
+ 5.4663889 0.451684
+ 5.4666667 0.459464
+ 5.4669444 0.451684
+ 5.4672222 0.429983
+ 5.4675000 0.396816
+ 5.4677778 0.354641
+ 5.4680556 0.305915
+ 5.4683333 0.253095
+ 5.4686111 0.198636
+ 5.4688889 0.144996
+ 5.4691667 0.094632
+ 5.4694444 0.050000
+ 5.4697222 0.050000
+ 5.4700000 0.050000
+ 5.4702778 0.050000
+ 5.4705556 0.050000
+ 5.4708333 0.050000
+ 5.4711111 0.050000
+ 5.4713889 0.050000
+ 5.4716667 0.050000
+ 5.4719444 0.050000
+ 5.4722222 0.050000
+ 5.4725000 0.094633
+ 5.4727778 0.144998
+ 5.4730556 0.198639
+ 5.4733333 0.253100
+ 5.4736111 0.305922
+ 5.4738889 0.354650
+ 5.4741667 0.396826
+ 5.4744444 0.429994
+ 5.4747222 0.451697
+ 5.4750000 0.459477
+ 5.4752778 0.451697
+ 5.4755556 0.429996
+ 5.4758333 0.396828
+ 5.4761111 0.354653
+ 5.4763889 0.305925
+ 5.4766667 0.253103
+ 5.4769444 0.198642
+ 5.4772222 0.145000
+ 5.4775000 0.094634
+ 5.4777778 0.050000
+ 5.4780556 0.050000
+ 5.4783333 0.050000
+ 5.4786111 0.050000
+ 5.4788889 0.050000
+ 5.4791667 0.050000
+ 5.4794444 0.050000
+ 5.4797222 0.050000
+ 5.4800000 0.050000
+ 5.4802778 0.050000
+ 5.4805556 0.050000
+ 5.4808333 0.094638
+ 5.4811111 0.145010
+ 5.4813889 0.198658
+ 5.4816667 0.253124
+ 5.4819444 0.305951
+ 5.4822222 0.354682
+ 5.4825000 0.396859
+ 5.4827778 0.430024
+ 5.4830556 0.451720
+ 5.4833333 0.459490
+ 5.4836111 0.451695
+ 5.4838889 0.429975
+ 5.4841667 0.396789
+ 5.4844444 0.354596
+ 5.4847222 0.305855
+ 5.4850000 0.253026
+ 5.4852778 0.198566
+ 5.4855556 0.144936
+ 5.4858333 0.094594
+ 5.4861111 0.050000
+ 5.4863889 0.050000
+ 5.4866667 0.050000
+ 5.4869444 0.050000
+ 5.4872222 0.050000
+ 5.4875000 0.050000
+ 5.4877778 0.050000
+ 5.4880556 0.050000
+ 5.4883333 0.050000
+ 5.4886111 0.050000
+ 5.4888889 0.050000
+ 5.4891667 0.094429
+ 5.4894444 0.144560
+ 5.4897222 0.197964
+ 5.4900000 0.252217
+ 5.4902778 0.304890
+ 5.4905556 0.353557
+ 5.4908333 0.395792
+ 5.4911111 0.429167
+ 5.4913889 0.451257
+ 5.4916667 0.459634
+ 5.4919444 0.452676
+ 5.4922222 0.431977
+ 5.4925000 0.399938
+ 5.4927778 0.358957
+ 5.4930556 0.311433
+ 5.4933333 0.259766
+ 5.4936111 0.206354
+ 5.4938889 0.153598
+ 5.4941667 0.103896
+ 5.4944444 0.059647
+ 5.4947222 0.050000
+ 5.4950000 0.050000
+ 5.4952778 0.050000
+ 5.4955556 0.050000
+ 5.4958333 0.050000
+ 5.4961111 0.050000
+ 5.4963889 0.050000
+ 5.4966667 0.050000
+ 5.4969444 0.050000
+ 5.4972222 0.050000
+ 5.4975000 0.092971
+ 5.4977778 0.141748
+ 5.4980556 0.193987
+ 5.4983333 0.247344
+ 5.4986111 0.299476
+ 5.4988889 0.348039
+ 5.4991667 0.390689
+ 5.4994444 0.425082
+ 5.4997222 0.448876
+ 5.5000000 0.459725
+ 5.5002778 0.456040
+ 5.5005556 0.439238
+ 5.5008333 0.411490
+ 5.5011111 0.374968
+ 5.5013889 0.331841
+ 5.5016667 0.284281
+ 5.5019444 0.234458
+ 5.5022222 0.184543
+ 5.5025000 0.136708
+ 5.5027778 0.093122
+ 5.5030556 0.055638
+ 5.5033333 0.050000
+ 5.5036111 0.050000
+ 5.5038889 0.050000
+ 5.5041667 0.050000
+ 5.5044444 0.050000
+ 5.5047222 0.050000
+ 5.5050000 0.050000
+ 5.5052778 0.050000
+ 5.5055556 0.050000
+ 5.5058333 0.090536
+ 5.5061111 0.137653
+ 5.5063889 0.188920
+ 5.5066667 0.241905
+ 5.5069444 0.294176
+ 5.5072222 0.343301
+ 5.5075000 0.386847
+ 5.5077778 0.422384
+ 5.5080556 0.447478
+ 5.5083333 0.459699
+ 5.5086111 0.457382
+ 5.5088889 0.441933
+ 5.5091667 0.415527
+ 5.5094444 0.380337
+ 5.5097222 0.338539
+ 5.5100000 0.292306
+ 5.5102778 0.243812
+ 5.5105556 0.195233
+ 5.5108333 0.148741
+ 5.5111111 0.106512
+ 5.5113889 0.070390
+ 5.5116667 0.050000
+ 5.5119444 0.050000
+ 5.5122222 0.050000
+ 5.5125000 0.050000
+ 5.5127778 0.050000
+ 5.5130556 0.050000
+ 5.5133333 0.050000
+ 5.5136111 0.050000
+ 5.5138889 0.068343
+ 5.5141667 0.107304
+ 5.5144444 0.152430
+ 5.5147222 0.201425
+ 5.5150000 0.251991
+ 5.5152778 0.301834
+ 5.5155556 0.348656
+ 5.5158333 0.390162
+ 5.5161111 0.424055
+ 5.5163889 0.448039
+ 5.5166667 0.459817
+ 5.5169444 0.457813
+ 5.5172222 0.443323
+ 5.5175000 0.418364
+ 5.5177778 0.384953
+ 5.5180556 0.345106
+ 5.5183333 0.300839
+ 5.5186111 0.254169
+ 5.5188889 0.207112
+ 5.5191667 0.161684
+ 5.5194444 0.119902
+ 5.5197222 0.083501
+ 5.5200000 0.053091
+ 5.5202778 0.050000
+ 5.5205556 0.050000
+ 5.5208333 0.050000
+ 5.5211111 0.050000
+ 5.5213889 0.050000
+ 5.5216667 0.050000
+ 5.5219444 0.050000
+ 5.5222222 0.065008
+ 5.5225000 0.102890
+ 5.5227778 0.147381
+ 5.5230556 0.196137
+ 5.5233333 0.246812
+ 5.5236111 0.297061
+ 5.5238889 0.344539
+ 5.5241667 0.386902
+ 5.5244444 0.421803
+ 5.5247222 0.446899
+ 5.5250000 0.459843
+ 5.5252778 0.459016
+ 5.5255556 0.445697
+ 5.5258333 0.421891
+ 5.5261111 0.389601
+ 5.5263889 0.350832
+ 5.5266667 0.307588
+ 5.5269444 0.261873
+ 5.5272222 0.215691
+ 5.5275000 0.171047
+ 5.5277778 0.129944
+ 5.5280556 0.094109
+ 5.5283333 0.064145
+ 5.5286111 0.050000
+ 5.5288889 0.050000
+ 5.5291667 0.050000
+ 5.5294444 0.050000
+ 5.5297222 0.050000
+ 5.5300000 0.050000
+ 5.5302778 0.050000
+ 5.5305556 0.075077
+ 5.5308333 0.112233
+ 5.5311111 0.155879
+ 5.5313889 0.203692
+ 5.5316667 0.253347
+ 5.5319444 0.302521
+ 5.5322222 0.348891
+ 5.5325000 0.390131
+ 5.5327778 0.423919
+ 5.5330556 0.447931
+ 5.5333333 0.459843
+ 5.5336111 0.458056
+ 5.5338889 0.443867
+ 5.5341667 0.419299
+ 5.5344444 0.386375
+ 5.5347222 0.347116
+ 5.5350000 0.303546
+ 5.5352778 0.257687
+ 5.5355556 0.211560
+ 5.5358333 0.167190
+ 5.5361111 0.126597
+ 5.5363889 0.091513
+ 5.5366667 0.062502
+ 5.5369444 0.050000
+ 5.5372222 0.050000
+ 5.5375000 0.050000
+ 5.5377778 0.050000
+ 5.5380556 0.050000
+ 5.5383333 0.050000
+ 5.5386111 0.052409
+ 5.5388889 0.081811
+ 5.5391667 0.119313
+ 5.5394444 0.163037
+ 5.5397222 0.210674
+ 5.5400000 0.259918
+ 5.5402778 0.308460
+ 5.5405556 0.353993
+ 5.5408333 0.394208
+ 5.5411111 0.426798
+ 5.5413889 0.449454
+ 5.5416667 0.459869
+ 5.5419444 0.456466
+ 5.5422222 0.440586
+ 5.5425000 0.414304
+ 5.5427778 0.379692
+ 5.5430556 0.338824
+ 5.5433333 0.293774
+ 5.5436111 0.246614
+ 5.5438889 0.199417
+ 5.5441667 0.154257
+ 5.5444444 0.113207
+ 5.5447222 0.078030
+ 5.5450000 0.050000
+ 5.5452778 0.050000
+ 5.5455556 0.050000
+ 5.5458333 0.050000
+ 5.5461111 0.050000
+ 5.5463889 0.050000
+ 5.5466667 0.050000
+ 5.5469444 0.050000
+ 5.5472222 0.075064
+ 5.5475000 0.113102
+ 5.5477778 0.157222
+ 5.5480556 0.205182
+ 5.5483333 0.254735
+ 5.5486111 0.303638
+ 5.5488889 0.349646
+ 5.5491667 0.390515
+ 5.5494444 0.424000
+ 5.5497222 0.447858
+ 5.5500000 0.459843
+ 5.5502778 0.458409
+ 5.5505556 0.444795
+ 5.5508333 0.420940
+ 5.5511111 0.388781
+ 5.5513889 0.350255
+ 5.5516667 0.307301
+ 5.5519444 0.261855
+ 5.5522222 0.215855
+ 5.5525000 0.171239
+ 5.5527778 0.129944
+ 5.5530556 0.093651
+ 5.5533333 0.063009
+ 5.5536111 0.050000
+ 5.5538889 0.050000
+ 5.5541667 0.050000
+ 5.5544444 0.050000
+ 5.5547222 0.050000
+ 5.5550000 0.050000
+ 5.5552778 0.050000
+ 5.5555556 0.068408
+ 5.5558333 0.105821
+ 5.5561111 0.150018
+ 5.5563889 0.198597
+ 5.5566667 0.249160
+ 5.5569444 0.299307
+ 5.5572222 0.346637
+ 5.5575000 0.388750
+ 5.5577778 0.423247
+ 5.5580556 0.447727
+ 5.5583333 0.459791
+ 5.5586111 0.457785
+ 5.5588889 0.443046
+ 5.5591667 0.417654
+ 5.5594444 0.383692
+ 5.5597222 0.343243
+ 5.5600000 0.298387
+ 5.5602778 0.251209
+ 5.5605556 0.203789
+ 5.5608333 0.158210
+ 5.5611111 0.116554
+ 5.5613889 0.080602
+ 5.5616667 0.050924
+ 5.5619444 0.050000
+ 5.5622222 0.050000
+ 5.5625000 0.050000
+ 5.5627778 0.050000
+ 5.5630556 0.050000
+ 5.5633333 0.050000
+ 5.5636111 0.050000
+ 5.5638889 0.071729
+ 5.5641667 0.110214
+ 5.5644444 0.155047
+ 5.5647222 0.203873
+ 5.5650000 0.254341
+ 5.5652778 0.304097
+ 5.5655556 0.350788
+ 5.5658333 0.392061
+ 5.5661111 0.425564
+ 5.5663889 0.448942
+ 5.5666667 0.459843
+ 5.5669444 0.456656
+ 5.5672222 0.440735
+ 5.5675000 0.414176
+ 5.5677778 0.379077
+ 5.5680556 0.337532
+ 5.5683333 0.291640
+ 5.5686111 0.243495
+ 5.5688889 0.195195
+ 5.5691667 0.148835
+ 5.5694444 0.106512
+ 5.5697222 0.070017
+ 5.5700000 0.050000
+ 5.5702778 0.050000
+ 5.5705556 0.050000
+ 5.5708333 0.050000
+ 5.5711111 0.050000
+ 5.5713889 0.050000
+ 5.5716667 0.050000
+ 5.5719444 0.050000
+ 5.5722222 0.061621
+ 5.5725000 0.100708
+ 5.5727778 0.146242
+ 5.5730556 0.195867
+ 5.5733333 0.247225
+ 5.5736111 0.297962
+ 5.5738889 0.345721
+ 5.5741667 0.388144
+ 5.5744444 0.422877
+ 5.5747222 0.447562
+ 5.5750000 0.459843
+ 5.5752778 0.458099
+ 5.5755556 0.443644
+ 5.5758333 0.418532
+ 5.5761111 0.384811
+ 5.5763889 0.344532
+ 5.5766667 0.299747
+ 5.5769444 0.252506
+ 5.5772222 0.204860
+ 5.5775000 0.158859
+ 5.5777778 0.116554
+ 5.5780556 0.079710
+ 5.5783333 0.050000
+ 5.5786111 0.050000
+ 5.5788889 0.050000
+ 5.5791667 0.050000
+ 5.5794444 0.050000
+ 5.5797222 0.050000
+ 5.5800000 0.050000
+ 5.5802778 0.050000
+ 5.5805556 0.061661
+ 5.5808333 0.100144
+ 5.5811111 0.145308
+ 5.5813889 0.194759
+ 5.5816667 0.246102
+ 5.5819444 0.296943
+ 5.5822222 0.344885
+ 5.5825000 0.387534
+ 5.5827778 0.422496
+ 5.5830556 0.447376
+ 5.5833333 0.459778
+ 5.5836111 0.458053
+ 5.5838889 0.443537
+ 5.5841667 0.418310
+ 5.5844444 0.384451
+ 5.5847222 0.344042
+ 5.5850000 0.299163
+ 5.5852778 0.251894
+ 5.5855556 0.204316
+ 5.5858333 0.158509
+ 5.5861111 0.116554
+ 5.5863889 0.080233
+ 5.5866667 0.050136
+ 5.5869444 0.050000
+ 5.5872222 0.050000
+ 5.5875000 0.050000
+ 5.5877778 0.050000
+ 5.5880556 0.050000
+ 5.5883333 0.050000
+ 5.5886111 0.050000
+ 5.5888889 0.068369
+ 5.5891667 0.106951
+ 5.5894444 0.152000
+ 5.5897222 0.201138
+ 5.5900000 0.251987
+ 5.5902778 0.302168
+ 5.5905556 0.349302
+ 5.5908333 0.391012
+ 5.5911111 0.424917
+ 5.5913889 0.448641
+ 5.5916667 0.459804
+ 5.5919444 0.456774
+ 5.5922222 0.440901
+ 5.5925000 0.414282
+ 5.5927778 0.379013
+ 5.5930556 0.337191
+ 5.5933333 0.290913
+ 5.5936111 0.242275
+ 5.5938889 0.193373
+ 5.5941667 0.146304
+ 5.5944444 0.103164
+ 5.5947222 0.065753
+ 5.5950000 0.050000
+ 5.5952778 0.050000
+ 5.5955556 0.050000
+ 5.5958333 0.050000
+ 5.5961111 0.050000
+ 5.5963889 0.050000
+ 5.5966667 0.050000
+ 5.5969444 0.050000
+ 5.5972222 0.051553
+ 5.5975000 0.091057
+ 5.5977778 0.137287
+ 5.5980556 0.187829
+ 5.5983333 0.240272
+ 5.5986111 0.292205
+ 5.5988889 0.341215
+ 5.5991667 0.384891
+ 5.5994444 0.420820
+ 5.5997222 0.446590
+ 5.6000000 0.459791
+ 5.6002778 0.458756
+ 5.6005556 0.444807
+ 5.6008333 0.420014
+ 5.6011111 0.386444
+ 5.6013889 0.346166
+ 5.6016667 0.301248
+ 5.6019444 0.253760
+ 5.6022222 0.205769
+ 5.6025000 0.159344
+ 5.6027778 0.116554
+ 5.6030556 0.079182
+ 5.6033333 0.050000
+ 5.6036111 0.050000
+ 5.6038889 0.050000
+ 5.6041667 0.050000
+ 5.6044444 0.050000
+ 5.6047222 0.050000
+ 5.6050000 0.050000
+ 5.6052778 0.050000
+ 5.6055556 0.058274
+ 5.6058333 0.097066
+ 5.6061111 0.142679
+ 5.6063889 0.192668
+ 5.6066667 0.244589
+ 5.6069444 0.295995
+ 5.6072222 0.344441
+ 5.6075000 0.387482
+ 5.6077778 0.422674
+ 5.6080556 0.447570
+ 5.6083333 0.459725
+ 5.6086111 0.457459
+ 5.6088889 0.442145
+ 5.6091667 0.415922
+ 5.6094444 0.380928
+ 5.6097222 0.339301
+ 5.6100000 0.293179
+ 5.6102778 0.244701
+ 5.6105556 0.196005
+ 5.6108333 0.149229
+ 5.6111111 0.106512
+ 5.6113889 0.069680
+ 5.6116667 0.050000
+ 5.6119444 0.050000
+ 5.6122222 0.050000
+ 5.6125000 0.050000
+ 5.6127778 0.050000
+ 5.6130556 0.050000
+ 5.6133333 0.050000
+ 5.6136111 0.050000
+ 5.6138889 0.061648
+ 5.6141667 0.101203
+ 5.6144444 0.147248
+ 5.6147222 0.197369
+ 5.6150000 0.249155
+ 5.6152778 0.300196
+ 5.6155556 0.348078
+ 5.6158333 0.390392
+ 5.6161111 0.424725
+ 5.6163889 0.448666
+ 5.6166667 0.459804
+ 5.6169444 0.456490
+ 5.6172222 0.440129
+ 5.6175000 0.412891
+ 5.6177778 0.376943
+ 5.6180556 0.334456
+ 5.6183333 0.287596
+ 5.6186111 0.238534
+ 5.6188889 0.189438
+ 5.6191667 0.142476
+ 5.6194444 0.099817
+ 5.6197222 0.063305
+ 5.6200000 0.050000
+ 5.6202778 0.050000
+ 5.6205556 0.050000
+ 5.6208333 0.050000
+ 5.6211111 0.050000
+ 5.6213889 0.050000
+ 5.6216667 0.050000
+ 5.6219444 0.050000
+ 5.6222222 0.061595
+ 5.6225000 0.101264
+ 5.6227778 0.147222
+ 5.6230556 0.197122
+ 5.6233333 0.248619
+ 5.6236111 0.299368
+ 5.6238889 0.347024
+ 5.6241667 0.389241
+ 5.6244444 0.423674
+ 5.6247222 0.447976
+ 5.6250000 0.459804
+ 5.6252778 0.457548
+ 5.6255556 0.442550
+ 5.6258333 0.416887
+ 5.6261111 0.382638
+ 5.6263889 0.341881
+ 5.6266667 0.296693
+ 5.6269444 0.249154
+ 5.6272222 0.201341
+ 5.6275000 0.155333
+ 5.6277778 0.113207
+ 5.6280556 0.076744
+ 5.6283333 0.050000
+ 5.6286111 0.050000
+ 5.6288889 0.050000
+ 5.6291667 0.050000
+ 5.6294444 0.050000
+ 5.6297222 0.050000
+ 5.6300000 0.050000
+ 5.6302778 0.050000
+ 5.6305556 0.064943
+ 5.6308333 0.103688
+ 5.6311111 0.148934
+ 5.6313889 0.198305
+ 5.6316667 0.249424
+ 5.6319444 0.299914
+ 5.6322222 0.347399
+ 5.6325000 0.389502
+ 5.6327778 0.423846
+ 5.6330556 0.448055
+ 5.6333333 0.459752
+ 5.6336111 0.457303
+ 5.6338889 0.442055
+ 5.6341667 0.416094
+ 5.6344444 0.381510
+ 5.6347222 0.340390
+ 5.6350000 0.294824
+ 5.6352778 0.246899
+ 5.6355556 0.198705
+ 5.6358333 0.152328
+ 5.6361111 0.109859
+ 5.6363889 0.073088
+ 5.6366667 0.050000
+ 5.6369444 0.050000
+ 5.6372222 0.050000
+ 5.6375000 0.050000
+ 5.6377778 0.050000
+ 5.6380556 0.050000
+ 5.6383333 0.050000
+ 5.6386111 0.050000
+ 5.6388889 0.061661
+ 5.6391667 0.100963
+ 5.6394444 0.146849
+ 5.6397222 0.196891
+ 5.6400000 0.248665
+ 5.6402778 0.299744
+ 5.6405556 0.347701
+ 5.6408333 0.390112
+ 5.6411111 0.424550
+ 5.6413889 0.448589
+ 5.6416667 0.459804
+ 5.6419444 0.456531
+ 5.6422222 0.440163
+ 5.6425000 0.412856
+ 5.6427778 0.376764
+ 5.6430556 0.334044
+ 5.6433333 0.286852
+ 5.6436111 0.237343
+ 5.6438889 0.187672
+ 5.6441667 0.139996
+ 5.6444444 0.096469
+ 5.6447222 0.058935
+ 5.6450000 0.050000
+ 5.6452778 0.050000
+ 5.6455556 0.050000
+ 5.6458333 0.050000
+ 5.6461111 0.050000
+ 5.6463889 0.050000
+ 5.6466667 0.050000
+ 5.6469444 0.050000
+ 5.6472222 0.050000
+ 5.6475000 0.090115
+ 5.6477778 0.136858
+ 5.6480556 0.187814
+ 5.6483333 0.240570
+ 5.6486111 0.292712
+ 5.6488889 0.341828
+ 5.6491667 0.385503
+ 5.6494444 0.421324
+ 5.6497222 0.446878
+ 5.6500000 0.459752
+ 5.6502778 0.458280
+ 5.6505556 0.443800
+ 5.6508333 0.418396
+ 5.6511111 0.384153
+ 5.6513889 0.343157
+ 5.6516667 0.297492
+ 5.6519444 0.249245
+ 5.6522222 0.200501
+ 5.6525000 0.153344
+ 5.6527778 0.109859
+ 5.6530556 0.071848
+ 5.6533333 0.050000
+ 5.6536111 0.050000
+ 5.6538889 0.050000
+ 5.6541667 0.050000
+ 5.6544444 0.050000
+ 5.6547222 0.050000
+ 5.6550000 0.050000
+ 5.6552778 0.050000
+ 5.6555556 0.050000
+ 5.6558333 0.089473
+ 5.6561111 0.135920
+ 5.6563889 0.186851
+ 5.6566667 0.239775
+ 5.6569444 0.292202
+ 5.6572222 0.341643
+ 5.6575000 0.385607
+ 5.6577778 0.421605
+ 5.6580556 0.447145
+ 5.6583333 0.459738
+ 5.6586111 0.457672
+ 5.6588889 0.442344
+ 5.6591667 0.415926
+ 5.6594444 0.380595
+ 5.6597222 0.338523
+ 5.6600000 0.291886
+ 5.6602778 0.242857
+ 5.6605556 0.193611
+ 5.6608333 0.146322
+ 5.6611111 0.103164
+ 5.6613889 0.065993
+ 5.6616667 0.050000
+ 5.6619444 0.050000
+ 5.6622222 0.050000
+ 5.6625000 0.050000
+ 5.6627778 0.050000
+ 5.6630556 0.050000
+ 5.6633333 0.050000
+ 5.6636111 0.050000
+ 5.6638889 0.058287
+ 5.6641667 0.098087
+ 5.6644444 0.144393
+ 5.6647222 0.194794
+ 5.6650000 0.246879
+ 5.6652778 0.298237
+ 5.6655556 0.346458
+ 5.6658333 0.389131
+ 5.6661111 0.423845
+ 5.6663889 0.448188
+ 5.6666667 0.459752
+ 5.6669444 0.456881
+ 5.6672222 0.440954
+ 5.6675000 0.414108
+ 5.6677778 0.378477
+ 5.6680556 0.336197
+ 5.6683333 0.289404
+ 5.6686111 0.240234
+ 5.6688889 0.190822
+ 5.6691667 0.143305
+ 5.6694444 0.099817
+ 5.6697222 0.062188
+ 5.6700000 0.050000
+ 5.6702778 0.050000
+ 5.6705556 0.050000
+ 5.6708333 0.050000
+ 5.6711111 0.050000
+ 5.6713889 0.050000
+ 5.6716667 0.050000
+ 5.6719444 0.050000
+ 5.6722222 0.050000
+ 5.6725000 0.089913
+ 5.6727778 0.136536
+ 5.6730556 0.187440
+ 5.6733333 0.240200
+ 5.6736111 0.292386
+ 5.6738889 0.341573
+ 5.6741667 0.385333
+ 5.6744444 0.421239
+ 5.6747222 0.446863
+ 5.6750000 0.459778
+ 5.6752778 0.458310
+ 5.6755556 0.443803
+ 5.6758333 0.418352
+ 5.6761111 0.384054
+ 5.6763889 0.343004
+ 5.6766667 0.297300
+ 5.6769444 0.249037
+ 5.6772222 0.200312
+ 5.6775000 0.153221
+ 5.6777778 0.109859
+ 5.6780556 0.072034
+ 5.6783333 0.050000
+ 5.6786111 0.050000
+ 5.6788889 0.050000
+ 5.6791667 0.050000
+ 5.6794444 0.050000
+ 5.6797222 0.050000
+ 5.6800000 0.050000
+ 5.6802778 0.050000
+ 5.6805556 0.051605
+ 5.6808333 0.090848
+ 5.6811111 0.136972
+ 5.6813889 0.187527
+ 5.6816667 0.240064
+ 5.6819444 0.292133
+ 5.6822222 0.341286
+ 5.6825000 0.385072
+ 5.6827778 0.421042
+ 5.6830556 0.446748
+ 5.6833333 0.459738
+ 5.6836111 0.458327
+ 5.6838889 0.443872
+ 5.6841667 0.418496
+ 5.6844444 0.384318
+ 5.6847222 0.343461
+ 5.6850000 0.298044
+ 5.6852778 0.250189
+ 5.6855556 0.202018
+ 5.6858333 0.155650
+ 5.6861111 0.113207
+ 5.6863889 0.076504
+ 5.6866667 0.050000
+ 5.6869444 0.050000
+ 5.6872222 0.050000
+ 5.6875000 0.050000
+ 5.6877778 0.050000
+ 5.6880556 0.050000
+ 5.6883333 0.050000
+ 5.6886111 0.050000
+ 5.6888889 0.065008
+ 5.6891667 0.103908
+ 5.6894444 0.149302
+ 5.6897222 0.198802
+ 5.6900000 0.250022
+ 5.6902778 0.300576
+ 5.6905556 0.348076
+ 5.6908333 0.390135
+ 5.6911111 0.424368
+ 5.6913889 0.448386
+ 5.6916667 0.459804
+ 5.6919444 0.456985
+ 5.6922222 0.441295
+ 5.6925000 0.414853
+ 5.6927778 0.379774
+ 5.6930556 0.338177
+ 5.6933333 0.292178
+ 5.6936111 0.243895
+ 5.6938889 0.195445
+ 5.6941667 0.148945
+ 5.6944444 0.106512
+ 5.6947222 0.069953
+ 5.6950000 0.050000
+ 5.6952778 0.050000
+ 5.6955556 0.050000
+ 5.6958333 0.050000
+ 5.6961111 0.050000
+ 5.6963889 0.050000
+ 5.6966667 0.050000
+ 5.6969444 0.050000
+ 5.6972222 0.061608
+ 5.6975000 0.100589
+ 5.6977778 0.145987
+ 5.6980556 0.195465
+ 5.6983333 0.246687
+ 5.6986111 0.297317
+ 5.6988889 0.345019
+ 5.6991667 0.387456
+ 5.6994444 0.422292
+ 5.6997222 0.447191
+ 5.7000000 0.459817
+ 5.7002778 0.458556
+ 5.7005556 0.444686
+ 5.7008333 0.420208
+ 5.7011111 0.387122
+ 5.7013889 0.347430
+ 5.7016667 0.303133
+ 5.7019444 0.256230
+ 5.7022222 0.208724
+ 5.7025000 0.162614
+ 5.7027778 0.119902
+ 5.7030556 0.082323
+ 5.7033333 0.050555
+ 5.7036111 0.050000
+ 5.7038889 0.050000
+ 5.7041667 0.050000
+ 5.7044444 0.050000
+ 5.7047222 0.050000
+ 5.7050000 0.050000
+ 5.7052778 0.050000
+ 5.7055556 0.054953
+ 5.7058333 0.093513
+ 5.7061111 0.139109
+ 5.7063889 0.189262
+ 5.7066667 0.241494
+ 5.7069444 0.293326
+ 5.7072222 0.342281
+ 5.7075000 0.385879
+ 5.7077778 0.421643
+ 5.7080556 0.447093
+ 5.7083333 0.459752
+ 5.7086111 0.457913
+ 5.7088889 0.442959
+ 5.7091667 0.417046
+ 5.7094444 0.382330
+ 5.7097222 0.340965
+ 5.7100000 0.295108
+ 5.7102778 0.246913
+ 5.7105556 0.198537
+ 5.7108333 0.152133
+ 5.7111111 0.109859
+ 5.7113889 0.073550
+ 5.7116667 0.050000
+ 5.7119444 0.050000
+ 5.7122222 0.050000
+ 5.7125000 0.050000
+ 5.7127778 0.050000
+ 5.7130556 0.050000
+ 5.7133333 0.050000
+ 5.7136111 0.050000
+ 5.7138889 0.068356
+ 5.7141667 0.107391
+ 5.7144444 0.152713
+ 5.7147222 0.201974
+ 5.7150000 0.252825
+ 5.7152778 0.302918
+ 5.7155556 0.349905
+ 5.7158333 0.391436
+ 5.7161111 0.425164
+ 5.7163889 0.448741
+ 5.7166667 0.459817
+ 5.7169444 0.456791
+ 5.7172222 0.441049
+ 5.7175000 0.414723
+ 5.7177778 0.379946
+ 5.7180556 0.338849
+ 5.7183333 0.293565
+ 5.7186111 0.246226
+ 5.7188889 0.198966
+ 5.7191667 0.153915
+ 5.7194444 0.113207
+ 5.7197222 0.078645
+ 5.7200000 0.050715
+ 5.7202778 0.050000
+ 5.7205556 0.050000
+ 5.7208333 0.050000
+ 5.7211111 0.050000
+ 5.7213889 0.050000
+ 5.7216667 0.050000
+ 5.7219444 0.054233
+ 5.7222222 0.085067
+ 5.7225000 0.123556
+ 5.7227778 0.167845
+ 5.7230556 0.215674
+ 5.7233333 0.264787
+ 5.7236111 0.312924
+ 5.7238889 0.357827
+ 5.7241667 0.397238
+ 5.7244444 0.428898
+ 5.7247222 0.450550
+ 5.7250000 0.459935
+ 5.7252778 0.455525
+ 5.7255556 0.438717
+ 5.7258333 0.411638
+ 5.7261111 0.376417
+ 5.7263889 0.335179
+ 5.7266667 0.290052
+ 5.7269444 0.243164
+ 5.7272222 0.196643
+ 5.7275000 0.152614
+ 5.7277778 0.113207
+ 5.7280556 0.080205
+ 5.7283333 0.054021
+ 5.7286111 0.050000
+ 5.7288889 0.050000
+ 5.7291667 0.050000
+ 5.7294444 0.050000
+ 5.7297222 0.050000
+ 5.7300000 0.050000
+ 5.7302778 0.067570
+ 5.7305556 0.098470
+ 5.7308333 0.136453
+ 5.7311111 0.179744
+ 5.7313889 0.226200
+ 5.7316667 0.273677
+ 5.7319444 0.320031
+ 5.7322222 0.363118
+ 5.7325000 0.400794
+ 5.7327778 0.430916
+ 5.7330556 0.451340
+ 5.7333333 0.459922
+ 5.7336111 0.455221
+ 5.7338889 0.438614
+ 5.7341667 0.412178
+ 5.7344444 0.377994
+ 5.7347222 0.338141
+ 5.7350000 0.294697
+ 5.7352778 0.249741
+ 5.7355556 0.205354
+ 5.7358333 0.163612
+ 5.7361111 0.126597
+ 5.7363889 0.096038
+ 5.7366667 0.072272
+ 5.7369444 0.055289
+ 5.7372222 0.050000
+ 5.7375000 0.050000
+ 5.7377778 0.050000
+ 5.7380556 0.054951
+ 5.7383333 0.071708
+ 5.7386111 0.095180
+ 5.7388889 0.125355
+ 5.7391667 0.161888
+ 5.7394444 0.203101
+ 5.7397222 0.246985
+ 5.7400000 0.291529
+ 5.7402778 0.334722
+ 5.7405556 0.374554
+ 5.7408333 0.409013
+ 5.7411111 0.436090
+ 5.7413889 0.453773
+ 5.7416667 0.460052
+ 5.7419444 0.453590
+ 5.7422222 0.435743
+ 5.7425000 0.408540
+ 5.7427778 0.374010
+ 5.7430556 0.334182
+ 5.7433333 0.291085
+ 5.7436111 0.246749
+ 5.7438889 0.203203
+ 5.7441667 0.162476
+ 5.7444444 0.126597
+ 5.7447222 0.097246
+ 5.7450000 0.074709
+ 5.7452778 0.058922
+ 5.7455556 0.050000
+ 5.7458333 0.050000
+ 5.7461111 0.051419
+ 5.7463889 0.061992
+ 5.7466667 0.078995
+ 5.7469444 0.102364
+ 5.7472222 0.132037
+ 5.7475000 0.167646
+ 5.7477778 0.207624
+ 5.7480556 0.250097
+ 5.7483333 0.293194
+ 5.7486111 0.335045
+ 5.7488889 0.373777
+ 5.7491667 0.407519
+ 5.7494444 0.434400
+ 5.7497222 0.452548
+ 5.7500000 0.460092
+ 5.7502778 0.455772
+ 5.7505556 0.440783
+ 5.7508333 0.416928
+ 5.7511111 0.386014
+ 5.7513889 0.349846
+ 5.7516667 0.310228
+ 5.7519444 0.268967
+ 5.7522222 0.227868
+ 5.7525000 0.188736
+ 5.7527778 0.153377
+ 5.7530556 0.123320
+ 5.7533333 0.098991
+ 5.7536111 0.080543
+ 5.7538889 0.068126
+ 5.7541667 0.061890
+ 5.7544444 0.061988
+ 5.7547222 0.068569
+ 5.7550000 0.081786
+ 5.7552778 0.101789
+ 5.7555556 0.128728
+ 5.7558333 0.162403
+ 5.7561111 0.201200
+ 5.7563889 0.243152
+ 5.7566667 0.286294
+ 5.7569444 0.328659
+ 5.7572222 0.368281
+ 5.7575000 0.403193
+ 5.7577778 0.431430
+ 5.7580556 0.451026
+ 5.7583333 0.460013
+ 5.7586111 0.457053
+ 5.7588889 0.443309
+ 5.7591667 0.420573
+ 5.7594444 0.390635
+ 5.7597222 0.355287
+ 5.7600000 0.316320
+ 5.7602778 0.275523
+ 5.7605556 0.234689
+ 5.7608333 0.195609
+ 5.7611111 0.160072
+ 5.7613889 0.129605
+ 5.7616667 0.104676
+ 5.7619444 0.085484
+ 5.7622222 0.072233
+ 5.7625000 0.065124
+ 5.7627778 0.064359
+ 5.7630556 0.070138
+ 5.7633333 0.082665
+ 5.7636111 0.102141
+ 5.7638889 0.128768
+ 5.7641667 0.162374
+ 5.7644444 0.201298
+ 5.7647222 0.243505
+ 5.7650000 0.286963
+ 5.7652778 0.329635
+ 5.7655556 0.369488
+ 5.7658333 0.404488
+ 5.7661111 0.432601
+ 5.7663889 0.451792
+ 5.7666667 0.460026
+ 5.7669444 0.455925
+ 5.7672222 0.440725
+ 5.7675000 0.416320
+ 5.7677778 0.384602
+ 5.7680556 0.347462
+ 5.7683333 0.306794
+ 5.7686111 0.264490
+ 5.7688889 0.222441
+ 5.7691667 0.182541
+ 5.7694444 0.146682
+ 5.7697222 0.116458
+ 5.7700000 0.092272
+ 5.7702778 0.074228
+ 5.7705556 0.062432
+ 5.7708333 0.056989
+ 5.7711111 0.058003
+ 5.7713889 0.065579
+ 5.7716667 0.079822
+ 5.7719444 0.100837
+ 5.7722222 0.128728
+ 5.7725000 0.163253
+ 5.7727778 0.202770
+ 5.7730556 0.245293
+ 5.7733333 0.288832
+ 5.7736111 0.331400
+ 5.7738889 0.371008
+ 5.7741667 0.405668
+ 5.7744444 0.433392
+ 5.7747222 0.452192
+ 5.7750000 0.460078
+ 5.7752778 0.455700
+ 5.7755556 0.440243
+ 5.7758333 0.415533
+ 5.7761111 0.383393
+ 5.7763889 0.345647
+ 5.7766667 0.304117
+ 5.7769444 0.260628
+ 5.7772222 0.217003
+ 5.7775000 0.175065
+ 5.7777778 0.136639
+ 5.7780556 0.103294
+ 5.7783333 0.075578
+ 5.7786111 0.053786
+ 5.7788889 0.050000
+ 5.7791667 0.050000
+ 5.7794444 0.050000
+ 5.7797222 0.050000
+ 5.7800000 0.050000
+ 5.7802778 0.063949
+ 5.7805556 0.091880
+ 5.7808333 0.127676
+ 5.7811111 0.169557
+ 5.7813889 0.215324
+ 5.7816667 0.262780
+ 5.7819444 0.309725
+ 5.7822222 0.353963
+ 5.7825000 0.393296
+ 5.7827778 0.425525
+ 5.7830556 0.448453
+ 5.7833333 0.459882
+ 5.7836111 0.458293
+ 5.7838889 0.444879
+ 5.7841667 0.421514
+ 5.7844444 0.390070
+ 5.7847222 0.352421
+ 5.7850000 0.310439
+ 5.7852778 0.265997
+ 5.7855556 0.220968
+ 5.7858333 0.177224
+ 5.7861111 0.136639
+ 5.7863889 0.100841
+ 5.7866667 0.070479
+ 5.7869444 0.050000
+ 5.7872222 0.050000
+ 5.7875000 0.050000
+ 5.7877778 0.050000
+ 5.7880556 0.050000
+ 5.7883333 0.050000
+ 5.7886111 0.050000
+ 5.7888889 0.071795
+ 5.7891667 0.108097
+ 5.7894444 0.151151
+ 5.7897222 0.198634
+ 5.7900000 0.248221
+ 5.7902778 0.297588
+ 5.7905556 0.344414
+ 5.7908333 0.386373
+ 5.7911111 0.421142
+ 5.7913889 0.446398
+ 5.7916667 0.459817
+ 5.7919444 0.459777
+ 5.7922222 0.447462
+ 5.7925000 0.424757
+ 5.7927778 0.393549
+ 5.7930556 0.355721
+ 5.7933333 0.313160
+ 5.7936111 0.267751
+ 5.7938889 0.221380
+ 5.7941667 0.175932
+ 5.7944444 0.133292
+ 5.7947222 0.095120
+ 5.7950000 0.062170
+ 5.7952778 0.050000
+ 5.7955556 0.050000
+ 5.7958333 0.050000
+ 5.7961111 0.050000
+ 5.7963889 0.050000
+ 5.7966667 0.050000
+ 5.7969444 0.050000
+ 5.7972222 0.050000
+ 5.7975000 0.087331
+ 5.7977778 0.132140
+ 5.7980556 0.181926
+ 5.7983333 0.234190
+ 5.7986111 0.286431
+ 5.7988889 0.336146
+ 5.7991667 0.380837
+ 5.7994444 0.418002
+ 5.7997222 0.445140
+ 5.8000000 0.459752
+ 5.8002778 0.460095
+ 5.8005556 0.447468
+ 5.8008333 0.423932
+ 5.8011111 0.391543
+ 5.8013889 0.352360
+ 5.8016667 0.308443
+ 5.8019444 0.261849
+ 5.8022222 0.214638
+ 5.8025000 0.168868
+ 5.8027778 0.126597
+ 5.8030556 0.089600
+ 5.8033333 0.058515
+ 5.8036111 0.050000
+ 5.8038889 0.050000
+ 5.8041667 0.050000
+ 5.8044444 0.050000
+ 5.8047222 0.050000
+ 5.8050000 0.050000
+ 5.8052778 0.050000
+ 5.8055556 0.065034
+ 5.8058333 0.102595
+ 5.8061111 0.146883
+ 5.8063889 0.195535
+ 5.8066667 0.246186
+ 5.8069444 0.296475
+ 5.8072222 0.344036
+ 5.8075000 0.386506
+ 5.8077778 0.421522
+ 5.8080556 0.446721
+ 5.8083333 0.459738
+ 5.8086111 0.458938
+ 5.8088889 0.445589
+ 5.8091667 0.421687
+ 5.8094444 0.389230
+ 5.8097222 0.350212
+ 5.8100000 0.306632
+ 5.8102778 0.260483
+ 5.8105556 0.213764
+ 5.8108333 0.168470
+ 5.8111111 0.126597
+ 5.8113889 0.089872
+ 5.8116667 0.058939
+ 5.8119444 0.050000
+ 5.8122222 0.050000
+ 5.8125000 0.050000
+ 5.8127778 0.050000
+ 5.8130556 0.050000
+ 5.8133333 0.050000
+ 5.8136111 0.050000
+ 5.8138889 0.065060
+ 5.8141667 0.102692
+ 5.8144444 0.147105
+ 5.8147222 0.195909
+ 5.8150000 0.246714
+ 5.8152778 0.297131
+ 5.8155556 0.344770
+ 5.8158333 0.387242
+ 5.8161111 0.422155
+ 5.8163889 0.447122
+ 5.8166667 0.459752
+ 5.8169444 0.458389
+ 5.8172222 0.444319
+ 5.8175000 0.419560
+ 5.8177778 0.386132
+ 5.8180556 0.346052
+ 5.8183333 0.301340
+ 5.8186111 0.254016
+ 5.8188889 0.206098
+ 5.8191667 0.159604
+ 5.8194444 0.116554
+ 5.8197222 0.078698
+ 5.8200000 0.050000
+ 5.8202778 0.050000
+ 5.8205556 0.050000
+ 5.8208333 0.050000
+ 5.8211111 0.050000
+ 5.8213889 0.050000
+ 5.8216667 0.050000
+ 5.8219444 0.050000
+ 5.8222222 0.050000
+ 5.8225000 0.088361
+ 5.8227778 0.133771
+ 5.8230556 0.183803
+ 5.8233333 0.236032
+ 5.8236111 0.288034
+ 5.8238889 0.337381
+ 5.8241667 0.381650
+ 5.8244444 0.418414
+ 5.8247222 0.445247
+ 5.8250000 0.459725
+ 5.8252778 0.460158
+ 5.8255556 0.447795
+ 5.8258333 0.424623
+ 5.8261111 0.392629
+ 5.8263889 0.353797
+ 5.8266667 0.310115
+ 5.8269444 0.263567
+ 5.8272222 0.216141
+ 5.8275000 0.169822
+ 5.8277778 0.126597
+ 5.8280556 0.088199
+ 5.8283333 0.055359
+ 5.8286111 0.050000
+ 5.8288889 0.050000
+ 5.8291667 0.050000
+ 5.8294444 0.050000
+ 5.8297222 0.050000
+ 5.8300000 0.050000
+ 5.8302778 0.050000
+ 5.8305556 0.050000
+ 5.8308333 0.088166
+ 5.8311111 0.133670
+ 5.8313889 0.183993
+ 5.8316667 0.236618
+ 5.8319444 0.289026
+ 5.8322222 0.338700
+ 5.8325000 0.383121
+ 5.8327778 0.419771
+ 5.8330556 0.446132
+ 5.8333333 0.459686
+ 5.8336111 0.458689
+ 5.8338889 0.444486
+ 5.8341667 0.419198
+ 5.8344444 0.384944
+ 5.8347222 0.343845
+ 5.8350000 0.298020
+ 5.8352778 0.249589
+ 5.8355556 0.200672
+ 5.8358333 0.153389
+ 5.8361111 0.109859
+ 5.8363889 0.071907
+ 5.8366667 0.050000
+ 5.8369444 0.050000
+ 5.8372222 0.050000
+ 5.8375000 0.050000
+ 5.8377778 0.050000
+ 5.8380556 0.050000
+ 5.8383333 0.050000
+ 5.8386111 0.050000
+ 5.8388889 0.051631
+ 5.8391667 0.090943
+ 5.8394444 0.137130
+ 5.8397222 0.187737
+ 5.8400000 0.240313
+ 5.8402778 0.292403
+ 5.8405556 0.341554
+ 5.8408333 0.385314
+ 5.8411111 0.421229
+ 5.8413889 0.446846
+ 5.8416667 0.459712
+ 5.8419444 0.458133
+ 5.8422222 0.443451
+ 5.8425000 0.417769
+ 5.8427778 0.383187
+ 5.8430556 0.341808
+ 5.8433333 0.295733
+ 5.8436111 0.247064
+ 5.8438889 0.197903
+ 5.8441667 0.150352
+ 5.8444444 0.106512
+ 5.8447222 0.068200
+ 5.8450000 0.050000
+ 5.8452778 0.050000
+ 5.8455556 0.050000
+ 5.8458333 0.050000
+ 5.8461111 0.050000
+ 5.8463889 0.050000
+ 5.8466667 0.050000
+ 5.8469444 0.050000
+ 5.8472222 0.050000
+ 5.8475000 0.090982
+ 5.8477778 0.139055
+ 5.8480556 0.191560
+ 5.8483333 0.245835
+ 5.8486111 0.299219
+ 5.8488889 0.349051
+ 5.8491667 0.392669
+ 5.8494444 0.427413
+ 5.8497222 0.450622
+ 5.8500000 0.459634
+ 5.8502778 0.452655
+ 5.8505556 0.431356
+ 5.8508333 0.398275
+ 5.8511111 0.355950
+ 5.8513889 0.306919
+ 5.8516667 0.253720
+ 5.8519444 0.198891
+ 5.8522222 0.144969
+ 5.8525000 0.094493
+ 5.8527778 0.050000
+ 5.8530556 0.050000
+ 5.8533333 0.050000
+ 5.8536111 0.050000
+ 5.8538889 0.050000
+ 5.8541667 0.050000
+ 5.8544444 0.050000
+ 5.8547222 0.050000
+ 5.8550000 0.050000
+ 5.8552778 0.050000
+ 5.8555556 0.050000
+ 5.8558333 0.092034
+ 5.8561111 0.139346
+ 5.8563889 0.189866
+ 5.8566667 0.241522
+ 5.8569444 0.292243
+ 5.8572222 0.339958
+ 5.8575000 0.382594
+ 5.8577778 0.418081
+ 5.8580556 0.444346
+ 5.8583333 0.459320
+ 5.8586111 0.461558
+ 5.8588889 0.452127
+ 5.8591667 0.432724
+ 5.8594444 0.405042
+ 5.8597222 0.370779
+ 5.8600000 0.331630
+ 5.8602778 0.289289
+ 5.8605556 0.245452
+ 5.8608333 0.201814
+ 5.8611111 0.160072
+ 5.8613889 0.121750
+ 5.8616667 0.087695
+ 5.8619444 0.058582
+ 5.8622222 0.050000
+ 5.8625000 0.050000
+ 5.8627778 0.050000
+ 5.8630556 0.050000
+ 5.8633333 0.050000
+ 5.8636111 0.050000
+ 5.8638889 0.050000
+ 5.8641667 0.084313
+ 5.8644444 0.126885
+ 5.8647222 0.175621
+ 5.8650000 0.228427
+ 5.8652778 0.283208
+ 5.8655556 0.337871
+ 5.8658333 0.390319
+ 5.8661111 0.438461
+ 5.8663889 0.480200
+ 5.8666667 0.513442
+ 5.8669444 0.536668
+ 5.8672222 0.550652
+ 5.8675000 0.556743
+ 5.8677778 0.556290
+ 5.8680556 0.550642
+ 5.8683333 0.541147
+ 5.8686111 0.529155
+ 5.8688889 0.516014
+ 5.8691667 0.503074
+ 5.8694444 0.491684
+ 5.8697222 0.482893
+ 5.8700000 0.476562
+ 5.8702778 0.472252
+ 5.8705556 0.469524
+ 5.8708333 0.467940
+ 5.8711111 0.467060
+ 5.8713889 0.466447
+ 5.8716667 0.465661
+ 5.8719444 0.464264
+ 5.8722222 0.461818
+ 5.8725000 0.458115
+ 5.8727778 0.453881
+ 5.8730556 0.450071
+ 5.8733333 0.447642
+ 5.8736111 0.447551
+ 5.8738889 0.450754
+ 5.8741667 0.458208
+ 5.8744444 0.470869
+ 5.8747222 0.489694
+ 5.8750000 0.515639
+ 5.8752778 0.549003
+ 5.8755556 0.587454
+ 5.8758333 0.628000
+ 5.8761111 0.667652
+ 5.8763889 0.703420
+ 5.8766667 0.732313
+ 5.8769444 0.751340
+ 5.8772222 0.757512
+ 5.8775000 0.747837
+ 5.8777778 0.719327
+ 5.8780556 0.670299
+ 5.8783333 0.604312
+ 5.8786111 0.526233
+ 5.8788889 0.440931
+ 5.8791667 0.353272
+ 5.8794444 0.268125
+ 5.8797222 0.190356
+ 5.8800000 0.124834
+ 5.8802778 0.076426
+ 5.8805556 0.050000
+ 5.8808333 0.050000
+ 5.8811111 0.069738
+ 5.8813889 0.108004
+ 5.8816667 0.158866
+ 5.8819444 0.217575
+ 5.8822222 0.279378
+ 5.8825000 0.339525
+ 5.8827778 0.393266
+ 5.8830556 0.435849
+ 5.8833333 0.462524
+ 5.8836111 0.469820
+ 5.8838889 0.459389
+ 5.8841667 0.434166
+ 5.8844444 0.397083
+ 5.8847222 0.351074
+ 5.8850000 0.299070
+ 5.8852778 0.244007
+ 5.8855556 0.188817
+ 5.8858333 0.136432
+ 5.8861111 0.089788
+ 5.8863889 0.051306
+ 5.8866667 0.050000
+ 5.8869444 0.050000
+ 5.8872222 0.050000
+ 5.8875000 0.050000
+ 5.8877778 0.050000
+ 5.8880556 0.050000
+ 5.8883333 0.050000
+ 5.8886111 0.050000
+ 5.8888889 0.075038
+ 5.8891667 0.116204
+ 5.8894444 0.162622
+ 5.8897222 0.212097
+ 5.8900000 0.262431
+ 5.8902778 0.311428
+ 5.8905556 0.356892
+ 5.8908333 0.396626
+ 5.8911111 0.428435
+ 5.8913889 0.450122
+ 5.8916667 0.459490
+ 5.8919444 0.455051
+ 5.8922222 0.438144
+ 5.8925000 0.410818
+ 5.8927778 0.375121
+ 5.8930556 0.333101
+ 5.8933333 0.286804
+ 5.8936111 0.238280
+ 5.8938889 0.189575
+ 5.8941667 0.142738
+ 5.8944444 0.099817
+ 5.8947222 0.062572
+ 5.8950000 0.050000
+ 5.8952778 0.050000
+ 5.8955556 0.050000
+ 5.8958333 0.050000
+ 5.8961111 0.050000
+ 5.8963889 0.050000
+ 5.8966667 0.050000
+ 5.8969444 0.050000
+ 5.8972222 0.050000
+ 5.8975000 0.090016
+ 5.8977778 0.136819
+ 5.8980556 0.187943
+ 5.8983333 0.240923
+ 5.8986111 0.293293
+ 5.8988889 0.342587
+ 5.8991667 0.386339
+ 5.8994444 0.422083
+ 5.8997222 0.447354
+ 5.9000000 0.459686
+ 5.9002778 0.457384
+ 5.9005556 0.441837
+ 5.9008333 0.415205
+ 5.9011111 0.379647
+ 5.9013889 0.337324
+ 5.9016667 0.290394
+ 5.9019444 0.241019
+ 5.9022222 0.191358
+ 5.9025000 0.143571
+ 5.9027778 0.099817
+ 5.9030556 0.061947
+ 5.9033333 0.050000
+ 5.9036111 0.050000
+ 5.9038889 0.050000
+ 5.9041667 0.050000
+ 5.9044444 0.050000
+ 5.9047222 0.050000
+ 5.9050000 0.050000
+ 5.9052778 0.050000
+ 5.9055556 0.050000
+ 5.9058333 0.090326
+ 5.9061111 0.137407
+ 5.9063889 0.188762
+ 5.9066667 0.241913
+ 5.9069444 0.294378
+ 5.9072222 0.343678
+ 5.9075000 0.387334
+ 5.9077778 0.422865
+ 5.9080556 0.447792
+ 5.9083333 0.459634
+ 5.9086111 0.456692
+ 5.9088889 0.440388
+ 5.9091667 0.412923
+ 5.9094444 0.376499
+ 5.9097222 0.333319
+ 5.9100000 0.285583
+ 5.9102778 0.235493
+ 5.9105556 0.185252
+ 5.9108333 0.137061
+ 5.9111111 0.093122
+ 5.9113889 0.055315
+ 5.9116667 0.050000
+ 5.9119444 0.050000
+ 5.9122222 0.050000
+ 5.9125000 0.050000
+ 5.9127778 0.050000
+ 5.9130556 0.050000
+ 5.9133333 0.050000
+ 5.9136111 0.050000
+ 5.9138889 0.050000
+ 5.9141667 0.091112
+ 5.9144444 0.138872
+ 5.9147222 0.190774
+ 5.9150000 0.244314
+ 5.9152778 0.296986
+ 5.9155556 0.346286
+ 5.9158333 0.389709
+ 5.9161111 0.424748
+ 5.9163889 0.448901
+ 5.9166667 0.459660
+ 5.9169444 0.455322
+ 5.9172222 0.437382
+ 5.9175000 0.408137
+ 5.9177778 0.369882
+ 5.9180556 0.324913
+ 5.9183333 0.275527
+ 5.9186111 0.224020
+ 5.9188889 0.172688
+ 5.9191667 0.123826
+ 5.9194444 0.079732
+ 5.9197222 0.050000
+ 5.9200000 0.050000
+ 5.9202778 0.050000
+ 5.9205556 0.050000
+ 5.9208333 0.050000
+ 5.9211111 0.050000
+ 5.9213889 0.050000
+ 5.9216667 0.050000
+ 5.9219444 0.050000
+ 5.9222222 0.050000
+ 5.9225000 0.091586
+ 5.9227778 0.139430
+ 5.9230556 0.191135
+ 5.9233333 0.244301
+ 5.9236111 0.296529
+ 5.9238889 0.345421
+ 5.9241667 0.388577
+ 5.9244444 0.423599
+ 5.9247222 0.448089
+ 5.9250000 0.459647
+ 5.9252778 0.456635
+ 5.9255556 0.440455
+ 5.9258333 0.413269
+ 5.9261111 0.377241
+ 5.9263889 0.334532
+ 5.9266667 0.287305
+ 5.9269444 0.237723
+ 5.9272222 0.187948
+ 5.9275000 0.140143
+ 5.9277778 0.096469
+ 5.9280556 0.058778
+ 5.9283333 0.050000
+ 5.9286111 0.050000
+ 5.9288889 0.050000
+ 5.9291667 0.050000
+ 5.9294444 0.050000
+ 5.9297222 0.050000
+ 5.9300000 0.050000
+ 5.9302778 0.050000
+ 5.9305556 0.050000
+ 5.9308333 0.090525
+ 5.9311111 0.137734
+ 5.9313889 0.189157
+ 5.9316667 0.242324
+ 5.9319444 0.294765
+ 5.9322222 0.344010
+ 5.9325000 0.387588
+ 5.9327778 0.423029
+ 5.9330556 0.447864
+ 5.9333333 0.459621
+ 5.9336111 0.456609
+ 5.9338889 0.440252
+ 5.9341667 0.412750
+ 5.9344444 0.376306
+ 5.9347222 0.333120
+ 5.9350000 0.285394
+ 5.9352778 0.235330
+ 5.9355556 0.185129
+ 5.9358333 0.136992
+ 5.9361111 0.093122
+ 5.9363889 0.055396
+ 5.9366667 0.050000
+ 5.9369444 0.050000
+ 5.9372222 0.050000
+ 5.9375000 0.050000
+ 5.9377778 0.050000
+ 5.9380556 0.050000
+ 5.9383333 0.050000
+ 5.9386111 0.050000
+ 5.9388889 0.050000
+ 5.9391667 0.090861
+ 5.9394444 0.138333
+ 5.9397222 0.189944
+ 5.9400000 0.243225
+ 5.9402778 0.295707
+ 5.9405556 0.344919
+ 5.9408333 0.388392
+ 5.9411111 0.423655
+ 5.9413889 0.448239
+ 5.9416667 0.459673
+ 5.9419444 0.456271
+ 5.9422222 0.439474
+ 5.9425000 0.411506
+ 5.9427778 0.374591
+ 5.9430556 0.330954
+ 5.9433333 0.282818
+ 5.9436111 0.232408
+ 5.9438889 0.181948
+ 5.9441667 0.133662
+ 5.9444444 0.089774
+ 5.9447222 0.052177
+ 5.9450000 0.050000
+ 5.9452778 0.050000
+ 5.9455556 0.050000
+ 5.9458333 0.050000
+ 5.9461111 0.050000
+ 5.9463889 0.050000
+ 5.9466667 0.050000
+ 5.9469444 0.050000
+ 5.9472222 0.050000
+ 5.9475000 0.090914
+ 5.9477778 0.138332
+ 5.9480556 0.189818
+ 5.9483333 0.242938
+ 5.9486111 0.295258
+ 5.9488889 0.344343
+ 5.9491667 0.387759
+ 5.9494444 0.423071
+ 5.9497222 0.447846
+ 5.9500000 0.459647
+ 5.9502778 0.456809
+ 5.9505556 0.440737
+ 5.9508333 0.413604
+ 5.9511111 0.377582
+ 5.9513889 0.334844
+ 5.9516667 0.287563
+ 5.9519444 0.237913
+ 5.9522222 0.188065
+ 5.9525000 0.140193
+ 5.9527778 0.096469
+ 5.9530556 0.058752
+ 5.9533333 0.050000
+ 5.9536111 0.050000
+ 5.9538889 0.050000
+ 5.9541667 0.050000
+ 5.9544444 0.050000
+ 5.9547222 0.050000
+ 5.9550000 0.050000
+ 5.9552778 0.050000
+ 5.9555556 0.050000
+ 5.9558333 0.090455
+ 5.9561111 0.137577
+ 5.9563889 0.188907
+ 5.9566667 0.241988
+ 5.9569444 0.294363
+ 5.9572222 0.343574
+ 5.9575000 0.387163
+ 5.9577778 0.422672
+ 5.9580556 0.447644
+ 5.9583333 0.459621
+ 5.9586111 0.456917
+ 5.9588889 0.440939
+ 5.9591667 0.413862
+ 5.9594444 0.377864
+ 5.9597222 0.335123
+ 5.9600000 0.287816
+ 5.9602778 0.238119
+ 5.9605556 0.188211
+ 5.9608333 0.140269
+ 5.9611111 0.096469
+ 5.9613889 0.058675
+ 5.9616667 0.050000
+ 5.9619444 0.050000
+ 5.9622222 0.050000
+ 5.9625000 0.050000
+ 5.9627778 0.050000
+ 5.9630556 0.050000
+ 5.9633333 0.050000
+ 5.9636111 0.050000
+ 5.9638889 0.050000
+ 5.9641667 0.090636
+ 5.9644444 0.137963
+ 5.9647222 0.189499
+ 5.9650000 0.242763
+ 5.9652778 0.295273
+ 5.9655556 0.344547
+ 5.9658333 0.388103
+ 5.9661111 0.423459
+ 5.9663889 0.448135
+ 5.9666667 0.459647
+ 5.9669444 0.456299
+ 5.9672222 0.439535
+ 5.9675000 0.411581
+ 5.9677778 0.374667
+ 5.9680556 0.331020
+ 5.9683333 0.282869
+ 5.9686111 0.232440
+ 5.9688889 0.181963
+ 5.9691667 0.133665
+ 5.9694444 0.089774
+ 5.9697222 0.052186
+ 5.9700000 0.050000
+ 5.9702778 0.050000
+ 5.9705556 0.050000
+ 5.9708333 0.050000
+ 5.9711111 0.050000
+ 5.9713889 0.050000
+ 5.9716667 0.050000
+ 5.9719444 0.050000
+ 5.9722222 0.050000
+ 5.9725000 0.090831
+ 5.9727778 0.138150
+ 5.9730556 0.189535
+ 5.9733333 0.242564
+ 5.9736111 0.294815
+ 5.9738889 0.343866
+ 5.9741667 0.387295
+ 5.9744444 0.422681
+ 5.9747222 0.447601
+ 5.9750000 0.459634
+ 5.9752778 0.457119
+ 5.9755556 0.441442
+ 5.9758333 0.414750
+ 5.9761111 0.379189
+ 5.9763889 0.336906
+ 5.9766667 0.290050
+ 5.9769444 0.240765
+ 5.9772222 0.191201
+ 5.9775000 0.143502
+ 5.9777778 0.099817
+ 5.9780556 0.061986
+ 5.9783333 0.050000
+ 5.9786111 0.050000
+ 5.9788889 0.050000
+ 5.9791667 0.050000
+ 5.9794444 0.050000
+ 5.9797222 0.050000
+ 5.9800000 0.050000
+ 5.9802778 0.050000
+ 5.9805556 0.050000
+ 5.9808333 0.090398
+ 5.9811111 0.137571
+ 5.9813889 0.189025
+ 5.9816667 0.242268
+ 5.9819444 0.294805
+ 5.9822222 0.344144
+ 5.9825000 0.387791
+ 5.9827778 0.423253
+ 5.9830556 0.448036
+ 5.9833333 0.459647
+ 5.9836111 0.456380
+ 5.9838889 0.439676
+ 5.9841667 0.411765
+ 5.9844444 0.374874
+ 5.9847222 0.331233
+ 5.9850000 0.283070
+ 5.9852778 0.232614
+ 5.9855556 0.182094
+ 5.9858333 0.133738
+ 5.9861111 0.089774
+ 5.9863889 0.052101
+ 5.9866667 0.050000
+ 5.9869444 0.050000
+ 5.9872222 0.050000
+ 5.9875000 0.050000
+ 5.9877778 0.050000
+ 5.9880556 0.050000
+ 5.9883333 0.050000
+ 5.9886111 0.050000
+ 5.9888889 0.050000
+ 5.9891667 0.091090
+ 5.9894444 0.138706
+ 5.9897222 0.190392
+ 5.9900000 0.243690
+ 5.9902778 0.296142
+ 5.9905556 0.345290
+ 5.9908333 0.388678
+ 5.9911111 0.423847
+ 5.9913889 0.448340
+ 5.9916667 0.459699
+ 5.9919444 0.456247
+ 5.9922222 0.439423
+ 5.9925000 0.411446
+ 5.9927778 0.374536
+ 5.9930556 0.330913
+ 5.9933333 0.282796
+ 5.9936111 0.232404
+ 5.9938889 0.181957
+ 5.9941667 0.133674
+ 5.9944444 0.089774
+ 5.9947222 0.052148
+ 5.9950000 0.050000
+ 5.9952778 0.050000
+ 5.9955556 0.050000
+ 5.9958333 0.050000
+ 5.9961111 0.050000
+ 5.9963889 0.050000
+ 5.9966667 0.050000
+ 5.9969444 0.050000
+ 5.9972222 0.050000
+ 5.9975000 0.091072
+ 5.9977778 0.138675
+ 5.9980556 0.190350
+ 5.9983333 0.243641
+ 5.9986111 0.296088
+ 5.9988889 0.345235
+ 5.9991667 0.388623
+ 5.9994444 0.423795
+ 5.9997222 0.448293
+ 6.0000000 0.459660
+ 6.0002778 0.456217
+ 6.0005556 0.439403
+ 6.0008333 0.411436
+ 6.0011111 0.374537
+ 6.0013889 0.330922
+ 6.0016667 0.282811
+ 6.0019444 0.232422
+ 6.0022222 0.181974
+ 6.0025000 0.133685
+ 6.0027778 0.089774
+ 6.0030556 0.052131
+ 6.0033333 0.050000
+ 6.0036111 0.050000
+ 6.0038889 0.050000
+ 6.0041667 0.050000
+ 6.0044444 0.050000
+ 6.0047222 0.050000
+ 6.0050000 0.050000
+ 6.0052778 0.050000
+ 6.0055556 0.050000
+ 6.0058333 0.091142
+ 6.0061111 0.138826
+ 6.0063889 0.190584
+ 6.0066667 0.243947
+ 6.0069444 0.296448
+ 6.0072222 0.345618
+ 6.0075000 0.388990
+ 6.0077778 0.424095
+ 6.0080556 0.448466
+ 6.0083333 0.459634
+ 6.0086111 0.455916
+ 6.0088889 0.438764
+ 6.0091667 0.410417
+ 6.0094444 0.373111
+ 6.0097222 0.329083
+ 6.0100000 0.280571
+ 6.0102778 0.229812
+ 6.0105556 0.179044
+ 6.0108333 0.130503
+ 6.0111111 0.086427
+ 6.0113889 0.050000
+ 6.0116667 0.050000
+ 6.0119444 0.050000
+ 6.0122222 0.050000
+ 6.0125000 0.050000
+ 6.0127778 0.050000
+ 6.0130556 0.050000
+ 6.0133333 0.050000
+ 6.0136111 0.050000
+ 6.0138889 0.050000
+ 6.0141667 0.091870
+ 6.0144444 0.140281
+ 6.0147222 0.192705
+ 6.0150000 0.246614
+ 6.0152778 0.299481
+ 6.0155556 0.348777
+ 6.0158333 0.391975
+ 6.0161111 0.426546
+ 6.0163889 0.449964
+ 6.0166667 0.459699
+ 6.0169444 0.454043
+ 6.0172222 0.434556
+ 6.0175000 0.403620
+ 6.0177778 0.363612
+ 6.0180556 0.316913
+ 6.0183333 0.265903
+ 6.0186111 0.212961
+ 6.0188889 0.160467
+ 6.0191667 0.110801
+ 6.0194444 0.066342
+ 6.0197222 0.050000
+ 6.0200000 0.050000
+ 6.0202778 0.050000
+ 6.0205556 0.050000
+ 6.0208333 0.050000
+ 6.0211111 0.050000
+ 6.0213889 0.050000
+ 6.0216667 0.050000
+ 6.0219444 0.050000
+ 6.0222222 0.050000
+ 6.0225000 0.093121
+ 6.0227778 0.142281
+ 6.0230556 0.195035
+ 6.0233333 0.248940
+ 6.0236111 0.301551
+ 6.0238889 0.350425
+ 6.0241667 0.393117
+ 6.0244444 0.427183
+ 6.0247222 0.450178
+ 6.0250000 0.459660
+ 6.0252778 0.453980
+ 6.0255556 0.434674
+ 6.0258333 0.404076
+ 6.0261111 0.364519
+ 6.0263889 0.318337
+ 6.0266667 0.267861
+ 6.0269444 0.215425
+ 6.0272222 0.163363
+ 6.0275000 0.114006
+ 6.0277778 0.069689
+ 6.0280556 0.050000
+ 6.0283333 0.050000
+ 6.0286111 0.050000
+ 6.0288889 0.050000
+ 6.0291667 0.050000
+ 6.0294444 0.050000
+ 6.0297222 0.050000
+ 6.0300000 0.050000
+ 6.0302778 0.050000
+ 6.0305556 0.050000
+ 6.0308333 0.093196
+ 6.0311111 0.142574
+ 6.0313889 0.195629
+ 6.0316667 0.249858
+ 6.0319444 0.302756
+ 6.0322222 0.351820
+ 6.0325000 0.394545
+ 6.0327778 0.428427
+ 6.0330556 0.450962
+ 6.0333333 0.459647
+ 6.0336111 0.452799
+ 6.0338889 0.432027
+ 6.0341667 0.399762
+ 6.0344444 0.358435
+ 6.0347222 0.310476
+ 6.0350000 0.258318
+ 6.0352778 0.204390
+ 6.0355556 0.151124
+ 6.0358333 0.100950
+ 6.0361111 0.056299
+ 6.0363889 0.050000
+ 6.0366667 0.050000
+ 6.0369444 0.050000
+ 6.0372222 0.050000
+ 6.0375000 0.050000
+ 6.0377778 0.050000
+ 6.0380556 0.050000
+ 6.0383333 0.050000
+ 6.0386111 0.050000
+ 6.0388889 0.050000
+ 6.0391667 0.094261
+ 6.0394444 0.144403
+ 6.0397222 0.197947
+ 6.0400000 0.252413
+ 6.0402778 0.305321
+ 6.0405556 0.354193
+ 6.0408333 0.396548
+ 6.0411111 0.429908
+ 6.0413889 0.451794
+ 6.0416667 0.459725
+ 6.0419444 0.452047
+ 6.0422222 0.430400
+ 6.0425000 0.397247
+ 6.0427778 0.355052
+ 6.0430556 0.306281
+ 6.0433333 0.253395
+ 6.0436111 0.198861
+ 6.0438889 0.145140
+ 6.0441667 0.094699
+ 6.0444444 0.050000
+ 6.0447222 0.050000
+ 6.0450000 0.050000
+ 6.0452778 0.050000
+ 6.0455556 0.050000
+ 6.0458333 0.050000
+ 6.0461111 0.050000
+ 6.0463889 0.050000
+ 6.0466667 0.050000
+ 6.0469444 0.050000
+ 6.0472222 0.050000
+ 6.0475000 0.094665
+ 6.0477778 0.145064
+ 6.0480556 0.198737
+ 6.0483333 0.253228
+ 6.0486111 0.306078
+ 6.0488889 0.354830
+ 6.0491667 0.397026
+ 6.0494444 0.430208
+ 6.0497222 0.451918
+ 6.0500000 0.459699
+ 6.0502778 0.451912
+ 6.0505556 0.430196
+ 6.0508333 0.397010
+ 6.0511111 0.354810
+ 6.0513889 0.306056
+ 6.0516667 0.253205
+ 6.0519444 0.198716
+ 6.0522222 0.145047
+ 6.0525000 0.094655
+ 6.0527778 0.050000
+ 6.0530556 0.050000
+ 6.0533333 0.050000
+ 6.0536111 0.050000
+ 6.0538889 0.050000
+ 6.0541667 0.050000
+ 6.0544444 0.050000
+ 6.0547222 0.050000
+ 6.0550000 0.050000
+ 6.0552778 0.050000
+ 6.0555556 0.050000
+ 6.0558333 0.094651
+ 6.0561111 0.145037
+ 6.0563889 0.198699
+ 6.0566667 0.253180
+ 6.0569444 0.306023
+ 6.0572222 0.354769
+ 6.0575000 0.396961
+ 6.0577778 0.430141
+ 6.0580556 0.451851
+ 6.0583333 0.459634
+ 6.0586111 0.451851
+ 6.0588889 0.430140
+ 6.0591667 0.396960
+ 6.0594444 0.354768
+ 6.0597222 0.306022
+ 6.0600000 0.253179
+ 6.0602778 0.198698
+ 6.0605556 0.145036
+ 6.0608333 0.094651
+ 6.0611111 0.050000
+ 6.0613889 0.050000
+ 6.0616667 0.050000
+ 6.0619444 0.050000
+ 6.0622222 0.050000
+ 6.0625000 0.050000
+ 6.0627778 0.050000
+ 6.0630556 0.050000
+ 6.0633333 0.050000
+ 6.0636111 0.050000
+ 6.0638889 0.050000
+ 6.0641667 0.094654
+ 6.0644444 0.145043
+ 6.0647222 0.198710
+ 6.0650000 0.253197
+ 6.0652778 0.306045
+ 6.0655556 0.354796
+ 6.0658333 0.396992
+ 6.0661111 0.430176
+ 6.0663889 0.451889
+ 6.0666667 0.459673
+ 6.0669444 0.451889
+ 6.0672222 0.430177
+ 6.0675000 0.396993
+ 6.0677778 0.354796
+ 6.0680556 0.306045
+ 6.0683333 0.253197
+ 6.0686111 0.198711
+ 6.0688889 0.145044
+ 6.0691667 0.094654
+ 6.0694444 0.050000
+ 6.0697222 0.050000
+ 6.0700000 0.050000
+ 6.0702778 0.050000
+ 6.0705556 0.050000
+ 6.0708333 0.050000
+ 6.0711111 0.050000
+ 6.0713889 0.050000
+ 6.0716667 0.050000
+ 6.0719444 0.050000
+ 6.0722222 0.050000
+ 6.0725000 0.094652
+ 6.0727778 0.145039
+ 6.0730556 0.198703
+ 6.0733333 0.253186
+ 6.0736111 0.306030
+ 6.0738889 0.354778
+ 6.0741667 0.396971
+ 6.0744444 0.430152
+ 6.0747222 0.451864
+ 6.0750000 0.459647
+ 6.0752778 0.451864
+ 6.0755556 0.430153
+ 6.0758333 0.396971
+ 6.0761111 0.354778
+ 6.0763889 0.306030
+ 6.0766667 0.253186
+ 6.0769444 0.198703
+ 6.0772222 0.145039
+ 6.0775000 0.094652
+ 6.0777778 0.050000
+ 6.0780556 0.050000
+ 6.0783333 0.050000
+ 6.0786111 0.050000
+ 6.0788889 0.050000
+ 6.0791667 0.050000
+ 6.0794444 0.050000
+ 6.0797222 0.050000
+ 6.0800000 0.050000
+ 6.0802778 0.050000
+ 6.0805556 0.050000
+ 6.0808333 0.094655
+ 6.0811111 0.145044
+ 6.0813889 0.198711
+ 6.0816667 0.253196
+ 6.0819444 0.306042
+ 6.0822222 0.354788
+ 6.0825000 0.396978
+ 6.0827778 0.430152
+ 6.0830556 0.451853
+ 6.0833333 0.459621
+ 6.0836111 0.451818
+ 6.0838889 0.430084
+ 6.0841667 0.396881
+ 6.0844444 0.354669
+ 6.0847222 0.305909
+ 6.0850000 0.253061
+ 6.0852778 0.198585
+ 6.0855556 0.144942
+ 6.0858333 0.094594
+ 6.0861111 0.050000
+ 6.0863889 0.050000
+ 6.0866667 0.050000
+ 6.0869444 0.050000
+ 6.0872222 0.050000
+ 6.0875000 0.050000
+ 6.0877778 0.050000
+ 6.0880556 0.050000
+ 6.0883333 0.050000
+ 6.0886111 0.050000
+ 6.0888889 0.050000
+ 6.0891667 0.094369
+ 6.0894444 0.144428
+ 6.0897222 0.197761
+ 6.0900000 0.251951
+ 6.0902778 0.304580
+ 6.0905556 0.353232
+ 6.0908333 0.395489
+ 6.0911111 0.428935
+ 6.0913889 0.451153
+ 6.0916667 0.459725
+ 6.0919444 0.453035
+ 6.0922222 0.432664
+ 6.0925000 0.400994
+ 6.0927778 0.360406
+ 6.0930556 0.313283
+ 6.0933333 0.262006
+ 6.0936111 0.208957
+ 6.0938889 0.156518
+ 6.0941667 0.107070
+ 6.0944444 0.062994
+ 6.0947222 0.050000
+ 6.0950000 0.050000
+ 6.0952778 0.050000
+ 6.0955556 0.050000
+ 6.0958333 0.050000
+ 6.0961111 0.050000
+ 6.0963889 0.050000
+ 6.0966667 0.050000
+ 6.0969444 0.050000
+ 6.0972222 0.051448
+ 6.0975000 0.094089
+ 6.0977778 0.142551
+ 6.0980556 0.194501
+ 6.0983333 0.247606
+ 6.0986111 0.299534
+ 6.0988889 0.347951
+ 6.0991667 0.390523
+ 6.0994444 0.424918
+ 6.0997222 0.448802
+ 6.1000000 0.459843
+ 6.1002778 0.456463
+ 6.1005556 0.440109
+ 6.1008333 0.412983
+ 6.1011111 0.377288
+ 6.1013889 0.335227
+ 6.1016667 0.289001
+ 6.1019444 0.240815
+ 6.1022222 0.192869
+ 6.1025000 0.147367
+ 6.1027778 0.106512
+ 6.1030556 0.072152
+ 6.1033333 0.050000
+ 6.1036111 0.050000
+ 6.1038889 0.050000
+ 6.1041667 0.050000
+ 6.1044444 0.050000
+ 6.1047222 0.050000
+ 6.1050000 0.050000
+ 6.1052778 0.053982
+ 6.1055556 0.085067
+ 6.1058333 0.123474
+ 6.1061111 0.167420
+ 6.1063889 0.214751
+ 6.1066667 0.263313
+ 6.1069444 0.310951
+ 6.1072222 0.355511
+ 6.1075000 0.394837
+ 6.1077778 0.426775
+ 6.1080556 0.449171
+ 6.1083333 0.459869
+ 6.1086111 0.457403
+ 6.1088889 0.443053
+ 6.1091667 0.418789
+ 6.1094444 0.386577
+ 6.1097222 0.348386
+ 6.1100000 0.306185
+ 6.1102778 0.261941
+ 6.1105556 0.217624
+ 6.1108333 0.175200
+ 6.1111111 0.136639
+ 6.1113889 0.103615
+ 6.1116667 0.076622
+ 6.1119444 0.055861
+ 6.1122222 0.050000
+ 6.1125000 0.050000
+ 6.1127778 0.050000
+ 6.1130556 0.050000
+ 6.1133333 0.052584
+ 6.1136111 0.073440
+ 6.1138889 0.101935
+ 6.1141667 0.137880
+ 6.1144444 0.179518
+ 6.1147222 0.224703
+ 6.1150000 0.271288
+ 6.1152778 0.317126
+ 6.1155556 0.360071
+ 6.1158333 0.397975
+ 6.1161111 0.428691
+ 6.1163889 0.450073
+ 6.1166667 0.459974
+ 6.1169444 0.456928
+ 6.1172222 0.442196
+ 6.1175000 0.417720
+ 6.1177778 0.385441
+ 6.1180556 0.347300
+ 6.1183333 0.305240
+ 6.1186111 0.261203
+ 6.1188889 0.217129
+ 6.1191667 0.174960
+ 6.1194444 0.136639
+ 6.1197222 0.103817
+ 6.1200000 0.076984
+ 6.1202778 0.056339
+ 6.1205556 0.050000
+ 6.1208333 0.050000
+ 6.1211111 0.050000
+ 6.1213889 0.050000
+ 6.1216667 0.052947
+ 6.1219444 0.073634
+ 6.1222222 0.101909
+ 6.1225000 0.137587
+ 6.1227778 0.178936
+ 6.1230556 0.223841
+ 6.1233333 0.270184
+ 6.1236111 0.315850
+ 6.1238889 0.358722
+ 6.1241667 0.396682
+ 6.1244444 0.427616
+ 6.1247222 0.449405
+ 6.1250000 0.459935
+ 6.1252778 0.457753
+ 6.1255556 0.444077
+ 6.1258333 0.420788
+ 6.1261111 0.389768
+ 6.1263889 0.352899
+ 6.1266667 0.312062
+ 6.1269444 0.269140
+ 6.1272222 0.226015
+ 6.1275000 0.184568
+ 6.1277778 0.146682
+ 6.1280556 0.113966
+ 6.1283333 0.086939
+ 6.1286111 0.065850
+ 6.1288889 0.050947
+ 6.1291667 0.050000
+ 6.1294444 0.050000
+ 6.1297222 0.050000
+ 6.1300000 0.058137
+ 6.1302778 0.077875
+ 6.1305556 0.105283
+ 6.1308333 0.140214
+ 6.1311111 0.180936
+ 6.1313889 0.225323
+ 6.1316667 0.271246
+ 6.1319444 0.316578
+ 6.1322222 0.359192
+ 6.1325000 0.396961
+ 6.1327778 0.427757
+ 6.1330556 0.449453
+ 6.1333333 0.459922
+ 6.1336111 0.457703
+ 6.1338889 0.444008
+ 6.1341667 0.420714
+ 6.1344444 0.389701
+ 6.1347222 0.352845
+ 6.1350000 0.312026
+ 6.1352778 0.269123
+ 6.1355556 0.226012
+ 6.1358333 0.184572
+ 6.1361111 0.146682
+ 6.1363889 0.113949
+ 6.1366667 0.086897
+ 6.1369444 0.065778
+ 6.1372222 0.050846
+ 6.1375000 0.050000
+ 6.1377778 0.050000
+ 6.1380556 0.050000
+ 6.1383333 0.058042
+ 6.1386111 0.077836
+ 6.1388889 0.105335
+ 6.1391667 0.140391
+ 6.1394444 0.181259
+ 6.1397222 0.225792
+ 6.1400000 0.271847
+ 6.1402778 0.317277
+ 6.1405556 0.359938
+ 6.1408333 0.397683
+ 6.1411111 0.428368
+ 6.1413889 0.449846
+ 6.1416667 0.459974
+ 6.1419444 0.457280
+ 6.1422222 0.442994
+ 6.1425000 0.419021
+ 6.1427778 0.387266
+ 6.1430556 0.349634
+ 6.1433333 0.308029
+ 6.1436111 0.264358
+ 6.1438889 0.220523
+ 6.1441667 0.178432
+ 6.1444444 0.139987
+ 6.1447222 0.106818
+ 6.1450000 0.079446
+ 6.1452778 0.058117
+ 6.1455556 0.050000
+ 6.1458333 0.050000
+ 6.1461111 0.050000
+ 6.1463889 0.050000
+ 6.1466667 0.050685
+ 6.1469444 0.070757
+ 6.1472222 0.098588
+ 6.1475000 0.134024
+ 6.1477778 0.175324
+ 6.1480556 0.220345
+ 6.1483333 0.266949
+ 6.1486111 0.312995
+ 6.1488889 0.356342
+ 6.1491667 0.394850
+ 6.1494444 0.426378
+ 6.1497222 0.448787
+ 6.1500000 0.459935
+ 6.1502778 0.458351
+ 6.1505556 0.445238
+ 6.1508333 0.422471
+ 6.1511111 0.391920
+ 6.1513889 0.355458
+ 6.1516667 0.314958
+ 6.1519444 0.272293
+ 6.1522222 0.229335
+ 6.1525000 0.187956
+ 6.1527778 0.150029
+ 6.1530556 0.117160
+ 6.1533333 0.089884
+ 6.1536111 0.068470
+ 6.1538889 0.053186
+ 6.1541667 0.050000
+ 6.1544444 0.050000
+ 6.1547222 0.050000
+ 6.1550000 0.058730
+ 6.1552778 0.078129
+ 6.1555556 0.105270
+ 6.1558333 0.140020
+ 6.1561111 0.180640
+ 6.1563889 0.224988
+ 6.1566667 0.270922
+ 6.1569444 0.316303
+ 6.1572222 0.358987
+ 6.1575000 0.396833
+ 6.1577778 0.427701
+ 6.1580556 0.449449
+ 6.1583333 0.459935
+ 6.1586111 0.457690
+ 6.1588889 0.443935
+ 6.1591667 0.420563
+ 6.1594444 0.389467
+ 6.1597222 0.352539
+ 6.1600000 0.311673
+ 6.1602778 0.268761
+ 6.1605556 0.225697
+ 6.1608333 0.184373
+ 6.1611111 0.146682
+ 6.1613889 0.114240
+ 6.1616667 0.087552
+ 6.1619444 0.066848
+ 6.1622222 0.052355
+ 6.1625000 0.050000
+ 6.1627778 0.050000
+ 6.1630556 0.050000
+ 6.1633333 0.061079
+ 6.1636111 0.081076
+ 6.1638889 0.108656
+ 6.1641667 0.143658
+ 6.1644444 0.184348
+ 6.1647222 0.228606
+ 6.1650000 0.274307
+ 6.1652778 0.319329
+ 6.1655556 0.361548
+ 6.1658333 0.398843
+ 6.1661111 0.429090
+ 6.1663889 0.450166
+ 6.1666667 0.459948
+ 6.1669444 0.456980
+ 6.1672222 0.442476
+ 6.1675000 0.418313
+ 6.1677778 0.386373
+ 6.1680556 0.348533
+ 6.1683333 0.306675
+ 6.1686111 0.262677
+ 6.1688889 0.218419
+ 6.1691667 0.175780
+ 6.1694444 0.136639
+ 6.1697222 0.102615
+ 6.1700000 0.074272
+ 6.1702778 0.051915
+ 6.1705556 0.050000
+ 6.1708333 0.050000
+ 6.1711111 0.050000
+ 6.1713889 0.050000
+ 6.1716667 0.050000
+ 6.1719444 0.060465
+ 6.1722222 0.088506
+ 6.1725000 0.124539
+ 6.1727778 0.166759
+ 6.1730556 0.212938
+ 6.1733333 0.260848
+ 6.1736111 0.308263
+ 6.1738889 0.352956
+ 6.1741667 0.392698
+ 6.1744444 0.425262
+ 6.1747222 0.448421
+ 6.1750000 0.459948
+ 6.1752778 0.458309
+ 6.1755556 0.444751
+ 6.1758333 0.421213
+ 6.1761111 0.389635
+ 6.1763889 0.351958
+ 6.1766667 0.310122
+ 6.1769444 0.266067
+ 6.1772222 0.221732
+ 6.1775000 0.179059
+ 6.1777778 0.139987
+ 6.1780556 0.106177
+ 6.1783333 0.078176
+ 6.1786111 0.056248
+ 6.1788889 0.050000
+ 6.1791667 0.050000
+ 6.1794444 0.050000
+ 6.1797222 0.050000
+ 6.1800000 0.050000
+ 6.1802778 0.067171
+ 6.1805556 0.095227
+ 6.1808333 0.131079
+ 6.1811111 0.172936
+ 6.1813889 0.218597
+ 6.1816667 0.265863
+ 6.1819444 0.312532
+ 6.1822222 0.356404
+ 6.1825000 0.395277
+ 6.1827778 0.426950
+ 6.1830556 0.449223
+ 6.1833333 0.459895
+ 6.1836111 0.457458
+ 6.1838889 0.443171
+ 6.1841667 0.418988
+ 6.1844444 0.386861
+ 6.1847222 0.348743
+ 6.1850000 0.306588
+ 6.1852778 0.262347
+ 6.1855556 0.217973
+ 6.1858333 0.175420
+ 6.1861111 0.136639
+ 6.1863889 0.103298
+ 6.1866667 0.075910
+ 6.1869444 0.054705
+ 6.1872222 0.050000
+ 6.1875000 0.050000
+ 6.1877778 0.050000
+ 6.1880556 0.050000
+ 6.1883333 0.050000
+ 6.1886111 0.070114
+ 6.1888889 0.098588
+ 6.1891667 0.134671
+ 6.1894444 0.176583
+ 6.1897222 0.222144
+ 6.1900000 0.269170
+ 6.1902778 0.315480
+ 6.1905556 0.358893
+ 6.1908333 0.397226
+ 6.1911111 0.428299
+ 6.1913889 0.449929
+ 6.1916667 0.459935
+ 6.1919444 0.456824
+ 6.1922222 0.441860
+ 6.1925000 0.416999
+ 6.1927778 0.384193
+ 6.1930556 0.345397
+ 6.1933333 0.302564
+ 6.1936111 0.257648
+ 6.1938889 0.212604
+ 6.1941667 0.169385
+ 6.1944444 0.129944
+ 6.1947222 0.095952
+ 6.1950000 0.067939
+ 6.1952778 0.050000
+ 6.1955556 0.050000
+ 6.1958333 0.050000
+ 6.1961111 0.050000
+ 6.1963889 0.050000
+ 6.1966667 0.050000
+ 6.1969444 0.059847
+ 6.1972222 0.088493
+ 6.1975000 0.124920
+ 6.1977778 0.167345
+ 6.1980556 0.213578
+ 6.1983333 0.261429
+ 6.1986111 0.308708
+ 6.1988889 0.353228
+ 6.1991667 0.392797
+ 6.1994444 0.425226
+ 6.1997222 0.448327
+ 6.2000000 0.459908
+ 6.2002778 0.458465
+ 6.2005556 0.445221
+ 6.2008333 0.422084
+ 6.2011111 0.390961
+ 6.2013889 0.353760
+ 6.2016667 0.312387
+ 6.2019444 0.268751
+ 6.2022222 0.224759
+ 6.2025000 0.182317
+ 6.2027778 0.143334
+ 6.2030556 0.109449
+ 6.2033333 0.081229
+ 6.2036111 0.058971
+ 6.2038889 0.050000
+ 6.2041667 0.050000
+ 6.2044444 0.050000
+ 6.2047222 0.050000
+ 6.2050000 0.050000
+ 6.2052778 0.067370
+ 6.2055556 0.095214
+ 6.2058333 0.130988
+ 6.2061111 0.172877
+ 6.2063889 0.218647
+ 6.2066667 0.266061
+ 6.2069444 0.312884
+ 6.2072222 0.356880
+ 6.2075000 0.395814
+ 6.2077778 0.427449
+ 6.2080556 0.449551
+ 6.2083333 0.459882
+ 6.2086111 0.456914
+ 6.2088889 0.441941
+ 6.2091667 0.416962
+ 6.2094444 0.383977
+ 6.2097222 0.344987
+ 6.2100000 0.301991
+ 6.2102778 0.256988
+ 6.2105556 0.211980
+ 6.2108333 0.168965
+ 6.2111111 0.129944
+ 6.2113889 0.096616
+ 6.2116667 0.069477
+ 6.2119444 0.050000
+ 6.2122222 0.050000
+ 6.2125000 0.050000
+ 6.2127778 0.050000
+ 6.2130556 0.050000
+ 6.2133333 0.050000
+ 6.2136111 0.069151
+ 6.2138889 0.098535
+ 6.2141667 0.135462
+ 6.2144444 0.178116
+ 6.2147222 0.224286
+ 6.2150000 0.271757
+ 6.2152778 0.318315
+ 6.2155556 0.361747
+ 6.2158333 0.399839
+ 6.2161111 0.430377
+ 6.2163889 0.451146
+ 6.2166667 0.459935
+ 6.2169444 0.455239
+ 6.2172222 0.438402
+ 6.2175000 0.411480
+ 6.2177778 0.376526
+ 6.2180556 0.335595
+ 6.2183333 0.290743
+ 6.2186111 0.244023
+ 6.2188889 0.197491
+ 6.2191667 0.153200
+ 6.2194444 0.113207
+ 6.2197222 0.079248
+ 6.2200000 0.051797
+ 6.2202778 0.050000
+ 6.2205556 0.050000
+ 6.2208333 0.050000
+ 6.2211111 0.050000
+ 6.2213889 0.050000
+ 6.2216667 0.050000
+ 6.2219444 0.054901
+ 6.2222222 0.085106
+ 6.2225000 0.122831
+ 6.2227778 0.166291
+ 6.2230556 0.213315
+ 6.2233333 0.261732
+ 6.2236111 0.309371
+ 6.2238889 0.354059
+ 6.2241667 0.393626
+ 6.2244444 0.425900
+ 6.2247222 0.448709
+ 6.2250000 0.459882
+ 6.2252778 0.457928
+ 6.2255556 0.444070
+ 6.2258333 0.420215
+ 6.2261111 0.388267
+ 6.2263889 0.350131
+ 6.2266667 0.307711
+ 6.2269444 0.262912
+ 6.2272222 0.217640
+ 6.2275000 0.173798
+ 6.2277778 0.133292
+ 6.2280556 0.097771
+ 6.2283333 0.067861
+ 6.2286111 0.050000
+ 6.2288889 0.050000
+ 6.2291667 0.050000
+ 6.2294444 0.050000
+ 6.2297222 0.050000
+ 6.2300000 0.050000
+ 6.2302778 0.050000
+ 6.2305556 0.075090
+ 6.2308333 0.111918
+ 6.2311111 0.155354
+ 6.2313889 0.203058
+ 6.2316667 0.252687
+ 6.2319444 0.301900
+ 6.2322222 0.348358
+ 6.2325000 0.389718
+ 6.2327778 0.423640
+ 6.2330556 0.447782
+ 6.2333333 0.459804
+ 6.2336111 0.458092
+ 6.2338889 0.443947
+ 6.2341667 0.419398
+ 6.2344444 0.386472
+ 6.2347222 0.347197
+ 6.2350000 0.303603
+ 6.2352778 0.257718
+ 6.2355556 0.211569
+ 6.2358333 0.167186
+ 6.2361111 0.126597
+ 6.2363889 0.091536
+ 6.2366667 0.062562
+ 6.2369444 0.050000
+ 6.2372222 0.050000
+ 6.2375000 0.050000
+ 6.2377778 0.050000
+ 6.2380556 0.050000
+ 6.2383333 0.050000
+ 6.2386111 0.052500
+ 6.2388889 0.081785
+ 6.2391667 0.119122
+ 6.2394444 0.162652
+ 6.2397222 0.210093
+ 6.2400000 0.259160
+ 6.2402778 0.307571
+ 6.2405556 0.353041
+ 6.2408333 0.393289
+ 6.2411111 0.426029
+ 6.2413889 0.448979
+ 6.2416667 0.459856
+ 6.2419444 0.457094
+ 6.2422222 0.441997
+ 6.2425000 0.416588
+ 6.2427778 0.382890
+ 6.2430556 0.342926
+ 6.2433333 0.298718
+ 6.2436111 0.252289
+ 6.2438889 0.205662
+ 6.2441667 0.160858
+ 6.2444444 0.119902
+ 6.2447222 0.084523
+ 6.2450000 0.055285
+ 6.2452778 0.050000
+ 6.2455556 0.050000
+ 6.2458333 0.050000
+ 6.2461111 0.050000
+ 6.2463889 0.050000
+ 6.2466667 0.050000
+ 6.2469444 0.050000
+ 6.2472222 0.075051
+ 6.2475000 0.112875
+ 6.2477778 0.156983
+ 6.2480556 0.205073
+ 6.2483333 0.254844
+ 6.2486111 0.303993
+ 6.2488889 0.350220
+ 6.2491667 0.391223
+ 6.2494444 0.424700
+ 6.2497222 0.448349
+ 6.2500000 0.459869
+ 6.2502778 0.457681
+ 6.2505556 0.443089
+ 6.2508333 0.418124
+ 6.2511111 0.384812
+ 6.2513889 0.345182
+ 6.2516667 0.301263
+ 6.2519444 0.255082
+ 6.2522222 0.208667
+ 6.2525000 0.164047
+ 6.2527778 0.123249
+ 6.2530556 0.088010
+ 6.2533333 0.058889
+ 6.2536111 0.050000
+ 6.2538889 0.050000
+ 6.2541667 0.050000
+ 6.2544444 0.050000
+ 6.2547222 0.050000
+ 6.2550000 0.050000
+ 6.2552778 0.050000
+ 6.2555556 0.078398
+ 6.2558333 0.115992
+ 6.2561111 0.159825
+ 6.2563889 0.207604
+ 6.2566667 0.257034
+ 6.2569444 0.305823
+ 6.2572222 0.351676
+ 6.2575000 0.392299
+ 6.2577778 0.425400
+ 6.2580556 0.448683
+ 6.2583333 0.459856
+ 6.2586111 0.457347
+ 6.2588889 0.442475
+ 6.2591667 0.417278
+ 6.2594444 0.383799
+ 6.2597222 0.344078
+ 6.2600000 0.300154
+ 6.2602778 0.254069
+ 6.2605556 0.207863
+ 6.2608333 0.163576
+ 6.2611111 0.123249
+ 6.2613889 0.088621
+ 6.2616667 0.060225
+ 6.2619444 0.050000
+ 6.2622222 0.050000
+ 6.2625000 0.050000
+ 6.2627778 0.050000
+ 6.2630556 0.050000
+ 6.2633333 0.050000
+ 6.2636111 0.055372
+ 6.2638889 0.085159
+ 6.2641667 0.122841
+ 6.2644444 0.166557
+ 6.2647222 0.214028
+ 6.2650000 0.262972
+ 6.2652778 0.311109
+ 6.2655556 0.356160
+ 6.2658333 0.395845
+ 6.2661111 0.427882
+ 6.2663889 0.449992
+ 6.2666667 0.459895
+ 6.2669444 0.456038
+ 6.2672222 0.439778
+ 6.2675000 0.413197
+ 6.2677778 0.378380
+ 6.2680556 0.337411
+ 6.2683333 0.292373
+ 6.2686111 0.245350
+ 6.2688889 0.198425
+ 6.2691667 0.153683
+ 6.2694444 0.113207
+ 6.2697222 0.078761
+ 6.2700000 0.050830
+ 6.2702778 0.050000
+ 6.2705556 0.050000
+ 6.2708333 0.050000
+ 6.2711111 0.050000
+ 6.2713889 0.050000
+ 6.2716667 0.050000
+ 6.2719444 0.051600
+ 6.2722222 0.081733
+ 6.2725000 0.119475
+ 6.2727778 0.163041
+ 6.2730556 0.210252
+ 6.2733333 0.258931
+ 6.2736111 0.306899
+ 6.2738889 0.351980
+ 6.2741667 0.391995
+ 6.2744444 0.424767
+ 6.2747222 0.448118
+ 6.2750000 0.459869
+ 6.2752778 0.458521
+ 6.2755556 0.445275
+ 6.2758333 0.422014
+ 6.2761111 0.390615
+ 6.2763889 0.352960
+ 6.2766667 0.310929
+ 6.2769444 0.266401
+ 6.2772222 0.221257
+ 6.2775000 0.177376
+ 6.2777778 0.136639
+ 6.2780556 0.100682
+ 6.2783333 0.070164
+ 6.2786111 0.050000
+ 6.2788889 0.050000
+ 6.2791667 0.050000
+ 6.2794444 0.050000
+ 6.2797222 0.050000
+ 6.2800000 0.050000
+ 6.2802778 0.050000
+ 6.2805556 0.071769
+ 6.2808333 0.108462
+ 6.2811111 0.151962
+ 6.2813889 0.199893
+ 6.2816667 0.249878
+ 6.2819444 0.299540
+ 6.2822222 0.346503
+ 6.2825000 0.388390
+ 6.2827778 0.422825
+ 6.2830556 0.447430
+ 6.2833333 0.459830
+ 6.2836111 0.458385
+ 6.2838889 0.444402
+ 6.2841667 0.419927
+ 6.2844444 0.387005
+ 6.2847222 0.347680
+ 6.2850000 0.303999
+ 6.2852778 0.258004
+ 6.2855556 0.211743
+ 6.2858333 0.167259
+ 6.2861111 0.126597
+ 6.2863889 0.091504
+ 6.2866667 0.062535
+ 6.2869444 0.050000
+ 6.2872222 0.050000
+ 6.2875000 0.050000
+ 6.2877778 0.050000
+ 6.2880556 0.050000
+ 6.2883333 0.050000
+ 6.2886111 0.052614
+ 6.2888889 0.081811
+ 6.2891667 0.119008
+ 6.2894444 0.162366
+ 6.2897222 0.209624
+ 6.2900000 0.258524
+ 6.2902778 0.306806
+ 6.2905556 0.352211
+ 6.2908333 0.392481
+ 6.2911111 0.425355
+ 6.2913889 0.448575
+ 6.2916667 0.459882
+ 6.2919444 0.457722
+ 6.2922222 0.443366
+ 6.2925000 0.418790
+ 6.2927778 0.385970
+ 6.2930556 0.346882
+ 6.2933333 0.303503
+ 6.2936111 0.257808
+ 6.2938889 0.211775
+ 6.2941667 0.167379
+ 6.2944444 0.126597
+ 6.2947222 0.091127
+ 6.2950000 0.061561
+ 6.2952778 0.050000
+ 6.2955556 0.050000
+ 6.2958333 0.050000
+ 6.2961111 0.050000
+ 6.2963889 0.050000
+ 6.2966667 0.050000
+ 6.2969444 0.050000
+ 6.2972222 0.075116
+ 6.2975000 0.112333
+ 6.2977778 0.155970
+ 6.2980556 0.203723
+ 6.2983333 0.253291
+ 6.2986111 0.302371
+ 6.2988889 0.348661
+ 6.2991667 0.389858
+ 6.2994444 0.423660
+ 6.2997222 0.447764
+ 6.3000000 0.459869
+ 6.3002778 0.458391
+ 6.3005556 0.444622
+ 6.3008333 0.420572
+ 6.3011111 0.388253
+ 6.3013889 0.349675
+ 6.3016667 0.306850
+ 6.3019444 0.261788
+ 6.3022222 0.216501
+ 6.3025000 0.172998
+ 6.3027778 0.133292
+ 6.3030556 0.099097
+ 6.3033333 0.070947
+ 6.3036111 0.050000
+ 6.3038889 0.050000
+ 6.3041667 0.050000
+ 6.3044444 0.050000
+ 6.3047222 0.050000
+ 6.3050000 0.050000
+ 6.3052778 0.063096
+ 6.3055556 0.091854
+ 6.3058333 0.128385
+ 6.3061111 0.170884
+ 6.3063889 0.217134
+ 6.3066667 0.264921
+ 6.3069444 0.312029
+ 6.3072222 0.356242
+ 6.3075000 0.395346
+ 6.3077778 0.427124
+ 6.3080556 0.449362
+ 6.3083333 0.459843
+ 6.3086111 0.457056
+ 6.3088889 0.442297
+ 6.3091667 0.417568
+ 6.3094444 0.384868
+ 6.3097222 0.346197
+ 6.3100000 0.303556
+ 6.3102778 0.258944
+ 6.3105556 0.214363
+ 6.3108333 0.171812
+ 6.3111111 0.133292
+ 6.3113889 0.100498
+ 6.3116667 0.073907
+ 6.3119444 0.053693
+ 6.3122222 0.050000
+ 6.3125000 0.050000
+ 6.3127778 0.050000
+ 6.3130556 0.050000
+ 6.3133333 0.054320
+ 6.3136111 0.075995
+ 6.3138889 0.105257
+ 6.3141667 0.141884
+ 6.3144444 0.184085
+ 6.3147222 0.229673
+ 6.3150000 0.276461
+ 6.3152778 0.322264
+ 6.3155556 0.364895
+ 6.3158333 0.402167
+ 6.3161111 0.431896
+ 6.3163889 0.451893
+ 6.3166667 0.459974
+ 6.3169444 0.454670
+ 6.3172222 0.437390
+ 6.3175000 0.410261
+ 6.3177778 0.375410
+ 6.3180556 0.334964
+ 6.3183333 0.291049
+ 6.3186111 0.245794
+ 6.3188889 0.201324
+ 6.3191667 0.159767
+ 6.3194444 0.123249
+ 6.3197222 0.093528
+ 6.3200000 0.070873
+ 6.3202778 0.055184
+ 6.3205556 0.050000
+ 6.3208333 0.050000
+ 6.3211111 0.050000
+ 6.3213889 0.060087
+ 6.3216667 0.077726
+ 6.3219444 0.101729
+ 6.3222222 0.131997
+ 6.3225000 0.168132
+ 6.3227778 0.208549
+ 6.3230556 0.251364
+ 6.3233333 0.294695
+ 6.3236111 0.336659
+ 6.3238889 0.375374
+ 6.3241667 0.408955
+ 6.3244444 0.435522
+ 6.3247222 0.453191
+ 6.3250000 0.460078
+ 6.3252778 0.454928
+ 6.3255556 0.438980
+ 6.3258333 0.414101
+ 6.3261111 0.382158
+ 6.3263889 0.345018
+ 6.3266667 0.304547
+ 6.3269444 0.262611
+ 6.3272222 0.221077
+ 6.3275000 0.181812
+ 6.3277778 0.146682
+ 6.3280556 0.117255
+ 6.3283333 0.093908
+ 6.3286111 0.076719
+ 6.3288889 0.065766
+ 6.3291667 0.061127
+ 6.3294444 0.062881
+ 6.3297222 0.071105
+ 6.3300000 0.085878
+ 6.3302778 0.107279
+ 6.3305556 0.135384
+ 6.3308333 0.169931
+ 6.3311111 0.209285
+ 6.3313889 0.251470
+ 6.3316667 0.294511
+ 6.3319444 0.336430
+ 6.3322222 0.375253
+ 6.3325000 0.409003
+ 6.3327778 0.435703
+ 6.3330556 0.453378
+ 6.3333333 0.460052
+ 6.3336111 0.454405
+ 6.3338889 0.437742
+ 6.3341667 0.412027
+ 6.3344444 0.379219
+ 6.3347222 0.341283
+ 6.3350000 0.300179
+ 6.3352778 0.257871
+ 6.3355556 0.216319
+ 6.3358333 0.177486
+ 6.3361111 0.143334
+ 6.3363889 0.115487
+ 6.3366667 0.094212
+ 6.3369444 0.079440
+ 6.3372222 0.071100
+ 6.3375000 0.069121
+ 6.3377778 0.073433
+ 6.3380556 0.083967
+ 6.3383333 0.100650
+ 6.3386111 0.123414
+ 6.3388889 0.152187
+ 6.3391667 0.186605
+ 6.3394444 0.225122
+ 6.3397222 0.265901
+ 6.3400000 0.307100
+ 6.3402778 0.346882
+ 6.3405556 0.383406
+ 6.3408333 0.414834
+ 6.3411111 0.439325
+ 6.3413889 0.455042
+ 6.3416667 0.460144
+ 6.3419444 0.453416
+ 6.3422222 0.436138
+ 6.3425000 0.410216
+ 6.3427778 0.377553
+ 6.3430556 0.340055
+ 6.3433333 0.299625
+ 6.3436111 0.258168
+ 6.3438889 0.217589
+ 6.3441667 0.179792
+ 6.3444444 0.146682
+ 6.3447222 0.119829
+ 6.3450000 0.099472
+ 6.3452778 0.085513
+ 6.3455556 0.077856
+ 6.3458333 0.076406
+ 6.3461111 0.081066
+ 6.3463889 0.091740
+ 6.3466667 0.108331
+ 6.3469444 0.130744
+ 6.3472222 0.158882
+ 6.3475000 0.192375
+ 6.3477778 0.229758
+ 6.3480556 0.269291
+ 6.3483333 0.309236
+ 6.3486111 0.347854
+ 6.3488889 0.383404
+ 6.3491667 0.414149
+ 6.3494444 0.438349
+ 6.3497222 0.454265
+ 6.3500000 0.460157
+ 6.3502778 0.454865
+ 6.3505556 0.439541
+ 6.3508333 0.415915
+ 6.3511111 0.385717
+ 6.3513889 0.350678
+ 6.3516667 0.312528
+ 6.3519444 0.272996
+ 6.3522222 0.233815
+ 6.3525000 0.196712
+ 6.3527778 0.163419
+ 6.3530556 0.135395
+ 6.3533333 0.113010
+ 6.3536111 0.096363
+ 6.3538889 0.085554
+ 6.3541667 0.080683
+ 6.3544444 0.081847
+ 6.3547222 0.089147
+ 6.3550000 0.102682
+ 6.3552778 0.122551
+ 6.3555556 0.148853
+ 6.3558333 0.181360
+ 6.3561111 0.218534
+ 6.3563889 0.258510
+ 6.3566667 0.299422
+ 6.3569444 0.339405
+ 6.3572222 0.376593
+ 6.3575000 0.409121
+ 6.3577778 0.435124
+ 6.3580556 0.452736
+ 6.3583333 0.460092
+ 6.3586111 0.455930
+ 6.3588889 0.441406
+ 6.3591667 0.418281
+ 6.3594444 0.388315
+ 6.3597222 0.353267
+ 6.3600000 0.314899
+ 6.3602778 0.274970
+ 6.3605556 0.235240
+ 6.3608333 0.197470
+ 6.3611111 0.163419
+ 6.3613889 0.134576
+ 6.3616667 0.111338
+ 6.3619444 0.093831
+ 6.3622222 0.082179
+ 6.3625000 0.076509
+ 6.3627778 0.076945
+ 6.3630556 0.083613
+ 6.3633333 0.096638
+ 6.3636111 0.116146
+ 6.3638889 0.142262
+ 6.3641667 0.174777
+ 6.3644444 0.212145
+ 6.3647222 0.252484
+ 6.3650000 0.293915
+ 6.3652778 0.334557
+ 6.3655556 0.372529
+ 6.3658333 0.405950
+ 6.3661111 0.432940
+ 6.3663889 0.451619
+ 6.3666667 0.460105
+ 6.3669444 0.457114
+ 6.3672222 0.443746
+ 6.3675000 0.421697
+ 6.3677778 0.392664
+ 6.3680556 0.358342
+ 6.3683333 0.320427
+ 6.3686111 0.280616
+ 6.3688889 0.240605
+ 6.3691667 0.202090
+ 6.3694444 0.166767
+ 6.3697222 0.136095
+ 6.3700000 0.110587
+ 6.3702778 0.090518
+ 6.3705556 0.076163
+ 6.3708333 0.067799
+ 6.3711111 0.065700
+ 6.3713889 0.070143
+ 6.3716667 0.081402
+ 6.3719444 0.099753
+ 6.3722222 0.125472
+ 6.3725000 0.158446
+ 6.3727778 0.197008
+ 6.3730556 0.239104
+ 6.3733333 0.282677
+ 6.3736111 0.325674
+ 6.3738889 0.366038
+ 6.3741667 0.401716
+ 6.3744444 0.430652
+ 6.3747222 0.450791
+ 6.3750000 0.460078
+ 6.3752778 0.457118
+ 6.3755556 0.443153
+ 6.3758333 0.420083
+ 6.3761111 0.389811
+ 6.3763889 0.354239
+ 6.3766667 0.315267
+ 6.3769444 0.274798
+ 6.3772222 0.234733
+ 6.3775000 0.196973
+ 6.3777778 0.163419
+ 6.3780556 0.135656
+ 6.3783333 0.113991
+ 6.3786111 0.098412
+ 6.3788889 0.088910
+ 6.3791667 0.085474
+ 6.3794444 0.088094
+ 6.3797222 0.096757
+ 6.3800000 0.111455
+ 6.3802778 0.132175
+ 6.3805556 0.158908
+ 6.3808333 0.191348
+ 6.3811111 0.228013
+ 6.3813889 0.267124
+ 6.3816667 0.306905
+ 6.3819444 0.345576
+ 6.3822222 0.381362
+ 6.3825000 0.412484
+ 6.3827778 0.437164
+ 6.3830556 0.453626
+ 6.3833333 0.460092
+ 6.3836111 0.455356
+ 6.3838889 0.440505
+ 6.3841667 0.417200
+ 6.3844444 0.387099
+ 6.3847222 0.351862
+ 6.3850000 0.313149
+ 6.3852778 0.272619
+ 6.3855556 0.231932
+ 6.3858333 0.192747
+ 6.3861111 0.156724
+ 6.3863889 0.125299
+ 6.3866667 0.099014
+ 6.3869444 0.078188
+ 6.3872222 0.063140
+ 6.3875000 0.054189
+ 6.3877778 0.051653
+ 6.3880556 0.055852
+ 6.3883333 0.067104
+ 6.3886111 0.085728
+ 6.3888889 0.112043
+ 6.3891667 0.145960
+ 6.3894444 0.185755
+ 6.3897222 0.229296
+ 6.3900000 0.274454
+ 6.3902778 0.319095
+ 6.3905556 0.361089
+ 6.3908333 0.398304
+ 6.3911111 0.428608
+ 6.3913889 0.449871
+ 6.3916667 0.459961
+ 6.3919444 0.457405
+ 6.3922222 0.443368
+ 6.3925000 0.419675
+ 6.3927778 0.388149
+ 6.3930556 0.350613
+ 6.3933333 0.308893
+ 6.3936111 0.264811
+ 6.3938889 0.220193
+ 6.3941667 0.176861
+ 6.3944444 0.136639
+ 6.3947222 0.101118
+ 6.3950000 0.070944
+ 6.3952778 0.050000
+ 6.3955556 0.050000
+ 6.3958333 0.050000
+ 6.3961111 0.050000
+ 6.3963889 0.050000
+ 6.3966667 0.050000
+ 6.3969444 0.050000
+ 6.3972222 0.071769
+ 6.3975000 0.107902
+ 6.3977778 0.150796
+ 6.3980556 0.198138
+ 6.3983333 0.247616
+ 6.3986111 0.296917
+ 6.3988889 0.343729
+ 6.3991667 0.385739
+ 6.3994444 0.420634
+ 6.3997222 0.446102
+ 6.4000000 0.459830
+ 6.4002778 0.460207
+ 6.4005556 0.448422
+ 6.4008333 0.426369
+ 6.4011111 0.395937
+ 6.4013889 0.359019
+ 6.4016667 0.317506
+ 6.4019444 0.273290
+ 6.4022222 0.228262
+ 6.4025000 0.184313
+ 6.4027778 0.143334
+ 6.4030556 0.106977
+ 6.4033333 0.075926
+ 6.4036111 0.050625
+ 6.4038889 0.050000
+ 6.4041667 0.050000
+ 6.4044444 0.050000
+ 6.4047222 0.050000
+ 6.4050000 0.050000
+ 6.4052778 0.050000
+ 6.4055556 0.071782
+ 6.4058333 0.107982
+ 6.4061111 0.151102
+ 6.4063889 0.198766
+ 6.4066667 0.248593
+ 6.4069444 0.298206
+ 6.4072222 0.345225
+ 6.4075000 0.387273
+ 6.4077778 0.421972
+ 6.4080556 0.446941
+ 6.4083333 0.459804
+ 6.4086111 0.458912
+ 6.4088889 0.445540
+ 6.4091667 0.421693
+ 6.4094444 0.389377
+ 6.4097222 0.350598
+ 6.4100000 0.307361
+ 6.4102778 0.261672
+ 6.4105556 0.215536
+ 6.4108333 0.170958
+ 6.4111111 0.129944
+ 6.4113889 0.094219
+ 6.4116667 0.064376
+ 6.4119444 0.050000
+ 6.4122222 0.050000
+ 6.4125000 0.050000
+ 6.4127778 0.050000
+ 6.4130556 0.050000
+ 6.4133333 0.050000
+ 6.4136111 0.050000
+ 6.4138889 0.075155
+ 6.4141667 0.111973
+ 6.4144444 0.155226
+ 6.4147222 0.202638
+ 6.4150000 0.251934
+ 6.4152778 0.300837
+ 6.4155556 0.347072
+ 6.4158333 0.388362
+ 6.4161111 0.422431
+ 6.4163889 0.447004
+ 6.4166667 0.459804
+ 6.4169444 0.459249
+ 6.4172222 0.446532
+ 6.4175000 0.423539
+ 6.4177778 0.392156
+ 6.4180556 0.354269
+ 6.4183333 0.311764
+ 6.4186111 0.266528
+ 6.4188889 0.220446
+ 6.4191667 0.175406
+ 6.4194444 0.133292
+ 6.4197222 0.095758
+ 6.4200000 0.063526
+ 6.4202778 0.050000
+ 6.4205556 0.050000
+ 6.4208333 0.050000
+ 6.4211111 0.050000
+ 6.4213889 0.050000
+ 6.4216667 0.050000
+ 6.4219444 0.050000
+ 6.4222222 0.055018
+ 6.4225000 0.091953
+ 6.4227778 0.136150
+ 6.4230556 0.185181
+ 6.4233333 0.236616
+ 6.4236111 0.288029
+ 6.4238889 0.336990
+ 6.4241667 0.381071
+ 6.4244444 0.417844
+ 6.4247222 0.444880
+ 6.4250000 0.459752
+ 6.4252778 0.460761
+ 6.4255556 0.449139
+ 6.4258333 0.426844
+ 6.4261111 0.395837
+ 6.4263889 0.358079
+ 6.4266667 0.315531
+ 6.4269444 0.270152
+ 6.4272222 0.223904
+ 6.4275000 0.178746
+ 6.4277778 0.136639
+ 6.4280556 0.099292
+ 6.4283333 0.067398
+ 6.4286111 0.050000
+ 6.4288889 0.050000
+ 6.4291667 0.050000
+ 6.4294444 0.050000
+ 6.4297222 0.050000
+ 6.4300000 0.050000
+ 6.4302778 0.050000
+ 6.4305556 0.061739
+ 6.4308333 0.098388
+ 6.4311111 0.142092
+ 6.4313889 0.190469
+ 6.4316667 0.241135
+ 6.4319444 0.291708
+ 6.4322222 0.339803
+ 6.4325000 0.383039
+ 6.4327778 0.419031
+ 6.4330556 0.445396
+ 6.4333333 0.459752
+ 6.4336111 0.460432
+ 6.4338889 0.448646
+ 6.4341667 0.426318
+ 6.4344444 0.395375
+ 6.4347222 0.357742
+ 6.4350000 0.315346
+ 6.4352778 0.270111
+ 6.4355556 0.223965
+ 6.4358333 0.178832
+ 6.4361111 0.136639
+ 6.4363889 0.099074
+ 6.4366667 0.066869
+ 6.4369444 0.050000
+ 6.4372222 0.050000
+ 6.4375000 0.050000
+ 6.4377778 0.050000
+ 6.4380556 0.050000
+ 6.4383333 0.050000
+ 6.4386111 0.050000
+ 6.4388889 0.061739
+ 6.4391667 0.099588
+ 6.4394444 0.144701
+ 6.4397222 0.194515
+ 6.4400000 0.246471
+ 6.4402778 0.298008
+ 6.4405556 0.346566
+ 6.4408333 0.389584
+ 6.4411111 0.424501
+ 6.4413889 0.448757
+ 6.4416667 0.459791
+ 6.4419444 0.455846
+ 6.4422222 0.438379
+ 6.4425000 0.409650
+ 6.4427778 0.371919
+ 6.4430556 0.327447
+ 6.4433333 0.278494
+ 6.4436111 0.227321
+ 6.4438889 0.176187
+ 6.4441667 0.127353
+ 6.4444444 0.083079
+ 6.4447222 0.050000
+ 6.4450000 0.050000
+ 6.4452778 0.050000
+ 6.4455556 0.050000
+ 6.4458333 0.050000
+ 6.4461111 0.050000
+ 6.4463889 0.050000
+ 6.4466667 0.050000
+ 6.4469444 0.050000
+ 6.4472222 0.050000
+ 6.4475000 0.092582
+ 6.4477778 0.141696
+ 6.4480556 0.194757
+ 6.4483333 0.249178
+ 6.4486111 0.302376
+ 6.4488889 0.351762
+ 6.4491667 0.394753
+ 6.4494444 0.428761
+ 6.4497222 0.451202
+ 6.4500000 0.459490
+ 6.4502778 0.451894
+ 6.4505556 0.430102
+ 6.4508333 0.396659
+ 6.4511111 0.354108
+ 6.4513889 0.304994
+ 6.4516667 0.251860
+ 6.4519444 0.197249
+ 6.4522222 0.143707
+ 6.4525000 0.093776
+ 6.4527778 0.050000
+ 6.4530556 0.050000
+ 6.4533333 0.050000
+ 6.4536111 0.050000
+ 6.4538889 0.050000
+ 6.4541667 0.050000
+ 6.4544444 0.050000
+ 6.4547222 0.050000
+ 6.4550000 0.050000
+ 6.4552778 0.050000
+ 6.4555556 0.050000
+ 6.4558333 0.089181
+ 6.4561111 0.133203
+ 6.4563889 0.180397
+ 6.4566667 0.229092
+ 6.4569444 0.277617
+ 6.4572222 0.324304
+ 6.4575000 0.367481
+ 6.4577778 0.405478
+ 6.4580556 0.436626
+ 6.4583333 0.459255
+ 6.4586111 0.472148
+ 6.4588889 0.475909
+ 6.4591667 0.471597
+ 6.4594444 0.460269
+ 6.4597222 0.442983
+ 6.4600000 0.420798
+ 6.4602778 0.394772
+ 6.4605556 0.365962
+ 6.4608333 0.335426
+ 6.4611111 0.304224
+ 6.4613889 0.273370
+ 6.4616667 0.243714
+ 6.4619444 0.216062
+ 6.4622222 0.191221
+ 6.4625000 0.169997
+ 6.4627778 0.153198
+ 6.4630556 0.141631
+ 6.4633333 0.136101
+ 6.4636111 0.137415
+ 6.4638889 0.146381
+ 6.4641667 0.163485
+ 6.4644444 0.187932
+ 6.4647222 0.218609
+ 6.4650000 0.254400
+ 6.4652778 0.294191
+ 6.4655556 0.336869
+ 6.4658333 0.381318
+ 6.4661111 0.426423
+ 6.4663889 0.471072
+ 6.4666667 0.514148
+ 6.4669444 0.554524
+ 6.4672222 0.591013
+ 6.4675000 0.622412
+ 6.4677778 0.647522
+ 6.4680556 0.665140
+ 6.4683333 0.674065
+ 6.4686111 0.673097
+ 6.4688889 0.661034
+ 6.4691667 0.636674
+ 6.4694444 0.598817
+ 6.4697222 0.547097
+ 6.4700000 0.484495
+ 6.4702778 0.414829
+ 6.4705556 0.341915
+ 6.4708333 0.269572
+ 6.4711111 0.201615
+ 6.4713889 0.141862
+ 6.4716667 0.094130
+ 6.4719444 0.062237
+ 6.4722222 0.050000
+ 6.4725000 0.059903
+ 6.4727778 0.089104
+ 6.4730556 0.133427
+ 6.4733333 0.188697
+ 6.4736111 0.250738
+ 6.4738889 0.315376
+ 6.4741667 0.378435
+ 6.4744444 0.435739
+ 6.4747222 0.483114
+ 6.4750000 0.516384
+ 6.4752778 0.532557
+ 6.4755556 0.533372
+ 6.4758333 0.521752
+ 6.4761111 0.500619
+ 6.4763889 0.472896
+ 6.4766667 0.441505
+ 6.4769444 0.409369
+ 6.4772222 0.379409
+ 6.4775000 0.354549
+ 6.4777778 0.337712
+ 6.4780556 0.331069
+ 6.4783333 0.333793
+ 6.4786111 0.344309
+ 6.4788889 0.361040
+ 6.4791667 0.382409
+ 6.4794444 0.406840
+ 6.4797222 0.432756
+ 6.4800000 0.458580
+ 6.4802778 0.482737
+ 6.4805556 0.503648
+ 6.4808333 0.520012
+ 6.4811111 0.531616
+ 6.4813889 0.538522
+ 6.4816667 0.540792
+ 6.4819444 0.538487
+ 6.4822222 0.531668
+ 6.4825000 0.520399
+ 6.4827778 0.504739
+ 6.4830556 0.484751
+ 6.4833333 0.460497
+ 6.4836111 0.432147
+ 6.4838889 0.400312
+ 6.4841667 0.365711
+ 6.4844444 0.329063
+ 6.4847222 0.291090
+ 6.4850000 0.252509
+ 6.4852778 0.214042
+ 6.4855556 0.176406
+ 6.4858333 0.140323
+ 6.4861111 0.106512
+ 6.4863889 0.075690
+ 6.4866667 0.050000
+ 6.4869444 0.050000
+ 6.4872222 0.050000
+ 6.4875000 0.050000
+ 6.4877778 0.050000
+ 6.4880556 0.050000
+ 6.4883333 0.050000
+ 6.4886111 0.050000
+ 6.4888889 0.050000
+ 6.4891667 0.087580
+ 6.4894444 0.132702
+ 6.4897222 0.182819
+ 6.4900000 0.235385
+ 6.4902778 0.287853
+ 6.4905556 0.337677
+ 6.4908333 0.382311
+ 6.4911111 0.419208
+ 6.4913889 0.445823
+ 6.4916667 0.459608
+ 6.4919444 0.458795
+ 6.4922222 0.444730
+ 6.4925000 0.419535
+ 6.4927778 0.385333
+ 6.4930556 0.344247
+ 6.4933333 0.298400
+ 6.4936111 0.249914
+ 6.4938889 0.200914
+ 6.4941667 0.153521
+ 6.4944444 0.109859
+ 6.4947222 0.071756
+ 6.4950000 0.050000
+ 6.4952778 0.050000
+ 6.4955556 0.050000
+ 6.4958333 0.050000
+ 6.4961111 0.050000
+ 6.4963889 0.050000
+ 6.4966667 0.050000
+ 6.4969444 0.050000
+ 6.4972222 0.050000
+ 6.4975000 0.089222
+ 6.4977778 0.135353
+ 6.4980556 0.185948
+ 6.4983333 0.238562
+ 6.4986111 0.290750
+ 6.4988889 0.340067
+ 6.4991667 0.384066
+ 6.4994444 0.420304
+ 6.4997222 0.446334
+ 6.5000000 0.459712
+ 6.5002778 0.458746
+ 6.5005556 0.444758
+ 6.5008333 0.419825
+ 6.5011111 0.386022
+ 6.5013889 0.345426
+ 6.5016667 0.300113
+ 6.5019444 0.252158
+ 6.5022222 0.203638
+ 6.5025000 0.156629
+ 6.5027778 0.113207
+ 6.5030556 0.075165
+ 6.5033333 0.050000
+ 6.5036111 0.050000
+ 6.5038889 0.050000
+ 6.5041667 0.050000
+ 6.5044444 0.050000
+ 6.5047222 0.050000
+ 6.5050000 0.050000
+ 6.5052778 0.050000
+ 6.5055556 0.050000
+ 6.5058333 0.088909
+ 6.5061111 0.134812
+ 6.5063889 0.185256
+ 6.5066667 0.237792
+ 6.5069444 0.289969
+ 6.5072222 0.339337
+ 6.5075000 0.383444
+ 6.5077778 0.419841
+ 6.5080556 0.446076
+ 6.5083333 0.459699
+ 6.5086111 0.459013
+ 6.5088889 0.445334
+ 6.5091667 0.420733
+ 6.5094444 0.387278
+ 6.5097222 0.347040
+ 6.5100000 0.302090
+ 6.5102778 0.254496
+ 6.5105556 0.206329
+ 6.5108333 0.159658
+ 6.5111111 0.116554
+ 6.5113889 0.078805
+ 6.5116667 0.050000
+ 6.5119444 0.050000
+ 6.5122222 0.050000
+ 6.5125000 0.050000
+ 6.5127778 0.050000
+ 6.5130556 0.050000
+ 6.5133333 0.050000
+ 6.5136111 0.050000
+ 6.5138889 0.054966
+ 6.5141667 0.093861
+ 6.5144444 0.139696
+ 6.5147222 0.190000
+ 6.5150000 0.242304
+ 6.5152778 0.294135
+ 6.5155556 0.343024
+ 6.5158333 0.386501
+ 6.5161111 0.422095
+ 6.5163889 0.447335
+ 6.5166667 0.459752
+ 6.5169444 0.457642
+ 6.5172222 0.442376
+ 6.5175000 0.416091
+ 6.5177778 0.380926
+ 6.5180556 0.339018
+ 6.5183333 0.292506
+ 6.5186111 0.243526
+ 6.5188889 0.194217
+ 6.5191667 0.146718
+ 6.5194444 0.103164
+ 6.5197222 0.065391
+ 6.5200000 0.050000
+ 6.5202778 0.050000
+ 6.5205556 0.050000
+ 6.5208333 0.050000
+ 6.5211111 0.050000
+ 6.5213889 0.050000
+ 6.5216667 0.050000
+ 6.5219444 0.050000
+ 6.5222222 0.050000
+ 6.5225000 0.089540
+ 6.5227778 0.135830
+ 6.5230556 0.186458
+ 6.5233333 0.239011
+ 6.5236111 0.291078
+ 6.5238889 0.340248
+ 6.5241667 0.384108
+ 6.5244444 0.420246
+ 6.5247222 0.446252
+ 6.5250000 0.459712
+ 6.5252778 0.458959
+ 6.5255556 0.445294
+ 6.5258333 0.420762
+ 6.5261111 0.387409
+ 6.5263889 0.347279
+ 6.5266667 0.302417
+ 6.5269444 0.254869
+ 6.5272222 0.206679
+ 6.5275000 0.159893
+ 6.5277778 0.116554
+ 6.5280556 0.078437
+ 6.5283333 0.050000
+ 6.5286111 0.050000
+ 6.5288889 0.050000
+ 6.5291667 0.050000
+ 6.5294444 0.050000
+ 6.5297222 0.050000
+ 6.5300000 0.050000
+ 6.5302778 0.050000
+ 6.5305556 0.050000
+ 6.5308333 0.088807
+ 6.5311111 0.134712
+ 6.5313889 0.185233
+ 6.5316667 0.237888
+ 6.5319444 0.290196
+ 6.5322222 0.339676
+ 6.5325000 0.383845
+ 6.5327778 0.420222
+ 6.5330556 0.446325
+ 6.5333333 0.459673
+ 6.5336111 0.458549
+ 6.5338889 0.444291
+ 6.5341667 0.419003
+ 6.5344444 0.384790
+ 6.5347222 0.343754
+ 6.5350000 0.297998
+ 6.5352778 0.249628
+ 6.5355556 0.200745
+ 6.5358333 0.153455
+ 6.5361111 0.109859
+ 6.5363889 0.071773
+ 6.5366667 0.050000
+ 6.5369444 0.050000
+ 6.5372222 0.050000
+ 6.5375000 0.050000
+ 6.5377778 0.050000
+ 6.5380556 0.050000
+ 6.5383333 0.050000
+ 6.5386111 0.050000
+ 6.5388889 0.050000
+ 6.5391667 0.089447
+ 6.5394444 0.135850
+ 6.5397222 0.186728
+ 6.5400000 0.239600
+ 6.5402778 0.291982
+ 6.5405556 0.341394
+ 6.5408333 0.385354
+ 6.5411111 0.421379
+ 6.5413889 0.446988
+ 6.5416667 0.459699
+ 6.5419444 0.457802
+ 6.5422222 0.442674
+ 6.5425000 0.416464
+ 6.5427778 0.381319
+ 6.5430556 0.339389
+ 6.5433333 0.292823
+ 6.5436111 0.243769
+ 6.5438889 0.194375
+ 6.5441667 0.146791
+ 6.5444444 0.103164
+ 6.5447222 0.065337
+ 6.5450000 0.050000
+ 6.5452778 0.050000
+ 6.5455556 0.050000
+ 6.5458333 0.050000
+ 6.5461111 0.050000
+ 6.5463889 0.050000
+ 6.5466667 0.050000
+ 6.5469444 0.050000
+ 6.5472222 0.050000
+ 6.5475000 0.089556
+ 6.5477778 0.135856
+ 6.5480556 0.186489
+ 6.5483333 0.239044
+ 6.5486111 0.291110
+ 6.5488889 0.340275
+ 6.5491667 0.384127
+ 6.5494444 0.420256
+ 6.5497222 0.446251
+ 6.5500000 0.459699
+ 6.5502778 0.458933
+ 6.5505556 0.445256
+ 6.5508333 0.420714
+ 6.5511111 0.387352
+ 6.5513889 0.347217
+ 6.5516667 0.302355
+ 6.5519444 0.254812
+ 6.5522222 0.206633
+ 6.5525000 0.159865
+ 6.5527778 0.116554
+ 6.5530556 0.078473
+ 6.5533333 0.050000
+ 6.5536111 0.050000
+ 6.5538889 0.050000
+ 6.5541667 0.050000
+ 6.5544444 0.050000
+ 6.5547222 0.050000
+ 6.5550000 0.050000
+ 6.5552778 0.050000
+ 6.5555556 0.050000
+ 6.5558333 0.088681
+ 6.5561111 0.134439
+ 6.5563889 0.184811
+ 6.5566667 0.237334
+ 6.5569444 0.289544
+ 6.5572222 0.338978
+ 6.5575000 0.383171
+ 6.5577778 0.419660
+ 6.5580556 0.445982
+ 6.5583333 0.459673
+ 6.5586111 0.459026
+ 6.5588889 0.445361
+ 6.5591667 0.420754
+ 6.5594444 0.387282
+ 6.5597222 0.347021
+ 6.5600000 0.302047
+ 6.5602778 0.254437
+ 6.5605556 0.206267
+ 6.5608333 0.159614
+ 6.5611111 0.116554
+ 6.5613889 0.078879
+ 6.5616667 0.050000
+ 6.5619444 0.050000
+ 6.5622222 0.050000
+ 6.5625000 0.050000
+ 6.5627778 0.050000
+ 6.5630556 0.050000
+ 6.5633333 0.050000
+ 6.5636111 0.050000
+ 6.5638889 0.054979
+ 6.5641667 0.093552
+ 6.5644444 0.139011
+ 6.5647222 0.188933
+ 6.5650000 0.240893
+ 6.5652778 0.292468
+ 6.5655556 0.341236
+ 6.5658333 0.384771
+ 6.5661111 0.420651
+ 6.5663889 0.446453
+ 6.5666667 0.459752
+ 6.5669444 0.458869
+ 6.5672222 0.445105
+ 6.5675000 0.420504
+ 6.5677778 0.387109
+ 6.5680556 0.346965
+ 6.5683333 0.302117
+ 6.5686111 0.254607
+ 6.5688889 0.206480
+ 6.5691667 0.159782
+ 6.5694444 0.116554
+ 6.5697222 0.078568
+ 6.5700000 0.050000
+ 6.5702778 0.050000
+ 6.5705556 0.050000
+ 6.5708333 0.050000
+ 6.5711111 0.050000
+ 6.5713889 0.050000
+ 6.5716667 0.050000
+ 6.5719444 0.050000
+ 6.5722222 0.050000
+ 6.5725000 0.088401
+ 6.5727778 0.133839
+ 6.5730556 0.183889
+ 6.5733333 0.236128
+ 6.5736111 0.288131
+ 6.5738889 0.337474
+ 6.5741667 0.381733
+ 6.5744444 0.418484
+ 6.5747222 0.445303
+ 6.5750000 0.459765
+ 6.5752778 0.460181
+ 6.5755556 0.447803
+ 6.5758333 0.424618
+ 6.5761111 0.392612
+ 6.5763889 0.353772
+ 6.5766667 0.310085
+ 6.5769444 0.263537
+ 6.5772222 0.216115
+ 6.5775000 0.169806
+ 6.5777778 0.126597
+ 6.5780556 0.088222
+ 6.5783333 0.055407
+ 6.5786111 0.050000
+ 6.5788889 0.050000
+ 6.5791667 0.050000
+ 6.5794444 0.050000
+ 6.5797222 0.050000
+ 6.5800000 0.050000
+ 6.5802778 0.050000
+ 6.5805556 0.050000
+ 6.5808333 0.088083
+ 6.5811111 0.133490
+ 6.5813889 0.183715
+ 6.5816667 0.236253
+ 6.5819444 0.288597
+ 6.5822222 0.338241
+ 6.5825000 0.382679
+ 6.5827778 0.419406
+ 6.5830556 0.445914
+ 6.5833333 0.459699
+ 6.5836111 0.459021
+ 6.5838889 0.445208
+ 6.5841667 0.420354
+ 6.5844444 0.386555
+ 6.5847222 0.345904
+ 6.5850000 0.300498
+ 6.5852778 0.252430
+ 6.5855556 0.203796
+ 6.5858333 0.156690
+ 6.5861111 0.113207
+ 6.5863889 0.075155
+ 6.5866667 0.050000
+ 6.5869444 0.050000
+ 6.5872222 0.050000
+ 6.5875000 0.050000
+ 6.5877778 0.050000
+ 6.5880556 0.050000
+ 6.5883333 0.050000
+ 6.5886111 0.050000
+ 6.5888889 0.051631
+ 6.5891667 0.090831
+ 6.5894444 0.137004
+ 6.5897222 0.187669
+ 6.5900000 0.240346
+ 6.5902778 0.292553
+ 6.5905556 0.341809
+ 6.5908333 0.385634
+ 6.5911111 0.421547
+ 6.5913889 0.447067
+ 6.5916667 0.459712
+ 6.5919444 0.457773
+ 6.5922222 0.442624
+ 6.5925000 0.416408
+ 6.5927778 0.381270
+ 6.5930556 0.339354
+ 6.5933333 0.292805
+ 6.5936111 0.243767
+ 6.5938889 0.194385
+ 6.5941667 0.146803
+ 6.5944444 0.103164
+ 6.5947222 0.065309
+ 6.5950000 0.050000
+ 6.5952778 0.050000
+ 6.5955556 0.050000
+ 6.5958333 0.050000
+ 6.5961111 0.050000
+ 6.5963889 0.050000
+ 6.5966667 0.050000
+ 6.5969444 0.050000
+ 6.5972222 0.050000
+ 6.5975000 0.089706
+ 6.5977778 0.136182
+ 6.5980556 0.186995
+ 6.5983333 0.239711
+ 6.5986111 0.291898
+ 6.5988889 0.341121
+ 6.5991667 0.384947
+ 6.5994444 0.420943
+ 6.5997222 0.446676
+ 6.6000000 0.459712
+ 6.6002778 0.458372
+ 6.6005556 0.443988
+ 6.6008333 0.418650
+ 6.6011111 0.384443
+ 6.6013889 0.343455
+ 6.6016667 0.297773
+ 6.6019444 0.249486
+ 6.6022222 0.200679
+ 6.6025000 0.153442
+ 6.6027778 0.109859
+ 6.6030556 0.071736
+ 6.6033333 0.050000
+ 6.6036111 0.050000
+ 6.6038889 0.050000
+ 6.6041667 0.050000
+ 6.6044444 0.050000
+ 6.6047222 0.050000
+ 6.6050000 0.050000
+ 6.6052778 0.050000
+ 6.6055556 0.050000
+ 6.6058333 0.089799
+ 6.6061111 0.136620
+ 6.6063889 0.187928
+ 6.6066667 0.241185
+ 6.6069444 0.293858
+ 6.6072222 0.343410
+ 6.6075000 0.387305
+ 6.6077778 0.423009
+ 6.6080556 0.447986
+ 6.6083333 0.459699
+ 6.6086111 0.456415
+ 6.6088889 0.439597
+ 6.6091667 0.411513
+ 6.6094444 0.374427
+ 6.6097222 0.330606
+ 6.6100000 0.282316
+ 6.6102778 0.231822
+ 6.6105556 0.181389
+ 6.6108333 0.133285
+ 6.6111111 0.089774
+ 6.6113889 0.052776
+ 6.6116667 0.050000
+ 6.6119444 0.050000
+ 6.6122222 0.050000
+ 6.6125000 0.050000
+ 6.6127778 0.050000
+ 6.6130556 0.050000
+ 6.6133333 0.050000
+ 6.6136111 0.050000
+ 6.6138889 0.058261
+ 6.6141667 0.099356
+ 6.6144444 0.146697
+ 6.6147222 0.197861
+ 6.6150000 0.250428
+ 6.6152778 0.301978
+ 6.6155556 0.350090
+ 6.6158333 0.392343
+ 6.6161111 0.426316
+ 6.6163889 0.449588
+ 6.6166667 0.459738
+ 6.6169444 0.455123
+ 6.6172222 0.437201
+ 6.6175000 0.408209
+ 6.6177778 0.370381
+ 6.6180556 0.325955
+ 6.6183333 0.277164
+ 6.6186111 0.226246
+ 6.6188889 0.175435
+ 6.6191667 0.126968
+ 6.6194444 0.083079
+ 6.6197222 0.050000
+ 6.6200000 0.050000
+ 6.6202778 0.050000
+ 6.6205556 0.050000
+ 6.6208333 0.050000
+ 6.6211111 0.050000
+ 6.6213889 0.050000
+ 6.6216667 0.050000
+ 6.6219444 0.050000
+ 6.6222222 0.050000
+ 6.6225000 0.091745
+ 6.6227778 0.139914
+ 6.6230556 0.192035
+ 6.6233333 0.245634
+ 6.6236111 0.298238
+ 6.6238889 0.347374
+ 6.6241667 0.390569
+ 6.6244444 0.425350
+ 6.6247222 0.449244
+ 6.6250000 0.459778
+ 6.6252778 0.455271
+ 6.6255556 0.437220
+ 6.6258333 0.407911
+ 6.6261111 0.369632
+ 6.6263889 0.324672
+ 6.6266667 0.275319
+ 6.6269444 0.223860
+ 6.6272222 0.172584
+ 6.6275000 0.123779
+ 6.6277778 0.079732
+ 6.6280556 0.050000
+ 6.6283333 0.050000
+ 6.6286111 0.050000
+ 6.6288889 0.050000
+ 6.6291667 0.050000
+ 6.6294444 0.050000
+ 6.6297222 0.050000
+ 6.6300000 0.050000
+ 6.6302778 0.050000
+ 6.6305556 0.051461
+ 6.6308333 0.093524
+ 6.6311111 0.141878
+ 6.6313889 0.194061
+ 6.6316667 0.247612
+ 6.6319444 0.300068
+ 6.6322222 0.348967
+ 6.6325000 0.391847
+ 6.6327778 0.426246
+ 6.6330556 0.449702
+ 6.6333333 0.459752
+ 6.6336111 0.454729
+ 6.6338889 0.436147
+ 6.6341667 0.406315
+ 6.6344444 0.367541
+ 6.6347222 0.322133
+ 6.6350000 0.272400
+ 6.6352778 0.220650
+ 6.6355556 0.169192
+ 6.6358333 0.120334
+ 6.6361111 0.076384
+ 6.6363889 0.050000
+ 6.6366667 0.050000
+ 6.6369444 0.050000
+ 6.6372222 0.050000
+ 6.6375000 0.050000
+ 6.6377778 0.050000
+ 6.6380556 0.050000
+ 6.6383333 0.050000
+ 6.6386111 0.050000
+ 6.6388889 0.054809
+ 6.6391667 0.097635
+ 6.6394444 0.146651
+ 6.6397222 0.199342
+ 6.6400000 0.253193
+ 6.6402778 0.305687
+ 6.6405556 0.354309
+ 6.6408333 0.396544
+ 6.6411111 0.429875
+ 6.6413889 0.451787
+ 6.6416667 0.459765
+ 6.6419444 0.452122
+ 6.6422222 0.430496
+ 6.6425000 0.397352
+ 6.6427778 0.355156
+ 6.6430556 0.306374
+ 6.6433333 0.253473
+ 6.6436111 0.198919
+ 6.6438889 0.145178
+ 6.6441667 0.094716
+ 6.6444444 0.050000
+ 6.6447222 0.050000
+ 6.6450000 0.050000
+ 6.6452778 0.050000
+ 6.6455556 0.050000
+ 6.6458333 0.050000
+ 6.6461111 0.050000
+ 6.6463889 0.050000
+ 6.6466667 0.050000
+ 6.6469444 0.050000
+ 6.6472222 0.050000
+ 6.6475000 0.094671
+ 6.6477778 0.145073
+ 6.6480556 0.198750
+ 6.6483333 0.253244
+ 6.6486111 0.306096
+ 6.6488889 0.354850
+ 6.6491667 0.397048
+ 6.6494444 0.430231
+ 6.6497222 0.451943
+ 6.6500000 0.459725
+ 6.6502778 0.451940
+ 6.6505556 0.430225
+ 6.6508333 0.397038
+ 6.6511111 0.354839
+ 6.6513889 0.306083
+ 6.6516667 0.253230
+ 6.6519444 0.198738
+ 6.6522222 0.145063
+ 6.6525000 0.094665
+ 6.6527778 0.050000
+ 6.6530556 0.050000
+ 6.6533333 0.050000
+ 6.6536111 0.050000
+ 6.6538889 0.050000
+ 6.6541667 0.050000
+ 6.6544444 0.050000
+ 6.6547222 0.050000
+ 6.6550000 0.050000
+ 6.6552778 0.050000
+ 6.6555556 0.050000
+ 6.6558333 0.094688
+ 6.6561111 0.145117
+ 6.6563889 0.198824
+ 6.6566667 0.253346
+ 6.6569444 0.306221
+ 6.6572222 0.354986
+ 6.6575000 0.397179
+ 6.6577778 0.430338
+ 6.6580556 0.451998
+ 6.6583333 0.459699
+ 6.6586111 0.451800
+ 6.6588889 0.429953
+ 6.6591667 0.396633
+ 6.6594444 0.354314
+ 6.6597222 0.305471
+ 6.6600000 0.252577
+ 6.6602778 0.198109
+ 6.6605556 0.144541
+ 6.6608333 0.094346
+ 6.6611111 0.050000
+ 6.6613889 0.050000
+ 6.6616667 0.050000
+ 6.6619444 0.050000
+ 6.6622222 0.050000
+ 6.6625000 0.050000
+ 6.6627778 0.050000
+ 6.6630556 0.050000
+ 6.6633333 0.050000
+ 6.6636111 0.050000
+ 6.6638889 0.054652
+ 6.6641667 0.099216
+ 6.6644444 0.149346
+ 6.6647222 0.202616
+ 6.6650000 0.256602
+ 6.6652778 0.308879
+ 6.6655556 0.357020
+ 6.6658333 0.398602
+ 6.6661111 0.431199
+ 6.6663889 0.452386
+ 6.6666667 0.459738
+ 6.6669444 0.451642
+ 6.6672222 0.429727
+ 6.6675000 0.396435
+ 6.6677778 0.354210
+ 6.6680556 0.305493
+ 6.6683333 0.252726
+ 6.6686111 0.198351
+ 6.6688889 0.144811
+ 6.6691667 0.094546
+ 6.6694444 0.050000
+ 6.6697222 0.050000
+ 6.6700000 0.050000
+ 6.6702778 0.050000
+ 6.6705556 0.050000
+ 6.6708333 0.050000
+ 6.6711111 0.050000
+ 6.6713889 0.050000
+ 6.6716667 0.050000
+ 6.6719444 0.050000
+ 6.6722222 0.050000
+ 6.6725000 0.094637
+ 6.6727778 0.145017
+ 6.6730556 0.198682
+ 6.6733333 0.253172
+ 6.6736111 0.306028
+ 6.6738889 0.354790
+ 6.6741667 0.396999
+ 6.6744444 0.430195
+ 6.6747222 0.451919
+ 6.6750000 0.459712
+ 6.6752778 0.451934
+ 6.6755556 0.430224
+ 6.6758333 0.397039
+ 6.6761111 0.354840
+ 6.6763889 0.306083
+ 6.6766667 0.253229
+ 6.6769444 0.198735
+ 6.6772222 0.145060
+ 6.6775000 0.094662
+ 6.6777778 0.050000
+ 6.6780556 0.050000
+ 6.6783333 0.050000
+ 6.6786111 0.050000
+ 6.6788889 0.050000
+ 6.6791667 0.050000
+ 6.6794444 0.050000
+ 6.6797222 0.050000
+ 6.6800000 0.050000
+ 6.6802778 0.050000
+ 6.6805556 0.050000
+ 6.6808333 0.094665
+ 6.6811111 0.145066
+ 6.6813889 0.198744
+ 6.6816667 0.253240
+ 6.6819444 0.306096
+ 6.6822222 0.354851
+ 6.6825000 0.397047
+ 6.6827778 0.430224
+ 6.6830556 0.451924
+ 6.6833333 0.459686
+ 6.6836111 0.451873
+ 6.6838889 0.430125
+ 6.6841667 0.396906
+ 6.6844444 0.354678
+ 6.6847222 0.305903
+ 6.6850000 0.253042
+ 6.6852778 0.198560
+ 6.6855556 0.144917
+ 6.6858333 0.094576
+ 6.6861111 0.050000
+ 6.6863889 0.050000
+ 6.6866667 0.050000
+ 6.6869444 0.050000
+ 6.6872222 0.050000
+ 6.6875000 0.050000
+ 6.6877778 0.050000
+ 6.6880556 0.050000
+ 6.6883333 0.050000
+ 6.6886111 0.050000
+ 6.6888889 0.051317
+ 6.6891667 0.095992
+ 6.6894444 0.146361
+ 6.6897222 0.199970
+ 6.6900000 0.254364
+ 6.6902778 0.307089
+ 6.6905556 0.355690
+ 6.6908333 0.397711
+ 6.6911111 0.430698
+ 6.6913889 0.452197
+ 6.6916667 0.459752
+ 6.6919444 0.451730
+ 6.6922222 0.429784
+ 6.6925000 0.396391
+ 6.6927778 0.354024
+ 6.6930556 0.305160
+ 6.6933333 0.252273
+ 6.6936111 0.197838
+ 6.6938889 0.144331
+ 6.6941667 0.094226
+ 6.6944444 0.050000
+ 6.6947222 0.050000
+ 6.6950000 0.050000
+ 6.6952778 0.050000
+ 6.6955556 0.050000
+ 6.6958333 0.050000
+ 6.6961111 0.050000
+ 6.6963889 0.050000
+ 6.6966667 0.050000
+ 6.6969444 0.050000
+ 6.6972222 0.054717
+ 6.6975000 0.098826
+ 6.6977778 0.148429
+ 6.6980556 0.201165
+ 6.6983333 0.254675
+ 6.6986111 0.306598
+ 6.6988889 0.354573
+ 6.6991667 0.396240
+ 6.6994444 0.429239
+ 6.6997222 0.451209
+ 6.7000000 0.459791
+ 6.7002778 0.453406
+ 6.7005556 0.433610
+ 6.7008333 0.402741
+ 6.7011111 0.363138
+ 6.7013889 0.317138
+ 6.7016667 0.267081
+ 6.7019444 0.215303
+ 6.7022222 0.164145
+ 6.7025000 0.115943
+ 6.7027778 0.073037
+ 6.7030556 0.050000
+ 6.7033333 0.050000
+ 6.7036111 0.050000
+ 6.7038889 0.050000
+ 6.7041667 0.050000
+ 6.7044444 0.050000
+ 6.7047222 0.050000
+ 6.7050000 0.050000
+ 6.7052778 0.050000
+ 6.7055556 0.064864
+ 6.7058333 0.106784
+ 6.7061111 0.154324
+ 6.7063889 0.205174
+ 6.7066667 0.257025
+ 6.7069444 0.307568
+ 6.7072222 0.354492
+ 6.7075000 0.395487
+ 6.7077778 0.428244
+ 6.7080556 0.450453
+ 6.7083333 0.459804
+ 6.7086111 0.454746
+ 6.7088889 0.436761
+ 6.7091667 0.408092
+ 6.7094444 0.370978
+ 6.7097222 0.327661
+ 6.7100000 0.280382
+ 6.7102778 0.231382
+ 6.7105556 0.182903
+ 6.7108333 0.137185
+ 6.7111111 0.096469
+ 6.7113889 0.062629
+ 6.7116667 0.050000
+ 6.7119444 0.050000
+ 6.7122222 0.050000
+ 6.7125000 0.050000
+ 6.7127778 0.050000
+ 6.7130556 0.050000
+ 6.7133333 0.050000
+ 6.7136111 0.055856
+ 6.7138889 0.088401
+ 6.7141667 0.128084
+ 6.7144444 0.173074
+ 6.7147222 0.221170
+ 6.7150000 0.270170
+ 6.7152778 0.317875
+ 6.7155556 0.362082
+ 6.7158333 0.400590
+ 6.7161111 0.431198
+ 6.7163889 0.451704
+ 6.7166667 0.459908
+ 6.7169444 0.454334
+ 6.7172222 0.436408
+ 6.7175000 0.408281
+ 6.7177778 0.372105
+ 6.7180556 0.330031
+ 6.7183333 0.284212
+ 6.7186111 0.236799
+ 6.7188889 0.189944
+ 6.7191667 0.145797
+ 6.7194444 0.106512
+ 6.7197222 0.073883
+ 6.7200000 0.050000
+ 6.7202778 0.050000
+ 6.7205556 0.050000
+ 6.7208333 0.050000
+ 6.7211111 0.050000
+ 6.7213889 0.050000
+ 6.7216667 0.050000
+ 6.7219444 0.067273
+ 6.7222222 0.098496
+ 6.7225000 0.136548
+ 6.7227778 0.179703
+ 6.7230556 0.225890
+ 6.7233333 0.273034
+ 6.7236111 0.319064
+ 6.7238889 0.361905
+ 6.7241667 0.399486
+ 6.7244444 0.429733
+ 6.7247222 0.450574
+ 6.7250000 0.459935
+ 6.7252778 0.456410
+ 6.7255556 0.441263
+ 6.7258333 0.416424
+ 6.7261111 0.383822
+ 6.7263889 0.345388
+ 6.7266667 0.303053
+ 6.7269444 0.258745
+ 6.7272222 0.214396
+ 6.7275000 0.171935
+ 6.7277778 0.133292
+ 6.7280556 0.100115
+ 6.7283333 0.072919
+ 6.7286111 0.051936
+ 6.7288889 0.050000
+ 6.7291667 0.050000
+ 6.7294444 0.050000
+ 6.7297222 0.050000
+ 6.7300000 0.050000
+ 6.7302778 0.069541
+ 6.7305556 0.098562
+ 6.7308333 0.135244
+ 6.7311111 0.177765
+ 6.7313889 0.223889
+ 6.7316667 0.271381
+ 6.7319444 0.318007
+ 6.7322222 0.361532
+ 6.7325000 0.399721
+ 6.7327778 0.430339
+ 6.7330556 0.451151
+ 6.7333333 0.459922
+ 6.7336111 0.455143
+ 6.7338889 0.438211
+ 6.7341667 0.411248
+ 6.7344444 0.376376
+ 6.7347222 0.335717
+ 6.7350000 0.291394
+ 6.7352778 0.245529
+ 6.7355556 0.200244
+ 6.7358333 0.157660
+ 6.7361111 0.119902
+ 6.7363889 0.088734
+ 6.7366667 0.064500
+ 6.7369444 0.050000
+ 6.7372222 0.050000
+ 6.7375000 0.050000
+ 6.7377778 0.050000
+ 6.7380556 0.050000
+ 6.7383333 0.063945
+ 6.7386111 0.087870
+ 6.7388889 0.118620
+ 6.7391667 0.155846
+ 6.7394444 0.197839
+ 6.7397222 0.242554
+ 6.7400000 0.287946
+ 6.7402778 0.331971
+ 6.7405556 0.372582
+ 6.7408333 0.407734
+ 6.7411111 0.435383
+ 6.7413889 0.453482
+ 6.7416667 0.459987
+ 6.7419444 0.453531
+ 6.7422222 0.435466
+ 6.7425000 0.407820
+ 6.7427778 0.372624
+ 6.7430556 0.331907
+ 6.7433333 0.287700
+ 6.7436111 0.242031
+ 6.7438889 0.196930
+ 6.7441667 0.154428
+ 6.7444444 0.116554
+ 6.7447222 0.085008
+ 6.7450000 0.060167
+ 6.7452778 0.050000
+ 6.7455556 0.050000
+ 6.7458333 0.050000
+ 6.7461111 0.050000
+ 6.7463889 0.050000
+ 6.7466667 0.054596
+ 6.7469444 0.078025
+ 6.7472222 0.108539
+ 6.7475000 0.145832
+ 6.7477778 0.188184
+ 6.7480556 0.233518
+ 6.7483333 0.279758
+ 6.7486111 0.324829
+ 6.7488889 0.366655
+ 6.7491667 0.403161
+ 6.7494444 0.432271
+ 6.7497222 0.451909
+ 6.7500000 0.460000
+ 6.7502778 0.455145
+ 6.7505556 0.438657
+ 6.7508333 0.412523
+ 6.7511111 0.378733
+ 6.7513889 0.339276
+ 6.7516667 0.296141
+ 6.7519444 0.251316
+ 6.7522222 0.206792
+ 6.7525000 0.164555
+ 6.7527778 0.126597
+ 6.7530556 0.094594
+ 6.7533333 0.068978
+ 6.7536111 0.050000
+ 6.7538889 0.050000
+ 6.7541667 0.050000
+ 6.7544444 0.050000
+ 6.7547222 0.050000
+ 6.7550000 0.056212
+ 6.7552778 0.078704
+ 6.7555556 0.108552
+ 6.7558333 0.145500
+ 6.7561111 0.187777
+ 6.7563889 0.233234
+ 6.7566667 0.279722
+ 6.7569444 0.325092
+ 6.7572222 0.367194
+ 6.7575000 0.403880
+ 6.7577778 0.433000
+ 6.7580556 0.452406
+ 6.7583333 0.459948
+ 6.7586111 0.454180
+ 6.7588889 0.436469
+ 6.7591667 0.408884
+ 6.7594444 0.373496
+ 6.7597222 0.332375
+ 6.7600000 0.287590
+ 6.7602778 0.241210
+ 6.7605556 0.195307
+ 6.7608333 0.151949
+ 6.7611111 0.113207
+ 6.7613889 0.080817
+ 6.7616667 0.055183
+ 6.7619444 0.050000
+ 6.7622222 0.050000
+ 6.7625000 0.050000
+ 6.7627778 0.050000
+ 6.7630556 0.050000
+ 6.7633333 0.050000
+ 6.7636111 0.070885
+ 6.7638889 0.101857
+ 6.7641667 0.139854
+ 6.7644444 0.183096
+ 6.7647222 0.229435
+ 6.7650000 0.276721
+ 6.7652778 0.322803
+ 6.7655556 0.365534
+ 6.7658333 0.402764
+ 6.7661111 0.432342
+ 6.7663889 0.452120
+ 6.7666667 0.459948
+ 6.7669444 0.454378
+ 6.7672222 0.436770
+ 6.7675000 0.409185
+ 6.7677778 0.373684
+ 6.7680556 0.332328
+ 6.7683333 0.287178
+ 6.7686111 0.240295
+ 6.7688889 0.193740
+ 6.7691667 0.149575
+ 6.7694444 0.109859
+ 6.7697222 0.076333
+ 6.7700000 0.050000
+ 6.7702778 0.050000
+ 6.7705556 0.050000
+ 6.7708333 0.050000
+ 6.7711111 0.050000
+ 6.7713889 0.050000
+ 6.7716667 0.050000
+ 6.7719444 0.057654
+ 6.7722222 0.088401
+ 6.7725000 0.126536
+ 6.7727778 0.170263
+ 6.7730556 0.217403
+ 6.7733333 0.265777
+ 6.7736111 0.313205
+ 6.7738889 0.357509
+ 6.7741667 0.396510
+ 6.7744444 0.428027
+ 6.7747222 0.449882
+ 6.7750000 0.459895
+ 6.7752778 0.456586
+ 6.7755556 0.441259
+ 6.7758333 0.415922
+ 6.7761111 0.382576
+ 6.7763889 0.343228
+ 6.7766667 0.299881
+ 6.7769444 0.254540
+ 6.7772222 0.209209
+ 6.7775000 0.165894
+ 6.7777778 0.126597
+ 6.7780556 0.093023
+ 6.7783333 0.065675
+ 6.7786111 0.050000
+ 6.7788889 0.050000
+ 6.7791667 0.050000
+ 6.7794444 0.050000
+ 6.7797222 0.050000
+ 6.7800000 0.050000
+ 6.7802778 0.065439
+ 6.7805556 0.095136
+ 6.7808333 0.132461
+ 6.7811111 0.175580
+ 6.7813889 0.222249
+ 6.7816667 0.270225
+ 6.7819444 0.317264
+ 6.7822222 0.361123
+ 6.7825000 0.399559
+ 6.7827778 0.430328
+ 6.7830556 0.451188
+ 6.7833333 0.459895
+ 6.7836111 0.454931
+ 6.7838889 0.437676
+ 6.7841667 0.410237
+ 6.7844444 0.374718
+ 6.7847222 0.333225
+ 6.7850000 0.287865
+ 6.7852778 0.240743
+ 6.7855556 0.193964
+ 6.7858333 0.149634
+ 6.7861111 0.109859
+ 6.7863889 0.076411
+ 6.7866667 0.050000
+ 6.7869444 0.050000
+ 6.7872222 0.050000
+ 6.7875000 0.050000
+ 6.7877778 0.050000
+ 6.7880556 0.050000
+ 6.7883333 0.050000
+ 6.7886111 0.060730
+ 6.7888889 0.091775
+ 6.7891667 0.130110
+ 6.7894444 0.173932
+ 6.7897222 0.221057
+ 6.7900000 0.269300
+ 6.7902778 0.316476
+ 6.7905556 0.360402
+ 6.7908333 0.398892
+ 6.7911111 0.429763
+ 6.7913889 0.450830
+ 6.7916667 0.459908
+ 6.7919444 0.455516
+ 6.7922222 0.438982
+ 6.7925000 0.412335
+ 6.7927778 0.377606
+ 6.7930556 0.336825
+ 6.7933333 0.292023
+ 6.7936111 0.245230
+ 6.7938889 0.198476
+ 6.7941667 0.153792
+ 6.7944444 0.113207
+ 6.7947222 0.078451
+ 6.7950000 0.050049
+ 6.7952778 0.050000
+ 6.7955556 0.050000
+ 6.7958333 0.050000
+ 6.7961111 0.050000
+ 6.7963889 0.050000
+ 6.7966667 0.050000
+ 6.7969444 0.050000
+ 6.7972222 0.078385
+ 6.7975000 0.116804
+ 6.7977778 0.161289
+ 6.7980556 0.209545
+ 6.7983333 0.259272
+ 6.7986111 0.308172
+ 6.7988889 0.353949
+ 6.7991667 0.394304
+ 6.7994444 0.426938
+ 6.7997222 0.449555
+ 6.8000000 0.459856
+ 6.8002778 0.456277
+ 6.8005556 0.440186
+ 6.8008333 0.413684
+ 6.8011111 0.378874
+ 6.8013889 0.337856
+ 6.8016667 0.292732
+ 6.8019444 0.245603
+ 6.8022222 0.198572
+ 6.8025000 0.153739
+ 6.8027778 0.113207
+ 6.8030556 0.078755
+ 6.8033333 0.050875
+ 6.8036111 0.050000
+ 6.8038889 0.050000
+ 6.8041667 0.050000
+ 6.8044444 0.050000
+ 6.8047222 0.050000
+ 6.8050000 0.050000
+ 6.8052778 0.054184
+ 6.8055556 0.085067
+ 6.8058333 0.123659
+ 6.8061111 0.168086
+ 6.8063889 0.216069
+ 6.8066667 0.265325
+ 6.8069444 0.313573
+ 6.8072222 0.358532
+ 6.8075000 0.397922
+ 6.8077778 0.429460
+ 6.8080556 0.450865
+ 6.8083333 0.459856
+ 6.8086111 0.454890
+ 6.8088889 0.437376
+ 6.8091667 0.409461
+ 6.8094444 0.373292
+ 6.8097222 0.331015
+ 6.8100000 0.284778
+ 6.8102778 0.236727
+ 6.8105556 0.189010
+ 6.8108333 0.143774
+ 6.8111111 0.103164
+ 6.8113889 0.068991
+ 6.8116667 0.050000
+ 6.8119444 0.050000
+ 6.8122222 0.050000
+ 6.8125000 0.050000
+ 6.8127778 0.050000
+ 6.8130556 0.050000
+ 6.8133333 0.050000
+ 6.8136111 0.053165
+ 6.8138889 0.085093
+ 6.8141667 0.124537
+ 6.8144444 0.169619
+ 6.8147222 0.218060
+ 6.8150000 0.267583
+ 6.8152778 0.315910
+ 6.8155556 0.360764
+ 6.8158333 0.399867
+ 6.8161111 0.430942
+ 6.8163889 0.451711
+ 6.8166667 0.459895
+ 6.8169444 0.453963
+ 6.8172222 0.435360
+ 6.8175000 0.406274
+ 6.8177778 0.368896
+ 6.8180556 0.325416
+ 6.8183333 0.278024
+ 6.8186111 0.228908
+ 6.8188889 0.180260
+ 6.8191667 0.134268
+ 6.8194444 0.093122
+ 6.8197222 0.058661
+ 6.8200000 0.050000
+ 6.8202778 0.050000
+ 6.8205556 0.050000
+ 6.8208333 0.050000
+ 6.8211111 0.050000
+ 6.8213889 0.050000
+ 6.8216667 0.050000
+ 6.8219444 0.050000
+ 6.8222222 0.078307
+ 6.8225000 0.118210
+ 6.8227778 0.163704
+ 6.8230556 0.212548
+ 6.8233333 0.262498
+ 6.8236111 0.311313
+ 6.8238889 0.356749
+ 6.8241667 0.396564
+ 6.8244444 0.428515
+ 6.8247222 0.450360
+ 6.8250000 0.459856
+ 6.8252778 0.455482
+ 6.8255556 0.438600
+ 6.8258333 0.411291
+ 6.8261111 0.375640
+ 6.8263889 0.333728
+ 6.8266667 0.287640
+ 6.8269444 0.239456
+ 6.8272222 0.191260
+ 6.8275000 0.145136
+ 6.8277778 0.103164
+ 6.8280556 0.067125
+ 6.8283333 0.050000
+ 6.8286111 0.050000
+ 6.8288889 0.050000
+ 6.8291667 0.050000
+ 6.8294444 0.050000
+ 6.8297222 0.050000
+ 6.8300000 0.050000
+ 6.8302778 0.050000
+ 6.8305556 0.064943
+ 6.8308333 0.104671
+ 6.8311111 0.150751
+ 6.8313889 0.200781
+ 6.8316667 0.252358
+ 6.8319444 0.303079
+ 6.8322222 0.350543
+ 6.8325000 0.392347
+ 6.8327778 0.426089
+ 6.8330556 0.449367
+ 6.8333333 0.459778
+ 6.8336111 0.455688
+ 6.8338889 0.438540
+ 6.8341667 0.410543
+ 6.8344444 0.373908
+ 6.8347222 0.330845
+ 6.8350000 0.283565
+ 6.8352778 0.234277
+ 6.8355556 0.185191
+ 6.8358333 0.138519
+ 6.8361111 0.096469
+ 6.8363889 0.060909
+ 6.8366667 0.050000
+ 6.8369444 0.050000
+ 6.8372222 0.050000
+ 6.8375000 0.050000
+ 6.8377778 0.050000
+ 6.8380556 0.050000
+ 6.8383333 0.050000
+ 6.8386111 0.050000
+ 6.8388889 0.071651
+ 6.8391667 0.111773
+ 6.8394444 0.157813
+ 6.8397222 0.207442
+ 6.8400000 0.258332
+ 6.8402778 0.308158
+ 6.8405556 0.354590
+ 6.8408333 0.395303
+ 6.8411111 0.427967
+ 6.8413889 0.450256
+ 6.8416667 0.459843
+ 6.8419444 0.455151
+ 6.8422222 0.437611
+ 6.8425000 0.409402
+ 6.8427778 0.372707
+ 6.8430556 0.329707
+ 6.8433333 0.282583
+ 6.8436111 0.233516
+ 6.8438889 0.184687
+ 6.8441667 0.138278
+ 6.8444444 0.096469
+ 6.8447222 0.061103
+ 6.8450000 0.050000
+ 6.8452778 0.050000
+ 6.8455556 0.050000
+ 6.8458333 0.050000
+ 6.8461111 0.050000
+ 6.8463889 0.050000
+ 6.8466667 0.050000
+ 6.8469444 0.050000
+ 6.8472222 0.071599
+ 6.8475000 0.111513
+ 6.8477778 0.157334
+ 6.8480556 0.206756
+ 6.8483333 0.257474
+ 6.8486111 0.307180
+ 6.8488889 0.353570
+ 6.8491667 0.394337
+ 6.8494444 0.427175
+ 6.8497222 0.449779
+ 6.8500000 0.459843
+ 6.8502778 0.455800
+ 6.8505556 0.439043
+ 6.8508333 0.411705
+ 6.8511111 0.375917
+ 6.8513889 0.333812
+ 6.8516667 0.287522
+ 6.8519444 0.239180
+ 6.8522222 0.190919
+ 6.8525000 0.144869
+ 6.8527778 0.103164
+ 6.8530556 0.067614
+ 6.8533333 0.050000
+ 6.8536111 0.050000
+ 6.8538889 0.050000
+ 6.8541667 0.050000
+ 6.8544444 0.050000
+ 6.8547222 0.050000
+ 6.8550000 0.050000
+ 6.8552778 0.050000
+ 6.8555556 0.071612
+ 6.8558333 0.111235
+ 6.8561111 0.156951
+ 6.8563889 0.206409
+ 6.8566667 0.257255
+ 6.8569444 0.307138
+ 6.8572222 0.353706
+ 6.8575000 0.394606
+ 6.8577778 0.427486
+ 6.8580556 0.449994
+ 6.8583333 0.459778
+ 6.8586111 0.455241
+ 6.8588889 0.437812
+ 6.8591667 0.409676
+ 6.8594444 0.373018
+ 6.8597222 0.330024
+ 6.8600000 0.282877
+ 6.8602778 0.233763
+ 6.8605556 0.184868
+ 6.8608333 0.138375
+ 6.8611111 0.096469
+ 6.8613889 0.060998
+ 6.8616667 0.050000
+ 6.8619444 0.050000
+ 6.8622222 0.050000
+ 6.8625000 0.050000
+ 6.8627778 0.050000
+ 6.8630556 0.050000
+ 6.8633333 0.050000
+ 6.8636111 0.050000
+ 6.8638889 0.071638
+ 6.8641667 0.111847
+ 6.8644444 0.158005
+ 6.8647222 0.207764
+ 6.8650000 0.258778
+ 6.8652778 0.308700
+ 6.8655556 0.355185
+ 6.8658333 0.395886
+ 6.8661111 0.428456
+ 6.8663889 0.450548
+ 6.8666667 0.459817
+ 6.8669444 0.454674
+ 6.8672222 0.436568
+ 6.8675000 0.407703
+ 6.8677778 0.370288
+ 6.8680556 0.326528
+ 6.8683333 0.278629
+ 6.8686111 0.228798
+ 6.8688889 0.179241
+ 6.8691667 0.132164
+ 6.8694444 0.089774
+ 6.8697222 0.053934
+ 6.8700000 0.050000
+ 6.8702778 0.050000
+ 6.8705556 0.050000
+ 6.8708333 0.050000
+ 6.8711111 0.050000
+ 6.8713889 0.050000
+ 6.8716667 0.050000
+ 6.8719444 0.050000
+ 6.8722222 0.064890
+ 6.8725000 0.105348
+ 6.8727778 0.151789
+ 6.8730556 0.201889
+ 6.8733333 0.253324
+ 6.8736111 0.303770
+ 6.8738889 0.350904
+ 6.8741667 0.392401
+ 6.8744444 0.425937
+ 6.8747222 0.449188
+ 6.8750000 0.459830
+ 6.8752778 0.456281
+ 6.8755556 0.439925
+ 6.8758333 0.412889
+ 6.8761111 0.377298
+ 6.8763889 0.335278
+ 6.8766667 0.288956
+ 6.8769444 0.240458
+ 6.8772222 0.191909
+ 6.8775000 0.145436
+ 6.8777778 0.103164
+ 6.8780556 0.066907
+ 6.8783333 0.050000
+ 6.8786111 0.050000
+ 6.8788889 0.050000
+ 6.8791667 0.050000
+ 6.8794444 0.050000
+ 6.8797222 0.050000
+ 6.8800000 0.050000
+ 6.8802778 0.050000
+ 6.8805556 0.064943
+ 6.8808333 0.104725
+ 6.8811111 0.150836
+ 6.8813889 0.200879
+ 6.8816667 0.252454
+ 6.8819444 0.303163
+ 6.8822222 0.350608
+ 6.8825000 0.392391
+ 6.8827778 0.426112
+ 6.8830556 0.449374
+ 6.8833333 0.459778
+ 6.8836111 0.455692
+ 6.8838889 0.438557
+ 6.8841667 0.410579
+ 6.8844444 0.373964
+ 6.8847222 0.330918
+ 6.8850000 0.283649
+ 6.8852778 0.234363
+ 6.8855556 0.185267
+ 6.8858333 0.138567
+ 6.8861111 0.096469
+ 6.8863889 0.060839
+ 6.8866667 0.050000
+ 6.8869444 0.050000
+ 6.8872222 0.050000
+ 6.8875000 0.050000
+ 6.8877778 0.050000
+ 6.8880556 0.050000
+ 6.8883333 0.050000
+ 6.8886111 0.050000
+ 6.8888889 0.071625
+ 6.8891667 0.112015
+ 6.8894444 0.158366
+ 6.8897222 0.208311
+ 6.8900000 0.259486
+ 6.8902778 0.309523
+ 6.8905556 0.356058
+ 6.8908333 0.396723
+ 6.8911111 0.429153
+ 6.8913889 0.450982
+ 6.8916667 0.459843
+ 6.8919444 0.454143
+ 6.8922222 0.435374
+ 6.8925000 0.405800
+ 6.8927778 0.367685
+ 6.8930556 0.323293
+ 6.8933333 0.274888
+ 6.8936111 0.224735
+ 6.8938889 0.175098
+ 6.8941667 0.128241
+ 6.8944444 0.086427
+ 6.8947222 0.051552
+ 6.8950000 0.050000
+ 6.8952778 0.050000
+ 6.8955556 0.050000
+ 6.8958333 0.050000
+ 6.8961111 0.050000
+ 6.8963889 0.050000
+ 6.8966667 0.050000
+ 6.8969444 0.050000
+ 6.8972222 0.074946
+ 6.8975000 0.115568
+ 6.8977778 0.161745
+ 6.8980556 0.211218
+ 6.8983333 0.261724
+ 6.8986111 0.311003
+ 6.8988889 0.356793
+ 6.8991667 0.396833
+ 6.8994444 0.428863
+ 6.8997222 0.450620
+ 6.9000000 0.459843
+ 6.9002778 0.455006
+ 6.9005556 0.437521
+ 6.9008333 0.409533
+ 6.9011111 0.373189
+ 6.9013889 0.330635
+ 6.9016667 0.284016
+ 6.9019444 0.235478
+ 6.9022222 0.187169
+ 6.9025000 0.141233
+ 6.9027778 0.099817
+ 6.9030556 0.064736
+ 6.9033333 0.050000
+ 6.9036111 0.050000
+ 6.9038889 0.050000
+ 6.9041667 0.050000
+ 6.9044444 0.050000
+ 6.9047222 0.050000
+ 6.9050000 0.050000
+ 6.9052778 0.050000
+ 6.9055556 0.074985
+ 6.9058333 0.114820
+ 6.9061111 0.160568
+ 6.9063889 0.209899
+ 6.9066667 0.260482
+ 6.9069444 0.309988
+ 6.9072222 0.356088
+ 6.9075000 0.396450
+ 6.9077778 0.428746
+ 6.9080556 0.450645
+ 6.9083333 0.459817
+ 6.9086111 0.454690
+ 6.9088889 0.436722
+ 6.9091667 0.408127
+ 6.9094444 0.371120
+ 6.9097222 0.327916
+ 6.9100000 0.280731
+ 6.9102778 0.231778
+ 6.9105556 0.183274
+ 6.9108333 0.137433
+ 6.9111111 0.096469
+ 6.9113889 0.062242
+ 6.9116667 0.050000
+ 6.9119444 0.050000
+ 6.9122222 0.050000
+ 6.9125000 0.050000
+ 6.9127778 0.050000
+ 6.9130556 0.050000
+ 6.9133333 0.050000
+ 6.9136111 0.052250
+ 6.9138889 0.085041
+ 6.9141667 0.125238
+ 6.9144444 0.170944
+ 6.9147222 0.219866
+ 6.9150000 0.269713
+ 6.9152778 0.318194
+ 6.9155556 0.363015
+ 6.9158333 0.401887
+ 6.9161111 0.432516
+ 6.9163889 0.452612
+ 6.9166667 0.459882
+ 6.9169444 0.452802
+ 6.9172222 0.432913
+ 6.9175000 0.402525
+ 6.9177778 0.363947
+ 6.9180556 0.319486
+ 6.9183333 0.271454
+ 6.9186111 0.222157
+ 6.9188889 0.173906
+ 6.9191667 0.129009
+ 6.9194444 0.089774
+ 6.9197222 0.058104
+ 6.9200000 0.050000
+ 6.9202778 0.050000
+ 6.9205556 0.050000
+ 6.9208333 0.050000
+ 6.9211111 0.050000
+ 6.9213889 0.050000
+ 6.9216667 0.050000
+ 6.9219444 0.074703
+ 6.9222222 0.108395
+ 6.9225000 0.148317
+ 6.9227778 0.192717
+ 6.9230556 0.239518
+ 6.9233333 0.286644
+ 6.9236111 0.332020
+ 6.9238889 0.373570
+ 6.9241667 0.409217
+ 6.9244444 0.436886
+ 6.9247222 0.454502
+ 6.9250000 0.459987
+ 6.9252778 0.451975
+ 6.9255556 0.431935
+ 6.9258333 0.402043
+ 6.9261111 0.364477
+ 6.9263889 0.321412
+ 6.9266667 0.275027
+ 6.9269444 0.227498
+ 6.9272222 0.181002
+ 6.9275000 0.137716
+ 6.9277778 0.099817
+ 6.9280556 0.069101
+ 6.9283333 0.050000
+ 6.9286111 0.050000
+ 6.9288889 0.050000
+ 6.9291667 0.050000
+ 6.9294444 0.050000
+ 6.9297222 0.050000
+ 6.9300000 0.056766
+ 6.9302778 0.082654
+ 6.9305556 0.115129
+ 6.9308333 0.153764
+ 6.9311111 0.196860
+ 6.9313889 0.242396
+ 6.9316667 0.288356
+ 6.9319444 0.332721
+ 6.9322222 0.373472
+ 6.9325000 0.408591
+ 6.9327778 0.436060
+ 6.9330556 0.453861
+ 6.9333333 0.459974
+ 6.9336111 0.453064
+ 6.9338889 0.434524
+ 6.9341667 0.406429
+ 6.9344444 0.370854
+ 6.9347222 0.329875
+ 6.9350000 0.285568
+ 6.9352778 0.240007
+ 6.9355556 0.195267
+ 6.9358333 0.153425
+ 6.9361111 0.116554
+ 6.9363889 0.086379
+ 6.9366667 0.063211
+ 6.9369444 0.050000
+ 6.9372222 0.050000
+ 6.9375000 0.050000
+ 6.9377778 0.050000
+ 6.9380556 0.051065
+ 6.9383333 0.069091
+ 6.9386111 0.093842
+ 6.9388889 0.125276
+ 6.9391667 0.163016
+ 6.9394444 0.205328
+ 6.9397222 0.250144
+ 6.9400000 0.295393
+ 6.9402778 0.339006
+ 6.9405556 0.378911
+ 6.9408333 0.413040
+ 6.9411111 0.439322
+ 6.9413889 0.455687
+ 6.9416667 0.460065
+ 6.9419444 0.451097
+ 6.9422222 0.430266
+ 6.9425000 0.399766
+ 6.9427778 0.361791
+ 6.9430556 0.318534
+ 6.9433333 0.272190
+ 6.9436111 0.224953
+ 6.9438889 0.179015
+ 6.9441667 0.136572
+ 6.9444444 0.099817
+ 6.9447222 0.070545
+ 6.9450000 0.050000
+ 6.9452778 0.050000
+ 6.9455556 0.050000
+ 6.9458333 0.050000
+ 6.9461111 0.050000
+ 6.9463889 0.050000
+ 6.9466667 0.069426
+ 6.9469444 0.095964
+ 6.9472222 0.128571
+ 6.9475000 0.166764
+ 6.9477778 0.208920
+ 6.9480556 0.253132
+ 6.9483333 0.297495
+ 6.9486111 0.340101
+ 6.9488889 0.379046
+ 6.9491667 0.412422
+ 6.9494444 0.438324
+ 6.9497222 0.454845
+ 6.9500000 0.460078
+ 6.9502778 0.452770
+ 6.9505556 0.434268
+ 6.9508333 0.406572
+ 6.9511111 0.371682
+ 6.9513889 0.331597
+ 6.9516667 0.288318
+ 6.9519444 0.243844
+ 6.9522222 0.200175
+ 6.9525000 0.159310
+ 6.9527778 0.123249
+ 6.9530556 0.093655
+ 6.9533333 0.070835
+ 6.9536111 0.054760
+ 6.9538889 0.050000
+ 6.9541667 0.050000
+ 6.9544444 0.050000
+ 6.9547222 0.057318
+ 6.9550000 0.074524
+ 6.9552778 0.098298
+ 6.9555556 0.128611
+ 6.9558333 0.165107
+ 6.9561111 0.206133
+ 6.9563889 0.249711
+ 6.9566667 0.293864
+ 6.9569444 0.336611
+ 6.9572222 0.375976
+ 6.9575000 0.409979
+ 6.9577778 0.436643
+ 6.9580556 0.453989
+ 6.9583333 0.460039
+ 6.9586111 0.453481
+ 6.9588889 0.435665
+ 6.9591667 0.408610
+ 6.9594444 0.374332
+ 6.9597222 0.334848
+ 6.9600000 0.292175
+ 6.9602778 0.248331
+ 6.9605556 0.205334
+ 6.9608333 0.165199
+ 6.9611111 0.129944
+ 6.9613889 0.101240
+ 6.9616667 0.079365
+ 6.9619444 0.064251
+ 6.9622222 0.055831
+ 6.9625000 0.054036
+ 6.9627778 0.058799
+ 6.9630556 0.070051
+ 6.9633333 0.087725
+ 6.9636111 0.111753
+ 6.9638889 0.142066
+ 6.9641667 0.178281
+ 6.9644444 0.218750
+ 6.9647222 0.261511
+ 6.9650000 0.304599
+ 6.9652778 0.346053
+ 6.9655556 0.383908
+ 6.9658333 0.416201
+ 6.9661111 0.440969
+ 6.9663889 0.456249
+ 6.9666667 0.460078
+ 6.9669444 0.451166
+ 6.9672222 0.430915
+ 6.9675000 0.401402
+ 6.9677778 0.364703
+ 6.9680556 0.322894
+ 6.9683333 0.278050
+ 6.9686111 0.232249
+ 6.9688889 0.187566
+ 6.9691667 0.146078
+ 6.9694444 0.109859
+ 6.9697222 0.080622
+ 6.9700000 0.058613
+ 6.9702778 0.050000
+ 6.9705556 0.050000
+ 6.9708333 0.050000
+ 6.9711111 0.050000
+ 6.9713889 0.052849
+ 6.9716667 0.071725
+ 6.9719444 0.097001
+ 6.9722222 0.128558
+ 6.9725000 0.165976
+ 6.9727778 0.207617
+ 6.9730556 0.251544
+ 6.9733333 0.295817
+ 6.9736111 0.338496
+ 6.9738889 0.377642
+ 6.9741667 0.411317
+ 6.9744444 0.437580
+ 6.9747222 0.454494
+ 6.9750000 0.460118
+ 6.9752778 0.453161
+ 6.9755556 0.434922
+ 6.9758333 0.407350
+ 6.9761111 0.372390
+ 6.9763889 0.331991
+ 6.9766667 0.288099
+ 6.9769444 0.242663
+ 6.9772222 0.197628
+ 6.9775000 0.154943
+ 6.9777778 0.116554
+ 6.9780556 0.084111
+ 6.9783333 0.058065
+ 6.9786111 0.050000
+ 6.9788889 0.050000
+ 6.9791667 0.050000
+ 6.9794444 0.050000
+ 6.9797222 0.050000
+ 6.9800000 0.050000
+ 6.9802778 0.067788
+ 6.9805556 0.098457
+ 6.9808333 0.136508
+ 6.9811111 0.180102
+ 6.9813889 0.227002
+ 6.9816667 0.274969
+ 6.9819444 0.321765
+ 6.9822222 0.365154
+ 6.9825000 0.402896
+ 6.9827778 0.432755
+ 6.9830556 0.452492
+ 6.9833333 0.459869
+ 6.9836111 0.453377
+ 6.9838889 0.434420
+ 6.9841667 0.405128
+ 6.9844444 0.367633
+ 6.9847222 0.324067
+ 6.9850000 0.276562
+ 6.9852778 0.227248
+ 6.9855556 0.178258
+ 6.9858333 0.131723
+ 6.9861111 0.089774
+ 6.9863889 0.054217
+ 6.9866667 0.050000
+ 6.9869444 0.050000
+ 6.9872222 0.050000
+ 6.9875000 0.050000
+ 6.9877778 0.050000
+ 6.9880556 0.050000
+ 6.9883333 0.050000
+ 6.9886111 0.050000
+ 6.9888889 0.064943
+ 6.9891667 0.105617
+ 6.9894444 0.152358
+ 6.9897222 0.202791
+ 6.9900000 0.254542
+ 6.9902778 0.305237
+ 6.9905556 0.352501
+ 6.9908333 0.393960
+ 6.9911111 0.427240
+ 6.9913889 0.449966
+ 6.9916667 0.459765
+ 6.9919444 0.455023
+ 6.9922222 0.437177
+ 6.9925000 0.408425
+ 6.9927778 0.370965
+ 6.9930556 0.326995
+ 6.9933333 0.278713
+ 6.9936111 0.228317
+ 6.9938889 0.178006
+ 6.9941667 0.129976
+ 6.9944444 0.086427
+ 6.9947222 0.050000
+ 6.9950000 0.050000
+ 6.9952778 0.050000
+ 6.9955556 0.050000
+ 6.9958333 0.050000
+ 6.9961111 0.050000
+ 6.9963889 0.050000
+ 6.9966667 0.050000
+ 6.9969444 0.050000
+ 6.9972222 0.051514
+ 6.9975000 0.092839
+ 6.9977778 0.140603
+ 6.9980556 0.192350
+ 6.9983333 0.245623
+ 6.9986111 0.297967
+ 6.9988889 0.346926
+ 6.9991667 0.390044
+ 6.9994444 0.424865
+ 6.9997222 0.448932
+ 7.0000000 0.459791
+ 7.0002778 0.455769
+ 7.0005556 0.438336
+ 7.0008333 0.409744
+ 7.0011111 0.372247
+ 7.0013889 0.328098
+ 7.0016667 0.279549
+ 7.0019444 0.228854
+ 7.0022222 0.178267
+ 7.0025000 0.130040
+ 7.0027778 0.086427
+ 7.0030556 0.050000
+ 7.0033333 0.050000
+ 7.0036111 0.050000
+ 7.0038889 0.050000
+ 7.0041667 0.050000
+ 7.0044444 0.050000
+ 7.0047222 0.050000
+ 7.0050000 0.050000
+ 7.0052778 0.050000
+ 7.0055556 0.054835
+ 7.0058333 0.096083
+ 7.0061111 0.143616
+ 7.0063889 0.195014
+ 7.0066667 0.247856
+ 7.0069444 0.299723
+ 7.0072222 0.348195
+ 7.0075000 0.390853
+ 7.0077778 0.425276
+ 7.0080556 0.449044
+ 7.0083333 0.459738
+ 7.0086111 0.455713
+ 7.0088889 0.438421
+ 7.0091667 0.410090
+ 7.0094444 0.372947
+ 7.0097222 0.329220
+ 7.0100000 0.281135
+ 7.0102778 0.230921
+ 7.0105556 0.180805
+ 7.0108333 0.133013
+ 7.0111111 0.089774
+ 7.0113889 0.052976
+ 7.0116667 0.050000
+ 7.0119444 0.050000
+ 7.0122222 0.050000
+ 7.0125000 0.050000
+ 7.0127778 0.050000
+ 7.0130556 0.050000
+ 7.0133333 0.050000
+ 7.0136111 0.050000
+ 7.0138889 0.058195
+ 7.0141667 0.099198
+ 7.0144444 0.146461
+ 7.0147222 0.197565
+ 7.0150000 0.250093
+ 7.0152778 0.301627
+ 7.0155556 0.349750
+ 7.0158333 0.392043
+ 7.0161111 0.426088
+ 7.0163889 0.449468
+ 7.0166667 0.459765
+ 7.0169444 0.455336
+ 7.0172222 0.437639
+ 7.0175000 0.408908
+ 7.0177778 0.371375
+ 7.0180556 0.327275
+ 7.0183333 0.278841
+ 7.0186111 0.228306
+ 7.0188889 0.177903
+ 7.0191667 0.129865
+ 7.0194444 0.086427
+ 7.0197222 0.050000
+ 7.0200000 0.050000
+ 7.0202778 0.050000
+ 7.0205556 0.050000
+ 7.0208333 0.050000
+ 7.0211111 0.050000
+ 7.0213889 0.050000
+ 7.0216667 0.050000
+ 7.0219444 0.050000
+ 7.0222222 0.054809
+ 7.0225000 0.095888
+ 7.0227778 0.143241
+ 7.0230556 0.194466
+ 7.0233333 0.247163
+ 7.0236111 0.298929
+ 7.0238889 0.347364
+ 7.0241667 0.390067
+ 7.0244444 0.424635
+ 7.0247222 0.448668
+ 7.0250000 0.459765
+ 7.0252778 0.456285
+ 7.0255556 0.439640
+ 7.0258333 0.412001
+ 7.0261111 0.375539
+ 7.0263889 0.332427
+ 7.0266667 0.284836
+ 7.0269444 0.234938
+ 7.0272222 0.184905
+ 7.0275000 0.136909
+ 7.0277778 0.093122
+ 7.0280556 0.055402
+ 7.0283333 0.050000
+ 7.0286111 0.050000
+ 7.0288889 0.050000
+ 7.0291667 0.050000
+ 7.0294444 0.050000
+ 7.0297222 0.050000
+ 7.0300000 0.050000
+ 7.0302778 0.050000
+ 7.0305556 0.051514
+ 7.0308333 0.093273
+ 7.0311111 0.141753
+ 7.0313889 0.194354
+ 7.0316667 0.248478
+ 7.0319444 0.301528
+ 7.0322222 0.350904
+ 7.0325000 0.394009
+ 7.0327778 0.428244
+ 7.0330556 0.451011
+ 7.0333333 0.459712
+ 7.0336111 0.452597
+ 7.0338889 0.431311
+ 7.0341667 0.398345
+ 7.0344444 0.356195
+ 7.0347222 0.307351
+ 7.0350000 0.254308
+ 7.0352778 0.199559
+ 7.0355556 0.145596
+ 7.0358333 0.094912
+ 7.0361111 0.050000
+ 7.0363889 0.050000
+ 7.0366667 0.050000
+ 7.0369444 0.050000
+ 7.0372222 0.050000
+ 7.0375000 0.050000
+ 7.0377778 0.050000
+ 7.0380556 0.050000
+ 7.0383333 0.050000
+ 7.0386111 0.050000
+ 7.0388889 0.050000
+ 7.0391667 0.094745
+ 7.0394444 0.145214
+ 7.0397222 0.198943
+ 7.0400000 0.253471
+ 7.0402778 0.306334
+ 7.0405556 0.355070
+ 7.0408333 0.397216
+ 7.0411111 0.430310
+ 7.0413889 0.451889
+ 7.0416667 0.459490
+ 7.0419444 0.451476
+ 7.0422222 0.429509
+ 7.0425000 0.396078
+ 7.0427778 0.353669
+ 7.0430556 0.304770
+ 7.0433333 0.251870
+ 7.0436111 0.197455
+ 7.0438889 0.144013
+ 7.0441667 0.094032
+ 7.0444444 0.050000
+ 7.0447222 0.050000
+ 7.0450000 0.050000
+ 7.0452778 0.050000
+ 7.0455556 0.050000
+ 7.0458333 0.050000
+ 7.0461111 0.050000
+ 7.0463889 0.050000
+ 7.0466667 0.050000
+ 7.0469444 0.050000
+ 7.0472222 0.050000
+ 7.0475000 0.091572
+ 7.0477778 0.138388
+ 7.0480556 0.188427
+ 7.0483333 0.239669
+ 7.0486111 0.290091
+ 7.0488889 0.337674
+ 7.0491667 0.380396
+ 7.0494444 0.416236
+ 7.0497222 0.443174
+ 7.0500000 0.459189
+ 7.0502778 0.462866
+ 7.0505556 0.455215
+ 7.0508333 0.437852
+ 7.0511111 0.412394
+ 7.0513889 0.380457
+ 7.0516667 0.343657
+ 7.0519444 0.303611
+ 7.0522222 0.261934
+ 7.0525000 0.220244
+ 7.0527778 0.180157
+ 7.0530556 0.143131
+ 7.0533333 0.109995
+ 7.0536111 0.081419
+ 7.0538889 0.058075
+ 7.0541667 0.050000
+ 7.0544444 0.050000
+ 7.0547222 0.050000
+ 7.0550000 0.050000
+ 7.0552778 0.050000
+ 7.0555556 0.065440
+ 7.0558333 0.097017
+ 7.0561111 0.136291
+ 7.0563889 0.181033
+ 7.0566667 0.229013
+ 7.0569444 0.278000
+ 7.0572222 0.325765
+ 7.0575000 0.370078
+ 7.0577778 0.408707
+ 7.0580556 0.439425
+ 7.0583333 0.460000
+ 7.0586111 0.468906
+ 7.0588889 0.467432
+ 7.0591667 0.457569
+ 7.0594444 0.441309
+ 7.0597222 0.420644
+ 7.0600000 0.397566
+ 7.0602778 0.374067
+ 7.0605556 0.352139
+ 7.0608333 0.333773
+ 7.0611111 0.320961
+ 7.0613889 0.315183
+ 7.0616667 0.315870
+ 7.0619444 0.321940
+ 7.0622222 0.332311
+ 7.0625000 0.345901
+ 7.0627778 0.361630
+ 7.0630556 0.378414
+ 7.0633333 0.395174
+ 7.0636111 0.410826
+ 7.0638889 0.424289
+ 7.0641667 0.434797
+ 7.0644444 0.442842
+ 7.0647222 0.449232
+ 7.0650000 0.454775
+ 7.0652778 0.460278
+ 7.0655556 0.466549
+ 7.0658333 0.474396
+ 7.0661111 0.484627
+ 7.0663889 0.498048
+ 7.0666667 0.515469
+ 7.0669444 0.537205
+ 7.0672222 0.561603
+ 7.0675000 0.586522
+ 7.0677778 0.609817
+ 7.0680556 0.629346
+ 7.0683333 0.642964
+ 7.0686111 0.648529
+ 7.0688889 0.643897
+ 7.0691667 0.626925
+ 7.0694444 0.595469
+ 7.0697222 0.548424
+ 7.0700000 0.488834
+ 7.0702778 0.420779
+ 7.0705556 0.348341
+ 7.0708333 0.275602
+ 7.0711111 0.206643
+ 7.0713889 0.145545
+ 7.0716667 0.096390
+ 7.0719444 0.063258
+ 7.0722222 0.050232
+ 7.0725000 0.059986
+ 7.0727778 0.089566
+ 7.0730556 0.134613
+ 7.0733333 0.190766
+ 7.0736111 0.253667
+ 7.0738889 0.318955
+ 7.0741667 0.382269
+ 7.0744444 0.439251
+ 7.0747222 0.485540
+ 7.0750000 0.516777
+ 7.0752778 0.529876
+ 7.0755556 0.526856
+ 7.0758333 0.511011
+ 7.0761111 0.485633
+ 7.0763889 0.454017
+ 7.0766667 0.419456
+ 7.0769444 0.385242
+ 7.0772222 0.354671
+ 7.0775000 0.331034
+ 7.0777778 0.317627
+ 7.0780556 0.316838
+ 7.0783333 0.327443
+ 7.0786111 0.347315
+ 7.0788889 0.374326
+ 7.0791667 0.406349
+ 7.0794444 0.441254
+ 7.0797222 0.476916
+ 7.0800000 0.511206
+ 7.0802778 0.541996
+ 7.0805556 0.567159
+ 7.0808333 0.584987
+ 7.0811111 0.595450
+ 7.0813889 0.598941
+ 7.0816667 0.595848
+ 7.0819444 0.586565
+ 7.0822222 0.571480
+ 7.0825000 0.550986
+ 7.0827778 0.525473
+ 7.0830556 0.495333
+ 7.0833333 0.460955
+ 7.0836111 0.422810
+ 7.0838889 0.381690
+ 7.0841667 0.338463
+ 7.0844444 0.294001
+ 7.0847222 0.249173
+ 7.0850000 0.204849
+ 7.0852778 0.161900
+ 7.0855556 0.121195
+ 7.0858333 0.083605
+ 7.0861111 0.050000
+ 7.0863889 0.050000
+ 7.0866667 0.050000
+ 7.0869444 0.050000
+ 7.0872222 0.050000
+ 7.0875000 0.050000
+ 7.0877778 0.050000
+ 7.0880556 0.050000
+ 7.0883333 0.050000
+ 7.0886111 0.050000
+ 7.0888889 0.050000
+ 7.0891667 0.092485
+ 7.0894444 0.141483
+ 7.0897222 0.194423
+ 7.0900000 0.248736
+ 7.0902778 0.301850
+ 7.0905556 0.351194
+ 7.0908333 0.394198
+ 7.0911111 0.428292
+ 7.0913889 0.450904
+ 7.0916667 0.459464
+ 7.0919444 0.452245
+ 7.0922222 0.430892
+ 7.0925000 0.397895
+ 7.0927778 0.355744
+ 7.0930556 0.306928
+ 7.0933333 0.253936
+ 7.0936111 0.199258
+ 7.0938889 0.145383
+ 7.0941667 0.094801
+ 7.0944444 0.050000
+ 7.0947222 0.050000
+ 7.0950000 0.050000
+ 7.0952778 0.050000
+ 7.0955556 0.050000
+ 7.0958333 0.050000
+ 7.0961111 0.050000
+ 7.0963889 0.050000
+ 7.0966667 0.050000
+ 7.0969444 0.050000
+ 7.0972222 0.050000
+ 7.0975000 0.094452
+ 7.0977778 0.144587
+ 7.0980556 0.197983
+ 7.0983333 0.252219
+ 7.0986111 0.304873
+ 7.0988889 0.353523
+ 7.0991667 0.395747
+ 7.0994444 0.429124
+ 7.0997222 0.451231
+ 7.1000000 0.459647
+ 7.1002778 0.452752
+ 7.1005556 0.432131
+ 7.1008333 0.400174
+ 7.1011111 0.359269
+ 7.1013889 0.311802
+ 7.1016667 0.260164
+ 7.1019444 0.206741
+ 7.1022222 0.153921
+ 7.1025000 0.104094
+ 7.1027778 0.059647
+ 7.1030556 0.050000
+ 7.1033333 0.050000
+ 7.1036111 0.050000
+ 7.1038889 0.050000
+ 7.1041667 0.050000
+ 7.1044444 0.050000
+ 7.1047222 0.050000
+ 7.1050000 0.050000
+ 7.1052778 0.050000
+ 7.1055556 0.050000
+ 7.1058333 0.094003
+ 7.1061111 0.143975
+ 7.1063889 0.197425
+ 7.1066667 0.251861
+ 7.1069444 0.304791
+ 7.1072222 0.353723
+ 7.1075000 0.396165
+ 7.1077778 0.429626
+ 7.1080556 0.451612
+ 7.1083333 0.459634
+ 7.1086111 0.452024
+ 7.1088889 0.430425
+ 7.1091667 0.397301
+ 7.1094444 0.355121
+ 7.1097222 0.306351
+ 7.1100000 0.253459
+ 7.1102778 0.198911
+ 7.1105556 0.145173
+ 7.1108333 0.094714
+ 7.1111111 0.050000
+ 7.1113889 0.050000
+ 7.1116667 0.050000
+ 7.1119444 0.050000
+ 7.1122222 0.050000
+ 7.1125000 0.050000
+ 7.1127778 0.050000
+ 7.1130556 0.050000
+ 7.1133333 0.050000
+ 7.1136111 0.050000
+ 7.1138889 0.050000
+ 7.1141667 0.094664
+ 7.1144444 0.145059
+ 7.1147222 0.198727
+ 7.1150000 0.253211
+ 7.1152778 0.306052
+ 7.1155556 0.354794
+ 7.1158333 0.396980
+ 7.1161111 0.430151
+ 7.1163889 0.451851
+ 7.1166667 0.459621
+ 7.1169444 0.451824
+ 7.1172222 0.430099
+ 7.1175000 0.396906
+ 7.1177778 0.354703
+ 7.1180556 0.305950
+ 7.1183333 0.253106
+ 7.1186111 0.198630
+ 7.1188889 0.144981
+ 7.1191667 0.094618
+ 7.1194444 0.050000
+ 7.1197222 0.050000
+ 7.1200000 0.050000
+ 7.1202778 0.050000
+ 7.1205556 0.050000
+ 7.1208333 0.050000
+ 7.1211111 0.050000
+ 7.1213889 0.050000
+ 7.1216667 0.050000
+ 7.1219444 0.050000
+ 7.1222222 0.050000
+ 7.1225000 0.094497
+ 7.1227778 0.144704
+ 7.1230556 0.198187
+ 7.1233333 0.252509
+ 7.1236111 0.305234
+ 7.1238889 0.353927
+ 7.1241667 0.396152
+ 7.1244444 0.429473
+ 7.1247222 0.451454
+ 7.1250000 0.459660
+ 7.1252778 0.452463
+ 7.1255556 0.431467
+ 7.1258333 0.399086
+ 7.1261111 0.357732
+ 7.1263889 0.309818
+ 7.1266667 0.257757
+ 7.1269444 0.203962
+ 7.1272222 0.150845
+ 7.1275000 0.100820
+ 7.1277778 0.056299
+ 7.1280556 0.050000
+ 7.1283333 0.050000
+ 7.1286111 0.050000
+ 7.1288889 0.050000
+ 7.1291667 0.050000
+ 7.1294444 0.050000
+ 7.1297222 0.050000
+ 7.1300000 0.050000
+ 7.1302778 0.050000
+ 7.1305556 0.050000
+ 7.1308333 0.094223
+ 7.1311111 0.144333
+ 7.1313889 0.197850
+ 7.1316667 0.252295
+ 7.1319444 0.305187
+ 7.1322222 0.354048
+ 7.1325000 0.396397
+ 7.1327778 0.429756
+ 7.1330556 0.451644
+ 7.1333333 0.459582
+ 7.1336111 0.451913
+ 7.1338889 0.430279
+ 7.1341667 0.397141
+ 7.1344444 0.354963
+ 7.1347222 0.306208
+ 7.1350000 0.253340
+ 7.1352778 0.198822
+ 7.1355556 0.145117
+ 7.1358333 0.094689
+ 7.1361111 0.050000
+ 7.1363889 0.050000
+ 7.1366667 0.050000
+ 7.1369444 0.050000
+ 7.1372222 0.050000
+ 7.1375000 0.050000
+ 7.1377778 0.050000
+ 7.1380556 0.050000
+ 7.1383333 0.050000
+ 7.1386111 0.050000
+ 7.1388889 0.050000
+ 7.1391667 0.094667
+ 7.1394444 0.145067
+ 7.1397222 0.198744
+ 7.1400000 0.253237
+ 7.1402778 0.306090
+ 7.1405556 0.354842
+ 7.1408333 0.397037
+ 7.1411111 0.430214
+ 7.1413889 0.451917
+ 7.1416667 0.459686
+ 7.1419444 0.451883
+ 7.1422222 0.430149
+ 7.1425000 0.396943
+ 7.1427778 0.354727
+ 7.1430556 0.305962
+ 7.1433333 0.253106
+ 7.1436111 0.198622
+ 7.1438889 0.144969
+ 7.1441667 0.094608
+ 7.1444444 0.050000
+ 7.1447222 0.050000
+ 7.1450000 0.050000
+ 7.1452778 0.050000
+ 7.1455556 0.050000
+ 7.1458333 0.050000
+ 7.1461111 0.050000
+ 7.1463889 0.050000
+ 7.1466667 0.050000
+ 7.1469444 0.050000
+ 7.1472222 0.050000
+ 7.1475000 0.094415
+ 7.1477778 0.144528
+ 7.1480556 0.197914
+ 7.1483333 0.252149
+ 7.1486111 0.304810
+ 7.1488889 0.353472
+ 7.1491667 0.395712
+ 7.1494444 0.429106
+ 7.1497222 0.451230
+ 7.1500000 0.459660
+ 7.1502778 0.452774
+ 7.1505556 0.432159
+ 7.1508333 0.400204
+ 7.1511111 0.359298
+ 7.1513889 0.311828
+ 7.1516667 0.260185
+ 7.1519444 0.206756
+ 7.1522222 0.153931
+ 7.1525000 0.104099
+ 7.1527778 0.059647
+ 7.1530556 0.050000
+ 7.1533333 0.050000
+ 7.1536111 0.050000
+ 7.1538889 0.050000
+ 7.1541667 0.050000
+ 7.1544444 0.050000
+ 7.1547222 0.050000
+ 7.1550000 0.050000
+ 7.1552778 0.050000
+ 7.1555556 0.050000
+ 7.1558333 0.094001
+ 7.1561111 0.143971
+ 7.1563889 0.197418
+ 7.1566667 0.251851
+ 7.1569444 0.304777
+ 7.1572222 0.353705
+ 7.1575000 0.396144
+ 7.1577778 0.429602
+ 7.1580556 0.451587
+ 7.1583333 0.459608
+ 7.1586111 0.451999
+ 7.1588889 0.430400
+ 7.1591667 0.397279
+ 7.1594444 0.355102
+ 7.1597222 0.306336
+ 7.1600000 0.253447
+ 7.1602778 0.198902
+ 7.1605556 0.145168
+ 7.1608333 0.094712
+ 7.1611111 0.050000
+ 7.1613889 0.050000
+ 7.1616667 0.050000
+ 7.1619444 0.050000
+ 7.1622222 0.050000
+ 7.1625000 0.050000
+ 7.1627778 0.050000
+ 7.1630556 0.050000
+ 7.1633333 0.050000
+ 7.1636111 0.050000
+ 7.1638889 0.050000
+ 7.1641667 0.094665
+ 7.1644444 0.145062
+ 7.1647222 0.198732
+ 7.1650000 0.253217
+ 7.1652778 0.306060
+ 7.1655556 0.354803
+ 7.1658333 0.396988
+ 7.1661111 0.430158
+ 7.1663889 0.451855
+ 7.1666667 0.459621
+ 7.1669444 0.451818
+ 7.1672222 0.430086
+ 7.1675000 0.396885
+ 7.1677778 0.354676
+ 7.1680556 0.305919
+ 7.1683333 0.253072
+ 7.1686111 0.198597
+ 7.1688889 0.144953
+ 7.1691667 0.094601
+ 7.1694444 0.050000
+ 7.1697222 0.050000
+ 7.1700000 0.050000
+ 7.1702778 0.050000
+ 7.1705556 0.050000
+ 7.1708333 0.050000
+ 7.1711111 0.050000
+ 7.1713889 0.050000
+ 7.1716667 0.050000
+ 7.1719444 0.050000
+ 7.1722222 0.050000
+ 7.1725000 0.094410
+ 7.1727778 0.144518
+ 7.1730556 0.197898
+ 7.1733333 0.252128
+ 7.1736111 0.304784
+ 7.1738889 0.353441
+ 7.1741667 0.395678
+ 7.1744444 0.429069
+ 7.1747222 0.451191
+ 7.1750000 0.459621
+ 7.1752778 0.452736
+ 7.1755556 0.432124
+ 7.1758333 0.400172
+ 7.1761111 0.359270
+ 7.1763889 0.311806
+ 7.1766667 0.260167
+ 7.1769444 0.206744
+ 7.1772222 0.153924
+ 7.1775000 0.104095
+ 7.1777778 0.059647
+ 7.1780556 0.050000
+ 7.1783333 0.050000
+ 7.1786111 0.050000
+ 7.1788889 0.050000
+ 7.1791667 0.050000
+ 7.1794444 0.050000
+ 7.1797222 0.050000
+ 7.1800000 0.050000
+ 7.1802778 0.050000
+ 7.1805556 0.050000
+ 7.1808333 0.094001
+ 7.1811111 0.143970
+ 7.1813889 0.197417
+ 7.1816667 0.251849
+ 7.1819444 0.304775
+ 7.1822222 0.353703
+ 7.1825000 0.396140
+ 7.1827778 0.429596
+ 7.1830556 0.451578
+ 7.1833333 0.459595
+ 7.1836111 0.451981
+ 7.1838889 0.430377
+ 7.1841667 0.397251
+ 7.1844444 0.355070
+ 7.1847222 0.306301
+ 7.1850000 0.253412
+ 7.1852778 0.198870
+ 7.1855556 0.145142
+ 7.1858333 0.094697
+ 7.1861111 0.050000
+ 7.1863889 0.050000
+ 7.1866667 0.050000
+ 7.1869444 0.050000
+ 7.1872222 0.050000
+ 7.1875000 0.050000
+ 7.1877778 0.050000
+ 7.1880556 0.050000
+ 7.1883333 0.050000
+ 7.1886111 0.050000
+ 7.1888889 0.050000
+ 7.1891667 0.094591
+ 7.1894444 0.144902
+ 7.1897222 0.198486
+ 7.1900000 0.252895
+ 7.1902778 0.305683
+ 7.1905556 0.354403
+ 7.1908333 0.396607
+ 7.1911111 0.429849
+ 7.1913889 0.451683
+ 7.1916667 0.459660
+ 7.1919444 0.452148
+ 7.1922222 0.430770
+ 7.1925000 0.397963
+ 7.1927778 0.356162
+ 7.1930556 0.307804
+ 7.1933333 0.255327
+ 7.1936111 0.201167
+ 7.1938889 0.147760
+ 7.1941667 0.097543
+ 7.1944444 0.052952
+ 7.1947222 0.050000
+ 7.1950000 0.050000
+ 7.1952778 0.050000
+ 7.1955556 0.050000
+ 7.1958333 0.050000
+ 7.1961111 0.050000
+ 7.1963889 0.050000
+ 7.1966667 0.050000
+ 7.1969444 0.050000
+ 7.1972222 0.050000
+ 7.1975000 0.094455
+ 7.1977778 0.144717
+ 7.1980556 0.198318
+ 7.1983333 0.252789
+ 7.1986111 0.305662
+ 7.1988889 0.354468
+ 7.1991667 0.396740
+ 7.1994444 0.430008
+ 7.1997222 0.451804
+ 7.2000000 0.459660
+ 7.2002778 0.451929
+ 7.2005556 0.430250
+ 7.2008333 0.397085
+ 7.2011111 0.354893
+ 7.2013889 0.306136
+ 7.2016667 0.253274
+ 7.2019444 0.198769
+ 7.2022222 0.145081
+ 7.2025000 0.094671
+ 7.2027778 0.050000
+ 7.2030556 0.050000
+ 7.2033333 0.050000
+ 7.2036111 0.050000
+ 7.2038889 0.050000
+ 7.2041667 0.050000
+ 7.2044444 0.050000
+ 7.2047222 0.050000
+ 7.2050000 0.050000
+ 7.2052778 0.050000
+ 7.2055556 0.050000
+ 7.2058333 0.094649
+ 7.2061111 0.145031
+ 7.2063889 0.198688
+ 7.2066667 0.253163
+ 7.2069444 0.305998
+ 7.2072222 0.354736
+ 7.2075000 0.396921
+ 7.2077778 0.430095
+ 7.2080556 0.451801
+ 7.2083333 0.459582
+ 7.2086111 0.451799
+ 7.2088889 0.430090
+ 7.2091667 0.396914
+ 7.2094444 0.354728
+ 7.2097222 0.305988
+ 7.2100000 0.253153
+ 7.2102778 0.198679
+ 7.2105556 0.145024
+ 7.2108333 0.094645
+ 7.2111111 0.050000
+ 7.2113889 0.050000
+ 7.2116667 0.050000
+ 7.2119444 0.050000
+ 7.2122222 0.050000
+ 7.2125000 0.050000
+ 7.2127778 0.050000
+ 7.2130556 0.050000
+ 7.2133333 0.050000
+ 7.2136111 0.050000
+ 7.2138889 0.050000
+ 7.2141667 0.094650
+ 7.2144444 0.145036
+ 7.2147222 0.198699
+ 7.2150000 0.253182
+ 7.2152778 0.306027
+ 7.2155556 0.354775
+ 7.2158333 0.396970
+ 7.2161111 0.430151
+ 7.2163889 0.451863
+ 7.2166667 0.459647
+ 7.2169444 0.451864
+ 7.2172222 0.430153
+ 7.2175000 0.396971
+ 7.2177778 0.354778
+ 7.2180556 0.306030
+ 7.2183333 0.253185
+ 7.2186111 0.198702
+ 7.2188889 0.145038
+ 7.2191667 0.094651
+ 7.2194444 0.050000
+ 7.2197222 0.050000
+ 7.2200000 0.050000
+ 7.2202778 0.050000
+ 7.2205556 0.050000
+ 7.2208333 0.050000
+ 7.2211111 0.050000
+ 7.2213889 0.050000
+ 7.2216667 0.050000
+ 7.2219444 0.050000
+ 7.2222222 0.050000
+ 7.2225000 0.094650
+ 7.2227778 0.145036
+ 7.2230556 0.198698
+ 7.2233333 0.253179
+ 7.2236111 0.306022
+ 7.2238889 0.354768
+ 7.2241667 0.396960
+ 7.2244444 0.430141
+ 7.2247222 0.451851
+ 7.2250000 0.459634
+ 7.2252778 0.451851
+ 7.2255556 0.430140
+ 7.2258333 0.396959
+ 7.2261111 0.354767
+ 7.2263889 0.306020
+ 7.2266667 0.253177
+ 7.2269444 0.198696
+ 7.2272222 0.145034
+ 7.2275000 0.094650
+ 7.2277778 0.050000
+ 7.2280556 0.050000
+ 7.2283333 0.050000
+ 7.2286111 0.050000
+ 7.2288889 0.050000
+ 7.2291667 0.050000
+ 7.2294444 0.050000
+ 7.2297222 0.050000
+ 7.2300000 0.050000
+ 7.2302778 0.050000
+ 7.2305556 0.050000
+ 7.2308333 0.094648
+ 7.2311111 0.145029
+ 7.2313889 0.198688
+ 7.2316667 0.253166
+ 7.2319444 0.306005
+ 7.2322222 0.354748
+ 7.2325000 0.396937
+ 7.2327778 0.430116
+ 7.2330556 0.451825
+ 7.2333333 0.459608
+ 7.2336111 0.451826
+ 7.2338889 0.430117
+ 7.2341667 0.396940
+ 7.2344444 0.354751
+ 7.2347222 0.306008
+ 7.2350000 0.253169
+ 7.2352778 0.198691
+ 7.2355556 0.145032
+ 7.2358333 0.094649
+ 7.2361111 0.050000
+ 7.2363889 0.050000
+ 7.2366667 0.050000
+ 7.2369444 0.050000
+ 7.2372222 0.050000
+ 7.2375000 0.050000
+ 7.2377778 0.050000
+ 7.2380556 0.050000
+ 7.2383333 0.050000
+ 7.2386111 0.050000
+ 7.2388889 0.050000
+ 7.2391667 0.094656
+ 7.2394444 0.145048
+ 7.2397222 0.198718
+ 7.2400000 0.253208
+ 7.2402778 0.306060
+ 7.2405556 0.354815
+ 7.2408333 0.397014
+ 7.2411111 0.430200
+ 7.2413889 0.451915
+ 7.2416667 0.459699
+ 7.2419444 0.451915
+ 7.2422222 0.430200
+ 7.2425000 0.397014
+ 7.2427778 0.354814
+ 7.2430556 0.306059
+ 7.2433333 0.253208
+ 7.2436111 0.198718
+ 7.2438889 0.145048
+ 7.2441667 0.094656
+ 7.2444444 0.050000
+ 7.2447222 0.050000
+ 7.2450000 0.050000
+ 7.2452778 0.050000
+ 7.2455556 0.050000
+ 7.2458333 0.050000
+ 7.2461111 0.050000
+ 7.2463889 0.050000
+ 7.2466667 0.050000
+ 7.2469444 0.050000
+ 7.2472222 0.050000
+ 7.2475000 0.094648
+ 7.2477778 0.145030
+ 7.2480556 0.198687
+ 7.2483333 0.253164
+ 7.2486111 0.306001
+ 7.2488889 0.354743
+ 7.2491667 0.396930
+ 7.2494444 0.430106
+ 7.2497222 0.451814
+ 7.2500000 0.459595
+ 7.2502778 0.451811
+ 7.2505556 0.430101
+ 7.2508333 0.396923
+ 7.2511111 0.354734
+ 7.2513889 0.305991
+ 7.2516667 0.253153
+ 7.2519444 0.198678
+ 7.2522222 0.145022
+ 7.2525000 0.094643
+ 7.2527778 0.050000
+ 7.2530556 0.050000
+ 7.2533333 0.050000
+ 7.2536111 0.050000
+ 7.2538889 0.050000
+ 7.2541667 0.050000
+ 7.2544444 0.050000
+ 7.2547222 0.050000
+ 7.2550000 0.050000
+ 7.2552778 0.050000
+ 7.2555556 0.050000
+ 7.2558333 0.094634
+ 7.2561111 0.144999
+ 7.2563889 0.198640
+ 7.2566667 0.253098
+ 7.2569444 0.305919
+ 7.2572222 0.354644
+ 7.2575000 0.396818
+ 7.2577778 0.429984
+ 7.2580556 0.451685
+ 7.2583333 0.459464
+ 7.2586111 0.451684
+ 7.2588889 0.429982
+ 7.2591667 0.396816
+ 7.2594444 0.354641
+ 7.2597222 0.305916
+ 7.2600000 0.253095
+ 7.2602778 0.198636
+ 7.2605556 0.144997
+ 7.2608333 0.094632
+ 7.2611111 0.050000
+ 7.2613889 0.050000
+ 7.2616667 0.050000
+ 7.2619444 0.050000
+ 7.2622222 0.050000
+ 7.2625000 0.050000
+ 7.2627778 0.050000
+ 7.2630556 0.050000
+ 7.2633333 0.050000
+ 7.2636111 0.050000
+ 7.2638889 0.050000
+ 7.2641667 0.094636
+ 7.2644444 0.145006
+ 7.2647222 0.198653
+ 7.2650000 0.253118
+ 7.2652778 0.305946
+ 7.2655556 0.354679
+ 7.2658333 0.396859
+ 7.2661111 0.430030
+ 7.2663889 0.451735
+ 7.2666667 0.459516
+ 7.2669444 0.451735
+ 7.2672222 0.430031
+ 7.2675000 0.396860
+ 7.2677778 0.354680
+ 7.2680556 0.305947
+ 7.2683333 0.253120
+ 7.2686111 0.198654
+ 7.2688889 0.145007
+ 7.2691667 0.094637
+ 7.2694444 0.050000
+ 7.2697222 0.050000
+ 7.2700000 0.050000
+ 7.2702778 0.050000
+ 7.2705556 0.050000
+ 7.2708333 0.050000
+ 7.2711111 0.050000
+ 7.2713889 0.050000
+ 7.2716667 0.050000
+ 7.2719444 0.050000
+ 7.2722222 0.050000
+ 7.2725000 0.094635
+ 7.2727778 0.145003
+ 7.2730556 0.198646
+ 7.2733333 0.253108
+ 7.2736111 0.305933
+ 7.2738889 0.354662
+ 7.2741667 0.396839
+ 7.2744444 0.430007
+ 7.2747222 0.451710
+ 7.2750000 0.459490
+ 7.2752778 0.451709
+ 7.2755556 0.430006
+ 7.2758333 0.396837
+ 7.2761111 0.354659
+ 7.2763889 0.305930
+ 7.2766667 0.253105
+ 7.2769444 0.198643
+ 7.2772222 0.145000
+ 7.2775000 0.094634
+ 7.2777778 0.050000
+ 7.2780556 0.050000
+ 7.2783333 0.050000
+ 7.2786111 0.050000
+ 7.2788889 0.050000
+ 7.2791667 0.050000
+ 7.2794444 0.050000
+ 7.2797222 0.050000
+ 7.2800000 0.050000
+ 7.2802778 0.050000
+ 7.2805556 0.050000
+ 7.2808333 0.094631
+ 7.2811111 0.144993
+ 7.2813889 0.198631
+ 7.2816667 0.253088
+ 7.2819444 0.305907
+ 7.2822222 0.354631
+ 7.2825000 0.396804
+ 7.2827778 0.429970
+ 7.2830556 0.451671
+ 7.2833333 0.459451
+ 7.2836111 0.451672
+ 7.2838889 0.429972
+ 7.2841667 0.396807
+ 7.2844444 0.354635
+ 7.2847222 0.305911
+ 7.2850000 0.253092
+ 7.2852778 0.198635
+ 7.2855556 0.144996
+ 7.2858333 0.094632
+ 7.2861111 0.050000
+ 7.2863889 0.050000
+ 7.2866667 0.050000
+ 7.2869444 0.050000
+ 7.2872222 0.050000
+ 7.2875000 0.050000
+ 7.2877778 0.050000
+ 7.2880556 0.050000
+ 7.2883333 0.050000
+ 7.2886111 0.050000
+ 7.2888889 0.050000
+ 7.2891667 0.094643
+ 7.2894444 0.145020
+ 7.2897222 0.198676
+ 7.2900000 0.253151
+ 7.2902778 0.305988
+ 7.2905556 0.354730
+ 7.2908333 0.396920
+ 7.2911111 0.430099
+ 7.2913889 0.451810
+ 7.2916667 0.459595
+ 7.2919444 0.451816
+ 7.2922222 0.430111
+ 7.2925000 0.396937
+ 7.2927778 0.354751
+ 7.2930556 0.306011
+ 7.2933333 0.253174
+ 7.2936111 0.198698
+ 7.2938889 0.145038
+ 7.2941667 0.094653
+ 7.2944444 0.050000
+ 7.2947222 0.050000
+ 7.2950000 0.050000
+ 7.2952778 0.050000
+ 7.2955556 0.050000
+ 7.2958333 0.050000
+ 7.2961111 0.050000
+ 7.2963889 0.050000
+ 7.2966667 0.050000
+ 7.2969444 0.050000
+ 7.2972222 0.050000
+ 7.2975000 0.094682
+ 7.2977778 0.145105
+ 7.2980556 0.198807
+ 7.2983333 0.253326
+ 7.2986111 0.306199
+ 7.2988889 0.354965
+ 7.2991667 0.397161
+ 7.2994444 0.430326
+ 7.2997222 0.451997
+ 7.3000000 0.459712
+ 7.3002778 0.451833
+ 7.3005556 0.430007
+ 7.3008333 0.396708
+ 7.3011111 0.354407
+ 7.3013889 0.305577
+ 7.3016667 0.252689
+ 7.3019444 0.198215
+ 7.3022222 0.144628
+ 7.3025000 0.094399
+ 7.3027778 0.050000
+ 7.3030556 0.050000
+ 7.3033333 0.050000
+ 7.3036111 0.050000
+ 7.3038889 0.050000
+ 7.3041667 0.050000
+ 7.3044444 0.050000
+ 7.3047222 0.050000
+ 7.3050000 0.050000
+ 7.3052778 0.050000
+ 7.3055556 0.054639
+ 7.3058333 0.099461
+ 7.3061111 0.149891
+ 7.3063889 0.203467
+ 7.3066667 0.257726
+ 7.3069444 0.310207
+ 7.3072222 0.358449
+ 7.3075000 0.399988
+ 7.3077778 0.432364
+ 7.3080556 0.453114
+ 7.3083333 0.459778
+ 7.3086111 0.450732
+ 7.3088889 0.427715
+ 7.3091667 0.393306
+ 7.3094444 0.350081
+ 7.3097222 0.300621
+ 7.3100000 0.247501
+ 7.3102778 0.193301
+ 7.3105556 0.140599
+ 7.3108333 0.091973
+ 7.3111111 0.050000
+ 7.3113889 0.050000
+ 7.3116667 0.050000
+ 7.3119444 0.050000
+ 7.3122222 0.050000
+ 7.3125000 0.050000
+ 7.3127778 0.050000
+ 7.3130556 0.050000
+ 7.3133333 0.050000
+ 7.3136111 0.050636
+ 7.3138889 0.088218
+ 7.3141667 0.131985
+ 7.3144444 0.180079
+ 7.3147222 0.230328
+ 7.3150000 0.280558
+ 7.3152778 0.328596
+ 7.3155556 0.372269
+ 7.3158333 0.409404
+ 7.3161111 0.437826
+ 7.3163889 0.455364
+ 7.3166667 0.459843
+ 7.3169444 0.449842
+ 7.3172222 0.426945
+ 7.3175000 0.393485
+ 7.3177778 0.351798
+ 7.3180556 0.304219
+ 7.3183333 0.253081
+ 7.3186111 0.200721
+ 7.3188889 0.149472
+ 7.3191667 0.101669
+ 7.3194444 0.059647
+ 7.3197222 0.050000
+ 7.3200000 0.050000
+ 7.3202778 0.050000
+ 7.3205556 0.050000
+ 7.3208333 0.050000
+ 7.3211111 0.050000
+ 7.3213889 0.050000
+ 7.3216667 0.050000
+ 7.3219444 0.050000
+ 7.3222222 0.071507
+ 7.3225000 0.114556
+ 7.3227778 0.162798
+ 7.3230556 0.213936
+ 7.3233333 0.265670
+ 7.3236111 0.315703
+ 7.3238889 0.361735
+ 7.3241667 0.401469
+ 7.3244444 0.432606
+ 7.3247222 0.452848
+ 7.3250000 0.459895
+ 7.3252778 0.452225
+ 7.3255556 0.431407
+ 7.3258333 0.399788
+ 7.3261111 0.359713
+ 7.3263889 0.313528
+ 7.3266667 0.263578
+ 7.3269444 0.212208
+ 7.3272222 0.161764
+ 7.3275000 0.114592
+ 7.3277778 0.073037
+ 7.3280556 0.050000
+ 7.3283333 0.050000
+ 7.3286111 0.050000
+ 7.3288889 0.050000
+ 7.3291667 0.050000
+ 7.3294444 0.050000
+ 7.3297222 0.050000
+ 7.3300000 0.050000
+ 7.3302778 0.050000
+ 7.3305556 0.081576
+ 7.3308333 0.123562
+ 7.3311111 0.170653
+ 7.3313889 0.220588
+ 7.3316667 0.271105
+ 7.3319444 0.319945
+ 7.3322222 0.364844
+ 7.3325000 0.403542
+ 7.3327778 0.433778
+ 7.3330556 0.453290
+ 7.3333333 0.459817
+ 7.3336111 0.451861
+ 7.3338889 0.430975
+ 7.3341667 0.399476
+ 7.3344444 0.359679
+ 7.3347222 0.313903
+ 7.3350000 0.264462
+ 7.3352778 0.213673
+ 7.3355556 0.163853
+ 7.3358333 0.117318
+ 7.3361111 0.076384
+ 7.3363889 0.050000
+ 7.3366667 0.050000
+ 7.3369444 0.050000
+ 7.3372222 0.050000
+ 7.3375000 0.050000
+ 7.3377778 0.050000
+ 7.3380556 0.050000
+ 7.3383333 0.050000
+ 7.3386111 0.053240
+ 7.3388889 0.088284
+ 7.3391667 0.130252
+ 7.3394444 0.177234
+ 7.3397222 0.226949
+ 7.3400000 0.277116
+ 7.3402778 0.325454
+ 7.3405556 0.369683
+ 7.3408333 0.407520
+ 7.3411111 0.436687
+ 7.3413889 0.454901
+ 7.3416667 0.459882
+ 7.3419444 0.450129
+ 7.3422222 0.427259
+ 7.3425000 0.393667
+ 7.3427778 0.351752
+ 7.3430556 0.303908
+ 7.3433333 0.252533
+ 7.3436111 0.200022
+ 7.3438889 0.148774
+ 7.3441667 0.101183
+ 7.3444444 0.059647
+ 7.3447222 0.050000
+ 7.3450000 0.050000
+ 7.3452778 0.050000
+ 7.3455556 0.050000
+ 7.3458333 0.050000
+ 7.3461111 0.050000
+ 7.3463889 0.050000
+ 7.3466667 0.050000
+ 7.3469444 0.050000
+ 7.3472222 0.081510
+ 7.3475000 0.124382
+ 7.3477778 0.172065
+ 7.3480556 0.222337
+ 7.3483333 0.272972
+ 7.3486111 0.321747
+ 7.3488889 0.366439
+ 7.3491667 0.404822
+ 7.3494444 0.434673
+ 7.3497222 0.453767
+ 7.3500000 0.459882
+ 7.3502778 0.451548
+ 7.3505556 0.430317
+ 7.3508333 0.398496
+ 7.3511111 0.358393
+ 7.3513889 0.312314
+ 7.3516667 0.262567
+ 7.3519444 0.211458
+ 7.3522222 0.161296
+ 7.3525000 0.114386
+ 7.3527778 0.073037
+ 7.3530556 0.050000
+ 7.3533333 0.050000
+ 7.3536111 0.050000
+ 7.3538889 0.050000
+ 7.3541667 0.050000
+ 7.3544444 0.050000
+ 7.3547222 0.050000
+ 7.3550000 0.050000
+ 7.3552778 0.050000
+ 7.3555556 0.081563
+ 7.3558333 0.123729
+ 7.3561111 0.171056
+ 7.3563889 0.221247
+ 7.3566667 0.272005
+ 7.3569444 0.321035
+ 7.3572222 0.366039
+ 7.3575000 0.404720
+ 7.3577778 0.434784
+ 7.3580556 0.453932
+ 7.3583333 0.459869
+ 7.3586111 0.451077
+ 7.3588889 0.429155
+ 7.3591667 0.396479
+ 7.3594444 0.355427
+ 7.3597222 0.308376
+ 7.3600000 0.257704
+ 7.3602778 0.205787
+ 7.3605556 0.155003
+ 7.3608333 0.107729
+ 7.3611111 0.066342
+ 7.3613889 0.050000
+ 7.3616667 0.050000
+ 7.3619444 0.050000
+ 7.3622222 0.050000
+ 7.3625000 0.050000
+ 7.3627778 0.050000
+ 7.3630556 0.050000
+ 7.3633333 0.050000
+ 7.3636111 0.050000
+ 7.3638889 0.084949
+ 7.3641667 0.127720
+ 7.3644444 0.175390
+ 7.3647222 0.225684
+ 7.3650000 0.276322
+ 7.3652778 0.325029
+ 7.3655556 0.369526
+ 7.3658333 0.407536
+ 7.3661111 0.436782
+ 7.3663889 0.454985
+ 7.3666667 0.459869
+ 7.3669444 0.449938
+ 7.3672222 0.426819
+ 7.3675000 0.392922
+ 7.3677778 0.350658
+ 7.3680556 0.302436
+ 7.3683333 0.250666
+ 7.3686111 0.197758
+ 7.3688889 0.146121
+ 7.3691667 0.098165
+ 7.3694444 0.056299
+ 7.3697222 0.050000
+ 7.3700000 0.050000
+ 7.3702778 0.050000
+ 7.3705556 0.050000
+ 7.3708333 0.050000
+ 7.3711111 0.050000
+ 7.3713889 0.050000
+ 7.3716667 0.050000
+ 7.3719444 0.050000
+ 7.3722222 0.078163
+ 7.3725000 0.121436
+ 7.3727778 0.169579
+ 7.3730556 0.220339
+ 7.3733333 0.271465
+ 7.3736111 0.320705
+ 7.3738889 0.365808
+ 7.3741667 0.404522
+ 7.3744444 0.434596
+ 7.3747222 0.453778
+ 7.3750000 0.459817
+ 7.3752778 0.451222
+ 7.3755556 0.429547
+ 7.3758333 0.397106
+ 7.3761111 0.356214
+ 7.3763889 0.309185
+ 7.3766667 0.258334
+ 7.3769444 0.205974
+ 7.3772222 0.154422
+ 7.3775000 0.105990
+ 7.3777778 0.062994
+ 7.3780556 0.050000
+ 7.3783333 0.050000
+ 7.3786111 0.050000
+ 7.3788889 0.050000
+ 7.3791667 0.050000
+ 7.3794444 0.050000
+ 7.3797222 0.050000
+ 7.3800000 0.050000
+ 7.3802778 0.050000
+ 7.3805556 0.061425
+ 7.3808333 0.104867
+ 7.3811111 0.153988
+ 7.3813889 0.206358
+ 7.3816667 0.259548
+ 7.3819444 0.311126
+ 7.3822222 0.358662
+ 7.3825000 0.399727
+ 7.3827778 0.431891
+ 7.3830556 0.452722
+ 7.3833333 0.459791
+ 7.3836111 0.451485
+ 7.3838889 0.429461
+ 7.3841667 0.396192
+ 7.3844444 0.354153
+ 7.3847222 0.305819
+ 7.3850000 0.253662
+ 7.3852778 0.200158
+ 7.3855556 0.147780
+ 7.3858333 0.099003
+ 7.3861111 0.056299
+ 7.3863889 0.050000
+ 7.3866667 0.050000
+ 7.3869444 0.050000
+ 7.3872222 0.050000
+ 7.3875000 0.050000
+ 7.3877778 0.050000
+ 7.3880556 0.050000
+ 7.3883333 0.050000
+ 7.3886111 0.050000
+ 7.3888889 0.074841
+ 7.3891667 0.118617
+ 7.3894444 0.167397
+ 7.3897222 0.218864
+ 7.3900000 0.270704
+ 7.3902778 0.320598
+ 7.3905556 0.366233
+ 7.3908333 0.405290
+ 7.3911111 0.435455
+ 7.3913889 0.454412
+ 7.3916667 0.459843
+ 7.3919444 0.450223
+ 7.3922222 0.427181
+ 7.3925000 0.393137
+ 7.3927778 0.350510
+ 7.3930556 0.301720
+ 7.3933333 0.249187
+ 7.3936111 0.195328
+ 7.3938889 0.142565
+ 7.3941667 0.093315
+ 7.3944444 0.050000
+ 7.3947222 0.050000
+ 7.3950000 0.050000
+ 7.3952778 0.050000
+ 7.3955556 0.050000
+ 7.3958333 0.050000
+ 7.3961111 0.050000
+ 7.3963889 0.050000
+ 7.3966667 0.050000
+ 7.3969444 0.050000
+ 7.3972222 0.061399
+ 7.3975000 0.105595
+ 7.3977778 0.155129
+ 7.3980556 0.207637
+ 7.3983333 0.260753
+ 7.3986111 0.312113
+ 7.3988889 0.359352
+ 7.3991667 0.400106
+ 7.3994444 0.432009
+ 7.3997222 0.452696
+ 7.4000000 0.459804
+ 7.4002778 0.451759
+ 7.4005556 0.430160
+ 7.4008333 0.397397
+ 7.4011111 0.355862
+ 7.4013889 0.307944
+ 7.4016667 0.256036
+ 7.4019444 0.202526
+ 7.4022222 0.149806
+ 7.4025000 0.100267
+ 7.4027778 0.056299
+ 7.4030556 0.050000
+ 7.4033333 0.050000
+ 7.4036111 0.050000
+ 7.4038889 0.050000
+ 7.4041667 0.050000
+ 7.4044444 0.050000
+ 7.4047222 0.050000
+ 7.4050000 0.050000
+ 7.4052778 0.050000
+ 7.4055556 0.054730
+ 7.4058333 0.098915
+ 7.4061111 0.148850
+ 7.4063889 0.202071
+ 7.4066667 0.256116
+ 7.4069444 0.308521
+ 7.4072222 0.356823
+ 7.4075000 0.398559
+ 7.4077778 0.431265
+ 7.4080556 0.452480
+ 7.4083333 0.459738
+ 7.4086111 0.451406
+ 7.4088889 0.429154
+ 7.4091667 0.395483
+ 7.4094444 0.352892
+ 7.4097222 0.303880
+ 7.4100000 0.250948
+ 7.4102778 0.196594
+ 7.4105556 0.143318
+ 7.4108333 0.093621
+ 7.4111111 0.050000
+ 7.4113889 0.050000
+ 7.4116667 0.050000
+ 7.4119444 0.050000
+ 7.4122222 0.050000
+ 7.4125000 0.050000
+ 7.4127778 0.050000
+ 7.4130556 0.050000
+ 7.4133333 0.050000
+ 7.4136111 0.050000
+ 7.4138889 0.064786
+ 7.4141667 0.109232
+ 7.4144444 0.158892
+ 7.4147222 0.211400
+ 7.4150000 0.264388
+ 7.4152778 0.315489
+ 7.4155556 0.362333
+ 7.4158333 0.402555
+ 7.4161111 0.433785
+ 7.4163889 0.453658
+ 7.4166667 0.459804
+ 7.4169444 0.450661
+ 7.4172222 0.427884
+ 7.4175000 0.393933
+ 7.4177778 0.351267
+ 7.4180556 0.302346
+ 7.4183333 0.249629
+ 7.4186111 0.195576
+ 7.4188889 0.142648
+ 7.4191667 0.093302
+ 7.4194444 0.050000
+ 7.4197222 0.050000
+ 7.4200000 0.050000
+ 7.4202778 0.050000
+ 7.4205556 0.050000
+ 7.4208333 0.050000
+ 7.4211111 0.050000
+ 7.4213889 0.050000
+ 7.4216667 0.050000
+ 7.4219444 0.050000
+ 7.4222222 0.064786
+ 7.4225000 0.109018
+ 7.4227778 0.158460
+ 7.4230556 0.210764
+ 7.4233333 0.263582
+ 7.4236111 0.314567
+ 7.4238889 0.361370
+ 7.4241667 0.401643
+ 7.4244444 0.433039
+ 7.4247222 0.453208
+ 7.4250000 0.459804
+ 7.4252778 0.451271
+ 7.4255556 0.429231
+ 7.4258333 0.396097
+ 7.4261111 0.354282
+ 7.4263889 0.306202
+ 7.4266667 0.254270
+ 7.4269444 0.200899
+ 7.4272222 0.148505
+ 7.4275000 0.099500
+ 7.4277778 0.056299
+ 7.4280556 0.050000
+ 7.4283333 0.050000
+ 7.4286111 0.050000
+ 7.4288889 0.050000
+ 7.4291667 0.050000
+ 7.4294444 0.050000
+ 7.4297222 0.050000
+ 7.4300000 0.050000
+ 7.4302778 0.050000
+ 7.4305556 0.064747
+ 7.4308333 0.108667
+ 7.4311111 0.157968
+ 7.4313889 0.210265
+ 7.4316667 0.263171
+ 7.4319444 0.314299
+ 7.4322222 0.361264
+ 7.4325000 0.401680
+ 7.4327778 0.433159
+ 7.4330556 0.453316
+ 7.4333333 0.459765
+ 7.4336111 0.450923
+ 7.4338889 0.428428
+ 7.4341667 0.394723
+ 7.4344444 0.352249
+ 7.4347222 0.303447
+ 7.4350000 0.250760
+ 7.4352778 0.196630
+ 7.4355556 0.143499
+ 7.4358333 0.093808
+ 7.4361111 0.050000
+ 7.4363889 0.050000
+ 7.4366667 0.050000
+ 7.4369444 0.050000
+ 7.4372222 0.050000
+ 7.4375000 0.050000
+ 7.4377778 0.050000
+ 7.4380556 0.050000
+ 7.4383333 0.050000
+ 7.4386111 0.050000
+ 7.4388889 0.058065
+ 7.4391667 0.102500
+ 7.4394444 0.152399
+ 7.4397222 0.205356
+ 7.4400000 0.258968
+ 7.4402778 0.310831
+ 7.4405556 0.358542
+ 7.4408333 0.399696
+ 7.4411111 0.431889
+ 7.4413889 0.452717
+ 7.4416667 0.459778
+ 7.4419444 0.451471
+ 7.4422222 0.429423
+ 7.4425000 0.396064
+ 7.4427778 0.353824
+ 7.4430556 0.305134
+ 7.4433333 0.252424
+ 7.4436111 0.198125
+ 7.4438889 0.144668
+ 7.4441667 0.094483
+ 7.4444444 0.050000
+ 7.4447222 0.050000
+ 7.4450000 0.050000
+ 7.4452778 0.050000
+ 7.4455556 0.050000
+ 7.4458333 0.050000
+ 7.4461111 0.050000
+ 7.4463889 0.050000
+ 7.4466667 0.050000
+ 7.4469444 0.050000
+ 7.4472222 0.050000
+ 7.4475000 0.094679
+ 7.4477778 0.145115
+ 7.4480556 0.198843
+ 7.4483333 0.253393
+ 7.4486111 0.306297
+ 7.4488889 0.355087
+ 7.4491667 0.397296
+ 7.4494444 0.430455
+ 7.4497222 0.452096
+ 7.4500000 0.459752
+ 7.4502778 0.451779
+ 7.4505556 0.429840
+ 7.4508333 0.396422
+ 7.4511111 0.354012
+ 7.4513889 0.305097
+ 7.4516667 0.252164
+ 7.4519444 0.197700
+ 7.4522222 0.144194
+ 7.4525000 0.094131
+ 7.4527778 0.050000
+ 7.4530556 0.050000
+ 7.4533333 0.050000
+ 7.4536111 0.050000
+ 7.4538889 0.050000
+ 7.4541667 0.050000
+ 7.4544444 0.050000
+ 7.4547222 0.050000
+ 7.4550000 0.050000
+ 7.4552778 0.050000
+ 7.4555556 0.058052
+ 7.4558333 0.102572
+ 7.4561111 0.152535
+ 7.4563889 0.205539
+ 7.4566667 0.259179
+ 7.4569444 0.311050
+ 7.4572222 0.358749
+ 7.4575000 0.399872
+ 7.4577778 0.432013
+ 7.4580556 0.452770
+ 7.4583333 0.459738
+ 7.4586111 0.451324
+ 7.4588889 0.429178
+ 7.4591667 0.395760
+ 7.4594444 0.353532
+ 7.4597222 0.304955
+ 7.4600000 0.252488
+ 7.4602778 0.198594
+ 7.4605556 0.145733
+ 7.4608333 0.096365
+ 7.4611111 0.052952
+ 7.4613889 0.050000
+ 7.4616667 0.050000
+ 7.4619444 0.050000
+ 7.4622222 0.050000
+ 7.4625000 0.050000
+ 7.4627778 0.050000
+ 7.4630556 0.050000
+ 7.4633333 0.050000
+ 7.4636111 0.050000
+ 7.4638889 0.064773
+ 7.4641667 0.108902
+ 7.4644444 0.158312
+ 7.4647222 0.210638
+ 7.4650000 0.263513
+ 7.4652778 0.314571
+ 7.4655556 0.361445
+ 7.4658333 0.401771
+ 7.4661111 0.433181
+ 7.4663889 0.453310
+ 7.4666667 0.459791
+ 7.4669444 0.451055
+ 7.4672222 0.428718
+ 7.4675000 0.395195
+ 7.4677778 0.352897
+ 7.4680556 0.304239
+ 7.4683333 0.251633
+ 7.4686111 0.197493
+ 7.4688889 0.144232
+ 7.4691667 0.094263
+ 7.4694444 0.050000
+ 7.4697222 0.050000
+ 7.4700000 0.050000
+ 7.4702778 0.050000
+ 7.4705556 0.050000
+ 7.4708333 0.050000
+ 7.4711111 0.050000
+ 7.4713889 0.050000
+ 7.4716667 0.050000
+ 7.4719444 0.050000
+ 7.4722222 0.050000
+ 7.4725000 0.094278
+ 7.4727778 0.144266
+ 7.4730556 0.197547
+ 7.4733333 0.251704
+ 7.4736111 0.304322
+ 7.4738889 0.352984
+ 7.4741667 0.395273
+ 7.4744444 0.428772
+ 7.4747222 0.451066
+ 7.4750000 0.459738
+ 7.4752778 0.453169
+ 7.4755556 0.432930
+ 7.4758333 0.401387
+ 7.4761111 0.360909
+ 7.4763889 0.313863
+ 7.4766667 0.262618
+ 7.4769444 0.209541
+ 7.4772222 0.156999
+ 7.4775000 0.107361
+ 7.4777778 0.062994
+ 7.4780556 0.050000
+ 7.4783333 0.050000
+ 7.4786111 0.050000
+ 7.4788889 0.050000
+ 7.4791667 0.050000
+ 7.4794444 0.050000
+ 7.4797222 0.050000
+ 7.4800000 0.050000
+ 7.4802778 0.050000
+ 7.4805556 0.050000
+ 7.4808333 0.093631
+ 7.4811111 0.143288
+ 7.4813889 0.196491
+ 7.4816667 0.250757
+ 7.4819444 0.303606
+ 7.4822222 0.352557
+ 7.4825000 0.395128
+ 7.4827778 0.428838
+ 7.4830556 0.451207
+ 7.4833333 0.459752
+ 7.4836111 0.452813
+ 7.4838889 0.432012
+ 7.4841667 0.399791
+ 7.4844444 0.358593
+ 7.4847222 0.310860
+ 7.4850000 0.259034
+ 7.4852778 0.205557
+ 7.4855556 0.152872
+ 7.4858333 0.103421
+ 7.4861111 0.059647
+ 7.4863889 0.050000
+ 7.4866667 0.050000
+ 7.4869444 0.050000
+ 7.4872222 0.050000
+ 7.4875000 0.050000
+ 7.4877778 0.050000
+ 7.4880556 0.050000
+ 7.4883333 0.050000
+ 7.4886111 0.050000
+ 7.4888889 0.061438
+ 7.4891667 0.105197
+ 7.4894444 0.154495
+ 7.4897222 0.206928
+ 7.4900000 0.260091
+ 7.4902778 0.311579
+ 7.4905556 0.358988
+ 7.4908333 0.399915
+ 7.4911111 0.431954
+ 7.4913889 0.452701
+ 7.4916667 0.459752
+ 7.4919444 0.451506
+ 7.4922222 0.429586
+ 7.4925000 0.396415
+ 7.4927778 0.354420
+ 7.4930556 0.306026
+ 7.4933333 0.253657
+ 7.4936111 0.199740
+ 7.4938889 0.146700
+ 7.4941667 0.096962
+ 7.4944444 0.052952
+ 7.4947222 0.050000
+ 7.4950000 0.050000
+ 7.4952778 0.050000
+ 7.4955556 0.050000
+ 7.4958333 0.050000
+ 7.4961111 0.050000
+ 7.4963889 0.050000
+ 7.4966667 0.050000
+ 7.4969444 0.050000
+ 7.4972222 0.054717
+ 7.4975000 0.098760
+ 7.4977778 0.148409
+ 7.4980556 0.201267
+ 7.4983333 0.254938
+ 7.4986111 0.307024
+ 7.4988889 0.355129
+ 7.4991667 0.396857
+ 7.4994444 0.429810
+ 7.4997222 0.451591
+ 7.5000000 0.459804
+ 7.5002778 0.452850
+ 7.5005556 0.432322
+ 7.5008333 0.400611
+ 7.5011111 0.360107
+ 7.5013889 0.313202
+ 7.5016667 0.262287
+ 7.5019444 0.209753
+ 7.5022222 0.157990
+ 7.5025000 0.109389
+ 7.5027778 0.066342
+ 7.5030556 0.050000
+ 7.5033333 0.050000
+ 7.5036111 0.050000
+ 7.5038889 0.050000
+ 7.5041667 0.050000
+ 7.5044444 0.050000
+ 7.5047222 0.050000
+ 7.5050000 0.050000
+ 7.5052778 0.050000
+ 7.5055556 0.068133
+ 7.5058333 0.111447
+ 7.5061111 0.160257
+ 7.5063889 0.212155
+ 7.5066667 0.264737
+ 7.5069444 0.315593
+ 7.5072222 0.362318
+ 7.5075000 0.402505
+ 7.5077778 0.433746
+ 7.5080556 0.453635
+ 7.5083333 0.459765
+ 7.5086111 0.450550
+ 7.5088889 0.427691
+ 7.5091667 0.393710
+ 7.5094444 0.351130
+ 7.5097222 0.302472
+ 7.5100000 0.250259
+ 7.5102778 0.197014
+ 7.5105556 0.145257
+ 7.5108333 0.097511
+ 7.5111111 0.056299
+ 7.5113889 0.050000
+ 7.5116667 0.050000
+ 7.5119444 0.050000
+ 7.5122222 0.050000
+ 7.5125000 0.050000
+ 7.5127778 0.050000
+ 7.5130556 0.050000
+ 7.5133333 0.050000
+ 7.5136111 0.057685
+ 7.5138889 0.094926
+ 7.5141667 0.138316
+ 7.5144444 0.185993
+ 7.5147222 0.235775
+ 7.5150000 0.285482
+ 7.5152778 0.332931
+ 7.5155556 0.375942
+ 7.5158333 0.412331
+ 7.5161111 0.439919
+ 7.5163889 0.456523
+ 7.5166667 0.459961
+ 7.5169444 0.448821
+ 7.5172222 0.424770
+ 7.5175000 0.390240
+ 7.5177778 0.347666
+ 7.5180556 0.299484
+ 7.5183333 0.248128
+ 7.5186111 0.196031
+ 7.5188889 0.145629
+ 7.5191667 0.099356
+ 7.5194444 0.059647
+ 7.5197222 0.050000
+ 7.5200000 0.050000
+ 7.5202778 0.050000
+ 7.5205556 0.050000
+ 7.5208333 0.050000
+ 7.5211111 0.050000
+ 7.5213889 0.050000
+ 7.5216667 0.050000
+ 7.5219444 0.068207
+ 7.5222222 0.104943
+ 7.5225000 0.147471
+ 7.5227778 0.194003
+ 7.5230556 0.242452
+ 7.5233333 0.290731
+ 7.5236111 0.336754
+ 7.5238889 0.378433
+ 7.5241667 0.413681
+ 7.5244444 0.440412
+ 7.5247222 0.456539
+ 7.5250000 0.459974
+ 7.5252778 0.449370
+ 7.5255556 0.426336
+ 7.5258333 0.393220
+ 7.5261111 0.352371
+ 7.5263889 0.306136
+ 7.5266667 0.256866
+ 7.5269444 0.206907
+ 7.5272222 0.158608
+ 7.5275000 0.114318
+ 7.5277778 0.076384
+ 7.5280556 0.050000
+ 7.5283333 0.050000
+ 7.5286111 0.050000
+ 7.5288889 0.050000
+ 7.5291667 0.050000
+ 7.5294444 0.050000
+ 7.5297222 0.050000
+ 7.5300000 0.057490
+ 7.5302778 0.086626
+ 7.5305556 0.121759
+ 7.5308333 0.162310
+ 7.5311111 0.206596
+ 7.5313889 0.252655
+ 7.5316667 0.298527
+ 7.5319444 0.342251
+ 7.5322222 0.381865
+ 7.5325000 0.415410
+ 7.5327778 0.440923
+ 7.5330556 0.456444
+ 7.5333333 0.460013
+ 7.5336111 0.450361
+ 7.5338889 0.428992
+ 7.5341667 0.398102
+ 7.5344444 0.359888
+ 7.5347222 0.316547
+ 7.5350000 0.270276
+ 7.5352778 0.223271
+ 7.5355556 0.177728
+ 7.5358333 0.135844
+ 7.5361111 0.099817
+ 7.5363889 0.071436
+ 7.5366667 0.050866
+ 7.5369444 0.050000
+ 7.5372222 0.050000
+ 7.5375000 0.050000
+ 7.5377778 0.050000
+ 7.5380556 0.056759
+ 7.5383333 0.077999
+ 7.5386111 0.105364
+ 7.5388889 0.138614
+ 7.5391667 0.177225
+ 7.5394444 0.219548
+ 7.5397222 0.263653
+ 7.5400000 0.307607
+ 7.5402778 0.349481
+ 7.5405556 0.387343
+ 7.5408333 0.419262
+ 7.5411111 0.443307
+ 7.5413889 0.457548
+ 7.5416667 0.460052
+ 7.5419444 0.449565
+ 7.5422222 0.427529
+ 7.5425000 0.396065
+ 7.5427778 0.357289
+ 7.5430556 0.313323
+ 7.5433333 0.266283
+ 7.5436111 0.218290
+ 7.5438889 0.171461
+ 7.5441667 0.127917
+ 7.5444444 0.089774
+ 7.5447222 0.058787
+ 7.5450000 0.050000
+ 7.5452778 0.050000
+ 7.5455556 0.050000
+ 7.5458333 0.050000
+ 7.5461111 0.050000
+ 7.5463889 0.050000
+ 7.5466667 0.050000
+ 7.5469444 0.072003
+ 7.5472222 0.105087
+ 7.5475000 0.144555
+ 7.5477778 0.188667
+ 7.5480556 0.235350
+ 7.5483333 0.282531
+ 7.5486111 0.328138
+ 7.5488889 0.370096
+ 7.5491667 0.406335
+ 7.5494444 0.434780
+ 7.5497222 0.453360
+ 7.5500000 0.460000
+ 7.5502778 0.453325
+ 7.5505556 0.434742
+ 7.5508333 0.406355
+ 7.5511111 0.370268
+ 7.5513889 0.328585
+ 7.5516667 0.283410
+ 7.5519444 0.236845
+ 7.5522222 0.190996
+ 7.5525000 0.147966
+ 7.5527778 0.109859
+ 7.5530556 0.078429
+ 7.5533333 0.054025
+ 7.5536111 0.050000
+ 7.5538889 0.050000
+ 7.5541667 0.050000
+ 7.5544444 0.050000
+ 7.5547222 0.050000
+ 7.5550000 0.055195
+ 7.5552778 0.079993
+ 7.5555556 0.111821
+ 7.5558333 0.150323
+ 7.5561111 0.193714
+ 7.5563889 0.239854
+ 7.5566667 0.286601
+ 7.5569444 0.331815
+ 7.5572222 0.373355
+ 7.5575000 0.409079
+ 7.5577778 0.436847
+ 7.5580556 0.454516
+ 7.5583333 0.459948
+ 7.5586111 0.451729
+ 7.5588889 0.431368
+ 7.5591667 0.401101
+ 7.5594444 0.363167
+ 7.5597222 0.319802
+ 7.5600000 0.273243
+ 7.5602778 0.225728
+ 7.5605556 0.179494
+ 7.5608333 0.136778
+ 7.5611111 0.099817
+ 7.5613889 0.070442
+ 7.5616667 0.050000
+ 7.5619444 0.050000
+ 7.5622222 0.050000
+ 7.5625000 0.050000
+ 7.5627778 0.050000
+ 7.5630556 0.050560
+ 7.5633333 0.071395
+ 7.5636111 0.098583
+ 7.5638889 0.131919
+ 7.5641667 0.170900
+ 7.5644444 0.213829
+ 7.5647222 0.258713
+ 7.5650000 0.303557
+ 7.5652778 0.346365
+ 7.5655556 0.385144
+ 7.5658333 0.417900
+ 7.5661111 0.442637
+ 7.5663889 0.457361
+ 7.5666667 0.460078
+ 7.5669444 0.449489
+ 7.5672222 0.427073
+ 7.5675000 0.395006
+ 7.5677778 0.355465
+ 7.5680556 0.310624
+ 7.5683333 0.262660
+ 7.5686111 0.213748
+ 7.5688889 0.166063
+ 7.5691667 0.121782
+ 7.5694444 0.083079
+ 7.5697222 0.051752
+ 7.5700000 0.050000
+ 7.5702778 0.050000
+ 7.5705556 0.050000
+ 7.5708333 0.050000
+ 7.5711111 0.050000
+ 7.5713889 0.050000
+ 7.5716667 0.050000
+ 7.5719444 0.067888
+ 7.5722222 0.101700
+ 7.5725000 0.141900
+ 7.5727778 0.186723
+ 7.5730556 0.234070
+ 7.5733333 0.281844
+ 7.5736111 0.327946
+ 7.5738889 0.370278
+ 7.5741667 0.406743
+ 7.5744444 0.435241
+ 7.5747222 0.453676
+ 7.5750000 0.459948
+ 7.5752778 0.452657
+ 7.5755556 0.433193
+ 7.5758333 0.403644
+ 7.5761111 0.366098
+ 7.5763889 0.322641
+ 7.5766667 0.275362
+ 7.5769444 0.226348
+ 7.5772222 0.177687
+ 7.5775000 0.131467
+ 7.5777778 0.089774
+ 7.5780556 0.054381
+ 7.5783333 0.050000
+ 7.5786111 0.050000
+ 7.5788889 0.050000
+ 7.5791667 0.050000
+ 7.5794444 0.050000
+ 7.5797222 0.050000
+ 7.5800000 0.050000
+ 7.5802778 0.050000
+ 7.5805556 0.064851
+ 7.5808333 0.105618
+ 7.5811111 0.152498
+ 7.5813889 0.203093
+ 7.5816667 0.255003
+ 7.5819444 0.305831
+ 7.5822222 0.353176
+ 7.5825000 0.394639
+ 7.5827778 0.427822
+ 7.5830556 0.450326
+ 7.5833333 0.459752
+ 7.5836111 0.454472
+ 7.5838889 0.435953
+ 7.5841667 0.406433
+ 7.5844444 0.368149
+ 7.5847222 0.323339
+ 7.5850000 0.274242
+ 7.5852778 0.223094
+ 7.5855556 0.172135
+ 7.5858333 0.123601
+ 7.5861111 0.079732
+ 7.5863889 0.050000
+ 7.5866667 0.050000
+ 7.5869444 0.050000
+ 7.5872222 0.050000
+ 7.5875000 0.050000
+ 7.5877778 0.050000
+ 7.5880556 0.050000
+ 7.5883333 0.050000
+ 7.5886111 0.050000
+ 7.5888889 0.050000
+ 7.5891667 0.092181
+ 7.5894444 0.140753
+ 7.5897222 0.193217
+ 7.5900000 0.247078
+ 7.5902778 0.299839
+ 7.5905556 0.349002
+ 7.5908333 0.392070
+ 7.5911111 0.426547
+ 7.5913889 0.449935
+ 7.5916667 0.459738
+ 7.5919444 0.454268
+ 7.5922222 0.435068
+ 7.5925000 0.404494
+ 7.5927778 0.364899
+ 7.5930556 0.318636
+ 7.5933333 0.268059
+ 7.5936111 0.215522
+ 7.5938889 0.163379
+ 7.5941667 0.113984
+ 7.5944444 0.069689
+ 7.5947222 0.050000
+ 7.5950000 0.050000
+ 7.5952778 0.050000
+ 7.5955556 0.050000
+ 7.5958333 0.050000
+ 7.5961111 0.050000
+ 7.5963889 0.050000
+ 7.5966667 0.050000
+ 7.5969444 0.050000
+ 7.5972222 0.050000
+ 7.5975000 0.092578
+ 7.5977778 0.141230
+ 7.5980556 0.193544
+ 7.5983333 0.247109
+ 7.5986111 0.299514
+ 7.5988889 0.348348
+ 7.5991667 0.391200
+ 7.5994444 0.425659
+ 7.5997222 0.449313
+ 7.6000000 0.459752
+ 7.6002778 0.455340
+ 7.6005556 0.437548
+ 7.6008333 0.408622
+ 7.6011111 0.370808
+ 7.6013889 0.326353
+ 7.6016667 0.277503
+ 7.6019444 0.226504
+ 7.6022222 0.175603
+ 7.6025000 0.127046
+ 7.6027778 0.083079
+ 7.6030556 0.050000
+ 7.6033333 0.050000
+ 7.6036111 0.050000
+ 7.6038889 0.050000
+ 7.6041667 0.050000
+ 7.6044444 0.050000
+ 7.6047222 0.050000
+ 7.6050000 0.050000
+ 7.6052778 0.050000
+ 7.6055556 0.050000
+ 7.6058333 0.091773
+ 7.6061111 0.139967
+ 7.6063889 0.192107
+ 7.6066667 0.245718
+ 7.6069444 0.298326
+ 7.6072222 0.347457
+ 7.6075000 0.390636
+ 7.6077778 0.425388
+ 7.6080556 0.449238
+ 7.6083333 0.459712
+ 7.6086111 0.455131
+ 7.6088889 0.436998
+ 7.6091667 0.407608
+ 7.6094444 0.369261
+ 7.6097222 0.324254
+ 7.6100000 0.274884
+ 7.6102778 0.223450
+ 7.6105556 0.172248
+ 7.6108333 0.123576
+ 7.6111111 0.079732
+ 7.6113889 0.050000
+ 7.6116667 0.050000
+ 7.6119444 0.050000
+ 7.6122222 0.050000
+ 7.6125000 0.050000
+ 7.6127778 0.050000
+ 7.6130556 0.050000
+ 7.6133333 0.050000
+ 7.6136111 0.050000
+ 7.6138889 0.054822
+ 7.6141667 0.096966
+ 7.6144444 0.145304
+ 7.6147222 0.197375
+ 7.6150000 0.250719
+ 7.6152778 0.302877
+ 7.6155556 0.351389
+ 7.6158333 0.393795
+ 7.6161111 0.427635
+ 7.6163889 0.450449
+ 7.6166667 0.459778
+ 7.6169444 0.453960
+ 7.6172222 0.434535
+ 7.6175000 0.403838
+ 7.6177778 0.364207
+ 7.6180556 0.317980
+ 7.6183333 0.267493
+ 7.6186111 0.215083
+ 7.6188889 0.163088
+ 7.6191667 0.113844
+ 7.6194444 0.069689
+ 7.6197222 0.050000
+ 7.6200000 0.050000
+ 7.6202778 0.050000
+ 7.6205556 0.050000
+ 7.6208333 0.050000
+ 7.6211111 0.050000
+ 7.6213889 0.050000
+ 7.6216667 0.050000
+ 7.6219444 0.050000
+ 7.6222222 0.050000
+ 7.6225000 0.092459
+ 7.6227778 0.140984
+ 7.6230556 0.193177
+ 7.6233333 0.246640
+ 7.6236111 0.298974
+ 7.6238889 0.347780
+ 7.6241667 0.390659
+ 7.6244444 0.425213
+ 7.6247222 0.449044
+ 7.6250000 0.459752
+ 7.6252778 0.455707
+ 7.6255556 0.438358
+ 7.6258333 0.409918
+ 7.6261111 0.372604
+ 7.6263889 0.328631
+ 7.6266667 0.280214
+ 7.6269444 0.229570
+ 7.6272222 0.178914
+ 7.6275000 0.130461
+ 7.6277778 0.086427
+ 7.6280556 0.050000
+ 7.6283333 0.050000
+ 7.6286111 0.050000
+ 7.6288889 0.050000
+ 7.6291667 0.050000
+ 7.6294444 0.050000
+ 7.6297222 0.050000
+ 7.6300000 0.050000
+ 7.6302778 0.050000
+ 7.6305556 0.050000
+ 7.6308333 0.092240
+ 7.6311111 0.141091
+ 7.6313889 0.193969
+ 7.6316667 0.248289
+ 7.6319444 0.301464
+ 7.6322222 0.350911
+ 7.6325000 0.394043
+ 7.6327778 0.428275
+ 7.6330556 0.451022
+ 7.6333333 0.459699
+ 7.6336111 0.452567
+ 7.6338889 0.431271
+ 7.6341667 0.398303
+ 7.6344444 0.356154
+ 7.6347222 0.307316
+ 7.6350000 0.254281
+ 7.6352778 0.199540
+ 7.6355556 0.145585
+ 7.6358333 0.094908
+ 7.6361111 0.050000
+ 7.6363889 0.050000
+ 7.6366667 0.050000
+ 7.6369444 0.050000
+ 7.6372222 0.050000
+ 7.6375000 0.050000
+ 7.6377778 0.050000
+ 7.6380556 0.050000
+ 7.6383333 0.050000
+ 7.6386111 0.050000
+ 7.6388889 0.050000
+ 7.6391667 0.094767
+ 7.6394444 0.145262
+ 7.6397222 0.199017
+ 7.6400000 0.253569
+ 7.6402778 0.306449
+ 7.6405556 0.355191
+ 7.6408333 0.397330
+ 7.6411111 0.430400
+ 7.6413889 0.451933
+ 7.6416667 0.459464
+ 7.6419444 0.451354
+ 7.6422222 0.429277
+ 7.6425000 0.395735
+ 7.6427778 0.353227
+ 7.6430556 0.304257
+ 7.6433333 0.251324
+ 7.6436111 0.196931
+ 7.6438889 0.143578
+ 7.6441667 0.093767
+ 7.6444444 0.050000
+ 7.6447222 0.050000
+ 7.6450000 0.050000
+ 7.6452778 0.050000
+ 7.6455556 0.050000
+ 7.6458333 0.050000
+ 7.6461111 0.050000
+ 7.6463889 0.050000
+ 7.6466667 0.050000
+ 7.6469444 0.050000
+ 7.6472222 0.050000
+ 7.6475000 0.090226
+ 7.6477778 0.135481
+ 7.6480556 0.183938
+ 7.6483333 0.233769
+ 7.6486111 0.283144
+ 7.6488889 0.330237
+ 7.6491667 0.373219
+ 7.6494444 0.410261
+ 7.6497222 0.439536
+ 7.6500000 0.459215
+ 7.6502778 0.468002
+ 7.6505556 0.466723
+ 7.6508333 0.456736
+ 7.6511111 0.439402
+ 7.6513889 0.416077
+ 7.6516667 0.388121
+ 7.6519444 0.356891
+ 7.6522222 0.323747
+ 7.6525000 0.290047
+ 7.6527778 0.257149
+ 7.6530556 0.226281
+ 7.6533333 0.198141
+ 7.6536111 0.173298
+ 7.6538889 0.152319
+ 7.6541667 0.135773
+ 7.6544444 0.124228
+ 7.6547222 0.118251
+ 7.6550000 0.118411
+ 7.6552778 0.125275
+ 7.6555556 0.139412
+ 7.6558333 0.161097
+ 7.6561111 0.189441
+ 7.6563889 0.223263
+ 7.6566667 0.261380
+ 7.6569444 0.302611
+ 7.6572222 0.345774
+ 7.6575000 0.389689
+ 7.6577778 0.433173
+ 7.6580556 0.475044
+ 7.6583333 0.514122
+ 7.6586111 0.549279
+ 7.6588889 0.579602
+ 7.6591667 0.604234
+ 7.6594444 0.622318
+ 7.6597222 0.632995
+ 7.6600000 0.635407
+ 7.6602778 0.628697
+ 7.6605556 0.612008
+ 7.6608333 0.584480
+ 7.6611111 0.545257
+ 7.6613889 0.494209
+ 7.6616667 0.434124
+ 7.6619444 0.368517
+ 7.6622222 0.300904
+ 7.6625000 0.234802
+ 7.6627778 0.173725
+ 7.6630556 0.121191
+ 7.6633333 0.080715
+ 7.6636111 0.055813
+ 7.6638889 0.050000
+ 7.6641667 0.065495
+ 7.6644444 0.099318
+ 7.6647222 0.147195
+ 7.6650000 0.204847
+ 7.6652778 0.268000
+ 7.6655556 0.332376
+ 7.6658333 0.393698
+ 7.6661111 0.447691
+ 7.6663889 0.490077
+ 7.6666667 0.516581
+ 7.6669444 0.524218
+ 7.6672222 0.515180
+ 7.6675000 0.492948
+ 7.6677778 0.461007
+ 7.6680556 0.422839
+ 7.6683333 0.381927
+ 7.6686111 0.341756
+ 7.6688889 0.305807
+ 7.6691667 0.277564
+ 7.6694444 0.260510
+ 7.6697222 0.257180
+ 7.6700000 0.266316
+ 7.6702778 0.285711
+ 7.6705556 0.313158
+ 7.6708333 0.346451
+ 7.6711111 0.383383
+ 7.6713889 0.421747
+ 7.6716667 0.459337
+ 7.6719444 0.493946
+ 7.6722222 0.523367
+ 7.6725000 0.545808
+ 7.6727778 0.561130
+ 7.6730556 0.569610
+ 7.6733333 0.571523
+ 7.6736111 0.567144
+ 7.6738889 0.556750
+ 7.6741667 0.540617
+ 7.6744444 0.519019
+ 7.6747222 0.492234
+ 7.6750000 0.460536
+ 7.6752778 0.424318
+ 7.6755556 0.384434
+ 7.6758333 0.341857
+ 7.6761111 0.297558
+ 7.6763889 0.252508
+ 7.6766667 0.207679
+ 7.6769444 0.164042
+ 7.6772222 0.122569
+ 7.6775000 0.084231
+ 7.6777778 0.050000
+ 7.6780556 0.050000
+ 7.6783333 0.050000
+ 7.6786111 0.050000
+ 7.6788889 0.050000
+ 7.6791667 0.050000
+ 7.6794444 0.050000
+ 7.6797222 0.050000
+ 7.6800000 0.050000
+ 7.6802778 0.050000
+ 7.6805556 0.050000
+ 7.6808333 0.092373
+ 7.6811111 0.141174
+ 7.6813889 0.193872
+ 7.6816667 0.247939
+ 7.6819444 0.300847
+ 7.6822222 0.350065
+ 7.6825000 0.393064
+ 7.6827778 0.427317
+ 7.6830556 0.450293
+ 7.6833333 0.459464
+ 7.6836111 0.453125
+ 7.6838889 0.432867
+ 7.6841667 0.401107
+ 7.6844444 0.360260
+ 7.6847222 0.312742
+ 7.6850000 0.260969
+ 7.6852778 0.207357
+ 7.6855556 0.154323
+ 7.6858333 0.104280
+ 7.6861111 0.059647
+ 7.6863889 0.050000
+ 7.6866667 0.050000
+ 7.6869444 0.050000
+ 7.6872222 0.050000
+ 7.6875000 0.050000
+ 7.6877778 0.050000
+ 7.6880556 0.050000
+ 7.6883333 0.050000
+ 7.6886111 0.050000
+ 7.6888889 0.050000
+ 7.6891667 0.094039
+ 7.6894444 0.144035
+ 7.6897222 0.197497
+ 7.6900000 0.251935
+ 7.6902778 0.304859
+ 7.6905556 0.353780
+ 7.6908333 0.396206
+ 7.6911111 0.429649
+ 7.6913889 0.451617
+ 7.6916667 0.459621
+ 7.6919444 0.451997
+ 7.6922222 0.430385
+ 7.6925000 0.397254
+ 7.6927778 0.355069
+ 7.6930556 0.306298
+ 7.6933333 0.253408
+ 7.6936111 0.198866
+ 7.6938889 0.145140
+ 7.6941667 0.094695
+ 7.6944444 0.050000
+ 7.6947222 0.050000
+ 7.6950000 0.050000
+ 7.6952778 0.050000
+ 7.6955556 0.050000
+ 7.6958333 0.050000
+ 7.6961111 0.050000
+ 7.6963889 0.050000
+ 7.6966667 0.050000
+ 7.6969444 0.050000
+ 7.6972222 0.050000
+ 7.6975000 0.094590
+ 7.6977778 0.144900
+ 7.6980556 0.198481
+ 7.6983333 0.252889
+ 7.6986111 0.305674
+ 7.6988889 0.354391
+ 7.6991667 0.396593
+ 7.6994444 0.429832
+ 7.6997222 0.451661
+ 7.7000000 0.459634
+ 7.7002778 0.452117
+ 7.7005556 0.430735
+ 7.7008333 0.397923
+ 7.7011111 0.356119
+ 7.7013889 0.307761
+ 7.7016667 0.255285
+ 7.7019444 0.201129
+ 7.7022222 0.147730
+ 7.7025000 0.097525
+ 7.7027778 0.052952
+ 7.7030556 0.050000
+ 7.7033333 0.050000
+ 7.7036111 0.050000
+ 7.7038889 0.050000
+ 7.7041667 0.050000
+ 7.7044444 0.050000
+ 7.7047222 0.050000
+ 7.7050000 0.050000
+ 7.7052778 0.050000
+ 7.7055556 0.050000
+ 7.7058333 0.094379
+ 7.7061111 0.144553
+ 7.7063889 0.198064
+ 7.7066667 0.252455
+ 7.7069444 0.305267
+ 7.7072222 0.354042
+ 7.7075000 0.396323
+ 7.7077778 0.429652
+ 7.7080556 0.451570
+ 7.7083333 0.459621
+ 7.7086111 0.452161
+ 7.7088889 0.430816
+ 7.7091667 0.398025
+ 7.7094444 0.356227
+ 7.7097222 0.307863
+ 7.7100000 0.255374
+ 7.7102778 0.201198
+ 7.7105556 0.147775
+ 7.7108333 0.097547
+ 7.7111111 0.052952
+ 7.7113889 0.050000
+ 7.7116667 0.050000
+ 7.7119444 0.050000
+ 7.7122222 0.050000
+ 7.7125000 0.050000
+ 7.7127778 0.050000
+ 7.7130556 0.050000
+ 7.7133333 0.050000
+ 7.7136111 0.050000
+ 7.7138889 0.050000
+ 7.7141667 0.094393
+ 7.7144444 0.144581
+ 7.7147222 0.198106
+ 7.7150000 0.252509
+ 7.7152778 0.305331
+ 7.7155556 0.354112
+ 7.7158333 0.396395
+ 7.7161111 0.429720
+ 7.7163889 0.451628
+ 7.7166667 0.459660
+ 7.7169444 0.452175
+ 7.7172222 0.430799
+ 7.7175000 0.397976
+ 7.7177778 0.356149
+ 7.7180556 0.307762
+ 7.7183333 0.255259
+ 7.7186111 0.201082
+ 7.7188889 0.147677
+ 7.7191667 0.097485
+ 7.7194444 0.052952
+ 7.7197222 0.050000
+ 7.7200000 0.050000
+ 7.7202778 0.050000
+ 7.7205556 0.050000
+ 7.7208333 0.050000
+ 7.7211111 0.050000
+ 7.7213889 0.050000
+ 7.7216667 0.050000
+ 7.7219444 0.050000
+ 7.7222222 0.050000
+ 7.7225000 0.094062
+ 7.7227778 0.143865
+ 7.7230556 0.197000
+ 7.7233333 0.251055
+ 7.7236111 0.303618
+ 7.7238889 0.352278
+ 7.7241667 0.394623
+ 7.7244444 0.428243
+ 7.7247222 0.450726
+ 7.7250000 0.459660
+ 7.7252778 0.453427
+ 7.7255556 0.433582
+ 7.7258333 0.402469
+ 7.7261111 0.362437
+ 7.7263889 0.315832
+ 7.7266667 0.265000
+ 7.7269444 0.212289
+ 7.7272222 0.160044
+ 7.7275000 0.110613
+ 7.7277778 0.066342
+ 7.7280556 0.050000
+ 7.7283333 0.050000
+ 7.7286111 0.050000
+ 7.7288889 0.050000
+ 7.7291667 0.050000
+ 7.7294444 0.050000
+ 7.7297222 0.050000
+ 7.7300000 0.050000
+ 7.7302778 0.050000
+ 7.7305556 0.050000
+ 7.7308333 0.093245
+ 7.7311111 0.142570
+ 7.7313889 0.195506
+ 7.7316667 0.249583
+ 7.7319444 0.302330
+ 7.7322222 0.351276
+ 7.7325000 0.393953
+ 7.7327778 0.427889
+ 7.7330556 0.450615
+ 7.7333333 0.459660
+ 7.7336111 0.453363
+ 7.7338889 0.433297
+ 7.7341667 0.401845
+ 7.7344444 0.361389
+ 7.7347222 0.314312
+ 7.7350000 0.262997
+ 7.7352778 0.209825
+ 7.7355556 0.157179
+ 7.7358333 0.107441
+ 7.7361111 0.062994
+ 7.7363889 0.050000
+ 7.7366667 0.050000
+ 7.7369444 0.050000
+ 7.7372222 0.050000
+ 7.7375000 0.050000
+ 7.7377778 0.050000
+ 7.7380556 0.050000
+ 7.7383333 0.050000
+ 7.7386111 0.050000
+ 7.7388889 0.050000
+ 7.7391667 0.093576
+ 7.7394444 0.143160
+ 7.7397222 0.196281
+ 7.7400000 0.250470
+ 7.7402778 0.303256
+ 7.7405556 0.352169
+ 7.7408333 0.394738
+ 7.7411111 0.428495
+ 7.7413889 0.450967
+ 7.7416667 0.459686
+ 7.7419444 0.452994
+ 7.7422222 0.432483
+ 7.7425000 0.400561
+ 7.7427778 0.359632
+ 7.7430556 0.312102
+ 7.7433333 0.260377
+ 7.7436111 0.206864
+ 7.7438889 0.153967
+ 7.7441667 0.104093
+ 7.7444444 0.059647
+ 7.7447222 0.050000
+ 7.7450000 0.050000
+ 7.7452778 0.050000
+ 7.7455556 0.050000
+ 7.7458333 0.050000
+ 7.7461111 0.050000
+ 7.7463889 0.050000
+ 7.7466667 0.050000
+ 7.7469444 0.050000
+ 7.7472222 0.050000
+ 7.7475000 0.093545
+ 7.7477778 0.142978
+ 7.7480556 0.195876
+ 7.7483333 0.249815
+ 7.7486111 0.302372
+ 7.7488889 0.351126
+ 7.7491667 0.393651
+ 7.7494444 0.427526
+ 7.7497222 0.450328
+ 7.7500000 0.459634
+ 7.7502778 0.453812
+ 7.7505556 0.434403
+ 7.7508333 0.403736
+ 7.7511111 0.364143
+ 7.7513889 0.317956
+ 7.7516667 0.267505
+ 7.7519444 0.215122
+ 7.7522222 0.163137
+ 7.7525000 0.113883
+ 7.7527778 0.069689
+ 7.7530556 0.050000
+ 7.7533333 0.050000
+ 7.7536111 0.050000
+ 7.7538889 0.050000
+ 7.7541667 0.050000
+ 7.7544444 0.050000
+ 7.7547222 0.050000
+ 7.7550000 0.050000
+ 7.7552778 0.050000
+ 7.7555556 0.050000
+ 7.7558333 0.092778
+ 7.7561111 0.141676
+ 7.7563889 0.194247
+ 7.7566667 0.248044
+ 7.7569444 0.300624
+ 7.7572222 0.349537
+ 7.7575000 0.392340
+ 7.7577778 0.426586
+ 7.7580556 0.449828
+ 7.7583333 0.459621
+ 7.7586111 0.454311
+ 7.7588889 0.435420
+ 7.7591667 0.405262
+ 7.7594444 0.366150
+ 7.7597222 0.320398
+ 7.7600000 0.270321
+ 7.7602778 0.218232
+ 7.7605556 0.166446
+ 7.7608333 0.117276
+ 7.7611111 0.073037
+ 7.7613889 0.050000
+ 7.7616667 0.050000
+ 7.7619444 0.050000
+ 7.7622222 0.050000
+ 7.7625000 0.050000
+ 7.7627778 0.050000
+ 7.7630556 0.050000
+ 7.7633333 0.050000
+ 7.7636111 0.050000
+ 7.7638889 0.050000
+ 7.7641667 0.092821
+ 7.7644444 0.141879
+ 7.7647222 0.194680
+ 7.7650000 0.248732
+ 7.7652778 0.301541
+ 7.7655556 0.350613
+ 7.7658333 0.393456
+ 7.7661111 0.427576
+ 7.7663889 0.450479
+ 7.7666667 0.459673
+ 7.7669444 0.453478
+ 7.7672222 0.433470
+ 7.7675000 0.402040
+ 7.7677778 0.361578
+ 7.7680556 0.314474
+ 7.7683333 0.263119
+ 7.7686111 0.209904
+ 7.7688889 0.157217
+ 7.7691667 0.107451
+ 7.7694444 0.062994
+ 7.7697222 0.050000
+ 7.7700000 0.050000
+ 7.7702778 0.050000
+ 7.7705556 0.050000
+ 7.7708333 0.050000
+ 7.7711111 0.050000
+ 7.7713889 0.050000
+ 7.7716667 0.050000
+ 7.7719444 0.050000
+ 7.7722222 0.050000
+ 7.7725000 0.093412
+ 7.7727778 0.142800
+ 7.7730556 0.195720
+ 7.7733333 0.249726
+ 7.7736111 0.302373
+ 7.7738889 0.351215
+ 7.7741667 0.393808
+ 7.7744444 0.427705
+ 7.7747222 0.450462
+ 7.7750000 0.459634
+ 7.7752778 0.453575
+ 7.7755556 0.433840
+ 7.7758333 0.402786
+ 7.7761111 0.362769
+ 7.7763889 0.316143
+ 7.7766667 0.265265
+ 7.7769444 0.212490
+ 7.7772222 0.160174
+ 7.7775000 0.110673
+ 7.7777778 0.066342
+ 7.7780556 0.050000
+ 7.7783333 0.050000
+ 7.7786111 0.050000
+ 7.7788889 0.050000
+ 7.7791667 0.050000
+ 7.7794444 0.050000
+ 7.7797222 0.050000
+ 7.7800000 0.050000
+ 7.7802778 0.050000
+ 7.7805556 0.050000
+ 7.7808333 0.093247
+ 7.7811111 0.142569
+ 7.7813889 0.195498
+ 7.7816667 0.249564
+ 7.7819444 0.302298
+ 7.7822222 0.351234
+ 7.7825000 0.393901
+ 7.7827778 0.427831
+ 7.7830556 0.450556
+ 7.7833333 0.459608
+ 7.7836111 0.453325
+ 7.7838889 0.433278
+ 7.7841667 0.401849
+ 7.7844444 0.361416
+ 7.7847222 0.314359
+ 7.7850000 0.263057
+ 7.7852778 0.209890
+ 7.7855556 0.157237
+ 7.7858333 0.107479
+ 7.7861111 0.062994
+ 7.7863889 0.050000
+ 7.7866667 0.050000
+ 7.7869444 0.050000
+ 7.7872222 0.050000
+ 7.7875000 0.050000
+ 7.7877778 0.050000
+ 7.7880556 0.050000
+ 7.7883333 0.050000
+ 7.7886111 0.050000
+ 7.7888889 0.050000
+ 7.7891667 0.093801
+ 7.7894444 0.143646
+ 7.7897222 0.197031
+ 7.7900000 0.251454
+ 7.7902778 0.304412
+ 7.7905556 0.353402
+ 7.7908333 0.395920
+ 7.7911111 0.429465
+ 7.7913889 0.451533
+ 7.7916667 0.459621
+ 7.7919444 0.452055
+ 7.7922222 0.430477
+ 7.7925000 0.397359
+ 7.7927778 0.355173
+ 7.7930556 0.306389
+ 7.7933333 0.253478
+ 7.7936111 0.198913
+ 7.7938889 0.145164
+ 7.7941667 0.094702
+ 7.7944444 0.050000
+ 7.7947222 0.050000
+ 7.7950000 0.050000
+ 7.7952778 0.050000
+ 7.7955556 0.050000
+ 7.7958333 0.050000
+ 7.7961111 0.050000
+ 7.7963889 0.050000
+ 7.7966667 0.050000
+ 7.7969444 0.050000
+ 7.7972222 0.050000
+ 7.7975000 0.094510
+ 7.7977778 0.144723
+ 7.7980556 0.198206
+ 7.7983333 0.252524
+ 7.7986111 0.305241
+ 7.7988889 0.353925
+ 7.7991667 0.396139
+ 7.7994444 0.429449
+ 7.7997222 0.451422
+ 7.8000000 0.459621
+ 7.8002778 0.452420
+ 7.8005556 0.431424
+ 7.8008333 0.399046
+ 7.8011111 0.357696
+ 7.8013889 0.309788
+ 7.8016667 0.257733
+ 7.8019444 0.203945
+ 7.8022222 0.150835
+ 7.8025000 0.100816
+ 7.8027778 0.056299
+ 7.8030556 0.050000
+ 7.8033333 0.050000
+ 7.8036111 0.050000
+ 7.8038889 0.050000
+ 7.8041667 0.050000
+ 7.8044444 0.050000
+ 7.8047222 0.050000
+ 7.8050000 0.050000
+ 7.8052778 0.050000
+ 7.8055556 0.050000
+ 7.8058333 0.094227
+ 7.8061111 0.144342
+ 7.8063889 0.197866
+ 7.8066667 0.252318
+ 7.8069444 0.305217
+ 7.8072222 0.354085
+ 7.8075000 0.396440
+ 7.8077778 0.429804
+ 7.8080556 0.451695
+ 7.8083333 0.459634
+ 7.8086111 0.451964
+ 7.8088889 0.430326
+ 7.8091667 0.397183
+ 7.8094444 0.354999
+ 7.8097222 0.306238
+ 7.8100000 0.253363
+ 7.8102778 0.198838
+ 7.8105556 0.145126
+ 7.8108333 0.094693
+ 7.8111111 0.050000
+ 7.8113889 0.050000
+ 7.8116667 0.050000
+ 7.8119444 0.050000
+ 7.8122222 0.050000
+ 7.8125000 0.050000
+ 7.8127778 0.050000
+ 7.8130556 0.050000
+ 7.8133333 0.050000
+ 7.8136111 0.050000
+ 7.8138889 0.050000
+ 7.8141667 0.094662
+ 7.8144444 0.145056
+ 7.8147222 0.198726
+ 7.8150000 0.253213
+ 7.8152778 0.306060
+ 7.8155556 0.354809
+ 7.8158333 0.397002
+ 7.8161111 0.430183
+ 7.8163889 0.451892
+ 7.8166667 0.459673
+ 7.8169444 0.451887
+ 7.8172222 0.430173
+ 7.8175000 0.396989
+ 7.8177778 0.354792
+ 7.8180556 0.306041
+ 7.8183333 0.253194
+ 7.8186111 0.198708
+ 7.8188889 0.145042
+ 7.8191667 0.094653
+ 7.8194444 0.050000
+ 7.8197222 0.050000
+ 7.8200000 0.050000
+ 7.8202778 0.050000
+ 7.8205556 0.050000
+ 7.8208333 0.050000
+ 7.8211111 0.050000
+ 7.8213889 0.050000
+ 7.8216667 0.050000
+ 7.8219444 0.050000
+ 7.8222222 0.050000
+ 7.8225000 0.094653
+ 7.8227778 0.145041
+ 7.8230556 0.198707
+ 7.8233333 0.253192
+ 7.8236111 0.306038
+ 7.8238889 0.354788
+ 7.8241667 0.396983
+ 7.8244444 0.430165
+ 7.8247222 0.451877
+ 7.8250000 0.459660
+ 7.8252778 0.451876
+ 7.8255556 0.430164
+ 7.8258333 0.396981
+ 7.8261111 0.354786
+ 7.8263889 0.306036
+ 7.8266667 0.253190
+ 7.8269444 0.198705
+ 7.8272222 0.145040
+ 7.8275000 0.094652
+ 7.8277778 0.050000
+ 7.8280556 0.050000
+ 7.8283333 0.050000
+ 7.8286111 0.050000
+ 7.8288889 0.050000
+ 7.8291667 0.050000
+ 7.8294444 0.050000
+ 7.8297222 0.050000
+ 7.8300000 0.050000
+ 7.8302778 0.050000
+ 7.8305556 0.050000
+ 7.8308333 0.094649
+ 7.8311111 0.145033
+ 7.8313889 0.198694
+ 7.8316667 0.253173
+ 7.8319444 0.306014
+ 7.8322222 0.354759
+ 7.8325000 0.396950
+ 7.8327778 0.430129
+ 7.8330556 0.451838
+ 7.8333333 0.459621
+ 7.8336111 0.451838
+ 7.8338889 0.430128
+ 7.8341667 0.396948
+ 7.8344444 0.354757
+ 7.8347222 0.306012
+ 7.8350000 0.253171
+ 7.8352778 0.198692
+ 7.8355556 0.145032
+ 7.8358333 0.094648
+ 7.8361111 0.050000
+ 7.8363889 0.050000
+ 7.8366667 0.050000
+ 7.8369444 0.050000
+ 7.8372222 0.050000
+ 7.8375000 0.050000
+ 7.8377778 0.050000
+ 7.8380556 0.050000
+ 7.8383333 0.050000
+ 7.8386111 0.050000
+ 7.8388889 0.050000
+ 7.8391667 0.094647
+ 7.8394444 0.145029
+ 7.8397222 0.198688
+ 7.8400000 0.253166
+ 7.8402778 0.306005
+ 7.8405556 0.354749
+ 7.8408333 0.396938
+ 7.8411111 0.430116
+ 7.8413889 0.451825
+ 7.8416667 0.459608
+ 7.8419444 0.451825
+ 7.8422222 0.430116
+ 7.8425000 0.396937
+ 7.8427778 0.354748
+ 7.8430556 0.306004
+ 7.8433333 0.253165
+ 7.8436111 0.198687
+ 7.8438889 0.145029
+ 7.8441667 0.094647
+ 7.8444444 0.050000
+ 7.8447222 0.050000
+ 7.8450000 0.050000
+ 7.8452778 0.050000
+ 7.8455556 0.050000
+ 7.8458333 0.050000
+ 7.8461111 0.050000
+ 7.8463889 0.050000
+ 7.8466667 0.050000
+ 7.8469444 0.050000
+ 7.8472222 0.050000
+ 7.8475000 0.094646
+ 7.8477778 0.145027
+ 7.8480556 0.198684
+ 7.8483333 0.253160
+ 7.8486111 0.305998
+ 7.8488889 0.354739
+ 7.8491667 0.396928
+ 7.8494444 0.430105
+ 7.8497222 0.451813
+ 7.8500000 0.459595
+ 7.8502778 0.451812
+ 7.8505556 0.430103
+ 7.8508333 0.396925
+ 7.8511111 0.354736
+ 7.8513889 0.305994
+ 7.8516667 0.253156
+ 7.8519444 0.198680
+ 7.8522222 0.145024
+ 7.8525000 0.094645
+ 7.8527778 0.050000
+ 7.8530556 0.050000
+ 7.8533333 0.050000
+ 7.8536111 0.050000
+ 7.8538889 0.050000
+ 7.8541667 0.050000
+ 7.8544444 0.050000
+ 7.8547222 0.050000
+ 7.8550000 0.050000
+ 7.8552778 0.050000
+ 7.8555556 0.050000
+ 7.8558333 0.094640
+ 7.8561111 0.145013
+ 7.8563889 0.198661
+ 7.8566667 0.253129
+ 7.8569444 0.305958
+ 7.8572222 0.354691
+ 7.8575000 0.396872
+ 7.8577778 0.430044
+ 7.8580556 0.451749
+ 7.8583333 0.459529
+ 7.8586111 0.451748
+ 7.8588889 0.430043
+ 7.8591667 0.396871
+ 7.8594444 0.354690
+ 7.8597222 0.305956
+ 7.8600000 0.253127
+ 7.8602778 0.198660
+ 7.8605556 0.145011
+ 7.8608333 0.094639
+ 7.8611111 0.050000
+ 7.8613889 0.050000
+ 7.8616667 0.050000
+ 7.8619444 0.050000
+ 7.8622222 0.050000
+ 7.8625000 0.050000
+ 7.8627778 0.050000
+ 7.8630556 0.050000
+ 7.8633333 0.050000
+ 7.8636111 0.050000
+ 7.8638889 0.050000
+ 7.8641667 0.094641
+ 7.8644444 0.145016
+ 7.8647222 0.198668
+ 7.8650000 0.253138
+ 7.8652778 0.305971
+ 7.8655556 0.354708
+ 7.8658333 0.396893
+ 7.8661111 0.430067
+ 7.8663889 0.451774
+ 7.8666667 0.459555
+ 7.8669444 0.451774
+ 7.8672222 0.430068
+ 7.8675000 0.396894
+ 7.8677778 0.354710
+ 7.8680556 0.305973
+ 7.8683333 0.253140
+ 7.8686111 0.198669
+ 7.8688889 0.145017
+ 7.8691667 0.094642
+ 7.8694444 0.050000
+ 7.8697222 0.050000
+ 7.8700000 0.050000
+ 7.8702778 0.050000
+ 7.8705556 0.050000
+ 7.8708333 0.050000
+ 7.8711111 0.050000
+ 7.8713889 0.050000
+ 7.8716667 0.050000
+ 7.8719444 0.050000
+ 7.8722222 0.050000
+ 7.8725000 0.094642
+ 7.8727778 0.145018
+ 7.8730556 0.198670
+ 7.8733333 0.253142
+ 7.8736111 0.305976
+ 7.8738889 0.354714
+ 7.8741667 0.396900
+ 7.8744444 0.430076
+ 7.8747222 0.451784
+ 7.8750000 0.459568
+ 7.8752778 0.451790
+ 7.8755556 0.430086
+ 7.8758333 0.396915
+ 7.8761111 0.354732
+ 7.8763889 0.305996
+ 7.8766667 0.253163
+ 7.8769444 0.198689
+ 7.8772222 0.145033
+ 7.8775000 0.094651
+ 7.8777778 0.050000
+ 7.8780556 0.050000
+ 7.8783333 0.050000
+ 7.8786111 0.050000
+ 7.8788889 0.050000
+ 7.8791667 0.050000
+ 7.8794444 0.050000
+ 7.8797222 0.050000
+ 7.8800000 0.050000
+ 7.8802778 0.050000
+ 7.8805556 0.050000
+ 7.8808333 0.094685
+ 7.8811111 0.145110
+ 7.8813889 0.198814
+ 7.8816667 0.253331
+ 7.8819444 0.306201
+ 7.8822222 0.354958
+ 7.8825000 0.397141
+ 7.8827778 0.430285
+ 7.8830556 0.451929
+ 7.8833333 0.459608
+ 7.8836111 0.451683
+ 7.8838889 0.429809
+ 7.8841667 0.396463
+ 7.8844444 0.354124
+ 7.8847222 0.305270
+ 7.8850000 0.252378
+ 7.8852778 0.197927
+ 7.8855556 0.144395
+ 7.8858333 0.094260
+ 7.8861111 0.050000
+ 7.8863889 0.050000
+ 7.8866667 0.050000
+ 7.8869444 0.050000
+ 7.8872222 0.050000
+ 7.8875000 0.050000
+ 7.8877778 0.050000
+ 7.8880556 0.050000
+ 7.8883333 0.050000
+ 7.8886111 0.050000
+ 7.8888889 0.054678
+ 7.8891667 0.098851
+ 7.8894444 0.148529
+ 7.8897222 0.201340
+ 7.8900000 0.254918
+ 7.8902778 0.306892
+ 7.8905556 0.354893
+ 7.8908333 0.396552
+ 7.8911111 0.429501
+ 7.8913889 0.451371
+ 7.8916667 0.459791
+ 7.8919444 0.453180
+ 7.8922222 0.433101
+ 7.8925000 0.401905
+ 7.8927778 0.361943
+ 7.8930556 0.315564
+ 7.8933333 0.265120
+ 7.8936111 0.212959
+ 7.8938889 0.161434
+ 7.8941667 0.112894
+ 7.8944444 0.069689
+ 7.8947222 0.050000
+ 7.8950000 0.050000
+ 7.8952778 0.050000
+ 7.8955556 0.050000
+ 7.8958333 0.050000
+ 7.8961111 0.050000
+ 7.8963889 0.050000
+ 7.8966667 0.050000
+ 7.8969444 0.050000
+ 7.8972222 0.061478
+ 7.8975000 0.103696
+ 7.8977778 0.151580
+ 7.8980556 0.202805
+ 7.8983333 0.255049
+ 7.8986111 0.305990
+ 7.8988889 0.353305
+ 7.8991667 0.394672
+ 7.8994444 0.427768
+ 7.8997222 0.450270
+ 7.9000000 0.459856
+ 7.9002778 0.454965
+ 7.9005556 0.437086
+ 7.9008333 0.408468
+ 7.9011111 0.371362
+ 7.9013889 0.328017
+ 7.9016667 0.280684
+ 7.9019444 0.231612
+ 7.9022222 0.183053
+ 7.9025000 0.137255
+ 7.9027778 0.096469
+ 7.9030556 0.062575
+ 7.9033333 0.050000
+ 7.9036111 0.050000
+ 7.9038889 0.050000
+ 7.9041667 0.050000
+ 7.9044444 0.050000
+ 7.9047222 0.050000
+ 7.9050000 0.050000
+ 7.9052778 0.055786
+ 7.9055556 0.088349
+ 7.9058333 0.128048
+ 7.9061111 0.173051
+ 7.9063889 0.221158
+ 7.9066667 0.270166
+ 7.9069444 0.317874
+ 7.9072222 0.362080
+ 7.9075000 0.400583
+ 7.9077778 0.431181
+ 7.9080556 0.451673
+ 7.9083333 0.459856
+ 7.9086111 0.454256
+ 7.9088889 0.436301
+ 7.9091667 0.408146
+ 7.9094444 0.371948
+ 7.9097222 0.329860
+ 7.9100000 0.284037
+ 7.9102778 0.236637
+ 7.9105556 0.189812
+ 7.9108333 0.145719
+ 7.9111111 0.106512
+ 7.9113889 0.073991
+ 7.9116667 0.050000
+ 7.9119444 0.050000
+ 7.9122222 0.050000
+ 7.9125000 0.050000
+ 7.9127778 0.050000
+ 7.9130556 0.050000
+ 7.9133333 0.050000
+ 7.9136111 0.070000
+ 7.9138889 0.101857
+ 7.9141667 0.140614
+ 7.9144444 0.184476
+ 7.9147222 0.231281
+ 7.9150000 0.278871
+ 7.9152778 0.325086
+ 7.9155556 0.367764
+ 7.9158333 0.404747
+ 7.9161111 0.433875
+ 7.9163889 0.452986
+ 7.9166667 0.459922
+ 7.9169444 0.453237
+ 7.9172222 0.434349
+ 7.9175000 0.405390
+ 7.9177778 0.368492
+ 7.9180556 0.325789
+ 7.9183333 0.279412
+ 7.9186111 0.231494
+ 7.9188889 0.184167
+ 7.9191667 0.139564
+ 7.9194444 0.099817
+ 7.9197222 0.066712
+ 7.9200000 0.050000
+ 7.9202778 0.050000
+ 7.9205556 0.050000
+ 7.9208333 0.050000
+ 7.9211111 0.050000
+ 7.9213889 0.050000
+ 7.9216667 0.050000
+ 7.9219444 0.059602
+ 7.9222222 0.091697
+ 7.9225000 0.130918
+ 7.9227778 0.175448
+ 7.9230556 0.223097
+ 7.9233333 0.271673
+ 7.9236111 0.318986
+ 7.9238889 0.362843
+ 7.9241667 0.401055
+ 7.9244444 0.431431
+ 7.9247222 0.451779
+ 7.9250000 0.459908
+ 7.9252778 0.454348
+ 7.9255556 0.436503
+ 7.9258333 0.408498
+ 7.9261111 0.372460
+ 7.9263889 0.330512
+ 7.9266667 0.284780
+ 7.9269444 0.237389
+ 7.9272222 0.190464
+ 7.9275000 0.146130
+ 7.9277778 0.106512
+ 7.9280556 0.073393
+ 7.9283333 0.050000
+ 7.9286111 0.050000
+ 7.9288889 0.050000
+ 7.9291667 0.050000
+ 7.9294444 0.050000
+ 7.9297222 0.050000
+ 7.9300000 0.050000
+ 7.9302778 0.063403
+ 7.9305556 0.095110
+ 7.9308333 0.134000
+ 7.9311111 0.178245
+ 7.9313889 0.225637
+ 7.9316667 0.273965
+ 7.9319444 0.321022
+ 7.9322222 0.364598
+ 7.9325000 0.402483
+ 7.9327778 0.432470
+ 7.9330556 0.452348
+ 7.9333333 0.459908
+ 7.9336111 0.453674
+ 7.9338889 0.435090
+ 7.9341667 0.406336
+ 7.9344444 0.369587
+ 7.9347222 0.327022
+ 7.9350000 0.280818
+ 7.9352778 0.233153
+ 7.9355556 0.186204
+ 7.9358333 0.142148
+ 7.9361111 0.103164
+ 7.9363889 0.071063
+ 7.9366667 0.050000
+ 7.9369444 0.050000
+ 7.9372222 0.050000
+ 7.9375000 0.050000
+ 7.9377778 0.050000
+ 7.9380556 0.050000
+ 7.9383333 0.050000
+ 7.9386111 0.072885
+ 7.9388889 0.105152
+ 7.9391667 0.144121
+ 7.9394444 0.188011
+ 7.9397222 0.234685
+ 7.9400000 0.282007
+ 7.9402778 0.327844
+ 7.9405556 0.370058
+ 7.9408333 0.406515
+ 7.9411111 0.435079
+ 7.9413889 0.453615
+ 7.9416667 0.459987
+ 7.9419444 0.452775
+ 7.9422222 0.433417
+ 7.9425000 0.404069
+ 7.9427778 0.366884
+ 7.9430556 0.324015
+ 7.9433333 0.277617
+ 7.9436111 0.229845
+ 7.9438889 0.182851
+ 7.9441667 0.138790
+ 7.9444444 0.099817
+ 7.9447222 0.067722
+ 7.9450000 0.050000
+ 7.9452778 0.050000
+ 7.9455556 0.050000
+ 7.9458333 0.050000
+ 7.9461111 0.050000
+ 7.9463889 0.050000
+ 7.9466667 0.050000
+ 7.9469444 0.069487
+ 7.9472222 0.101752
+ 7.9475000 0.140729
+ 7.9477778 0.184650
+ 7.9480556 0.231398
+ 7.9483333 0.278855
+ 7.9486111 0.324906
+ 7.9488889 0.367431
+ 7.9491667 0.404316
+ 7.9494444 0.433441
+ 7.9497222 0.452691
+ 7.9500000 0.459948
+ 7.9502778 0.453794
+ 7.9505556 0.435609
+ 7.9508333 0.407473
+ 7.9511111 0.371463
+ 7.9513889 0.329660
+ 7.9516667 0.284143
+ 7.9519444 0.236991
+ 7.9522222 0.190282
+ 7.9525000 0.146096
+ 7.9527778 0.106512
+ 7.9530556 0.073280
+ 7.9533333 0.050000
+ 7.9536111 0.050000
+ 7.9538889 0.050000
+ 7.9541667 0.050000
+ 7.9544444 0.050000
+ 7.9547222 0.050000
+ 7.9550000 0.050000
+ 7.9552778 0.060240
+ 7.9555556 0.091749
+ 7.9558333 0.130576
+ 7.9561111 0.174886
+ 7.9563889 0.222454
+ 7.9566667 0.271056
+ 7.9569444 0.318470
+ 7.9572222 0.362470
+ 7.9575000 0.400834
+ 7.9577778 0.431338
+ 7.9580556 0.451758
+ 7.9583333 0.459869
+ 7.9586111 0.454181
+ 7.9588889 0.436128
+ 7.9591667 0.407875
+ 7.9594444 0.371590
+ 7.9597222 0.329439
+ 7.9600000 0.283588
+ 7.9602778 0.236203
+ 7.9605556 0.189452
+ 7.9608333 0.145499
+ 7.9611111 0.106512
+ 7.9613889 0.074296
+ 7.9616667 0.050000
+ 7.9619444 0.050000
+ 7.9622222 0.050000
+ 7.9625000 0.050000
+ 7.9627778 0.050000
+ 7.9630556 0.050000
+ 7.9633333 0.050000
+ 7.9636111 0.073226
+ 7.9638889 0.105165
+ 7.9641667 0.143872
+ 7.9644444 0.187566
+ 7.9647222 0.234106
+ 7.9650000 0.281356
+ 7.9652778 0.327176
+ 7.9655556 0.369427
+ 7.9658333 0.405971
+ 7.9661111 0.434670
+ 7.9663889 0.453383
+ 7.9666667 0.459974
+ 7.9669444 0.453010
+ 7.9672222 0.433894
+ 7.9675000 0.404732
+ 7.9677778 0.367634
+ 7.9680556 0.324709
+ 7.9683333 0.278065
+ 7.9686111 0.229810
+ 7.9688889 0.182054
+ 7.9691667 0.136904
+ 7.9694444 0.096469
+ 7.9697222 0.062525
+ 7.9700000 0.050000
+ 7.9702778 0.050000
+ 7.9705556 0.050000
+ 7.9708333 0.050000
+ 7.9711111 0.050000
+ 7.9713889 0.050000
+ 7.9716667 0.050000
+ 7.9719444 0.050000
+ 7.9722222 0.081680
+ 7.9725000 0.121438
+ 7.9727778 0.166817
+ 7.9730556 0.215546
+ 7.9733333 0.265358
+ 7.9736111 0.313984
+ 7.9738889 0.359153
+ 7.9741667 0.398598
+ 7.9744444 0.430049
+ 7.9747222 0.451238
+ 7.9750000 0.459895
+ 7.9752778 0.454494
+ 7.9755556 0.436473
+ 7.9758333 0.408015
+ 7.9761111 0.371301
+ 7.9763889 0.328514
+ 7.9766667 0.281833
+ 7.9769444 0.233442
+ 7.9772222 0.185521
+ 7.9775000 0.140252
+ 7.9777778 0.099817
+ 7.9780556 0.066044
+ 7.9783333 0.050000
+ 7.9786111 0.050000
+ 7.9788889 0.050000
+ 7.9791667 0.050000
+ 7.9794444 0.050000
+ 7.9797222 0.050000
+ 7.9800000 0.050000
+ 7.9802778 0.056121
+ 7.9805556 0.088375
+ 7.9808333 0.127904
+ 7.9811111 0.172858
+ 7.9813889 0.221003
+ 7.9816667 0.270108
+ 7.9819444 0.317940
+ 7.9822222 0.362266
+ 7.9825000 0.400853
+ 7.9827778 0.431469
+ 7.9830556 0.451881
+ 7.9833333 0.459856
+ 7.9836111 0.453898
+ 7.9838889 0.435450
+ 7.9841667 0.406693
+ 7.9844444 0.369806
+ 7.9847222 0.326968
+ 7.9850000 0.280360
+ 7.9852778 0.232161
+ 7.9855556 0.184551
+ 7.9858333 0.139710
+ 7.9861111 0.099817
+ 7.9863889 0.066695
+ 7.9866667 0.050000
+ 7.9869444 0.050000
+ 7.9872222 0.050000
+ 7.9875000 0.050000
+ 7.9877778 0.050000
+ 7.9880556 0.050000
+ 7.9883333 0.050000
+ 7.9886111 0.062491
+ 7.9888889 0.095083
+ 7.9891667 0.134772
+ 7.9894444 0.179703
+ 7.9897222 0.227642
+ 7.9900000 0.276357
+ 7.9902778 0.323614
+ 7.9905556 0.367180
+ 7.9908333 0.404822
+ 7.9911111 0.434306
+ 7.9913889 0.453400
+ 7.9916667 0.459869
+ 7.9919444 0.452226
+ 7.9922222 0.431957
+ 7.9925000 0.401295
+ 7.9927778 0.362470
+ 7.9930556 0.317714
+ 7.9933333 0.269259
+ 7.9936111 0.219337
+ 7.9938889 0.170178
+ 7.9941667 0.124015
+ 7.9944444 0.083079
+ 7.9947222 0.050000
+ 7.9950000 0.050000
+ 7.9952778 0.050000
+ 7.9955556 0.050000
+ 7.9958333 0.050000
+ 7.9961111 0.050000
+ 7.9963889 0.050000
+ 7.9966667 0.050000
+ 7.9969444 0.050000
+ 7.9972222 0.081641
+ 7.9975000 0.122471
+ 7.9977778 0.168605
+ 7.9980556 0.217803
+ 7.9983333 0.267826
+ 7.9986111 0.316435
+ 7.9988889 0.361390
+ 7.9991667 0.400452
+ 7.9994444 0.431380
+ 7.9997222 0.451937
+ 8.0000000 0.459882
+ 8.0002778 0.453717
+ 8.0005556 0.434901
+ 8.0008333 0.405637
+ 8.0011111 0.368125
+ 8.0013889 0.324567
+ 8.0016667 0.277164
+ 8.0019444 0.228116
+ 8.0022222 0.179626
+ 8.0025000 0.133894
+ 8.0027778 0.093122
+ 8.0030556 0.059153
+ 8.0033333 0.050000
+ 8.0036111 0.050000
+ 8.0038889 0.050000
+ 8.0041667 0.050000
+ 8.0044444 0.050000
+ 8.0047222 0.050000
+ 8.0050000 0.050000
+ 8.0052778 0.051958
+ 8.0055556 0.084975
+ 8.0058333 0.125329
+ 8.0061111 0.171127
+ 8.0063889 0.220089
+ 8.0066667 0.269935
+ 8.0069444 0.318382
+ 8.0072222 0.363152
+ 8.0075000 0.401962
+ 8.0077778 0.432532
+ 8.0080556 0.452582
+ 8.0083333 0.459830
+ 8.0086111 0.452753
+ 8.0088889 0.432852
+ 8.0091667 0.402387
+ 8.0094444 0.363617
+ 8.0097222 0.318800
+ 8.0100000 0.270196
+ 8.0102778 0.220063
+ 8.0105556 0.170660
+ 8.0108333 0.124246
+ 8.0111111 0.083079
+ 8.0113889 0.050000
+ 8.0116667 0.050000
+ 8.0119444 0.050000
+ 8.0122222 0.050000
+ 8.0125000 0.050000
+ 8.0127778 0.050000
+ 8.0130556 0.050000
+ 8.0133333 0.050000
+ 8.0136111 0.050000
+ 8.0138889 0.081667
+ 8.0141667 0.122699
+ 8.0144444 0.169045
+ 8.0147222 0.218445
+ 8.0150000 0.268639
+ 8.0152778 0.317367
+ 8.0155556 0.362368
+ 8.0158333 0.401382
+ 8.0161111 0.432148
+ 8.0163889 0.452406
+ 8.0166667 0.459895
+ 8.0169444 0.453104
+ 8.0172222 0.433511
+ 8.0175000 0.403342
+ 8.0177778 0.364824
+ 8.0180556 0.320184
+ 8.0183333 0.271648
+ 8.0186111 0.221443
+ 8.0188889 0.171795
+ 8.0191667 0.124932
+ 8.0194444 0.083079
+ 8.0197222 0.050000
+ 8.0200000 0.050000
+ 8.0202778 0.050000
+ 8.0205556 0.050000
+ 8.0208333 0.050000
+ 8.0211111 0.050000
+ 8.0213889 0.050000
+ 8.0216667 0.050000
+ 8.0219444 0.050000
+ 8.0222222 0.071572
+ 8.0225000 0.112755
+ 8.0227778 0.159611
+ 8.0230556 0.209817
+ 8.0233333 0.261048
+ 8.0236111 0.310982
+ 8.0238889 0.357292
+ 8.0241667 0.397656
+ 8.0244444 0.429750
+ 8.0247222 0.451249
+ 8.0250000 0.459830
+ 8.0252778 0.453931
+ 8.0255556 0.435040
+ 8.0258333 0.405410
+ 8.0261111 0.367292
+ 8.0263889 0.322938
+ 8.0266667 0.274599
+ 8.0269444 0.224527
+ 8.0272222 0.174973
+ 8.0275000 0.128189
+ 8.0277778 0.086427
+ 8.0280556 0.051572
+ 8.0283333 0.050000
+ 8.0286111 0.050000
+ 8.0288889 0.050000
+ 8.0291667 0.050000
+ 8.0294444 0.050000
+ 8.0297222 0.050000
+ 8.0300000 0.050000
+ 8.0302778 0.050000
+ 8.0305556 0.074959
+ 8.0308333 0.115708
+ 8.0311111 0.162041
+ 8.0313889 0.211674
+ 8.0316667 0.262327
+ 8.0319444 0.311715
+ 8.0322222 0.357557
+ 8.0325000 0.397569
+ 8.0327778 0.429469
+ 8.0330556 0.450975
+ 8.0333333 0.459804
+ 8.0336111 0.454421
+ 8.0338889 0.436282
+ 8.0341667 0.407592
+ 8.0344444 0.370555
+ 8.0347222 0.327374
+ 8.0350000 0.280255
+ 8.0352778 0.231400
+ 8.0355556 0.183015
+ 8.0358333 0.137303
+ 8.0361111 0.096469
+ 8.0363889 0.062361
+ 8.0366667 0.050000
+ 8.0369444 0.050000
+ 8.0372222 0.050000
+ 8.0375000 0.050000
+ 8.0377778 0.050000
+ 8.0380556 0.050000
+ 8.0383333 0.050000
+ 8.0386111 0.052429
+ 8.0388889 0.085054
+ 8.0391667 0.125038
+ 8.0394444 0.170506
+ 8.0397222 0.219192
+ 8.0400000 0.268832
+ 8.0402778 0.317162
+ 8.0405556 0.361915
+ 8.0408333 0.400829
+ 8.0411111 0.431638
+ 8.0413889 0.452077
+ 8.0416667 0.459882
+ 8.0419444 0.453533
+ 8.0422222 0.434491
+ 8.0425000 0.404959
+ 8.0427778 0.367144
+ 8.0430556 0.323250
+ 8.0433333 0.275482
+ 8.0436111 0.226045
+ 8.0438889 0.177145
+ 8.0441667 0.130987
+ 8.0444444 0.089774
+ 8.0447222 0.055357
+ 8.0450000 0.050000
+ 8.0452778 0.050000
+ 8.0455556 0.050000
+ 8.0458333 0.050000
+ 8.0461111 0.050000
+ 8.0463889 0.050000
+ 8.0466667 0.050000
+ 8.0469444 0.050000
+ 8.0472222 0.078280
+ 8.0475000 0.118610
+ 8.0477778 0.164489
+ 8.0480556 0.213653
+ 8.0483333 0.263843
+ 8.0486111 0.312797
+ 8.0488889 0.358253
+ 8.0491667 0.397950
+ 8.0494444 0.429626
+ 8.0497222 0.451019
+ 8.0500000 0.459869
+ 8.0502778 0.454650
+ 8.0505556 0.436776
+ 8.0508333 0.408401
+ 8.0511111 0.371676
+ 8.0513889 0.328753
+ 8.0516667 0.281783
+ 8.0519444 0.232918
+ 8.0522222 0.184309
+ 8.0525000 0.138109
+ 8.0527778 0.096469
+ 8.0530556 0.061209
+ 8.0533333 0.050000
+ 8.0536111 0.050000
+ 8.0538889 0.050000
+ 8.0541667 0.050000
+ 8.0544444 0.050000
+ 8.0547222 0.050000
+ 8.0550000 0.050000
+ 8.0552778 0.050000
+ 8.0555556 0.071625
+ 8.0558333 0.111645
+ 8.0561111 0.157607
+ 8.0563889 0.207184
+ 8.0566667 0.258047
+ 8.0569444 0.307868
+ 8.0572222 0.354318
+ 8.0575000 0.395069
+ 8.0577778 0.427792
+ 8.0580556 0.450160
+ 8.0583333 0.459843
+ 8.0586111 0.455267
+ 8.0588889 0.437868
+ 8.0591667 0.409835
+ 8.0594444 0.373360
+ 8.0597222 0.330630
+ 8.0600000 0.283837
+ 8.0602778 0.235169
+ 8.0605556 0.186817
+ 8.0608333 0.140969
+ 8.0611111 0.099817
+ 8.0613889 0.065203
+ 8.0616667 0.050000
+ 8.0619444 0.050000
+ 8.0622222 0.050000
+ 8.0625000 0.050000
+ 8.0627778 0.050000
+ 8.0630556 0.050000
+ 8.0633333 0.050000
+ 8.0636111 0.050000
+ 8.0638889 0.081706
+ 8.0641667 0.121611
+ 8.0644444 0.167200
+ 8.0647222 0.216167
+ 8.0650000 0.266207
+ 8.0652778 0.315014
+ 8.0655556 0.360283
+ 8.0658333 0.399709
+ 8.0661111 0.430985
+ 8.0663889 0.451807
+ 8.0666667 0.459869
+ 8.0669444 0.453624
+ 8.0672222 0.434557
+ 8.0675000 0.404914
+ 8.0677778 0.366937
+ 8.0680556 0.322873
+ 8.0683333 0.274964
+ 8.0686111 0.225456
+ 8.0688889 0.176592
+ 8.0691667 0.130617
+ 8.0694444 0.089774
+ 8.0697222 0.055937
+ 8.0700000 0.050000
+ 8.0702778 0.050000
+ 8.0705556 0.050000
+ 8.0708333 0.050000
+ 8.0711111 0.050000
+ 8.0713889 0.050000
+ 8.0716667 0.050000
+ 8.0719444 0.052021
+ 8.0722222 0.085028
+ 8.0725000 0.125144
+ 8.0727778 0.170539
+ 8.0730556 0.219014
+ 8.0733333 0.268371
+ 8.0736111 0.316412
+ 8.0738889 0.360939
+ 8.0741667 0.399753
+ 8.0744444 0.430655
+ 8.0747222 0.451449
+ 8.0750000 0.459935
+ 8.0752778 0.454634
+ 8.0755556 0.436942
+ 8.0758333 0.408974
+ 8.0761111 0.372847
+ 8.0763889 0.330674
+ 8.0766667 0.284571
+ 8.0769444 0.236654
+ 8.0772222 0.189037
+ 8.0775000 0.143835
+ 8.0777778 0.103164
+ 8.0780556 0.068810
+ 8.0783333 0.050000
+ 8.0786111 0.050000
+ 8.0788889 0.050000
+ 8.0791667 0.050000
+ 8.0794444 0.050000
+ 8.0797222 0.050000
+ 8.0800000 0.050000
+ 8.0802778 0.050000
+ 8.0805556 0.081667
+ 8.0808333 0.121027
+ 8.0811111 0.166140
+ 8.0813889 0.214719
+ 8.0816667 0.264480
+ 8.0819444 0.313137
+ 8.0822222 0.358403
+ 8.0825000 0.397994
+ 8.0827778 0.429624
+ 8.0830556 0.451006
+ 8.0833333 0.459856
+ 8.0836111 0.454631
+ 8.0838889 0.436764
+ 8.0841667 0.408430
+ 8.0844444 0.371806
+ 8.0847222 0.329067
+ 8.0850000 0.282390
+ 8.0852778 0.233950
+ 8.0855556 0.185924
+ 8.0858333 0.140488
+ 8.0861111 0.099817
+ 8.0863889 0.065739
+ 8.0866667 0.050000
+ 8.0869444 0.050000
+ 8.0872222 0.050000
+ 8.0875000 0.050000
+ 8.0877778 0.050000
+ 8.0880556 0.050000
+ 8.0883333 0.050000
+ 8.0886111 0.052964
+ 8.0888889 0.085093
+ 8.0891667 0.124606
+ 8.0894444 0.169648
+ 8.0897222 0.217975
+ 8.0900000 0.267346
+ 8.0902778 0.315517
+ 8.0905556 0.360245
+ 8.0908333 0.399289
+ 8.0911111 0.430405
+ 8.0913889 0.451350
+ 8.0916667 0.459882
+ 8.0919444 0.454489
+ 8.0922222 0.436582
+ 8.0925000 0.408302
+ 8.0927778 0.371791
+ 8.0930556 0.329192
+ 8.0933333 0.282645
+ 8.0936111 0.234292
+ 8.0938889 0.186275
+ 8.0941667 0.140736
+ 8.0944444 0.099817
+ 8.0947222 0.065321
+ 8.0950000 0.050000
+ 8.0952778 0.050000
+ 8.0955556 0.050000
+ 8.0958333 0.050000
+ 8.0961111 0.050000
+ 8.0963889 0.050000
+ 8.0966667 0.050000
+ 8.0969444 0.050000
+ 8.0972222 0.078320
+ 8.0975000 0.117449
+ 8.0977778 0.162283
+ 8.0980556 0.210601
+ 8.0983333 0.260184
+ 8.0986111 0.308811
+ 8.0988889 0.354262
+ 8.0991667 0.394316
+ 8.0994444 0.426753
+ 8.0997222 0.449353
+ 8.1000000 0.459895
+ 8.1002778 0.456866
+ 8.1005556 0.441576
+ 8.1008333 0.416042
+ 8.1011111 0.382282
+ 8.1013889 0.342311
+ 8.1016667 0.298147
+ 8.1019444 0.251807
+ 8.1022222 0.205309
+ 8.1025000 0.160668
+ 8.1027778 0.119902
+ 8.1030556 0.084737
+ 8.1033333 0.055737
+ 8.1036111 0.050000
+ 8.1038889 0.050000
+ 8.1041667 0.050000
+ 8.1044444 0.050000
+ 8.1047222 0.050000
+ 8.1050000 0.050000
+ 8.1052778 0.050000
+ 8.1055556 0.078359
+ 8.1058333 0.116664
+ 8.1061111 0.161227
+ 8.1063889 0.209689
+ 8.1066667 0.259688
+ 8.1069444 0.308866
+ 8.1072222 0.354862
+ 8.1075000 0.395318
+ 8.1077778 0.427873
+ 8.1080556 0.450168
+ 8.1083333 0.459843
+ 8.1086111 0.455298
+ 8.1088889 0.437973
+ 8.1091667 0.410066
+ 8.1094444 0.373776
+ 8.1097222 0.331304
+ 8.1100000 0.284847
+ 8.1102778 0.236606
+ 8.1105556 0.188779
+ 8.1108333 0.143565
+ 8.1111111 0.103164
+ 8.1113889 0.069419
+ 8.1116667 0.050000
+ 8.1119444 0.050000
+ 8.1122222 0.050000
+ 8.1125000 0.050000
+ 8.1127778 0.050000
+ 8.1130556 0.050000
+ 8.1133333 0.050000
+ 8.1136111 0.059532
+ 8.1138889 0.091762
+ 8.1141667 0.131256
+ 8.1144444 0.176151
+ 8.1147222 0.224199
+ 8.1150000 0.273151
+ 8.1152778 0.320759
+ 8.1155556 0.364773
+ 8.1158333 0.402947
+ 8.1161111 0.433030
+ 8.1163889 0.452776
+ 8.1166667 0.459935
+ 8.1169444 0.453014
+ 8.1172222 0.433540
+ 8.1175000 0.403798
+ 8.1177778 0.366068
+ 8.1180556 0.322636
+ 8.1183333 0.275782
+ 8.1186111 0.227790
+ 8.1188889 0.180944
+ 8.1191667 0.137525
+ 8.1194444 0.099817
+ 8.1197222 0.069689
+ 8.1200000 0.050000
+ 8.1202778 0.050000
+ 8.1205556 0.050000
+ 8.1208333 0.050000
+ 8.1211111 0.050000
+ 8.1213889 0.050000
+ 8.1216667 0.065786
+ 8.1219444 0.092396
+ 8.1222222 0.125198
+ 8.1225000 0.163700
+ 8.1227778 0.206256
+ 8.1230556 0.250927
+ 8.1233333 0.295776
+ 8.1236111 0.338864
+ 8.1238889 0.378254
+ 8.1241667 0.412009
+ 8.1244444 0.438189
+ 8.1247222 0.454858
+ 8.1250000 0.460078
+ 8.1252778 0.452575
+ 8.1255556 0.433729
+ 8.1258333 0.405584
+ 8.1261111 0.370184
+ 8.1263889 0.329573
+ 8.1266667 0.285796
+ 8.1269444 0.240896
+ 8.1272222 0.196918
+ 8.1275000 0.155905
+ 8.1277778 0.119902
+ 8.1280556 0.090600
+ 8.1283333 0.068276
+ 8.1286111 0.052857
+ 8.1288889 0.050000
+ 8.1291667 0.050000
+ 8.1294444 0.050000
+ 8.1297222 0.058727
+ 8.1300000 0.076707
+ 8.1302778 0.101142
+ 8.1305556 0.131958
+ 8.1308333 0.168766
+ 8.1311111 0.209917
+ 8.1313889 0.253451
+ 8.1316667 0.297404
+ 8.1319444 0.339816
+ 8.1322222 0.378724
+ 8.1325000 0.412166
+ 8.1327778 0.438180
+ 8.1330556 0.454805
+ 8.1333333 0.460078
+ 8.1336111 0.452711
+ 8.1338889 0.434108
+ 8.1341667 0.406343
+ 8.1344444 0.371496
+ 8.1347222 0.331641
+ 8.1350000 0.288856
+ 8.1352778 0.245217
+ 8.1355556 0.202801
+ 8.1358333 0.163685
+ 8.1361111 0.129944
+ 8.1363889 0.103274
+ 8.1366667 0.083836
+ 8.1369444 0.071408
+ 8.1372222 0.065772
+ 8.1375000 0.066705
+ 8.1377778 0.073987
+ 8.1380556 0.087397
+ 8.1383333 0.106715
+ 8.1386111 0.131720
+ 8.1388889 0.162190
+ 8.1391667 0.197647
+ 8.1394444 0.236576
+ 8.1397222 0.277203
+ 8.1400000 0.317755
+ 8.1402778 0.356459
+ 8.1405556 0.391541
+ 8.1408333 0.421228
+ 8.1411111 0.443746
+ 8.1413889 0.457322
+ 8.1416667 0.460183
+ 8.1419444 0.451176
+ 8.1422222 0.431630
+ 8.1425000 0.403496
+ 8.1427778 0.368725
+ 8.1430556 0.329267
+ 8.1433333 0.287073
+ 8.1436111 0.244093
+ 8.1438889 0.202278
+ 8.1441667 0.163578
+ 8.1444444 0.129944
+ 8.1447222 0.102977
+ 8.1450000 0.082882
+ 8.1452778 0.069512
+ 8.1455556 0.062724
+ 8.1458333 0.062372
+ 8.1461111 0.068312
+ 8.1463889 0.080397
+ 8.1466667 0.098484
+ 8.1469444 0.122428
+ 8.1472222 0.152082
+ 8.1475000 0.187033
+ 8.1477778 0.225780
+ 8.1480556 0.266555
+ 8.1483333 0.307589
+ 8.1486111 0.347112
+ 8.1488889 0.383355
+ 8.1491667 0.414549
+ 8.1494444 0.438925
+ 8.1497222 0.454713
+ 8.1500000 0.460144
+ 8.1502778 0.454043
+ 8.1505556 0.437614
+ 8.1508333 0.412653
+ 8.1511111 0.380958
+ 8.1513889 0.344327
+ 8.1516667 0.304556
+ 8.1519444 0.263444
+ 8.1522222 0.222787
+ 8.1525000 0.184383
+ 8.1527778 0.150029
+ 8.1530556 0.121238
+ 8.1533333 0.098376
+ 8.1536111 0.081525
+ 8.1538889 0.070768
+ 8.1541667 0.066187
+ 8.1544444 0.067864
+ 8.1547222 0.075879
+ 8.1550000 0.090317
+ 8.1552778 0.111258
+ 8.1555556 0.138784
+ 8.1558333 0.172643
+ 8.1561111 0.211247
+ 8.1563889 0.252671
+ 8.1566667 0.294994
+ 8.1569444 0.336290
+ 8.1572222 0.374638
+ 8.1575000 0.408114
+ 8.1577778 0.434795
+ 8.1580556 0.452758
+ 8.1583333 0.460078
+ 8.1586111 0.455463
+ 8.1588889 0.440130
+ 8.1591667 0.415928
+ 8.1594444 0.384704
+ 8.1597222 0.348306
+ 8.1600000 0.308582
+ 8.1602778 0.267380
+ 8.1605556 0.226546
+ 8.1608333 0.187929
+ 8.1611111 0.153377
+ 8.1613889 0.124441
+ 8.1616667 0.101491
+ 8.1619444 0.084600
+ 8.1622222 0.073841
+ 8.1625000 0.069287
+ 8.1627778 0.071013
+ 8.1630556 0.079091
+ 8.1633333 0.093594
+ 8.1636111 0.114596
+ 8.1638889 0.142171
+ 8.1641667 0.176055
+ 8.1644444 0.214646
+ 8.1647222 0.256003
+ 8.1650000 0.298188
+ 8.1652778 0.339260
+ 8.1655556 0.377280
+ 8.1658333 0.410309
+ 8.1661111 0.436407
+ 8.1663889 0.453635
+ 8.1666667 0.460052
+ 8.1669444 0.454364
+ 8.1672222 0.437850
+ 8.1675000 0.412431
+ 8.1677778 0.380031
+ 8.1680556 0.342571
+ 8.1683333 0.301976
+ 8.1686111 0.260167
+ 8.1688889 0.219066
+ 8.1691667 0.180597
+ 8.1694444 0.146682
+ 8.1697222 0.118915
+ 8.1700000 0.097574
+ 8.1702778 0.082609
+ 8.1705556 0.073971
+ 8.1708333 0.071608
+ 8.1711111 0.075471
+ 8.1713889 0.085509
+ 8.1716667 0.101673
+ 8.1719444 0.123911
+ 8.1722222 0.152174
+ 8.1725000 0.186116
+ 8.1727778 0.224214
+ 8.1730556 0.264646
+ 8.1733333 0.305592
+ 8.1736111 0.345234
+ 8.1738889 0.381751
+ 8.1741667 0.413323
+ 8.1744444 0.438130
+ 8.1747222 0.454352
+ 8.1750000 0.460170
+ 8.1752778 0.454364
+ 8.1755556 0.438120
+ 8.1758333 0.413223
+ 8.1761111 0.381460
+ 8.1763889 0.344615
+ 8.1766667 0.304475
+ 8.1769444 0.262826
+ 8.1772222 0.221454
+ 8.1775000 0.182144
+ 8.1777778 0.146682
+ 8.1780556 0.116583
+ 8.1783333 0.092277
+ 8.1786111 0.073921
+ 8.1788889 0.061675
+ 8.1791667 0.055695
+ 8.1794444 0.056141
+ 8.1797222 0.063170
+ 8.1800000 0.076941
+ 8.1802778 0.097612
+ 8.1805556 0.125342
+ 8.1808333 0.159922
+ 8.1811111 0.199682
+ 8.1813889 0.242588
+ 8.1816667 0.286602
+ 8.1819444 0.329689
+ 8.1822222 0.369813
+ 8.1825000 0.404938
+ 8.1827778 0.433028
+ 8.1830556 0.452048
+ 8.1833333 0.459961
+ 8.1836111 0.455384
+ 8.1838889 0.439547
+ 8.1841667 0.414331
+ 8.1844444 0.381619
+ 8.1847222 0.343291
+ 8.1850000 0.301230
+ 8.1852778 0.257318
+ 8.1855556 0.213436
+ 8.1858333 0.171467
+ 8.1861111 0.133292
+ 8.1863889 0.100517
+ 8.1866667 0.073647
+ 8.1869444 0.052908
+ 8.1872222 0.050000
+ 8.1875000 0.050000
+ 8.1877778 0.050000
+ 8.1880556 0.050000
+ 8.1883333 0.050000
+ 8.1886111 0.070018
+ 8.1888889 0.098588
+ 8.1891667 0.134714
+ 8.1894444 0.176626
+ 8.1897222 0.222155
+ 8.1900000 0.269132
+ 8.1902778 0.315387
+ 8.1905556 0.358750
+ 8.1908333 0.397052
+ 8.1911111 0.428123
+ 8.1913889 0.449794
+ 8.1916667 0.459895
+ 8.1919444 0.456940
+ 8.1922222 0.442173
+ 8.1925000 0.417518
+ 8.1927778 0.384905
+ 8.1930556 0.346257
+ 8.1933333 0.303503
+ 8.1936111 0.258568
+ 8.1938889 0.213379
+ 8.1941667 0.169862
+ 8.1944444 0.129944
+ 8.1947222 0.095281
+ 8.1950000 0.066445
+ 8.1952778 0.050000
+ 8.1955556 0.050000
+ 8.1958333 0.050000
+ 8.1961111 0.050000
+ 8.1963889 0.050000
+ 8.1966667 0.050000
+ 8.1969444 0.053119
+ 8.1972222 0.081772
+ 8.1975000 0.118541
+ 8.1977778 0.161588
+ 8.1980556 0.208645
+ 8.1983333 0.257444
+ 8.1986111 0.305718
+ 8.1988889 0.351199
+ 8.1991667 0.391620
+ 8.1994444 0.424712
+ 8.1997222 0.448209
+ 8.2000000 0.459843
+ 8.2002778 0.458048
+ 8.2005556 0.444065
+ 8.2008333 0.419838
+ 8.2011111 0.387308
+ 8.2013889 0.348420
+ 8.2016667 0.305115
+ 8.2019444 0.259338
+ 8.2022222 0.213030
+ 8.2025000 0.168136
+ 8.2027778 0.126597
+ 8.2030556 0.090099
+ 8.2033333 0.059293
+ 8.2036111 0.050000
+ 8.2038889 0.050000
+ 8.2041667 0.050000
+ 8.2044444 0.050000
+ 8.2047222 0.050000
+ 8.2050000 0.050000
+ 8.2052778 0.050000
+ 8.2055556 0.065034
+ 8.2058333 0.102715
+ 8.2061111 0.147221
+ 8.2063889 0.196144
+ 8.2066667 0.247072
+ 8.2069444 0.297596
+ 8.2072222 0.345304
+ 8.2075000 0.387786
+ 8.2077778 0.422633
+ 8.2080556 0.447434
+ 8.2083333 0.459778
+ 8.2086111 0.458003
+ 8.2088889 0.443444
+ 8.2091667 0.418182
+ 8.2094444 0.384299
+ 8.2097222 0.343877
+ 8.2100000 0.298998
+ 8.2102778 0.251744
+ 8.2105556 0.204198
+ 8.2108333 0.158441
+ 8.2111111 0.116554
+ 8.2113889 0.080321
+ 8.2116667 0.050322
+ 8.2119444 0.050000
+ 8.2122222 0.050000
+ 8.2125000 0.050000
+ 8.2127778 0.050000
+ 8.2130556 0.050000
+ 8.2133333 0.050000
+ 8.2136111 0.050000
+ 8.2138889 0.068421
+ 8.2141667 0.106718
+ 8.2144444 0.151436
+ 8.2147222 0.200238
+ 8.2150000 0.250785
+ 8.2152778 0.300740
+ 8.2155556 0.347765
+ 8.2158333 0.389522
+ 8.2161111 0.423673
+ 8.2163889 0.447879
+ 8.2166667 0.459804
+ 8.2169444 0.457836
+ 8.2172222 0.443274
+ 8.2175000 0.418146
+ 8.2177778 0.384475
+ 8.2180556 0.344290
+ 8.2183333 0.299616
+ 8.2186111 0.252479
+ 8.2188889 0.204906
+ 8.2191667 0.158922
+ 8.2194444 0.116554
+ 8.2197222 0.079550
+ 8.2200000 0.050000
+ 8.2202778 0.050000
+ 8.2205556 0.050000
+ 8.2208333 0.050000
+ 8.2211111 0.050000
+ 8.2213889 0.050000
+ 8.2216667 0.050000
+ 8.2219444 0.050000
+ 8.2222222 0.058313
+ 8.2225000 0.096578
+ 8.2227778 0.141612
+ 8.2230556 0.191035
+ 8.2233333 0.242464
+ 8.2236111 0.293519
+ 8.2238889 0.341816
+ 8.2241667 0.384975
+ 8.2244444 0.420614
+ 8.2247222 0.446351
+ 8.2250000 0.459804
+ 8.2252778 0.459320
+ 8.2255556 0.446160
+ 8.2258333 0.422313
+ 8.2261111 0.389768
+ 8.2263889 0.350515
+ 8.2266667 0.306543
+ 8.2269444 0.259841
+ 8.2272222 0.212399
+ 8.2275000 0.166205
+ 8.2277778 0.123249
+ 8.2280556 0.085263
+ 8.2283333 0.052947
+ 8.2286111 0.050000
+ 8.2288889 0.050000
+ 8.2291667 0.050000
+ 8.2294444 0.050000
+ 8.2297222 0.050000
+ 8.2300000 0.050000
+ 8.2302778 0.050000
+ 8.2305556 0.051631
+ 8.2308333 0.089772
+ 8.2311111 0.135094
+ 8.2313889 0.185127
+ 8.2316667 0.237401
+ 8.2319444 0.289445
+ 8.2322222 0.338788
+ 8.2325000 0.382960
+ 8.2327778 0.419489
+ 8.2330556 0.445906
+ 8.2333333 0.459738
+ 8.2336111 0.459274
+ 8.2338889 0.445830
+ 8.2341667 0.421480
+ 8.2344444 0.388299
+ 8.2347222 0.348360
+ 8.2350000 0.303737
+ 8.2352778 0.256506
+ 8.2355556 0.208741
+ 8.2358333 0.162514
+ 8.2361111 0.119902
+ 8.2363889 0.082690
+ 8.2366667 0.051518
+ 8.2369444 0.050000
+ 8.2372222 0.050000
+ 8.2375000 0.050000
+ 8.2377778 0.050000
+ 8.2380556 0.050000
+ 8.2383333 0.050000
+ 8.2386111 0.050000
+ 8.2388889 0.061700
+ 8.2391667 0.100222
+ 8.2394444 0.145514
+ 8.2397222 0.195143
+ 8.2400000 0.246678
+ 8.2402778 0.297688
+ 8.2405556 0.345742
+ 8.2408333 0.388408
+ 8.2411111 0.423255
+ 8.2413889 0.447851
+ 8.2416667 0.459765
+ 8.2419444 0.457322
+ 8.2422222 0.441875
+ 8.2425000 0.415531
+ 8.2427778 0.380401
+ 8.2430556 0.338591
+ 8.2433333 0.292212
+ 8.2436111 0.243370
+ 8.2438889 0.194176
+ 8.2441667 0.146738
+ 8.2444444 0.103164
+ 8.2447222 0.065271
+ 8.2450000 0.050000
+ 8.2452778 0.050000
+ 8.2455556 0.050000
+ 8.2458333 0.050000
+ 8.2461111 0.050000
+ 8.2463889 0.050000
+ 8.2466667 0.050000
+ 8.2469444 0.050000
+ 8.2472222 0.051566
+ 8.2475000 0.092426
+ 8.2477778 0.140208
+ 8.2480556 0.192313
+ 8.2483333 0.246141
+ 8.2486111 0.299094
+ 8.2488889 0.348572
+ 8.2491667 0.391976
+ 8.2494444 0.426707
+ 8.2497222 0.450165
+ 8.2500000 0.459752
+ 8.2502778 0.453706
+ 8.2505556 0.433623
+ 8.2508333 0.401936
+ 8.2511111 0.361079
+ 8.2513889 0.313486
+ 8.2516667 0.261590
+ 8.2519444 0.207824
+ 8.2522222 0.154623
+ 8.2525000 0.104419
+ 8.2527778 0.059647
+ 8.2530556 0.050000
+ 8.2533333 0.050000
+ 8.2536111 0.050000
+ 8.2538889 0.050000
+ 8.2541667 0.050000
+ 8.2544444 0.050000
+ 8.2547222 0.050000
+ 8.2550000 0.050000
+ 8.2552778 0.050000
+ 8.2555556 0.050000
+ 8.2558333 0.094075
+ 8.2561111 0.144097
+ 8.2563889 0.197575
+ 8.2566667 0.252017
+ 8.2569444 0.304933
+ 8.2572222 0.353831
+ 8.2575000 0.396221
+ 8.2577778 0.429610
+ 8.2580556 0.451509
+ 8.2583333 0.459425
+ 8.2586111 0.451696
+ 8.2588889 0.429973
+ 8.2591667 0.396736
+ 8.2594444 0.354466
+ 8.2597222 0.305641
+ 8.2600000 0.252742
+ 8.2602778 0.198249
+ 8.2605556 0.144641
+ 8.2608333 0.094398
+ 8.2611111 0.050000
+ 8.2613889 0.050000
+ 8.2616667 0.050000
+ 8.2619444 0.050000
+ 8.2622222 0.050000
+ 8.2625000 0.050000
+ 8.2627778 0.050000
+ 8.2630556 0.050000
+ 8.2633333 0.050000
+ 8.2636111 0.050000
+ 8.2638889 0.050000
+ 8.2641667 0.093222
+ 8.2644444 0.142258
+ 8.2647222 0.195186
+ 8.2650000 0.250079
+ 8.2652778 0.305015
+ 8.2655556 0.358068
+ 8.2658333 0.407315
+ 8.2661111 0.450831
+ 8.2663889 0.486691
+ 8.2666667 0.512972
+ 8.2669444 0.528287
+ 8.2672222 0.533408
+ 8.2675000 0.529643
+ 8.2677778 0.518302
+ 8.2680556 0.500694
+ 8.2683333 0.478129
+ 8.2686111 0.451915
+ 8.2688889 0.423363
+ 8.2691667 0.393781
+ 8.2694444 0.364479
+ 8.2697222 0.336614
+ 8.2700000 0.310740
+ 8.2702778 0.287259
+ 8.2705556 0.266571
+ 8.2708333 0.249080
+ 8.2711111 0.235186
+ 8.2713889 0.225292
+ 8.2716667 0.219799
+ 8.2719444 0.219108
+ 8.2722222 0.223622
+ 8.2725000 0.233613
+ 8.2727778 0.248839
+ 8.2730556 0.268928
+ 8.2733333 0.293508
+ 8.2736111 0.322207
+ 8.2738889 0.354655
+ 8.2741667 0.390478
+ 8.2744444 0.429306
+ 8.2747222 0.470767
+ 8.2750000 0.514488
+ 8.2752778 0.559805
+ 8.2755556 0.604868
+ 8.2758333 0.647537
+ 8.2761111 0.685669
+ 8.2763889 0.717123
+ 8.2766667 0.739756
+ 8.2769444 0.751427
+ 8.2772222 0.749992
+ 8.2775000 0.733311
+ 8.2777778 0.699242
+ 8.2780556 0.646760
+ 8.2783333 0.579321
+ 8.2786111 0.501495
+ 8.2788889 0.417856
+ 8.2791667 0.332976
+ 8.2794444 0.251428
+ 8.2797222 0.177784
+ 8.2800000 0.116616
+ 8.2802778 0.072497
+ 8.2805556 0.050000
+ 8.2808333 0.052193
+ 8.2811111 0.076132
+ 8.2813889 0.117368
+ 8.2816667 0.171455
+ 8.2819444 0.233944
+ 8.2822222 0.300386
+ 8.2825000 0.366335
+ 8.2827778 0.427342
+ 8.2830556 0.478958
+ 8.2833333 0.516737
+ 8.2836111 0.537470
+ 8.2838889 0.542908
+ 8.2841667 0.536040
+ 8.2844444 0.519858
+ 8.2847222 0.497352
+ 8.2850000 0.471511
+ 8.2852778 0.445328
+ 8.2855556 0.421791
+ 8.2858333 0.403891
+ 8.2861111 0.394619
+ 8.2863889 0.396142
+ 8.2866667 0.407333
+ 8.2869444 0.426244
+ 8.2872222 0.450924
+ 8.2875000 0.479424
+ 8.2877778 0.509794
+ 8.2880556 0.540086
+ 8.2883333 0.568348
+ 8.2886111 0.592633
+ 8.2888889 0.610991
+ 8.2891667 0.621892
+ 8.2894444 0.625494
+ 8.2897222 0.622373
+ 8.2900000 0.613109
+ 8.2902778 0.598277
+ 8.2905556 0.578455
+ 8.2908333 0.554222
+ 8.2911111 0.526154
+ 8.2913889 0.494828
+ 8.2916667 0.460824
+ 8.2919444 0.424706
+ 8.2922222 0.387000
+ 8.2925000 0.348219
+ 8.2927778 0.308876
+ 8.2930556 0.269485
+ 8.2933333 0.230559
+ 8.2936111 0.192612
+ 8.2938889 0.156156
+ 8.2941667 0.121706
+ 8.2944444 0.089774
+ 8.2947222 0.060903
+ 8.2950000 0.050000
+ 8.2952778 0.050000
+ 8.2955556 0.050000
+ 8.2958333 0.050000
+ 8.2961111 0.050000
+ 8.2963889 0.050000
+ 8.2966667 0.050000
+ 8.2969444 0.050000
+ 8.2972222 0.050000
+ 8.2975000 0.088411
+ 8.2977778 0.134139
+ 8.2980556 0.184652
+ 8.2983333 0.237419
+ 8.2986111 0.289906
+ 8.2988889 0.339582
+ 8.2991667 0.383915
+ 8.2994444 0.420371
+ 8.2997222 0.446420
+ 8.3000000 0.459529
+ 8.3002778 0.457947
+ 8.3005556 0.443049
+ 8.3008333 0.416990
+ 8.3011111 0.381926
+ 8.3013889 0.340013
+ 8.3016667 0.293407
+ 8.3019444 0.244263
+ 8.3022222 0.194738
+ 8.3025000 0.146986
+ 8.3027778 0.103164
+ 8.3030556 0.065123
+ 8.3033333 0.050000
+ 8.3036111 0.050000
+ 8.3038889 0.050000
+ 8.3041667 0.050000
+ 8.3044444 0.050000
+ 8.3047222 0.050000
+ 8.3050000 0.050000
+ 8.3052778 0.050000
+ 8.3055556 0.050000
+ 8.3058333 0.090145
+ 8.3061111 0.137120
+ 8.3063889 0.188431
+ 8.3066667 0.241587
+ 8.3069444 0.294094
+ 8.3072222 0.343460
+ 8.3075000 0.387192
+ 8.3077778 0.422798
+ 8.3080556 0.447785
+ 8.3083333 0.459660
+ 8.3086111 0.456715
+ 8.3088889 0.440379
+ 8.3091667 0.412864
+ 8.3094444 0.376383
+ 8.3097222 0.333149
+ 8.3100000 0.285374
+ 8.3102778 0.235271
+ 8.3105556 0.185053
+ 8.3108333 0.136932
+ 8.3111111 0.093122
+ 8.3113889 0.055507
+ 8.3116667 0.050000
+ 8.3119444 0.050000
+ 8.3122222 0.050000
+ 8.3125000 0.050000
+ 8.3127778 0.050000
+ 8.3130556 0.050000
+ 8.3133333 0.050000
+ 8.3136111 0.050000
+ 8.3138889 0.051553
+ 8.3141667 0.092398
+ 8.3144444 0.139796
+ 8.3147222 0.191286
+ 8.3150000 0.244410
+ 8.3152778 0.296710
+ 8.3155556 0.345726
+ 8.3158333 0.388999
+ 8.3161111 0.424072
+ 8.3163889 0.448484
+ 8.3166667 0.459778
+ 8.3169444 0.456273
+ 8.3172222 0.439409
+ 8.3175000 0.411404
+ 8.3177778 0.374477
+ 8.3180556 0.330846
+ 8.3183333 0.282729
+ 8.3186111 0.232345
+ 8.3188889 0.181912
+ 8.3191667 0.133649
+ 8.3194444 0.089774
+ 8.3197222 0.052176
+ 8.3200000 0.050000
+ 8.3202778 0.050000
+ 8.3205556 0.050000
+ 8.3208333 0.050000
+ 8.3211111 0.050000
+ 8.3213889 0.050000
+ 8.3216667 0.050000
+ 8.3219444 0.050000
+ 8.3222222 0.050000
+ 8.3225000 0.090993
+ 8.3227778 0.138504
+ 8.3230556 0.190088
+ 8.3233333 0.243298
+ 8.3236111 0.295688
+ 8.3238889 0.344812
+ 8.3241667 0.388222
+ 8.3244444 0.423473
+ 8.3247222 0.448119
+ 8.3250000 0.459712
+ 8.3252778 0.456581
+ 8.3255556 0.440146
+ 8.3258333 0.412602
+ 8.3261111 0.376145
+ 8.3263889 0.332968
+ 8.3266667 0.285268
+ 8.3269444 0.235238
+ 8.3272222 0.185074
+ 8.3275000 0.136970
+ 8.3277778 0.093122
+ 8.3280556 0.055402
+ 8.3283333 0.050000
+ 8.3286111 0.050000
+ 8.3288889 0.050000
+ 8.3291667 0.050000
+ 8.3294444 0.050000
+ 8.3297222 0.050000
+ 8.3300000 0.050000
+ 8.3302778 0.050000
+ 8.3305556 0.050000
+ 8.3308333 0.090930
+ 8.3311111 0.138485
+ 8.3313889 0.190183
+ 8.3316667 0.243544
+ 8.3319444 0.296086
+ 8.3322222 0.345329
+ 8.3325000 0.388792
+ 8.3327778 0.423993
+ 8.3330556 0.448451
+ 8.3333333 0.459686
+ 8.3336111 0.456004
+ 8.3338889 0.438861
+ 8.3341667 0.410502
+ 8.3344444 0.373170
+ 8.3347222 0.329110
+ 8.3350000 0.280565
+ 8.3352778 0.229781
+ 8.3355556 0.179000
+ 8.3358333 0.130468
+ 8.3361111 0.086427
+ 8.3363889 0.050000
+ 8.3366667 0.050000
+ 8.3369444 0.050000
+ 8.3372222 0.050000
+ 8.3375000 0.050000
+ 8.3377778 0.050000
+ 8.3380556 0.050000
+ 8.3383333 0.050000
+ 8.3386111 0.050000
+ 8.3388889 0.050000
+ 8.3391667 0.091556
+ 8.3394444 0.139600
+ 8.3397222 0.191650
+ 8.3400000 0.245224
+ 8.3402778 0.297841
+ 8.3405556 0.347018
+ 8.3408333 0.390272
+ 8.3411111 0.425123
+ 8.3413889 0.449089
+ 8.3416667 0.459686
+ 8.3419444 0.455229
+ 8.3422222 0.437213
+ 8.3425000 0.407926
+ 8.3427778 0.369660
+ 8.3430556 0.324705
+ 8.3433333 0.275349
+ 8.3436111 0.223884
+ 8.3438889 0.172600
+ 8.3441667 0.123786
+ 8.3444444 0.079732
+ 8.3447222 0.050000
+ 8.3450000 0.050000
+ 8.3452778 0.050000
+ 8.3455556 0.050000
+ 8.3458333 0.050000
+ 8.3461111 0.050000
+ 8.3463889 0.050000
+ 8.3466667 0.050000
+ 8.3469444 0.050000
+ 8.3472222 0.050000
+ 8.3475000 0.091579
+ 8.3477778 0.139420
+ 8.3480556 0.191124
+ 8.3483333 0.244290
+ 8.3486111 0.296521
+ 8.3488889 0.345417
+ 8.3491667 0.388578
+ 8.3494444 0.423605
+ 8.3497222 0.448099
+ 8.3500000 0.459660
+ 8.3502778 0.456650
+ 8.3505556 0.440471
+ 8.3508333 0.413285
+ 8.3511111 0.377255
+ 8.3513889 0.334545
+ 8.3516667 0.287316
+ 8.3519444 0.237731
+ 8.3522222 0.187953
+ 8.3525000 0.140145
+ 8.3527778 0.096469
+ 8.3530556 0.058776
+ 8.3533333 0.050000
+ 8.3536111 0.050000
+ 8.3538889 0.050000
+ 8.3541667 0.050000
+ 8.3544444 0.050000
+ 8.3547222 0.050000
+ 8.3550000 0.050000
+ 8.3552778 0.050000
+ 8.3555556 0.050000
+ 8.3558333 0.090527
+ 8.3561111 0.137740
+ 8.3563889 0.189166
+ 8.3566667 0.242337
+ 8.3569444 0.294781
+ 8.3572222 0.344029
+ 8.3575000 0.387610
+ 8.3577778 0.423053
+ 8.3580556 0.447889
+ 8.3583333 0.459647
+ 8.3586111 0.456635
+ 8.3588889 0.440276
+ 8.3591667 0.412773
+ 8.3594444 0.376325
+ 8.3597222 0.333136
+ 8.3600000 0.285407
+ 8.3602778 0.235340
+ 8.3605556 0.185135
+ 8.3608333 0.136995
+ 8.3611111 0.093122
+ 8.3613889 0.055393
+ 8.3616667 0.050000
+ 8.3619444 0.050000
+ 8.3622222 0.050000
+ 8.3625000 0.050000
+ 8.3627778 0.050000
+ 8.3630556 0.050000
+ 8.3633333 0.050000
+ 8.3636111 0.050000
+ 8.3638889 0.050000
+ 8.3641667 0.090864
+ 8.3644444 0.138339
+ 8.3647222 0.189953
+ 8.3650000 0.243238
+ 8.3652778 0.295723
+ 8.3655556 0.344938
+ 8.3658333 0.388414
+ 8.3661111 0.423679
+ 8.3663889 0.448264
+ 8.3666667 0.459699
+ 8.3669444 0.456297
+ 8.3672222 0.439498
+ 8.3675000 0.411528
+ 8.3677778 0.374611
+ 8.3680556 0.330971
+ 8.3683333 0.282832
+ 8.3686111 0.232419
+ 8.3688889 0.181955
+ 8.3691667 0.133666
+ 8.3694444 0.089774
+ 8.3697222 0.052174
+ 8.3700000 0.050000
+ 8.3702778 0.050000
+ 8.3705556 0.050000
+ 8.3708333 0.050000
+ 8.3711111 0.050000
+ 8.3713889 0.050000
+ 8.3716667 0.050000
+ 8.3719444 0.050000
+ 8.3722222 0.050000
+ 8.3725000 0.090919
+ 8.3727778 0.138342
+ 8.3730556 0.189834
+ 8.3733333 0.242961
+ 8.3736111 0.295289
+ 8.3738889 0.344382
+ 8.3741667 0.387807
+ 8.3744444 0.423129
+ 8.3747222 0.447913
+ 8.3750000 0.459725
+ 8.3752778 0.456899
+ 8.3755556 0.440837
+ 8.3758333 0.413711
+ 8.3761111 0.377694
+ 8.3763889 0.334957
+ 8.3766667 0.287670
+ 8.3769444 0.238007
+ 8.3772222 0.188138
+ 8.3775000 0.140235
+ 8.3777778 0.096469
+ 8.3780556 0.058699
+ 8.3783333 0.050000
+ 8.3786111 0.050000
+ 8.3788889 0.050000
+ 8.3791667 0.050000
+ 8.3794444 0.050000
+ 8.3797222 0.050000
+ 8.3800000 0.050000
+ 8.3802778 0.050000
+ 8.3805556 0.050000
+ 8.3808333 0.090634
+ 8.3811111 0.137962
+ 8.3813889 0.189502
+ 8.3816667 0.242771
+ 8.3819444 0.295287
+ 8.3822222 0.344567
+ 8.3825000 0.388128
+ 8.3827778 0.423488
+ 8.3830556 0.448164
+ 8.3833333 0.459673
+ 8.3836111 0.456318
+ 8.3838889 0.439544
+ 8.3841667 0.411579
+ 8.3844444 0.374654
+ 8.3847222 0.330997
+ 8.3850000 0.282838
+ 8.3852778 0.232407
+ 8.3855556 0.181933
+ 8.3858333 0.133646
+ 8.3861111 0.089774
+ 8.3863889 0.052216
+ 8.3866667 0.050000
+ 8.3869444 0.050000
+ 8.3872222 0.050000
+ 8.3875000 0.050000
+ 8.3877778 0.050000
+ 8.3880556 0.050000
+ 8.3883333 0.050000
+ 8.3886111 0.050000
+ 8.3888889 0.051553
+ 8.3891667 0.092771
+ 8.3894444 0.140486
+ 8.3897222 0.192228
+ 8.3900000 0.245527
+ 8.3902778 0.297912
+ 8.3905556 0.346913
+ 8.3908333 0.390060
+ 8.3911111 0.424883
+ 8.3913889 0.448910
+ 8.3916667 0.459673
+ 8.3919444 0.455489
+ 8.3922222 0.437833
+ 8.3925000 0.408966
+ 8.3927778 0.371152
+ 8.3930556 0.326653
+ 8.3933333 0.277732
+ 8.3936111 0.226651
+ 8.3938889 0.175674
+ 8.3941667 0.127063
+ 8.3944444 0.083079
+ 8.3947222 0.050000
+ 8.3950000 0.050000
+ 8.3952778 0.050000
+ 8.3955556 0.050000
+ 8.3958333 0.050000
+ 8.3961111 0.050000
+ 8.3963889 0.050000
+ 8.3966667 0.050000
+ 8.3969444 0.050000
+ 8.3972222 0.050000
+ 8.3975000 0.091437
+ 8.3977778 0.139233
+ 8.3980556 0.190964
+ 8.3983333 0.244207
+ 8.3986111 0.296538
+ 8.3988889 0.345535
+ 8.3991667 0.388775
+ 8.3994444 0.423833
+ 8.3997222 0.448286
+ 8.4000000 0.459712
+ 8.4002778 0.456456
+ 8.4005556 0.439938
+ 8.4008333 0.412349
+ 8.4011111 0.375876
+ 8.4013889 0.332711
+ 8.4016667 0.285042
+ 8.4019444 0.235059
+ 8.4022222 0.184952
+ 8.4025000 0.136910
+ 8.4027778 0.093122
+ 8.4030556 0.055457
+ 8.4033333 0.050000
+ 8.4036111 0.050000
+ 8.4038889 0.050000
+ 8.4041667 0.050000
+ 8.4044444 0.050000
+ 8.4047222 0.050000
+ 8.4050000 0.050000
+ 8.4052778 0.050000
+ 8.4055556 0.050000
+ 8.4058333 0.090835
+ 8.4061111 0.138284
+ 8.4063889 0.189877
+ 8.4066667 0.243146
+ 8.4069444 0.295621
+ 8.4072222 0.344832
+ 8.4075000 0.388311
+ 8.4077778 0.423588
+ 8.4080556 0.448194
+ 8.4083333 0.459660
+ 8.4086111 0.456297
+ 8.4088889 0.439544
+ 8.4091667 0.411620
+ 8.4094444 0.374744
+ 8.4097222 0.331135
+ 8.4100000 0.283013
+ 8.4102778 0.232596
+ 8.4105556 0.182105
+ 8.4108333 0.133758
+ 8.4111111 0.089774
+ 8.4113889 0.052046
+ 8.4116667 0.050000
+ 8.4119444 0.050000
+ 8.4122222 0.050000
+ 8.4125000 0.050000
+ 8.4127778 0.050000
+ 8.4130556 0.050000
+ 8.4133333 0.050000
+ 8.4136111 0.050000
+ 8.4138889 0.050000
+ 8.4141667 0.091402
+ 8.4144444 0.139385
+ 8.4147222 0.191446
+ 8.4150000 0.245080
+ 8.4152778 0.297783
+ 8.4155556 0.347053
+ 8.4158333 0.390384
+ 8.4161111 0.425274
+ 8.4163889 0.449218
+ 8.4166667 0.459712
+ 8.4169444 0.455056
+ 8.4172222 0.436756
+ 8.4175000 0.407123
+ 8.4177778 0.368466
+ 8.4180556 0.323096
+ 8.4183333 0.273322
+ 8.4186111 0.221454
+ 8.4188889 0.169801
+ 8.4191667 0.120675
+ 8.4194444 0.076384
+ 8.4197222 0.050000
+ 8.4200000 0.050000
+ 8.4202778 0.050000
+ 8.4205556 0.050000
+ 8.4208333 0.050000
+ 8.4211111 0.050000
+ 8.4213889 0.050000
+ 8.4216667 0.050000
+ 8.4219444 0.050000
+ 8.4222222 0.050000
+ 8.4225000 0.092541
+ 8.4227778 0.141377
+ 8.4230556 0.194016
+ 8.4233333 0.247968
+ 8.4236111 0.300739
+ 8.4238889 0.349837
+ 8.4241667 0.392772
+ 8.4244444 0.427051
+ 8.4247222 0.450182
+ 8.4250000 0.459673
+ 8.4252778 0.453843
+ 8.4255556 0.434250
+ 8.4258333 0.403263
+ 8.4261111 0.363252
+ 8.4263889 0.316586
+ 8.4266667 0.265633
+ 8.4269444 0.212763
+ 8.4272222 0.160345
+ 8.4275000 0.110749
+ 8.4277778 0.066342
+ 8.4280556 0.050000
+ 8.4283333 0.050000
+ 8.4286111 0.050000
+ 8.4288889 0.050000
+ 8.4291667 0.050000
+ 8.4294444 0.050000
+ 8.4297222 0.050000
+ 8.4300000 0.050000
+ 8.4302778 0.050000
+ 8.4305556 0.050000
+ 8.4308333 0.093192
+ 8.4311111 0.142442
+ 8.4313889 0.195292
+ 8.4316667 0.249286
+ 8.4319444 0.301967
+ 8.4322222 0.350878
+ 8.4325000 0.393562
+ 8.4327778 0.427563
+ 8.4330556 0.450423
+ 8.4333333 0.459686
+ 8.4336111 0.453698
+ 8.4338889 0.434013
+ 8.4341667 0.402988
+ 8.4344444 0.362982
+ 8.4347222 0.316352
+ 8.4350000 0.265454
+ 8.4352778 0.212647
+ 8.4355556 0.160288
+ 8.4358333 0.110734
+ 8.4361111 0.066342
+ 8.4363889 0.050000
+ 8.4366667 0.050000
+ 8.4369444 0.050000
+ 8.4372222 0.050000
+ 8.4375000 0.050000
+ 8.4377778 0.050000
+ 8.4380556 0.050000
+ 8.4383333 0.050000
+ 8.4386111 0.050000
+ 8.4388889 0.050000
+ 8.4391667 0.093429
+ 8.4394444 0.142959
+ 8.4397222 0.196098
+ 8.4400000 0.250353
+ 8.4402778 0.303232
+ 8.4405556 0.352240
+ 8.4408333 0.394887
+ 8.4411111 0.428679
+ 8.4413889 0.451122
+ 8.4416667 0.459725
+ 8.4419444 0.452815
+ 8.4422222 0.432000
+ 8.4425000 0.399708
+ 8.4427778 0.358368
+ 8.4430556 0.310408
+ 8.4433333 0.258256
+ 8.4436111 0.204341
+ 8.4438889 0.151091
+ 8.4441667 0.100934
+ 8.4444444 0.056299
+ 8.4447222 0.050000
+ 8.4450000 0.050000
+ 8.4452778 0.050000
+ 8.4455556 0.050000
+ 8.4458333 0.050000
+ 8.4461111 0.050000
+ 8.4463889 0.050000
+ 8.4466667 0.050000
+ 8.4469444 0.050000
+ 8.4472222 0.050000
+ 8.4475000 0.094256
+ 8.4477778 0.144393
+ 8.4480556 0.197933
+ 8.4483333 0.252395
+ 8.4486111 0.305300
+ 8.4488889 0.354169
+ 8.4491667 0.396523
+ 8.4494444 0.429882
+ 8.4497222 0.451767
+ 8.4500000 0.459699
+ 8.4502778 0.452022
+ 8.4505556 0.430377
+ 8.4508333 0.397226
+ 8.4511111 0.355034
+ 8.4513889 0.306265
+ 8.4516667 0.253383
+ 8.4519444 0.198852
+ 8.4522222 0.145135
+ 8.4525000 0.094696
+ 8.4527778 0.050000
+ 8.4530556 0.050000
+ 8.4533333 0.050000
+ 8.4536111 0.050000
+ 8.4538889 0.050000
+ 8.4541667 0.050000
+ 8.4544444 0.050000
+ 8.4547222 0.050000
+ 8.4550000 0.050000
+ 8.4552778 0.050000
+ 8.4555556 0.050000
+ 8.4558333 0.094662
+ 8.4561111 0.145057
+ 8.4563889 0.198727
+ 8.4566667 0.253214
+ 8.4569444 0.306061
+ 8.4572222 0.354810
+ 8.4575000 0.397003
+ 8.4577778 0.430183
+ 8.4580556 0.451892
+ 8.4583333 0.459673
+ 8.4586111 0.451887
+ 8.4588889 0.430174
+ 8.4591667 0.396990
+ 8.4594444 0.354793
+ 8.4597222 0.306043
+ 8.4600000 0.253196
+ 8.4602778 0.198710
+ 8.4605556 0.145044
+ 8.4608333 0.094654
+ 8.4611111 0.050000
+ 8.4613889 0.050000
+ 8.4616667 0.050000
+ 8.4619444 0.050000
+ 8.4622222 0.050000
+ 8.4625000 0.050000
+ 8.4627778 0.050000
+ 8.4630556 0.050000
+ 8.4633333 0.050000
+ 8.4636111 0.050000
+ 8.4638889 0.050000
+ 8.4641667 0.094658
+ 8.4644444 0.145052
+ 8.4647222 0.198724
+ 8.4650000 0.253216
+ 8.4652778 0.306069
+ 8.4655556 0.354825
+ 8.4658333 0.397026
+ 8.4661111 0.430213
+ 8.4663889 0.451928
+ 8.4666667 0.459712
+ 8.4669444 0.451928
+ 8.4672222 0.430213
+ 8.4675000 0.397026
+ 8.4677778 0.354825
+ 8.4680556 0.306069
+ 8.4683333 0.253216
+ 8.4686111 0.198725
+ 8.4688889 0.145052
+ 8.4691667 0.094658
+ 8.4694444 0.050000
+ 8.4697222 0.050000
+ 8.4700000 0.050000
+ 8.4702778 0.050000
+ 8.4705556 0.050000
+ 8.4708333 0.050000
+ 8.4711111 0.050000
+ 8.4713889 0.050000
+ 8.4716667 0.050000
+ 8.4719444 0.050000
+ 8.4722222 0.050000
+ 8.4725000 0.094655
+ 8.4727778 0.145045
+ 8.4730556 0.198713
+ 8.4733333 0.253200
+ 8.4736111 0.306047
+ 8.4738889 0.354798
+ 8.4741667 0.396994
+ 8.4744444 0.430178
+ 8.4747222 0.451890
+ 8.4750000 0.459673
+ 8.4752778 0.451889
+ 8.4755556 0.430176
+ 8.4758333 0.396992
+ 8.4761111 0.354795
+ 8.4763889 0.306044
+ 8.4766667 0.253196
+ 8.4769444 0.198710
+ 8.4772222 0.145043
+ 8.4775000 0.094654
+ 8.4777778 0.050000
+ 8.4780556 0.050000
+ 8.4783333 0.050000
+ 8.4786111 0.050000
+ 8.4788889 0.050000
+ 8.4791667 0.050000
+ 8.4794444 0.050000
+ 8.4797222 0.050000
+ 8.4800000 0.050000
+ 8.4802778 0.050000
+ 8.4805556 0.050000
+ 8.4808333 0.094651
+ 8.4811111 0.145036
+ 8.4813889 0.198698
+ 8.4816667 0.253179
+ 8.4819444 0.306022
+ 8.4822222 0.354768
+ 8.4825000 0.396960
+ 8.4827778 0.430140
+ 8.4830556 0.451851
+ 8.4833333 0.459634
+ 8.4836111 0.451851
+ 8.4838889 0.430140
+ 8.4841667 0.396960
+ 8.4844444 0.354768
+ 8.4847222 0.306022
+ 8.4850000 0.253180
+ 8.4852778 0.198698
+ 8.4855556 0.145036
+ 8.4858333 0.094651
+ 8.4861111 0.050000
+ 8.4863889 0.050000
+ 8.4866667 0.050000
+ 8.4869444 0.050000
+ 8.4872222 0.050000
+ 8.4875000 0.050000
+ 8.4877778 0.050000
+ 8.4880556 0.050000
+ 8.4883333 0.050000
+ 8.4886111 0.050000
+ 8.4888889 0.050000
+ 8.4891667 0.094654
+ 8.4894444 0.145043
+ 8.4897222 0.198710
+ 8.4900000 0.253196
+ 8.4902778 0.306044
+ 8.4905556 0.354796
+ 8.4908333 0.396992
+ 8.4911111 0.430176
+ 8.4913889 0.451889
+ 8.4916667 0.459673
+ 8.4919444 0.451890
+ 8.4922222 0.430177
+ 8.4925000 0.396994
+ 8.4927778 0.354798
+ 8.4930556 0.306047
+ 8.4933333 0.253199
+ 8.4936111 0.198712
+ 8.4938889 0.145045
+ 8.4941667 0.094655
+ 8.4944444 0.050000
+ 8.4947222 0.050000
+ 8.4950000 0.050000
+ 8.4952778 0.050000
+ 8.4955556 0.050000
+ 8.4958333 0.050000
+ 8.4961111 0.050000
+ 8.4963889 0.050000
+ 8.4966667 0.050000
+ 8.4969444 0.050000
+ 8.4972222 0.050000
+ 8.4975000 0.094656
+ 8.4977778 0.145047
+ 8.4980556 0.198716
+ 8.4983333 0.253204
+ 8.4986111 0.306054
+ 8.4988889 0.354807
+ 8.4991667 0.397005
+ 8.4994444 0.430189
+ 8.4997222 0.451902
+ 8.5000000 0.459686
+ 8.5002778 0.451902
+ 8.5005556 0.430188
+ 8.5008333 0.397003
+ 8.5011111 0.354805
+ 8.5013889 0.306052
+ 8.5016667 0.253202
+ 8.5019444 0.198714
+ 8.5022222 0.145045
+ 8.5025000 0.094655
+ 8.5027778 0.050000
+ 8.5030556 0.050000
+ 8.5033333 0.050000
+ 8.5036111 0.050000
+ 8.5038889 0.050000
+ 8.5041667 0.050000
+ 8.5044444 0.050000
+ 8.5047222 0.050000
+ 8.5050000 0.050000
+ 8.5052778 0.050000
+ 8.5055556 0.050000
+ 8.5058333 0.094649
+ 8.5061111 0.145033
+ 8.5063889 0.198693
+ 8.5066667 0.253172
+ 8.5069444 0.306012
+ 8.5072222 0.354756
+ 8.5075000 0.396947
+ 8.5077778 0.430126
+ 8.5080556 0.451837
+ 8.5083333 0.459621
+ 8.5086111 0.451840
+ 8.5088889 0.430132
+ 8.5091667 0.396956
+ 8.5094444 0.354767
+ 8.5097222 0.306024
+ 8.5100000 0.253184
+ 8.5102778 0.198704
+ 8.5105556 0.145042
+ 8.5108333 0.094655
+ 8.5111111 0.050000
+ 8.5113889 0.050000
+ 8.5116667 0.050000
+ 8.5119444 0.050000
+ 8.5122222 0.050000
+ 8.5125000 0.050000
+ 8.5127778 0.050000
+ 8.5130556 0.050000
+ 8.5133333 0.050000
+ 8.5136111 0.050000
+ 8.5138889 0.050000
+ 8.5141667 0.094680
+ 8.5144444 0.145099
+ 8.5147222 0.198798
+ 8.5150000 0.253313
+ 8.5152778 0.306184
+ 8.5155556 0.354948
+ 8.5158333 0.397145
+ 8.5161111 0.430312
+ 8.5163889 0.451989
+ 8.5166667 0.459712
+ 8.5169444 0.451844
+ 8.5172222 0.430032
+ 8.5175000 0.396746
+ 8.5177778 0.354457
+ 8.5180556 0.305636
+ 8.5183333 0.252752
+ 8.5186111 0.198276
+ 8.5188889 0.144679
+ 8.5191667 0.094430
+ 8.5194444 0.050000
+ 8.5197222 0.050000
+ 8.5200000 0.050000
+ 8.5202778 0.050000
+ 8.5205556 0.050000
+ 8.5208333 0.050000
+ 8.5211111 0.050000
+ 8.5213889 0.050000
+ 8.5216667 0.050000
+ 8.5219444 0.050000
+ 8.5222222 0.051357
+ 8.5225000 0.095279
+ 8.5227778 0.144776
+ 8.5230556 0.197499
+ 8.5233333 0.251103
+ 8.5236111 0.303241
+ 8.5238889 0.351566
+ 8.5241667 0.393732
+ 8.5244444 0.427391
+ 8.5247222 0.450197
+ 8.5250000 0.459804
+ 8.5252778 0.454637
+ 8.5255556 0.436214
+ 8.5258333 0.406825
+ 8.5261111 0.368760
+ 8.5263889 0.324310
+ 8.5266667 0.275764
+ 8.5269444 0.225412
+ 8.5272222 0.175545
+ 8.5275000 0.128454
+ 8.5277778 0.086427
+ 8.5280556 0.051382
+ 8.5283333 0.050000
+ 8.5286111 0.050000
+ 8.5288889 0.050000
+ 8.5291667 0.050000
+ 8.5294444 0.050000
+ 8.5297222 0.050000
+ 8.5300000 0.050000
+ 8.5302778 0.050000
+ 8.5305556 0.074920
+ 8.5308333 0.115693
+ 8.5311111 0.162028
+ 8.5313889 0.211648
+ 8.5316667 0.262279
+ 8.5319444 0.311643
+ 8.5322222 0.357466
+ 8.5325000 0.397470
+ 8.5327778 0.429381
+ 8.5330556 0.450922
+ 8.5333333 0.459817
+ 8.5336111 0.454538
+ 8.5338889 0.436545
+ 8.5341667 0.408045
+ 8.5344444 0.371247
+ 8.5347222 0.328359
+ 8.5350000 0.281586
+ 8.5352778 0.233138
+ 8.5355556 0.185222
+ 8.5358333 0.140046
+ 8.5361111 0.099817
+ 8.5363889 0.066379
+ 8.5366667 0.050000
+ 8.5369444 0.050000
+ 8.5372222 0.050000
+ 8.5375000 0.050000
+ 8.5377778 0.050000
+ 8.5380556 0.050000
+ 8.5383333 0.050000
+ 8.5386111 0.059610
+ 8.5388889 0.091749
+ 8.5391667 0.130941
+ 8.5394444 0.175383
+ 8.5397222 0.222909
+ 8.5400000 0.271353
+ 8.5402778 0.318547
+ 8.5405556 0.362325
+ 8.5408333 0.400519
+ 8.5411111 0.430964
+ 8.5413889 0.451491
+ 8.5416667 0.459935
+ 8.5419444 0.454838
+ 8.5422222 0.437584
+ 8.5425000 0.410268
+ 8.5427778 0.374984
+ 8.5430556 0.333825
+ 8.5433333 0.288886
+ 8.5436111 0.242261
+ 8.5438889 0.196043
+ 8.5441667 0.152327
+ 8.5444444 0.113207
+ 8.5447222 0.080440
+ 8.5450000 0.054434
+ 8.5452778 0.050000
+ 8.5455556 0.050000
+ 8.5458333 0.050000
+ 8.5461111 0.050000
+ 8.5463889 0.050000
+ 8.5466667 0.050000
+ 8.5469444 0.067776
+ 8.5472222 0.098457
+ 8.5475000 0.136183
+ 8.5477778 0.179202
+ 8.5480556 0.225399
+ 8.5483333 0.272656
+ 8.5486111 0.318859
+ 8.5488889 0.361889
+ 8.5491667 0.399633
+ 8.5494444 0.429972
+ 8.5497222 0.450791
+ 8.5500000 0.459974
+ 8.5502778 0.456088
+ 8.5505556 0.440435
+ 8.5508333 0.415002
+ 8.5511111 0.381775
+ 8.5513889 0.342739
+ 8.5516667 0.299881
+ 8.5519444 0.255186
+ 8.5522222 0.210641
+ 8.5525000 0.168232
+ 8.5527778 0.129944
+ 8.5530556 0.097459
+ 8.5533333 0.071235
+ 8.5536111 0.051425
+ 8.5538889 0.050000
+ 8.5541667 0.050000
+ 8.5544444 0.050000
+ 8.5547222 0.050000
+ 8.5550000 0.053948
+ 8.5552778 0.075840
+ 8.5555556 0.105217
+ 8.5558333 0.141850
+ 8.5561111 0.183969
+ 8.5563889 0.229420
+ 8.5566667 0.276048
+ 8.5569444 0.321701
+ 8.5572222 0.364225
+ 8.5575000 0.401465
+ 8.5577778 0.431268
+ 8.5580556 0.451480
+ 8.5583333 0.459948
+ 8.5586111 0.455215
+ 8.5588889 0.438621
+ 8.5591667 0.412201
+ 8.5594444 0.377993
+ 8.5597222 0.338034
+ 8.5600000 0.294360
+ 8.5602778 0.249007
+ 8.5605556 0.204014
+ 8.5608333 0.161416
+ 8.5611111 0.123249
+ 8.5613889 0.091227
+ 8.5616667 0.065762
+ 8.5619444 0.050000
+ 8.5622222 0.050000
+ 8.5625000 0.050000
+ 8.5627778 0.050000
+ 8.5630556 0.050000
+ 8.5633333 0.055544
+ 8.5636111 0.078420
+ 8.5638889 0.108552
+ 8.5641667 0.145658
+ 8.5644444 0.187986
+ 8.5647222 0.233414
+ 8.5650000 0.279821
+ 8.5652778 0.325084
+ 8.5655556 0.367083
+ 8.5658333 0.403695
+ 8.5661111 0.432800
+ 8.5663889 0.452275
+ 8.5666667 0.460000
+ 8.5669444 0.454545
+ 8.5672222 0.437250
+ 8.5675000 0.410147
+ 8.5677778 0.375270
+ 8.5680556 0.334650
+ 8.5683333 0.290321
+ 8.5686111 0.244314
+ 8.5688889 0.198662
+ 8.5691667 0.155398
+ 8.5694444 0.116554
+ 8.5697222 0.083843
+ 8.5700000 0.057698
+ 8.5702778 0.050000
+ 8.5705556 0.050000
+ 8.5708333 0.050000
+ 8.5711111 0.050000
+ 8.5713889 0.050000
+ 8.5716667 0.050000
+ 8.5719444 0.068019
+ 8.5722222 0.098470
+ 8.5725000 0.136126
+ 8.5727778 0.179207
+ 8.5730556 0.225551
+ 8.5733333 0.273001
+ 8.5736111 0.319395
+ 8.5738889 0.362576
+ 8.5741667 0.400382
+ 8.5744444 0.430655
+ 8.5747222 0.451234
+ 8.5750000 0.459961
+ 8.5752778 0.455375
+ 8.5755556 0.438815
+ 8.5758333 0.412320
+ 8.5761111 0.377928
+ 8.5763889 0.337678
+ 8.5766667 0.293608
+ 8.5769444 0.247757
+ 8.5772222 0.202163
+ 8.5775000 0.158865
+ 8.5777778 0.119902
+ 8.5780556 0.086993
+ 8.5783333 0.060583
+ 8.5786111 0.050000
+ 8.5788889 0.050000
+ 8.5791667 0.050000
+ 8.5794444 0.050000
+ 8.5797222 0.050000
+ 8.5800000 0.050000
+ 8.5802778 0.068338
+ 8.5805556 0.098483
+ 8.5808333 0.135886
+ 8.5811111 0.178769
+ 8.5813889 0.224972
+ 8.5816667 0.272335
+ 8.5819444 0.318698
+ 8.5822222 0.361902
+ 8.5825000 0.399788
+ 8.5827778 0.430195
+ 8.5830556 0.450964
+ 8.5833333 0.459935
+ 8.5836111 0.455646
+ 8.5838889 0.439426
+ 8.5841667 0.413300
+ 8.5844444 0.379294
+ 8.5847222 0.339436
+ 8.5850000 0.295749
+ 8.5852778 0.250262
+ 8.5855556 0.204998
+ 8.5858333 0.161986
+ 8.5861111 0.123249
+ 8.5863889 0.090501
+ 8.5866667 0.064191
+ 8.5869444 0.050000
+ 8.5872222 0.050000
+ 8.5875000 0.050000
+ 8.5877778 0.050000
+ 8.5880556 0.050000
+ 8.5883333 0.050000
+ 8.5886111 0.071751
+ 8.5888889 0.101857
+ 8.5891667 0.139240
+ 8.5894444 0.182103
+ 8.5897222 0.228260
+ 8.5900000 0.275523
+ 8.5902778 0.321709
+ 8.5905556 0.364631
+ 8.5908333 0.402103
+ 8.5911111 0.431939
+ 8.5913889 0.451954
+ 8.5916667 0.459961
+ 8.5919444 0.454486
+ 8.5922222 0.436899
+ 8.5925000 0.409280
+ 8.5927778 0.373711
+ 8.5930556 0.332272
+ 8.5933333 0.287044
+ 8.5936111 0.240108
+ 8.5938889 0.193544
+ 8.5941667 0.149435
+ 8.5944444 0.109859
+ 8.5947222 0.076570
+ 8.5950000 0.050000
+ 8.5952778 0.050000
+ 8.5955556 0.050000
+ 8.5958333 0.050000
+ 8.5961111 0.050000
+ 8.5963889 0.050000
+ 8.5966667 0.050000
+ 8.5969444 0.060848
+ 8.5972222 0.091762
+ 8.5975000 0.129949
+ 8.5977778 0.173619
+ 8.5980556 0.220601
+ 8.5983333 0.268725
+ 8.5986111 0.315821
+ 8.5988889 0.359719
+ 8.5991667 0.398250
+ 8.5994444 0.429243
+ 8.5997222 0.450528
+ 8.6000000 0.459935
+ 8.6002778 0.455994
+ 8.6005556 0.440035
+ 8.6008333 0.414087
+ 8.6011111 0.380180
+ 8.6013889 0.340344
+ 8.6016667 0.296607
+ 8.6019444 0.250999
+ 8.6022222 0.205551
+ 8.6025000 0.162291
+ 8.6027778 0.123249
+ 8.6030556 0.090142
+ 8.6033333 0.063435
+ 8.6036111 0.050000
+ 8.6038889 0.050000
+ 8.6041667 0.050000
+ 8.6044444 0.050000
+ 8.6047222 0.050000
+ 8.6050000 0.050000
+ 8.6052778 0.068509
+ 8.6055556 0.098496
+ 8.6058333 0.135866
+ 8.6061111 0.178815
+ 8.6063889 0.225150
+ 8.6066667 0.272675
+ 8.6069444 0.319197
+ 8.6072222 0.362521
+ 8.6075000 0.400454
+ 8.6077778 0.430801
+ 8.6080556 0.451368
+ 8.6083333 0.459961
+ 8.6086111 0.455097
+ 8.6088889 0.438143
+ 8.6091667 0.411175
+ 8.6094444 0.376272
+ 8.6097222 0.335511
+ 8.6100000 0.290969
+ 8.6102778 0.244725
+ 8.6105556 0.198857
+ 8.6108333 0.155440
+ 8.6111111 0.116554
+ 8.6113889 0.083944
+ 8.6116667 0.058027
+ 8.6119444 0.050000
+ 8.6122222 0.050000
+ 8.6125000 0.050000
+ 8.6127778 0.050000
+ 8.6130556 0.050000
+ 8.6133333 0.050000
+ 8.6136111 0.071136
+ 8.6138889 0.101818
+ 8.6141667 0.139583
+ 8.6144444 0.182653
+ 8.6147222 0.228876
+ 8.6150000 0.276099
+ 8.6152778 0.322170
+ 8.6155556 0.364937
+ 8.6158333 0.402248
+ 8.6161111 0.431950
+ 8.6163889 0.451892
+ 8.6166667 0.459922
+ 8.6169444 0.454584
+ 8.6172222 0.437220
+ 8.6175000 0.409866
+ 8.6177778 0.374561
+ 8.6180556 0.333342
+ 8.6183333 0.288246
+ 8.6186111 0.241313
+ 8.6188889 0.194579
+ 8.6191667 0.150082
+ 8.6194444 0.109859
+ 8.6197222 0.075641
+ 8.6200000 0.050000
+ 8.6202778 0.050000
+ 8.6205556 0.050000
+ 8.6208333 0.050000
+ 8.6211111 0.050000
+ 8.6213889 0.050000
+ 8.6216667 0.050000
+ 8.6219444 0.050958
+ 8.6222222 0.081733
+ 8.6225000 0.120230
+ 8.6227778 0.164600
+ 8.6230556 0.212582
+ 8.6233333 0.261917
+ 8.6236111 0.310348
+ 8.6238889 0.355615
+ 8.6241667 0.395460
+ 8.6244444 0.427623
+ 8.6247222 0.449845
+ 8.6250000 0.459869
+ 8.6252778 0.456156
+ 8.6255556 0.440053
+ 8.6258333 0.413625
+ 8.6261111 0.378942
+ 8.6263889 0.338068
+ 8.6266667 0.293072
+ 8.6269444 0.246021
+ 8.6272222 0.198982
+ 8.6275000 0.154022
+ 8.6277778 0.113207
+ 8.6280556 0.078296
+ 8.6283333 0.050000
+ 8.6286111 0.050000
+ 8.6288889 0.050000
+ 8.6291667 0.050000
+ 8.6294444 0.050000
+ 8.6297222 0.050000
+ 8.6300000 0.050000
+ 8.6302778 0.050000
+ 8.6305556 0.078346
+ 8.6308333 0.116705
+ 8.6311111 0.161098
+ 8.6313889 0.209244
+ 8.6316667 0.258864
+ 8.6319444 0.307677
+ 8.6322222 0.353403
+ 8.6325000 0.393761
+ 8.6327778 0.426472
+ 8.6330556 0.449255
+ 8.6333333 0.459830
+ 8.6336111 0.456641
+ 8.6338889 0.441028
+ 8.6341667 0.415054
+ 8.6344444 0.380785
+ 8.6347222 0.340285
+ 8.6350000 0.295617
+ 8.6352778 0.248846
+ 8.6355556 0.202035
+ 8.6358333 0.157250
+ 8.6361111 0.116554
+ 8.6363889 0.081705
+ 8.6366667 0.053232
+ 8.6369444 0.050000
+ 8.6372222 0.050000
+ 8.6375000 0.050000
+ 8.6377778 0.050000
+ 8.6380556 0.050000
+ 8.6383333 0.050000
+ 8.6386111 0.051183
+ 8.6388889 0.081746
+ 8.6391667 0.120265
+ 8.6394444 0.164839
+ 8.6397222 0.213136
+ 8.6400000 0.262830
+ 8.6402778 0.311589
+ 8.6405556 0.357087
+ 8.6408333 0.396992
+ 8.6411111 0.428977
+ 8.6413889 0.450713
+ 8.6416667 0.459869
+ 8.6419444 0.454868
+ 8.6422222 0.437125
+ 8.6425000 0.408807
+ 8.6427778 0.372081
+ 8.6430556 0.329113
+ 8.6433333 0.282069
+ 8.6436111 0.233117
+ 8.6438889 0.184422
+ 8.6441667 0.138150
+ 8.6444444 0.096469
+ 8.6447222 0.061208
+ 8.6450000 0.050000
+ 8.6452778 0.050000
+ 8.6455556 0.050000
+ 8.6458333 0.050000
+ 8.6461111 0.050000
+ 8.6463889 0.050000
+ 8.6466667 0.050000
+ 8.6469444 0.050000
+ 8.6472222 0.071651
+ 8.6475000 0.111465
+ 8.6477778 0.157179
+ 8.6480556 0.206498
+ 8.6483333 0.257126
+ 8.6486111 0.306768
+ 8.6488889 0.353128
+ 8.6491667 0.393912
+ 8.6494444 0.426822
+ 8.6497222 0.449564
+ 8.6500000 0.459843
+ 8.6502778 0.456097
+ 8.6505556 0.439703
+ 8.6508333 0.412771
+ 8.6511111 0.377412
+ 8.6513889 0.335738
+ 8.6516667 0.289859
+ 8.6519444 0.241886
+ 8.6522222 0.193930
+ 8.6525000 0.148102
+ 8.6527778 0.106512
+ 8.6530556 0.070955
+ 8.6533333 0.050000
+ 8.6536111 0.050000
+ 8.6538889 0.050000
+ 8.6541667 0.050000
+ 8.6544444 0.050000
+ 8.6547222 0.050000
+ 8.6550000 0.050000
+ 8.6552778 0.050000
+ 8.6555556 0.071664
+ 8.6558333 0.110842
+ 8.6561111 0.156159
+ 8.6563889 0.205281
+ 8.6566667 0.255878
+ 8.6569444 0.305617
+ 8.6572222 0.352165
+ 8.6575000 0.393192
+ 8.6577778 0.426364
+ 8.6580556 0.449349
+ 8.6583333 0.459817
+ 8.6586111 0.456178
+ 8.6588889 0.439817
+ 8.6591667 0.412865
+ 8.6594444 0.377451
+ 8.6597222 0.335704
+ 8.6600000 0.289754
+ 8.6602778 0.241731
+ 8.6605556 0.193763
+ 8.6608333 0.147980
+ 8.6611111 0.106512
+ 8.6613889 0.071165
+ 8.6616667 0.050000
+ 8.6619444 0.050000
+ 8.6622222 0.050000
+ 8.6625000 0.050000
+ 8.6627778 0.050000
+ 8.6630556 0.050000
+ 8.6633333 0.050000
+ 8.6636111 0.050000
+ 8.6638889 0.075025
+ 8.6641667 0.114362
+ 8.6644444 0.159745
+ 8.6647222 0.208834
+ 8.6650000 0.259292
+ 8.6652778 0.308781
+ 8.6655556 0.354962
+ 8.6658333 0.395497
+ 8.6661111 0.428047
+ 8.6663889 0.450275
+ 8.6666667 0.459843
+ 8.6669444 0.455167
+ 8.6672222 0.437684
+ 8.6675000 0.409586
+ 8.6677778 0.373066
+ 8.6680556 0.330314
+ 8.6683333 0.283524
+ 8.6686111 0.234887
+ 8.6688889 0.186596
+ 8.6691667 0.140842
+ 8.6694444 0.099817
+ 8.6697222 0.065363
+ 8.6700000 0.050000
+ 8.6702778 0.050000
+ 8.6705556 0.050000
+ 8.6708333 0.050000
+ 8.6711111 0.050000
+ 8.6713889 0.050000
+ 8.6716667 0.050000
+ 8.6719444 0.050000
+ 8.6722222 0.081641
+ 8.6725000 0.120982
+ 8.6727778 0.165921
+ 8.6730556 0.214233
+ 8.6733333 0.263692
+ 8.6736111 0.312071
+ 8.6738889 0.357145
+ 8.6741667 0.396688
+ 8.6744444 0.428473
+ 8.6747222 0.450276
+ 8.6750000 0.459869
+ 8.6752778 0.455743
+ 8.6755556 0.439247
+ 8.6758333 0.412448
+ 8.6761111 0.377410
+ 8.6763889 0.336200
+ 8.6766667 0.290883
+ 8.6769444 0.243525
+ 8.6772222 0.196191
+ 8.6775000 0.150948
+ 8.6777778 0.109859
+ 8.6780556 0.074686
+ 8.6783333 0.050000
+ 8.6786111 0.050000
+ 8.6788889 0.050000
+ 8.6791667 0.050000
+ 8.6794444 0.050000
+ 8.6797222 0.050000
+ 8.6800000 0.050000
+ 8.6802778 0.050000
+ 8.6805556 0.075011
+ 8.6808333 0.113935
+ 8.6811111 0.158984
+ 8.6813889 0.207824
+ 8.6816667 0.258121
+ 8.6819444 0.307541
+ 8.6822222 0.353750
+ 8.6825000 0.394414
+ 8.6827778 0.427198
+ 8.6830556 0.449768
+ 8.6833333 0.459791
+ 8.6836111 0.455678
+ 8.6838889 0.438830
+ 8.6841667 0.411393
+ 8.6844444 0.375513
+ 8.6847222 0.333339
+ 8.6850000 0.287015
+ 8.6852778 0.238689
+ 8.6855556 0.190508
+ 8.6858333 0.144617
+ 8.6861111 0.103164
+ 8.6863889 0.067966
+ 8.6866667 0.050000
+ 8.6869444 0.050000
+ 8.6872222 0.050000
+ 8.6875000 0.050000
+ 8.6877778 0.050000
+ 8.6880556 0.050000
+ 8.6883333 0.050000
+ 8.6886111 0.050000
+ 8.6888889 0.075025
+ 8.6891667 0.114441
+ 8.6894444 0.159803
+ 8.6897222 0.208804
+ 8.6900000 0.259135
+ 8.6902778 0.308488
+ 8.6905556 0.354557
+ 8.6908333 0.395032
+ 8.6911111 0.427605
+ 8.6913889 0.449970
+ 8.6916667 0.459817
+ 8.6919444 0.455577
+ 8.6922222 0.438630
+ 8.6925000 0.411095
+ 8.6927778 0.375090
+ 8.6930556 0.332734
+ 8.6933333 0.286144
+ 8.6936111 0.237439
+ 8.6938889 0.188737
+ 8.6941667 0.142157
+ 8.6944444 0.099817
+ 8.6947222 0.063521
+ 8.6950000 0.050000
+ 8.6952778 0.050000
+ 8.6955556 0.050000
+ 8.6958333 0.050000
+ 8.6961111 0.050000
+ 8.6963889 0.050000
+ 8.6966667 0.050000
+ 8.6969444 0.050000
+ 8.6972222 0.061595
+ 8.6975000 0.101320
+ 8.6977778 0.147377
+ 8.6980556 0.197399
+ 8.6983333 0.249020
+ 8.6986111 0.299874
+ 8.6988889 0.347594
+ 8.6991667 0.389813
+ 8.6994444 0.424165
+ 8.6997222 0.448285
+ 8.7000000 0.459804
+ 8.7002778 0.457102
+ 8.7005556 0.441538
+ 8.7008333 0.415216
+ 8.7011111 0.380241
+ 8.7013889 0.338717
+ 8.7016667 0.292748
+ 8.7019444 0.244439
+ 8.7022222 0.195894
+ 8.7025000 0.149217
+ 8.7027778 0.106512
+ 8.7030556 0.069582
+ 8.7033333 0.050000
+ 8.7036111 0.050000
+ 8.7038889 0.050000
+ 8.7041667 0.050000
+ 8.7044444 0.050000
+ 8.7047222 0.050000
+ 8.7050000 0.050000
+ 8.7052778 0.050000
+ 8.7055556 0.058261
+ 8.7058333 0.097517
+ 8.7061111 0.143346
+ 8.7063889 0.193356
+ 8.7066667 0.245158
+ 8.7069444 0.296363
+ 8.7072222 0.344582
+ 8.7075000 0.387423
+ 8.7077778 0.422498
+ 8.7080556 0.447417
+ 8.7083333 0.459791
+ 8.7086111 0.457974
+ 8.7088889 0.443305
+ 8.7091667 0.417867
+ 8.7094444 0.383741
+ 8.7097222 0.343012
+ 8.7100000 0.297762
+ 8.7102778 0.250073
+ 8.7105556 0.202029
+ 8.7108333 0.155713
+ 8.7111111 0.113207
+ 8.7113889 0.076300
+ 8.7116667 0.050000
+ 8.7119444 0.050000
+ 8.7122222 0.050000
+ 8.7125000 0.050000
+ 8.7127778 0.050000
+ 8.7130556 0.050000
+ 8.7133333 0.050000
+ 8.7136111 0.050000
+ 8.7138889 0.061661
+ 8.7141667 0.100672
+ 8.7144444 0.146325
+ 8.7147222 0.196196
+ 8.7150000 0.247860
+ 8.7152778 0.298896
+ 8.7155556 0.346878
+ 8.7158333 0.389383
+ 8.7161111 0.423988
+ 8.7163889 0.448270
+ 8.7166667 0.459804
+ 8.7169444 0.456929
+ 8.7172222 0.441034
+ 8.7175000 0.414269
+ 8.7177778 0.378783
+ 8.7180556 0.336728
+ 8.7183333 0.290253
+ 8.7186111 0.241509
+ 8.7188889 0.192646
+ 8.7191667 0.145815
+ 8.7194444 0.103164
+ 8.7197222 0.066528
+ 8.7200000 0.050000
+ 8.7202778 0.050000
+ 8.7205556 0.050000
+ 8.7208333 0.050000
+ 8.7211111 0.050000
+ 8.7213889 0.050000
+ 8.7216667 0.050000
+ 8.7219444 0.050000
+ 8.7222222 0.061608
+ 8.7225000 0.101147
+ 8.7227778 0.147064
+ 8.7230556 0.196993
+ 8.7233333 0.248564
+ 8.7236111 0.299408
+ 8.7238889 0.347156
+ 8.7241667 0.389440
+ 8.7244444 0.423890
+ 8.7247222 0.448139
+ 8.7250000 0.459817
+ 8.7252778 0.457301
+ 8.7255556 0.441952
+ 8.7258333 0.415874
+ 8.7261111 0.381176
+ 8.7263889 0.339961
+ 8.7266667 0.294336
+ 8.7269444 0.246408
+ 8.7272222 0.198282
+ 8.7275000 0.152064
+ 8.7277778 0.109859
+ 8.7280556 0.073468
+ 8.7283333 0.050000
+ 8.7286111 0.050000
+ 8.7288889 0.050000
+ 8.7291667 0.050000
+ 8.7294444 0.050000
+ 8.7297222 0.050000
+ 8.7300000 0.050000
+ 8.7302778 0.050000
+ 8.7305556 0.064995
+ 8.7308333 0.103917
+ 8.7311111 0.149247
+ 8.7313889 0.198629
+ 8.7316667 0.249706
+ 8.7319444 0.300122
+ 8.7322222 0.347520
+ 8.7325000 0.389542
+ 8.7327778 0.423832
+ 8.7330556 0.448034
+ 8.7333333 0.459791
+ 8.7336111 0.457487
+ 8.7338889 0.442478
+ 8.7341667 0.416860
+ 8.7344444 0.382728
+ 8.7347222 0.342179
+ 8.7350000 0.297310
+ 8.7352778 0.250217
+ 8.7355556 0.202995
+ 8.7358333 0.157743
+ 8.7361111 0.116554
+ 8.7363889 0.081216
+ 8.7366667 0.052270
+ 8.7369444 0.050000
+ 8.7372222 0.050000
+ 8.7375000 0.050000
+ 8.7377778 0.050000
+ 8.7380556 0.050000
+ 8.7383333 0.050000
+ 8.7386111 0.050000
+ 8.7388889 0.078411
+ 8.7391667 0.116920
+ 8.7394444 0.161562
+ 8.7397222 0.210007
+ 8.7400000 0.259925
+ 8.7402778 0.308986
+ 8.7405556 0.354859
+ 8.7408333 0.395214
+ 8.7411111 0.427721
+ 8.7413889 0.450049
+ 8.7416667 0.459869
+ 8.7419444 0.455596
+ 8.7422222 0.438629
+ 8.7425000 0.411110
+ 8.7427778 0.375186
+ 8.7430556 0.332998
+ 8.7433333 0.286692
+ 8.7436111 0.238412
+ 8.7438889 0.190301
+ 8.7441667 0.144504
+ 8.7444444 0.103164
+ 8.7447222 0.068095
+ 8.7450000 0.050000
+ 8.7452778 0.050000
+ 8.7455556 0.050000
+ 8.7458333 0.050000
+ 8.7461111 0.050000
+ 8.7463889 0.050000
+ 8.7466667 0.050000
+ 8.7469444 0.050000
+ 8.7472222 0.075025
+ 8.7475000 0.114063
+ 8.7477778 0.158992
+ 8.7480556 0.207557
+ 8.7483333 0.257502
+ 8.7486111 0.306573
+ 8.7488889 0.352514
+ 8.7491667 0.393071
+ 8.7494444 0.425988
+ 8.7497222 0.449010
+ 8.7500000 0.459882
+ 8.7502778 0.457069
+ 8.7505556 0.441910
+ 8.7508333 0.416463
+ 8.7511111 0.382789
+ 8.7513889 0.342945
+ 8.7516667 0.298991
+ 8.7519444 0.252985
+ 8.7522222 0.206987
+ 8.7525000 0.163056
+ 8.7527778 0.123249
+ 8.7530556 0.089314
+ 8.7533333 0.061742
+ 8.7536111 0.050000
+ 8.7538889 0.050000
+ 8.7541667 0.050000
+ 8.7544444 0.050000
+ 8.7547222 0.050000
+ 8.7550000 0.050000
+ 8.7552778 0.061992
+ 8.7555556 0.091788
+ 8.7558333 0.129165
+ 8.7561111 0.172309
+ 8.7563889 0.219011
+ 8.7566667 0.267059
+ 8.7569444 0.314244
+ 8.7572222 0.358354
+ 8.7575000 0.397180
+ 8.7577778 0.428510
+ 8.7580556 0.450135
+ 8.7583333 0.459843
+ 8.7586111 0.456132
+ 8.7588889 0.440332
+ 8.7591667 0.414481
+ 8.7594444 0.380616
+ 8.7597222 0.340775
+ 8.7600000 0.296995
+ 8.7602778 0.251315
+ 8.7605556 0.205772
+ 8.7608333 0.162405
+ 8.7611111 0.123249
+ 8.7613889 0.090032
+ 8.7616667 0.063223
+ 8.7619444 0.050000
+ 8.7622222 0.050000
+ 8.7625000 0.050000
+ 8.7627778 0.050000
+ 8.7630556 0.050000
+ 8.7633333 0.050000
+ 8.7636111 0.068346
+ 8.7638889 0.098522
+ 8.7641667 0.136139
+ 8.7644444 0.179366
+ 8.7647222 0.225976
+ 8.7650000 0.273743
+ 8.7652778 0.320440
+ 8.7655556 0.363840
+ 8.7658333 0.401716
+ 8.7661111 0.431842
+ 8.7663889 0.451991
+ 8.7666667 0.459935
+ 8.7669444 0.454179
+ 8.7672222 0.436156
+ 8.7675000 0.408027
+ 8.7677778 0.371955
+ 8.7680556 0.330105
+ 8.7683333 0.284637
+ 8.7686111 0.237716
+ 8.7688889 0.191504
+ 8.7691667 0.148164
+ 8.7694444 0.109859
+ 8.7697222 0.078385
+ 8.7700000 0.054064
+ 8.7702778 0.050000
+ 8.7705556 0.050000
+ 8.7708333 0.050000
+ 8.7711111 0.050000
+ 8.7713889 0.050000
+ 8.7716667 0.055952
+ 8.7719444 0.080496
+ 8.7722222 0.111847
+ 8.7725000 0.149631
+ 8.7727778 0.192154
+ 8.7730556 0.237392
+ 8.7733333 0.283320
+ 8.7736111 0.327915
+ 8.7738889 0.369151
+ 8.7741667 0.405004
+ 8.7744444 0.433451
+ 8.7747222 0.452466
+ 8.7750000 0.460026
+ 8.7752778 0.454776
+ 8.7755556 0.438040
+ 8.7758333 0.411812
+ 8.7761111 0.378087
+ 8.7763889 0.338857
+ 8.7766667 0.296118
+ 8.7769444 0.251863
+ 8.7772222 0.208087
+ 8.7775000 0.166782
+ 8.7777778 0.129944
+ 8.7780556 0.099243
+ 8.7783333 0.075052
+ 8.7786111 0.057422
+ 8.7788889 0.050000
+ 8.7791667 0.050000
+ 8.7794444 0.050000
+ 8.7797222 0.053512
+ 8.7800000 0.069439
+ 8.7802778 0.092228
+ 8.7805556 0.121929
+ 8.7808333 0.158242
+ 8.7811111 0.199467
+ 8.7813889 0.243554
+ 8.7816667 0.288451
+ 8.7819444 0.332108
+ 8.7822222 0.372475
+ 8.7825000 0.407501
+ 8.7827778 0.435135
+ 8.7830556 0.453327
+ 8.7833333 0.460026
+ 8.7836111 0.453868
+ 8.7838889 0.436233
+ 8.7841667 0.409187
+ 8.7844444 0.374797
+ 8.7847222 0.335129
+ 8.7850000 0.292250
+ 8.7852778 0.248226
+ 8.7855556 0.205122
+ 8.7858333 0.165006
+ 8.7861111 0.129944
+ 8.7863889 0.101636
+ 8.7866667 0.080316
+ 8.7869444 0.065852
+ 8.7872222 0.058111
+ 8.7875000 0.056960
+ 8.7877778 0.062268
+ 8.7880556 0.073903
+ 8.7883333 0.091731
+ 8.7886111 0.115621
+ 8.7888889 0.145440
+ 8.7891667 0.180775
+ 8.7894444 0.220091
+ 8.7897222 0.261573
+ 8.7900000 0.303406
+ 8.7902778 0.343773
+ 8.7905556 0.380860
+ 8.7908333 0.412851
+ 8.7911111 0.437930
+ 8.7913889 0.454282
+ 8.7916667 0.460092
+ 8.7919444 0.454151
+ 8.7922222 0.437683
+ 8.7925000 0.412519
+ 8.7927778 0.380490
+ 8.7930556 0.343426
+ 8.7933333 0.303160
+ 8.7936111 0.261521
+ 8.7938889 0.220342
+ 8.7941667 0.181451
+ 8.7944444 0.146682
+ 8.7947222 0.117571
+ 8.7950000 0.094485
+ 8.7952778 0.077495
+ 8.7955556 0.066675
+ 8.7958333 0.062097
+ 8.7961111 0.063834
+ 8.7963889 0.071959
+ 8.7966667 0.086544
+ 8.7969444 0.107661
+ 8.7972222 0.135384
+ 8.7975000 0.169453
+ 8.7977778 0.208282
+ 8.7980556 0.249953
+ 8.7983333 0.292547
+ 8.7986111 0.334147
+ 8.7988889 0.372834
+ 8.7991667 0.406690
+ 8.7994444 0.433797
+ 8.7997222 0.452237
+ 8.8000000 0.460092
+ 8.8002778 0.456065
+ 8.8005556 0.441350
+ 8.8008333 0.417763
+ 8.8011111 0.387119
+ 8.8013889 0.351233
+ 8.8016667 0.311921
+ 8.8019444 0.270999
+ 8.8022222 0.230282
+ 8.8025000 0.191585
+ 8.8027778 0.156724
+ 8.8030556 0.127232
+ 8.8033333 0.103509
+ 8.8036111 0.085671
+ 8.8038889 0.073835
+ 8.8041667 0.068120
+ 8.8044444 0.068641
+ 8.8047222 0.075517
+ 8.8050000 0.088863
+ 8.8052778 0.108797
+ 8.8055556 0.135436
+ 8.8058333 0.168562
+ 8.8061111 0.206608
+ 8.8063889 0.247675
+ 8.8066667 0.289860
+ 8.8069444 0.331265
+ 8.8072222 0.369986
+ 8.8075000 0.404124
+ 8.8077778 0.431777
+ 8.8080556 0.451045
+ 8.8083333 0.460026
+ 8.8086111 0.457424
+ 8.8088889 0.444359
+ 8.8091667 0.422556
+ 8.8094444 0.393738
+ 8.8097222 0.359631
+ 8.8100000 0.321960
+ 8.8102778 0.282448
+ 8.8105556 0.242820
+ 8.8108333 0.204800
+ 8.8111111 0.170114
+ 8.8113889 0.140236
+ 8.8116667 0.115636
+ 8.8119444 0.096538
+ 8.8122222 0.083163
+ 8.8125000 0.075733
+ 8.8127778 0.074469
+ 8.8130556 0.079593
+ 8.8133333 0.091328
+ 8.8136111 0.109895
+ 8.8138889 0.135515
+ 8.8141667 0.168042
+ 8.8144444 0.205856
+ 8.8147222 0.246968
+ 8.8150000 0.289390
+ 8.8152778 0.331132
+ 8.8155556 0.370206
+ 8.8158333 0.404624
+ 8.8161111 0.432397
+ 8.8163889 0.451536
+ 8.8166667 0.460052
+ 8.8169444 0.456594
+ 8.8172222 0.442356
+ 8.8175000 0.419168
+ 8.8177778 0.388862
+ 8.8180556 0.353269
+ 8.8183333 0.314219
+ 8.8186111 0.273543
+ 8.8188889 0.233073
+ 8.8191667 0.194639
+ 8.8194444 0.160072
+ 8.8197222 0.130915
+ 8.8200000 0.107561
+ 8.8202778 0.090113
+ 8.8205556 0.078676
+ 8.8208333 0.073355
+ 8.8211111 0.074254
+ 8.8213889 0.081476
+ 8.8216667 0.095127
+ 8.8219444 0.115311
+ 8.8222222 0.142131
+ 8.8225000 0.175355
+ 8.8227778 0.213396
+ 8.8230556 0.254329
+ 8.8233333 0.296228
+ 8.8236111 0.337171
+ 8.8238889 0.375231
+ 8.8241667 0.408485
+ 8.8244444 0.435007
+ 8.8247222 0.452872
+ 8.8250000 0.460157
+ 8.8252778 0.455555
+ 8.8255556 0.440237
+ 8.8258333 0.415993
+ 8.8261111 0.384612
+ 8.8263889 0.347885
+ 8.8266667 0.307600
+ 8.8269444 0.265547
+ 8.8272222 0.223517
+ 8.8275000 0.183299
+ 8.8277778 0.146682
+ 8.8280556 0.115196
+ 8.8283333 0.089329
+ 8.8286111 0.069309
+ 8.8288889 0.055362
+ 8.8291667 0.050000
+ 8.8294444 0.050000
+ 8.8297222 0.052245
+ 8.8300000 0.064872
+ 8.8302778 0.084712
+ 8.8305556 0.111991
+ 8.8308333 0.146554
+ 8.8311111 0.186707
+ 8.8313889 0.230374
+ 8.8316667 0.275476
+ 8.8319444 0.319937
+ 8.8322222 0.361680
+ 8.8325000 0.398627
+ 8.8327778 0.428701
+ 8.8330556 0.449825
+ 8.8333333 0.459922
+ 8.8336111 0.457559
+ 8.8338889 0.443891
+ 8.8341667 0.420715
+ 8.8344444 0.389829
+ 8.8347222 0.353033
+ 8.8350000 0.312124
+ 8.8352778 0.268901
+ 8.8355556 0.225163
+ 8.8358333 0.182708
+ 8.8361111 0.143334
+ 8.8363889 0.108608
+ 8.8366667 0.079162
+ 8.8369444 0.055398
+ 8.8372222 0.050000
+ 8.8375000 0.050000
+ 8.8377778 0.050000
+ 8.8380556 0.050000
+ 8.8383333 0.050000
+ 8.8386111 0.054607
+ 8.8388889 0.081850
+ 8.8391667 0.117536
+ 8.8394444 0.159815
+ 8.8397222 0.206393
+ 8.8400000 0.254971
+ 8.8402778 0.303253
+ 8.8405556 0.348942
+ 8.8408333 0.389741
+ 8.8411111 0.423353
+ 8.8413889 0.447482
+ 8.8416667 0.459830
+ 8.8419444 0.458801
+ 8.8422222 0.445596
+ 8.8425000 0.422120
+ 8.8427778 0.390272
+ 8.8430556 0.351957
+ 8.8433333 0.309076
+ 8.8436111 0.263532
+ 8.8438889 0.217228
+ 8.8441667 0.172064
+ 8.8444444 0.129944
+ 8.8447222 0.092531
+ 8.8450000 0.060529
+ 8.8452778 0.050000
+ 8.8455556 0.050000
+ 8.8458333 0.050000
+ 8.8461111 0.050000
+ 8.8463889 0.050000
+ 8.8466667 0.050000
+ 8.8469444 0.050000
+ 8.8472222 0.055018
+ 8.8475000 0.092130
+ 8.8477778 0.136420
+ 8.8480556 0.185478
+ 8.8483333 0.236891
+ 8.8486111 0.288249
+ 8.8488889 0.337139
+ 8.8491667 0.381149
+ 8.8494444 0.417869
+ 8.8497222 0.444887
+ 8.8500000 0.459791
+ 8.8502778 0.460897
+ 8.8505556 0.449434
+ 8.8508333 0.427359
+ 8.8511111 0.396626
+ 8.8513889 0.359193
+ 8.8516667 0.317016
+ 8.8519444 0.272050
+ 8.8522222 0.226253
+ 8.8525000 0.181580
+ 8.8527778 0.139987
+ 8.8530556 0.103176
+ 8.8533333 0.071824
+ 8.8536111 0.050000
+ 8.8538889 0.050000
+ 8.8541667 0.050000
+ 8.8544444 0.050000
+ 8.8547222 0.050000
+ 8.8550000 0.050000
+ 8.8552778 0.050000
+ 8.8555556 0.068395
+ 8.8558333 0.104776
+ 8.8561111 0.148067
+ 8.8563889 0.195906
+ 8.8566667 0.245932
+ 8.8569444 0.295783
+ 8.8572222 0.343098
+ 8.8575000 0.385515
+ 8.8577778 0.420673
+ 8.8580556 0.446210
+ 8.8583333 0.459765
+ 8.8586111 0.459692
+ 8.8588889 0.447214
+ 8.8591667 0.424267
+ 8.8594444 0.392790
+ 8.8597222 0.354720
+ 8.8600000 0.311994
+ 8.8602778 0.266551
+ 8.8605556 0.220327
+ 8.8608333 0.175262
+ 8.8611111 0.133292
+ 8.8613889 0.096107
+ 8.8616667 0.064402
+ 8.8619444 0.050000
+ 8.8622222 0.050000
+ 8.8625000 0.050000
+ 8.8627778 0.050000
+ 8.8630556 0.050000
+ 8.8633333 0.050000
+ 8.8636111 0.050000
+ 8.8638889 0.061726
+ 8.8641667 0.098990
+ 8.8644444 0.143321
+ 8.8647222 0.192281
+ 8.8650000 0.243431
+ 8.8652778 0.294333
+ 8.8655556 0.342547
+ 8.8658333 0.385636
+ 8.8661111 0.421161
+ 8.8663889 0.446684
+ 8.8666667 0.459765
+ 8.8669444 0.458713
+ 8.8672222 0.444823
+ 8.8675000 0.420137
+ 8.8677778 0.386697
+ 8.8680556 0.346544
+ 8.8683333 0.301720
+ 8.8686111 0.254268
+ 8.8688889 0.206228
+ 8.8691667 0.159643
+ 8.8694444 0.116554
+ 8.8697222 0.078728
+ 8.8700000 0.050000
+ 8.8702778 0.050000
+ 8.8705556 0.050000
+ 8.8708333 0.050000
+ 8.8711111 0.050000
+ 8.8713889 0.050000
+ 8.8716667 0.050000
+ 8.8719444 0.050000
+ 8.8722222 0.051631
+ 8.8725000 0.090090
+ 8.8727778 0.135546
+ 8.8730556 0.185571
+ 8.8733333 0.237737
+ 8.8736111 0.289618
+ 8.8738889 0.338786
+ 8.8741667 0.382813
+ 8.8744444 0.419273
+ 8.8747222 0.445737
+ 8.8750000 0.459778
+ 8.8752778 0.459709
+ 8.8755556 0.446804
+ 8.8758333 0.423079
+ 8.8761111 0.390548
+ 8.8763889 0.351224
+ 8.8766667 0.307124
+ 8.8769444 0.260262
+ 8.8772222 0.212653
+ 8.8775000 0.166310
+ 8.8777778 0.123249
+ 8.8780556 0.085221
+ 8.8783333 0.052914
+ 8.8786111 0.050000
+ 8.8788889 0.050000
+ 8.8791667 0.050000
+ 8.8794444 0.050000
+ 8.8797222 0.050000
+ 8.8800000 0.050000
+ 8.8802778 0.050000
+ 8.8805556 0.051631
+ 8.8808333 0.089534
+ 8.8811111 0.134565
+ 8.8813889 0.184293
+ 8.8816667 0.236288
+ 8.8819444 0.288118
+ 8.8822222 0.337355
+ 8.8825000 0.381565
+ 8.8827778 0.418320
+ 8.8830556 0.445188
+ 8.8833333 0.459738
+ 8.8836111 0.460278
+ 8.8838889 0.448059
+ 8.8841667 0.425075
+ 8.8844444 0.393314
+ 8.8847222 0.354769
+ 8.8850000 0.311429
+ 8.8852778 0.265286
+ 8.8855556 0.218330
+ 8.8858333 0.172553
+ 8.8861111 0.129944
+ 8.8863889 0.092238
+ 8.8866667 0.060136
+ 8.8869444 0.050000
+ 8.8872222 0.050000
+ 8.8875000 0.050000
+ 8.8877778 0.050000
+ 8.8880556 0.050000
+ 8.8883333 0.050000
+ 8.8886111 0.050000
+ 8.8888889 0.058405
+ 8.8891667 0.096253
+ 8.8894444 0.141225
+ 8.8897222 0.190840
+ 8.8900000 0.242617
+ 8.8902778 0.294077
+ 8.8905556 0.342737
+ 8.8908333 0.386118
+ 8.8911111 0.421739
+ 8.8913889 0.447119
+ 8.8916667 0.459778
+ 8.8919444 0.458000
+ 8.8922222 0.443134
+ 8.8925000 0.417291
+ 8.8927778 0.382584
+ 8.8930556 0.341126
+ 8.8933333 0.295029
+ 8.8936111 0.246407
+ 8.8938889 0.197372
+ 8.8941667 0.150036
+ 8.8944444 0.106512
+ 8.8947222 0.068617
+ 8.8950000 0.050000
+ 8.8952778 0.050000
+ 8.8955556 0.050000
+ 8.8958333 0.050000
+ 8.8961111 0.050000
+ 8.8963889 0.050000
+ 8.8966667 0.050000
+ 8.8969444 0.050000
+ 8.8972222 0.050000
+ 8.8975000 0.089495
+ 8.8977778 0.135848
+ 8.8980556 0.186611
+ 8.8983333 0.239334
+ 8.8986111 0.291570
+ 8.8988889 0.340868
+ 8.8991667 0.384781
+ 8.8994444 0.420858
+ 8.8997222 0.446652
+ 8.9000000 0.459712
+ 8.9002778 0.458313
+ 8.9005556 0.443614
+ 8.9008333 0.417496
+ 8.9011111 0.381842
+ 8.9013889 0.338534
+ 8.9016667 0.289452
+ 8.9019444 0.236480
+ 8.9022222 0.181499
+ 8.9025000 0.126391
+ 8.9027778 0.073037
+ 8.9030556 0.050000
+ 8.9033333 0.050000
+ 8.9036111 0.050000
+ 8.9038889 0.050000
+ 8.9041667 0.050000
+ 8.9044444 0.050000
+ 8.9047222 0.050000
+ 8.9050000 0.050000
+ 8.9052778 0.050000
+ 8.9055556 0.050000
+ )

* === R-PEAK DETECTOR (self-contained, drives measurement) ===
Vth_rpk rpeak_threshold 0 0.4
Xrpk ecg_amp_l0 rpeak_threshold rpeak_out vdd vss vbias rpeak_detector

* === BRIEF R-PEAK PULSES (digital monostable equivalent) ===
* In a real ASIC: rpeak_out feeds a digital edge detector (~3 gates)
* producing 0.5ms pulses. Here we inject the equivalent directly.
Vrpeak rpeak_pulse 0 PWL(
+ 0 0
+ 0.1999000 0
+ 0.1999500 0.9
+ 0.2005000 0.9
+ 0.2005500 0
+ 0.8526778 0
+ 0.8527278 0.9
+ 0.8532778 0.9
+ 0.8533278 0
+ 1.8471222 0
+ 1.8471722 0.9
+ 1.8477222 0.9
+ 1.8477722 0
+ 2.6915667 0
+ 2.6916167 0.9
+ 2.6921667 0.9
+ 2.6922167 0
+ 3.5026778 0
+ 3.5027278 0.9
+ 3.5032778 0.9
+ 3.5033278 0
+ 4.2915667 0
+ 4.2916167 0.9
+ 4.2921667 0.9
+ 4.2922167 0
+ 5.0637889 0
+ 5.0638389 0.9
+ 5.0643889 0.9
+ 5.0644389 0
+ 5.9026778 0
+ 5.9027278 0.9
+ 5.9032778 0.9
+ 5.9033278 0
+ 6.7582333 0
+ 6.7582833 0.9
+ 6.7588333 0.9
+ 6.7588833 0
+ 7.5804556 0
+ 7.5805056 0.9
+ 7.5810556 0.9
+ 7.5811056 0
+ )

* === DELAY TIMER ===
Xdelay rpeak_pulse trig_s14 trig_s69 trig_wid trig_bi_copy trig_rr_copy
+ vdd vss vbias vth_14 vth_69 vth_83 vth_300 vth_10 delay_timer
Vth14 vth_14 0 0.4757
Vth69 vth_69 0 0.4471
Vth83 vth_83 0 0.4684
Vth300 vth_300 0 0.3269
Vth10 vth_10 0 0.2282

* === RR TIMING (F1, F2) ===
Xrr ecg_amp_l0 trig_rr_cap rpeak_pulse trig_rr_copy
+   f1_rr_ratio f2_rr_asym rr_timer_node rr_ewma_node vdd vss vbias rr_timing

* === P-WAVE PREDICTOR ===
Vthpb vth_pw_base 0 0.425
Vthpp vth_pw_peak 0 0.415
Xpw rr_timer_node rr_ewma_node trig_pw_base trig_pw_peak trig_rr_cap
+ vth_pw_base vth_pw_peak vdd vss vbias pwave_predictor

* === FEATURE EXTRACTION ===
Xbi_l0 ecg_amp_l0 rpeak_pulse trig_bi_copy f3_bi_l0 vdd vss vbias beat_instability
Xbi_l1 ecg_amp_l1 rpeak_pulse trig_bi_copy f4_bi_l1 vdd vss vbias beat_instability
Xpwave ecg_amp_l0 trig_pw_base trig_pw_peak f5_pwave vdd vss vbias pwave_diff
Xwidth ecg_amp_l0 trig_wid f6_width vdd vss qrs_width
Xslope ecg_amp_l0 trig_s14 trig_s69 f7_slope vdd vss vbias qrs_slope
Xsym ecg_amp_l0 rpeak_pulse f8_symmetry vdd vss qrs_symmetry

* === INITIAL CONDITIONS ===
.ic v(xdelay.timer_node) = 0.9
.ic v(xdelay.timer2) = 0.9
.ic v(xrr.net_timer) = 0.9
.ic v(xrr.ewma_node) = 0.40
.ic v(xrr.prev_node) = 0.40
.ic v(xrr.esamp_node) = 0.40

.tran 0.5m 8.908 uic

.meas tran f1_rr_ratio_b1 FIND V(f1_rr_ratio) AT=0.842778
.meas tran f2_rr_asym_b1 FIND V(f2_rr_asym) AT=0.842778
.meas tran f3_bi_l0_b1 FIND V(f3_bi_l0) AT=0.842778
.meas tran f4_bi_l1_b1 FIND V(f4_bi_l1) AT=0.842778
.meas tran f5_pwave_b1 FIND V(f5_pwave) AT=0.842778
.meas tran f6_width_b1 FIND V(f6_width) AT=0.842778
.meas tran f7_slope_b1 FIND V(f7_slope) AT=0.842778
.meas tran f8_symmetry_b1 FIND V(f8_symmetry) AT=0.842778
.meas tran f1_rr_ratio_b2 FIND V(f1_rr_ratio) AT=1.837222
.meas tran f2_rr_asym_b2 FIND V(f2_rr_asym) AT=1.837222
.meas tran f3_bi_l0_b2 FIND V(f3_bi_l0) AT=1.837222
.meas tran f4_bi_l1_b2 FIND V(f4_bi_l1) AT=1.837222
.meas tran f5_pwave_b2 FIND V(f5_pwave) AT=1.837222
.meas tran f6_width_b2 FIND V(f6_width) AT=1.837222
.meas tran f7_slope_b2 FIND V(f7_slope) AT=1.837222
.meas tran f8_symmetry_b2 FIND V(f8_symmetry) AT=1.837222
.meas tran f1_rr_ratio_b3 FIND V(f1_rr_ratio) AT=2.681667
.meas tran f2_rr_asym_b3 FIND V(f2_rr_asym) AT=2.681667
.meas tran f3_bi_l0_b3 FIND V(f3_bi_l0) AT=2.681667
.meas tran f4_bi_l1_b3 FIND V(f4_bi_l1) AT=2.681667
.meas tran f5_pwave_b3 FIND V(f5_pwave) AT=2.681667
.meas tran f6_width_b3 FIND V(f6_width) AT=2.681667
.meas tran f7_slope_b3 FIND V(f7_slope) AT=2.681667
.meas tran f8_symmetry_b3 FIND V(f8_symmetry) AT=2.681667
.meas tran f1_rr_ratio_b4 FIND V(f1_rr_ratio) AT=3.492778
.meas tran f2_rr_asym_b4 FIND V(f2_rr_asym) AT=3.492778
.meas tran f3_bi_l0_b4 FIND V(f3_bi_l0) AT=3.492778
.meas tran f4_bi_l1_b4 FIND V(f4_bi_l1) AT=3.492778
.meas tran f5_pwave_b4 FIND V(f5_pwave) AT=3.492778
.meas tran f6_width_b4 FIND V(f6_width) AT=3.492778
.meas tran f7_slope_b4 FIND V(f7_slope) AT=3.492778
.meas tran f8_symmetry_b4 FIND V(f8_symmetry) AT=3.492778
.meas tran f1_rr_ratio_b5 FIND V(f1_rr_ratio) AT=4.281667
.meas tran f2_rr_asym_b5 FIND V(f2_rr_asym) AT=4.281667
.meas tran f3_bi_l0_b5 FIND V(f3_bi_l0) AT=4.281667
.meas tran f4_bi_l1_b5 FIND V(f4_bi_l1) AT=4.281667
.meas tran f5_pwave_b5 FIND V(f5_pwave) AT=4.281667
.meas tran f6_width_b5 FIND V(f6_width) AT=4.281667
.meas tran f7_slope_b5 FIND V(f7_slope) AT=4.281667
.meas tran f8_symmetry_b5 FIND V(f8_symmetry) AT=4.281667
.meas tran f1_rr_ratio_b6 FIND V(f1_rr_ratio) AT=5.053889
.meas tran f2_rr_asym_b6 FIND V(f2_rr_asym) AT=5.053889
.meas tran f3_bi_l0_b6 FIND V(f3_bi_l0) AT=5.053889
.meas tran f4_bi_l1_b6 FIND V(f4_bi_l1) AT=5.053889
.meas tran f5_pwave_b6 FIND V(f5_pwave) AT=5.053889
.meas tran f6_width_b6 FIND V(f6_width) AT=5.053889
.meas tran f7_slope_b6 FIND V(f7_slope) AT=5.053889
.meas tran f8_symmetry_b6 FIND V(f8_symmetry) AT=5.053889
.meas tran f1_rr_ratio_b7 FIND V(f1_rr_ratio) AT=5.892778
.meas tran f2_rr_asym_b7 FIND V(f2_rr_asym) AT=5.892778
.meas tran f3_bi_l0_b7 FIND V(f3_bi_l0) AT=5.892778
.meas tran f4_bi_l1_b7 FIND V(f4_bi_l1) AT=5.892778
.meas tran f5_pwave_b7 FIND V(f5_pwave) AT=5.892778
.meas tran f6_width_b7 FIND V(f6_width) AT=5.892778
.meas tran f7_slope_b7 FIND V(f7_slope) AT=5.892778
.meas tran f8_symmetry_b7 FIND V(f8_symmetry) AT=5.892778
.meas tran f1_rr_ratio_b8 FIND V(f1_rr_ratio) AT=6.748333
.meas tran f2_rr_asym_b8 FIND V(f2_rr_asym) AT=6.748333
.meas tran f3_bi_l0_b8 FIND V(f3_bi_l0) AT=6.748333
.meas tran f4_bi_l1_b8 FIND V(f4_bi_l1) AT=6.748333
.meas tran f5_pwave_b8 FIND V(f5_pwave) AT=6.748333
.meas tran f6_width_b8 FIND V(f6_width) AT=6.748333
.meas tran f7_slope_b8 FIND V(f7_slope) AT=6.748333
.meas tran f8_symmetry_b8 FIND V(f8_symmetry) AT=6.748333
.meas tran f1_rr_ratio_b9 FIND V(f1_rr_ratio) AT=7.570556
.meas tran f2_rr_asym_b9 FIND V(f2_rr_asym) AT=7.570556
.meas tran f3_bi_l0_b9 FIND V(f3_bi_l0) AT=7.570556
.meas tran f4_bi_l1_b9 FIND V(f4_bi_l1) AT=7.570556
.meas tran f5_pwave_b9 FIND V(f5_pwave) AT=7.570556
.meas tran f6_width_b9 FIND V(f6_width) AT=7.570556
.meas tran f7_slope_b9 FIND V(f7_slope) AT=7.570556
.meas tran f8_symmetry_b9 FIND V(f8_symmetry) AT=7.570556
.meas tran rpk_integ_r0 FIND V(rpeak_out) AT=0.200000
.meas tran rpk_integ_r1 FIND V(rpeak_out) AT=0.852778
.meas tran rpk_integ_r2 FIND V(rpeak_out) AT=1.847222
.meas tran rpk_integ_r3 FIND V(rpeak_out) AT=2.691667
.meas tran rpk_integ_r4 FIND V(rpeak_out) AT=3.502778
.meas tran rpk_integ_r5 FIND V(rpeak_out) AT=4.291667
.meas tran rpk_integ_r6 FIND V(rpeak_out) AT=5.063889
.meas tran rpk_integ_r7 FIND V(rpeak_out) AT=5.902778
.meas tran rpk_integ_r8 FIND V(rpeak_out) AT=6.758333
.meas tran rpk_integ_r9 FIND V(rpeak_out) AT=7.580556
.meas tran vbias_integ FIND V(vbias) AT=4.454167
.meas tran trg_s14_b1 FIND V(trig_s14) AT=0.904778
.meas tran trg_wid_b1 FIND V(trig_wid) AT=0.892778
.meas tran trg_s14_b2 FIND V(trig_s14) AT=1.899222
.meas tran trg_wid_b2 FIND V(trig_wid) AT=1.887222
.meas tran trg_s14_b3 FIND V(trig_s14) AT=2.743667
.meas tran trg_wid_b3 FIND V(trig_wid) AT=2.731667
.meas tran pwbase_b2 FIND V(trig_pw_base) AT=1.657222
.meas tran pwbase_b3 FIND V(trig_pw_base) AT=2.501667
.meas tran pwbase_b4 FIND V(trig_pw_base) AT=3.312778
.meas tran avg_idd AVG I(Vdd) FROM=0.5 TO=8.908

.control
run
.endc
.end
