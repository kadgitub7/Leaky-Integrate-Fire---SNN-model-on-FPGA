.title bias_gen
.lib "C:/Users/kadhi/OneDrive/Desktop/amux/verilogLearning/Leaky-Integrate-Fire---SNN-model-on-FPGA/experiments/frontend_optimization/ngspice_frontend/sky130_minimal.lib.spice" tt
.option scale=1.0u method=gear reltol=0.01 gmin=1e-15
.temp 27
Vdd vdd 0 0.9
Vss vss 0 0
.include "C:/Users/kadhi/OneDrive/Desktop/amux/verilogLearning/Leaky-Integrate-Fire---SNN-model-on-FPGA/experiments/frontend_optimization/complete_frontend/bias_gen.spice"
Xbias vbias vref vdd vss bias_gen
.ic V(xbias.iref)=0.3

.tran 0.1m 5m
.meas tran vbias_dc FIND V(vbias) AT=4.0e-3
.meas tran vref_dc FIND V(vref) AT=4.0e-3

.end
