* ============================================================
* FEATURES 1 & 2: RR Timing — v9 (slow EWMA + hybrid loads ~1.67x gain)
*
* Timer: 320pF MIM, VDD precharge at rpeak, ~148pA discharge
*   V_timer ≈ 0.59-0.62V at typical HR (0.6-0.67s)
*
* Source follower: NFET, level-shifts timer down by ~0.40V
*   V_sf ≈ 0.48V; CMOS TG switches (near-zero loss vs ~24mV NFET-only)
*
* Control signals (3 pins):
*   capture_trig: 2ms pulse, 5ms before rpeak
*   rpeak_trigger: 5ms pulse at rpeak (PMOS precharges timer to VDD)
*   copy_trig: 2ms pulse, 10ms after rpeak
*     Charge-shares esamp (5pF) ↔ ewma (330pF)
*     ewma_new = 0.015*sf_val + 0.985*ewma_old  (alpha≈0.015)
*
* Diff pair readout:
*   Hybrid load = active mirror + parallel diode PMOS (gain control)
*   Mirror W=2 + diode W=3 → gain ≈ 1.67x (expands 200mV to ~334mV)
*   v8→v9: reduced gain from 3x to 1.67x to eliminate clipping
*
* Pin: ecg_unused capture_trig rpeak_trigger copy_trig
*      rr_ratio_out rr_asym_out timer_out ewma_out vdd vss vbias
* ============================================================

.subckt rr_timing ecg_unused capture_trig rpeak_trigger copy_trig rr_ratio_out rr_asym_out timer_out ewma_out vdd vss vbias

* inverter_sub must be included by the top-level netlist
Xinv_trig rpeak_trigger rpeak_bar vdd vss inverter_sub

* === TIMER ===
XMrr_charge net_timer rpeak_bar vdd vdd sky130_fd_pr__pfet_01v8 L=0.5 W=2 nf=1
XMrr_drain net_timer vbias vss vss sky130_fd_pr__nfet_01v8 L=8 W=0.42 nf=1
XCtimer net_timer vss sky130_fd_pr__cap_mim_m3_1 W=400 L=400

* === SOURCE FOLLOWER ===
XMsf vdd net_timer sf_out vss sky130_fd_pr__nfet_01v8 L=8 W=0.42 nf=1
XMsf_bias sf_out vbias vss vss sky130_fd_pr__nfet_01v8 L=8 W=0.42 nf=1

* === COMPLEMENTARY CLOCKS FOR CMOS TGs ===
* NFET-only switches had ~24mV loss at Vsf≈0.4V (Vgs barely above Vth)
* CMOS TGs eliminate this: PFET conducts when NFET pinches off
Xinv_cap capture_trig capture_trig_bar vdd vss inverter_sub
Xinv_copy copy_trig copy_trig_bar vdd vss inverter_sub

* === PREV CAPTURE at capture_trig (CMOS TG) ===
XMprev sf_out capture_trig prev_node vss sky130_fd_pr__nfet_01v8 L=0.5 W=2 nf=1
XMprev_p sf_out capture_trig_bar prev_node vdd sky130_fd_pr__pfet_01v8 L=0.5 W=2 nf=1
XCprev prev_node vss sky130_fd_pr__cap_mim_m3_1 W=50 L=50

* === EWMA SAMPLE at capture_trig (CMOS TG) ===
XMesamp sf_out capture_trig esamp_node vss sky130_fd_pr__nfet_01v8 L=0.5 W=2 nf=1
XMesamp_p sf_out capture_trig_bar esamp_node vdd sky130_fd_pr__pfet_01v8 L=0.5 W=2 nf=1
XCesamp esamp_node vss sky130_fd_pr__cap_mim_m3_1 W=50 L=50

* === EWMA CHARGE-SHARE at copy_trig (CMOS TG) ===
* alpha = Cesamp/(Cesamp+Cewma) = 5/(5+330) ≈ 0.015
XMewma esamp_node copy_trig ewma_node vss sky130_fd_pr__nfet_01v8 L=0.5 W=2 nf=1
XMewma_p esamp_node copy_trig_bar ewma_node vdd sky130_fd_pr__pfet_01v8 L=0.5 W=2 nf=1
XCewma ewma_node vss sky130_fd_pr__cap_mim_m3_1 W=405 L=405

* === DIFF PAIR: rr_ratio (diode loads, gain ~1) ===
* Tail current source
XMtail_r tail_r vbias vss vss sky130_fd_pr__nfet_01v8 L=8 W=0.42 nf=1
* Input diff pair — ewma on reference side, sf_out on output side
XMd1_r net_r1 ewma_node tail_r vss sky130_fd_pr__nfet_01v8 L=1 W=8 nf=1
XMd2_r rr_ratio_out sf_out tail_r vss sky130_fd_pr__nfet_01v8 L=1 W=8 nf=1
* Both sides: diode-connected (gain ~1, 0% clipping, minimum energy)
XMl1_r net_r1 net_r1 vdd vdd sky130_fd_pr__pfet_01v8 L=4 W=2 nf=1
XMl2_r rr_ratio_out rr_ratio_out vdd vdd sky130_fd_pr__pfet_01v8 L=4 W=2 nf=1

* === DIFF PAIR: rr_asym (diode loads, gain ~1) ===
* Tail current source
XMtail_a tail_a vbias vss vss sky130_fd_pr__nfet_01v8 L=8 W=0.42 nf=1
* Input diff pair
XMd1_a net_a1 sf_out tail_a vss sky130_fd_pr__nfet_01v8 L=1 W=8 nf=1
XMd2_a rr_asym_out prev_node tail_a vss sky130_fd_pr__nfet_01v8 L=1 W=8 nf=1
* Both sides: diode-connected (gain ~1, 0% clipping, minimum energy)
XMl1_a net_a1 net_a1 vdd vdd sky130_fd_pr__pfet_01v8 L=4 W=2 nf=1
XMl2_a rr_asym_out rr_asym_out vdd vdd sky130_fd_pr__pfet_01v8 L=4 W=2 nf=1

* Expose internal nodes for P-wave predictor
R_timer_out sf_out timer_out 0
R_ewma_out ewma_node ewma_out 0

.ends rr_timing
