.title energy_measurement_complete_asic_frontend
.lib "C:/Users/kadhi/OneDrive/Desktop/amux/verilogLearning/Leaky-Integrate-Fire---SNN-model-on-FPGA/experiments/frontend_optimization/ngspice_frontend/sky130_minimal.lib.spice" tt
.option scale=1.0u method=gear reltol=0.01 gmin=1e-15
.temp 27

* ============================================================
* POWER SUPPLY — single VDD with current measurement
* ALL circuits powered from this one supply
* ============================================================
Vmeas vdd_ext vdd 0
Vvdd vdd_ext 0 0.9
Vss vss 0 0

* ============================================================
* 1. BIAS GENERATOR
*    Use ideal source for correct biasing (ensures DC convergence)
*    AND instantiate bias_gen subcircuit for its current draw.
*    In real ASIC, bias_gen replaces the ideal source.
* ============================================================
.include "C:/Users/kadhi/OneDrive/Desktop/amux/verilogLearning/Leaky-Integrate-Fire---SNN-model-on-FPGA/experiments/frontend_optimization/complete_frontend/bias_gen.spice"
Vbias_ideal vbias 0 0.300
Vref_ideal vref 0 0.300

* Bias gen draws current from VDD (connected to its own internal nodes)
Xbias bg_vbias bg_vref vdd vss bias_gen
.ic V(bg_vbias)=0.3

* ============================================================
* 2. INSTRUMENTATION AMPLIFIERS (2×, one per lead)
*    In this testbench: ECG is pre-amplified, so IAs see the
*    same signal and add their quiescent current to VDD.
*    In real ASIC: IAs would amplify raw electrode signals.
* ============================================================
.include "C:/Users/kadhi/OneDrive/Desktop/amux/verilogLearning/Leaky-Integrate-Fire---SNN-model-on-FPGA/experiments/frontend_optimization/complete_frontend/ia.spice"

* IA for Lead 0: single-ended input (differential pair sees ecg vs vref)
Xia_l0 ecg_l0 vref ia_out_l0 vdd vss vbias vref ia

* IA for Lead 1: single-ended input
Xia_l1 ecg_l1 vref ia_out_l1 vdd vss vbias vref ia

* ============================================================
* 3. R-PEAK DETECTOR (comparator watching Lead 0)
* ============================================================
.include "C:/Users/kadhi/OneDrive/Desktop/amux/verilogLearning/Leaky-Integrate-Fire---SNN-model-on-FPGA/experiments/frontend_optimization/complete_frontend/rpeak_detector.spice"
Vthresh rpeak_thresh 0 0.36
Xrpeak ecg_l0 rpeak_thresh rpeak_det_out vdd vss vbias rpeak_detector

* ============================================================
* 4. POST-R DELAY TIMER (5 comparators + timer cap)
*    Powered and drawing quiescent current.
*    Triggers come from external PWL for simulation accuracy.
* ============================================================
.include "C:/Users/kadhi/OneDrive/Desktop/amux/verilogLearning/Leaky-Integrate-Fire---SNN-model-on-FPGA/experiments/frontend_optimization/complete_frontend/inverter.spice"
.include "C:/Users/kadhi/OneDrive/Desktop/amux/verilogLearning/Leaky-Integrate-Fire---SNN-model-on-FPGA/experiments/frontend_optimization/complete_frontend/delay_timer.spice"

* Threshold voltages for the delay comparators
Vth14 vth_14 0 0.858
Vth69 vth_69 0 0.693
Vth83 vth_83 0 0.651
Vth300 vth_300 0 0.010
Vth10 vth_10 0 0.870

* Delay timer driven by rpeak detection output
Xdelay rpeak_det_out dt_s14 dt_s69 dt_wid dt_bi_copy dt_rr_copy vdd vss vbias vth_14 vth_69 vth_83 vth_300 vth_10 delay_timer

* ============================================================
* 5. P-WAVE PREDICTOR (2 source followers + 2 comparators)
*    Connected to the RR timer node for adaptive prediction.
*    Draws quiescent current from VDD.
* ============================================================
.include "C:/Users/kadhi/OneDrive/Desktop/amux/verilogLearning/Leaky-Integrate-Fire---SNN-model-on-FPGA/experiments/frontend_optimization/complete_frontend/pwave_predictor.spice"

* Connect to a dummy timer/EWMA node (voltage divider)
* In real operation these connect to rr_timing internal nodes
Rpw_timer_dummy vdd pw_timer_dummy 1e12
Rpw_ewma_dummy vdd pw_ewma_dummy 1e12
Cpw_timer pw_timer_dummy vss 1p
Cpw_ewma pw_ewma_dummy vss 1p

Xpw_pred pw_timer_dummy pw_ewma_dummy pw_pred_base pw_pred_peak vdd vss vbias pwave_predictor

* ============================================================
* 6-13. FEATURE EXTRACTION CIRCUITS (8 total)
*        These are the validated circuits from individual testing.
*        All share VDD, VSS, VBIAS.
* ============================================================

* ECG inputs (pre-amplified for simulation accuracy)
Vecg0 ecg_l0 0 PWL(0.0000000 0.300000 1.7450000 0.300000 1.7500000 0.279963 1.7527778 0.279963 1.7555556 0.279963 1.7583333 0.280847 1.7611111 0.280847 1.7638889 0.280847 1.7666667 0.279669 1.7694444 0.279374 1.7722222 0.279963 1.7750000 0.280552 1.7777778 0.281142 1.7805556 0.281731 1.7833333 0.282026 1.7861111 0.282026 1.7888889 0.283794 1.7916667 0.284088 1.7944444 0.284972 1.7972222 0.284678 1.8000000 0.284383 1.8027778 0.284678 1.8055556 0.285267 1.8083333 0.286151 1.8111111 0.286151 1.8138889 0.287035 1.8166667 0.286151 1.8194444 0.286151 1.8222222 0.287035 1.8250000 0.286446 1.8277778 0.286740 1.8305556 0.286151 1.8333333 0.285562 1.8361111 0.284972 1.8388889 0.285856 1.8416667 0.286446 1.8444444 0.286446 1.8472222 0.285267 1.8500000 0.284972 1.8527778 0.285267 1.8555556 0.286446 1.8583333 0.287919 1.8611111 0.288508 1.8638889 0.287624 1.8666667 0.286446 1.8694444 0.284088 1.8722222 0.284088 1.8750000 0.283204 1.8777778 0.283204 1.8805556 0.281731 1.8833333 0.280552 1.8861111 0.279963 1.8888889 0.279963 1.8916667 0.279669 1.8944444 0.279374 1.8972222 0.279374 1.9000000 0.279963 1.9027778 0.279079 1.9055556 0.279669 1.9083333 0.279963 1.9111111 0.279963 1.9138889 0.279669 1.9166667 0.279079 1.9194444 0.278195 1.9222222 0.279079 1.9250000 0.278195 1.9277778 0.279669 1.9305556 0.279963 1.9333333 0.278785 1.9361111 0.277606 1.9388889 0.278785 1.9416667 0.279669 1.9444444 0.279374 1.9472222 0.279374 1.9500000 0.279079 1.9527778 0.277606 1.9555556 0.277017 1.9583333 0.276722 1.9611111 0.274954 1.9638889 0.273186 1.9666667 0.272007 1.9694444 0.269945 1.9722222 0.267882 1.9750000 0.268177 1.9777778 0.270829 1.9805556 0.276133 1.9833333 0.282615 1.9861111 0.290571 1.9888889 0.302357 1.9916667 0.318564 1.9944444 0.335064 1.9972222 0.347145 2.0000000 0.352155 2.0027778 0.346851 2.0055556 0.330645 2.0083333 0.307661 2.0111111 0.287330 2.0138889 0.274954 2.0166667 0.270534 2.0194444 0.271123 2.0222222 0.273481 2.0250000 0.276427 2.0277778 0.277017 2.0305556 0.276722 2.0333333 0.276722 2.0361111 0.276427 2.0388889 0.277017 2.0416667 0.277606 2.0444444 0.277311 2.0472222 0.277311 2.0500000 0.276427 2.0527778 0.275838 2.0555556 0.275838 2.0583333 0.277017 2.0611111 0.277017 2.0638889 0.276133 2.0666667 0.276133 2.0694444 0.275543 2.0722222 0.275838 2.0750000 0.276722 2.0777778 0.276722 2.0805556 0.276427 2.0833333 0.275543 2.0861111 0.275543 2.0888889 0.275543 2.0916667 0.276427 2.0944444 0.277017 2.0972222 0.277017 2.1000000 0.275838 2.1027778 0.275543 2.1055556 0.276133 2.1083333 0.276722 2.1111111 0.276722 2.1138889 0.276722 2.1166667 0.276133 2.1194444 0.275838 2.1222222 0.275838 2.1250000 0.276427 2.1277778 0.277017 2.1305556 0.276722 2.1333333 0.275838 2.1361111 0.274954 2.1388889 0.275543 2.1416667 0.276133 2.1444444 0.275838 2.1472222 0.276133 2.1500000 0.275543 2.1527778 0.274954 2.1555556 0.274954 2.1583333 0.275838 2.1611111 0.276722 2.1638889 0.277017 2.1666667 0.276427 2.1694444 0.275838 2.1722222 0.275838 2.1750000 0.276427 2.1777778 0.277017 2.1805556 0.275838 2.1833333 0.275249 2.1861111 0.275249 2.1888889 0.275543 2.1916667 0.275543 2.1944444 0.276133 2.1972222 0.275249 2.2000000 0.275543 2.2027778 0.274954 2.2055556 0.275838 2.2083333 0.276427 2.2111111 0.276133 2.2138889 0.276427 2.2166667 0.276427 2.2194444 0.275838 2.2222222 0.276427 2.2250000 0.276722 2.2277778 0.276722 2.2305556 0.276133 2.2333333 0.275838 2.2361111 0.274954 2.2388889 0.274954 2.2416667 0.275838 2.2444444 0.275838 2.2472222 0.275249 2.2500000 0.274659 2.2527778 0.273775 2.2555556 0.274070 2.2583333 0.274365 2.2611111 0.274659 2.2638889 0.274659 2.2666667 0.273481 2.2694444 0.273775 2.2722222 0.273775 2.2750000 0.274365 2.2777778 0.274365 2.2805556 0.273775 2.2833333 0.274070 2.2861111 0.273481 2.2888889 0.274659 2.2916667 0.274659 2.2944444 0.275543 2.2972222 0.276427 2.3050000 0.300000 2.5616667 0.300000 2.5666667 0.280552 2.5694444 0.280552 2.5722222 0.280847 2.5750000 0.281436 2.5777778 0.281436 2.5805556 0.281436 2.5833333 0.280552 2.5861111 0.280552 2.5888889 0.281142 2.5916667 0.281436 2.5944444 0.282026 2.5972222 0.282026 2.6000000 0.282615 2.6027778 0.281436 2.6055556 0.282320 2.6083333 0.283794 2.6111111 0.284972 2.6138889 0.284972 2.6166667 0.284678 2.6194444 0.284383 2.6222222 0.284972 2.6250000 0.286151 2.6277778 0.286446 2.6305556 0.286740 2.6333333 0.287035 2.6361111 0.287035 2.6388889 0.287330 2.6416667 0.288214 2.6444444 0.287919 2.6472222 0.287919 2.6500000 0.286740 2.6527778 0.286151 2.6555556 0.285856 2.6583333 0.286446 2.6611111 0.287330 2.6638889 0.285856 2.6666667 0.285856 2.6694444 0.285267 2.6722222 0.286151 2.6750000 0.287624 2.6777778 0.288214 2.6805556 0.287035 2.6833333 0.284972 2.6861111 0.283794 2.6888889 0.283204 2.6916667 0.282320 2.6944444 0.282026 2.6972222 0.281142 2.7000000 0.280552 2.7027778 0.280847 2.7055556 0.281142 2.7083333 0.280552 2.7111111 0.280552 2.7138889 0.280258 2.7166667 0.279963 2.7194444 0.279669 2.7222222 0.279963 2.7250000 0.280258 2.7277778 0.281142 2.7305556 0.280847 2.7333333 0.280258 2.7361111 0.279669 2.7388889 0.279669 2.7416667 0.279669 2.7444444 0.280258 2.7472222 0.279963 2.7500000 0.279669 2.7527778 0.279079 2.7555556 0.279963 2.7583333 0.279963 2.7611111 0.279963 2.7638889 0.279963 2.7666667 0.279669 2.7694444 0.279079 2.7722222 0.278490 2.7750000 0.278195 2.7777778 0.276133 2.7805556 0.273775 2.7833333 0.271713 2.7861111 0.270829 2.7888889 0.269355 2.7916667 0.268471 2.7944444 0.270239 2.7972222 0.275543 2.8000000 0.283499 2.8027778 0.292044 2.8055556 0.303831 2.8083333 0.317680 2.8111111 0.334180 2.8138889 0.347735 2.8166667 0.355691 2.8194444 0.354217 2.8222222 0.345672 2.8250000 0.326225 2.8277778 0.301179 2.8305556 0.282615 2.8333333 0.273775 2.8361111 0.272302 2.8388889 0.274954 2.8416667 0.277606 2.8444444 0.278785 2.8472222 0.278785 2.8500000 0.278195 2.8527778 0.277606 2.8555556 0.277606 2.8583333 0.277901 2.8611111 0.278195 2.8638889 0.278490 2.8666667 0.278195 2.8694444 0.277311 2.8722222 0.277311 2.8750000 0.277901 2.8777778 0.278195 2.8805556 0.278195 2.8833333 0.277311 2.8861111 0.276722 2.8888889 0.277311 2.8916667 0.277311 2.8944444 0.277017 2.8972222 0.277311 2.9000000 0.276722 2.9027778 0.275838 2.9055556 0.276427 2.9083333 0.276722 2.9111111 0.277606 2.9138889 0.276722 2.9166667 0.276722 2.9194444 0.276427 2.9222222 0.276427 2.9250000 0.276722 2.9277778 0.277017 2.9305556 0.277017 2.9333333 0.276722 2.9361111 0.276133 2.9388889 0.277017 2.9416667 0.277311 2.9444444 0.277901 2.9472222 0.277901 2.9500000 0.277606 2.9527778 0.277017 2.9555556 0.277311 2.9583333 0.278195 2.9611111 0.278195 2.9638889 0.278195 2.9666667 0.277901 2.9694444 0.277311 2.9722222 0.278195 2.9750000 0.277017 2.9777778 0.277901 2.9805556 0.278195 2.9833333 0.277606 2.9861111 0.277017 2.9888889 0.277017 2.9916667 0.277311 2.9944444 0.277901 2.9972222 0.277901 3.0000000 0.277311 3.0027778 0.276722 3.0055556 0.277017 3.0083333 0.277311 3.0111111 0.277901 3.0138889 0.277606 3.0166667 0.277311 3.0194444 0.277017 3.0222222 0.277606 3.0250000 0.277606 3.0277778 0.278195 3.0305556 0.278195 3.0333333 0.278490 3.0361111 0.277017 3.0388889 0.278490 3.0416667 0.278490 3.0444444 0.278785 3.0472222 0.277901 3.0500000 0.277606 3.0527778 0.276427 3.0555556 0.277017 3.0583333 0.277901 3.0611111 0.277901 3.0638889 0.278195 3.0666667 0.277311 3.0694444 0.277017 3.0722222 0.277017 3.0750000 0.277017 3.0777778 0.277017 3.0805556 0.277901 3.0833333 0.277311 3.0861111 0.276722 3.0888889 0.277606 3.0916667 0.278195 3.0944444 0.277901 3.0972222 0.277901 3.1000000 0.277017 3.1027778 0.276133 3.1055556 0.277901 3.1083333 0.278195 3.1111111 0.278785 3.1138889 0.277901 3.1216667 0.300000 3.2144444 0.300000 3.2194444 0.282615 3.2222222 0.283204 3.2250000 0.283499 3.2277778 0.283794 3.2305556 0.283499 3.2333333 0.282910 3.2361111 0.281731 3.2388889 0.282026 3.2416667 0.283204 3.2444444 0.284088 3.2472222 0.284088 3.2500000 0.283794 3.2527778 0.283204 3.2555556 0.283204 3.2583333 0.284088 3.2611111 0.284383 3.2638889 0.284383 3.2666667 0.284383 3.2694444 0.283499 3.2722222 0.284383 3.2750000 0.285562 3.2777778 0.286151 3.2805556 0.286151 3.2833333 0.285267 3.2861111 0.285267 3.2888889 0.285562 3.2916667 0.287330 3.2944444 0.287035 3.2972222 0.285562 3.3000000 0.284972 3.3027778 0.286446 3.3055556 0.287919 3.3083333 0.287624 3.3111111 0.287035 3.3138889 0.286446 3.3166667 0.285856 3.3194444 0.285856 3.3222222 0.285562 3.3250000 0.285267 3.3277778 0.284088 3.3305556 0.283204 3.3333333 0.281436 3.3361111 0.281142 3.3388889 0.281142 3.3416667 0.281731 3.3444444 0.280552 3.3472222 0.279963 3.3500000 0.279669 3.3527778 0.278785 3.3555556 0.278490 3.3583333 0.278785 3.3611111 0.279374 3.3638889 0.279079 3.3666667 0.277901 3.3694444 0.277311 3.3722222 0.277901 3.3750000 0.278195 3.3777778 0.278490 3.3805556 0.278490 3.3833333 0.278195 3.3861111 0.277606 3.3888889 0.278785 3.3916667 0.279374 3.3944444 0.279079 3.3972222 0.279079 3.4000000 0.279374 3.4027778 0.278490 3.4055556 0.279374 3.4083333 0.279374 3.4111111 0.279963 3.4138889 0.279079 3.4166667 0.279374 3.4194444 0.277901 3.4222222 0.278490 3.4250000 0.277901 3.4277778 0.276427 3.4305556 0.274659 3.4333333 0.272007 3.4361111 0.269355 3.4388889 0.269355 3.4416667 0.267587 3.4444444 0.266409 3.4472222 0.268177 3.4500000 0.273775 3.4527778 0.282026 3.4555556 0.291750 3.4583333 0.301473 3.4611111 0.315322 3.4638889 0.330055 3.4666667 0.343315 3.4694444 0.349797 3.4722222 0.351565 3.4750000 0.343315 3.4777778 0.323573 3.4805556 0.298527 3.4833333 0.280258 3.4861111 0.271713 3.4888889 0.272302 3.4916667 0.275543 3.4944444 0.277901 3.4972222 0.278490 3.5000000 0.277311 3.5027778 0.276427 3.5055556 0.277606 3.5083333 0.277017 3.5111111 0.277901 3.5138889 0.277311 3.5166667 0.276722 3.5194444 0.276133 3.5222222 0.277017 3.5250000 0.277606 3.5277778 0.277311 3.5305556 0.277311 3.5333333 0.276722 3.5361111 0.276427 3.5388889 0.276133 3.5416667 0.276427 3.5444444 0.277017 3.5472222 0.277017 3.5500000 0.276722 3.5527778 0.276427 3.5555556 0.277017 3.5583333 0.277311 3.5611111 0.277017 3.5638889 0.277311 3.5666667 0.275838 3.5694444 0.275249 3.5722222 0.276133 3.5750000 0.275838 3.5777778 0.277017 3.5805556 0.277017 3.5833333 0.277017 3.5861111 0.276427 3.5888889 0.276427 3.5916667 0.277017 3.5944444 0.277901 3.5972222 0.277606 3.6000000 0.276722 3.6027778 0.276427 3.6055556 0.277017 3.6083333 0.276427 3.6111111 0.277017 3.6138889 0.276722 3.6166667 0.275838 3.6194444 0.275543 3.6222222 0.276133 3.6250000 0.277311 3.6277778 0.277311 3.6305556 0.277606 3.6333333 0.276427 3.6361111 0.276427 3.6388889 0.276722 3.6416667 0.277017 3.6444444 0.277606 3.6472222 0.277901 3.6500000 0.276722 3.6527778 0.276722 3.6555556 0.277311 3.6583333 0.277606 3.6611111 0.277901 3.6638889 0.277311 3.6666667 0.277017 3.6694444 0.276427 3.6722222 0.276427 3.6750000 0.277311 3.6777778 0.277606 3.6805556 0.276722 3.6833333 0.277017 3.6861111 0.276427 3.6888889 0.276722 3.6916667 0.277311 3.6944444 0.277606 3.6972222 0.277311 3.7000000 0.276722 3.7027778 0.276133 3.7055556 0.276427 3.7083333 0.277017 3.7111111 0.277606 3.7138889 0.277606 3.7166667 0.277311 3.7194444 0.276133 3.7222222 0.276722 3.7250000 0.276427 3.7277778 0.277017 3.7305556 0.276427 3.7333333 0.276133 3.7361111 0.274954 3.7388889 0.275249 3.7416667 0.276133 3.7444444 0.276427 3.7472222 0.276133 3.7500000 0.276133 3.7527778 0.275543 3.7555556 0.276427 3.7583333 0.277017 3.7611111 0.277606 3.7638889 0.277311 3.7666667 0.276722 3.7744444 0.300000 4.2088889 0.300000 4.2138889 0.279669 4.2166667 0.279079 4.2194444 0.278785 4.2222222 0.278785 4.2250000 0.278490 4.2277778 0.279669 4.2305556 0.279079 4.2333333 0.279374 4.2361111 0.278785 4.2388889 0.279079 4.2416667 0.278785 4.2444444 0.279669 4.2472222 0.280258 4.2500000 0.280552 4.2527778 0.280552 4.2555556 0.281731 4.2583333 0.282026 4.2611111 0.282320 4.2638889 0.282026 4.2666667 0.282615 4.2694444 0.282026 4.2722222 0.283204 4.2750000 0.283794 4.2777778 0.284383 4.2805556 0.284972 4.2833333 0.284972 4.2861111 0.284678 4.2888889 0.284383 4.2916667 0.284972 4.2944444 0.284972 4.2972222 0.284678 4.3000000 0.283499 4.3027778 0.282910 4.3055556 0.283499 4.3083333 0.284088 4.3111111 0.284972 4.3138889 0.283794 4.3166667 0.282910 4.3194444 0.281142 4.3222222 0.282320 4.3250000 0.282615 4.3277778 0.284088 4.3305556 0.284383 4.3333333 0.284088 4.3361111 0.283204 4.3388889 0.282320 4.3416667 0.281731 4.3444444 0.281436 4.3472222 0.281142 4.3500000 0.279374 4.3527778 0.278195 4.3555556 0.278490 4.3583333 0.278490 4.3611111 0.278490 4.3638889 0.278195 4.3666667 0.278195 4.3694444 0.278195 4.3722222 0.277606 4.3750000 0.278785 4.3777778 0.277901 4.3805556 0.277901 4.3833333 0.276427 4.3861111 0.275249 4.3888889 0.276133 4.3916667 0.276427 4.3944444 0.277311 4.3972222 0.277606 4.4000000 0.276427 4.4027778 0.275543 4.4055556 0.276133 4.4083333 0.276722 4.4111111 0.276722 4.4138889 0.276722 4.4166667 0.275838 4.4194444 0.274659 4.4222222 0.274070 4.4250000 0.273186 4.4277778 0.271123 4.4305556 0.271418 4.4333333 0.269355 4.4361111 0.266409 4.4388889 0.266114 4.4416667 0.269061 4.4444444 0.275249 4.4472222 0.282026 4.4500000 0.288803 4.4527778 0.298821 4.4555556 0.312965 4.4583333 0.328582 4.4611111 0.342136 4.4638889 0.349797 4.4666667 0.352155 4.4694444 0.346556 4.4722222 0.333002 4.4750000 0.313260 4.4777778 0.295875 4.4805556 0.283204 4.4833333 0.274954 4.4861111 0.270534 4.4888889 0.267587 4.4916667 0.268471 4.4944444 0.270534 4.4972222 0.272597 4.5000000 0.273481 4.5027778 0.273481 4.5055556 0.274365 4.5083333 0.275249 4.5111111 0.275838 4.5138889 0.275838 4.5166667 0.275543 4.5194444 0.275249 4.5222222 0.274954 4.5250000 0.275249 4.5277778 0.274659 4.5305556 0.274659 4.5333333 0.274070 4.5361111 0.273481 4.5388889 0.273481 4.5416667 0.274659 4.5444444 0.274659 4.5472222 0.274659 4.5500000 0.273775 4.5527778 0.273775 4.5555556 0.274070 4.5583333 0.274954 4.5611111 0.274659 4.5638889 0.274659 4.5666667 0.274954 4.5694444 0.273775 4.5722222 0.273775 4.5750000 0.274659 4.5777778 0.274365 4.5805556 0.274365 4.5833333 0.273775 4.5861111 0.273775 4.5888889 0.274365 4.5916667 0.274659 4.5944444 0.274954 4.5972222 0.274659 4.6000000 0.274659 4.6027778 0.274070 4.6055556 0.275249 4.6083333 0.274659 4.6111111 0.274954 4.6138889 0.274659 4.6166667 0.274070 4.6194444 0.274070 4.6222222 0.274659 4.6250000 0.274659 4.6277778 0.275543 4.6305556 0.274954 4.6333333 0.274659 4.6361111 0.273186 4.6388889 0.273775 4.6416667 0.273775 4.6444444 0.274659 4.6472222 0.274659 4.6500000 0.274070 4.6527778 0.274070 4.6555556 0.274365 4.6583333 0.274659 4.6611111 0.275543 4.6638889 0.275543 4.6666667 0.274954 4.6694444 0.274954 4.6722222 0.275249 4.6750000 0.276133 4.6777778 0.276133 4.6805556 0.275543 4.6833333 0.275543 4.6861111 0.274954 4.6888889 0.274659 4.6916667 0.276133 4.6944444 0.276133 4.6972222 0.276133 4.7000000 0.276133 4.7027778 0.274659 4.7055556 0.275543 4.7083333 0.275838 4.7111111 0.275543 4.7138889 0.274659 4.7166667 0.273775 4.7194444 0.272597 4.7222222 0.272891 4.7250000 0.273481 4.7277778 0.273186 4.7305556 0.272891 4.7333333 0.272597 4.7361111 0.271418 4.7388889 0.270829 4.7416667 0.272007 4.7444444 0.271123 4.7472222 0.270534 4.7500000 0.270829 4.7527778 0.269650 4.7555556 0.270534 4.7583333 0.271418 4.7611111 0.271123 4.7688889 0.300000 5.0533333 0.300000 5.0583333 0.279079 5.0611111 0.279963 5.0638889 0.279669 5.0666667 0.279079 5.0694444 0.279079 5.0722222 0.279079 5.0750000 0.279963 5.0777778 0.279963 5.0805556 0.279669 5.0833333 0.278490 5.0861111 0.278195 5.0888889 0.279374 5.0916667 0.280552 5.0944444 0.281142 5.0972222 0.281436 5.1000000 0.282615 5.1027778 0.282026 5.1055556 0.282615 5.1083333 0.282320 5.1111111 0.283204 5.1138889 0.283794 5.1166667 0.284678 5.1194444 0.283794 5.1222222 0.284383 5.1250000 0.284678 5.1277778 0.285267 5.1305556 0.285562 5.1333333 0.284972 5.1361111 0.284383 5.1388889 0.284678 5.1416667 0.284678 5.1444444 0.285267 5.1472222 0.284678 5.1500000 0.283499 5.1527778 0.283499 5.1555556 0.283794 5.1583333 0.283204 5.1611111 0.283499 5.1638889 0.284972 5.1666667 0.285562 5.1694444 0.285562 5.1722222 0.284678 5.1750000 0.283204 5.1777778 0.282910 5.1805556 0.282320 5.1833333 0.281142 5.1861111 0.280258 5.1888889 0.279079 5.1916667 0.279374 5.1944444 0.279079 5.1972222 0.279079 5.2000000 0.277901 5.2027778 0.277311 5.2055556 0.277606 5.2083333 0.278785 5.2111111 0.279374 5.2138889 0.278785 5.2166667 0.278490 5.2194444 0.278195 5.2222222 0.278195 5.2250000 0.278490 5.2277778 0.278785 5.2305556 0.278490 5.2333333 0.278195 5.2361111 0.277311 5.2388889 0.277311 5.2416667 0.278490 5.2444444 0.278785 5.2472222 0.277606 5.2500000 0.277311 5.2527778 0.276722 5.2555556 0.276722 5.2583333 0.277311 5.2611111 0.277606 5.2638889 0.276722 5.2666667 0.274954 5.2694444 0.272597 5.2722222 0.270534 5.2750000 0.269650 5.2777778 0.268766 5.2805556 0.266998 5.2833333 0.265525 5.2861111 0.268766 5.2888889 0.275838 5.2916667 0.284972 5.2944444 0.293812 5.2972222 0.306188 5.3000000 0.320921 5.3027778 0.335359 5.3055556 0.347735 5.3083333 0.352449 5.3111111 0.348913 5.3138889 0.334180 5.3166667 0.310902 5.3194444 0.287919 5.3222222 0.273481 5.3250000 0.269061 5.3277778 0.270829 5.3305556 0.272597 5.3333333 0.274365 5.3361111 0.275543 5.3388889 0.275543 5.3416667 0.275543 5.3444444 0.276427 5.3472222 0.276722 5.3500000 0.276133 5.3527778 0.274954 5.3555556 0.274365 5.3583333 0.275543 5.3611111 0.275543 5.3638889 0.275543 5.3666667 0.275543 5.3694444 0.274659 5.3722222 0.275249 5.3750000 0.275838 5.3777778 0.276133 5.3805556 0.275249 5.3833333 0.275838 5.3861111 0.275249 5.3888889 0.276427 5.3916667 0.276722 5.3944444 0.277311 5.3972222 0.276427 5.4000000 0.276427 5.4027778 0.276427 5.4055556 0.276427 5.4083333 0.276722 5.4111111 0.276427 5.4138889 0.276427 5.4166667 0.276427 5.4194444 0.275838 5.4222222 0.276722 5.4250000 0.275838 5.4277778 0.276427 5.4305556 0.276722 5.4333333 0.276133 5.4361111 0.275838 5.4388889 0.275543 5.4416667 0.276133 5.4444444 0.276427 5.4472222 0.276722 5.4500000 0.276133 5.4527778 0.275543 5.4555556 0.276133 5.4583333 0.275543 5.4611111 0.275838 5.4638889 0.276133 5.4666667 0.276133 5.4694444 0.275838 5.4722222 0.276133 5.4750000 0.276427 5.4777778 0.276722 5.4805556 0.276133 5.4833333 0.276133 5.4861111 0.276427 5.4888889 0.276722 5.4916667 0.277017 5.4944444 0.276722 5.4972222 0.277017 5.5000000 0.276722 5.5027778 0.275249 5.5055556 0.275543 5.5083333 0.276133 5.5111111 0.276427 5.5138889 0.276427 5.5166667 0.275543 5.5194444 0.275249 5.5222222 0.275838 5.5250000 0.276722 5.5277778 0.276427 5.5305556 0.276133 5.5333333 0.275543 5.5361111 0.274365 5.5388889 0.275543 5.5416667 0.275543 5.5444444 0.276427 5.5472222 0.276133 5.5500000 0.275249 5.5527778 0.274659 5.5555556 0.274954 5.5583333 0.275838 5.5611111 0.275838 5.5638889 0.276133 5.5666667 0.275543 5.5694444 0.274954 5.5722222 0.274954 5.5750000 0.275249 5.5777778 0.275838 5.5805556 0.275838 5.5833333 0.275249 5.5861111 0.274659 5.5888889 0.274954 5.5916667 0.275249 5.5944444 0.276133 5.5972222 0.275543 5.6000000 0.275838 5.6027778 0.275838 5.6055556 0.277311 5.6133333 0.300000 6.3083333 0.300000)
Vecg1 ecg_l1 0 PWL(0.0000000 0.300000 1.7450000 0.300000 1.7500000 0.284088 1.7527778 0.284383 1.7555556 0.284972 1.7583333 0.285562 1.7611111 0.284972 1.7638889 0.283794 1.7666667 0.283794 1.7694444 0.283794 1.7722222 0.284972 1.7750000 0.284972 1.7777778 0.284678 1.7805556 0.284383 1.7833333 0.283204 1.7861111 0.283499 1.7888889 0.284383 1.7916667 0.284678 1.7944444 0.284972 1.7972222 0.285267 1.8000000 0.284972 1.8027778 0.285267 1.8055556 0.285856 1.8083333 0.286446 1.8111111 0.286151 1.8138889 0.286740 1.8166667 0.286151 1.8194444 0.285856 1.8222222 0.286740 1.8250000 0.287330 1.8277778 0.286151 1.8305556 0.286446 1.8333333 0.286740 1.8361111 0.287330 1.8388889 0.287919 1.8416667 0.288214 1.8444444 0.287624 1.8472222 0.286740 1.8500000 0.286446 1.8527778 0.286740 1.8555556 0.287330 1.8583333 0.287624 1.8611111 0.286151 1.8638889 0.285856 1.8666667 0.284972 1.8694444 0.285562 1.8722222 0.286151 1.8750000 0.286446 1.8777778 0.286151 1.8805556 0.285562 1.8833333 0.284088 1.8861111 0.284678 1.8888889 0.285267 1.8916667 0.285856 1.8944444 0.285856 1.8972222 0.284972 1.9000000 0.284678 1.9027778 0.284383 1.9055556 0.284972 1.9083333 0.285562 1.9111111 0.285562 1.9138889 0.284678 1.9166667 0.284972 1.9194444 0.284678 1.9222222 0.284972 1.9250000 0.285856 1.9277778 0.285856 1.9305556 0.284678 1.9333333 0.284678 1.9361111 0.285267 1.9388889 0.285856 1.9416667 0.286151 1.9444444 0.285856 1.9472222 0.284972 1.9500000 0.284088 1.9527778 0.283204 1.9555556 0.282910 1.9583333 0.281731 1.9611111 0.280552 1.9638889 0.278490 1.9666667 0.278195 1.9694444 0.279374 1.9722222 0.284678 1.9750000 0.292044 1.9777778 0.298821 1.9805556 0.302063 1.9833333 0.305599 1.9861111 0.310902 1.9888889 0.318564 1.9916667 0.326519 1.9944444 0.330350 1.9972222 0.326519 2.0000000 0.310313 2.0027778 0.289392 2.0055556 0.277311 2.0083333 0.276722 2.0111111 0.279669 2.0138889 0.281731 2.0166667 0.282910 2.0194444 0.283794 2.0222222 0.284383 2.0250000 0.286151 2.0277778 0.285267 2.0305556 0.284383 2.0333333 0.284972 2.0361111 0.285562 2.0388889 0.285856 2.0416667 0.285856 2.0444444 0.285267 2.0472222 0.284678 2.0500000 0.284383 2.0527778 0.283794 2.0555556 0.284972 2.0583333 0.285856 2.0611111 0.285562 2.0638889 0.284678 2.0666667 0.284678 2.0694444 0.284383 2.0722222 0.285267 2.0750000 0.285267 2.0777778 0.285562 2.0805556 0.285267 2.0833333 0.284383 2.0861111 0.284972 2.0888889 0.285267 2.0916667 0.285562 2.0944444 0.285562 2.0972222 0.284972 2.1000000 0.284678 2.1027778 0.285267 2.1055556 0.285856 2.1083333 0.287330 2.1111111 0.286446 2.1138889 0.285267 2.1166667 0.285267 2.1194444 0.284972 2.1222222 0.285856 2.1250000 0.287035 2.1277778 0.286151 2.1305556 0.286151 2.1333333 0.285856 2.1361111 0.284972 2.1388889 0.285562 2.1416667 0.286740 2.1444444 0.286446 2.1472222 0.286151 2.1500000 0.285856 2.1527778 0.285856 2.1555556 0.285856 2.1583333 0.286446 2.1611111 0.285562 2.1638889 0.284972 2.1666667 0.285267 2.1694444 0.285267 2.1722222 0.286151 2.1750000 0.285856 2.1777778 0.286151 2.1805556 0.284972 2.1833333 0.284972 2.1861111 0.284972 2.1888889 0.285267 2.1916667 0.286151 2.1944444 0.284678 2.1972222 0.284972 2.2000000 0.284088 2.2027778 0.283204 2.2055556 0.283204 2.2083333 0.283499 2.2111111 0.283204 2.2138889 0.283204 2.2166667 0.282026 2.2194444 0.282615 2.2222222 0.283204 2.2250000 0.282910 2.2277778 0.282026 2.2305556 0.281142 2.2333333 0.280258 2.2361111 0.279963 2.2388889 0.281436 2.2416667 0.281436 2.2444444 0.280552 2.2472222 0.279669 2.2500000 0.279374 2.2527778 0.279079 2.2555556 0.278490 2.2583333 0.279079 2.2611111 0.278490 2.2638889 0.278195 2.2666667 0.277901 2.2694444 0.277901 2.2722222 0.278195 2.2750000 0.279079 2.2777778 0.278785 2.2805556 0.279963 2.2833333 0.279963 2.2861111 0.280552 2.2888889 0.281436 2.2916667 0.282910 2.2944444 0.283794 2.2972222 0.284383 2.3050000 0.300000 2.5616667 0.300000 2.5666667 0.290276 2.5694444 0.290571 2.5722222 0.290571 2.5750000 0.291455 2.5777778 0.291160 2.5805556 0.291160 2.5833333 0.290571 2.5861111 0.290571 2.5888889 0.291160 2.5916667 0.291160 2.5944444 0.291160 2.5972222 0.290866 2.6000000 0.290571 2.6027778 0.290571 2.6055556 0.291160 2.6083333 0.292339 2.6111111 0.291160 2.6138889 0.290866 2.6166667 0.290571 2.6194444 0.291160 2.6222222 0.292634 2.6250000 0.292928 2.6277778 0.293223 2.6305556 0.292634 2.6333333 0.292044 2.6361111 0.291750 2.6388889 0.292339 2.6416667 0.293812 2.6444444 0.293812 2.6472222 0.294107 2.6500000 0.293812 2.6527778 0.294696 2.6555556 0.295285 2.6583333 0.295580 2.6611111 0.294696 2.6638889 0.294696 2.6666667 0.294107 2.6694444 0.294107 2.6722222 0.294401 2.6750000 0.294696 2.6777778 0.293517 2.6805556 0.292634 2.6833333 0.292339 2.6861111 0.292928 2.6888889 0.292928 2.6916667 0.293517 2.6944444 0.293517 2.6972222 0.292928 2.7000000 0.292339 2.7027778 0.291750 2.7055556 0.291455 2.7083333 0.292634 2.7111111 0.292339 2.7138889 0.291160 2.7166667 0.291455 2.7194444 0.291750 2.7222222 0.291750 2.7250000 0.292928 2.7277778 0.292044 2.7305556 0.291455 2.7333333 0.290571 2.7361111 0.291160 2.7388889 0.292044 2.7416667 0.292634 2.7444444 0.292044 2.7472222 0.291455 2.7500000 0.291160 2.7527778 0.290571 2.7555556 0.291455 2.7583333 0.292044 2.7611111 0.292044 2.7638889 0.292634 2.7666667 0.290571 2.7694444 0.289687 2.7722222 0.288508 2.7750000 0.287624 2.7777778 0.286446 2.7805556 0.284088 2.7833333 0.282910 2.7861111 0.283499 2.7888889 0.288508 2.7916667 0.297053 2.7944444 0.305009 2.7972222 0.311492 2.8000000 0.317974 2.8027778 0.324751 2.8055556 0.333297 2.8083333 0.341547 2.8111111 0.347145 2.8138889 0.346851 2.8166667 0.335064 2.8194444 0.313849 2.8222222 0.295580 2.8250000 0.288803 2.8277778 0.289098 2.8305556 0.290866 2.8333333 0.289982 2.8361111 0.290276 2.8388889 0.290866 2.8416667 0.291455 2.8444444 0.290866 2.8472222 0.288803 2.8500000 0.288214 2.8527778 0.288508 2.8555556 0.289687 2.8583333 0.289687 2.8611111 0.289392 2.8638889 0.289098 2.8666667 0.288214 2.8694444 0.288508 2.8722222 0.288214 2.8750000 0.288508 2.8777778 0.288803 2.8805556 0.288508 2.8833333 0.288214 2.8861111 0.288214 2.8888889 0.288803 2.8916667 0.289392 2.8944444 0.289098 2.8972222 0.288508 2.9000000 0.287624 2.9027778 0.287624 2.9055556 0.289687 2.9083333 0.288803 2.9111111 0.289098 2.9138889 0.289098 2.9166667 0.288508 2.9194444 0.288214 2.9222222 0.288508 2.9250000 0.289392 2.9277778 0.288803 2.9305556 0.288508 2.9333333 0.288803 2.9361111 0.288508 2.9388889 0.289687 2.9416667 0.289687 2.9444444 0.289098 2.9472222 0.288803 2.9500000 0.288508 2.9527778 0.288803 2.9555556 0.289098 2.9583333 0.289982 2.9611111 0.289982 2.9638889 0.288803 2.9666667 0.288214 2.9694444 0.288214 2.9722222 0.289392 2.9750000 0.289687 2.9777778 0.288508 2.9805556 0.289687 2.9833333 0.288803 2.9861111 0.288803 2.9888889 0.288803 2.9916667 0.289392 2.9944444 0.288803 2.9972222 0.287624 3.0000000 0.287919 3.0027778 0.288214 3.0055556 0.287624 3.0083333 0.288508 3.0111111 0.287919 3.0138889 0.287330 3.0166667 0.286446 3.0194444 0.287330 3.0222222 0.286740 3.0250000 0.287919 3.0277778 0.287330 3.0305556 0.286151 3.0333333 0.285562 3.0361111 0.285562 3.0388889 0.285856 3.0416667 0.285562 3.0444444 0.286151 3.0472222 0.284678 3.0500000 0.284383 3.0527778 0.284088 3.0555556 0.284383 3.0583333 0.284383 3.0611111 0.284088 3.0638889 0.283204 3.0666667 0.282320 3.0694444 0.282615 3.0722222 0.282615 3.0750000 0.282615 3.0777778 0.282026 3.0805556 0.281731 3.0833333 0.281142 3.0861111 0.280847 3.0888889 0.281142 3.0916667 0.281731 3.0944444 0.281142 3.0972222 0.281142 3.1000000 0.280847 3.1027778 0.281731 3.1055556 0.283499 3.1083333 0.283499 3.1111111 0.283499 3.1138889 0.284383 3.1216667 0.300000 3.2144444 0.300000 3.2194444 0.292928 3.2222222 0.293223 3.2250000 0.293812 3.2277778 0.293517 3.2305556 0.292634 3.2333333 0.293223 3.2361111 0.292339 3.2388889 0.293223 3.2416667 0.294401 3.2444444 0.294107 3.2472222 0.293517 3.2500000 0.293223 3.2527778 0.293223 3.2555556 0.293812 3.2583333 0.294107 3.2611111 0.293517 3.2638889 0.294107 3.2666667 0.294107 3.2694444 0.293812 3.2722222 0.294401 3.2750000 0.294401 3.2777778 0.294401 3.2805556 0.293517 3.2833333 0.293223 3.2861111 0.293517 3.2888889 0.293812 3.2916667 0.293812 3.2944444 0.293223 3.2972222 0.293223 3.3000000 0.292044 3.3027778 0.292634 3.3055556 0.292044 3.3083333 0.292634 3.3111111 0.292339 3.3138889 0.291160 3.3166667 0.290866 3.3194444 0.290276 3.3222222 0.290276 3.3250000 0.289982 3.3277778 0.289687 3.3305556 0.289982 3.3333333 0.289687 3.3361111 0.289982 3.3388889 0.290276 3.3416667 0.290571 3.3444444 0.290571 3.3472222 0.289982 3.3500000 0.289392 3.3527778 0.289982 3.3555556 0.290866 3.3583333 0.290866 3.3611111 0.290571 3.3638889 0.290571 3.3666667 0.289687 3.3694444 0.289982 3.3722222 0.290866 3.3750000 0.291160 3.3777778 0.290571 3.3805556 0.290866 3.3833333 0.290276 3.3861111 0.290571 3.3888889 0.291160 3.3916667 0.291160 3.3944444 0.291455 3.3972222 0.290866 3.4000000 0.290276 3.4027778 0.290866 3.4055556 0.292044 3.4083333 0.292339 3.4111111 0.291455 3.4138889 0.290866 3.4166667 0.290571 3.4194444 0.290571 3.4222222 0.289687 3.4250000 0.288803 3.4277778 0.286151 3.4305556 0.285267 3.4333333 0.282615 3.4361111 0.281436 3.4388889 0.282615 3.4416667 0.288803 3.4444444 0.294991 3.4472222 0.303536 3.4500000 0.310313 3.4527778 0.315617 3.4555556 0.322394 3.4583333 0.328582 3.4611111 0.334770 3.4638889 0.339190 3.4666667 0.339190 3.4694444 0.329466 3.4722222 0.312081 3.4750000 0.295580 3.4777778 0.287330 3.4805556 0.287919 3.4833333 0.289392 3.4861111 0.289687 3.4888889 0.290276 3.4916667 0.291455 3.4944444 0.291455 3.4972222 0.290571 3.5000000 0.290276 3.5027778 0.289982 3.5055556 0.290866 3.5083333 0.290866 3.5111111 0.290866 3.5138889 0.289982 3.5166667 0.289687 3.5194444 0.289982 3.5222222 0.290866 3.5250000 0.290866 3.5277778 0.290571 3.5305556 0.290276 3.5333333 0.289392 3.5361111 0.289687 3.5388889 0.289982 3.5416667 0.290571 3.5444444 0.290571 3.5472222 0.289982 3.5500000 0.289392 3.5527778 0.289392 3.5555556 0.289982 3.5583333 0.290276 3.5611111 0.290276 3.5638889 0.289687 3.5666667 0.289392 3.5694444 0.289098 3.5722222 0.289982 3.5750000 0.290571 3.5777778 0.290276 3.5805556 0.289687 3.5833333 0.289687 3.5861111 0.289687 3.5888889 0.289392 3.5916667 0.289982 3.5944444 0.290571 3.5972222 0.289982 3.6000000 0.289392 3.6027778 0.289098 3.6055556 0.289982 3.6083333 0.290571 3.6111111 0.289392 3.6138889 0.289392 3.6166667 0.289098 3.6194444 0.289098 3.6222222 0.290276 3.6250000 0.290866 3.6277778 0.289982 3.6305556 0.289687 3.6333333 0.288508 3.6361111 0.288508 3.6388889 0.288803 3.6416667 0.289687 3.6444444 0.289687 3.6472222 0.288803 3.6500000 0.288803 3.6527778 0.288803 3.6555556 0.289098 3.6583333 0.288803 3.6611111 0.287330 3.6638889 0.287035 3.6666667 0.287330 3.6694444 0.286740 3.6722222 0.287330 3.6750000 0.288214 3.6777778 0.286446 3.6805556 0.286740 3.6833333 0.285562 3.6861111 0.285856 3.6888889 0.285562 3.6916667 0.287035 3.6944444 0.285562 3.6972222 0.284678 3.7000000 0.283499 3.7027778 0.283499 3.7055556 0.283204 3.7083333 0.284088 3.7111111 0.283204 3.7138889 0.282615 3.7166667 0.282026 3.7194444 0.282026 3.7222222 0.281436 3.7250000 0.282026 3.7277778 0.281731 3.7305556 0.280552 3.7333333 0.280847 3.7361111 0.280552 3.7388889 0.281436 3.7416667 0.281731 3.7444444 0.281436 3.7472222 0.281731 3.7500000 0.281142 3.7527778 0.282026 3.7555556 0.282910 3.7583333 0.283794 3.7611111 0.284088 3.7638889 0.284383 3.7666667 0.284383 3.7744444 0.300000 4.2088889 0.300000 4.2138889 0.287035 4.2166667 0.286740 4.2194444 0.286740 4.2222222 0.287919 4.2250000 0.288214 4.2277778 0.287919 4.2305556 0.287919 4.2333333 0.287624 4.2361111 0.287624 4.2388889 0.288508 4.2416667 0.288508 4.2444444 0.288508 4.2472222 0.288214 4.2500000 0.286740 4.2527778 0.286740 4.2555556 0.287919 4.2583333 0.288803 4.2611111 0.288508 4.2638889 0.288803 4.2666667 0.288214 4.2694444 0.289098 4.2722222 0.289392 4.2750000 0.290276 4.2777778 0.289982 4.2805556 0.289392 4.2833333 0.289687 4.2861111 0.289982 4.2888889 0.290276 4.2916667 0.291160 4.2944444 0.290866 4.2972222 0.290276 4.3000000 0.289982 4.3027778 0.290276 4.3055556 0.290276 4.3083333 0.290866 4.3111111 0.289982 4.3138889 0.289392 4.3166667 0.289982 4.3194444 0.290276 4.3222222 0.290571 4.3250000 0.290571 4.3277778 0.289392 4.3305556 0.288803 4.3333333 0.287919 4.3361111 0.288803 4.3388889 0.288803 4.3416667 0.289982 4.3444444 0.289098 4.3472222 0.288803 4.3500000 0.288508 4.3527778 0.286740 4.3555556 0.287330 4.3583333 0.288214 4.3611111 0.287919 4.3638889 0.287919 4.3666667 0.287919 4.3694444 0.287035 4.3722222 0.287624 4.3750000 0.287624 4.3777778 0.287624 4.3805556 0.287330 4.3833333 0.286740 4.3861111 0.286151 4.3888889 0.286446 4.3916667 0.287919 4.3944444 0.287330 4.3972222 0.286740 4.4000000 0.286740 4.4027778 0.287035 4.4055556 0.287035 4.4083333 0.287330 4.4111111 0.286740 4.4138889 0.286740 4.4166667 0.284972 4.4194444 0.283794 4.4222222 0.282910 4.4250000 0.282910 4.4277778 0.281436 4.4305556 0.280552 4.4333333 0.282026 4.4361111 0.285562 4.4388889 0.293223 4.4416667 0.298527 4.4444444 0.301768 4.4472222 0.304715 4.4500000 0.309134 4.4527778 0.315617 4.4555556 0.322689 4.4583333 0.329466 4.4611111 0.332118 4.4638889 0.326519 4.4666667 0.312670 4.4694444 0.294696 4.4722222 0.280847 4.4750000 0.277017 4.4777778 0.277311 4.4805556 0.278490 4.4833333 0.280258 4.4861111 0.282615 4.4888889 0.283204 4.4916667 0.284088 4.4944444 0.284383 4.4972222 0.284088 4.5000000 0.283794 4.5027778 0.283204 4.5055556 0.284383 4.5083333 0.285267 4.5111111 0.284678 4.5138889 0.284678 4.5166667 0.284383 4.5194444 0.284088 4.5222222 0.284383 4.5250000 0.285562 4.5277778 0.284678 4.5305556 0.284972 4.5333333 0.283499 4.5361111 0.284678 4.5388889 0.285267 4.5416667 0.285267 4.5444444 0.284972 4.5472222 0.284972 4.5500000 0.284678 4.5527778 0.284678 4.5555556 0.284972 4.5583333 0.286740 4.5611111 0.285856 4.5638889 0.285562 4.5666667 0.284383 4.5694444 0.283794 4.5722222 0.285267 4.5750000 0.285562 4.5777778 0.286446 4.5805556 0.285856 4.5833333 0.284972 4.5861111 0.285267 4.5888889 0.285267 4.5916667 0.285562 4.5944444 0.286151 4.5972222 0.285856 4.6000000 0.285267 4.6027778 0.285267 4.6055556 0.285562 4.6083333 0.287035 4.6111111 0.285562 4.6138889 0.285562 4.6166667 0.285856 4.6194444 0.284972 4.6222222 0.285562 4.6250000 0.286740 4.6277778 0.285856 4.6305556 0.285267 4.6333333 0.284678 4.6361111 0.284383 4.6388889 0.284972 4.6416667 0.285856 4.6444444 0.285267 4.6472222 0.285267 4.6500000 0.284383 4.6527778 0.284678 4.6555556 0.284678 4.6583333 0.284383 4.6611111 0.283794 4.6638889 0.284088 4.6666667 0.284088 4.6694444 0.284088 4.6722222 0.284088 4.6750000 0.285562 4.6777778 0.284383 4.6805556 0.284383 4.6833333 0.284088 4.6861111 0.283204 4.6888889 0.284678 4.6916667 0.285562 4.6944444 0.284972 4.6972222 0.284383 4.7000000 0.283204 4.7027778 0.282615 4.7055556 0.282320 4.7083333 0.282615 4.7111111 0.283204 4.7138889 0.281142 4.7166667 0.280847 4.7194444 0.280258 4.7222222 0.280258 4.7250000 0.280552 4.7277778 0.279374 4.7305556 0.279669 4.7333333 0.278490 4.7361111 0.277606 4.7388889 0.277901 4.7416667 0.277901 4.7444444 0.277311 4.7472222 0.277311 4.7500000 0.276427 4.7527778 0.276427 4.7555556 0.276722 4.7583333 0.277017 4.7611111 0.277017 4.7688889 0.300000 5.0533333 0.300000 5.0583333 0.289098 5.0611111 0.288508 5.0638889 0.288214 5.0666667 0.288214 5.0694444 0.287919 5.0722222 0.288508 5.0750000 0.289098 5.0777778 0.288803 5.0805556 0.288508 5.0833333 0.288214 5.0861111 0.288214 5.0888889 0.288214 5.0916667 0.288803 5.0944444 0.288214 5.0972222 0.288803 5.1000000 0.288214 5.1027778 0.288508 5.1055556 0.289392 5.1083333 0.290571 5.1111111 0.289392 5.1138889 0.289392 5.1166667 0.289098 5.1194444 0.289392 5.1222222 0.290571 5.1250000 0.291455 5.1277778 0.290866 5.1305556 0.289982 5.1333333 0.289982 5.1361111 0.290866 5.1388889 0.291455 5.1416667 0.292339 5.1444444 0.292044 5.1472222 0.291750 5.1500000 0.292044 5.1527778 0.291750 5.1555556 0.291750 5.1583333 0.292634 5.1611111 0.292339 5.1638889 0.291160 5.1666667 0.290276 5.1694444 0.290276 5.1722222 0.290276 5.1750000 0.290866 5.1777778 0.291160 5.1805556 0.290276 5.1833333 0.289392 5.1861111 0.288508 5.1888889 0.289687 5.1916667 0.289982 5.1944444 0.289687 5.1972222 0.289098 5.2000000 0.288508 5.2027778 0.288803 5.2055556 0.289687 5.2083333 0.289098 5.2111111 0.288803 5.2138889 0.287919 5.2166667 0.287330 5.2194444 0.287330 5.2222222 0.288508 5.2250000 0.289392 5.2277778 0.288803 5.2305556 0.288214 5.2333333 0.288214 5.2361111 0.287330 5.2388889 0.288214 5.2416667 0.289392 5.2444444 0.288508 5.2472222 0.288214 5.2500000 0.287919 5.2527778 0.287624 5.2555556 0.288214 5.2583333 0.287919 5.2611111 0.286151 5.2638889 0.284678 5.2666667 0.283204 5.2694444 0.282320 5.2722222 0.280847 5.2750000 0.281142 5.2777778 0.282910 5.2805556 0.288803 5.2833333 0.296759 5.2861111 0.302947 5.2888889 0.308840 5.2916667 0.314438 5.2944444 0.320331 5.2972222 0.326225 5.3000000 0.331234 5.3027778 0.335064 5.3055556 0.330645 5.3083333 0.316206 5.3111111 0.294991 5.3138889 0.282320 5.3166667 0.280258 5.3194444 0.283204 5.3222222 0.285267 5.3250000 0.285562 5.3277778 0.286151 5.3305556 0.287330 5.3333333 0.286446 5.3361111 0.286446 5.3388889 0.285856 5.3416667 0.286151 5.3444444 0.286151 5.3472222 0.285562 5.3500000 0.284972 5.3527778 0.285267 5.3555556 0.285856 5.3583333 0.286740 5.3611111 0.286446 5.3638889 0.285267 5.3666667 0.285856 5.3694444 0.284972 5.3722222 0.286446 5.3750000 0.286740 5.3777778 0.286740 5.3805556 0.286740 5.3833333 0.286446 5.3861111 0.285856 5.3888889 0.286740 5.3916667 0.287330 5.3944444 0.287330 5.3972222 0.286740 5.4000000 0.286151 5.4027778 0.285856 5.4055556 0.286740 5.4083333 0.287919 5.4111111 0.287624 5.4138889 0.286740 5.4166667 0.286446 5.4194444 0.286151 5.4222222 0.286740 5.4250000 0.287330 5.4277778 0.287035 5.4305556 0.286446 5.4333333 0.286151 5.4361111 0.286446 5.4388889 0.287330 5.4416667 0.287330 5.4444444 0.287330 5.4472222 0.286740 5.4500000 0.286151 5.4527778 0.286151 5.4555556 0.286446 5.4583333 0.287330 5.4611111 0.286740 5.4638889 0.286740 5.4666667 0.286151 5.4694444 0.285562 5.4722222 0.285856 5.4750000 0.286740 5.4777778 0.287624 5.4805556 0.286446 5.4833333 0.286446 5.4861111 0.285562 5.4888889 0.287035 5.4916667 0.286740 5.4944444 0.286151 5.4972222 0.285562 5.5000000 0.285267 5.5027778 0.285267 5.5055556 0.285856 5.5083333 0.285856 5.5111111 0.285562 5.5138889 0.285267 5.5166667 0.284088 5.5194444 0.284088 5.5222222 0.284383 5.5250000 0.284678 5.5277778 0.283499 5.5305556 0.282615 5.5333333 0.282615 5.5361111 0.281436 5.5388889 0.281731 5.5416667 0.282026 5.5444444 0.281731 5.5472222 0.280847 5.5500000 0.280552 5.5527778 0.279374 5.5555556 0.279963 5.5583333 0.280258 5.5611111 0.279374 5.5638889 0.279374 5.5666667 0.278195 5.5694444 0.278490 5.5722222 0.279079 5.5750000 0.280258 5.5777778 0.279079 5.5805556 0.278490 5.5833333 0.278195 5.5861111 0.278785 5.5888889 0.280258 5.5916667 0.281436 5.5944444 0.281436 5.5972222 0.282026 5.6000000 0.283204 5.6027778 0.283204 5.6055556 0.284088 5.6133333 0.300000 6.3083333 0.300000)

* Trigger signals (from external PWL for accurate timing)
Vpwb trig_pw_base 0 PWL(0.0000000 0.000000 1.7939444 0.000000 1.7944444 0.900000 1.7949444 0.900000 1.7954444 0.000000 2.6106111 0.000000 2.6111111 0.900000 2.6116111 0.900000 2.6121111 0.000000 3.2633889 0.000000 3.2638889 0.900000 3.2643889 0.900000 3.2648889 0.000000 4.2578333 0.000000 4.2583333 0.900000 4.2588333 0.900000 4.2593333 0.000000 5.1022778 0.000000 5.1027778 0.900000 5.1032778 0.900000 5.1037778 0.000000 6.3083333 0.000000)
Vpwp trig_pw_peak 0 PWL(0.0000000 0.000000 1.8689444 0.000000 1.8694444 0.900000 1.8699444 0.900000 1.8704444 0.000000 2.6856111 0.000000 2.6861111 0.900000 2.6866111 0.900000 2.6871111 0.000000 3.3383889 0.000000 3.3388889 0.900000 3.3393889 0.900000 3.3398889 0.000000 4.3328333 0.000000 4.3333333 0.900000 4.3338333 0.900000 4.3343333 0.000000 5.1772778 0.000000 5.1777778 0.900000 5.1782778 0.900000 5.1787778 0.000000 6.3083333 0.000000)
Vrrc trig_rr_cap 0 PWL(0.0000000 0.000000 1.9945000 0.000000 1.9950000 0.900000 1.9970000 0.900000 1.9975000 0.000000 2.8111667 0.000000 2.8116667 0.900000 2.8136667 0.900000 2.8141667 0.000000 3.4639444 0.000000 3.4644444 0.900000 3.4664444 0.900000 3.4669444 0.000000 4.4583889 0.000000 4.4588889 0.900000 4.4608889 0.900000 4.4613889 0.000000 5.3028333 0.000000 5.3033333 0.900000 5.3053333 0.900000 5.3058333 0.000000 6.3083333 0.000000)
Vrsh trig_rpeak_sh 0 PWL(0.0000000 0.000000 1.9995000 0.000000 2.0000000 0.900000 2.0005000 0.900000 2.0010000 0.000000 2.8161667 0.000000 2.8166667 0.900000 2.8171667 0.900000 2.8176667 0.000000 3.4689444 0.000000 3.4694444 0.900000 3.4699444 0.900000 3.4704444 0.000000 4.4633889 0.000000 4.4638889 0.900000 4.4643889 0.900000 4.4648889 0.000000 5.3078333 0.000000 5.3083333 0.900000 5.3088333 0.900000 5.3093333 0.000000 6.3083333 0.000000)
Vrrp trig_rr_rpeak 0 PWL(0.0000000 0.000000 1.9995000 0.000000 2.0000000 0.900000 2.0050000 0.900000 2.0055000 0.000000 2.8161667 0.000000 2.8166667 0.900000 2.8216667 0.900000 2.8221667 0.000000 3.4689444 0.000000 3.4694444 0.900000 3.4744444 0.900000 3.4749444 0.000000 4.4633889 0.000000 4.4638889 0.900000 4.4688889 0.900000 4.4693889 0.000000 5.3078333 0.000000 5.3083333 0.900000 5.3133333 0.900000 5.3138333 0.000000 6.3083333 0.000000)
Vs14 trig_s14 0 PWL(0.0000000 0.000000 2.0133889 0.000000 2.0138889 0.900000 2.0143889 0.900000 2.0148889 0.000000 2.8300556 0.000000 2.8305556 0.900000 2.8310556 0.900000 2.8315556 0.000000 3.4828333 0.000000 3.4833333 0.900000 3.4838333 0.900000 3.4843333 0.000000 4.4772778 0.000000 4.4777778 0.900000 4.4782778 0.900000 4.4787778 0.000000 5.3217222 0.000000 5.3222222 0.900000 5.3227222 0.900000 5.3232222 0.000000 6.3083333 0.000000)
Vs69 trig_s69 0 PWL(0.0000000 0.000000 2.0689444 0.000000 2.0694444 0.900000 2.0699444 0.900000 2.0704444 0.000000 2.8856111 0.000000 2.8861111 0.900000 2.8866111 0.900000 2.8871111 0.000000 3.5383889 0.000000 3.5388889 0.900000 3.5393889 0.900000 3.5398889 0.000000 4.5328333 0.000000 4.5333333 0.900000 4.5338333 0.900000 4.5343333 0.000000 5.3772778 0.000000 5.3777778 0.900000 5.3782778 0.900000 5.3787778 0.000000 6.3083333 0.000000)
Vwid trig_wid 0 PWL(0.0000000 0.000000 2.0828333 0.000000 2.0833333 0.900000 2.0838333 0.900000 2.0843333 0.000000 2.8995000 0.000000 2.9000000 0.900000 2.9005000 0.900000 2.9010000 0.000000 3.5522778 0.000000 3.5527778 0.900000 3.5532778 0.900000 3.5537778 0.000000 4.5467222 0.000000 4.5472222 0.900000 4.5477222 0.900000 4.5482222 0.000000 5.3911667 0.000000 5.3916667 0.900000 5.3921667 0.900000 5.3926667 0.000000 6.3083333 0.000000)
Vrco trig_rr_copy 0 PWL(0.0000000 0.000000 2.0095000 0.000000 2.0100000 0.900000 2.0120000 0.900000 2.0125000 0.000000 2.8261667 0.000000 2.8266667 0.900000 2.8286667 0.900000 2.8291667 0.000000 3.4789444 0.000000 3.4794444 0.900000 3.4814444 0.900000 3.4819444 0.000000 4.4733889 0.000000 4.4738889 0.900000 4.4758889 0.900000 4.4763889 0.000000 5.3178333 0.000000 5.3183333 0.900000 5.3203333 0.900000 5.3208333 0.000000 6.3083333 0.000000)
Vbco trig_bi_copy 0 PWL(0.0000000 0.000000 2.2995000 0.000000 2.3000000 0.900000 2.3020000 0.900000 2.3025000 0.000000 3.1161667 0.000000 3.1166667 0.900000 3.1186667 0.900000 3.1191667 0.000000 3.7689444 0.000000 3.7694444 0.900000 3.7714444 0.900000 3.7719444 0.000000 4.7633889 0.000000 4.7638889 0.900000 4.7658889 0.900000 4.7663889 0.000000 5.6078333 0.000000 5.6083333 0.900000 5.6103333 0.900000 5.6108333 0.000000 6.3083333 0.000000)

.include "C:/Users/kadhi/OneDrive/Desktop/amux/verilogLearning/Leaky-Integrate-Fire---SNN-model-on-FPGA/experiments/frontend_optimization/complete_frontend/rr_timing.spice"
.include "C:/Users/kadhi/OneDrive/Desktop/amux/verilogLearning/Leaky-Integrate-Fire---SNN-model-on-FPGA/experiments/frontend_optimization/complete_frontend/beat_instability.spice"
.include "C:/Users/kadhi/OneDrive/Desktop/amux/verilogLearning/Leaky-Integrate-Fire---SNN-model-on-FPGA/experiments/frontend_optimization/complete_frontend/pwave_diff.spice"
.include "C:/Users/kadhi/OneDrive/Desktop/amux/verilogLearning/Leaky-Integrate-Fire---SNN-model-on-FPGA/experiments/frontend_optimization/complete_frontend/qrs_width.spice"
.include "C:/Users/kadhi/OneDrive/Desktop/amux/verilogLearning/Leaky-Integrate-Fire---SNN-model-on-FPGA/experiments/frontend_optimization/complete_frontend/qrs_slope.spice"
.include "C:/Users/kadhi/OneDrive/Desktop/amux/verilogLearning/Leaky-Integrate-Fire---SNN-model-on-FPGA/experiments/frontend_optimization/complete_frontend/qrs_symmetry.spice"

* F1 & F2: RR Timing
Xrr ecg_l0 trig_rr_cap trig_rr_rpeak trig_rr_copy f1_rr_ratio f2_rr_asym vdd vss vbias rr_timing

* F3: Beat Instability L0
Xbi0 ecg_l0 trig_rpeak_sh trig_bi_copy f3_bi_l0 vdd vss vbias beat_instability

* F4: Beat Instability L1
Xbi1 ecg_l1 trig_rpeak_sh trig_bi_copy f4_bi_l1 vdd vss vbias beat_instability

* F5: P-wave Diff (Lead 0)
Xpw ecg_l0 trig_pw_base trig_pw_peak f5_pwave vdd vss vbias pwave_diff

* F6: QRS Width (Lead 0)
Xwid ecg_l0 trig_wid f6_width vdd vss qrs_width

* F7: QRS Slope (Lead 0)
Xslp ecg_l0 trig_s14 trig_s69 f7_slope vdd vss vbias qrs_slope

* F8: QRS Symmetry (Lead 0)
Xsym ecg_l0 trig_rpeak_sh f8_symmetry vdd vss qrs_symmetry

* ============================================================
* SIMULATION
* ============================================================
* Initial conditions for convergence
.ic V(pw_timer_dummy)=0.5 V(pw_ewma_dummy)=0.3

.tran 0.5m 6.3083 uic

* Average VDD current over steady-state beats
.meas tran avg_i_vdd AVG I(Vmeas) FROM=2.8067 TO=5.6583
.meas tran max_i_vdd MAX I(Vmeas) FROM=2.8067 TO=5.6583
.meas tran min_i_vdd MIN I(Vmeas) FROM=2.8067 TO=5.6583

.end
