* FEATURE 7: QRS Slope — v9 (diode loads)
*
* Proxy: ECG@R+14ms - ECG@R+69ms (signed). Captures post-R slope asymmetry.
* Diode-connected loads, gain ~1. v8 hybrid (2x) caused 55.8% clipping.
* v8→v9: reverted to diode loads for 0% clipping.
*
* Triggers: sample14_trig (R+14ms), sample69_trig (R+69ms)

.subckt qrs_slope ecg_in sample14_trig sample69_trig slope_out vdd vss vbias

XMs14 ecg_in sample14_trig sh14 vss sky130_fd_pr__nfet_01v8 L=0.5 W=2 nf=1
XCs14 sh14 vss sky130_fd_pr__cap_mim_m3_1 W=32 L=32

XMs69 ecg_in sample69_trig sh69 vss sky130_fd_pr__nfet_01v8 L=0.5 W=2 nf=1
XCs69 sh69 vss sky130_fd_pr__cap_mim_m3_1 W=32 L=32

XMd_tail dtail vbias vss vss sky130_fd_pr__nfet_01v8 L=8 W=0.42 nf=1
XMd1 dnet sh14 dtail vss sky130_fd_pr__nfet_01v8 L=1 W=8 nf=1
XMd2 slope_out sh69 dtail vss sky130_fd_pr__nfet_01v8 L=1 W=8 nf=1
* Both sides: diode-connected (gain ~1, 0% clipping)
XMd3 dnet dnet vdd vdd sky130_fd_pr__pfet_01v8 L=4 W=2 nf=1
XMd4 slope_out slope_out vdd vdd sky130_fd_pr__pfet_01v8 L=4 W=2 nf=1

.ends qrs_slope
