.title integ_207
.lib "C:/Users/kadhi/OneDrive/Desktop/amux/verilogLearning/Leaky-Integrate-Fire---SNN-model-on-FPGA/experiments/frontend_optimization/ngspice_frontend/sky130_minimal.lib.spice" tt
.option scale=1.0u method=gear reltol=0.01 gmin=1e-15 itl4=200
.temp 27
Vdd vdd 0 0.9
Vss vss 0 0

* ECG inputs
Vecg0 ecg_l0 0 PWL(0.0000000 0.300000 0.4747778 0.300000 0.4777778 0.313974 0.4805556 0.312576 0.4833333 0.313974 0.4861111 0.315371 0.4888889 0.314672 0.4916667 0.312576 0.4944444 0.310480 0.4972222 0.311179 0.5000000 0.311878 0.5027778 0.315371 0.5055556 0.314672 0.5083333 0.313974 0.5111111 0.311878 0.5138889 0.312576 0.5166667 0.314672 0.5194444 0.313275 0.5222222 0.313275 0.5250000 0.311179 0.5277778 0.309782 0.5305556 0.308384 0.5333333 0.309782 0.5361111 0.312576 0.5388889 0.312576 0.5416667 0.312576 0.5444444 0.311878 0.5472222 0.310480 0.5500000 0.311878 0.5527778 0.314672 0.5555556 0.316070 0.5583333 0.314672 0.5611111 0.315371 0.5638889 0.315371 0.5666667 0.316769 0.5694444 0.318166 0.5722222 0.320262 0.5750000 0.318865 0.5777778 0.317467 0.5805556 0.317467 0.5833333 0.318865 0.5861111 0.318865 0.5888889 0.320961 0.5916667 0.320262 0.5944444 0.320262 0.5972222 0.320262 0.6000000 0.322358 0.6027778 0.323057 0.6055556 0.324454 0.6083333 0.323755 0.6111111 0.323057 0.6138889 0.324454 0.6166667 0.323057 0.6194444 0.327249 0.6222222 0.327249 0.6250000 0.325852 0.6277778 0.325852 0.6305556 0.326550 0.6333333 0.327948 0.6361111 0.331441 0.6388889 0.330742 0.6416667 0.328646 0.6444444 0.325852 0.6472222 0.325153 0.6500000 0.325852 0.6527778 0.326550 0.6555556 0.326550 0.6583333 0.326550 0.6611111 0.327948 0.6638889 0.329345 0.6666667 0.338428 0.6694444 0.346812 0.6722222 0.354498 0.6750000 0.356594 0.6777778 0.356594 0.6805556 0.355197 0.6833333 0.358690 0.6861111 0.358690 0.6888889 0.356594 0.6916667 0.349607 0.6944444 0.339825 0.6972222 0.327948 0.7000000 0.315371 0.7027778 0.301397 0.7055556 0.290218 0.7083333 0.272052 0.7111111 0.253886 0.7138889 0.235022 0.7166667 0.218952 0.7194444 0.202183 0.7222222 0.189607 0.7250000 0.178428 0.7277778 0.170044 0.7305556 0.163755 0.7333333 0.162358 0.7361111 0.165153 0.7388889 0.170044 0.7416667 0.178428 0.7444444 0.188210 0.7472222 0.201485 0.7500000 0.215459 0.7527778 0.230830 0.7555556 0.237817 0.7583333 0.237817 0.7611111 0.234323 0.7638889 0.226638 0.7666667 0.220349 0.7694444 0.211965 0.7722222 0.200786 0.7750000 0.188210 0.7777778 0.176332 0.7805556 0.168646 0.7833333 0.166550 0.7861111 0.163755 0.7888889 0.163755 0.7916667 0.163755 0.7944444 0.162358 0.7972222 0.160262 0.8000000 0.161659 0.8027778 0.162358 0.8055556 0.161659 0.8083333 0.159563 0.8111111 0.160961 0.8138889 0.159563 0.8166667 0.159563 0.8194444 0.160961 0.8222222 0.161659 0.8250000 0.158865 0.8277778 0.157467 0.8305556 0.156769 0.8333333 0.156769 0.8361111 0.157467 0.8388889 0.159563 0.8416667 0.156769 0.8444444 0.156070 0.8472222 0.156070 0.8500000 0.158166 0.8527778 0.158166 0.8555556 0.159563 0.8583333 0.158166 0.8611111 0.157467 0.8638889 0.156070 0.8666667 0.158166 0.8694444 0.163057 0.8722222 0.161659 0.8750000 0.161659 0.8777778 0.160262 0.8805556 0.159563 0.8833333 0.160961 0.8861111 0.162358 0.8888889 0.158865 0.8916667 0.158865 0.8944444 0.160961 0.8972222 0.160262 0.9000000 0.162358 0.9027778 0.165153 0.9055556 0.165852 0.9083333 0.165153 0.9111111 0.163755 0.9138889 0.165852 0.9166667 0.168646 0.9194444 0.171441 0.9222222 0.172838 0.9250000 0.172838 0.9277778 0.168646 0.9305556 0.167948 0.9333333 0.172140 0.9361111 0.174934 0.9388889 0.174934 0.9416667 0.173537 0.9444444 0.176332 0.9472222 0.177729 0.9500000 0.181921 0.9527778 0.185415 0.9555556 0.186812 0.9583333 0.186812 0.9611111 0.185415 0.9638889 0.186812 0.9666667 0.188210 0.9694444 0.188210 0.9722222 0.189607 0.9750000 0.188210 0.9777778 0.189607 0.9805556 0.191703 0.9833333 0.195197 0.9861111 0.196594 0.9888889 0.198690 0.9916667 0.199389 0.9944444 0.198690 0.9972222 0.199389 1.0000000 0.202183 1.0027778 0.202183 1.0055556 0.202183 1.0083333 0.202183 1.0111111 0.200087 1.0138889 0.200786 1.0166667 0.205677 1.0194444 0.207074 1.0222222 0.209170 1.0250000 0.209170 1.0307778 0.300000 1.9275556 0.300000 1.9305556 0.283930 1.9333333 0.286725 1.9361111 0.288821 1.9388889 0.288821 1.9416667 0.286725 1.9444444 0.283231 1.9472222 0.286725 1.9500000 0.285328 1.9527778 0.288821 1.9555556 0.288122 1.9583333 0.288821 1.9611111 0.286725 1.9638889 0.287424 1.9666667 0.288122 1.9694444 0.288821 1.9722222 0.290218 1.9750000 0.287424 1.9777778 0.285328 1.9805556 0.283930 1.9833333 0.286725 1.9861111 0.286725 1.9888889 0.288122 1.9916667 0.284629 1.9944444 0.284629 1.9972222 0.284629 2.0000000 0.286725 2.0027778 0.289520 2.0055556 0.290218 2.0083333 0.288122 2.0111111 0.286725 2.0138889 0.287424 2.0166667 0.288821 2.0194444 0.290917 2.0222222 0.291616 2.0250000 0.289520 2.0277778 0.287424 2.0305556 0.286725 2.0333333 0.286026 2.0361111 0.288122 2.0388889 0.288122 2.0416667 0.287424 2.0444444 0.288122 2.0472222 0.285328 2.0500000 0.288122 2.0527778 0.288821 2.0555556 0.288821 2.0583333 0.287424 2.0611111 0.287424 2.0638889 0.286026 2.0666667 0.288821 2.0694444 0.289520 2.0722222 0.290218 2.0750000 0.289520 2.0777778 0.288122 2.0805556 0.288122 2.0833333 0.290218 2.0861111 0.290917 2.0888889 0.290218 2.0916667 0.289520 2.0944444 0.288821 2.0972222 0.288122 2.1000000 0.290218 2.1027778 0.290218 2.1055556 0.292314 2.1083333 0.290218 2.1111111 0.290917 2.1138889 0.289520 2.1166667 0.290218 2.1194444 0.292314 2.1222222 0.292314 2.1250000 0.291616 2.1277778 0.286725 2.1305556 0.281834 2.1333333 0.281834 2.1361111 0.283930 2.1388889 0.285328 2.1416667 0.283930 2.1444444 0.282533 2.1472222 0.288122 2.1500000 0.297904 2.1527778 0.313275 2.1555556 0.331441 2.1583333 0.344017 2.1611111 0.353799 2.1638889 0.357991 2.1666667 0.364978 2.1694444 0.371965 2.1722222 0.385939 2.1750000 0.404803 2.1777778 0.420873 2.1805556 0.425764 2.1833333 0.422271 2.1861111 0.414585 2.1888889 0.404803 2.1916667 0.394323 2.1944444 0.382445 2.1972222 0.363581 2.2000000 0.341921 2.2027778 0.316070 2.2055556 0.291616 2.2083333 0.277642 2.2111111 0.267162 2.2138889 0.265066 2.2166667 0.264367 2.2194444 0.259476 2.2222222 0.257380 2.2250000 0.248996 2.2277778 0.246201 2.2305556 0.252489 2.2333333 0.261572 2.2361111 0.265764 2.2388889 0.273450 2.2416667 0.277642 2.2444444 0.286026 2.2472222 0.291616 2.2500000 0.293013 2.2527778 0.295808 2.2555556 0.290917 2.2583333 0.285328 2.2611111 0.279039 2.2638889 0.276245 2.2666667 0.276943 2.2694444 0.279738 2.2722222 0.278341 2.2750000 0.277642 2.2777778 0.273450 2.2805556 0.276245 2.2833333 0.277642 2.2861111 0.279039 2.2888889 0.279039 2.2916667 0.278341 2.2944444 0.276245 2.2972222 0.275546 2.3000000 0.279039 2.3027778 0.278341 2.3055556 0.279738 2.3083333 0.278341 2.3111111 0.276245 2.3138889 0.277642 2.3166667 0.276943 2.3194444 0.279039 2.3222222 0.278341 2.3250000 0.276943 2.3277778 0.274847 2.3305556 0.276245 2.3333333 0.276245 2.3361111 0.278341 2.3388889 0.278341 2.3416667 0.276943 2.3444444 0.276943 2.3472222 0.274847 2.3500000 0.277642 2.3527778 0.281135 2.3555556 0.281135 2.3583333 0.280437 2.3611111 0.276943 2.3638889 0.279738 2.3666667 0.282533 2.3694444 0.283930 2.3722222 0.283231 2.3750000 0.282533 2.3777778 0.280437 2.3805556 0.282533 2.3833333 0.283930 2.3861111 0.286725 2.3888889 0.285328 2.3916667 0.284629 2.3944444 0.283930 2.3972222 0.283930 2.4000000 0.286026 2.4027778 0.288821 2.4055556 0.288821 2.4083333 0.288122 2.4111111 0.289520 2.4138889 0.289520 2.4166667 0.290917 2.4194444 0.295109 2.4222222 0.295109 2.4250000 0.291616 2.4277778 0.290917 2.4305556 0.293712 2.4333333 0.295808 2.4361111 0.297904 2.4388889 0.297205 2.4416667 0.295808 2.4444444 0.294410 2.4472222 0.294410 2.4500000 0.297205 2.4527778 0.298603 2.4555556 0.301397 2.4583333 0.297904 2.4611111 0.300000 2.4638889 0.300699 2.4666667 0.301397 2.4694444 0.305590 2.4722222 0.305590 2.4750000 0.306288 2.4777778 0.305590 2.4835556 0.300000 2.6025556 0.300000 2.6055556 0.326550 2.6083333 0.324454 2.6111111 0.323755 2.6138889 0.323057 2.6166667 0.324454 2.6194444 0.325153 2.6222222 0.324454 2.6250000 0.323057 2.6277778 0.321659 2.6305556 0.322358 2.6333333 0.321659 2.6361111 0.323057 2.6388889 0.322358 2.6416667 0.321659 2.6444444 0.318166 2.6472222 0.323057 2.6500000 0.322358 2.6527778 0.323755 2.6555556 0.320262 2.6583333 0.318865 2.6611111 0.318166 2.6638889 0.318865 2.6666667 0.320262 2.6694444 0.318865 2.6722222 0.318166 2.6750000 0.318166 2.6777778 0.318865 2.6805556 0.318865 2.6833333 0.320961 2.6861111 0.319563 2.6888889 0.317467 2.6916667 0.318166 2.6944444 0.319563 2.6972222 0.321659 2.7000000 0.323057 2.7027778 0.323755 2.7055556 0.323057 2.7083333 0.320961 2.7111111 0.323057 2.7138889 0.323057 2.7166667 0.324454 2.7194444 0.323755 2.7222222 0.320961 2.7250000 0.323057 2.7277778 0.322358 2.7305556 0.324454 2.7333333 0.327249 2.7361111 0.328646 2.7388889 0.327249 2.7416667 0.326550 2.7444444 0.328646 2.7472222 0.329345 2.7500000 0.331441 2.7527778 0.332140 2.7555556 0.332140 2.7583333 0.330742 2.7611111 0.333537 2.7638889 0.335633 2.7666667 0.338428 2.7694444 0.337729 2.7722222 0.335633 2.7750000 0.332838 2.7777778 0.330742 2.7805556 0.333537 2.7833333 0.332140 2.7861111 0.329345 2.7888889 0.322358 2.7916667 0.320961 2.7944444 0.322358 2.7972222 0.322358 2.8000000 0.325852 2.8027778 0.324454 2.8055556 0.320262 2.8083333 0.318166 2.8111111 0.318166 2.8138889 0.319563 2.8166667 0.321659 2.8194444 0.320961 2.8222222 0.313974 2.8250000 0.304891 2.8277778 0.289520 2.8305556 0.272751 2.8333333 0.256681 2.8361111 0.242009 2.8388889 0.230131 2.8416667 0.212664 2.8444444 0.190306 2.8472222 0.167948 2.8500000 0.160262 2.8527778 0.152576 2.8555556 0.149083 2.8583333 0.144891 2.8611111 0.140000 2.8638889 0.140000 2.8666667 0.147686 2.8694444 0.159563 2.8722222 0.167249 2.8750000 0.171441 2.8777778 0.174934 2.8805556 0.178428 2.8833333 0.184017 2.8861111 0.187511 2.8888889 0.187511 2.8916667 0.184017 2.8944444 0.181921 2.8972222 0.182620 2.9000000 0.182620 2.9027778 0.182620 2.9055556 0.179825 2.9083333 0.176332 2.9111111 0.176332 2.9138889 0.178428 2.9166667 0.182620 2.9194444 0.183319 2.9222222 0.181921 2.9250000 0.179825 2.9277778 0.179127 2.9305556 0.180524 2.9333333 0.180524 2.9361111 0.181223 2.9388889 0.179127 2.9416667 0.176332 2.9444444 0.175633 2.9472222 0.177729 2.9500000 0.180524 2.9527778 0.180524 2.9555556 0.179127 2.9583333 0.177031 2.9611111 0.177031 2.9638889 0.177729 2.9666667 0.181223 2.9694444 0.179825 2.9722222 0.179127 2.9750000 0.179127 2.9777778 0.177031 2.9805556 0.179825 2.9833333 0.184017 2.9861111 0.183319 2.9888889 0.181921 2.9916667 0.179825 2.9944444 0.181223 2.9972222 0.184017 3.0000000 0.186812 3.0027778 0.186812 3.0055556 0.184017 3.0083333 0.185415 3.0111111 0.186114 3.0138889 0.188210 3.0166667 0.191703 3.0194444 0.192402 3.0222222 0.192402 3.0250000 0.192402 3.0277778 0.194498 3.0305556 0.195895 3.0333333 0.199389 3.0361111 0.197991 3.0388889 0.197991 3.0416667 0.199389 3.0444444 0.199389 3.0472222 0.203581 3.0500000 0.204279 3.0527778 0.207773 3.0555556 0.204978 3.0583333 0.205677 3.0611111 0.207074 3.0638889 0.210568 3.0666667 0.214061 3.0694444 0.213362 3.0722222 0.213362 3.0750000 0.212664 3.0777778 0.213362 3.0805556 0.216856 3.0833333 0.218952 3.0861111 0.219651 3.0888889 0.221048 3.0916667 0.220349 3.0944444 0.223843 3.0972222 0.226638 3.1000000 0.230131 3.1027778 0.229432 3.1055556 0.232227 3.1083333 0.233624 3.1111111 0.233624 3.1138889 0.236419 3.1166667 0.239214 3.1194444 0.237817 3.1222222 0.236419 3.1250000 0.239214 3.1277778 0.240611 3.1305556 0.242707 3.1333333 0.246201 3.1361111 0.246900 3.1388889 0.248297 3.1416667 0.248996 3.1444444 0.249694 3.1472222 0.253188 3.1500000 0.256681 3.1527778 0.255284 3.1585556 0.300000 4.0192222 0.300000 4.0222222 0.275546 4.0250000 0.276245 4.0277778 0.276245 4.0305556 0.278341 4.0333333 0.279738 4.0361111 0.278341 4.0388889 0.278341 4.0416667 0.277642 4.0444444 0.279039 4.0472222 0.279738 4.0500000 0.280437 4.0527778 0.279039 4.0555556 0.276245 4.0583333 0.274847 4.0611111 0.274847 4.0638889 0.276943 4.0666667 0.279738 4.0694444 0.278341 4.0722222 0.274847 4.0750000 0.276245 4.0777778 0.276943 4.0805556 0.276943 4.0833333 0.279738 4.0861111 0.277642 4.0888889 0.274148 4.0916667 0.276245 4.0944444 0.278341 4.0972222 0.279738 4.1000000 0.281834 4.1027778 0.281135 4.1055556 0.279039 4.1083333 0.277642 4.1111111 0.278341 4.1138889 0.280437 4.1166667 0.279738 4.1194444 0.279738 4.1222222 0.279039 4.1250000 0.277642 4.1277778 0.278341 4.1305556 0.279738 4.1333333 0.280437 4.1361111 0.278341 4.1388889 0.278341 4.1416667 0.276943 4.1444444 0.279039 4.1472222 0.279738 4.1500000 0.280437 4.1527778 0.279039 4.1555556 0.276943 4.1583333 0.275546 4.1611111 0.276943 4.1638889 0.281135 4.1666667 0.281135 4.1694444 0.279738 4.1722222 0.277642 4.1750000 0.277642 4.1777778 0.278341 4.1805556 0.280437 4.1833333 0.281834 4.1861111 0.281135 4.1888889 0.279738 4.1916667 0.279039 4.1944444 0.278341 4.1972222 0.279738 4.2000000 0.282533 4.2027778 0.283231 4.2055556 0.281834 4.2083333 0.281135 4.2111111 0.281834 4.2138889 0.283930 4.2166667 0.284629 4.2194444 0.282533 4.2222222 0.276943 4.2250000 0.272751 4.2277778 0.268559 4.2305556 0.266463 4.2333333 0.267860 4.2361111 0.266463 4.2388889 0.269258 4.2416667 0.276943 4.2444444 0.292314 4.2472222 0.311179 4.2500000 0.329345 4.2527778 0.341921 4.2555556 0.346114 4.2583333 0.349607 4.2611111 0.357293 4.2638889 0.375459 4.2666667 0.396419 4.2694444 0.408297 4.2722222 0.408297 4.2750000 0.400611 4.2777778 0.392926 4.2805556 0.385939 4.2833333 0.375459 4.2861111 0.357991 4.2888889 0.334236 4.2916667 0.305590 4.2944444 0.283231 4.2972222 0.269258 4.3000000 0.263668 4.3027778 0.260175 4.3055556 0.253188 4.3083333 0.249694 4.3111111 0.244803 4.3138889 0.240611 4.3166667 0.242009 4.3194444 0.246201 4.3222222 0.249694 4.3250000 0.253188 4.3277778 0.258079 4.3305556 0.265764 4.3333333 0.274847 4.3361111 0.280437 4.3388889 0.281135 4.3416667 0.282533 4.3444444 0.280437 4.3472222 0.274847 4.3500000 0.271354 4.3527778 0.267860 4.3555556 0.265066 4.3583333 0.265764 4.3611111 0.266463 4.3638889 0.267860 4.3666667 0.270655 4.3694444 0.269258 4.3722222 0.267860 4.3750000 0.267860 4.3777778 0.267860 4.3805556 0.269258 4.3833333 0.270655 4.3861111 0.269258 4.3888889 0.268559 4.3916667 0.267162 4.3944444 0.267860 4.3972222 0.268559 4.4000000 0.267860 4.4027778 0.267162 4.4055556 0.265764 4.4083333 0.265066 4.4111111 0.265764 4.4138889 0.269258 4.4166667 0.269956 4.4194444 0.269258 4.4222222 0.268559 4.4250000 0.265066 4.4277778 0.267860 4.4305556 0.271354 4.4333333 0.272751 4.4361111 0.272751 4.4388889 0.270655 4.4416667 0.269258 4.4444444 0.270655 4.4472222 0.273450 4.4500000 0.272751 4.4527778 0.272052 4.4555556 0.269956 4.4583333 0.272052 4.4611111 0.273450 4.4638889 0.274148 4.4666667 0.275546 4.4694444 0.274847 4.4722222 0.272052 4.4750000 0.272751 4.4777778 0.274847 4.4805556 0.277642 4.4833333 0.279039 4.4861111 0.279039 4.4888889 0.279039 4.4916667 0.278341 4.4944444 0.280437 4.4972222 0.282533 4.5000000 0.283231 4.5027778 0.281834 4.5055556 0.280437 4.5083333 0.279738 4.5111111 0.281834 4.5138889 0.283930 4.5166667 0.285328 4.5194444 0.283231 4.5222222 0.281834 4.5250000 0.283231 4.5277778 0.286026 4.5305556 0.288821 4.5333333 0.289520 4.5361111 0.290218 4.5388889 0.290218 4.5416667 0.289520 4.5444444 0.290917 4.5472222 0.294410 4.5500000 0.295808 4.5527778 0.296507 4.5555556 0.295109 4.5583333 0.293712 4.5611111 0.293712 4.5638889 0.295109 4.5666667 0.298603 4.5694444 0.298603 4.5752222 0.300000 4.6664444 0.300000 4.6694444 0.316070 4.6722222 0.313974 4.6750000 0.313275 4.6777778 0.313275 4.6805556 0.313974 4.6833333 0.313275 4.6861111 0.313275 4.6888889 0.312576 4.6916667 0.310480 4.6944444 0.311878 4.6972222 0.313974 4.7000000 0.313974 4.7027778 0.311179 4.7055556 0.310480 4.7083333 0.310480 4.7111111 0.311878 4.7138889 0.312576 4.7166667 0.309782 4.7194444 0.309782 4.7222222 0.308384 4.7250000 0.307686 4.7277778 0.307686 4.7305556 0.309083 4.7333333 0.308384 4.7361111 0.306987 4.7388889 0.306987 4.7416667 0.304192 4.7444444 0.306288 4.7472222 0.305590 4.7500000 0.306288 4.7527778 0.305590 4.7555556 0.306288 4.7583333 0.305590 4.7611111 0.308384 4.7638889 0.309782 4.7666667 0.309782 4.7694444 0.307686 4.7722222 0.306987 4.7750000 0.306288 4.7777778 0.305590 4.7805556 0.307686 4.7833333 0.309083 4.7861111 0.306987 4.7888889 0.307686 4.7916667 0.306987 4.7944444 0.309782 4.7972222 0.311878 4.8000000 0.312576 4.8027778 0.312576 4.8055556 0.312576 4.8083333 0.313974 4.8111111 0.314672 4.8138889 0.317467 4.8166667 0.318166 4.8194444 0.318865 4.8222222 0.319563 4.8250000 0.318166 4.8277778 0.318865 4.8305556 0.319563 4.8333333 0.321659 4.8361111 0.323755 4.8388889 0.323057 4.8416667 0.321659 4.8444444 0.321659 4.8472222 0.320262 4.8500000 0.318865 4.8527778 0.318166 4.8555556 0.315371 4.8583333 0.315371 4.8611111 0.319563 4.8638889 0.322358 4.8666667 0.325852 4.8694444 0.329345 4.8722222 0.327249 4.8750000 0.330044 4.8777778 0.330742 4.8805556 0.331441 4.8833333 0.328646 4.8861111 0.320961 4.8888889 0.311179 4.8916667 0.300000 4.8944444 0.289520 4.8972222 0.274148 4.9000000 0.260873 4.9027778 0.244803 4.9055556 0.227336 4.9083333 0.209170 4.9111111 0.199389 4.9138889 0.185415 4.9166667 0.171441 4.9194444 0.160961 4.9222222 0.155371 4.9250000 0.153974 4.9277778 0.160262 4.9305556 0.167249 4.9333333 0.177729 4.9361111 0.192402 4.9388889 0.202882 4.9416667 0.213362 4.9444444 0.222445 4.9472222 0.230131 4.9500000 0.232227 4.9527778 0.225939 4.9555556 0.216856 4.9583333 0.207773 4.9611111 0.200786 4.9638889 0.195197 4.9666667 0.188210 4.9694444 0.183319 4.9722222 0.179825 4.9750000 0.176332 4.9777778 0.177031 4.9805556 0.179127 4.9833333 0.178428 4.9861111 0.174934 4.9888889 0.174934 4.9916667 0.173537 4.9944444 0.173537 4.9972222 0.174934 5.0000000 0.174236 5.0027778 0.173537 5.0055556 0.172140 5.0083333 0.172838 5.0111111 0.172838 5.0138889 0.174934 5.0166667 0.174236 5.0194444 0.173537 5.0222222 0.172140 5.0250000 0.172140 5.0277778 0.172838 5.0305556 0.172838 5.0333333 0.174236 5.0361111 0.174934 5.0388889 0.172838 5.0416667 0.172140 5.0444444 0.172838 5.0472222 0.174934 5.0500000 0.176332 5.0527778 0.174236 5.0555556 0.174236 5.0583333 0.172838 5.0611111 0.176332 5.0638889 0.177729 5.0666667 0.179127 5.0694444 0.178428 5.0722222 0.175633 5.0750000 0.177031 5.0777778 0.179825 5.0805556 0.182620 5.0833333 0.184716 5.0861111 0.181921 5.0888889 0.184017 5.0916667 0.183319 5.0944444 0.186114 5.0972222 0.186812 5.1000000 0.187511 5.1027778 0.188210 5.1055556 0.186812 5.1083333 0.185415 5.1111111 0.187511 5.1138889 0.190306 5.1166667 0.190306 5.1194444 0.189607 5.1222222 0.187511 5.1250000 0.188908 5.1277778 0.191703 5.1305556 0.195895 5.1333333 0.199389 5.1361111 0.199389 5.1388889 0.200087 5.1416667 0.200087 5.1444444 0.201485 5.1472222 0.205677 5.1500000 0.205677 5.1527778 0.208472 5.1555556 0.204279 5.1583333 0.205677 5.1611111 0.207074 5.1638889 0.209869 5.1666667 0.211266 5.1694444 0.209869 5.1722222 0.209869 5.1750000 0.211965 5.1777778 0.212664 5.1805556 0.215459 5.1833333 0.215459 5.1861111 0.216856 5.1888889 0.213362 5.1916667 0.214760 5.1944444 0.216157 5.1972222 0.220349 5.2000000 0.222445 5.2027778 0.222445 5.2055556 0.220349 5.2083333 0.220349 5.2111111 0.223144 5.2138889 0.227336 5.2166667 0.228734 5.2224444 0.300000 6.1136667 0.300000 6.1166667 0.279738 6.1194444 0.279738 6.1222222 0.279039 6.1250000 0.276943 6.1277778 0.276245 6.1305556 0.279738 6.1333333 0.280437 6.1361111 0.279738 6.1388889 0.276245 6.1416667 0.277642 6.1444444 0.278341 6.1472222 0.279039 6.1500000 0.280437 6.1527778 0.276245 6.1555556 0.274847 6.1583333 0.275546 6.1611111 0.276245 6.1638889 0.279039 6.1666667 0.279738 6.1694444 0.276245 6.1722222 0.275546 6.1750000 0.276245 6.1777778 0.279738 6.1805556 0.281135 6.1833333 0.281135 6.1861111 0.280437 6.1888889 0.279039 6.1916667 0.276943 6.1944444 0.276245 6.1972222 0.276943 6.2000000 0.279039 6.2027778 0.276943 6.2055556 0.276245 6.2083333 0.275546 6.2111111 0.276943 6.2138889 0.279039 6.2166667 0.279738 6.2194444 0.278341 6.2222222 0.276943 6.2250000 0.276245 6.2277778 0.278341 6.2305556 0.280437 6.2333333 0.281135 6.2361111 0.279039 6.2388889 0.279039 6.2416667 0.278341 6.2444444 0.280437 6.2472222 0.281135 6.2500000 0.281135 6.2527778 0.279039 6.2555556 0.276943 6.2583333 0.275546 6.2611111 0.276943 6.2638889 0.279738 6.2666667 0.279039 6.2694444 0.276245 6.2722222 0.276245 6.2750000 0.277642 6.2777778 0.280437 6.2805556 0.281834 6.2833333 0.283930 6.2861111 0.283231 6.2888889 0.282533 6.2916667 0.281135 6.2944444 0.283930 6.2972222 0.286725 6.3000000 0.286026 6.3027778 0.282533 6.3055556 0.281135 6.3083333 0.281834 6.3111111 0.281135 6.3138889 0.280437 6.3166667 0.279738 6.3194444 0.274148 6.3222222 0.268559 6.3250000 0.267860 6.3277778 0.267162 6.3305556 0.269258 6.3333333 0.272751 6.3361111 0.276943 6.3388889 0.288821 6.3416667 0.304891 6.3444444 0.322358 6.3472222 0.336332 6.3500000 0.344716 6.3527778 0.350306 6.3555556 0.353100 6.3583333 0.363581 6.3611111 0.383843 6.3638889 0.400611 6.3666667 0.407598 6.3694444 0.402707 6.3722222 0.392227 6.3750000 0.383843 6.3777778 0.376157 6.3805556 0.365677 6.3833333 0.348908 6.3861111 0.321659 6.3888889 0.293712 6.3916667 0.274148 6.3944444 0.265764 6.3972222 0.263668 6.4000000 0.259476 6.4027778 0.257380 6.4055556 0.249694 6.4083333 0.243406 6.4111111 0.242009 6.4138889 0.246201 6.4166667 0.251092 6.4194444 0.255284 6.4222222 0.256681 6.4250000 0.262271 6.4277778 0.269956 6.4305556 0.279738 6.4333333 0.283231 6.4361111 0.283231 6.4388889 0.279738 6.4416667 0.273450 6.4444444 0.271354 6.4472222 0.269258 6.4500000 0.268559 6.4527778 0.267162 6.4555556 0.266463 6.4583333 0.268559 6.4611111 0.268559 6.4638889 0.270655 6.4666667 0.271354 6.4694444 0.271354 6.4722222 0.269258 6.4750000 0.269956 6.4777778 0.270655 6.4805556 0.270655 6.4833333 0.269956 6.4861111 0.268559 6.4888889 0.265764 6.4916667 0.267162 6.4944444 0.269258 6.4972222 0.269956 6.5000000 0.269258 6.5027778 0.269258 6.5055556 0.268559 6.5083333 0.269258 6.5111111 0.271354 6.5138889 0.270655 6.5166667 0.273450 6.5194444 0.272052 6.5222222 0.270655 6.5250000 0.272052 6.5277778 0.272751 6.5305556 0.275546 6.5333333 0.273450 6.5361111 0.272751 6.5388889 0.271354 6.5416667 0.271354 6.5444444 0.273450 6.5472222 0.275546 6.5500000 0.276943 6.5527778 0.275546 6.5555556 0.274148 6.5583333 0.273450 6.5611111 0.276943 6.5638889 0.279039 6.5666667 0.279738 6.5694444 0.279039 6.5722222 0.279039 6.5750000 0.278341 6.5777778 0.279738 6.5805556 0.282533 6.5833333 0.282533 6.5861111 0.281135 6.5888889 0.279738 6.5916667 0.281834 6.5944444 0.279738 6.5972222 0.283930 6.6000000 0.284629 6.6027778 0.283231 6.6055556 0.281135 6.6083333 0.283231 6.6111111 0.284629 6.6138889 0.286725 6.6166667 0.286725 6.6194444 0.286725 6.6222222 0.285328 6.6250000 0.286026 6.6277778 0.289520 6.6305556 0.291616 6.6333333 0.292314 6.6361111 0.289520 6.6388889 0.290218 6.6416667 0.293013 6.6444444 0.293712 6.6472222 0.295808 6.6500000 0.294410 6.6527778 0.294410 6.6555556 0.291616 6.6583333 0.293013 6.6611111 0.295109 6.6638889 0.297904 6.6696667 0.300000 6.8108889 0.300000 6.8138889 0.314672 6.8166667 0.313974 6.8194444 0.312576 6.8222222 0.309782 6.8250000 0.310480 6.8277778 0.310480 6.8305556 0.311878 6.8333333 0.312576 6.8361111 0.309782 6.8388889 0.306288 6.8416667 0.304891 6.8444444 0.307686 6.8472222 0.309782 6.8500000 0.309782 6.8527778 0.306987 6.8555556 0.304192 6.8583333 0.304891 6.8611111 0.306288 6.8638889 0.308384 6.8666667 0.308384 6.8694444 0.308384 6.8722222 0.304192 6.8750000 0.306987 6.8777778 0.308384 6.8805556 0.310480 6.8833333 0.310480 6.8861111 0.309782 6.8888889 0.308384 6.8916667 0.309083 6.8944444 0.309083 6.8972222 0.309083 6.9000000 0.311179 6.9027778 0.309083 6.9055556 0.309083 6.9083333 0.309083 6.9111111 0.309782 6.9138889 0.309083 6.9166667 0.311878 6.9194444 0.311179 6.9222222 0.309782 6.9250000 0.311179 6.9277778 0.312576 6.9305556 0.314672 6.9333333 0.315371 6.9361111 0.315371 6.9388889 0.313275 6.9416667 0.314672 6.9444444 0.318166 6.9472222 0.318166 6.9500000 0.320262 6.9527778 0.320262 6.9555556 0.318166 6.9583333 0.318166 6.9611111 0.321659 6.9638889 0.321659 6.9666667 0.325852 6.9694444 0.325153 6.9722222 0.323755 6.9750000 0.324454 6.9777778 0.325852 6.9805556 0.327948 6.9833333 0.325852 6.9861111 0.323057 6.9888889 0.320262 6.9916667 0.321659 6.9944444 0.323057 6.9972222 0.326550 7.0000000 0.326550 7.0027778 0.324454 7.0055556 0.323057 7.0083333 0.323755 7.0111111 0.324454 7.0138889 0.325852 7.0166667 0.323057 7.0194444 0.318865 7.0222222 0.316769 7.0250000 0.311179 7.0277778 0.306987 7.0305556 0.300699 7.0333333 0.293013 7.0361111 0.282533 7.0388889 0.265764 7.0416667 0.249694 7.0444444 0.232227 7.0472222 0.221048 7.0500000 0.214061 7.0527778 0.200786 7.0555556 0.178428 7.0583333 0.158865 7.0611111 0.147686 7.0638889 0.145590 7.0666667 0.146288 7.0694444 0.146987 7.0722222 0.143493 7.0750000 0.144891 7.0777778 0.151878 7.0805556 0.163755 7.0833333 0.175633 7.0861111 0.184017 7.0888889 0.189607 7.0916667 0.195197 7.0944444 0.201485 7.0972222 0.200786 7.1000000 0.199389 7.1027778 0.195895 7.1055556 0.191703 7.1083333 0.189607 7.1111111 0.186114 7.1138889 0.187511 7.1166667 0.185415 7.1194444 0.181223 7.1222222 0.177729 7.1250000 0.174934 7.1277778 0.175633 7.1305556 0.174934 7.1333333 0.177031 7.1361111 0.174934 7.1388889 0.174934 7.1416667 0.173537 7.1444444 0.174236 7.1472222 0.176332 7.1500000 0.175633 7.1527778 0.172838 7.1555556 0.172838 7.1583333 0.172838 7.1611111 0.174236 7.1638889 0.177031 7.1666667 0.175633 7.1694444 0.174236 7.1722222 0.172838 7.1750000 0.172838 7.1777778 0.173537 7.1805556 0.175633 7.1833333 0.174934 7.1861111 0.176332 7.1888889 0.174236 7.1916667 0.174934 7.1944444 0.176332 7.1972222 0.179127 7.2000000 0.179127 7.2027778 0.179127 7.2055556 0.178428 7.2083333 0.178428 7.2111111 0.179825 7.2138889 0.181223 7.2166667 0.182620 7.2194444 0.182620 7.2222222 0.182620 7.2250000 0.181921 7.2277778 0.184716 7.2305556 0.186812 7.2333333 0.189607 7.2361111 0.189607 7.2388889 0.187511 7.2416667 0.187511 7.2444444 0.189607 7.2472222 0.192402 7.2500000 0.193100 7.2527778 0.193100 7.2555556 0.192402 7.2583333 0.192402 7.2611111 0.194498 7.2638889 0.198690 7.2666667 0.199389 7.2694444 0.200087 7.2722222 0.197293 7.2750000 0.198690 7.2777778 0.201485 7.2805556 0.202882 7.2833333 0.206376 7.2861111 0.208472 7.2888889 0.208472 7.2916667 0.208472 7.2944444 0.210568 7.2972222 0.211266 7.3000000 0.212664 7.3027778 0.213362 7.3055556 0.211266 7.3083333 0.211266 7.3111111 0.214061 7.3138889 0.216157 7.3166667 0.218253 7.3194444 0.218952 7.3222222 0.218253 7.3250000 0.218253 7.3277778 0.223144 7.3305556 0.225240 7.3333333 0.225240 7.3361111 0.226638 7.3388889 0.226638 7.3416667 0.228035 7.3444444 0.229432 7.3472222 0.232926 7.3500000 0.234323 7.3527778 0.234323 7.3555556 0.234323 7.3583333 0.235022 7.3611111 0.237118 7.3668889 0.300000 8.2497778 0.300000 8.2527778 0.276245 8.2555556 0.276245 8.2583333 0.276943 8.2611111 0.276943 8.2638889 0.278341 8.2666667 0.279738 8.2694444 0.277642 8.2722222 0.272751 8.2750000 0.273450 8.2777778 0.275546 8.2805556 0.277642 8.2833333 0.276943 8.2861111 0.276245 8.2888889 0.275546 8.2916667 0.275546 8.2944444 0.276245 8.2972222 0.278341 8.3000000 0.276943 8.3027778 0.276245 8.3055556 0.276943 8.3083333 0.274847 8.3111111 0.277642 8.3138889 0.279738 8.3166667 0.279738 8.3194444 0.277642 8.3222222 0.276943 8.3250000 0.274148 8.3277778 0.274847 8.3305556 0.275546 8.3333333 0.276943 8.3361111 0.278341 8.3388889 0.274148 8.3416667 0.274148 8.3444444 0.275546 8.3472222 0.278341 8.3500000 0.277642 8.3527778 0.274148 8.3555556 0.272751 8.3583333 0.274148 8.3611111 0.276943 8.3638889 0.278341 8.3666667 0.279039 8.3694444 0.277642 8.3722222 0.274148 8.3750000 0.276245 8.3777778 0.278341 8.3805556 0.278341 8.3833333 0.276245 8.3861111 0.275546 8.3888889 0.274847 8.3916667 0.274847 8.3944444 0.276245 8.3972222 0.277642 8.4000000 0.277642 8.4027778 0.276943 8.4055556 0.275546 8.4083333 0.272052 8.4111111 0.277642 8.4138889 0.278341 8.4166667 0.279039 8.4194444 0.278341 8.4222222 0.277642 8.4250000 0.279039 8.4277778 0.281834 8.4305556 0.282533 8.4333333 0.283231 8.4361111 0.281834 8.4388889 0.281135 8.4416667 0.280437 8.4444444 0.281834 8.4472222 0.285328 8.4500000 0.285328 8.4527778 0.281834 8.4555556 0.276943 8.4583333 0.272751 8.4611111 0.272052 8.4638889 0.274847 8.4666667 0.277642 8.4694444 0.276245 8.4722222 0.281135 8.4750000 0.292314 8.4777778 0.310480 8.4805556 0.327948 8.4833333 0.341921 8.4861111 0.347511 8.4888889 0.348908 8.4916667 0.352402 8.4944444 0.364279 8.4972222 0.382445 8.5000000 0.399913 8.5027778 0.404803 8.5055556 0.401310 8.5083333 0.392227 8.5111111 0.385240 8.5138889 0.378952 8.5166667 0.367074 8.5194444 0.346114 8.5222222 0.320262 8.5250000 0.293013 8.5277778 0.275546 8.5305556 0.269258 8.5333333 0.266463 8.5361111 0.262969 8.5388889 0.257380 8.5416667 0.253188 8.5444444 0.248996 8.5472222 0.246900 8.5500000 0.246900 8.5527778 0.248297 8.5555556 0.252489 8.5583333 0.256681 8.5611111 0.263668 8.5638889 0.272751 8.5666667 0.278341 8.5694444 0.281135 8.5722222 0.278341 8.5750000 0.274148 8.5777778 0.272052 8.5805556 0.268559 8.5833333 0.267162 8.5861111 0.265764 8.5888889 0.264367 8.5916667 0.265764 8.5944444 0.267162 8.5972222 0.268559 8.6000000 0.268559 8.6027778 0.265764 8.6055556 0.263668 8.6083333 0.263668 8.6111111 0.265066 8.6138889 0.265764 8.6166667 0.267162 8.6194444 0.265066 8.6222222 0.262969 8.6250000 0.262969 8.6277778 0.263668 8.6305556 0.267162 8.6333333 0.266463 8.6361111 0.264367 8.6388889 0.265764 8.6416667 0.265764 8.6444444 0.268559 8.6472222 0.269956 8.6500000 0.269258 8.6527778 0.268559 8.6555556 0.267162 8.6583333 0.265066 8.6611111 0.265066 8.6638889 0.267162 8.6666667 0.269258 8.6694444 0.267860 8.6722222 0.265764 8.6750000 0.266463 8.6777778 0.268559 8.6805556 0.271354 8.6833333 0.269956 8.6861111 0.268559 8.6888889 0.269258 8.6916667 0.269956 8.6944444 0.272052 8.6972222 0.272751 8.7000000 0.274847 8.7027778 0.274847 8.7055556 0.274148 8.7083333 0.274847 8.7111111 0.275546 8.7138889 0.277642 8.7166667 0.277642 8.7194444 0.276245 8.7222222 0.274148 8.7250000 0.275546 8.7277778 0.277642 8.7305556 0.279738 8.7333333 0.279738 8.7361111 0.278341 8.7388889 0.278341 8.7416667 0.277642 8.7444444 0.281135 8.7472222 0.283930 8.7500000 0.283930 8.7527778 0.281834 8.7555556 0.281834 8.7583333 0.281135 8.7611111 0.283231 8.7638889 0.287424 8.7666667 0.288122 8.7694444 0.285328 8.7722222 0.286725 8.7750000 0.286026 8.7777778 0.290218 8.7805556 0.291616 8.7833333 0.290218 8.7861111 0.290218 8.7888889 0.288122 8.7916667 0.288122 8.7944444 0.292314 8.7972222 0.295109 8.8000000 0.294410 8.8057778 0.300000 8.9331111 0.300000 8.9361111 0.312576 8.9388889 0.311179 8.9416667 0.310480 8.9444444 0.311179 8.9472222 0.312576 8.9500000 0.310480 8.9527778 0.308384 8.9555556 0.306987 8.9583333 0.306987 8.9611111 0.307686 8.9638889 0.308384 8.9666667 0.309782 8.9694444 0.308384 8.9722222 0.306987 8.9750000 0.307686 8.9777778 0.308384 8.9805556 0.308384 8.9833333 0.310480 8.9861111 0.308384 8.9888889 0.308384 8.9916667 0.307686 8.9944444 0.308384 8.9972222 0.312576 9.0000000 0.312576 9.0027778 0.309782 9.0055556 0.304891 9.0083333 0.307686 9.0111111 0.309782 9.0138889 0.311878 9.0166667 0.312576 9.0194444 0.310480 9.0222222 0.308384 9.0250000 0.310480 9.0277778 0.311878 9.0305556 0.314672 9.0333333 0.314672 9.0361111 0.313974 9.0388889 0.312576 9.0416667 0.313974 9.0444444 0.314672 9.0472222 0.318166 9.0500000 0.318166 9.0527778 0.318166 9.0555556 0.316769 9.0583333 0.316769 9.0611111 0.320262 9.0638889 0.321659 9.0666667 0.322358 9.0694444 0.320262 9.0722222 0.320961 9.0750000 0.321659 9.0777778 0.323755 9.0805556 0.326550 9.0833333 0.327249 9.0861111 0.327249 9.0888889 0.325852 9.0916667 0.326550 9.0944444 0.330742 9.0972222 0.331441 9.1000000 0.334236 9.1027778 0.330044 9.1055556 0.328646 9.1083333 0.327948 9.1111111 0.326550 9.1138889 0.325852 9.1166667 0.324454 9.1194444 0.320961 9.1222222 0.320262 9.1250000 0.318865 9.1277778 0.321659 9.1305556 0.322358 9.1333333 0.320961 9.1361111 0.318166 9.1388889 0.311878 9.1416667 0.306987 9.1444444 0.302795 9.1472222 0.300699 9.1500000 0.294410 9.1527778 0.288821 9.1555556 0.283930 9.1583333 0.279039 9.1611111 0.270655 9.1638889 0.256681 9.1666667 0.239214 9.1694444 0.222445 9.1722222 0.212664 9.1750000 0.205677 9.1777778 0.193799 9.1805556 0.177031 9.1833333 0.163755 9.1861111 0.156070 9.1888889 0.153275 9.1916667 0.154672 9.1944444 0.156769 9.1972222 0.160961 9.2000000 0.168646 9.2027778 0.178428 9.2055556 0.188908 9.2083333 0.195197 9.2111111 0.197991 9.2138889 0.199389 9.2166667 0.199389 9.2194444 0.198690 9.2222222 0.195895 9.2250000 0.193100 9.2277778 0.188908 9.2305556 0.187511 9.2333333 0.184017 9.2361111 0.180524 9.2388889 0.179825 9.2416667 0.179127 9.2444444 0.178428 9.2472222 0.180524 9.2500000 0.181223 9.2527778 0.179127 9.2555556 0.177729 9.2583333 0.178428 9.2611111 0.179127 9.2638889 0.180524 9.2666667 0.180524 9.2694444 0.179127 9.2722222 0.179127 9.2750000 0.177729 9.2777778 0.179825 9.2805556 0.181223 9.2833333 0.181223 9.2861111 0.177729 9.2888889 0.175633 9.2916667 0.176332 9.2944444 0.177729 9.2972222 0.181223 9.3000000 0.181921 9.3027778 0.177031 9.3055556 0.177729 9.3083333 0.179825 9.3111111 0.181223 9.3138889 0.182620 9.3166667 0.185415 9.3194444 0.184017 9.3222222 0.184017 9.3250000 0.185415 9.3277778 0.187511 9.3305556 0.188210 9.3333333 0.188210 9.3361111 0.188908 9.3388889 0.187511 9.3416667 0.186812 9.3444444 0.187511 9.3472222 0.190306 9.3500000 0.192402 9.3527778 0.191004 9.3555556 0.189607 9.3583333 0.191703 9.3611111 0.194498 9.3638889 0.198690 9.3666667 0.200087 9.3694444 0.197293 9.3722222 0.197991 9.3750000 0.200087 9.3777778 0.202183 9.3805556 0.204978 9.3833333 0.207074 9.3861111 0.207773 9.3888889 0.206376 9.3916667 0.207074 9.3944444 0.209869 9.3972222 0.213362 9.4000000 0.213362 9.4027778 0.214061 9.4055556 0.213362 9.4083333 0.215459 9.4111111 0.216157 9.4138889 0.220349 9.4166667 0.219651 9.4194444 0.221048 9.4222222 0.221048 9.4250000 0.222445 9.4277778 0.224541 9.4305556 0.227336 9.4333333 0.228734 9.4361111 0.230131 9.4388889 0.230131 9.4416667 0.232227 9.4444444 0.233624 9.4472222 0.236419 9.4500000 0.236419 9.4527778 0.237118 9.4555556 0.235721 9.4583333 0.235721 9.4611111 0.239214 9.4638889 0.242009 9.4666667 0.242707 9.4694444 0.243406 9.4722222 0.244105 9.4750000 0.245502 9.4777778 0.248297 9.4805556 0.251092 9.4833333 0.252489 9.4891111 0.300000 10.3220000 0.300000 10.3250000 0.284629 10.3277778 0.284629 10.3305556 0.286026 10.3333333 0.284629 10.3361111 0.283231 10.3388889 0.282533 10.3416667 0.281135 10.3444444 0.283231 10.3472222 0.287424 10.3500000 0.285328 10.3527778 0.283930 10.3555556 0.282533 10.3583333 0.283231 10.3611111 0.286026 10.3638889 0.286026 10.3666667 0.286026 10.3694444 0.284629 10.3722222 0.283930 10.3750000 0.283930 10.3777778 0.286725 10.3805556 0.287424 10.3833333 0.285328 10.3861111 0.282533 10.3888889 0.281834 10.3916667 0.282533 10.3944444 0.286725 10.3972222 0.286026 10.4000000 0.285328 10.4027778 0.283231 10.4055556 0.283231 10.4083333 0.284629 10.4111111 0.286026 10.4138889 0.285328 10.4166667 0.283930 10.4194444 0.284629 10.4222222 0.284629 10.4250000 0.285328 10.4277778 0.288122 10.4305556 0.288821 10.4333333 0.286725 10.4361111 0.284629 10.4388889 0.283930 10.4416667 0.285328 10.4444444 0.285328 10.4472222 0.286026 10.4500000 0.285328 10.4527778 0.284629 10.4555556 0.282533 10.4583333 0.283930 10.4611111 0.286026 10.4638889 0.286725 10.4666667 0.286026 10.4694444 0.284629 10.4722222 0.281834 10.4750000 0.284629 10.4777778 0.286026 10.4805556 0.288821 10.4833333 0.287424 10.4861111 0.286026 10.4888889 0.284629 10.4916667 0.283930 10.4944444 0.286026 10.4972222 0.286725 10.5000000 0.286026 10.5027778 0.286026 10.5055556 0.283930 10.5083333 0.283231 10.5111111 0.284629 10.5138889 0.287424 10.5166667 0.286026 10.5194444 0.283930 10.5222222 0.283231 10.5250000 0.285328 10.5277778 0.286725 10.5305556 0.286725 10.5333333 0.282533 10.5361111 0.279039 10.5388889 0.277642 10.5416667 0.279039 10.5444444 0.280437 10.5472222 0.285328 10.5500000 0.293013 10.5527778 0.306987 10.5555556 0.323755 10.5583333 0.339825 10.5611111 0.351004 10.5638889 0.354498 10.5666667 0.359389 10.5694444 0.372664 10.5722222 0.392227 10.5750000 0.406900 10.5777778 0.409694 10.5805556 0.404803 10.5833333 0.392227 10.5861111 0.381747 10.5888889 0.364279 10.5916667 0.341921 10.5944444 0.312576 10.5972222 0.288821 10.6000000 0.278341 10.6027778 0.272052 10.6055556 0.268559 10.6083333 0.262271 10.6111111 0.256681 10.6138889 0.259476 10.6166667 0.267860 10.6194444 0.272052 10.6222222 0.278341 10.6250000 0.286725 10.6277778 0.292314 10.6305556 0.293712 10.6333333 0.289520 10.6361111 0.281834 10.6388889 0.275546 10.6416667 0.272751 10.6444444 0.272751 10.6472222 0.274847 10.6500000 0.276245 10.6527778 0.273450 10.6555556 0.273450 10.6583333 0.272751 10.6611111 0.275546 10.6638889 0.276943 10.6666667 0.275546 10.6694444 0.275546 10.6722222 0.274148 10.6750000 0.276245 10.6777778 0.276245 10.6805556 0.277642 10.6833333 0.276943 10.6861111 0.274847 10.6888889 0.275546 10.6916667 0.275546 10.6944444 0.274148 10.6972222 0.277642 10.7000000 0.276245 10.7027778 0.276245 10.7055556 0.274847 10.7083333 0.274847 10.7111111 0.276245 10.7138889 0.277642 10.7166667 0.277642 10.7194444 0.276245 10.7222222 0.274847 10.7250000 0.276943 10.7277778 0.279039 10.7305556 0.279738 10.7333333 0.279738 10.7361111 0.279039 10.7388889 0.277642 10.7416667 0.276943 10.7444444 0.279039 10.7472222 0.279738 10.7500000 0.279738 10.7527778 0.279738 10.7555556 0.279039 10.7583333 0.279039 10.7611111 0.283231 10.7638889 0.283231 10.7666667 0.283231 10.7694444 0.281834 10.7722222 0.281135 10.7750000 0.283231 10.7777778 0.286026 10.7805556 0.288122 10.7833333 0.288122 10.7861111 0.287424 10.7888889 0.287424 10.7916667 0.288821 10.7944444 0.288122 10.7972222 0.291616 10.8000000 0.290218 10.8027778 0.287424 10.8055556 0.287424 10.8083333 0.288821 10.8111111 0.291616 10.8138889 0.293013 10.8166667 0.293712 10.8194444 0.292314 10.8222222 0.292314 10.8250000 0.293013 10.8277778 0.296507 10.8305556 0.296507 10.8333333 0.297205 10.8361111 0.299301 10.8388889 0.296507 10.8416667 0.297205 10.8444444 0.300699 10.8472222 0.302795 10.8500000 0.302795 10.8527778 0.299301 10.8555556 0.297904 10.8583333 0.300699 10.8611111 0.302096 10.8638889 0.304192 10.8666667 0.303493 10.8694444 0.302096 10.8722222 0.301397 10.8780000 0.300000 10.9747778 0.300000 10.9777778 0.314672 10.9805556 0.314672 10.9833333 0.315371 10.9861111 0.312576 10.9888889 0.311179 10.9916667 0.311878 10.9944444 0.313275 10.9972222 0.313974 11.0000000 0.315371 11.0027778 0.313974 11.0055556 0.312576 11.0083333 0.311878 11.0111111 0.311878 11.0138889 0.313974 11.0166667 0.311878 11.0194444 0.310480 11.0222222 0.309782 11.0250000 0.309782 11.0277778 0.312576 11.0305556 0.312576 11.0333333 0.311179 11.0361111 0.309083 11.0388889 0.310480 11.0416667 0.311179 11.0444444 0.313275 11.0472222 0.314672 11.0500000 0.314672 11.0527778 0.313974 11.0555556 0.313974 11.0583333 0.315371 11.0611111 0.316769 11.0638889 0.317467 11.0666667 0.316070 11.0694444 0.315371 11.0722222 0.315371 11.0750000 0.314672 11.0777778 0.316769 11.0805556 0.318865 11.0833333 0.319563 11.0861111 0.318865 11.0888889 0.316769 11.0916667 0.318166 11.0944444 0.321659 11.0972222 0.323057 11.1000000 0.323057 11.1027778 0.323755 11.1055556 0.323057 11.1083333 0.323755 11.1111111 0.328646 11.1138889 0.328646 11.1166667 0.327948 11.1194444 0.326550 11.1222222 0.327249 11.1250000 0.330742 11.1277778 0.333537 11.1305556 0.333537 11.1333333 0.332838 11.1361111 0.334236 11.1388889 0.332838 11.1416667 0.333537 11.1444444 0.330742 11.1472222 0.329345 11.1500000 0.325852 11.1527778 0.322358 11.1555556 0.321659 11.1583333 0.322358 11.1611111 0.319563 11.1638889 0.321659 11.1666667 0.318865 11.1694444 0.316070 11.1722222 0.314672 11.1750000 0.313974 11.1777778 0.313275 11.1805556 0.309083 11.1833333 0.304891 11.1861111 0.302096 11.1888889 0.300000 11.1916667 0.297205 11.1944444 0.295109 11.1972222 0.285328 11.2000000 0.268559 11.2027778 0.255284 11.2055556 0.246201 11.2083333 0.236419 11.2111111 0.223843 11.2138889 0.208472 11.2166667 0.192402 11.2194444 0.179127 11.2222222 0.170742 11.2250000 0.163057 11.2277778 0.160961 11.2305556 0.158865 11.2333333 0.161659 11.2361111 0.161659 11.2388889 0.167249 11.2416667 0.177031 11.2444444 0.186114 11.2472222 0.192402 11.2500000 0.194498 11.2527778 0.197293 11.2555556 0.197293 11.2583333 0.197293 11.2611111 0.196594 11.2638889 0.197293 11.2666667 0.193799 11.2694444 0.190306 11.2722222 0.187511 11.2750000 0.186812 11.2777778 0.188210 11.2805556 0.187511 11.2833333 0.186114 11.2861111 0.184017 11.2888889 0.185415 11.2916667 0.187511 11.2944444 0.188908 11.2972222 0.187511 11.3000000 0.186812 11.3027778 0.184716 11.3055556 0.184017 11.3083333 0.183319 11.3111111 0.184017 11.3138889 0.186812 11.3166667 0.186114 11.3194444 0.185415 11.3222222 0.184017 11.3250000 0.186114 11.3277778 0.186812 11.3305556 0.186812 11.3333333 0.186812 11.3361111 0.185415 11.3388889 0.182620 11.3416667 0.185415 11.3444444 0.188210 11.3472222 0.188210 11.3500000 0.188908 11.3527778 0.188210 11.3555556 0.185415 11.3583333 0.186114 11.3611111 0.188908 11.3638889 0.191703 11.3666667 0.191004 11.3694444 0.189607 11.3722222 0.188908 11.3750000 0.191004 11.3777778 0.195197 11.3805556 0.194498 11.3833333 0.196594 11.3861111 0.195895 11.3888889 0.195895 11.3916667 0.199389 11.3944444 0.200786 11.3972222 0.202882 11.4000000 0.203581 11.4027778 0.204279 11.4055556 0.201485 11.4083333 0.204279 11.4111111 0.204279 11.4138889 0.206376 11.4166667 0.206376 11.4194444 0.204279 11.4222222 0.207074 11.4250000 0.207773 11.4277778 0.210568 11.4305556 0.210568 11.4333333 0.212664 11.4361111 0.214061 11.4388889 0.213362 11.4416667 0.214061 11.4444444 0.215459 11.4472222 0.218952 11.4500000 0.219651 11.4527778 0.218952 11.4555556 0.218253 11.4583333 0.221747 11.4611111 0.224541 11.4638889 0.228035 11.4666667 0.229432 11.4694444 0.225240 11.4722222 0.226638 11.4750000 0.226638 11.4777778 0.228734 11.4805556 0.230830 11.4833333 0.232227 11.4861111 0.231528 11.4888889 0.232227 11.4916667 0.234323 11.4944444 0.235022 11.4972222 0.239214 11.5000000 0.239214 11.5027778 0.240611 11.5055556 0.239214 11.5083333 0.242009 11.5111111 0.244105 11.5138889 0.246900 11.5166667 0.247598 11.5194444 0.248297 11.5222222 0.247598 11.5250000 0.250393 11.5307778 0.300000 12.4886667 0.300000 12.4916667 0.288821 12.4944444 0.290218 12.4972222 0.290917 12.5000000 0.289520 12.5027778 0.288122 12.5055556 0.288122 12.5083333 0.288821 12.5111111 0.290218 12.5138889 0.291616 12.5166667 0.288821 12.5194444 0.287424 12.5222222 0.288122 12.5250000 0.289520 12.5277778 0.289520 12.5305556 0.290917 12.5333333 0.290917 12.5361111 0.291616 12.5388889 0.288122 12.5416667 0.290218 12.5444444 0.291616 12.5472222 0.290917 12.5500000 0.288821 12.5527778 0.288122 12.5555556 0.287424 12.5583333 0.289520 12.5611111 0.289520 12.5638889 0.290218 12.5666667 0.288821 12.5694444 0.286026 12.5722222 0.286725 12.5750000 0.288821 12.5777778 0.290218 12.5805556 0.289520 12.5833333 0.288821 12.5861111 0.289520 12.5888889 0.289520 12.5916667 0.290917 12.5944444 0.290218 12.5972222 0.291616 12.6000000 0.290917 12.6027778 0.289520 12.6055556 0.288122 12.6083333 0.288122 12.6111111 0.291616 12.6138889 0.290218 12.6166667 0.288122 12.6194444 0.288821 12.6222222 0.288122 12.6250000 0.288821 12.6277778 0.290917 12.6305556 0.290917 12.6333333 0.291616 12.6361111 0.288821 12.6388889 0.287424 12.6416667 0.289520 12.6444444 0.291616 12.6472222 0.292314 12.6500000 0.292314 12.6527778 0.290218 12.6555556 0.290218 12.6583333 0.291616 12.6611111 0.295109 12.6638889 0.293712 12.6666667 0.292314 12.6694444 0.289520 12.6722222 0.287424 12.6750000 0.290218 12.6777778 0.293013 12.6805556 0.292314 12.6833333 0.292314 12.6861111 0.289520 12.6888889 0.290218 12.6916667 0.289520 12.6944444 0.286725 12.6972222 0.286026 12.7000000 0.284629 12.7027778 0.283930 12.7055556 0.286026 12.7083333 0.289520 12.7111111 0.298603 12.7138889 0.309782 12.7166667 0.322358 12.7194444 0.335633 12.7222222 0.346114 12.7250000 0.355197 12.7277778 0.359389 12.7305556 0.362183 12.7333333 0.375459 12.7361111 0.393624 12.7388889 0.407598 12.7416667 0.414585 12.7444444 0.412489 12.7472222 0.404105 12.7500000 0.395022 12.7527778 0.385240 12.7555556 0.376856 12.7583333 0.364978 12.7611111 0.348210 12.7638889 0.324454 12.7666667 0.302795 12.7694444 0.291616 12.7722222 0.285328 12.7750000 0.281135 12.7777778 0.279039 12.7805556 0.276245 12.7833333 0.272052 12.7861111 0.265066 12.7888889 0.261572 12.7916667 0.265066 12.7944444 0.271354 12.7972222 0.277642 12.8000000 0.281135 12.8027778 0.284629 12.8055556 0.289520 12.8083333 0.295808 12.8111111 0.300000 12.8138889 0.299301 12.8166667 0.293013 12.8194444 0.289520 12.8222222 0.284629 12.8250000 0.284629 12.8277778 0.283231 12.8305556 0.282533 12.8333333 0.281834 12.8361111 0.281834 12.8388889 0.276245 12.8416667 0.279039 12.8444444 0.281834 12.8472222 0.280437 12.8500000 0.281135 12.8527778 0.277642 12.8555556 0.279039 12.8583333 0.279738 12.8611111 0.280437 12.8638889 0.281135 12.8666667 0.280437 12.8694444 0.279039 12.8722222 0.278341 12.8750000 0.279738 12.8777778 0.280437 12.8805556 0.281135 12.8833333 0.281834 12.8861111 0.279738 12.8888889 0.281135 12.8916667 0.281834 12.8944444 0.282533 12.8972222 0.282533 12.9000000 0.282533 12.9027778 0.279039 12.9055556 0.278341 12.9083333 0.281135 12.9111111 0.281135 12.9138889 0.282533 12.9166667 0.281834 12.9194444 0.279738 12.9222222 0.279039 12.9250000 0.282533 12.9277778 0.283930 12.9305556 0.285328 12.9333333 0.285328 12.9361111 0.281135 12.9388889 0.281834 12.9416667 0.285328 12.9444444 0.286725 12.9472222 0.287424 12.9500000 0.287424 12.9527778 0.286725 12.9555556 0.286725 12.9583333 0.286026 12.9611111 0.288821 12.9638889 0.288122 12.9666667 0.288821 12.9694444 0.288122 12.9722222 0.286725 12.9750000 0.289520 12.9777778 0.291616 12.9805556 0.290218 12.9833333 0.290917 12.9861111 0.289520 12.9888889 0.290917 12.9916667 0.291616 12.9944444 0.296507 12.9972222 0.295109 13.0000000 0.295808 13.0027778 0.294410 13.0055556 0.296507 13.0083333 0.297904 13.0111111 0.297904 13.0138889 0.297904 13.0166667 0.297904 13.0194444 0.297904 13.0222222 0.298603 13.0250000 0.299301 13.0277778 0.301397 13.0305556 0.302096 13.0333333 0.302795 13.0361111 0.300699 13.0388889 0.300000 13.0446667 0.300000 13.1886667 0.300000 13.1916667 0.316769 13.1944444 0.317467 13.1972222 0.318166 13.2000000 0.316769 13.2027778 0.313974 13.2055556 0.311878 13.2083333 0.313275 13.2111111 0.313275 13.2138889 0.316070 13.2166667 0.313974 13.2194444 0.313974 13.2222222 0.314672 13.2250000 0.315371 13.2277778 0.318166 13.2305556 0.318865 13.2333333 0.317467 13.2361111 0.315371 13.2388889 0.312576 13.2416667 0.313974 13.2444444 0.316769 13.2472222 0.316769 13.2500000 0.314672 13.2527778 0.314672 13.2555556 0.314672 13.2583333 0.315371 13.2611111 0.316769 13.2638889 0.316769 13.2666667 0.316769 13.2694444 0.313275 13.2722222 0.314672 13.2750000 0.317467 13.2777778 0.320961 13.2805556 0.320262 13.2833333 0.319563 13.2861111 0.320262 13.2888889 0.318865 13.2916667 0.323057 13.2944444 0.323755 13.2972222 0.325852 13.3000000 0.325153 13.3027778 0.325852 13.3055556 0.325153 13.3083333 0.326550 13.3111111 0.327249 13.3138889 0.324454 13.3166667 0.325852 13.3194444 0.326550 13.3222222 0.327948 13.3250000 0.327948 13.3277778 0.330044 13.3305556 0.330044 13.3333333 0.330742 13.3361111 0.330044 13.3388889 0.330044 13.3416667 0.333537 13.3444444 0.334934 13.3472222 0.336332 13.3500000 0.337031 13.3527778 0.335633 13.3555556 0.334934 13.3583333 0.334236 13.3611111 0.333537 13.3638889 0.331441 13.3666667 0.327948 13.3694444 0.323755 13.3722222 0.323057 13.3750000 0.321659 13.3777778 0.320961 13.3805556 0.319563 13.3833333 0.318166 13.3861111 0.314672 13.3888889 0.313974 13.3916667 0.311179 13.3944444 0.308384 13.3972222 0.306987 13.4000000 0.305590 13.4027778 0.302795 13.4055556 0.303493 13.4083333 0.302795 13.4111111 0.297904 13.4138889 0.286026 13.4166667 0.270655 13.4194444 0.260175 13.4222222 0.247598 13.4250000 0.237817 13.4277778 0.229432 13.4305556 0.213362 13.4333333 0.197991 13.4361111 0.184017 13.4388889 0.172838 13.4416667 0.165852 13.4444444 0.164454 13.4472222 0.163755 13.4500000 0.167249 13.4527778 0.170742 13.4555556 0.174934 13.4583333 0.185415 13.4611111 0.193799 13.4638889 0.200786 13.4666667 0.202183 13.4694444 0.202183 13.4722222 0.202183 13.4750000 0.203581 13.4777778 0.200786 13.4805556 0.198690 13.4833333 0.193100 13.4861111 0.188210 13.4888889 0.186812 13.4916667 0.187511 13.4944444 0.186812 13.4972222 0.185415 13.5000000 0.184716 13.5027778 0.182620 13.5055556 0.182620 13.5083333 0.184017 13.5111111 0.186812 13.5138889 0.187511 13.5166667 0.186114 13.5194444 0.185415 13.5222222 0.185415 13.5250000 0.186114 13.5277778 0.184017 13.5305556 0.184716 13.5333333 0.184017 13.5361111 0.182620 13.5388889 0.181223 13.5416667 0.182620 13.5444444 0.185415 13.5472222 0.185415 13.5500000 0.185415 13.5527778 0.184716 13.5555556 0.184716 13.5583333 0.186114 13.5611111 0.187511 13.5638889 0.188210 13.5666667 0.188210 13.5694444 0.187511 13.5722222 0.188908 13.5750000 0.188908 13.5777778 0.191004 13.5805556 0.192402 13.5833333 0.190306 13.5861111 0.188908 13.5888889 0.188210 13.5916667 0.191004 13.5944444 0.191703 13.5972222 0.193799 13.6000000 0.193799 13.6027778 0.193799 13.6055556 0.192402 13.6083333 0.196594 13.6111111 0.198690 13.6138889 0.199389 13.6166667 0.200087 13.6194444 0.200087 13.6222222 0.199389 13.6250000 0.203581 13.6277778 0.206376 13.6305556 0.206376 13.6333333 0.207074 13.6361111 0.206376 13.6388889 0.205677 13.6416667 0.208472 13.6444444 0.210568 13.6472222 0.212664 13.6500000 0.214061 13.6527778 0.211266 13.6555556 0.212664 13.6583333 0.215459 13.6611111 0.218253 13.6638889 0.218952 13.6666667 0.220349 13.6694444 0.218952 13.6722222 0.220349 13.6750000 0.222445 13.6777778 0.224541 13.6805556 0.226638 13.6833333 0.227336 13.6861111 0.227336 13.6888889 0.228035 13.6916667 0.230830 13.6944444 0.233624 13.6972222 0.235022 13.7000000 0.235022 13.7027778 0.232227 13.7055556 0.232926 13.7083333 0.236419 13.7111111 0.239214 13.7138889 0.239913 13.7166667 0.240611 13.7194444 0.241310 13.7222222 0.241310 13.7250000 0.244105 13.7277778 0.248996 13.7305556 0.248996 13.7333333 0.251092 13.7361111 0.251092 13.7388889 0.251092 13.7446667 0.300000 14.6331111 0.300000 14.6361111 0.290218 14.6388889 0.290218 14.6416667 0.291616 14.6444444 0.294410 14.6472222 0.293013 14.6500000 0.290917 14.6527778 0.290218 14.6555556 0.289520 14.6583333 0.290917 14.6611111 0.290917 14.6638889 0.291616 14.6666667 0.291616 14.6694444 0.287424 14.6722222 0.288821 14.6750000 0.290218 14.6777778 0.292314 14.6805556 0.293013 14.6833333 0.290917 14.6861111 0.290917 14.6888889 0.290218 14.6916667 0.290917 14.6944444 0.293712 14.6972222 0.293712 14.7000000 0.293013 14.7027778 0.293013 14.7055556 0.292314 14.7083333 0.293013 14.7111111 0.294410 14.7138889 0.292314 14.7166667 0.292314 14.7194444 0.289520 14.7222222 0.289520 14.7250000 0.290218 14.7277778 0.289520 14.7305556 0.290218 14.7333333 0.289520 14.7361111 0.289520 14.7388889 0.289520 14.7416667 0.290218 14.7444444 0.292314 14.7472222 0.292314 14.7500000 0.291616 14.7527778 0.288122 14.7555556 0.289520 14.7583333 0.291616 14.7611111 0.293013 14.7638889 0.293013 14.7666667 0.290917 14.7694444 0.289520 14.7722222 0.288821 14.7750000 0.288122 14.7777778 0.290917 14.7805556 0.291616 14.7833333 0.288821 14.7861111 0.287424 14.7888889 0.287424 14.7916667 0.290917 14.7944444 0.293013 14.7972222 0.291616 14.8000000 0.290917 14.8027778 0.290917 14.8055556 0.289520 14.8083333 0.290917 14.8111111 0.292314 14.8138889 0.293712 14.8166667 0.293013 14.8194444 0.292314 14.8222222 0.288821 14.8250000 0.290218 14.8277778 0.294410 14.8305556 0.292314 14.8333333 0.290218 14.8361111 0.288821 14.8388889 0.284629 14.8416667 0.283930 14.8444444 0.286725 14.8472222 0.288122 14.8500000 0.287424 14.8527778 0.287424 14.8555556 0.293013 14.8583333 0.309083 14.8611111 0.325153 14.8638889 0.339825 14.8666667 0.348908 14.8694444 0.353799 14.8722222 0.357293 14.8750000 0.366376 14.8777778 0.383144 14.8805556 0.404105 14.8833333 0.412489 14.8861111 0.411790 14.8888889 0.405502 14.8916667 0.398515 14.8944444 0.392227 14.8972222 0.383144 14.9000000 0.367773 14.9027778 0.348908 14.9055556 0.324454 14.9083333 0.303493 14.9111111 0.291616 14.9138889 0.286026 14.9166667 0.280437 14.9194444 0.277642 14.9222222 0.273450 14.9250000 0.269956 14.9277778 0.267162 14.9305556 0.265066 14.9333333 0.267162 14.9361111 0.269956 14.9388889 0.272751 14.9416667 0.280437 14.9444444 0.287424 14.9472222 0.293712 14.9500000 0.297205 14.9527778 0.296507 14.9555556 0.293712 14.9583333 0.290917 14.9611111 0.286725 14.9638889 0.284629 14.9666667 0.281834 14.9694444 0.278341 14.9722222 0.277642 14.9750000 0.283231 14.9777778 0.284629 14.9805556 0.286026 14.9833333 0.283231 14.9861111 0.281834 14.9888889 0.279738 14.9916667 0.281834 14.9944444 0.283930 14.9972222 0.282533 15.0000000 0.279738 15.0027778 0.279738 15.0055556 0.280437 15.0083333 0.281135 15.0111111 0.282533 15.0138889 0.282533 15.0166667 0.281135 15.0194444 0.277642 15.0222222 0.277642 15.0250000 0.281135 15.0277778 0.281834 15.0305556 0.283231 15.0333333 0.282533 15.0361111 0.282533 15.0388889 0.279738 15.0416667 0.282533 15.0444444 0.283930 15.0472222 0.283231 15.0500000 0.283231 15.0527778 0.280437 15.0555556 0.279738 15.0583333 0.281135 15.0611111 0.283231 15.0638889 0.284629 15.0666667 0.284629 15.0694444 0.281834 15.0722222 0.280437 15.0750000 0.283930 15.0777778 0.286725 15.0805556 0.287424 15.0833333 0.286026 15.0861111 0.284629 15.0888889 0.284629 15.0916667 0.287424 15.0944444 0.289520 15.0972222 0.289520 15.1000000 0.287424 15.1027778 0.288821 15.1055556 0.288122 15.1083333 0.288821 15.1111111 0.290917 15.1138889 0.292314 15.1166667 0.291616 15.1194444 0.289520 15.1222222 0.289520 15.1250000 0.290917 15.1277778 0.294410 15.1305556 0.295808 15.1333333 0.292314 15.1361111 0.294410 15.1388889 0.293712 15.1416667 0.294410 15.1444444 0.297904 15.1472222 0.297904 15.1500000 0.298603 15.1527778 0.297205 15.1555556 0.297205 15.1583333 0.297904 15.1611111 0.300699 15.1638889 0.302795 15.1666667 0.300000 15.1694444 0.299301 15.1722222 0.298603 15.1750000 0.301397 15.1777778 0.303493 15.1805556 0.304192 15.1833333 0.302795 15.1891111 0.300000 15.2970000 0.300000 15.3000000 0.315371 15.3027778 0.313275 15.3055556 0.313974 15.3083333 0.316769 15.3111111 0.316769 15.3138889 0.317467 15.3166667 0.316769 15.3194444 0.315371 15.3222222 0.315371 15.3250000 0.315371 15.3277778 0.317467 15.3305556 0.316070 15.3333333 0.313974 15.3361111 0.311878 15.3388889 0.310480 15.3416667 0.313275 15.3444444 0.316070 15.3472222 0.313974 15.3500000 0.313275 15.3527778 0.313275 15.3555556 0.312576 15.3583333 0.315371 15.3611111 0.316769 15.3638889 0.316070 15.3666667 0.315371 15.3694444 0.314672 15.3722222 0.314672 15.3750000 0.316070 15.3777778 0.317467 15.3805556 0.318166 15.3833333 0.316769 15.3861111 0.313974 15.3888889 0.313974 15.3916667 0.317467 15.3944444 0.318166 15.3972222 0.318865 15.4000000 0.318865 15.4027778 0.319563 15.4055556 0.318865 15.4083333 0.322358 15.4111111 0.323755 15.4138889 0.323755 15.4166667 0.324454 15.4194444 0.323057 15.4222222 0.323057 15.4250000 0.325852 15.4277778 0.327948 15.4305556 0.327249 15.4333333 0.328646 15.4361111 0.326550 15.4388889 0.327948 15.4416667 0.330742 15.4444444 0.332140 15.4472222 0.331441 15.4500000 0.330044 15.4527778 0.330742 15.4555556 0.330742 15.4583333 0.333537 15.4611111 0.336332 15.4638889 0.335633 15.4666667 0.336332 15.4694444 0.334236 15.4722222 0.331441 15.4750000 0.331441 15.4777778 0.330742 15.4805556 0.328646 15.4833333 0.325852 15.4861111 0.320262 15.4888889 0.319563 15.4916667 0.318166 15.4944444 0.319563 15.4972222 0.317467 15.5000000 0.311179 15.5027778 0.307686 15.5055556 0.304891 15.5083333 0.308384 15.5111111 0.310480 15.5138889 0.308384 15.5166667 0.305590 15.5194444 0.298603 15.5222222 0.287424 15.5250000 0.276245 15.5277778 0.267162 15.5305556 0.255983 15.5333333 0.244803 15.5361111 0.229432 15.5388889 0.212664 15.5416667 0.200087 15.5444444 0.190306 15.5472222 0.181921 15.5500000 0.177729 15.5527778 0.179127 15.5555556 0.180524 15.5583333 0.184017 15.5611111 0.189607 15.5638889 0.195895 15.5666667 0.202183 15.5694444 0.206376 15.5722222 0.210568 15.5750000 0.214061 15.5777778 0.214760 15.5805556 0.210568 15.5833333 0.205677 15.5861111 0.201485 15.5888889 0.195895 15.5916667 0.195197 15.5944444 0.193799 15.5972222 0.191703 15.6000000 0.188210 15.6027778 0.183319 15.6055556 0.184017 15.6083333 0.184716 15.6111111 0.185415 15.6138889 0.185415 15.6166667 0.184716 15.6194444 0.184017 15.6222222 0.184017 15.6250000 0.184716 15.6277778 0.187511 15.6305556 0.186114 15.6333333 0.184716 15.6361111 0.184716 15.6388889 0.184017 15.6416667 0.186812 15.6444444 0.188908 15.6472222 0.189607 15.6500000 0.186114 15.6527778 0.186114 15.6555556 0.186114 15.6583333 0.186812 15.6611111 0.188210 15.6638889 0.188908 15.6666667 0.188210 15.6694444 0.186812 15.6722222 0.188210 15.6750000 0.189607 15.6777778 0.191703 15.6805556 0.191703 15.6833333 0.191703 15.6861111 0.191703 15.6888889 0.191703 15.6916667 0.194498 15.6944444 0.197991 15.6972222 0.199389 15.7000000 0.197991 15.7027778 0.194498 15.7055556 0.193799 15.7083333 0.198690 15.7111111 0.200087 15.7138889 0.200786 15.7166667 0.200786 15.7194444 0.200087 15.7222222 0.198690 15.7250000 0.203581 15.7277778 0.204978 15.7305556 0.207074 15.7333333 0.207773 15.7361111 0.204978 15.7388889 0.206376 15.7416667 0.209170 15.7444444 0.211266 15.7472222 0.211965 15.7500000 0.211965 15.7527778 0.212664 15.7555556 0.212664 15.7583333 0.216157 15.7611111 0.219651 15.7638889 0.220349 15.7666667 0.216157 15.7694444 0.218253 15.7722222 0.218952 15.7750000 0.221048 15.7777778 0.223843 15.7805556 0.224541 15.7833333 0.225240 15.7861111 0.224541 15.7888889 0.228035 15.7916667 0.228035 15.7944444 0.232926 15.7972222 0.232227 15.8000000 0.231528 15.8027778 0.232926 15.8055556 0.235721 15.8083333 0.237817 15.8111111 0.242009 15.8138889 0.242009 15.8166667 0.239913 15.8194444 0.240611 15.8222222 0.241310 15.8250000 0.244105 15.8277778 0.246900 15.8305556 0.246900 15.8333333 0.247598 15.8361111 0.247598 15.8388889 0.247598 15.8416667 0.251092 15.8444444 0.254585 15.8472222 0.256681 15.8530000 0.300000 16.7192222 0.300000 16.7222222 0.286725 16.7250000 0.288821 16.7277778 0.290218 16.7305556 0.292314 16.7333333 0.289520 16.7361111 0.288821 16.7388889 0.289520 16.7416667 0.292314 16.7444444 0.293712 16.7472222 0.293712 16.7500000 0.290917 16.7527778 0.290917 16.7555556 0.289520 16.7583333 0.292314 16.7611111 0.291616 16.7638889 0.288122 16.7666667 0.288821 16.7694444 0.288122 16.7722222 0.288821 16.7750000 0.291616 16.7777778 0.293013 16.7805556 0.289520 16.7833333 0.290218 16.7861111 0.289520 16.7888889 0.289520 16.7916667 0.290218 16.7944444 0.290917 16.7972222 0.291616 16.8000000 0.290218 16.8027778 0.289520 16.8055556 0.290218 16.8083333 0.291616 16.8111111 0.292314 16.8138889 0.292314 16.8166667 0.290218 16.8194444 0.288821 16.8222222 0.289520 16.8250000 0.290917 16.8277778 0.290917 16.8305556 0.290917 16.8333333 0.290218 16.8361111 0.288122 16.8388889 0.288821 16.8416667 0.291616 16.8444444 0.290917 16.8472222 0.291616 16.8500000 0.289520 16.8527778 0.289520 16.8555556 0.290917 16.8583333 0.293013 16.8611111 0.292314 16.8638889 0.293013 16.8666667 0.289520 16.8694444 0.289520 16.8722222 0.290218 16.8750000 0.291616 16.8777778 0.290917 16.8805556 0.290218 16.8833333 0.290218 16.8861111 0.288821 16.8888889 0.288122 16.8916667 0.290917 16.8944444 0.292314 16.8972222 0.293712 16.9000000 0.293013 16.9027778 0.292314 16.9055556 0.293712 16.9083333 0.294410 16.9111111 0.297904 16.9138889 0.295109 16.9166667 0.292314 16.9194444 0.290218 16.9222222 0.286026 16.9250000 0.284629 16.9277778 0.283930 16.9305556 0.284629 16.9333333 0.283231 16.9361111 0.283231 16.9388889 0.291616 16.9416667 0.303493 16.9444444 0.318166 16.9472222 0.333537 16.9500000 0.344017 16.9527778 0.349607 16.9555556 0.355197 16.9583333 0.360786 16.9611111 0.368472 16.9638889 0.382445 16.9666667 0.398515 16.9694444 0.411092 16.9722222 0.413886 16.9750000 0.410393 16.9777778 0.405502 16.9805556 0.397118 16.9833333 0.388734 16.9861111 0.374760 16.9888889 0.359389 16.9916667 0.336332 16.9944444 0.311878 16.9972222 0.290917 17.0000000 0.279738 17.0027778 0.274847 17.0055556 0.273450 17.0083333 0.273450 17.0111111 0.272052 17.0138889 0.266463 17.0166667 0.261572 17.0194444 0.262969 17.0222222 0.267860 17.0250000 0.272052 17.0277778 0.279738 17.0305556 0.282533 17.0333333 0.290218 17.0361111 0.294410 17.0388889 0.297205 17.0416667 0.296507 17.0444444 0.293013 17.0472222 0.286725 17.0500000 0.282533 17.0527778 0.277642 17.0555556 0.278341 17.0583333 0.279039 17.0611111 0.281135 17.0638889 0.281135 17.0666667 0.278341 17.0694444 0.279039 17.0722222 0.280437 17.0750000 0.282533 17.0777778 0.280437 17.0805556 0.280437 17.0833333 0.279738 17.0861111 0.280437 17.0888889 0.281135 17.0916667 0.283231 17.0944444 0.284629 17.0972222 0.283930 17.1000000 0.281834 17.1027778 0.277642 17.1055556 0.280437 17.1083333 0.281834 17.1111111 0.283231 17.1138889 0.281135 17.1166667 0.281834 17.1194444 0.280437 17.1222222 0.280437 17.1250000 0.282533 17.1277778 0.282533 17.1305556 0.283231 17.1333333 0.281135 17.1361111 0.281834 17.1388889 0.283930 17.1416667 0.285328 17.1444444 0.286725 17.1472222 0.286026 17.1500000 0.283231 17.1527778 0.283930 17.1555556 0.284629 17.1583333 0.286725 17.1611111 0.286725 17.1638889 0.286026 17.1666667 0.283930 17.1694444 0.285328 17.1722222 0.286026 17.1750000 0.288122 17.1777778 0.286725 17.1805556 0.288122 17.1833333 0.286725 17.1861111 0.287424 17.1888889 0.288122 17.1916667 0.290917 17.1944444 0.292314 17.1972222 0.293013 17.2000000 0.291616 17.2027778 0.292314 17.2055556 0.291616 17.2083333 0.295808 17.2111111 0.295109 17.2138889 0.295808 17.2166667 0.295808 17.2194444 0.293712 17.2222222 0.295109 17.2250000 0.295808 17.2277778 0.298603 17.2305556 0.298603 17.2333333 0.297205 17.2361111 0.297205 17.2388889 0.298603 17.2416667 0.300699 17.2444444 0.301397 17.2472222 0.303493 17.2500000 0.302096 17.2527778 0.302795 17.2555556 0.302096 17.2583333 0.303493 17.2611111 0.305590 17.2638889 0.304891 17.2666667 0.303493 17.2694444 0.302096 17.2752222 0.300000 17.4081111 0.300000 17.4111111 0.318865 17.4138889 0.318166 17.4166667 0.317467 17.4194444 0.316070 17.4222222 0.316070 17.4250000 0.316070 17.4277778 0.317467 17.4305556 0.317467 17.4333333 0.315371 17.4361111 0.313974 17.4388889 0.315371 17.4416667 0.315371 17.4444444 0.314672 17.4472222 0.314672 17.4500000 0.313974 17.4527778 0.313275 17.4555556 0.313974 17.4583333 0.313974 17.4611111 0.317467 17.4638889 0.316769 17.4666667 0.314672 17.4694444 0.313974 17.4722222 0.314672 17.4750000 0.316769 17.4777778 0.319563 17.4805556 0.319563 17.4833333 0.317467 17.4861111 0.317467 17.4888889 0.318865 17.4916667 0.318166 17.4944444 0.319563 17.4972222 0.318166 17.5000000 0.316769 17.5027778 0.318166 17.5055556 0.318865 17.5083333 0.320262 17.5111111 0.321659 17.5138889 0.323755 17.5166667 0.322358 17.5194444 0.322358 17.5222222 0.323755 17.5250000 0.325852 17.5277778 0.328646 17.5305556 0.327948 17.5333333 0.327948 17.5361111 0.327249 17.5388889 0.328646 17.5416667 0.330742 17.5444444 0.332838 17.5472222 0.332838 17.5500000 0.330742 17.5527778 0.328646 17.5555556 0.330044 17.5583333 0.333537 17.5611111 0.334934 17.5638889 0.336332 17.5666667 0.334934 17.5694444 0.336332 17.5722222 0.335633 17.5750000 0.338428 17.5777778 0.338428 17.5805556 0.336332 17.5833333 0.333537 17.5861111 0.329345 17.5888889 0.329345 17.5916667 0.327249 17.5944444 0.326550 17.5972222 0.326550 17.6000000 0.327948 17.6027778 0.329345 17.6055556 0.328646 17.6083333 0.325852 17.6111111 0.323057 17.6138889 0.318865 17.6166667 0.320961 17.6194444 0.319563 17.6222222 0.317467 17.6250000 0.313974 17.6277778 0.309782 17.6305556 0.300000 17.6333333 0.287424 17.6361111 0.275546 17.6388889 0.265764 17.6416667 0.254585 17.6444444 0.245502 17.6472222 0.229432 17.6500000 0.210568 17.6527778 0.197991 17.6555556 0.189607 17.6583333 0.188908 17.6611111 0.186114 17.6638889 0.184017 17.6666667 0.182620 17.6694444 0.181921 17.6722222 0.184716 17.6750000 0.190306 17.6777778 0.197991 17.6805556 0.204978 17.6833333 0.209869 17.6861111 0.214061 17.6888889 0.216856 17.6916667 0.216856 17.6944444 0.214061 17.6972222 0.209170 17.7000000 0.202183 17.7027778 0.199389 17.7055556 0.194498 17.7083333 0.192402 17.7111111 0.188908 17.7138889 0.186114 17.7166667 0.182620 17.7194444 0.183319 17.7222222 0.184017 17.7250000 0.185415 17.7277778 0.186812 17.7305556 0.185415 17.7333333 0.182620 17.7361111 0.181223 17.7388889 0.181921 17.7416667 0.183319 17.7444444 0.184017 17.7472222 0.183319 17.7500000 0.181223 17.7527778 0.180524 17.7555556 0.181921 17.7583333 0.183319 17.7611111 0.185415 17.7638889 0.184017 17.7666667 0.182620 17.7694444 0.181921 17.7722222 0.182620 17.7750000 0.186114 17.7777778 0.186114 17.7805556 0.184716 17.7833333 0.184017 17.7861111 0.184716 17.7888889 0.186114 17.7916667 0.187511 17.7944444 0.187511 17.7972222 0.187511 17.8000000 0.185415 17.8027778 0.185415 17.8055556 0.187511 17.8083333 0.188908 17.8111111 0.191004 17.8138889 0.191004 17.8166667 0.188908 17.8194444 0.190306 17.8222222 0.192402 17.8250000 0.192402 17.8277778 0.194498 17.8305556 0.193799 17.8333333 0.191703 17.8361111 0.193799 17.8388889 0.197293 17.8416667 0.200087 17.8444444 0.200786 17.8472222 0.200786 17.8500000 0.198690 17.8527778 0.198690 17.8555556 0.200786 17.8583333 0.203581 17.8611111 0.203581 17.8638889 0.206376 17.8666667 0.204978 17.8694444 0.207773 17.8722222 0.209869 17.8750000 0.214061 17.8777778 0.215459 17.8805556 0.216856 17.8833333 0.214061 17.8861111 0.214760 17.8888889 0.218253 17.8916667 0.221747 17.8944444 0.223843 17.8972222 0.223144 17.9000000 0.223144 17.9027778 0.221048 17.9055556 0.225240 17.9083333 0.225939 17.9111111 0.228035 17.9138889 0.228734 17.9166667 0.229432 17.9194444 0.228035 17.9222222 0.228734 17.9250000 0.228734 17.9277778 0.229432 17.9305556 0.230131 17.9333333 0.231528 17.9361111 0.231528 17.9388889 0.235022 17.9416667 0.237817 17.9444444 0.239214 17.9472222 0.242009 17.9500000 0.240611 17.9527778 0.241310 17.9555556 0.240611 17.9583333 0.244105 17.9641111 0.300000 18.8831111 0.300000 18.8861111 0.294410 18.8888889 0.297205 18.8916667 0.296507 18.8944444 0.297904 18.8972222 0.295109 18.9000000 0.296507 18.9027778 0.294410 18.9055556 0.295808 18.9083333 0.296507 18.9111111 0.295808 18.9138889 0.296507 18.9166667 0.293712 18.9194444 0.293712 18.9222222 0.293712 18.9250000 0.295109 18.9277778 0.296507 18.9305556 0.295808 18.9333333 0.296507 18.9361111 0.295808 18.9388889 0.296507 18.9416667 0.297904 18.9444444 0.299301 18.9472222 0.296507 18.9500000 0.294410 18.9527778 0.293712 18.9555556 0.294410 18.9583333 0.295109 18.9611111 0.297205 18.9638889 0.295808 18.9666667 0.293712 18.9694444 0.292314 18.9722222 0.292314 18.9750000 0.295109 18.9777778 0.296507 18.9805556 0.296507 18.9833333 0.295808 18.9861111 0.293013 18.9888889 0.294410 18.9916667 0.294410 18.9944444 0.297904 18.9972222 0.297205 19.0000000 0.295109 19.0027778 0.293712 19.0055556 0.295808 19.0083333 0.297205 19.0111111 0.298603 19.0138889 0.297904 19.0166667 0.295808 19.0194444 0.294410 19.0222222 0.296507 19.0250000 0.295808 19.0277778 0.297904 19.0305556 0.296507 19.0333333 0.292314 19.0361111 0.292314 19.0388889 0.290917 19.0416667 0.295808 19.0444444 0.295109 19.0472222 0.294410 19.0500000 0.296507 19.0527778 0.296507 19.0555556 0.298603 19.0583333 0.300699 19.0611111 0.300699 19.0638889 0.300699 19.0666667 0.299301 19.0694444 0.299301 19.0722222 0.299301 19.0750000 0.299301 19.0777778 0.300000 19.0805556 0.295808 19.0833333 0.292314 19.0861111 0.288821 19.0888889 0.288122 19.0916667 0.290218 19.0944444 0.290218 19.0972222 0.289520 19.1000000 0.289520 19.1027778 0.295808 19.1055556 0.307686 19.1083333 0.321659 19.1111111 0.334236 19.1138889 0.345415 19.1166667 0.354498 19.1194444 0.357293 19.1222222 0.360786 19.1250000 0.369869 19.1277778 0.385240 19.1305556 0.402009 19.1333333 0.415284 19.1361111 0.415983 19.1388889 0.411790 19.1416667 0.406900 19.1444444 0.398515 19.1472222 0.389432 19.1500000 0.376856 19.1527778 0.361485 19.1555556 0.341921 19.1583333 0.318166 19.1611111 0.297904 19.1638889 0.286026 19.1666667 0.277642 19.1694444 0.277642 19.1722222 0.277642 19.1750000 0.276943 19.1777778 0.271354 19.1805556 0.265764 19.1833333 0.262969 19.1861111 0.266463 19.1888889 0.273450 19.1916667 0.277642 19.1944444 0.281834 19.1972222 0.288821 19.2000000 0.294410 19.2027778 0.295808 19.2055556 0.300000 19.2083333 0.299301 19.2111111 0.297205 19.2138889 0.289520 19.2166667 0.286725 19.2194444 0.283930 19.2222222 0.286026 19.2250000 0.286725 19.2277778 0.288821 19.2305556 0.288122 19.2333333 0.286725 19.2361111 0.286026 19.2388889 0.286725 19.2416667 0.287424 19.2444444 0.289520 19.2472222 0.287424 19.2500000 0.287424 19.2527778 0.284629 19.2555556 0.286725 19.2583333 0.288122 19.2611111 0.288122 19.2638889 0.286725 19.2666667 0.285328 19.2694444 0.284629 19.2722222 0.286026 19.2750000 0.289520 19.2777778 0.288821 19.2805556 0.288821 19.2833333 0.286725 19.2861111 0.286725 19.2888889 0.287424 19.2916667 0.289520 19.2944444 0.289520 19.2972222 0.288122 19.3000000 0.288122 19.3027778 0.286725 19.3055556 0.288821 19.3083333 0.290218 19.3111111 0.291616 19.3138889 0.289520 19.3166667 0.288821 19.3194444 0.288122 19.3222222 0.287424 19.3250000 0.288821 19.3277778 0.290218 19.3305556 0.291616 19.3333333 0.288821 19.3361111 0.288821 19.3388889 0.292314 19.3416667 0.294410 19.3444444 0.294410 19.3472222 0.295109 19.3500000 0.294410 19.3527778 0.294410 19.3555556 0.295808 19.3583333 0.297205 19.3611111 0.297205 19.3638889 0.297205 19.3666667 0.296507 19.3694444 0.296507 19.3722222 0.297904 19.3750000 0.300000 19.3777778 0.301397 19.3805556 0.298603 19.3833333 0.297205 19.3861111 0.298603 19.3888889 0.297904 19.3916667 0.302096 19.3944444 0.302795 19.3972222 0.302795 19.4000000 0.303493 19.4027778 0.302795 19.4055556 0.305590 19.4083333 0.307686 19.4111111 0.307686 19.4138889 0.309083 19.4166667 0.306288 19.4194444 0.306987 19.4222222 0.309083 19.4250000 0.311179 19.4277778 0.311179 19.4305556 0.309083 19.4333333 0.308384 19.4391111 0.300000 19.5831111 0.300000 19.5861111 0.321659 19.5888889 0.325153 19.5916667 0.324454 19.5944444 0.326550 19.5972222 0.325153 19.6000000 0.321659 19.6027778 0.320262 19.6055556 0.321659 19.6083333 0.323755 19.6111111 0.323057 19.6138889 0.321659 19.6166667 0.320961 19.6194444 0.318865 19.6222222 0.320262 19.6250000 0.321659 19.6277778 0.323755 19.6305556 0.323755 19.6333333 0.323057 19.6361111 0.320961 19.6388889 0.320961 19.6416667 0.322358 19.6444444 0.321659 19.6472222 0.320262 19.6500000 0.319563 19.6527778 0.321659 19.6555556 0.322358 19.6583333 0.324454 19.6611111 0.325153 19.6638889 0.324454 19.6666667 0.321659 19.6694444 0.321659 19.6722222 0.323057 19.6750000 0.325153 19.6777778 0.326550 19.6805556 0.325153 19.6833333 0.324454 19.6861111 0.324454 19.6888889 0.327948 19.6916667 0.330044 19.6944444 0.330742 19.6972222 0.330742 19.7000000 0.327249 19.7027778 0.327948 19.7055556 0.332140 19.7083333 0.333537 19.7111111 0.334934 19.7138889 0.332838 19.7166667 0.333537 19.7194444 0.333537 19.7222222 0.334934 19.7250000 0.335633 19.7277778 0.336332 19.7305556 0.335633 19.7333333 0.334934 19.7361111 0.337729 19.7388889 0.338428 19.7416667 0.342620 19.7444444 0.344716 19.7472222 0.341921 19.7500000 0.339825 19.7527778 0.341921 19.7555556 0.339127 19.7583333 0.337729 19.7611111 0.334934 19.7638889 0.334934 19.7666667 0.331441 19.7694444 0.330044 19.7722222 0.336332 19.7750000 0.340524 19.7777778 0.341921 19.7805556 0.339127 19.7833333 0.338428 19.7861111 0.334934 19.7888889 0.336332 19.7916667 0.337729 19.7944444 0.334934 19.7972222 0.331441 19.8000000 0.324454 19.8027778 0.318166 19.8055556 0.309083 19.8083333 0.300699 19.8111111 0.287424 19.8138889 0.270655 19.8166667 0.256681 19.8194444 0.242707 19.8222222 0.229432 19.8250000 0.218952 19.8277778 0.206376 19.8305556 0.196594 19.8333333 0.188210 19.8361111 0.180524 19.8388889 0.176332 19.8416667 0.177729 19.8444444 0.182620 19.8472222 0.184017 19.8500000 0.188210 19.8527778 0.196594 19.8555556 0.207773 19.8583333 0.216856 19.8611111 0.224541 19.8638889 0.228035 19.8666667 0.230131 19.8694444 0.230830 19.8722222 0.231528 19.8750000 0.230131 19.8777778 0.230131 19.8805556 0.226638 19.8833333 0.219651 19.8861111 0.213362 19.8888889 0.209869 19.8916667 0.208472 19.8944444 0.207773 19.8972222 0.203581 19.9000000 0.198690 19.9027778 0.199389 19.9055556 0.200786 19.9083333 0.201485 19.9111111 0.202882 19.9138889 0.202882 19.9166667 0.200786 19.9194444 0.200786 19.9222222 0.200786 19.9250000 0.201485 19.9277778 0.200786 19.9305556 0.200786 19.9333333 0.199389 19.9361111 0.198690 19.9388889 0.200087 19.9416667 0.204279 19.9444444 0.203581 19.9472222 0.202882 19.9500000 0.200087 19.9527778 0.201485 19.9555556 0.202882 19.9583333 0.202882 19.9611111 0.203581 19.9638889 0.202183 19.9666667 0.201485 19.9694444 0.201485 19.9722222 0.202183 19.9750000 0.206376 19.9777778 0.207773 19.9805556 0.207074 19.9833333 0.204978 19.9861111 0.205677 19.9888889 0.207773 19.9916667 0.210568 19.9944444 0.210568 19.9972222 0.211266 20.0000000 0.209869 20.0027778 0.210568 20.0055556 0.211965 20.0083333 0.214061 20.0111111 0.214760 20.0138889 0.215459 20.0166667 0.213362 20.0194444 0.213362 20.0222222 0.213362 20.0250000 0.217555 20.0277778 0.218952 20.0305556 0.220349 20.0333333 0.219651 20.0361111 0.218253 20.0388889 0.221747 20.0416667 0.225939 20.0444444 0.224541 20.0472222 0.223843 20.0500000 0.224541 20.0527778 0.226638 20.0555556 0.228734 20.0583333 0.230830 20.0611111 0.232926 20.0638889 0.232227 20.0666667 0.232926 20.0694444 0.231528 20.0722222 0.233624 20.0750000 0.236419 20.0777778 0.236419 20.0805556 0.235721 20.0833333 0.233624 20.0861111 0.235721 20.0888889 0.237817 20.0916667 0.240611 20.0944444 0.242009 20.0972222 0.243406 20.1000000 0.244803 20.1027778 0.246900 20.1055556 0.250393 20.1083333 0.253188 20.1111111 0.253188 20.1138889 0.253188 20.1166667 0.253188 20.1194444 0.253188 20.1222222 0.255284 20.1250000 0.258777 20.1277778 0.260175 20.1305556 0.257380 20.1333333 0.258777 20.1391111 0.300000 20.9970000 0.300000 21.0000000 0.304891 21.0027778 0.304891 21.0055556 0.306987 21.0083333 0.306987 21.0111111 0.305590 21.0138889 0.306288 21.0166667 0.304192 21.0194444 0.304891 21.0222222 0.306288 21.0250000 0.306288 21.0277778 0.306288 21.0305556 0.304891 21.0333333 0.302795 21.0361111 0.302795 21.0388889 0.303493 21.0416667 0.306288 21.0444444 0.305590 21.0472222 0.305590 21.0500000 0.304192 21.0527778 0.304192 21.0555556 0.306987 21.0583333 0.309083 21.0611111 0.308384 21.0638889 0.306288 21.0666667 0.304891 21.0694444 0.302096 21.0722222 0.304891 21.0750000 0.306288 21.0777778 0.305590 21.0805556 0.304192 21.0833333 0.302795 21.0861111 0.303493 21.0888889 0.304891 21.0916667 0.306288 21.0944444 0.304891 21.0972222 0.304192 21.1000000 0.303493 21.1027778 0.304192 21.1055556 0.304192 21.1083333 0.308384 21.1111111 0.306987 21.1138889 0.305590 21.1166667 0.304891 21.1194444 0.304192 21.1222222 0.306987 21.1250000 0.307686 21.1277778 0.307686 21.1305556 0.306288 21.1333333 0.304891 21.1361111 0.304891 21.1388889 0.305590 21.1416667 0.308384 21.1444444 0.304891 21.1472222 0.305590 21.1500000 0.302795 21.1527778 0.301397 21.1555556 0.303493 21.1583333 0.306288 21.1611111 0.306987 21.1638889 0.304891 21.1666667 0.304192 21.1694444 0.304891 21.1722222 0.306987 21.1750000 0.306987 21.1777778 0.306288 21.1805556 0.304891 21.1833333 0.304891 21.1861111 0.304891 21.1888889 0.306288 21.1916667 0.310480 21.1944444 0.308384 21.1972222 0.308384 21.2000000 0.305590 21.2027778 0.300699 21.2055556 0.300000 21.2083333 0.301397 21.2111111 0.302096 21.2138889 0.300699 21.2166667 0.302795 21.2194444 0.307686 21.2222222 0.320961 21.2250000 0.338428 21.2277778 0.351004 21.2305556 0.362183 21.2333333 0.365677 21.2361111 0.368472 21.2388889 0.376856 21.2416667 0.388035 21.2444444 0.404803 21.2472222 0.415284 21.2500000 0.418777 21.2527778 0.414585 21.2555556 0.408996 21.2583333 0.403406 21.2611111 0.395721 21.2638889 0.381747 21.2666667 0.364279 21.2694444 0.340524 21.2722222 0.318166 21.2750000 0.302795 21.2777778 0.293712 21.2805556 0.293013 21.2833333 0.290218 21.2861111 0.288122 21.2888889 0.288122 21.2916667 0.283231 21.2944444 0.280437 21.2972222 0.278341 21.3000000 0.281834 21.3027778 0.285328 21.3055556 0.288821 21.3083333 0.296507 21.3111111 0.302096 21.3138889 0.305590 21.3166667 0.306987 21.3194444 0.306987 21.3222222 0.305590 21.3250000 0.303493 21.3277778 0.300000 21.3305556 0.295808 21.3333333 0.292314 21.3361111 0.293712 21.3388889 0.293712 21.3416667 0.295109 21.3444444 0.294410 21.3472222 0.291616 21.3500000 0.291616 21.3527778 0.290917 21.3555556 0.293013 21.3583333 0.295808 21.3611111 0.293013 21.3638889 0.292314 21.3666667 0.290218 21.3694444 0.290917 21.3722222 0.293712 21.3750000 0.293712 21.3777778 0.295109 21.3805556 0.293712 21.3833333 0.293712 21.3861111 0.293712 21.3888889 0.295808 21.3916667 0.297205 21.3944444 0.297205 21.3972222 0.295109 21.4000000 0.294410 21.4027778 0.293712 21.4055556 0.295109 21.4083333 0.295808 21.4111111 0.295808 21.4138889 0.295109 21.4166667 0.294410 21.4194444 0.291616 21.4222222 0.293712 21.4250000 0.296507 21.4277778 0.297205 21.4305556 0.295808 21.4333333 0.294410 21.4361111 0.295808 21.4388889 0.296507 21.4416667 0.298603 21.4444444 0.299301 21.4472222 0.297904 21.4500000 0.297904 21.4527778 0.298603 21.4555556 0.300000 21.4583333 0.302795 21.4611111 0.302096 21.4638889 0.300000 21.4666667 0.298603 21.4694444 0.298603 21.4722222 0.298603 21.4750000 0.303493 21.4777778 0.302096 21.4805556 0.301397 21.4833333 0.302096 21.4861111 0.302096 21.4888889 0.305590 21.4916667 0.306987 21.4944444 0.306987 21.4972222 0.307686 21.5000000 0.306288 21.5027778 0.306987 21.5055556 0.310480 21.5083333 0.310480 21.5111111 0.313275 21.5138889 0.311878 21.5166667 0.311878 21.5194444 0.311179 21.5222222 0.313275 21.5250000 0.314672 21.5277778 0.315371 21.5305556 0.312576 21.5333333 0.313275 21.5361111 0.313275 21.5388889 0.315371 21.5416667 0.317467 21.5444444 0.319563 21.5472222 0.318865 21.5530000 0.300000 21.6553333 0.300000 21.6583333 0.327948 21.6611111 0.329345 21.6638889 0.328646 21.6666667 0.327948 21.6694444 0.327249 21.6722222 0.329345 21.6750000 0.331441 21.6777778 0.330742 21.6805556 0.327948 21.6833333 0.325153 21.6861111 0.324454 21.6888889 0.325852 21.6916667 0.328646 21.6944444 0.328646 21.6972222 0.323057 21.7000000 0.323057 21.7027778 0.323755 21.7055556 0.325852 21.7083333 0.328646 21.7111111 0.328646 21.7138889 0.327249 21.7166667 0.325153 21.7194444 0.324454 21.7222222 0.327249 21.7250000 0.329345 21.7277778 0.330044 21.7305556 0.325852 21.7333333 0.326550 21.7361111 0.328646 21.7388889 0.328646 21.7416667 0.332140 21.7444444 0.331441 21.7472222 0.329345 21.7500000 0.329345 21.7527778 0.332140 21.7555556 0.334236 21.7583333 0.334934 21.7611111 0.334236 21.7638889 0.334934 21.7666667 0.333537 21.7694444 0.336332 21.7722222 0.337729 21.7750000 0.339825 21.7777778 0.339825 21.7805556 0.339127 21.7833333 0.339825 21.7861111 0.339127 21.7888889 0.341223 21.7916667 0.343319 21.7944444 0.342620 21.7972222 0.340524 21.8000000 0.339825 21.8027778 0.339825 21.8055556 0.343319 21.8083333 0.343319 21.8111111 0.346812 21.8138889 0.346114 21.8166667 0.348210 21.8194444 0.347511 21.8222222 0.348908 21.8250000 0.351004 21.8277778 0.352402 21.8305556 0.348908 21.8333333 0.347511 21.8361111 0.346812 21.8388889 0.345415 21.8416667 0.346812 21.8444444 0.349607 21.8472222 0.346812 21.8500000 0.344017 21.8527778 0.344017 21.8555556 0.344017 21.8583333 0.341223 21.8611111 0.337729 21.8638889 0.332140 21.8666667 0.330044 21.8694444 0.329345 21.8722222 0.327249 21.8750000 0.321659 21.8777778 0.311878 21.8805556 0.300699 21.8833333 0.288122 21.8861111 0.275546 21.8888889 0.265764 21.8916667 0.260873 21.8944444 0.251092 21.8972222 0.238515 21.9000000 0.222445 21.9027778 0.209170 21.9055556 0.202882 21.9083333 0.202882 21.9111111 0.204978 21.9138889 0.202183 21.9166667 0.203581 21.9194444 0.209869 21.9222222 0.214760 21.9250000 0.217555 21.9277778 0.219651 21.9305556 0.221048 21.9333333 0.222445 21.9361111 0.228734 21.9388889 0.232227 21.9416667 0.237817 21.9444444 0.237118 21.9472222 0.235022 21.9500000 0.228035 21.9527778 0.224541 21.9555556 0.217555 21.9583333 0.214760 21.9611111 0.210568 21.9638889 0.207074 21.9666667 0.202183 21.9694444 0.200786 21.9722222 0.200087 21.9750000 0.200786 21.9777778 0.200087 21.9805556 0.199389 21.9833333 0.197991 21.9861111 0.197991 21.9888889 0.200087 21.9916667 0.200786 21.9944444 0.200087 21.9972222 0.198690 22.0000000 0.196594 22.0027778 0.197293 22.0055556 0.196594 22.0083333 0.199389 22.0111111 0.199389 22.0138889 0.198690 22.0166667 0.196594 22.0194444 0.197293 22.0222222 0.197293 22.0250000 0.200087 22.0277778 0.200087 22.0305556 0.199389 22.0333333 0.199389 22.0361111 0.199389 22.0388889 0.202183 22.0416667 0.203581 22.0444444 0.204279 22.0472222 0.202882 22.0500000 0.202183 22.0527778 0.200786 22.0555556 0.204978 22.0583333 0.207074 22.0611111 0.207074 22.0638889 0.207074 22.0666667 0.207074 22.0694444 0.207074 22.0722222 0.209869 22.0750000 0.210568 22.0777778 0.211965 22.0805556 0.209869 22.0833333 0.209869 22.0861111 0.210568 22.0888889 0.214061 22.0916667 0.216856 22.0944444 0.218253 22.0972222 0.216856 22.1000000 0.216157 22.1027778 0.216157 22.1055556 0.221048 22.1083333 0.221747 22.1111111 0.223843 22.1138889 0.223843 22.1166667 0.221747 22.1194444 0.221048 22.1222222 0.225240 22.1250000 0.226638 22.1277778 0.228734 22.1305556 0.226638 22.1333333 0.226638 22.1361111 0.228035 22.1388889 0.230131 22.1416667 0.233624 22.1444444 0.233624 22.1472222 0.232926 22.1500000 0.231528 22.1527778 0.233624 22.1555556 0.236419 22.1583333 0.239214 22.1611111 0.241310 22.1638889 0.239913 22.1666667 0.239913 22.1694444 0.240611 22.1722222 0.242707 22.1750000 0.244803 22.1777778 0.245502 22.1805556 0.245502 22.1833333 0.244803 22.1861111 0.246900 22.1888889 0.246900 22.1916667 0.251790 22.1944444 0.251790 22.1972222 0.251092 22.2000000 0.250393 22.2027778 0.251790 22.2055556 0.255983 22.2113333 0.300000 23.0442222 0.300000 23.0472222 0.298603 23.0500000 0.297904 23.0527778 0.297205 23.0555556 0.297205 23.0583333 0.299301 23.0611111 0.299301 23.0638889 0.297205 23.0666667 0.296507 23.0694444 0.299301 23.0722222 0.299301 23.0750000 0.300000 23.0777778 0.300000 23.0805556 0.299301 23.0833333 0.300000 23.0861111 0.300699 23.0888889 0.302096 23.0916667 0.302795 23.0944444 0.301397 23.0972222 0.302096 23.1000000 0.300699 23.1027778 0.299301 23.1055556 0.300699 23.1083333 0.301397 23.1111111 0.300699 23.1138889 0.297904 23.1166667 0.296507 23.1194444 0.299301 23.1222222 0.301397 23.1250000 0.302795 23.1277778 0.301397 23.1305556 0.298603 23.1333333 0.299301 23.1361111 0.301397 23.1388889 0.302795 23.1416667 0.304192 23.1444444 0.304192 23.1472222 0.300699 23.1500000 0.299301 23.1527778 0.300000 23.1555556 0.302096 23.1583333 0.304192 23.1611111 0.302096 23.1638889 0.301397 23.1666667 0.299301 23.1694444 0.299301 23.1722222 0.298603 23.1750000 0.302096 23.1777778 0.301397 23.1805556 0.301397 23.1833333 0.300000 23.1861111 0.302096 23.1888889 0.304192 23.1916667 0.304891 23.1944444 0.304192 23.1972222 0.302096 23.2000000 0.302795 23.2027778 0.302795 23.2055556 0.304192 23.2083333 0.305590 23.2111111 0.303493 23.2138889 0.301397 23.2166667 0.300699 23.2194444 0.302096 23.2222222 0.304192 23.2250000 0.304192 23.2277778 0.304192 23.2305556 0.301397 23.2333333 0.302096 23.2361111 0.300699 23.2388889 0.302795 23.2416667 0.304192 23.2444444 0.302795 23.2472222 0.297904 23.2500000 0.295808 23.2527778 0.294410 23.2555556 0.295808 23.2583333 0.297205 23.2611111 0.297205 23.2638889 0.299301 23.2666667 0.308384 23.2694444 0.321659 23.2722222 0.341921 23.2750000 0.354498 23.2777778 0.364279 23.2805556 0.367074 23.2833333 0.370568 23.2861111 0.375459 23.2888889 0.390830 23.2916667 0.407598 23.2944444 0.421572 23.2972222 0.420873 23.3000000 0.416681 23.3027778 0.409694 23.3055556 0.404105 23.3083333 0.397817 23.3111111 0.385939 23.3138889 0.366376 23.3166667 0.342620 23.3194444 0.319563 23.3222222 0.306987 23.3250000 0.303493 23.3277778 0.300699 23.3305556 0.297205 23.3333333 0.293712 23.3361111 0.288821 23.3388889 0.285328 23.3416667 0.285328 23.3444444 0.289520 23.3472222 0.292314 23.3500000 0.294410 23.3527778 0.297904 23.3555556 0.304891 23.3583333 0.309782 23.3611111 0.314672 23.3638889 0.315371 23.3666667 0.311179 23.3694444 0.308384 23.3722222 0.306987 23.3750000 0.304891 23.3777778 0.300699 23.3805556 0.298603 23.3833333 0.295808 23.3861111 0.297205 23.3888889 0.298603 23.3916667 0.300000 23.3944444 0.297205 23.3972222 0.295109 23.4000000 0.293013 23.4027778 0.293013 23.4055556 0.293013 23.4083333 0.296507 23.4111111 0.298603 23.4138889 0.295808 23.4166667 0.295109 23.4194444 0.295808 23.4222222 0.297205 23.4250000 0.297205 23.4277778 0.297205 23.4305556 0.295808 23.4333333 0.296507 23.4361111 0.297205 23.4388889 0.299301 23.4416667 0.299301 23.4444444 0.297904 23.4472222 0.297205 23.4500000 0.295109 23.4527778 0.296507 23.4555556 0.297205 23.4583333 0.298603 23.4611111 0.298603 23.4638889 0.296507 23.4666667 0.297205 23.4694444 0.298603 23.4722222 0.300699 23.4750000 0.301397 23.4777778 0.300699 23.4805556 0.297205 23.4833333 0.298603 23.4861111 0.300699 23.4888889 0.302096 23.4916667 0.305590 23.4944444 0.304192 23.4972222 0.303493 23.5000000 0.302795 23.5027778 0.304192 23.5055556 0.306987 23.5083333 0.306987 23.5111111 0.302795 23.5138889 0.300699 23.5166667 0.302096 23.5194444 0.302096 23.5222222 0.306288 23.5250000 0.311179 23.5277778 0.311878 23.5305556 0.309782 23.5333333 0.308384 23.5361111 0.309782 23.5388889 0.309782 23.5416667 0.311179 23.5444444 0.311179 23.5472222 0.311878 23.5500000 0.312576 23.5527778 0.314672 23.5555556 0.317467 23.5583333 0.318166 23.5611111 0.316769 23.5638889 0.315371 23.5666667 0.313275 23.5694444 0.316070 23.5722222 0.318166 23.5750000 0.320262 23.5777778 0.322358 23.5805556 0.319563 23.5833333 0.319563 23.5861111 0.320262 23.5888889 0.322358 23.5916667 0.325852 23.5944444 0.325852 23.6002222 0.300000 23.7581111 0.300000 23.7611111 0.345415 23.7638889 0.346114 23.7666667 0.344017 23.7694444 0.344716 23.7722222 0.344716 23.7750000 0.347511 23.7777778 0.346812 23.7805556 0.346812 23.7833333 0.345415 23.7861111 0.344017 23.7888889 0.344017 23.7916667 0.346114 23.7944444 0.344716 23.7972222 0.345415 23.8000000 0.342620 23.8027778 0.341223 23.8055556 0.341921 23.8083333 0.342620 23.8111111 0.343319 23.8138889 0.341223 23.8166667 0.341921 23.8194444 0.341921 23.8222222 0.347511 23.8250000 0.351004 23.8277778 0.351004 23.8305556 0.347511 23.8333333 0.344716 23.8361111 0.346114 23.8388889 0.348210 23.8416667 0.348210 23.8444444 0.348908 23.8472222 0.349607 23.8500000 0.346812 23.8527778 0.349607 23.8555556 0.350306 23.8583333 0.352402 23.8611111 0.356594 23.8638889 0.357293 23.8666667 0.355197 23.8694444 0.353799 23.8722222 0.355895 23.8750000 0.357991 23.8777778 0.358690 23.8805556 0.358690 23.8833333 0.357991 23.8861111 0.361485 23.8888889 0.364978 23.8916667 0.363581 23.8944444 0.363581 23.8972222 0.364978 23.9000000 0.366376 23.9027778 0.371965 23.9055556 0.372664 23.9083333 0.371965 23.9111111 0.371965 23.9138889 0.370568 23.9166667 0.371266 23.9194444 0.373362 23.9222222 0.376157 23.9250000 0.376157 23.9277778 0.373362 23.9305556 0.371266 23.9333333 0.371965 23.9361111 0.371266 23.9388889 0.371965 23.9416667 0.376856 23.9444444 0.374061 23.9472222 0.369170 23.9500000 0.367773 23.9527778 0.367074 23.9555556 0.369170 23.9583333 0.366376 23.9611111 0.363581 23.9638889 0.358690 23.9666667 0.353100 23.9694444 0.348210 23.9722222 0.344017 23.9750000 0.340524 23.9777778 0.332838 23.9805556 0.320262 23.9833333 0.309782 23.9861111 0.299301 23.9888889 0.288821 23.9916667 0.276943 23.9944444 0.265764 23.9972222 0.255284 24.0000000 0.243406 24.0027778 0.230131 24.0055556 0.223144 24.0083333 0.221747 24.0111111 0.218952 24.0138889 0.213362 24.0166667 0.212664 24.0194444 0.214061 24.0222222 0.217555 24.0250000 0.221048 24.0277778 0.222445 24.0305556 0.224541 24.0333333 0.230830 24.0361111 0.235721 24.0388889 0.242009 24.0416667 0.246900 24.0444444 0.243406 24.0472222 0.235721 24.0500000 0.232227 24.0527778 0.229432 24.0555556 0.228035 24.0583333 0.225939 24.0611111 0.224541 24.0638889 0.223144 24.0666667 0.218253 24.0694444 0.216157 24.0722222 0.214760 24.0750000 0.213362 24.0777778 0.209869 24.0805556 0.207074 24.0833333 0.206376 24.0861111 0.207074 24.0888889 0.210568 24.0916667 0.211965 24.0944444 0.209170 24.0972222 0.204978 24.1000000 0.203581 24.1027778 0.202882 24.1055556 0.206376 24.1083333 0.210568 24.1111111 0.211266 24.1138889 0.207773 24.1166667 0.204978 24.1194444 0.205677 24.1222222 0.207773 24.1250000 0.210568 24.1277778 0.210568 24.1305556 0.211266 24.1333333 0.209869 24.1361111 0.210568 24.1388889 0.212664 24.1416667 0.214061 24.1444444 0.214061 24.1472222 0.214760 24.1500000 0.213362 24.1527778 0.214760 24.1555556 0.218253 24.1583333 0.222445 24.1611111 0.224541 24.1638889 0.223144 24.1666667 0.221747 24.1694444 0.223144 24.1722222 0.228035 24.1750000 0.233624 24.1777778 0.234323 24.1805556 0.234323 24.1833333 0.238515 24.1861111 0.240611 24.1888889 0.245502 24.1916667 0.249694 24.1944444 0.250393 24.1972222 0.248297 24.2000000 0.248996 24.2027778 0.251092 24.2055556 0.253886 24.2083333 0.258777 24.2111111 0.260873 24.2138889 0.262271 24.2166667 0.261572 24.2194444 0.258079 24.2222222 0.261572 24.2250000 0.264367 24.2277778 0.265764 24.2305556 0.266463 24.2333333 0.269258 24.2361111 0.271354 24.2388889 0.274847 24.2416667 0.276245 24.2444444 0.278341 24.2472222 0.278341 24.2500000 0.280437 24.2527778 0.283231 24.2555556 0.286026 24.2583333 0.287424 24.2611111 0.290218 24.2638889 0.290917 24.2666667 0.291616 24.2694444 0.291616 24.2722222 0.293013 24.2750000 0.294410 24.2777778 0.295808 24.2805556 0.295808 24.2833333 0.298603 24.2861111 0.299301 24.2888889 0.302096 24.2916667 0.306987 24.2944444 0.307686 24.2972222 0.309782 24.3000000 0.311878 24.3027778 0.311878 24.3055556 0.318166 24.3083333 0.321659 24.3141111 0.300000 25.2053333 0.300000 25.2083333 0.270655 25.2111111 0.272052 25.2138889 0.272052 25.2166667 0.272052 25.2194444 0.273450 25.2222222 0.272751 25.2250000 0.274148 25.2277778 0.273450 25.2305556 0.272052 25.2333333 0.267860 25.2361111 0.269956 25.2388889 0.273450 25.2416667 0.272751 25.2444444 0.271354 25.2472222 0.268559 25.2500000 0.269956 25.2527778 0.269258 25.2555556 0.272751 25.2583333 0.274847 25.2611111 0.275546 25.2638889 0.274148 25.2666667 0.272052 25.2694444 0.273450 25.2722222 0.275546 25.2750000 0.275546 25.2777778 0.275546 25.2805556 0.274847 25.2833333 0.273450 25.2861111 0.273450 25.2888889 0.274847 25.2916667 0.276943 25.2944444 0.276245 25.2972222 0.272751 25.3000000 0.272052 25.3027778 0.272751 25.3055556 0.274148 25.3083333 0.276245 25.3111111 0.273450 25.3138889 0.275546 25.3166667 0.274847 25.3194444 0.276245 25.3222222 0.277642 25.3250000 0.279738 25.3277778 0.278341 25.3305556 0.275546 25.3333333 0.274148 25.3361111 0.276943 25.3388889 0.278341 25.3416667 0.279738 25.3444444 0.279039 25.3472222 0.277642 25.3500000 0.275546 25.3527778 0.274847 25.3555556 0.276245 25.3583333 0.277642 25.3611111 0.277642 25.3638889 0.276943 25.3666667 0.274847 25.3694444 0.275546 25.3722222 0.276943 25.3750000 0.277642 25.3777778 0.279039 25.3805556 0.277642 25.3833333 0.274847 25.3861111 0.279039 25.3888889 0.279738 25.3916667 0.281834 25.3944444 0.281135 25.3972222 0.279039 25.4000000 0.279738 25.4027778 0.281834 25.4055556 0.281135 25.4083333 0.279039 25.4111111 0.275546 25.4138889 0.270655 25.4166667 0.272751 25.4194444 0.274148 25.4222222 0.276943 25.4250000 0.282533 25.4277778 0.290917 25.4305556 0.302795 25.4333333 0.319563 25.4361111 0.331441 25.4388889 0.342620 25.4416667 0.346114 25.4444444 0.347511 25.4472222 0.351703 25.4500000 0.363581 25.4527778 0.379651 25.4555556 0.390830 25.4583333 0.393624 25.4611111 0.390131 25.4638889 0.381747 25.4666667 0.374760 25.4694444 0.367773 25.4722222 0.357293 25.4750000 0.340524 25.4777778 0.317467 25.4805556 0.296507 25.4833333 0.281834 25.4861111 0.274847 25.4888889 0.274847 25.4916667 0.272751 25.4944444 0.270655 25.4972222 0.265764 25.5000000 0.258777 25.5027778 0.255983 25.5055556 0.260873 25.5083333 0.266463 25.5111111 0.267162 25.5138889 0.269258 25.5166667 0.276943 25.5194444 0.284629 25.5222222 0.291616 25.5250000 0.292314 25.5277778 0.292314 25.5305556 0.284629 25.5333333 0.279039 25.5361111 0.278341 25.5388889 0.278341 25.5416667 0.279738 25.5444444 0.280437 25.5472222 0.279738 25.5500000 0.280437 25.5527778 0.281135 25.5555556 0.281834 25.5583333 0.282533 25.5611111 0.281834 25.5638889 0.280437 25.5666667 0.277642 25.5694444 0.281135 25.5722222 0.281834 25.5750000 0.283930 25.5777778 0.284629 25.5805556 0.283231 25.5833333 0.281834 25.5861111 0.281135 25.5888889 0.282533 25.5916667 0.283930 25.5944444 0.283930 25.5972222 0.282533 25.6000000 0.283930 25.6027778 0.284629 25.6055556 0.286026 25.6083333 0.286026 25.6111111 0.284629 25.6138889 0.286725 25.6166667 0.285328 25.6194444 0.288122 25.6222222 0.289520 25.6250000 0.291616 25.6277778 0.292314 25.6305556 0.293712 25.6333333 0.291616 25.6361111 0.290917 25.6388889 0.290218 25.6416667 0.290218 25.6444444 0.292314 25.6472222 0.292314 25.6500000 0.294410 25.6527778 0.296507 25.6555556 0.299301 25.6583333 0.298603 25.6611111 0.297904 25.6638889 0.298603 25.6666667 0.297205 25.6694444 0.300000 25.6722222 0.301397 25.6750000 0.305590 25.6777778 0.305590 25.6805556 0.304891 25.6833333 0.304891 25.6861111 0.306987 25.6888889 0.308384 25.6916667 0.309782 25.6944444 0.309083 25.6972222 0.310480 25.7000000 0.309782 25.7027778 0.311179 25.7055556 0.313974 25.7083333 0.316070 25.7111111 0.317467 25.7138889 0.316769 25.7166667 0.317467 25.7194444 0.320961 25.7222222 0.322358 25.7250000 0.324454 25.7277778 0.325852 25.7305556 0.323755 25.7333333 0.325153 25.7361111 0.326550 25.7388889 0.330044 25.7416667 0.331441 25.7444444 0.331441 25.7472222 0.330742 25.7500000 0.330742 25.7527778 0.332140 25.7555556 0.334934 25.7613333 0.300000 25.8942222 0.300000 25.8972222 0.350306 25.9000000 0.348908 25.9027778 0.347511 25.9055556 0.348908 25.9083333 0.349607 25.9111111 0.348908 25.9138889 0.348210 25.9166667 0.351004 25.9194444 0.350306 25.9222222 0.351004 25.9250000 0.349607 25.9277778 0.347511 25.9305556 0.348210 25.9333333 0.347511 25.9361111 0.348210 25.9388889 0.347511 25.9416667 0.348908 25.9444444 0.351004 25.9472222 0.349607 25.9500000 0.349607 25.9527778 0.349607 25.9555556 0.351703 25.9583333 0.353100 25.9611111 0.351703 25.9638889 0.351004 25.9666667 0.350306 25.9694444 0.351703 25.9722222 0.355197 25.9750000 0.357293 25.9777778 0.356594 25.9805556 0.353799 25.9833333 0.351703 25.9861111 0.353100 25.9888889 0.354498 25.9916667 0.355197 25.9944444 0.357991 25.9972222 0.357293 26.0000000 0.358690 26.0027778 0.362183 26.0055556 0.366376 26.0083333 0.369170 26.0111111 0.371965 26.0138889 0.371266 26.0166667 0.371266 26.0194444 0.372664 26.0222222 0.378952 26.0250000 0.381048 26.0277778 0.381048 26.0305556 0.379651 26.0333333 0.378253 26.0361111 0.381048 26.0388889 0.383843 26.0416667 0.385939 26.0444444 0.385939 26.0472222 0.385939 26.0500000 0.385939 26.0527778 0.388035 26.0555556 0.390131 26.0583333 0.392926 26.0611111 0.392926 26.0638889 0.392227 26.0666667 0.389432 26.0694444 0.389432 26.0722222 0.390131 26.0750000 0.391528 26.0777778 0.392926 26.0805556 0.393624 26.0833333 0.395721 26.0861111 0.397118 26.0888889 0.398515 26.0916667 0.399913 26.0944444 0.402707 26.0972222 0.404803 26.1000000 0.402707 26.1027778 0.402009 26.1055556 0.399913 26.1083333 0.397118 26.1111111 0.392926 26.1138889 0.384541 26.1166667 0.377555 26.1194444 0.369170 26.1222222 0.360786 26.1250000 0.348210 26.1277778 0.334236 26.1305556 0.322358 26.1333333 0.312576 26.1361111 0.301397 26.1388889 0.291616 26.1416667 0.279039 26.1444444 0.269258 26.1472222 0.262969 26.1500000 0.260873 26.1527778 0.263668 26.1555556 0.265066 26.1583333 0.267860 26.1611111 0.271354 26.1638889 0.279738 26.1666667 0.285328 26.1694444 0.286725 26.1722222 0.287424 26.1750000 0.286026 26.1777778 0.281135 26.1805556 0.273450 26.1833333 0.267860 26.1861111 0.262271 26.1888889 0.259476 26.1916667 0.260175 26.1944444 0.258079 26.1972222 0.253188 26.2000000 0.248297 26.2027778 0.249694 26.2055556 0.251092 26.2083333 0.252489 26.2111111 0.253188 26.2138889 0.249694 26.2166667 0.247598 26.2194444 0.246900 26.2222222 0.246900 26.2250000 0.246900 26.2277778 0.246900 26.2305556 0.245502 26.2333333 0.244105 26.2361111 0.243406 26.2388889 0.244803 26.2416667 0.242707 26.2444444 0.242009 26.2472222 0.239913 26.2500000 0.239214 26.2527778 0.239913 26.2555556 0.242009 26.2583333 0.242009 26.2611111 0.239214 26.2638889 0.237118 26.2666667 0.233624 26.2694444 0.235022 26.2722222 0.234323 26.2750000 0.235022 26.2777778 0.235721 26.2805556 0.234323 26.2833333 0.235022 26.2861111 0.234323 26.2888889 0.234323 26.2916667 0.236419 26.2944444 0.237118 26.2972222 0.235721 26.3000000 0.235721 26.3027778 0.236419 26.3055556 0.235721 26.3083333 0.237118 26.3111111 0.237817 26.3138889 0.235022 26.3166667 0.235721 26.3194444 0.237817 26.3222222 0.241310 26.3250000 0.239913 26.3277778 0.237817 26.3305556 0.236419 26.3333333 0.238515 26.3361111 0.238515 26.3388889 0.239913 26.3416667 0.242009 26.3444444 0.244105 26.3472222 0.242009 26.3500000 0.242707 26.3527778 0.245502 26.3555556 0.248297 26.3583333 0.248996 26.3611111 0.249694 26.3638889 0.249694 26.3666667 0.248297 26.3694444 0.248297 26.3722222 0.250393 26.3750000 0.250393 26.3777778 0.250393 26.3805556 0.251092 26.3833333 0.250393 26.3861111 0.251790 26.3888889 0.255284 26.3916667 0.257380 26.3944444 0.255284 26.3972222 0.255284 26.4000000 0.256681 26.4027778 0.258079 26.4055556 0.260175 26.4083333 0.260873 26.4111111 0.262969 26.4138889 0.260873 26.4166667 0.262969 26.4194444 0.264367 26.4222222 0.266463 26.4250000 0.272052 26.4277778 0.271354 26.4305556 0.271354 26.4333333 0.269956 26.4361111 0.271354 26.4388889 0.273450 26.4416667 0.273450 26.4444444 0.274148 26.4502222 0.300000 27.2442222 0.300000 27.2472222 0.290917 27.2500000 0.289520 27.2527778 0.292314 27.2555556 0.292314 27.2583333 0.294410 27.2611111 0.292314 27.2638889 0.292314 27.2666667 0.290218 27.2694444 0.290917 27.2722222 0.291616 27.2750000 0.290917 27.2777778 0.289520 27.2805556 0.288821 27.2833333 0.288821 27.2861111 0.289520 27.2888889 0.292314 27.2916667 0.294410 27.2944444 0.293013 27.2972222 0.291616 27.3000000 0.291616 27.3027778 0.291616 27.3055556 0.295109 27.3083333 0.295808 27.3111111 0.295109 27.3138889 0.292314 27.3166667 0.292314 27.3194444 0.293013 27.3222222 0.294410 27.3250000 0.293013 27.3277778 0.291616 27.3305556 0.292314 27.3333333 0.290917 27.3361111 0.293013 27.3388889 0.293013 27.3416667 0.297205 27.3444444 0.295808 27.3472222 0.296507 27.3500000 0.294410 27.3527778 0.296507 27.3555556 0.297205 27.3583333 0.297205 27.3611111 0.297205 27.3638889 0.295808 27.3666667 0.295808 27.3694444 0.297904 27.3722222 0.297205 27.3750000 0.300000 27.3777778 0.295808 27.3805556 0.293712 27.3833333 0.295808 27.3861111 0.297205 27.3888889 0.298603 27.3916667 0.299301 27.3944444 0.297904 27.3972222 0.297205 27.4000000 0.297904 27.4027778 0.298603 27.4055556 0.301397 27.4083333 0.302096 27.4111111 0.300699 27.4138889 0.300000 27.4166667 0.299301 27.4194444 0.299301 27.4222222 0.302096 27.4250000 0.302096 27.4277778 0.300699 27.4305556 0.299301 27.4333333 0.297904 27.4361111 0.297904 27.4388889 0.300699 27.4416667 0.299301 27.4444444 0.297904 27.4472222 0.295109 27.4500000 0.289520 27.4527778 0.290917 27.4555556 0.292314 27.4583333 0.295109 27.4611111 0.297205 27.4638889 0.297205 27.4666667 0.304192 27.4694444 0.318865 27.4722222 0.334236 27.4750000 0.348908 27.4777778 0.355197 27.4805556 0.359389 27.4833333 0.360786 27.4861111 0.368472 27.4888889 0.379651 27.4916667 0.392227 27.4944444 0.399913 27.4972222 0.398515 27.5000000 0.392227 27.5027778 0.387336 27.5055556 0.382445 27.5083333 0.374061 27.5111111 0.363581 27.5138889 0.346114 27.5166667 0.326550 27.5194444 0.311878 27.5222222 0.302096 27.5250000 0.295808 27.5277778 0.293013 27.5305556 0.288821 27.5333333 0.284629 27.5361111 0.281834 27.5388889 0.278341 27.5416667 0.276943 27.5444444 0.278341 27.5472222 0.279738 27.5500000 0.281834 27.5527778 0.288821 27.5555556 0.295808 27.5583333 0.300699 27.5611111 0.303493 27.5638889 0.301397 27.5666667 0.300699 27.5694444 0.297205 27.5722222 0.295808 27.5750000 0.295109 27.5777778 0.290917 27.5805556 0.289520 27.5833333 0.290218 27.5861111 0.291616 27.5888889 0.294410 27.5916667 0.292314 27.5944444 0.292314 27.5972222 0.288122 27.6000000 0.288821 27.6027778 0.288122 27.6055556 0.288821 27.6083333 0.288122 27.6111111 0.287424 27.6138889 0.286725 27.6166667 0.285328 27.6194444 0.286026 27.6222222 0.288821 27.6250000 0.288821 27.6277778 0.287424 27.6305556 0.286725 27.6333333 0.285328 27.6361111 0.287424 27.6388889 0.288821 27.6416667 0.290218 27.6444444 0.287424 27.6472222 0.288122 27.6500000 0.286725 27.6527778 0.288122 27.6555556 0.289520 27.6583333 0.290218 27.6611111 0.288122 27.6638889 0.286026 27.6666667 0.287424 27.6694444 0.286725 27.6722222 0.288122 27.6750000 0.289520 27.6777778 0.289520 27.6805556 0.288122 27.6833333 0.288821 27.6861111 0.288821 27.6888889 0.292314 27.6916667 0.291616 27.6944444 0.293013 27.6972222 0.292314 27.7000000 0.291616 27.7027778 0.290917 27.7055556 0.295808 27.7083333 0.295109 27.7111111 0.295808 27.7138889 0.292314 27.7166667 0.293013 27.7194444 0.293013 27.7222222 0.296507 27.7250000 0.296507 27.7277778 0.296507 27.7305556 0.293712 27.7333333 0.293712 27.7361111 0.298603 27.7388889 0.300000 27.7416667 0.302096 27.7444444 0.301397 27.7472222 0.299301 27.7500000 0.301397 27.7527778 0.302096 27.7555556 0.303493 27.7583333 0.305590 27.7611111 0.304891 27.7638889 0.302795 27.7666667 0.304891 27.7694444 0.303493 27.7722222 0.304891 27.7750000 0.306987 27.7777778 0.306288 27.7805556 0.306288 27.7833333 0.304891 27.7861111 0.308384 27.7888889 0.310480 27.7916667 0.310480 27.7944444 0.309782 27.8002222 0.300000 27.9303333 0.300000 27.9333333 0.320961 27.9361111 0.321659 27.9388889 0.322358 27.9416667 0.323755 27.9444444 0.322358 27.9472222 0.319563 27.9500000 0.318166 27.9527778 0.320262 27.9555556 0.320262 27.9583333 0.319563 27.9611111 0.319563 27.9638889 0.318865 27.9666667 0.319563 27.9694444 0.320961 27.9722222 0.320961 27.9750000 0.322358 27.9777778 0.320961 27.9805556 0.320262 27.9833333 0.319563 27.9861111 0.322358 27.9888889 0.323057 27.9916667 0.321659 27.9944444 0.320262 27.9972222 0.320262 28.0000000 0.318865 28.0027778 0.319563 28.0055556 0.320262 28.0083333 0.321659 28.0111111 0.320961 28.0138889 0.318865 28.0166667 0.318865 28.0194444 0.320961 28.0222222 0.322358 28.0250000 0.324454 28.0277778 0.325852 28.0305556 0.325153 28.0333333 0.325852 28.0361111 0.325852 28.0388889 0.327948 28.0416667 0.327249 28.0444444 0.327249 28.0472222 0.325852 28.0500000 0.325852 28.0527778 0.328646 28.0555556 0.331441 28.0583333 0.332838 28.0611111 0.333537 28.0638889 0.330044 28.0666667 0.329345 28.0694444 0.331441 28.0722222 0.334236 28.0750000 0.333537 28.0777778 0.332140 28.0805556 0.332838 28.0833333 0.332838 28.0861111 0.335633 28.0888889 0.339127 28.0916667 0.339825 28.0944444 0.337729 28.0972222 0.336332 28.1000000 0.336332 28.1027778 0.336332 28.1055556 0.335633 28.1083333 0.334934 28.1111111 0.333537 28.1138889 0.333537 28.1166667 0.333537 28.1194444 0.334934 28.1222222 0.334236 28.1250000 0.332838 28.1277778 0.330742 28.1305556 0.329345 28.1333333 0.330742 28.1361111 0.331441 28.1388889 0.330742 28.1416667 0.328646 28.1444444 0.320262 28.1472222 0.313275 28.1500000 0.309083 28.1527778 0.304192 28.1555556 0.293013 28.1583333 0.276943 28.1611111 0.259476 28.1638889 0.244105 28.1666667 0.232926 28.1694444 0.225939 28.1722222 0.213362 28.1750000 0.198690 28.1777778 0.184716 28.1805556 0.177031 28.1833333 0.174236 28.1861111 0.174236 28.1888889 0.177729 28.1916667 0.178428 28.1944444 0.181223 28.1972222 0.183319 28.2000000 0.191004 28.2027778 0.201485 28.2055556 0.209869 28.2083333 0.213362 28.2111111 0.214061 28.2138889 0.211266 28.2166667 0.209869 28.2194444 0.208472 28.2222222 0.209869 28.2250000 0.209170 28.2277778 0.203581 28.2305556 0.201485 28.2333333 0.199389 28.2361111 0.197293 28.2388889 0.199389 28.2416667 0.199389 28.2444444 0.197991 28.2472222 0.197991 28.2500000 0.197293 28.2527778 0.197991 28.2555556 0.199389 28.2583333 0.199389 28.2611111 0.197991 28.2638889 0.197991 28.2666667 0.197991 28.2694444 0.198690 28.2722222 0.198690 28.2750000 0.197293 28.2777778 0.196594 28.2805556 0.196594 28.2833333 0.196594 28.2861111 0.197293 28.2888889 0.198690 28.2916667 0.197293 28.2944444 0.197991 28.2972222 0.197293 28.3000000 0.196594 28.3027778 0.197293 28.3055556 0.200087 28.3083333 0.201485 28.3111111 0.199389 28.3138889 0.200087 28.3166667 0.200087 28.3194444 0.202882 28.3222222 0.202882 28.3250000 0.204978 28.3277778 0.204279 28.3305556 0.203581 28.3333333 0.203581 28.3361111 0.204279 28.3388889 0.208472 28.3416667 0.209170 28.3444444 0.207773 28.3472222 0.208472 28.3500000 0.208472 28.3527778 0.211266 28.3555556 0.214061 28.3583333 0.215459 28.3611111 0.214061 28.3638889 0.213362 28.3666667 0.216856 28.3694444 0.221048 28.3722222 0.220349 28.3750000 0.221048 28.3777778 0.221048 28.3805556 0.219651 28.3833333 0.222445 28.3861111 0.223144 28.3888889 0.225939 28.3916667 0.224541 28.3944444 0.225939 28.3972222 0.225939 28.4000000 0.225240 28.4027778 0.230131 28.4055556 0.229432 28.4083333 0.230830 28.4111111 0.230830 28.4138889 0.232227 28.4166667 0.232227 28.4194444 0.236419 28.4222222 0.238515 28.4250000 0.238515 28.4277778 0.239913 28.4305556 0.239913 28.4333333 0.239913 28.4361111 0.241310 28.4388889 0.245502 28.4416667 0.247598 28.4444444 0.247598 28.4472222 0.246900 28.4500000 0.248996 28.4527778 0.251092 28.4555556 0.251092 28.4583333 0.253188 28.4611111 0.251790 28.4638889 0.251092 28.4666667 0.252489 28.4694444 0.255983 28.4722222 0.260175 28.4750000 0.261572 28.4777778 0.261572 28.4805556 0.261572 28.4863333 0.300000 29.2997778 0.300000 29.3027778 0.297904 29.3055556 0.297904 29.3083333 0.299301 29.3111111 0.300000 29.3138889 0.298603 29.3166667 0.297904 29.3194444 0.297205 29.3222222 0.299301 29.3250000 0.300699 29.3277778 0.299301 29.3305556 0.299301 29.3333333 0.297904 29.3361111 0.299301 29.3388889 0.300699 29.3416667 0.300000 29.3444444 0.298603 29.3472222 0.297904 29.3500000 0.296507 29.3527778 0.297904 29.3555556 0.300000 29.3583333 0.297904 29.3611111 0.297904 29.3638889 0.296507 29.3666667 0.297205 29.3694444 0.299301 29.3722222 0.300699 29.3750000 0.299301 29.3777778 0.298603 29.3805556 0.297904 29.3833333 0.295109 29.3861111 0.296507 29.3888889 0.300000 29.3916667 0.300000 29.3944444 0.297205 29.3972222 0.295808 29.4000000 0.295808 29.4027778 0.295808 29.4055556 0.298603 29.4083333 0.298603 29.4111111 0.297205 29.4138889 0.295808 29.4166667 0.296507 29.4194444 0.298603 29.4222222 0.299301 29.4250000 0.300000 29.4277778 0.298603 29.4305556 0.297205 29.4333333 0.295808 29.4361111 0.297904 29.4388889 0.299301 29.4416667 0.299301 29.4444444 0.299301 29.4472222 0.296507 29.4500000 0.294410 29.4527778 0.297205 29.4555556 0.297904 29.4583333 0.297904 29.4611111 0.296507 29.4638889 0.294410 29.4666667 0.295109 29.4694444 0.295808 29.4722222 0.296507 29.4750000 0.297904 29.4777778 0.297904 29.4805556 0.297205 29.4833333 0.295109 29.4861111 0.297205 29.4888889 0.298603 29.4916667 0.300699 29.4944444 0.298603 29.4972222 0.296507 29.5000000 0.296507 29.5027778 0.296507 29.5055556 0.295808 29.5083333 0.291616 29.5111111 0.289520 29.5138889 0.286725 29.5166667 0.285328 29.5194444 0.290218 29.5222222 0.297904 29.5250000 0.307686 29.5277778 0.320262 29.5305556 0.334934 29.5333333 0.348210 29.5361111 0.356594 29.5388889 0.363581 29.5416667 0.364978 29.5444444 0.370568 29.5472222 0.382445 29.5500000 0.395022 29.5527778 0.404803 29.5555556 0.405502 29.5583333 0.397817 29.5611111 0.384541 29.5638889 0.374061 29.5666667 0.360087 29.5694444 0.344017 29.5722222 0.323057 29.5750000 0.302795 29.5777778 0.289520 29.5805556 0.284629 29.5833333 0.283231 29.5861111 0.282533 29.5888889 0.282533 29.5916667 0.279039 29.5944444 0.274148 29.5972222 0.272052 29.6000000 0.276245 29.6027778 0.283231 29.6055556 0.288122 29.6083333 0.291616 29.6111111 0.297205 29.6138889 0.304192 29.6166667 0.304891 29.6194444 0.306987 29.6222222 0.304891 29.6250000 0.300000 29.6277778 0.294410 29.6305556 0.288821 29.6333333 0.285328 29.6361111 0.286725 29.6388889 0.288122 29.6416667 0.289520 29.6444444 0.290218 29.6472222 0.288122 29.6500000 0.286026 29.6527778 0.290218 29.6555556 0.289520 29.6583333 0.287424 29.6611111 0.288122 29.6638889 0.285328 29.6666667 0.286026 29.6694444 0.288122 29.6722222 0.288122 29.6750000 0.285328 29.6777778 0.283930 29.6805556 0.285328 29.6833333 0.285328 29.6861111 0.288821 29.6888889 0.288122 29.6916667 0.286725 29.6944444 0.286026 29.6972222 0.284629 29.7000000 0.287424 29.7027778 0.290218 29.7055556 0.292314 29.7083333 0.293013 29.7111111 0.290917 29.7138889 0.290917 29.7166667 0.288821 29.7194444 0.290917 29.7222222 0.294410 29.7250000 0.294410 29.7277778 0.290917 29.7305556 0.290917 29.7333333 0.290917 29.7361111 0.293013 29.7388889 0.293712 29.7416667 0.294410 29.7444444 0.294410 29.7472222 0.294410 29.7500000 0.295109 29.7527778 0.297904 29.7555556 0.298603 29.7583333 0.299301 29.7611111 0.298603 29.7638889 0.297904 29.7666667 0.297904 29.7694444 0.299301 29.7722222 0.302795 29.7750000 0.302096 29.7777778 0.302096 29.7805556 0.301397 29.7833333 0.300699 29.7861111 0.301397 29.7888889 0.304891 29.7916667 0.304891 29.7944444 0.302795 29.7972222 0.302096 29.8000000 0.302795 29.8027778 0.305590 29.8055556 0.306987 29.8083333 0.306987 29.8111111 0.307686 29.8138889 0.307686 29.8166667 0.308384 29.8194444 0.309782 29.8222222 0.311878 29.8250000 0.313275 29.8277778 0.312576 29.8305556 0.311878 29.8333333 0.312576 29.8361111 0.316070 29.8388889 0.315371 29.8416667 0.316769 29.8444444 0.316070 29.8472222 0.315371 29.8500000 0.315371 29.8557778 0.300000 29.9942222 0.300000 29.9972222 0.327249 30.0000000 0.326550 30.0027778 0.329345 30.0055556 0.329345 30.0083333 0.329345 30.0111111 0.326550 30.0138889 0.325852 30.0166667 0.325153 30.0194444 0.326550 30.0222222 0.328646 30.0250000 0.327249 30.0277778 0.325153 30.0305556 0.323057 30.0333333 0.321659 30.0361111 0.325852 30.0388889 0.326550 30.0416667 0.327249 30.0444444 0.326550 30.0472222 0.324454 30.0500000 0.325852 30.0527778 0.325153 30.0555556 0.330044 30.0583333 0.327948 30.0611111 0.328646 30.0638889 0.326550 30.0666667 0.325852 30.0694444 0.327249 30.0722222 0.330044 30.0750000 0.330044 30.0777778 0.329345 30.0805556 0.329345 30.0833333 0.328646 30.0861111 0.329345 30.0888889 0.332838 30.0916667 0.333537 30.0944444 0.333537 30.0972222 0.331441 30.1000000 0.333537 30.1027778 0.337031 30.1055556 0.339127 30.1083333 0.337729 30.1111111 0.337031 30.1138889 0.334934 30.1166667 0.336332 30.1194444 0.338428 30.1222222 0.339825 30.1250000 0.342620 30.1277778 0.342620 30.1305556 0.341223 30.1333333 0.341223 30.1361111 0.343319 30.1388889 0.345415 30.1416667 0.345415 30.1444444 0.342620 30.1472222 0.341223 30.1500000 0.341223 30.1527778 0.344716 30.1555556 0.346812 30.1583333 0.346812 30.1611111 0.346812 30.1638889 0.344017 30.1666667 0.343319 30.1694444 0.341223 30.1722222 0.340524 30.1750000 0.339825 30.1777778 0.339127 30.1805556 0.337729 30.1833333 0.341223 30.1861111 0.342620 30.1888889 0.344017 30.1916667 0.343319 30.1944444 0.341921 30.1972222 0.341921 30.2000000 0.341921 30.2027778 0.337729 30.2055556 0.334934 30.2083333 0.330044 30.2111111 0.320262 30.2138889 0.313275 30.2166667 0.305590 30.2194444 0.297205 30.2222222 0.285328 30.2250000 0.267162 30.2277778 0.248297 30.2305556 0.235022 30.2333333 0.224541 30.2361111 0.212664 30.2388889 0.203581 30.2416667 0.195197 30.2444444 0.188908 30.2472222 0.184017 30.2500000 0.179127 30.2527778 0.182620 30.2555556 0.186114 30.2583333 0.187511 30.2611111 0.193100 30.2638889 0.200087 30.2666667 0.208472 30.2694444 0.218253 30.2722222 0.225939 30.2750000 0.230131 30.2777778 0.230131 30.2805556 0.228734 30.2833333 0.226638 30.2861111 0.225939 30.2888889 0.225240 30.2916667 0.221048 30.2944444 0.218952 30.2972222 0.215459 30.3000000 0.211266 30.3027778 0.210568 30.3055556 0.207773 30.3083333 0.207074 30.3111111 0.204279 30.3138889 0.202183 30.3166667 0.203581 30.3194444 0.204279 30.3222222 0.204978 30.3250000 0.204978 30.3277778 0.202882 30.3305556 0.200786 30.3333333 0.202183 30.3361111 0.203581 30.3388889 0.203581 30.3416667 0.204279 30.3444444 0.200087 30.3472222 0.200087 30.3500000 0.199389 30.3527778 0.202183 30.3555556 0.204978 30.3583333 0.204978 30.3611111 0.203581 30.3638889 0.201485 30.3666667 0.202882 30.3694444 0.204279 30.3722222 0.204279 30.3750000 0.204279 30.3777778 0.204978 30.3805556 0.202882 30.3833333 0.204279 30.3861111 0.207074 30.3888889 0.208472 30.3916667 0.207773 30.3944444 0.206376 30.3972222 0.206376 30.4000000 0.205677 30.4027778 0.208472 30.4055556 0.210568 30.4083333 0.208472 30.4111111 0.210568 30.4138889 0.209170 30.4166667 0.211965 30.4194444 0.214760 30.4222222 0.216856 30.4250000 0.215459 30.4277778 0.214061 30.4305556 0.213362 30.4333333 0.214061 30.4361111 0.216856 30.4388889 0.219651 30.4416667 0.219651 30.4444444 0.218952 30.4472222 0.217555 30.4500000 0.219651 30.4527778 0.222445 30.4555556 0.223843 30.4583333 0.224541 30.4611111 0.224541 30.4638889 0.224541 30.4666667 0.226638 30.4694444 0.229432 30.4722222 0.229432 30.4750000 0.231528 30.4777778 0.229432 30.4805556 0.227336 30.4833333 0.229432 30.4861111 0.232227 30.4888889 0.234323 30.4916667 0.234323 30.4944444 0.233624 30.4972222 0.235721 30.5000000 0.235022 30.5027778 0.238515 30.5055556 0.239214 30.5083333 0.240611 30.5111111 0.242009 30.5138889 0.242009 30.5166667 0.244105 30.5194444 0.246201 30.5222222 0.247598 30.5250000 0.248297 30.5277778 0.246900 30.5305556 0.247598 30.5333333 0.248297 30.5361111 0.250393 30.5388889 0.251790 30.5416667 0.253886 30.5444444 0.253188 30.5502222 0.300000 31.4136667 0.300000 31.4166667 0.290917 31.4194444 0.292314 31.4222222 0.294410 31.4250000 0.291616 31.4277778 0.290917 31.4305556 0.288821 31.4333333 0.288821 31.4361111 0.293013 31.4388889 0.293013 31.4416667 0.294410 31.4444444 0.293013 31.4472222 0.292314 31.4500000 0.290917 31.4527778 0.293013 31.4555556 0.294410 31.4583333 0.295109 31.4611111 0.292314 31.4638889 0.292314 31.4666667 0.290917 31.4694444 0.292314 31.4722222 0.292314 31.4750000 0.290218 31.4777778 0.290917 31.4805556 0.287424 31.4833333 0.290218 31.4861111 0.290218 31.4888889 0.290218 31.4916667 0.287424 31.4944444 0.288821 31.4972222 0.288821 31.5000000 0.290917 31.5027778 0.292314 31.5055556 0.293013 31.5083333 0.291616 31.5111111 0.290917 31.5138889 0.290917 31.5166667 0.290917 31.5194444 0.290917 31.5222222 0.292314 31.5250000 0.293712 31.5277778 0.290218 31.5305556 0.288821 31.5333333 0.288821 31.5361111 0.290218 31.5388889 0.292314 31.5416667 0.290218 31.5444444 0.290218 31.5472222 0.288821 31.5500000 0.288122 31.5527778 0.290917 31.5555556 0.292314 31.5583333 0.290917 31.5611111 0.288821 31.5638889 0.288821 31.5666667 0.290218 31.5694444 0.291616 31.5722222 0.289520 31.5750000 0.291616 31.5777778 0.290218 31.5805556 0.289520 31.5833333 0.288821 31.5861111 0.286725 31.5888889 0.292314 31.5916667 0.290917 31.5944444 0.290218 31.5972222 0.288821 31.6000000 0.287424 31.6027778 0.288821 31.6055556 0.290917 31.6083333 0.293712 31.6111111 0.293013 31.6138889 0.288821 31.6166667 0.290218 31.6194444 0.290917 31.6222222 0.289520 31.6250000 0.286725 31.6277778 0.285328 31.6305556 0.286026 31.6333333 0.285328 31.6361111 0.288821 31.6388889 0.295808 31.6416667 0.306288 31.6444444 0.320262 31.6472222 0.333537 31.6500000 0.344716 31.6527778 0.353799 31.6555556 0.357293 31.6583333 0.360786 31.6611111 0.369170 31.6638889 0.378253 31.6666667 0.388035 31.6694444 0.392926 31.6722222 0.388734 31.6750000 0.379651 31.6777778 0.368472 31.6805556 0.358690 31.6833333 0.347511 31.6861111 0.333537 31.6888889 0.318166 31.6916667 0.297904 31.6944444 0.285328 31.6972222 0.279738 31.7000000 0.278341 31.7027778 0.279039 31.7055556 0.280437 31.7083333 0.275546 31.7111111 0.269956 31.7138889 0.269258 31.7166667 0.275546 31.7194444 0.283930 31.7222222 0.288821 31.7250000 0.292314 31.7277778 0.295808 31.7305556 0.299301 31.7333333 0.302096 31.7361111 0.304192 31.7388889 0.302795 31.7416667 0.299301 31.7444444 0.294410 31.7472222 0.289520 31.7500000 0.288122 31.7527778 0.286725 31.7555556 0.284629 31.7583333 0.283231 31.7611111 0.281834 31.7638889 0.283930 31.7666667 0.283930 31.7694444 0.286026 31.7722222 0.288122 31.7750000 0.288122 31.7777778 0.288122 31.7805556 0.286026 31.7833333 0.287424 31.7861111 0.287424 31.7888889 0.290218 31.7916667 0.288821 31.7944444 0.288122 31.7972222 0.286026 31.8000000 0.285328 31.8027778 0.287424 31.8055556 0.286725 31.8083333 0.286725 31.8111111 0.286725 31.8138889 0.283231 31.8166667 0.284629 31.8194444 0.286725 31.8222222 0.288122 31.8250000 0.286725 31.8277778 0.286725 31.8305556 0.286725 31.8333333 0.286725 31.8361111 0.288821 31.8388889 0.290917 31.8416667 0.290218 31.8444444 0.288122 31.8472222 0.287424 31.8500000 0.286725 31.8527778 0.288122 31.8555556 0.291616 31.8583333 0.290917 31.8611111 0.289520 31.8638889 0.290218 31.8666667 0.289520 31.8694444 0.288122 31.8722222 0.291616 31.8750000 0.292314 31.8777778 0.291616 31.8805556 0.293712 31.8833333 0.293013 31.8861111 0.293013 31.8888889 0.296507 31.8916667 0.296507 31.8944444 0.293712 31.8972222 0.295808 31.9000000 0.294410 31.9027778 0.297205 31.9055556 0.297904 31.9083333 0.297205 31.9111111 0.296507 31.9138889 0.296507 31.9166667 0.296507 31.9194444 0.299301 31.9222222 0.301397 31.9250000 0.302096 31.9277778 0.300000 31.9305556 0.300000 31.9333333 0.300699 31.9361111 0.302795 31.9388889 0.304891 31.9416667 0.307686 31.9444444 0.305590 31.9472222 0.304891 31.9500000 0.305590 31.9527778 0.306987 31.9555556 0.307686 31.9583333 0.307686 31.9611111 0.306987 31.9638889 0.307686 31.9696667 0.300000 32.1053333 0.300000 32.1083333 0.319563 32.1111111 0.318166 32.1138889 0.318166 32.1166667 0.317467 32.1194444 0.320262 32.1222222 0.319563 32.1250000 0.317467 32.1277778 0.317467 32.1305556 0.317467 32.1333333 0.316769 32.1361111 0.316769 32.1388889 0.316769 32.1416667 0.316769 32.1444444 0.315371 32.1472222 0.313974 32.1500000 0.313275 32.1527778 0.316769 32.1555556 0.316769 32.1583333 0.316070 32.1611111 0.314672 32.1638889 0.313974 32.1666667 0.314672 32.1694444 0.317467 32.1722222 0.317467 32.1750000 0.320262 32.1777778 0.315371 32.1805556 0.316769 32.1833333 0.317467 32.1861111 0.318865 32.1888889 0.320262 32.1916667 0.320262 32.1944444 0.318166 32.1972222 0.320262 32.2000000 0.318166 32.2027778 0.321659 32.2055556 0.322358 32.2083333 0.321659 32.2111111 0.318865 32.2138889 0.320961 32.2166667 0.319563 32.2194444 0.323755 32.2222222 0.327249 32.2250000 0.326550 32.2277778 0.326550 32.2305556 0.327249 32.2333333 0.328646 32.2361111 0.329345 32.2388889 0.330742 32.2416667 0.329345 32.2444444 0.328646 32.2472222 0.327249 32.2500000 0.330044 32.2527778 0.332838 32.2555556 0.332140 32.2583333 0.331441 32.2611111 0.330742 32.2638889 0.329345 32.2666667 0.329345 32.2694444 0.330742 32.2722222 0.332140 32.2750000 0.331441 32.2777778 0.329345 32.2805556 0.325852 32.2833333 0.323755 32.2861111 0.323755 32.2888889 0.322358 32.2916667 0.320262 32.2944444 0.316769 32.2972222 0.314672 32.3000000 0.311878 32.3027778 0.313974 32.3055556 0.315371 32.3083333 0.313275 32.3111111 0.310480 32.3138889 0.306288 32.3166667 0.304192 32.3194444 0.302096 32.3222222 0.304192 32.3250000 0.303493 32.3277778 0.300000 32.3305556 0.293013 32.3333333 0.284629 32.3361111 0.277642 32.3388889 0.269956 32.3416667 0.260873 32.3444444 0.248297 32.3472222 0.235022 32.3500000 0.226638 32.3527778 0.225939 32.3555556 0.220349 32.3583333 0.213362 32.3611111 0.208472 32.3638889 0.209170 32.3666667 0.209869 32.3694444 0.214061 32.3722222 0.218253 32.3750000 0.223144 32.3777778 0.226638 32.3805556 0.230131 32.3833333 0.234323 32.3861111 0.235022 32.3888889 0.233624 32.3916667 0.227336 32.3944444 0.218253 32.3972222 0.211266 32.4000000 0.204279 32.4027778 0.200087 32.4055556 0.195895 32.4083333 0.191004 32.4111111 0.186114 32.4138889 0.185415 32.4166667 0.184716 32.4194444 0.186114 32.4222222 0.188210 32.4250000 0.185415 32.4277778 0.184017 32.4305556 0.181921 32.4333333 0.181921 32.4361111 0.182620 32.4388889 0.184017 32.4416667 0.184716 32.4444444 0.184017 32.4472222 0.182620 32.4500000 0.183319 32.4527778 0.184017 32.4555556 0.185415 32.4583333 0.184716 32.4611111 0.182620 32.4638889 0.181921 32.4666667 0.182620 32.4694444 0.185415 32.4722222 0.186812 32.4750000 0.186114 32.4777778 0.185415 32.4805556 0.183319 32.4833333 0.184716 32.4861111 0.185415 32.4888889 0.186114 32.4916667 0.186812 32.4944444 0.186114 32.4972222 0.187511 32.5000000 0.188908 32.5027778 0.189607 32.5055556 0.190306 32.5083333 0.190306 32.5111111 0.191703 32.5138889 0.190306 32.5166667 0.191703 32.5194444 0.194498 32.5222222 0.194498 32.5250000 0.195197 32.5277778 0.195895 32.5305556 0.195895 32.5333333 0.197293 32.5361111 0.199389 32.5388889 0.200786 32.5416667 0.199389 32.5444444 0.198690 32.5472222 0.197293 32.5500000 0.199389 32.5527778 0.202183 32.5555556 0.202882 32.5583333 0.203581 32.5611111 0.202882 32.5638889 0.204279 32.5666667 0.205677 32.5694444 0.207074 32.5722222 0.209170 32.5750000 0.209170 32.5777778 0.209170 32.5805556 0.209170 32.5833333 0.210568 32.5861111 0.212664 32.5888889 0.214061 32.5916667 0.213362 32.5944444 0.211266 32.5972222 0.211266 32.6000000 0.213362 32.6027778 0.216157 32.6055556 0.218253 32.6083333 0.218253 32.6111111 0.216157 32.6138889 0.217555 32.6166667 0.218952 32.6194444 0.221048 32.6222222 0.225939 32.6250000 0.225939 32.6277778 0.225939 32.6305556 0.225240 32.6333333 0.227336 32.6361111 0.229432 32.6388889 0.232227 32.6416667 0.232926 32.6444444 0.231528 32.6472222 0.231528 32.6500000 0.232926 32.6527778 0.235022 32.6555556 0.235721 32.6613333 0.300000 33.4886667 0.300000 33.4916667 0.293712 33.4944444 0.292314 33.4972222 0.294410 33.5000000 0.294410 33.5027778 0.295808 33.5055556 0.293712 33.5083333 0.292314 33.5111111 0.290218 33.5138889 0.290218 33.5166667 0.291616 33.5194444 0.293712 33.5222222 0.295109 33.5250000 0.293013 33.5277778 0.293013 33.5305556 0.293712 33.5333333 0.294410 33.5361111 0.293712 33.5388889 0.293013 33.5416667 0.293712 33.5444444 0.292314 33.5472222 0.290917 33.5500000 0.293712 33.5527778 0.295109 33.5555556 0.296507 33.5583333 0.295109 33.5611111 0.291616 33.5638889 0.293013 33.5666667 0.293013 33.5694444 0.295109 33.5722222 0.294410 33.5750000 0.291616 33.5777778 0.289520 33.5805556 0.292314 33.5833333 0.294410 33.5861111 0.295109 33.5888889 0.295808 33.5916667 0.294410 33.5944444 0.293013 33.5972222 0.293013 33.6000000 0.294410 33.6027778 0.293712 33.6055556 0.295109 33.6083333 0.295109 33.6111111 0.295808 33.6138889 0.293013 33.6166667 0.292314 33.6194444 0.294410 33.6222222 0.293013 33.6250000 0.292314 33.6277778 0.291616 33.6305556 0.288122 33.6333333 0.288122 33.6361111 0.293712 33.6388889 0.295808 33.6416667 0.295808 33.6444444 0.293712 33.6472222 0.292314 33.6500000 0.293712 33.6527778 0.292314 33.6555556 0.295808 33.6583333 0.296507 33.6611111 0.293013 33.6638889 0.290917 33.6666667 0.292314 33.6694444 0.297205 33.6722222 0.297205 33.6750000 0.293013 33.6777778 0.292314 33.6805556 0.291616 33.6833333 0.292314 33.6861111 0.294410 33.6888889 0.295109 33.6916667 0.294410 33.6944444 0.291616 33.6972222 0.289520 33.7000000 0.288122 33.7027778 0.288122 33.7055556 0.289520 33.7083333 0.291616 33.7111111 0.297904 33.7138889 0.306288 33.7166667 0.319563 33.7194444 0.334934 33.7222222 0.348908 33.7250000 0.354498 33.7277778 0.356594 33.7305556 0.357293 33.7333333 0.364978 33.7361111 0.376157 33.7388889 0.386638 33.7416667 0.391528 33.7444444 0.388035 33.7472222 0.380349 33.7500000 0.371266 33.7527778 0.363581 33.7555556 0.353100 33.7583333 0.339127 33.7611111 0.320262 33.7638889 0.301397 33.7666667 0.290218 33.7694444 0.286725 33.7722222 0.286725 33.7750000 0.286725 33.7777778 0.286026 33.7805556 0.282533 33.7833333 0.277642 33.7861111 0.276245 33.7888889 0.282533 33.7916667 0.287424 33.7944444 0.290917 33.7972222 0.294410 33.8000000 0.297205 33.8027778 0.300699 33.8055556 0.304192 33.8083333 0.302096 33.8111111 0.298603 33.8138889 0.293712 33.8166667 0.290917 33.8194444 0.288821 33.8222222 0.290218 33.8250000 0.288122 33.8277778 0.286026 33.8305556 0.283930 33.8333333 0.283231 33.8361111 0.286026 33.8388889 0.286725 33.8416667 0.284629 33.8444444 0.282533 33.8472222 0.282533 33.8500000 0.283930 33.8527778 0.284629 33.8555556 0.286725 33.8583333 0.284629 33.8611111 0.282533 33.8638889 0.283930 33.8666667 0.284629 33.8694444 0.284629 33.8722222 0.286026 33.8750000 0.283930 33.8777778 0.281834 33.8805556 0.283231 33.8833333 0.284629 33.8861111 0.286725 33.8888889 0.286026 33.8916667 0.285328 33.8944444 0.283930 33.8972222 0.283231 33.9000000 0.284629 33.9027778 0.288821 33.9055556 0.290218 33.9083333 0.288122 33.9111111 0.286026 33.9138889 0.287424 33.9166667 0.288821 33.9194444 0.288821 33.9222222 0.290218 33.9250000 0.290218 33.9277778 0.290218 33.9305556 0.289520 33.9333333 0.289520 33.9361111 0.292314 33.9388889 0.294410 33.9416667 0.294410 33.9444444 0.292314 33.9472222 0.293013 33.9500000 0.293712 33.9527778 0.293712 33.9555556 0.293013 33.9583333 0.294410 33.9611111 0.297205 33.9638889 0.296507 33.9666667 0.299301 33.9694444 0.299301 33.9722222 0.300000 33.9750000 0.298603 33.9777778 0.298603 33.9805556 0.300699 33.9833333 0.300000 33.9861111 0.302096 33.9888889 0.304192 33.9916667 0.304891 33.9944444 0.303493 33.9972222 0.302795 34.0000000 0.302795 34.0027778 0.305590 34.0055556 0.309083 34.0083333 0.306987 34.0111111 0.305590 34.0138889 0.304891 34.0166667 0.308384 34.0194444 0.310480 34.0222222 0.313275 34.0250000 0.313974 34.0277778 0.311878 34.0305556 0.313974 34.0333333 0.317467 34.0361111 0.318865 34.0388889 0.316070 34.0446667 0.300000 34.1525556 0.300000 34.1555556 0.338428 34.1583333 0.334236 34.1611111 0.331441 34.1638889 0.330742 34.1666667 0.332838 34.1694444 0.336332 34.1722222 0.337031 34.1750000 0.334236 34.1777778 0.331441 34.1805556 0.327948 34.1833333 0.330044 34.1861111 0.332838 34.1888889 0.335633 34.1916667 0.337031 34.1944444 0.333537 34.1972222 0.330742 34.2000000 0.331441 34.2027778 0.334934 34.2055556 0.334236 34.2083333 0.332838 34.2111111 0.332140 34.2138889 0.331441 34.2166667 0.333537 34.2194444 0.334236 34.2222222 0.333537 34.2250000 0.334236 34.2277778 0.334236 34.2305556 0.331441 34.2333333 0.329345 34.2361111 0.332140 34.2388889 0.335633 34.2416667 0.336332 34.2444444 0.334934 34.2472222 0.332838 34.2500000 0.335633 34.2527778 0.338428 34.2555556 0.339127 34.2583333 0.335633 34.2611111 0.334934 34.2638889 0.335633 34.2666667 0.337729 34.2694444 0.337729 34.2722222 0.337031 34.2750000 0.336332 34.2777778 0.336332 34.2805556 0.334934 34.2833333 0.336332 34.2861111 0.336332 34.2888889 0.338428 34.2916667 0.339127 34.2944444 0.338428 34.2972222 0.337729 34.3000000 0.339825 34.3027778 0.342620 34.3055556 0.341921 34.3083333 0.341921 34.3111111 0.341921 34.3138889 0.342620 34.3166667 0.342620 34.3194444 0.346812 34.3222222 0.347511 34.3250000 0.344716 34.3277778 0.344017 34.3305556 0.344716 34.3333333 0.344716 34.3361111 0.341921 34.3388889 0.339825 34.3416667 0.337031 34.3444444 0.337031 34.3472222 0.341223 34.3500000 0.346114 34.3527778 0.348908 34.3555556 0.354498 34.3583333 0.357293 34.3611111 0.355895 34.3638889 0.350306 34.3666667 0.344716 34.3694444 0.337031 34.3722222 0.329345 34.3750000 0.322358 34.3777778 0.310480 34.3805556 0.296507 34.3833333 0.280437 34.3861111 0.267860 34.3888889 0.255284 34.3916667 0.242707 34.3944444 0.230830 34.3972222 0.223843 34.4000000 0.218952 34.4027778 0.218952 34.4055556 0.215459 34.4083333 0.209869 34.4111111 0.206376 34.4138889 0.202882 34.4166667 0.204279 34.4194444 0.204978 34.4222222 0.211266 34.4250000 0.221048 34.4277778 0.226638 34.4305556 0.226638 34.4333333 0.225240 34.4361111 0.225240 34.4388889 0.221747 34.4416667 0.217555 34.4444444 0.212664 34.4472222 0.208472 34.4500000 0.208472 34.4527778 0.209869 34.4555556 0.211266 34.4583333 0.212664 34.4611111 0.211965 34.4638889 0.209869 34.4666667 0.209170 34.4694444 0.212664 34.4722222 0.210568 34.4750000 0.208472 34.4777778 0.207074 34.4805556 0.206376 34.4833333 0.209170 34.4861111 0.211266 34.4888889 0.211965 34.4916667 0.207773 34.4944444 0.204279 34.4972222 0.207773 34.5000000 0.211266 34.5027778 0.212664 34.5055556 0.210568 34.5083333 0.207074 34.5111111 0.207773 34.5138889 0.210568 34.5166667 0.212664 34.5194444 0.211266 34.5222222 0.211965 34.5250000 0.211965 34.5277778 0.213362 34.5305556 0.216856 34.5333333 0.219651 34.5361111 0.221048 34.5388889 0.218253 34.5416667 0.215459 34.5444444 0.214760 34.5472222 0.216856 34.5500000 0.218952 34.5527778 0.223144 34.5555556 0.223144 34.5583333 0.223144 34.5611111 0.225240 34.5638889 0.220349 34.5666667 0.218952 34.5694444 0.222445 34.5722222 0.230830 34.5750000 0.232926 34.5777778 0.227336 34.5805556 0.225240 34.5833333 0.227336 34.5861111 0.233624 34.5888889 0.236419 34.5916667 0.237118 34.5944444 0.235022 34.5972222 0.234323 34.6000000 0.233624 34.6027778 0.241310 34.6055556 0.245502 34.6083333 0.242707 34.6111111 0.242707 34.6138889 0.246201 34.6166667 0.249694 34.6194444 0.251790 34.6222222 0.252489 34.6250000 0.248996 34.6277778 0.247598 34.6305556 0.252489 34.6333333 0.258777 34.6361111 0.258079 34.6388889 0.259476 34.6416667 0.258777 34.6444444 0.255983 34.6472222 0.258079 34.6500000 0.257380 34.6527778 0.257380 34.6555556 0.260175 34.6583333 0.262271 34.6611111 0.262271 34.6638889 0.265066 34.6666667 0.270655 34.6694444 0.266463 34.6722222 0.267162 34.6750000 0.266463 34.6777778 0.265764 34.6805556 0.264367 34.6833333 0.269956 34.6861111 0.276245 34.6888889 0.276245 34.6916667 0.274148 34.6944444 0.273450 34.6972222 0.272751 34.7000000 0.272751 34.7027778 0.276245 34.7085556 0.300000 35.5414444 0.300000 35.5444444 0.300000 35.5472222 0.299301 35.5500000 0.300000 35.5527778 0.304192 35.5555556 0.304891 35.5583333 0.302096 35.5611111 0.302096 35.5638889 0.300699 35.5666667 0.303493 35.5694444 0.302795 35.5722222 0.304192 35.5750000 0.303493 35.5777778 0.300699 35.5805556 0.297904 35.5833333 0.300000 35.5861111 0.304192 35.5888889 0.304192 35.5916667 0.303493 35.5944444 0.300000 35.5972222 0.298603 35.6000000 0.299301 35.6027778 0.302096 35.6055556 0.300699 35.6083333 0.300699 35.6111111 0.300699 35.6138889 0.300699 35.6166667 0.302096 35.6194444 0.304192 35.6222222 0.304891 35.6250000 0.303493 35.6277778 0.302096 35.6305556 0.302096 35.6333333 0.302795 35.6361111 0.302096 35.6388889 0.302795 35.6416667 0.302795 35.6444444 0.302795 35.6472222 0.300000 35.6500000 0.300000 35.6527778 0.304192 35.6555556 0.302795 35.6583333 0.301397 35.6611111 0.300000 35.6638889 0.302096 35.6666667 0.304192 35.6694444 0.304192 35.6722222 0.304891 35.6750000 0.304891 35.6777778 0.304192 35.6805556 0.302795 35.6833333 0.304891 35.6861111 0.305590 35.6888889 0.306987 35.6916667 0.306288 35.6944444 0.304192 35.6972222 0.303493 35.7000000 0.306288 35.7027778 0.306987 35.7055556 0.305590 35.7083333 0.304891 35.7111111 0.302795 35.7138889 0.302096 35.7166667 0.301397 35.7194444 0.304192 35.7222222 0.304891 35.7250000 0.304192 35.7277778 0.303493 35.7305556 0.304192 35.7333333 0.305590 35.7361111 0.307686 35.7388889 0.306288 35.7416667 0.302795 35.7444444 0.299301 35.7472222 0.297904 35.7500000 0.300000 35.7527778 0.301397 35.7555556 0.301397 35.7583333 0.302096 35.7611111 0.304891 35.7638889 0.310480 35.7666667 0.322358 35.7694444 0.336332 35.7722222 0.348210 35.7750000 0.355197 35.7777778 0.360786 35.7805556 0.364978 35.7833333 0.368472 35.7861111 0.378253 35.7888889 0.388734 35.7916667 0.400611 35.7944444 0.406201 35.7972222 0.404105 35.8000000 0.401310 35.8027778 0.394323 35.8055556 0.388035 35.8083333 0.376157 35.8111111 0.362882 35.8138889 0.349607 35.8166667 0.333537 35.8194444 0.317467 35.8222222 0.304192 35.8250000 0.297205 35.8277778 0.294410 35.8305556 0.290917 35.8333333 0.290218 35.8361111 0.287424 35.8388889 0.284629 35.8416667 0.279738 35.8444444 0.280437 35.8472222 0.281834 35.8500000 0.286725 35.8527778 0.294410 35.8555556 0.297904 35.8583333 0.302096 35.8611111 0.306987 35.8638889 0.312576 35.8666667 0.316070 35.8694444 0.316769 35.8722222 0.313974 35.8750000 0.308384 35.8777778 0.302795 35.8805556 0.300000 35.8833333 0.298603 35.8861111 0.299301 35.8888889 0.298603 35.8916667 0.297904 35.8944444 0.296507 35.8972222 0.295109 35.9000000 0.297205 35.9027778 0.297904 35.9055556 0.297904 35.9083333 0.297205 35.9111111 0.295808 35.9138889 0.295109 35.9166667 0.296507 35.9194444 0.297904 35.9222222 0.298603 35.9250000 0.296507 35.9277778 0.294410 35.9305556 0.293712 35.9333333 0.296507 35.9361111 0.299301 35.9388889 0.297205 35.9416667 0.295109 35.9444444 0.293712 35.9472222 0.296507 35.9500000 0.294410 35.9527778 0.297904 35.9555556 0.297205 35.9583333 0.294410 35.9611111 0.293712 35.9638889 0.294410 35.9666667 0.295109 35.9694444 0.297904 35.9722222 0.295808 35.9750000 0.296507 35.9777778 0.296507 35.9805556 0.296507 35.9833333 0.297205 35.9861111 0.301397 35.9888889 0.299301 35.9916667 0.299301 35.9944444 0.297205 35.9972222 0.297904 36.0000000 0.299301 36.0027778 0.300699 36.0055556 0.302096 36.0083333 0.300000 36.0111111 0.298603 36.0138889 0.298603 36.0166667 0.300699 36.0194444 0.302096 36.0222222 0.302096 36.0250000 0.301397 36.0277778 0.300699 36.0305556 0.297904 36.0333333 0.302795 36.0361111 0.303493 36.0388889 0.305590 36.0416667 0.304192 36.0444444 0.303493 36.0472222 0.302795 36.0500000 0.305590 36.0527778 0.309083 36.0555556 0.307686 36.0583333 0.307686 36.0611111 0.305590 36.0638889 0.306288 36.0666667 0.307686 36.0694444 0.309083 36.0722222 0.310480 36.0750000 0.309083 36.0777778 0.306288 36.0805556 0.307686 36.0833333 0.309083 36.0861111 0.311878 36.0888889 0.312576 36.0916667 0.309782 36.0974444 0.300000 36.2747778 0.300000 36.2777778 0.323057 36.2805556 0.321659 36.2833333 0.325852 36.2861111 0.326550 36.2888889 0.325852 36.2916667 0.323755 36.2944444 0.323057 36.2972222 0.323057 36.3000000 0.322358 36.3027778 0.326550 36.3055556 0.324454 36.3083333 0.322358 36.3111111 0.320961 36.3138889 0.320262 36.3166667 0.323057 36.3194444 0.323755 36.3222222 0.322358 36.3250000 0.320262 36.3277778 0.319563 36.3305556 0.320262 36.3333333 0.319563 36.3361111 0.323057 36.3388889 0.322358 36.3416667 0.322358 36.3444444 0.320961 36.3472222 0.318865 36.3500000 0.323057 36.3527778 0.325852 36.3555556 0.324454 36.3583333 0.324454 36.3611111 0.324454 36.3638889 0.323755 36.3666667 0.325153 36.3694444 0.329345 36.3722222 0.327249 36.3750000 0.327249 36.3777778 0.326550 36.3805556 0.326550 36.3833333 0.328646 36.3861111 0.330742 36.3888889 0.330742 36.3916667 0.327948 36.3944444 0.330044 36.3972222 0.330044 36.4000000 0.331441 36.4027778 0.334934 36.4055556 0.334934 36.4083333 0.334236 36.4111111 0.332838 36.4138889 0.334934 36.4166667 0.334236 36.4194444 0.337729 36.4222222 0.339127 36.4250000 0.337031 36.4277778 0.336332 36.4305556 0.337031 36.4333333 0.339825 36.4361111 0.341921 36.4388889 0.340524 36.4416667 0.338428 36.4444444 0.335633 36.4472222 0.335633 36.4500000 0.337031 36.4527778 0.337729 36.4555556 0.334934 36.4583333 0.335633 36.4611111 0.337031 36.4638889 0.337031 36.4666667 0.340524 36.4694444 0.343319 36.4722222 0.343319 36.4750000 0.343319 36.4777778 0.339825 36.4805556 0.336332 36.4833333 0.339127 36.4861111 0.334934 36.4888889 0.331441 36.4916667 0.325153 36.4944444 0.314672 36.4972222 0.303493 36.5000000 0.292314 36.5027778 0.279738 36.5055556 0.265764 36.5083333 0.249694 36.5111111 0.238515 36.5138889 0.228035 36.5166667 0.221747 36.5194444 0.213362 36.5222222 0.201485 36.5250000 0.191004 36.5277778 0.182620 36.5305556 0.177031 36.5333333 0.178428 36.5361111 0.181223 36.5388889 0.186114 36.5416667 0.187511 36.5444444 0.192402 36.5472222 0.193799 36.5500000 0.200087 36.5527778 0.207074 36.5555556 0.213362 36.5583333 0.216157 36.5611111 0.217555 36.5638889 0.219651 36.5666667 0.221048 36.5694444 0.218952 36.5722222 0.214760 36.5750000 0.211266 36.5777778 0.203581 36.5805556 0.202882 36.5833333 0.202183 36.5861111 0.202882 36.5888889 0.202183 36.5916667 0.201485 36.5944444 0.198690 36.5972222 0.198690 36.6000000 0.201485 36.6027778 0.202183 36.6055556 0.200786 36.6083333 0.198690 36.6111111 0.197293 36.6138889 0.196594 36.6166667 0.197991 36.6194444 0.200087 36.6222222 0.196594 36.6250000 0.195895 36.6277778 0.193100 36.6305556 0.194498 36.6333333 0.195895 36.6361111 0.197991 36.6388889 0.197293 36.6416667 0.195895 36.6444444 0.195895 36.6472222 0.195197 36.6500000 0.197293 36.6527778 0.198690 36.6555556 0.198690 36.6583333 0.197293 36.6611111 0.195197 36.6638889 0.195197 36.6666667 0.195895 36.6694444 0.200087 36.6722222 0.198690 36.6750000 0.197991 36.6777778 0.197991 36.6805556 0.198690 36.6833333 0.202183 36.6861111 0.204279 36.6888889 0.204978 36.6916667 0.204978 36.6944444 0.204978 36.6972222 0.204279 36.7000000 0.207074 36.7027778 0.207773 36.7055556 0.211266 36.7083333 0.209869 36.7111111 0.209869 36.7138889 0.211965 36.7166667 0.213362 36.7194444 0.216856 36.7222222 0.216157 36.7250000 0.213362 36.7277778 0.216157 36.7305556 0.215459 36.7333333 0.218952 36.7361111 0.218952 36.7388889 0.220349 36.7416667 0.223144 36.7444444 0.223144 36.7472222 0.225240 36.7500000 0.227336 36.7527778 0.230830 36.7555556 0.232227 36.7583333 0.231528 36.7611111 0.231528 36.7638889 0.232227 36.7666667 0.233624 36.7694444 0.238515 36.7722222 0.240611 36.7750000 0.239913 36.7777778 0.240611 36.7805556 0.241310 36.7833333 0.242009 36.7861111 0.246201 36.7888889 0.248297 36.7916667 0.248297 36.7944444 0.249694 36.7972222 0.251790 36.8000000 0.253886 36.8027778 0.256681 36.8055556 0.257380 36.8083333 0.258079 36.8111111 0.259476 36.8138889 0.262271 36.8166667 0.266463 36.8194444 0.270655 36.8222222 0.270655 36.8250000 0.272052 36.8307778 0.300000 37.0277778 0.300000)
Vecg1 ecg_l1 0 PWL(0.0000000 0.300000 0.4747778 0.300000 0.4777778 0.371266 0.4805556 0.373362 0.4833333 0.374061 0.4861111 0.374760 0.4888889 0.375459 0.4916667 0.376856 0.4944444 0.379651 0.4972222 0.378952 0.5000000 0.381747 0.5027778 0.381048 0.5055556 0.381048 0.5083333 0.381048 0.5111111 0.383843 0.5138889 0.385240 0.5166667 0.388035 0.5194444 0.388734 0.5222222 0.385939 0.5250000 0.387336 0.5277778 0.386638 0.5305556 0.390830 0.5333333 0.392227 0.5361111 0.390131 0.5388889 0.388734 0.5416667 0.389432 0.5444444 0.388035 0.5472222 0.391528 0.5500000 0.392227 0.5527778 0.391528 0.5555556 0.390131 0.5583333 0.388035 0.5611111 0.389432 0.5638889 0.390131 0.5666667 0.390830 0.5694444 0.389432 0.5722222 0.384541 0.5750000 0.385240 0.5777778 0.385240 0.5805556 0.388035 0.5833333 0.389432 0.5861111 0.388734 0.5888889 0.387336 0.5916667 0.385240 0.5944444 0.385240 0.5972222 0.388734 0.6000000 0.390830 0.6027778 0.389432 0.6055556 0.388035 0.6083333 0.386638 0.6111111 0.385240 0.6138889 0.387336 0.6166667 0.389432 0.6194444 0.388035 0.6222222 0.387336 0.6250000 0.382445 0.6277778 0.382445 0.6305556 0.384541 0.6333333 0.386638 0.6361111 0.387336 0.6388889 0.384541 0.6416667 0.377555 0.6444444 0.373362 0.6472222 0.371965 0.6500000 0.373362 0.6527778 0.371266 0.6555556 0.366376 0.6583333 0.357293 0.6611111 0.351004 0.6638889 0.352402 0.6666667 0.355197 0.6694444 0.360786 0.6722222 0.362882 0.6750000 0.364978 0.6777778 0.366376 0.6805556 0.368472 0.6833333 0.374061 0.6861111 0.378952 0.6888889 0.378952 0.6916667 0.378253 0.6944444 0.371965 0.6972222 0.372664 0.7000000 0.369869 0.7027778 0.372664 0.7055556 0.374760 0.7083333 0.377555 0.7111111 0.377555 0.7138889 0.375459 0.7166667 0.374760 0.7194444 0.370568 0.7222222 0.363581 0.7250000 0.355197 0.7277778 0.349607 0.7305556 0.343319 0.7333333 0.342620 0.7361111 0.342620 0.7388889 0.344716 0.7416667 0.348908 0.7444444 0.353799 0.7472222 0.358690 0.7500000 0.363581 0.7527778 0.366376 0.7555556 0.363581 0.7583333 0.355895 0.7611111 0.342620 0.7638889 0.327948 0.7666667 0.311878 0.7694444 0.296507 0.7722222 0.281135 0.7750000 0.263668 0.7777778 0.246201 0.7805556 0.229432 0.7833333 0.214061 0.7861111 0.204279 0.7888889 0.196594 0.7916667 0.192402 0.7944444 0.186812 0.7972222 0.183319 0.8000000 0.181223 0.8027778 0.180524 0.8055556 0.178428 0.8083333 0.178428 0.8111111 0.177031 0.8138889 0.177729 0.8166667 0.175633 0.8194444 0.174236 0.8222222 0.173537 0.8250000 0.172140 0.8277778 0.171441 0.8305556 0.172838 0.8333333 0.171441 0.8361111 0.170044 0.8388889 0.167249 0.8416667 0.167948 0.8444444 0.167249 0.8472222 0.169345 0.8500000 0.169345 0.8527778 0.167249 0.8555556 0.164454 0.8583333 0.163755 0.8611111 0.165153 0.8638889 0.165852 0.8666667 0.167948 0.8694444 0.165852 0.8722222 0.163057 0.8750000 0.162358 0.8777778 0.163755 0.8805556 0.166550 0.8833333 0.168646 0.8861111 0.167249 0.8888889 0.165852 0.8916667 0.163755 0.8944444 0.164454 0.8972222 0.167948 0.9000000 0.170742 0.9027778 0.169345 0.9055556 0.168646 0.9083333 0.169345 0.9111111 0.170044 0.9138889 0.173537 0.9166667 0.174934 0.9194444 0.176332 0.9222222 0.174236 0.9250000 0.174236 0.9277778 0.177031 0.9305556 0.179825 0.9333333 0.184017 0.9361111 0.184017 0.9388889 0.183319 0.9416667 0.182620 0.9444444 0.184716 0.9472222 0.188908 0.9500000 0.192402 0.9527778 0.193799 0.9555556 0.190306 0.9583333 0.191703 0.9611111 0.192402 0.9638889 0.195197 0.9666667 0.198690 0.9694444 0.200087 0.9722222 0.197991 0.9750000 0.197991 0.9777778 0.198690 0.9805556 0.203581 0.9833333 0.209170 0.9861111 0.210568 0.9888889 0.210568 0.9916667 0.207773 0.9944444 0.209170 0.9972222 0.212664 1.0000000 0.218952 1.0027778 0.217555 1.0055556 0.216157 1.0083333 0.216157 1.0111111 0.216157 1.0138889 0.221048 1.0166667 0.225240 1.0194444 0.228035 1.0222222 0.228734 1.0250000 0.228734 1.0307778 0.300000 1.9275556 0.300000 1.9305556 0.307686 1.9333333 0.309782 1.9361111 0.309083 1.9388889 0.304891 1.9416667 0.304891 1.9444444 0.304891 1.9472222 0.306987 1.9500000 0.308384 1.9527778 0.307686 1.9555556 0.303493 1.9583333 0.303493 1.9611111 0.303493 1.9638889 0.307686 1.9666667 0.306987 1.9694444 0.306288 1.9722222 0.302096 1.9750000 0.302096 1.9777778 0.304891 1.9805556 0.306288 1.9833333 0.307686 1.9861111 0.305590 1.9888889 0.302096 1.9916667 0.302096 1.9944444 0.304891 1.9972222 0.306987 2.0000000 0.306288 2.0027778 0.306987 2.0055556 0.302096 2.0083333 0.302096 2.0111111 0.304192 2.0138889 0.304192 2.0166667 0.306987 2.0194444 0.306987 2.0222222 0.302096 2.0250000 0.300699 2.0277778 0.302795 2.0305556 0.305590 2.0333333 0.305590 2.0361111 0.304192 2.0388889 0.302795 2.0416667 0.301397 2.0444444 0.301397 2.0472222 0.304192 2.0500000 0.306288 2.0527778 0.304891 2.0555556 0.301397 2.0583333 0.300699 2.0611111 0.301397 2.0638889 0.304891 2.0666667 0.307686 2.0694444 0.306288 2.0722222 0.304192 2.0750000 0.302795 2.0777778 0.305590 2.0805556 0.306987 2.0833333 0.309782 2.0861111 0.309083 2.0888889 0.306987 2.0916667 0.304891 2.0944444 0.304891 2.0972222 0.308384 2.1000000 0.310480 2.1027778 0.309083 2.1055556 0.303493 2.1083333 0.300699 2.1111111 0.301397 2.1138889 0.302096 2.1166667 0.304192 2.1194444 0.303493 2.1222222 0.298603 2.1250000 0.295109 2.1277778 0.293712 2.1305556 0.292314 2.1333333 0.288821 2.1361111 0.283231 2.1388889 0.276943 2.1416667 0.267860 2.1444444 0.263668 2.1472222 0.261572 2.1500000 0.260873 2.1527778 0.262969 2.1555556 0.262271 2.1583333 0.258777 2.1611111 0.260175 2.1638889 0.266463 2.1666667 0.274847 2.1694444 0.288122 2.1722222 0.318865 2.1750000 0.360087 2.1777778 0.405502 2.1805556 0.435546 2.1833333 0.450218 2.1861111 0.455808 2.1888889 0.458603 2.1916667 0.464192 2.1944444 0.469083 2.1972222 0.471878 2.2000000 0.470480 2.2027778 0.462096 2.2055556 0.446026 2.2083333 0.428559 2.2111111 0.417380 2.2138889 0.413886 2.2166667 0.415983 2.2194444 0.416681 2.2222222 0.414585 2.2250000 0.411092 2.2277778 0.415284 2.2305556 0.425066 2.2333333 0.434847 2.2361111 0.437642 2.2388889 0.437642 2.2416667 0.433450 2.2444444 0.430655 2.2472222 0.427162 2.2500000 0.419476 2.2527778 0.405502 2.2555556 0.383843 2.2583333 0.363581 2.2611111 0.344017 2.2638889 0.330742 2.2666667 0.323057 2.2694444 0.317467 2.2722222 0.309782 2.2750000 0.300699 2.2777778 0.298603 2.2805556 0.298603 2.2833333 0.299301 2.2861111 0.298603 2.2888889 0.297205 2.2916667 0.291616 2.2944444 0.290917 2.2972222 0.291616 2.3000000 0.293013 2.3027778 0.295109 2.3055556 0.294410 2.3083333 0.290218 2.3111111 0.288821 2.3138889 0.289520 2.3166667 0.293013 2.3194444 0.294410 2.3222222 0.293013 2.3250000 0.288821 2.3277778 0.286725 2.3305556 0.287424 2.3333333 0.288821 2.3361111 0.292314 2.3388889 0.290917 2.3416667 0.289520 2.3444444 0.285328 2.3472222 0.286026 2.3500000 0.288821 2.3527778 0.290218 2.3555556 0.293013 2.3583333 0.286026 2.3611111 0.286026 2.3638889 0.286026 2.3666667 0.289520 2.3694444 0.292314 2.3722222 0.291616 2.3750000 0.290218 2.3777778 0.285328 2.3805556 0.289520 2.3833333 0.290917 2.3861111 0.293712 2.3888889 0.294410 2.3916667 0.288821 2.3944444 0.288821 2.3972222 0.290218 2.4000000 0.295109 2.4027778 0.296507 2.4055556 0.295808 2.4083333 0.292314 2.4111111 0.290218 2.4138889 0.291616 2.4166667 0.297205 2.4194444 0.297904 2.4222222 0.297904 2.4250000 0.295808 2.4277778 0.295808 2.4305556 0.296507 2.4333333 0.301397 2.4361111 0.304891 2.4388889 0.304891 2.4416667 0.301397 2.4444444 0.300000 2.4472222 0.303493 2.4500000 0.307686 2.4527778 0.309083 2.4555556 0.307686 2.4583333 0.306288 2.4611111 0.305590 2.4638889 0.309083 2.4666667 0.313275 2.4694444 0.316769 2.4722222 0.314672 2.4750000 0.309782 2.4777778 0.309782 2.4835556 0.300000 2.6025556 0.300000 2.6055556 0.344716 2.6083333 0.342620 2.6111111 0.346812 2.6138889 0.350306 2.6166667 0.352402 2.6194444 0.350306 2.6222222 0.347511 2.6250000 0.346812 2.6277778 0.350306 2.6305556 0.353100 2.6333333 0.356594 2.6361111 0.353799 2.6388889 0.353799 2.6416667 0.357991 2.6444444 0.361485 2.6472222 0.364978 2.6500000 0.362882 2.6527778 0.361485 2.6555556 0.361485 2.6583333 0.364279 2.6611111 0.367074 2.6638889 0.369170 2.6666667 0.367773 2.6694444 0.367074 2.6722222 0.364978 2.6750000 0.367773 2.6777778 0.371266 2.6805556 0.372664 2.6833333 0.369869 2.6861111 0.367773 2.6888889 0.367074 2.6916667 0.369869 2.6944444 0.371965 2.6972222 0.371266 2.7000000 0.369869 2.7027778 0.367773 2.7055556 0.368472 2.7083333 0.368472 2.7111111 0.370568 2.7138889 0.371266 2.7166667 0.369869 2.7194444 0.367074 2.7222222 0.367773 2.7250000 0.368472 2.7277778 0.370568 2.7305556 0.371965 2.7333333 0.368472 2.7361111 0.367773 2.7388889 0.365677 2.7416667 0.367773 2.7444444 0.371965 2.7472222 0.371266 2.7500000 0.369170 2.7527778 0.368472 2.7555556 0.367773 2.7583333 0.369170 2.7611111 0.371965 2.7638889 0.371965 2.7666667 0.369170 2.7694444 0.368472 2.7722222 0.367773 2.7750000 0.366376 2.7777778 0.365677 2.7805556 0.364978 2.7833333 0.361485 2.7861111 0.355197 2.7888889 0.351703 2.7916667 0.349607 2.7944444 0.348908 2.7972222 0.348908 2.8000000 0.348908 2.8027778 0.348210 2.8055556 0.348210 2.8083333 0.345415 2.8111111 0.344716 2.8138889 0.344716 2.8166667 0.344716 2.8194444 0.348210 2.8222222 0.348908 2.8250000 0.349607 2.8277778 0.346812 2.8305556 0.348210 2.8333333 0.347511 2.8361111 0.349607 2.8388889 0.350306 2.8416667 0.345415 2.8444444 0.332140 2.8472222 0.321659 2.8500000 0.311179 2.8527778 0.302795 2.8555556 0.296507 2.8583333 0.290917 2.8611111 0.286026 2.8638889 0.284629 2.8666667 0.290218 2.8694444 0.299301 2.8722222 0.307686 2.8750000 0.315371 2.8777778 0.318865 2.8805556 0.321659 2.8833333 0.323755 2.8861111 0.323755 2.8888889 0.319563 2.8916667 0.308384 2.8944444 0.295808 2.8972222 0.277642 2.9000000 0.256681 2.9027778 0.235022 2.9055556 0.213362 2.9083333 0.193100 2.9111111 0.179127 2.9138889 0.172140 2.9166667 0.167948 2.9194444 0.165852 2.9222222 0.160961 2.9250000 0.156769 2.9277778 0.156070 2.9305556 0.154672 2.9333333 0.156769 2.9361111 0.156769 2.9388889 0.152576 2.9416667 0.151179 2.9444444 0.149782 2.9472222 0.149782 2.9500000 0.149782 2.9527778 0.150480 2.9555556 0.151179 2.9583333 0.148384 2.9611111 0.147686 2.9638889 0.148384 2.9666667 0.149083 2.9694444 0.149083 2.9722222 0.146288 2.9750000 0.144891 2.9777778 0.144891 2.9805556 0.147686 2.9833333 0.148384 2.9861111 0.147686 2.9888889 0.144891 2.9916667 0.144192 2.9944444 0.144192 2.9972222 0.147686 3.0000000 0.151179 3.0027778 0.150480 3.0055556 0.147686 3.0083333 0.146288 3.0111111 0.149083 3.0138889 0.152576 3.0166667 0.156070 3.0194444 0.153974 3.0222222 0.153275 3.0250000 0.152576 3.0277778 0.155371 3.0305556 0.159563 3.0333333 0.163057 3.0361111 0.163057 3.0388889 0.160262 3.0416667 0.160961 3.0444444 0.163755 3.0472222 0.168646 3.0500000 0.172140 3.0527778 0.170742 3.0555556 0.168646 3.0583333 0.167948 3.0611111 0.174236 3.0638889 0.178428 3.0666667 0.184017 3.0694444 0.182620 3.0722222 0.180524 3.0750000 0.181921 3.0777778 0.186812 3.0805556 0.192402 3.0833333 0.195197 3.0861111 0.192402 3.0888889 0.191703 3.0916667 0.194498 3.0944444 0.198690 3.0972222 0.204978 3.1000000 0.205677 3.1027778 0.205677 3.1055556 0.204279 3.1083333 0.206376 3.1111111 0.211266 3.1138889 0.214760 3.1166667 0.215459 3.1194444 0.213362 3.1222222 0.211965 3.1250000 0.215459 3.1277778 0.221747 3.1305556 0.226638 3.1333333 0.225240 3.1361111 0.225240 3.1388889 0.224541 3.1416667 0.227336 3.1444444 0.232926 3.1472222 0.234323 3.1500000 0.236419 3.1527778 0.233624 3.1585556 0.300000 4.0192222 0.300000 4.0222222 0.334934 4.0250000 0.336332 4.0277778 0.337031 4.0305556 0.337031 4.0333333 0.335633 4.0361111 0.333537 4.0388889 0.335633 4.0416667 0.337729 4.0444444 0.336332 4.0472222 0.337729 4.0500000 0.335633 4.0527778 0.334236 4.0555556 0.335633 4.0583333 0.335633 4.0611111 0.336332 4.0638889 0.336332 4.0666667 0.335633 4.0694444 0.334934 4.0722222 0.337031 4.0750000 0.337031 4.0777778 0.337729 4.0805556 0.337031 4.0833333 0.335633 4.0861111 0.335633 4.0888889 0.337729 4.0916667 0.337031 4.0944444 0.337031 4.0972222 0.338428 4.1000000 0.336332 4.1027778 0.336332 4.1055556 0.337031 4.1083333 0.338428 4.1111111 0.339825 4.1138889 0.339825 4.1166667 0.337729 4.1194444 0.338428 4.1222222 0.337729 4.1250000 0.339825 4.1277778 0.339825 4.1305556 0.341223 4.1333333 0.337729 4.1361111 0.337729 4.1388889 0.338428 4.1416667 0.341223 4.1444444 0.342620 4.1472222 0.341223 4.1500000 0.340524 4.1527778 0.340524 4.1555556 0.340524 4.1583333 0.341921 4.1611111 0.343319 4.1638889 0.341223 4.1666667 0.341223 4.1694444 0.340524 4.1722222 0.340524 4.1750000 0.343319 4.1777778 0.341921 4.1805556 0.343319 4.1833333 0.340524 4.1861111 0.337729 4.1888889 0.337729 4.1916667 0.339127 4.1944444 0.343319 4.1972222 0.341921 4.2000000 0.341223 4.2027778 0.339825 4.2055556 0.339825 4.2083333 0.341921 4.2111111 0.341223 4.2138889 0.341223 4.2166667 0.337031 4.2194444 0.335633 4.2222222 0.334934 4.2250000 0.332140 4.2277778 0.326550 4.2305556 0.320961 4.2333333 0.313275 4.2361111 0.308384 4.2388889 0.304891 4.2416667 0.302096 4.2444444 0.301397 4.2472222 0.302096 4.2500000 0.306288 4.2527778 0.305590 4.2555556 0.309782 4.2583333 0.316070 4.2611111 0.330742 4.2638889 0.360786 4.2666667 0.408996 4.2694444 0.453013 4.2722222 0.478166 4.2750000 0.485153 4.2777778 0.487948 4.2805556 0.495633 4.2833333 0.506114 4.2861111 0.511703 4.2888889 0.511004 4.2916667 0.501921 4.2944444 0.491441 4.2972222 0.478865 4.3000000 0.467686 4.3027778 0.460699 4.3055556 0.458603 4.3083333 0.459301 4.3111111 0.457205 4.3138889 0.458603 4.3166667 0.460699 4.3194444 0.466288 4.3222222 0.474672 4.3250000 0.479563 4.3277778 0.478865 4.3305556 0.478865 4.3333333 0.479563 4.3361111 0.475371 4.3388889 0.469782 4.3416667 0.456507 4.3444444 0.440437 4.3472222 0.421572 4.3500000 0.402009 4.3527778 0.384541 4.3555556 0.369170 4.3583333 0.360786 4.3611111 0.352402 4.3638889 0.348210 4.3666667 0.346114 4.3694444 0.344716 4.3722222 0.341223 4.3750000 0.340524 4.3777778 0.339825 4.3805556 0.337729 4.3833333 0.338428 4.3861111 0.337729 4.3888889 0.337729 4.3916667 0.336332 4.3944444 0.335633 4.3972222 0.337031 4.4000000 0.334236 4.4027778 0.336332 4.4055556 0.337031 4.4083333 0.335633 4.4111111 0.332140 4.4138889 0.334236 4.4166667 0.336332 4.4194444 0.337031 4.4222222 0.334934 4.4250000 0.332140 4.4277778 0.332140 4.4305556 0.333537 4.4333333 0.336332 4.4361111 0.336332 4.4388889 0.332838 4.4416667 0.331441 4.4444444 0.332140 4.4472222 0.337031 4.4500000 0.337729 4.4527778 0.334236 4.4555556 0.331441 4.4583333 0.331441 4.4611111 0.333537 4.4638889 0.337729 4.4666667 0.339825 4.4694444 0.337729 4.4722222 0.332838 4.4750000 0.332838 4.4777778 0.337031 4.4805556 0.341223 4.4833333 0.341223 4.4861111 0.337729 4.4888889 0.335633 4.4916667 0.335633 4.4944444 0.339127 4.4972222 0.343319 4.5000000 0.342620 4.5027778 0.341223 4.5055556 0.337031 4.5083333 0.337729 4.5111111 0.343319 4.5138889 0.347511 4.5166667 0.347511 4.5194444 0.344716 4.5222222 0.344716 4.5250000 0.344017 4.5277778 0.349607 4.5305556 0.352402 4.5333333 0.351703 4.5361111 0.349607 4.5388889 0.347511 4.5416667 0.350306 4.5444444 0.354498 4.5472222 0.357293 4.5500000 0.355895 4.5527778 0.353799 4.5555556 0.355197 4.5583333 0.355895 4.5611111 0.360786 4.5638889 0.362882 4.5666667 0.360786 4.5694444 0.360087 4.5752222 0.300000 4.6664444 0.300000 4.6694444 0.383144 4.6722222 0.383843 4.6750000 0.385939 4.6777778 0.389432 4.6805556 0.389432 4.6833333 0.388035 4.6861111 0.385939 4.6888889 0.386638 4.6916667 0.390131 4.6944444 0.392926 4.6972222 0.395022 4.7000000 0.392227 4.7027778 0.392227 4.7055556 0.391528 4.7083333 0.396419 4.7111111 0.399913 4.7138889 0.399214 4.7166667 0.397817 4.7194444 0.397817 4.7222222 0.399214 4.7250000 0.402009 4.7277778 0.406900 4.7305556 0.406900 4.7333333 0.403406 4.7361111 0.402707 4.7388889 0.404803 4.7416667 0.406900 4.7444444 0.408297 4.7472222 0.406900 4.7500000 0.404105 4.7527778 0.404803 4.7555556 0.404105 4.7583333 0.406201 4.7611111 0.406201 4.7638889 0.406900 4.7666667 0.406201 4.7694444 0.403406 4.7722222 0.403406 4.7750000 0.402707 4.7777778 0.404803 4.7805556 0.405502 4.7833333 0.403406 4.7861111 0.400611 4.7888889 0.402707 4.7916667 0.404105 4.7944444 0.404803 4.7972222 0.402707 4.8000000 0.402009 4.8027778 0.402009 4.8055556 0.402707 4.8083333 0.404105 4.8111111 0.402707 4.8138889 0.402707 4.8166667 0.402009 4.8194444 0.401310 4.8222222 0.402009 4.8250000 0.401310 4.8277778 0.399913 4.8305556 0.399214 4.8333333 0.400611 4.8361111 0.398515 4.8388889 0.398515 4.8416667 0.398515 4.8444444 0.395022 4.8472222 0.392926 4.8500000 0.390830 4.8527778 0.386638 4.8555556 0.384541 4.8583333 0.378952 4.8611111 0.373362 4.8638889 0.369170 4.8666667 0.367074 4.8694444 0.367074 4.8722222 0.367074 4.8750000 0.371266 4.8777778 0.374061 4.8805556 0.378952 4.8833333 0.383144 4.8861111 0.383144 4.8888889 0.381747 4.8916667 0.379651 4.8944444 0.384541 4.8972222 0.392227 4.9000000 0.399214 4.9027778 0.399214 4.9055556 0.395721 4.9083333 0.388734 4.9111111 0.382445 4.9138889 0.375459 4.9166667 0.366376 4.9194444 0.356594 4.9222222 0.346812 4.9250000 0.341921 4.9277778 0.345415 4.9305556 0.351703 4.9333333 0.357293 4.9361111 0.361485 4.9388889 0.362183 4.9416667 0.365677 4.9444444 0.367074 4.9472222 0.367773 4.9500000 0.362183 4.9527778 0.348210 4.9555556 0.325852 4.9583333 0.306288 4.9611111 0.290218 4.9638889 0.276943 4.9666667 0.260175 4.9694444 0.242707 4.9722222 0.228734 4.9750000 0.216157 4.9777778 0.209869 4.9805556 0.206376 4.9833333 0.202183 4.9861111 0.195895 4.9888889 0.193100 4.9916667 0.190306 4.9944444 0.190306 4.9972222 0.191703 5.0000000 0.191004 5.0027778 0.187511 5.0055556 0.183319 5.0083333 0.181921 5.0111111 0.181921 5.0138889 0.184716 5.0166667 0.184017 5.0194444 0.181921 5.0222222 0.177031 5.0250000 0.175633 5.0277778 0.178428 5.0305556 0.179825 5.0333333 0.181223 5.0361111 0.177729 5.0388889 0.174236 5.0416667 0.172838 5.0444444 0.174934 5.0472222 0.177729 5.0500000 0.177031 5.0527778 0.174236 5.0555556 0.170742 5.0583333 0.170044 5.0611111 0.172140 5.0638889 0.174934 5.0666667 0.174934 5.0694444 0.171441 5.0722222 0.168646 5.0750000 0.168646 5.0777778 0.172140 5.0805556 0.175633 5.0833333 0.177031 5.0861111 0.174934 5.0888889 0.170742 5.0916667 0.171441 5.0944444 0.176332 5.0972222 0.179127 5.1000000 0.181223 5.1027778 0.179825 5.1055556 0.176332 5.1083333 0.175633 5.1111111 0.180524 5.1138889 0.184017 5.1166667 0.186114 5.1194444 0.184716 5.1222222 0.184017 5.1250000 0.182620 5.1277778 0.187511 5.1305556 0.190306 5.1333333 0.193799 5.1361111 0.193799 5.1388889 0.190306 5.1416667 0.191004 5.1444444 0.193799 5.1472222 0.196594 5.1500000 0.200087 5.1527778 0.197991 5.1555556 0.198690 5.1583333 0.197991 5.1611111 0.200786 5.1638889 0.206376 5.1666667 0.209170 5.1694444 0.209170 5.1722222 0.207074 5.1750000 0.207074 5.1777778 0.208472 5.1805556 0.211965 5.1833333 0.215459 5.1861111 0.214061 5.1888889 0.215459 5.1916667 0.214760 5.1944444 0.215459 5.1972222 0.218952 5.2000000 0.222445 5.2027778 0.221048 5.2055556 0.224541 5.2083333 0.223843 5.2111111 0.225939 5.2138889 0.228734 5.2166667 0.232227 5.2224444 0.300000 6.1136667 0.300000 6.1166667 0.266463 6.1194444 0.265066 6.1222222 0.261572 6.1250000 0.263668 6.1277778 0.265066 6.1305556 0.268559 6.1333333 0.267860 6.1361111 0.265764 6.1388889 0.262271 6.1416667 0.262271 6.1444444 0.264367 6.1472222 0.266463 6.1500000 0.268559 6.1527778 0.267162 6.1555556 0.262969 6.1583333 0.262271 6.1611111 0.264367 6.1638889 0.267162 6.1666667 0.267860 6.1694444 0.265764 6.1722222 0.264367 6.1750000 0.263668 6.1777778 0.264367 6.1805556 0.267162 6.1833333 0.268559 6.1861111 0.268559 6.1888889 0.265764 6.1916667 0.263668 6.1944444 0.265066 6.1972222 0.265764 6.2000000 0.268559 6.2027778 0.267860 6.2055556 0.265764 6.2083333 0.265066 6.2111111 0.265066 6.2138889 0.266463 6.2166667 0.267162 6.2194444 0.267162 6.2222222 0.265764 6.2250000 0.265066 6.2277778 0.265764 6.2305556 0.267162 6.2333333 0.268559 6.2361111 0.267860 6.2388889 0.265764 6.2416667 0.263668 6.2444444 0.265764 6.2472222 0.267860 6.2500000 0.269258 6.2527778 0.269258 6.2555556 0.267162 6.2583333 0.265764 6.2611111 0.268559 6.2638889 0.269258 6.2666667 0.271354 6.2694444 0.270655 6.2722222 0.269956 6.2750000 0.270655 6.2777778 0.269258 6.2805556 0.271354 6.2833333 0.274148 6.2861111 0.273450 6.2888889 0.272052 6.2916667 0.271354 6.2944444 0.267860 6.2972222 0.270655 6.3000000 0.268559 6.3027778 0.268559 6.3055556 0.267162 6.3083333 0.264367 6.3111111 0.264367 6.3138889 0.264367 6.3166667 0.261572 6.3194444 0.258079 6.3222222 0.252489 6.3250000 0.244803 6.3277778 0.239913 6.3305556 0.235721 6.3333333 0.230131 6.3361111 0.228734 6.3388889 0.225240 6.3416667 0.224541 6.3444444 0.228035 6.3472222 0.229432 6.3500000 0.231528 6.3527778 0.235721 6.3555556 0.243406 6.3583333 0.260873 6.3611111 0.297205 6.3638889 0.341223 6.3666667 0.380349 6.3694444 0.399913 6.3722222 0.406201 6.3750000 0.410393 6.3777778 0.416681 6.3805556 0.427860 6.3833333 0.432751 6.3861111 0.428559 6.3888889 0.418777 6.3916667 0.405502 6.3944444 0.394323 6.3972222 0.386638 6.4000000 0.381747 6.4027778 0.379651 6.4055556 0.376856 6.4083333 0.376157 6.4111111 0.377555 6.4138889 0.383843 6.4166667 0.392227 6.4194444 0.395721 6.4222222 0.396419 6.4250000 0.396419 6.4277778 0.397817 6.4305556 0.398515 6.4333333 0.392227 6.4361111 0.381747 6.4388889 0.364279 6.4416667 0.345415 6.4444444 0.327249 6.4472222 0.311878 6.4500000 0.297904 6.4527778 0.288122 6.4555556 0.279738 6.4583333 0.272052 6.4611111 0.269956 6.4638889 0.269258 6.4666667 0.269956 6.4694444 0.266463 6.4722222 0.263668 6.4750000 0.260873 6.4777778 0.260873 6.4805556 0.263668 6.4833333 0.263668 6.4861111 0.262969 6.4888889 0.258777 6.4916667 0.258079 6.4944444 0.258777 6.4972222 0.261572 6.5000000 0.261572 6.5027778 0.261572 6.5055556 0.258079 6.5083333 0.255983 6.5111111 0.257380 6.5138889 0.260175 6.5166667 0.260873 6.5194444 0.260873 6.5222222 0.256681 6.5250000 0.255284 6.5277778 0.258079 6.5305556 0.261572 6.5333333 0.262969 6.5361111 0.260873 6.5388889 0.257380 6.5416667 0.255983 6.5444444 0.258079 6.5472222 0.261572 6.5500000 0.262271 6.5527778 0.260175 6.5555556 0.257380 6.5583333 0.256681 6.5611111 0.260175 6.5638889 0.263668 6.5666667 0.264367 6.5694444 0.262271 6.5722222 0.260175 6.5750000 0.258777 6.5777778 0.260175 6.5805556 0.263668 6.5833333 0.265066 6.5861111 0.264367 6.5888889 0.263668 6.5916667 0.261572 6.5944444 0.263668 6.5972222 0.267860 6.6000000 0.267162 6.6027778 0.267162 6.6055556 0.265066 6.6083333 0.264367 6.6111111 0.266463 6.6138889 0.271354 6.6166667 0.272751 6.6194444 0.271354 6.6222222 0.269956 6.6250000 0.269258 6.6277778 0.269956 6.6305556 0.274847 6.6333333 0.275546 6.6361111 0.276245 6.6388889 0.271354 6.6416667 0.272052 6.6444444 0.275546 6.6472222 0.279039 6.6500000 0.281135 6.6527778 0.280437 6.6555556 0.276943 6.6583333 0.276943 6.6611111 0.281135 6.6638889 0.283930 6.6696667 0.300000 6.8108889 0.300000 6.8138889 0.312576 6.8166667 0.312576 6.8194444 0.311878 6.8222222 0.313275 6.8250000 0.317467 6.8277778 0.320262 6.8305556 0.320262 6.8333333 0.317467 6.8361111 0.316070 6.8388889 0.318865 6.8416667 0.322358 6.8444444 0.326550 6.8472222 0.325852 6.8500000 0.324454 6.8527778 0.324454 6.8555556 0.323755 6.8583333 0.329345 6.8611111 0.331441 6.8638889 0.330044 6.8666667 0.329345 6.8694444 0.325852 6.8722222 0.327948 6.8750000 0.331441 6.8777778 0.333537 6.8805556 0.333537 6.8833333 0.332140 6.8861111 0.327948 6.8888889 0.328646 6.8916667 0.332838 6.8944444 0.333537 6.8972222 0.334236 6.9000000 0.330044 6.9027778 0.327948 6.9055556 0.327249 6.9083333 0.330044 6.9111111 0.332140 6.9138889 0.332838 6.9166667 0.330044 6.9194444 0.328646 6.9222222 0.327249 6.9250000 0.330742 6.9277778 0.331441 6.9305556 0.332838 6.9333333 0.330044 6.9361111 0.325852 6.9388889 0.325153 6.9416667 0.329345 6.9444444 0.330742 6.9472222 0.333537 6.9500000 0.330742 6.9527778 0.327249 6.9555556 0.325852 6.9583333 0.327249 6.9611111 0.330742 6.9638889 0.332140 6.9666667 0.330742 6.9694444 0.327249 6.9722222 0.325852 6.9750000 0.324454 6.9777778 0.327249 6.9805556 0.327948 6.9833333 0.325852 6.9861111 0.320961 6.9888889 0.316769 6.9916667 0.314672 6.9944444 0.316070 6.9972222 0.311878 7.0000000 0.307686 7.0027778 0.300000 7.0055556 0.290917 7.0083333 0.288821 7.0111111 0.289520 7.0138889 0.293013 7.0166667 0.295109 7.0194444 0.293013 7.0222222 0.292314 7.0250000 0.293712 7.0277778 0.297205 7.0305556 0.297904 7.0333333 0.294410 7.0361111 0.290917 7.0388889 0.288122 7.0416667 0.290218 7.0444444 0.295109 7.0472222 0.296507 7.0500000 0.297205 7.0527778 0.293013 7.0555556 0.286725 7.0583333 0.281135 7.0611111 0.277642 7.0638889 0.271354 7.0666667 0.265066 7.0694444 0.258079 7.0722222 0.255983 7.0750000 0.257380 7.0777778 0.265764 7.0805556 0.274148 7.0833333 0.283930 7.0861111 0.288122 7.0888889 0.289520 7.0916667 0.292314 7.0944444 0.294410 7.0972222 0.295808 7.1000000 0.288821 7.1027778 0.280437 7.1055556 0.269258 7.1083333 0.259476 7.1111111 0.250393 7.1138889 0.238515 7.1166667 0.218253 7.1194444 0.196594 7.1222222 0.174236 7.1250000 0.159563 7.1277778 0.149083 7.1305556 0.145590 7.1333333 0.140699 7.1361111 0.133712 7.1388889 0.128122 7.1416667 0.126026 7.1444444 0.124629 7.1472222 0.125328 7.1500000 0.124629 7.1527778 0.122533 7.1555556 0.118341 7.1583333 0.116943 7.1611111 0.116245 7.1638889 0.119039 7.1666667 0.120437 7.1694444 0.116943 7.1722222 0.115546 7.1750000 0.112751 7.1777778 0.114847 7.1805556 0.115546 7.1833333 0.115546 7.1861111 0.114148 7.1888889 0.111354 7.1916667 0.110655 7.1944444 0.111354 7.1972222 0.113450 7.2000000 0.113450 7.2027778 0.112052 7.2055556 0.109956 7.2083333 0.109258 7.2111111 0.109956 7.2138889 0.110655 7.2166667 0.114847 7.2194444 0.113450 7.2222222 0.112751 7.2250000 0.112052 7.2277778 0.113450 7.2305556 0.116943 7.2333333 0.117642 7.2361111 0.117642 7.2388889 0.116943 7.2416667 0.116943 7.2444444 0.118341 7.2472222 0.121834 7.2500000 0.123231 7.2527778 0.123231 7.2555556 0.123930 7.2583333 0.123231 7.2611111 0.126026 7.2638889 0.129520 7.2666667 0.132314 7.2694444 0.132314 7.2722222 0.133013 7.2750000 0.132314 7.2777778 0.135109 7.2805556 0.139301 7.2833333 0.141397 7.2861111 0.142795 7.2888889 0.141397 7.2916667 0.142795 7.2944444 0.144891 7.2972222 0.148384 7.3000000 0.151179 7.3027778 0.152576 7.3055556 0.151878 7.3083333 0.153275 7.3111111 0.153974 7.3138889 0.159563 7.3166667 0.160961 7.3194444 0.161659 7.3222222 0.163057 7.3250000 0.163755 7.3277778 0.165852 7.3305556 0.169345 7.3333333 0.172838 7.3361111 0.174934 7.3388889 0.174934 7.3416667 0.174934 7.3444444 0.177729 7.3472222 0.179825 7.3500000 0.184017 7.3527778 0.184017 7.3555556 0.185415 7.3583333 0.184716 7.3611111 0.188908 7.3668889 0.300000 8.2497778 0.300000 8.2527778 0.269258 8.2555556 0.271354 8.2583333 0.272751 8.2611111 0.274148 8.2638889 0.271354 8.2666667 0.270655 8.2694444 0.271354 8.2722222 0.270655 8.2750000 0.272751 8.2777778 0.274847 8.2805556 0.271354 8.2833333 0.270655 8.2861111 0.269956 8.2888889 0.270655 8.2916667 0.272751 8.2944444 0.272751 8.2972222 0.269956 8.3000000 0.269956 8.3027778 0.269258 8.3055556 0.271354 8.3083333 0.272052 8.3111111 0.272052 8.3138889 0.270655 8.3166667 0.270655 8.3194444 0.269956 8.3222222 0.272751 8.3250000 0.272751 8.3277778 0.272751 8.3305556 0.271354 8.3333333 0.272052 8.3361111 0.272052 8.3388889 0.272052 8.3416667 0.273450 8.3444444 0.271354 8.3472222 0.270655 8.3500000 0.270655 8.3527778 0.271354 8.3555556 0.271354 8.3583333 0.272751 8.3611111 0.272751 8.3638889 0.271354 8.3666667 0.271354 8.3694444 0.272751 8.3722222 0.274148 8.3750000 0.274148 8.3777778 0.272052 8.3805556 0.272751 8.3833333 0.274847 8.3861111 0.274148 8.3888889 0.272751 8.3916667 0.272052 8.3944444 0.272052 8.3972222 0.272751 8.4000000 0.274847 8.4027778 0.274847 8.4055556 0.272052 8.4083333 0.272751 8.4111111 0.273450 8.4138889 0.273450 8.4166667 0.275546 8.4194444 0.275546 8.4222222 0.272751 8.4250000 0.270655 8.4277778 0.274847 8.4305556 0.274847 8.4333333 0.276245 8.4361111 0.274148 8.4388889 0.274148 8.4416667 0.272751 8.4444444 0.274148 8.4472222 0.277642 8.4500000 0.277642 8.4527778 0.274847 8.4555556 0.269258 8.4583333 0.266463 8.4611111 0.261572 8.4638889 0.259476 8.4666667 0.255284 8.4694444 0.247598 8.4722222 0.240611 8.4750000 0.236419 8.4777778 0.239214 8.4805556 0.242009 8.4833333 0.244803 8.4861111 0.242707 8.4888889 0.242707 8.4916667 0.250393 8.4944444 0.269956 8.4972222 0.304891 8.5000000 0.349607 8.5027778 0.384541 8.5055556 0.401310 8.5083333 0.411092 8.5111111 0.420175 8.5138889 0.429956 8.5166667 0.434847 8.5194444 0.433450 8.5222222 0.427860 8.5250000 0.420175 8.5277778 0.410393 8.5305556 0.399214 8.5333333 0.386638 8.5361111 0.378253 8.5388889 0.378253 8.5416667 0.378952 8.5444444 0.381048 8.5472222 0.382445 8.5500000 0.387336 8.5527778 0.390131 8.5555556 0.394323 8.5583333 0.399913 8.5611111 0.404803 8.5638889 0.406201 8.5666667 0.402707 8.5694444 0.392227 8.5722222 0.381747 8.5750000 0.367074 8.5777778 0.354498 8.5805556 0.334236 8.5833333 0.314672 8.5861111 0.298603 8.5888889 0.288821 8.5916667 0.285328 8.5944444 0.283231 8.5972222 0.282533 8.6000000 0.275546 8.6027778 0.273450 8.6055556 0.269956 8.6083333 0.272052 8.6111111 0.274148 8.6138889 0.274148 8.6166667 0.271354 8.6194444 0.267162 8.6222222 0.264367 8.6250000 0.267860 8.6277778 0.272052 8.6305556 0.270655 8.6333333 0.269258 8.6361111 0.266463 8.6388889 0.262969 8.6416667 0.265066 8.6444444 0.270655 8.6472222 0.270655 8.6500000 0.268559 8.6527778 0.265066 8.6555556 0.264367 8.6583333 0.265066 8.6611111 0.268559 8.6638889 0.270655 8.6666667 0.267162 8.6694444 0.262969 8.6722222 0.262969 8.6750000 0.265764 8.6777778 0.269258 8.6805556 0.269258 8.6833333 0.267860 8.6861111 0.265066 8.6888889 0.264367 8.6916667 0.265764 8.6944444 0.269956 8.6972222 0.268559 8.7000000 0.267860 8.7027778 0.265764 8.7055556 0.265764 8.7083333 0.268559 8.7111111 0.272052 8.7138889 0.272052 8.7166667 0.271354 8.7194444 0.268559 8.7222222 0.266463 8.7250000 0.269258 8.7277778 0.273450 8.7305556 0.274148 8.7333333 0.272052 8.7361111 0.272052 8.7388889 0.270655 8.7416667 0.271354 8.7444444 0.277642 8.7472222 0.277642 8.7500000 0.276943 8.7527778 0.274847 8.7555556 0.272751 8.7583333 0.275546 8.7611111 0.281135 8.7638889 0.282533 8.7666667 0.281135 8.7694444 0.279738 8.7722222 0.278341 8.7750000 0.279738 8.7777778 0.283231 8.7805556 0.286026 8.7833333 0.287424 8.7861111 0.283231 8.7888889 0.283930 8.7916667 0.286026 8.7944444 0.290218 8.7972222 0.291616 8.8000000 0.290917 8.8057778 0.300000 8.9331111 0.300000 8.9361111 0.318865 8.9388889 0.320961 8.9416667 0.323755 8.9444444 0.325852 8.9472222 0.331441 8.9500000 0.327249 8.9527778 0.325852 8.9555556 0.327249 8.9583333 0.330044 8.9611111 0.334236 8.9638889 0.337031 8.9666667 0.334236 8.9694444 0.334236 8.9722222 0.332140 8.9750000 0.334934 8.9777778 0.340524 8.9805556 0.341921 8.9833333 0.341223 8.9861111 0.338428 8.9888889 0.336332 8.9916667 0.339127 8.9944444 0.343319 8.9972222 0.344017 9.0000000 0.343319 9.0027778 0.339825 9.0055556 0.339825 9.0083333 0.343319 9.0111111 0.344716 9.0138889 0.346114 9.0166667 0.344017 9.0194444 0.340524 9.0222222 0.340524 9.0250000 0.341921 9.0277778 0.346114 9.0305556 0.348210 9.0333333 0.344017 9.0361111 0.341223 9.0388889 0.339825 9.0416667 0.339825 9.0444444 0.344716 9.0472222 0.346114 9.0500000 0.343319 9.0527778 0.340524 9.0555556 0.338428 9.0583333 0.341223 9.0611111 0.345415 9.0638889 0.345415 9.0666667 0.342620 9.0694444 0.339127 9.0722222 0.341223 9.0750000 0.343319 9.0777778 0.346114 9.0805556 0.344716 9.0833333 0.341921 9.0861111 0.339127 9.0888889 0.341223 9.0916667 0.344017 9.0944444 0.346812 9.0972222 0.344716 9.1000000 0.341921 9.1027778 0.337031 9.1055556 0.335633 9.1083333 0.336332 9.1111111 0.337031 9.1138889 0.334934 9.1166667 0.329345 9.1194444 0.322358 9.1222222 0.319563 9.1250000 0.318166 9.1277778 0.314672 9.1305556 0.311878 9.1333333 0.307686 9.1361111 0.307686 9.1388889 0.309782 9.1416667 0.312576 9.1444444 0.313974 9.1472222 0.309083 9.1500000 0.305590 9.1527778 0.301397 9.1555556 0.300699 9.1583333 0.302096 9.1611111 0.305590 9.1638889 0.309083 9.1666667 0.311878 9.1694444 0.311878 9.1722222 0.318865 9.1750000 0.323755 9.1777778 0.321659 9.1805556 0.312576 9.1833333 0.302096 9.1861111 0.293013 9.1888889 0.290218 9.1916667 0.293013 9.1944444 0.296507 9.1972222 0.298603 9.2000000 0.297205 9.2027778 0.299301 9.2055556 0.305590 9.2083333 0.315371 9.2111111 0.318865 9.2138889 0.316070 9.2166667 0.308384 9.2194444 0.302795 9.2222222 0.299301 9.2250000 0.296507 9.2277778 0.287424 9.2305556 0.272052 9.2333333 0.255983 9.2361111 0.236419 9.2388889 0.218952 9.2416667 0.202882 9.2444444 0.188210 9.2472222 0.172140 9.2500000 0.158865 9.2527778 0.147686 9.2555556 0.146288 9.2583333 0.145590 9.2611111 0.146987 9.2638889 0.143493 9.2666667 0.138603 9.2694444 0.136507 9.2722222 0.138603 9.2750000 0.139301 9.2777778 0.139301 9.2805556 0.137205 9.2833333 0.133013 9.2861111 0.132314 9.2888889 0.130917 9.2916667 0.135808 9.2944444 0.134410 9.2972222 0.130218 9.3000000 0.129520 9.3027778 0.127424 9.3055556 0.130218 9.3083333 0.133013 9.3111111 0.133013 9.3138889 0.130917 9.3166667 0.127424 9.3194444 0.128122 9.3222222 0.130917 9.3250000 0.133712 9.3277778 0.133013 9.3305556 0.130218 9.3333333 0.129520 9.3361111 0.128821 9.3388889 0.131616 9.3416667 0.133712 9.3444444 0.134410 9.3472222 0.133712 9.3500000 0.132314 9.3527778 0.132314 9.3555556 0.136507 9.3583333 0.140699 9.3611111 0.139301 9.3638889 0.141397 9.3666667 0.140000 9.3694444 0.140699 9.3722222 0.142795 9.3750000 0.146987 9.3777778 0.146288 9.3805556 0.147686 9.3833333 0.148384 9.3861111 0.150480 9.3888889 0.153974 9.3916667 0.154672 9.3944444 0.155371 9.3972222 0.156769 9.4000000 0.160961 9.4027778 0.160262 9.4055556 0.163755 9.4083333 0.165852 9.4111111 0.164454 9.4138889 0.167948 9.4166667 0.170044 9.4194444 0.172838 9.4222222 0.174236 9.4250000 0.174934 9.4277778 0.177031 9.4305556 0.179825 9.4333333 0.182620 9.4361111 0.183319 9.4388889 0.186812 9.4416667 0.188210 9.4444444 0.189607 9.4472222 0.191004 9.4500000 0.193799 9.4527778 0.194498 9.4555556 0.196594 9.4583333 0.197991 9.4611111 0.199389 9.4638889 0.202882 9.4666667 0.203581 9.4694444 0.205677 9.4722222 0.206376 9.4750000 0.207773 9.4777778 0.210568 9.4805556 0.212664 9.4833333 0.216856 9.4891111 0.300000 10.3220000 0.300000 10.3250000 0.288122 10.3277778 0.288821 10.3305556 0.291616 10.3333333 0.290917 10.3361111 0.290218 10.3388889 0.288122 10.3416667 0.287424 10.3444444 0.289520 10.3472222 0.291616 10.3500000 0.291616 10.3527778 0.288821 10.3555556 0.288122 10.3583333 0.288122 10.3611111 0.290218 10.3638889 0.293712 10.3666667 0.290917 10.3694444 0.289520 10.3722222 0.286725 10.3750000 0.289520 10.3777778 0.290917 10.3805556 0.293013 10.3833333 0.291616 10.3861111 0.290218 10.3888889 0.286725 10.3916667 0.288821 10.3944444 0.292314 10.3972222 0.293013 10.4000000 0.293013 10.4027778 0.288122 10.4055556 0.287424 10.4083333 0.291616 10.4111111 0.293712 10.4138889 0.293013 10.4166667 0.291616 10.4194444 0.286725 10.4222222 0.288821 10.4250000 0.290917 10.4277778 0.295109 10.4305556 0.291616 10.4333333 0.290218 10.4361111 0.287424 10.4388889 0.290917 10.4416667 0.294410 10.4444444 0.294410 10.4472222 0.293712 10.4500000 0.290218 10.4527778 0.288821 10.4555556 0.288821 10.4583333 0.293712 10.4611111 0.293712 10.4638889 0.293013 10.4666667 0.289520 10.4694444 0.288821 10.4722222 0.290917 10.4750000 0.293013 10.4777778 0.293712 10.4805556 0.290917 10.4833333 0.290917 10.4861111 0.289520 10.4888889 0.292314 10.4916667 0.294410 10.4944444 0.293013 10.4972222 0.290917 10.5000000 0.290917 10.5027778 0.291616 10.5055556 0.290917 10.5083333 0.292314 10.5111111 0.292314 10.5138889 0.292314 10.5166667 0.292314 10.5194444 0.293712 10.5222222 0.292314 10.5250000 0.290917 10.5277778 0.291616 10.5305556 0.290218 10.5333333 0.286026 10.5361111 0.281834 10.5388889 0.276245 10.5416667 0.272052 10.5444444 0.267162 10.5472222 0.265066 10.5500000 0.264367 10.5527778 0.261572 10.5555556 0.260175 10.5583333 0.264367 10.5611111 0.266463 10.5638889 0.269258 10.5666667 0.276245 10.5694444 0.294410 10.5722222 0.334236 10.5750000 0.390131 10.5777778 0.425066 10.5805556 0.437642 10.5833333 0.438341 10.5861111 0.443231 10.5888889 0.449520 10.5916667 0.455109 10.5944444 0.446725 10.5972222 0.426463 10.6000000 0.405502 10.6027778 0.394323 10.6055556 0.393624 10.6083333 0.390830 10.6111111 0.394323 10.6138889 0.399214 10.6166667 0.410393 10.6194444 0.414585 10.6222222 0.415284 10.6250000 0.415983 10.6277778 0.415983 10.6305556 0.409694 10.6333333 0.392227 10.6361111 0.371266 10.6388889 0.348210 10.6416667 0.332140 10.6444444 0.322358 10.6472222 0.313275 10.6500000 0.304891 10.6527778 0.297904 10.6555556 0.294410 10.6583333 0.293712 10.6611111 0.296507 10.6638889 0.295109 10.6666667 0.291616 10.6694444 0.286725 10.6722222 0.286725 10.6750000 0.289520 10.6777778 0.293013 10.6805556 0.290218 10.6833333 0.288821 10.6861111 0.285328 10.6888889 0.286026 10.6916667 0.290218 10.6944444 0.293013 10.6972222 0.290218 10.7000000 0.286725 10.7027778 0.284629 10.7055556 0.286725 10.7083333 0.288122 10.7111111 0.290218 10.7138889 0.286725 10.7166667 0.286026 10.7194444 0.284629 10.7222222 0.286725 10.7250000 0.288821 10.7277778 0.290218 10.7305556 0.287424 10.7333333 0.286725 10.7361111 0.286725 10.7388889 0.288821 10.7416667 0.289520 10.7444444 0.288821 10.7472222 0.288122 10.7500000 0.287424 10.7527778 0.288821 10.7555556 0.290218 10.7583333 0.291616 10.7611111 0.291616 10.7638889 0.290218 10.7666667 0.290218 10.7694444 0.290917 10.7722222 0.290917 10.7750000 0.293013 10.7777778 0.291616 10.7805556 0.291616 10.7833333 0.294410 10.7861111 0.294410 10.7888889 0.293712 10.7916667 0.297205 10.7944444 0.295808 10.7972222 0.297904 10.8000000 0.299301 10.8027778 0.300000 10.8055556 0.297904 10.8083333 0.299301 10.8111111 0.302096 10.8138889 0.302096 10.8166667 0.303493 10.8194444 0.303493 10.8222222 0.302795 10.8250000 0.303493 10.8277778 0.306987 10.8305556 0.308384 10.8333333 0.309083 10.8361111 0.309083 10.8388889 0.309083 10.8416667 0.308384 10.8444444 0.310480 10.8472222 0.315371 10.8500000 0.314672 10.8527778 0.314672 10.8555556 0.312576 10.8583333 0.313275 10.8611111 0.316769 10.8638889 0.317467 10.8666667 0.319563 10.8694444 0.317467 10.8722222 0.317467 10.8780000 0.300000 10.9747778 0.300000 10.9777778 0.345415 10.9805556 0.345415 10.9833333 0.344017 10.9861111 0.340524 10.9888889 0.341921 10.9916667 0.346114 10.9944444 0.351703 10.9972222 0.350306 11.0000000 0.349607 11.0027778 0.346812 11.0055556 0.350306 11.0083333 0.353100 11.0111111 0.357991 11.0138889 0.355197 11.0166667 0.353100 11.0194444 0.351703 11.0222222 0.352402 11.0250000 0.357991 11.0277778 0.360087 11.0305556 0.358690 11.0333333 0.354498 11.0361111 0.355197 11.0388889 0.355895 11.0416667 0.358690 11.0444444 0.360786 11.0472222 0.358690 11.0500000 0.355197 11.0527778 0.355895 11.0555556 0.358690 11.0583333 0.360087 11.0611111 0.362183 11.0638889 0.360087 11.0666667 0.358690 11.0694444 0.355895 11.0722222 0.357293 11.0750000 0.361485 11.0777778 0.363581 11.0805556 0.360786 11.0833333 0.357293 11.0861111 0.357991 11.0888889 0.357991 11.0916667 0.362183 11.0944444 0.364978 11.0972222 0.361485 11.1000000 0.360087 11.1027778 0.359389 11.1055556 0.360786 11.1083333 0.362882 11.1111111 0.365677 11.1138889 0.364279 11.1166667 0.360786 11.1194444 0.360786 11.1222222 0.364279 11.1250000 0.364978 11.1277778 0.366376 11.1305556 0.366376 11.1333333 0.362183 11.1361111 0.360786 11.1388889 0.362882 11.1416667 0.362882 11.1444444 0.362183 11.1472222 0.357991 11.1500000 0.353100 11.1527778 0.351004 11.1555556 0.351004 11.1583333 0.352402 11.1611111 0.348908 11.1638889 0.344017 11.1666667 0.337729 11.1694444 0.338428 11.1722222 0.338428 11.1750000 0.339825 11.1777778 0.339127 11.1805556 0.335633 11.1833333 0.332838 11.1861111 0.332140 11.1888889 0.334236 11.1916667 0.334236 11.1944444 0.334934 11.1972222 0.332140 11.2000000 0.330044 11.2027778 0.333537 11.2055556 0.342620 11.2083333 0.353100 11.2111111 0.357293 11.2138889 0.355895 11.2166667 0.344017 11.2194444 0.336332 11.2222222 0.328646 11.2250000 0.323755 11.2277778 0.319563 11.2305556 0.312576 11.2333333 0.308384 11.2361111 0.311878 11.2388889 0.316769 11.2416667 0.324454 11.2444444 0.330044 11.2472222 0.330742 11.2500000 0.329345 11.2527778 0.329345 11.2555556 0.330742 11.2583333 0.328646 11.2611111 0.325852 11.2638889 0.318166 11.2666667 0.308384 11.2694444 0.297205 11.2722222 0.287424 11.2750000 0.273450 11.2777778 0.255284 11.2805556 0.232227 11.2833333 0.209869 11.2861111 0.192402 11.2888889 0.184017 11.2916667 0.179127 11.2944444 0.175633 11.2972222 0.170044 11.3000000 0.165153 11.3027778 0.162358 11.3055556 0.160961 11.3083333 0.164454 11.3111111 0.163755 11.3138889 0.161659 11.3166667 0.158166 11.3194444 0.156070 11.3222222 0.154672 11.3250000 0.157467 11.3277778 0.159563 11.3305556 0.158166 11.3333333 0.155371 11.3361111 0.151179 11.3388889 0.151179 11.3416667 0.154672 11.3444444 0.156769 11.3472222 0.156769 11.3500000 0.151878 11.3527778 0.149083 11.3555556 0.149083 11.3583333 0.153275 11.3611111 0.155371 11.3638889 0.154672 11.3666667 0.151878 11.3694444 0.149083 11.3722222 0.148384 11.3750000 0.153275 11.3777778 0.156769 11.3805556 0.156070 11.3833333 0.153974 11.3861111 0.152576 11.3888889 0.153275 11.3916667 0.156769 11.3944444 0.160262 11.3972222 0.160262 11.4000000 0.158865 11.4027778 0.156070 11.4055556 0.156769 11.4083333 0.161659 11.4111111 0.167249 11.4138889 0.167249 11.4166667 0.165153 11.4194444 0.163755 11.4222222 0.164454 11.4250000 0.167249 11.4277778 0.173537 11.4305556 0.174934 11.4333333 0.173537 11.4361111 0.172140 11.4388889 0.172140 11.4416667 0.176332 11.4444444 0.181223 11.4472222 0.184716 11.4500000 0.181921 11.4527778 0.181921 11.4555556 0.181921 11.4583333 0.185415 11.4611111 0.189607 11.4638889 0.192402 11.4666667 0.192402 11.4694444 0.191004 11.4722222 0.191703 11.4750000 0.192402 11.4777778 0.197991 11.4805556 0.200786 11.4833333 0.201485 11.4861111 0.202183 11.4888889 0.202882 11.4916667 0.203581 11.4944444 0.208472 11.4972222 0.209170 11.5000000 0.213362 11.5027778 0.212664 11.5055556 0.211965 11.5083333 0.214760 11.5111111 0.218952 11.5138889 0.220349 11.5166667 0.223144 11.5194444 0.223144 11.5222222 0.223843 11.5250000 0.225240 11.5307778 0.300000 12.4886667 0.300000 12.4916667 0.302795 12.4944444 0.306288 12.4972222 0.307686 12.5000000 0.306288 12.5027778 0.302795 12.5055556 0.302795 12.5083333 0.303493 12.5111111 0.306288 12.5138889 0.306288 12.5166667 0.305590 12.5194444 0.303493 12.5222222 0.303493 12.5250000 0.304192 12.5277778 0.306987 12.5305556 0.306288 12.5333333 0.306987 12.5361111 0.304192 12.5388889 0.303493 12.5416667 0.303493 12.5444444 0.305590 12.5472222 0.306987 12.5500000 0.306987 12.5527778 0.304192 12.5555556 0.303493 12.5583333 0.303493 12.5611111 0.307686 12.5638889 0.308384 12.5666667 0.306987 12.5694444 0.305590 12.5722222 0.303493 12.5750000 0.303493 12.5777778 0.306288 12.5805556 0.307686 12.5833333 0.306987 12.5861111 0.304891 12.5888889 0.302096 12.5916667 0.303493 12.5944444 0.305590 12.5972222 0.307686 12.6000000 0.306288 12.6027778 0.304891 12.6055556 0.302795 12.6083333 0.304891 12.6111111 0.307686 12.6138889 0.308384 12.6166667 0.306288 12.6194444 0.304192 12.6222222 0.302795 12.6250000 0.303493 12.6277778 0.306987 12.6305556 0.307686 12.6333333 0.308384 12.6361111 0.304192 12.6388889 0.305590 12.6416667 0.305590 12.6444444 0.306987 12.6472222 0.309083 12.6500000 0.307686 12.6527778 0.303493 12.6555556 0.304192 12.6583333 0.305590 12.6611111 0.306288 12.6638889 0.309083 12.6666667 0.307686 12.6694444 0.306288 12.6722222 0.305590 12.6750000 0.305590 12.6777778 0.307686 12.6805556 0.309083 12.6833333 0.308384 12.6861111 0.306987 12.6888889 0.303493 12.6916667 0.302096 12.6944444 0.301397 12.6972222 0.299301 12.7000000 0.295109 12.7027778 0.288122 12.7055556 0.283231 12.7083333 0.279039 12.7111111 0.277642 12.7138889 0.276943 12.7166667 0.278341 12.7194444 0.279039 12.7222222 0.277642 12.7250000 0.279738 12.7277778 0.282533 12.7305556 0.289520 12.7333333 0.303493 12.7361111 0.332140 12.7388889 0.375459 12.7416667 0.414585 12.7444444 0.436943 12.7472222 0.445328 12.7500000 0.448122 12.7527778 0.450218 12.7555556 0.455808 12.7583333 0.459301 12.7611111 0.461397 12.7638889 0.460000 12.7666667 0.448821 12.7694444 0.432751 12.7722222 0.418777 12.7750000 0.408996 12.7777778 0.404105 12.7805556 0.404105 12.7833333 0.403406 12.7861111 0.398515 12.7888889 0.399913 12.7916667 0.405502 12.7944444 0.412489 12.7972222 0.419476 12.8000000 0.422271 12.8027778 0.422969 12.8055556 0.424367 12.8083333 0.423668 12.8111111 0.423668 12.8138889 0.417380 12.8166667 0.405502 12.8194444 0.391528 12.8222222 0.374760 12.8250000 0.356594 12.8277778 0.343319 12.8305556 0.330044 12.8333333 0.320961 12.8361111 0.316769 12.8388889 0.311179 12.8416667 0.307686 12.8444444 0.306288 12.8472222 0.306288 12.8500000 0.304192 12.8527778 0.302096 12.8555556 0.301397 12.8583333 0.300699 12.8611111 0.300000 12.8638889 0.302096 12.8666667 0.301397 12.8694444 0.300699 12.8722222 0.300000 12.8750000 0.298603 12.8777778 0.299301 12.8805556 0.299301 12.8833333 0.300000 12.8861111 0.298603 12.8888889 0.297904 12.8916667 0.297904 12.8944444 0.297904 12.8972222 0.299301 12.9000000 0.298603 12.9027778 0.297205 12.9055556 0.299301 12.9083333 0.298603 12.9111111 0.297904 12.9138889 0.297904 12.9166667 0.299301 12.9194444 0.297904 12.9222222 0.300000 12.9250000 0.297904 12.9277778 0.298603 12.9305556 0.299301 12.9333333 0.299301 12.9361111 0.298603 12.9388889 0.297904 12.9416667 0.298603 12.9444444 0.297904 12.9472222 0.300000 12.9500000 0.300000 12.9527778 0.299301 12.9555556 0.300000 12.9583333 0.300000 12.9611111 0.300000 12.9638889 0.300699 12.9666667 0.300000 12.9694444 0.300000 12.9722222 0.302795 12.9750000 0.303493 12.9777778 0.303493 12.9805556 0.302096 12.9833333 0.303493 12.9861111 0.304192 12.9888889 0.304192 12.9916667 0.304891 12.9944444 0.306987 12.9972222 0.304891 13.0000000 0.304891 13.0027778 0.306288 13.0055556 0.306987 13.0083333 0.308384 13.0111111 0.308384 13.0138889 0.308384 13.0166667 0.309782 13.0194444 0.309782 13.0222222 0.311878 13.0250000 0.312576 13.0277778 0.313974 13.0305556 0.313974 13.0333333 0.313974 13.0361111 0.314672 13.0388889 0.318166 13.0446667 0.300000 13.1886667 0.300000 13.1916667 0.348210 13.1944444 0.351004 13.1972222 0.348908 13.2000000 0.347511 13.2027778 0.347511 13.2055556 0.351004 13.2083333 0.355197 13.2111111 0.355197 13.2138889 0.353799 13.2166667 0.351703 13.2194444 0.351703 13.2222222 0.357293 13.2250000 0.358690 13.2277778 0.359389 13.2305556 0.357293 13.2333333 0.354498 13.2361111 0.355197 13.2388889 0.357293 13.2416667 0.360786 13.2444444 0.361485 13.2472222 0.360786 13.2500000 0.356594 13.2527778 0.355895 13.2555556 0.358690 13.2583333 0.362882 13.2611111 0.362882 13.2638889 0.360087 13.2666667 0.358690 13.2694444 0.355895 13.2722222 0.357991 13.2750000 0.361485 13.2777778 0.362882 13.2805556 0.360786 13.2833333 0.358690 13.2861111 0.355197 13.2888889 0.357293 13.2916667 0.361485 13.2944444 0.364978 13.2972222 0.362183 13.3000000 0.357991 13.3027778 0.355895 13.3055556 0.358690 13.3083333 0.362183 13.3111111 0.364978 13.3138889 0.362183 13.3166667 0.359389 13.3194444 0.355895 13.3222222 0.357293 13.3250000 0.361485 13.3277778 0.363581 13.3305556 0.365677 13.3333333 0.360087 13.3361111 0.359389 13.3388889 0.359389 13.3416667 0.361485 13.3444444 0.365677 13.3472222 0.365677 13.3500000 0.362882 13.3527778 0.358690 13.3555556 0.359389 13.3583333 0.360786 13.3611111 0.362183 13.3638889 0.359389 13.3666667 0.353799 13.3694444 0.350306 13.3722222 0.348908 13.3750000 0.349607 13.3777778 0.347511 13.3805556 0.343319 13.3833333 0.337729 13.3861111 0.333537 13.3888889 0.334236 13.3916667 0.337031 13.3944444 0.336332 13.3972222 0.334934 13.4000000 0.330742 13.4027778 0.327948 13.4055556 0.328646 13.4083333 0.332140 13.4111111 0.333537 13.4138889 0.334236 13.4166667 0.333537 13.4194444 0.337729 13.4222222 0.348210 13.4250000 0.355895 13.4277778 0.363581 13.4305556 0.363581 13.4333333 0.355895 13.4361111 0.344017 13.4388889 0.337031 13.4416667 0.331441 13.4444444 0.327249 13.4472222 0.322358 13.4500000 0.318166 13.4527778 0.317467 13.4555556 0.319563 13.4583333 0.322358 13.4611111 0.328646 13.4638889 0.330044 13.4666667 0.328646 13.4694444 0.324454 13.4722222 0.325852 13.4750000 0.325153 13.4777778 0.323755 13.4805556 0.314672 13.4833333 0.300699 13.4861111 0.288821 13.4888889 0.276943 13.4916667 0.264367 13.4944444 0.249694 13.4972222 0.230830 13.5000000 0.209869 13.5027778 0.193799 13.5055556 0.184716 13.5083333 0.178428 13.5111111 0.177729 13.5138889 0.171441 13.5166667 0.167948 13.5194444 0.163755 13.5222222 0.163057 13.5250000 0.164454 13.5277778 0.167249 13.5305556 0.165852 13.5333333 0.159563 13.5361111 0.156070 13.5388889 0.158166 13.5416667 0.159563 13.5444444 0.158865 13.5472222 0.157467 13.5500000 0.154672 13.5527778 0.150480 13.5555556 0.153275 13.5583333 0.156070 13.5611111 0.157467 13.5638889 0.153275 13.5666667 0.151179 13.5694444 0.149782 13.5722222 0.153974 13.5750000 0.154672 13.5777778 0.156070 13.5805556 0.153275 13.5833333 0.149782 13.5861111 0.151179 13.5888889 0.152576 13.5916667 0.156070 13.5944444 0.156769 13.5972222 0.153974 13.6000000 0.152576 13.6027778 0.153275 13.6055556 0.156769 13.6083333 0.159563 13.6111111 0.160961 13.6138889 0.160262 13.6166667 0.158166 13.6194444 0.160961 13.6222222 0.164454 13.6250000 0.166550 13.6277778 0.165852 13.6305556 0.165153 13.6333333 0.164454 13.6361111 0.167948 13.6388889 0.170044 13.6416667 0.173537 13.6444444 0.174934 13.6472222 0.173537 13.6500000 0.173537 13.6527778 0.176332 13.6555556 0.181223 13.6583333 0.181921 13.6611111 0.184017 13.6638889 0.184716 13.6666667 0.185415 13.6694444 0.188210 13.6722222 0.191004 13.6750000 0.193100 13.6777778 0.193799 13.6805556 0.193799 13.6833333 0.195895 13.6861111 0.197991 13.6888889 0.198690 13.6916667 0.200087 13.6944444 0.201485 13.6972222 0.203581 13.7000000 0.204978 13.7027778 0.207773 13.7055556 0.209170 13.7083333 0.209869 13.7111111 0.210568 13.7138889 0.212664 13.7166667 0.216157 13.7194444 0.217555 13.7222222 0.218952 13.7250000 0.218253 13.7277778 0.223144 13.7305556 0.225939 13.7333333 0.226638 13.7361111 0.228035 13.7388889 0.228734 13.7446667 0.300000 14.6331111 0.300000 14.6361111 0.299301 14.6388889 0.302795 14.6416667 0.304891 14.6444444 0.302795 14.6472222 0.299301 14.6500000 0.299301 14.6527778 0.300000 14.6555556 0.302096 14.6583333 0.303493 14.6611111 0.302795 14.6638889 0.300699 14.6666667 0.300000 14.6694444 0.301397 14.6722222 0.302096 14.6750000 0.303493 14.6777778 0.302795 14.6805556 0.298603 14.6833333 0.299301 14.6861111 0.300699 14.6888889 0.302795 14.6916667 0.303493 14.6944444 0.302795 14.6972222 0.300000 14.7000000 0.300000 14.7027778 0.301397 14.7055556 0.302096 14.7083333 0.302096 14.7111111 0.301397 14.7138889 0.299301 14.7166667 0.299301 14.7194444 0.300000 14.7222222 0.302795 14.7250000 0.302096 14.7277778 0.300699 14.7305556 0.299301 14.7333333 0.298603 14.7361111 0.300000 14.7388889 0.302096 14.7416667 0.302795 14.7444444 0.300000 14.7472222 0.300699 14.7500000 0.298603 14.7527778 0.300000 14.7555556 0.300699 14.7583333 0.302096 14.7611111 0.298603 14.7638889 0.298603 14.7666667 0.298603 14.7694444 0.300000 14.7722222 0.302096 14.7750000 0.300699 14.7777778 0.300000 14.7805556 0.300000 14.7833333 0.299301 14.7861111 0.300000 14.7888889 0.301397 14.7916667 0.300000 14.7944444 0.299301 14.7972222 0.300000 14.8000000 0.298603 14.8027778 0.298603 14.8055556 0.300699 14.8083333 0.300699 14.8111111 0.300000 14.8138889 0.298603 14.8166667 0.298603 14.8194444 0.298603 14.8222222 0.302096 14.8250000 0.301397 14.8277778 0.299301 14.8305556 0.299301 14.8333333 0.295808 14.8361111 0.297205 14.8388889 0.295109 14.8416667 0.293013 14.8444444 0.287424 14.8472222 0.281834 14.8500000 0.276245 14.8527778 0.274847 14.8555556 0.272751 14.8583333 0.272052 14.8611111 0.272052 14.8638889 0.268559 14.8666667 0.269956 14.8694444 0.269956 14.8722222 0.274148 14.8750000 0.281834 14.8777778 0.300000 14.8805556 0.337031 14.8833333 0.380349 14.8861111 0.414585 14.8888889 0.429956 14.8916667 0.436245 14.8944444 0.439039 14.8972222 0.446725 14.9000000 0.453013 14.9027778 0.455109 14.9055556 0.453013 14.9083333 0.440437 14.9111111 0.427860 14.9138889 0.413886 14.9166667 0.402707 14.9194444 0.398515 14.9222222 0.397817 14.9250000 0.396419 14.9277778 0.393624 14.9305556 0.393624 14.9333333 0.399913 14.9361111 0.407598 14.9388889 0.413886 14.9416667 0.417380 14.9444444 0.418079 14.9472222 0.418777 14.9500000 0.417380 14.9527778 0.413886 14.9555556 0.404105 14.9583333 0.387336 14.9611111 0.371965 14.9638889 0.353100 14.9666667 0.336332 14.9694444 0.323755 14.9722222 0.318166 14.9750000 0.309782 14.9777778 0.305590 14.9805556 0.302096 14.9833333 0.301397 14.9861111 0.300000 14.9888889 0.298603 14.9916667 0.296507 14.9944444 0.295109 14.9972222 0.295808 15.0000000 0.296507 15.0027778 0.295109 15.0055556 0.295808 15.0083333 0.293712 15.0111111 0.293013 15.0138889 0.294410 15.0166667 0.293712 15.0194444 0.293013 15.0222222 0.291616 15.0250000 0.291616 15.0277778 0.293013 15.0305556 0.291616 15.0333333 0.292314 15.0361111 0.291616 15.0388889 0.292314 15.0416667 0.291616 15.0444444 0.291616 15.0472222 0.293013 15.0500000 0.293013 15.0527778 0.290218 15.0555556 0.292314 15.0583333 0.291616 15.0611111 0.292314 15.0638889 0.293013 15.0666667 0.293013 15.0694444 0.292314 15.0722222 0.292314 15.0750000 0.291616 15.0777778 0.292314 15.0805556 0.294410 15.0833333 0.295808 15.0861111 0.293013 15.0888889 0.293013 15.0916667 0.294410 15.0944444 0.295808 15.0972222 0.296507 15.1000000 0.296507 15.1027778 0.293712 15.1055556 0.293712 15.1083333 0.293013 15.1111111 0.295808 15.1138889 0.297205 15.1166667 0.297205 15.1194444 0.297205 15.1222222 0.297205 15.1250000 0.297205 15.1277778 0.299301 15.1305556 0.301397 15.1333333 0.300699 15.1361111 0.300000 15.1388889 0.300000 15.1416667 0.300699 15.1444444 0.302795 15.1472222 0.305590 15.1500000 0.304192 15.1527778 0.302795 15.1555556 0.303493 15.1583333 0.304891 15.1611111 0.306987 15.1638889 0.309782 15.1666667 0.306987 15.1694444 0.309782 15.1722222 0.307686 15.1750000 0.309782 15.1777778 0.312576 15.1805556 0.313974 15.1833333 0.313275 15.1891111 0.300000 15.2970000 0.300000 15.3000000 0.334236 15.3027778 0.335633 15.3055556 0.338428 15.3083333 0.341921 15.3111111 0.344017 15.3138889 0.342620 15.3166667 0.338428 15.3194444 0.339127 15.3222222 0.342620 15.3250000 0.346812 15.3277778 0.348210 15.3305556 0.345415 15.3333333 0.343319 15.3361111 0.344017 15.3388889 0.348908 15.3416667 0.351004 15.3444444 0.351004 15.3472222 0.348908 15.3500000 0.347511 15.3527778 0.347511 15.3555556 0.351004 15.3583333 0.354498 15.3611111 0.353100 15.3638889 0.351703 15.3666667 0.348908 15.3694444 0.351703 15.3722222 0.353799 15.3750000 0.356594 15.3777778 0.354498 15.3805556 0.352402 15.3833333 0.351004 15.3861111 0.352402 15.3888889 0.354498 15.3916667 0.354498 15.3944444 0.353100 15.3972222 0.352402 15.4000000 0.352402 15.4027778 0.353100 15.4055556 0.355895 15.4083333 0.355197 15.4111111 0.353799 15.4138889 0.355197 15.4166667 0.355895 15.4194444 0.357293 15.4222222 0.357991 15.4250000 0.356594 15.4277778 0.355197 15.4305556 0.357991 15.4333333 0.357991 15.4361111 0.359389 15.4388889 0.357991 15.4416667 0.358690 15.4444444 0.357991 15.4472222 0.359389 15.4500000 0.360786 15.4527778 0.360087 15.4555556 0.359389 15.4583333 0.360786 15.4611111 0.362882 15.4638889 0.362882 15.4666667 0.361485 15.4694444 0.359389 15.4722222 0.357991 15.4750000 0.355895 15.4777778 0.355895 15.4805556 0.355197 15.4833333 0.353799 15.4861111 0.347511 15.4888889 0.340524 15.4916667 0.337031 15.4944444 0.335633 15.4972222 0.336332 15.5000000 0.334236 15.5027778 0.330044 15.5055556 0.328646 15.5083333 0.330742 15.5111111 0.334934 15.5138889 0.335633 15.5166667 0.332838 15.5194444 0.332140 15.5222222 0.336332 15.5250000 0.344017 15.5277778 0.355895 15.5305556 0.362183 15.5333333 0.364978 15.5361111 0.362882 15.5388889 0.360786 15.5416667 0.357991 15.5444444 0.352402 15.5472222 0.342620 15.5500000 0.332838 15.5527778 0.324454 15.5555556 0.326550 15.5583333 0.326550 15.5611111 0.323755 15.5638889 0.318166 15.5666667 0.316070 15.5694444 0.319563 15.5722222 0.323755 15.5750000 0.325153 15.5777778 0.323057 15.5805556 0.316070 15.5833333 0.304891 15.5861111 0.292314 15.5888889 0.278341 15.5916667 0.265066 15.5944444 0.243406 15.5972222 0.218952 15.6000000 0.199389 15.6027778 0.185415 15.6055556 0.177729 15.6083333 0.172838 15.6111111 0.163755 15.6138889 0.158865 15.6166667 0.156070 15.6194444 0.155371 15.6222222 0.154672 15.6250000 0.154672 15.6277778 0.153974 15.6305556 0.148384 15.6333333 0.148384 15.6361111 0.149782 15.6388889 0.151179 15.6416667 0.150480 15.6444444 0.149083 15.6472222 0.145590 15.6500000 0.143493 15.6527778 0.144891 15.6555556 0.147686 15.6583333 0.146288 15.6611111 0.144891 15.6638889 0.142096 15.6666667 0.141397 15.6694444 0.144192 15.6722222 0.144192 15.6750000 0.146288 15.6777778 0.143493 15.6805556 0.141397 15.6833333 0.144192 15.6861111 0.144192 15.6888889 0.146288 15.6916667 0.146288 15.6944444 0.145590 15.6972222 0.142795 15.7000000 0.144891 15.7027778 0.146987 15.7055556 0.148384 15.7083333 0.148384 15.7111111 0.148384 15.7138889 0.149782 15.7166667 0.150480 15.7194444 0.153275 15.7222222 0.153974 15.7250000 0.156070 15.7277778 0.155371 15.7305556 0.158166 15.7333333 0.158166 15.7361111 0.160961 15.7388889 0.162358 15.7416667 0.162358 15.7444444 0.163755 15.7472222 0.166550 15.7500000 0.167948 15.7527778 0.170044 15.7555556 0.169345 15.7583333 0.174236 15.7611111 0.174236 15.7638889 0.175633 15.7666667 0.177729 15.7694444 0.179825 15.7722222 0.180524 15.7750000 0.182620 15.7777778 0.184017 15.7805556 0.187511 15.7833333 0.188210 15.7861111 0.188210 15.7888889 0.189607 15.7916667 0.192402 15.7944444 0.194498 15.7972222 0.195895 15.8000000 0.199389 15.8027778 0.198690 15.8055556 0.200087 15.8083333 0.202183 15.8111111 0.204978 15.8138889 0.206376 15.8166667 0.208472 15.8194444 0.208472 15.8222222 0.207074 15.8250000 0.211965 15.8277778 0.214760 15.8305556 0.215459 15.8333333 0.216856 15.8361111 0.218253 15.8388889 0.220349 15.8416667 0.219651 15.8444444 0.223843 15.8472222 0.226638 15.8530000 0.300000 16.7192222 0.300000 16.7222222 0.298603 16.7250000 0.302096 16.7277778 0.302096 16.7305556 0.302096 16.7333333 0.297904 16.7361111 0.296507 16.7388889 0.299301 16.7416667 0.300699 16.7444444 0.303493 16.7472222 0.300000 16.7500000 0.298603 16.7527778 0.296507 16.7555556 0.297205 16.7583333 0.300699 16.7611111 0.302795 16.7638889 0.302096 16.7666667 0.297205 16.7694444 0.296507 16.7722222 0.297205 16.7750000 0.301397 16.7777778 0.303493 16.7805556 0.300699 16.7833333 0.297904 16.7861111 0.296507 16.7888889 0.299301 16.7916667 0.303493 16.7944444 0.303493 16.7972222 0.300000 16.8000000 0.297904 16.8027778 0.295808 16.8055556 0.300000 16.8083333 0.301397 16.8111111 0.302795 16.8138889 0.301397 16.8166667 0.296507 16.8194444 0.297904 16.8222222 0.300000 16.8250000 0.301397 16.8277778 0.304891 16.8305556 0.300000 16.8333333 0.297904 16.8361111 0.297904 16.8388889 0.300000 16.8416667 0.302795 16.8444444 0.303493 16.8472222 0.302096 16.8500000 0.299301 16.8527778 0.295808 16.8555556 0.299301 16.8583333 0.302795 16.8611111 0.304192 16.8638889 0.301397 16.8666667 0.297904 16.8694444 0.298603 16.8722222 0.299301 16.8750000 0.302795 16.8777778 0.302795 16.8805556 0.302096 16.8833333 0.298603 16.8861111 0.297205 16.8888889 0.298603 16.8916667 0.302096 16.8944444 0.304192 16.8972222 0.301397 16.9000000 0.298603 16.9027778 0.297904 16.9055556 0.300000 16.9083333 0.303493 16.9111111 0.303493 16.9138889 0.301397 16.9166667 0.298603 16.9194444 0.295808 16.9222222 0.297205 16.9250000 0.295808 16.9277778 0.290917 16.9305556 0.283930 16.9333333 0.276245 16.9361111 0.269258 16.9388889 0.267860 16.9416667 0.267860 16.9444444 0.267860 16.9472222 0.267162 16.9500000 0.264367 16.9527778 0.264367 16.9555556 0.268559 16.9583333 0.272052 16.9611111 0.282533 16.9638889 0.299301 16.9666667 0.327249 16.9694444 0.365677 16.9722222 0.399214 16.9750000 0.420175 16.9777778 0.427860 16.9805556 0.431354 16.9833333 0.433450 16.9861111 0.439039 16.9888889 0.442533 16.9916667 0.444629 16.9944444 0.438341 16.9972222 0.425764 17.0000000 0.407598 17.0027778 0.395022 17.0055556 0.390131 17.0083333 0.393624 17.0111111 0.393624 17.0138889 0.393624 17.0166667 0.390131 17.0194444 0.393624 17.0222222 0.404105 17.0250000 0.411092 17.0277778 0.414585 17.0305556 0.413886 17.0333333 0.412489 17.0361111 0.407598 17.0388889 0.406900 17.0416667 0.402009 17.0444444 0.389432 17.0472222 0.372664 17.0500000 0.352402 17.0527778 0.335633 17.0555556 0.324454 17.0583333 0.318166 17.0611111 0.311878 17.0638889 0.304891 17.0666667 0.300699 17.0694444 0.297904 17.0722222 0.297205 17.0750000 0.299301 17.0777778 0.299301 17.0805556 0.296507 17.0833333 0.291616 17.0861111 0.290917 17.0888889 0.292314 17.0916667 0.295109 17.0944444 0.295109 17.0972222 0.292314 17.1000000 0.289520 17.1027778 0.288821 17.1055556 0.290218 17.1083333 0.293712 17.1111111 0.293013 17.1138889 0.292314 17.1166667 0.287424 17.1194444 0.286725 17.1222222 0.289520 17.1250000 0.292314 17.1277778 0.291616 17.1305556 0.288821 17.1333333 0.286725 17.1361111 0.285328 17.1388889 0.288122 17.1416667 0.290218 17.1444444 0.290218 17.1472222 0.289520 17.1500000 0.288122 17.1527778 0.285328 17.1555556 0.287424 17.1583333 0.290917 17.1611111 0.293013 17.1638889 0.290917 17.1666667 0.288122 17.1694444 0.286725 17.1722222 0.288122 17.1750000 0.292314 17.1777778 0.293712 17.1805556 0.291616 17.1833333 0.289520 17.1861111 0.288821 17.1888889 0.290218 17.1916667 0.295808 17.1944444 0.294410 17.1972222 0.292314 17.2000000 0.291616 17.2027778 0.290218 17.2055556 0.292314 17.2083333 0.296507 17.2111111 0.297904 17.2138889 0.295808 17.2166667 0.293712 17.2194444 0.293013 17.2222222 0.295808 17.2250000 0.300000 17.2277778 0.300699 17.2305556 0.297904 17.2333333 0.295808 17.2361111 0.295808 17.2388889 0.300699 17.2416667 0.304891 17.2444444 0.304192 17.2472222 0.300000 17.2500000 0.300000 17.2527778 0.299301 17.2555556 0.304891 17.2583333 0.308384 17.2611111 0.306987 17.2638889 0.306288 17.2666667 0.305590 17.2694444 0.304891 17.2752222 0.300000 17.4081111 0.300000 17.4111111 0.337031 17.4138889 0.335633 17.4166667 0.334236 17.4194444 0.335633 17.4222222 0.339825 17.4250000 0.343319 17.4277778 0.341921 17.4305556 0.339127 17.4333333 0.338428 17.4361111 0.340524 17.4388889 0.344716 17.4416667 0.346114 17.4444444 0.346114 17.4472222 0.342620 17.4500000 0.341921 17.4527778 0.345415 17.4555556 0.347511 17.4583333 0.349607 17.4611111 0.348210 17.4638889 0.345415 17.4666667 0.342620 17.4694444 0.345415 17.4722222 0.347511 17.4750000 0.350306 17.4777778 0.348908 17.4805556 0.346114 17.4833333 0.342620 17.4861111 0.342620 17.4888889 0.346812 17.4916667 0.348210 17.4944444 0.348908 17.4972222 0.344017 17.5000000 0.344017 17.5027778 0.341921 17.5055556 0.346812 17.5083333 0.348908 17.5111111 0.348908 17.5138889 0.346114 17.5166667 0.341921 17.5194444 0.344017 17.5222222 0.348210 17.5250000 0.351004 17.5277778 0.347511 17.5305556 0.346114 17.5333333 0.344716 17.5361111 0.346812 17.5388889 0.349607 17.5416667 0.353799 17.5444444 0.351004 17.5472222 0.347511 17.5500000 0.346114 17.5527778 0.348908 17.5555556 0.350306 17.5583333 0.353100 17.5611111 0.351703 17.5638889 0.350306 17.5666667 0.349607 17.5694444 0.348210 17.5722222 0.350306 17.5750000 0.352402 17.5777778 0.347511 17.5805556 0.344017 17.5833333 0.340524 17.5861111 0.341921 17.5888889 0.344017 17.5916667 0.341223 17.5944444 0.334934 17.5972222 0.325852 17.6000000 0.321659 17.6027778 0.318865 17.6055556 0.322358 17.6083333 0.325153 17.6111111 0.321659 17.6138889 0.320961 17.6166667 0.320961 17.6194444 0.323057 17.6222222 0.327948 17.6250000 0.330044 17.6277778 0.329345 17.6305556 0.327948 17.6333333 0.330044 17.6361111 0.337031 17.6388889 0.343319 17.6416667 0.349607 17.6444444 0.348908 17.6472222 0.343319 17.6500000 0.337729 17.6527778 0.332838 17.6555556 0.330742 17.6583333 0.326550 17.6611111 0.323057 17.6638889 0.320262 17.6666667 0.316070 17.6694444 0.313275 17.6722222 0.313974 17.6750000 0.314672 17.6777778 0.313275 17.6805556 0.311878 17.6833333 0.312576 17.6861111 0.313974 17.6888889 0.318865 17.6916667 0.318865 17.6944444 0.312576 17.6972222 0.304891 17.7000000 0.295109 17.7027778 0.286725 17.7055556 0.276943 17.7083333 0.267860 17.7111111 0.248996 17.7138889 0.226638 17.7166667 0.209869 17.7194444 0.195197 17.7222222 0.188210 17.7250000 0.179825 17.7277778 0.172140 17.7305556 0.164454 17.7333333 0.156769 17.7361111 0.156070 17.7388889 0.156769 17.7416667 0.158865 17.7444444 0.154672 17.7472222 0.151878 17.7500000 0.147686 17.7527778 0.149083 17.7555556 0.152576 17.7583333 0.151179 17.7611111 0.150480 17.7638889 0.147686 17.7666667 0.143493 17.7694444 0.144891 17.7722222 0.147686 17.7750000 0.149782 17.7777778 0.149083 17.7805556 0.145590 17.7833333 0.142096 17.7861111 0.141397 17.7888889 0.142795 17.7916667 0.147686 17.7944444 0.144192 17.7972222 0.143493 17.8000000 0.140699 17.8027778 0.140699 17.8055556 0.144192 17.8083333 0.146987 17.8111111 0.147686 17.8138889 0.144192 17.8166667 0.141397 17.8194444 0.142096 17.8222222 0.145590 17.8250000 0.149083 17.8277778 0.149083 17.8305556 0.148384 17.8333333 0.146987 17.8361111 0.148384 17.8388889 0.150480 17.8416667 0.153275 17.8444444 0.156070 17.8472222 0.153974 17.8500000 0.153275 17.8527778 0.151878 17.8555556 0.156070 17.8583333 0.159563 17.8611111 0.163057 17.8638889 0.160262 17.8666667 0.161659 17.8694444 0.162358 17.8722222 0.165153 17.8750000 0.170742 17.8777778 0.173537 17.8805556 0.173537 17.8833333 0.171441 17.8861111 0.172838 17.8888889 0.176332 17.8916667 0.179127 17.8944444 0.181223 17.8972222 0.182620 17.9000000 0.181921 17.9027778 0.181921 17.9055556 0.183319 17.9083333 0.187511 17.9111111 0.188210 17.9138889 0.189607 17.9166667 0.189607 17.9194444 0.188908 17.9222222 0.190306 17.9250000 0.193100 17.9277778 0.195197 17.9305556 0.196594 17.9333333 0.195895 17.9361111 0.195197 17.9388889 0.197991 17.9416667 0.201485 17.9444444 0.203581 17.9472222 0.205677 17.9500000 0.204279 17.9527778 0.204978 17.9555556 0.205677 17.9583333 0.207773 17.9641111 0.300000 18.8831111 0.300000 18.8861111 0.298603 18.8888889 0.299301 18.8916667 0.300699 18.8944444 0.300000 18.8972222 0.300699 18.9000000 0.300699 18.9027778 0.300000 18.9055556 0.300699 18.9083333 0.300000 18.9111111 0.300699 18.9138889 0.300000 18.9166667 0.301397 18.9194444 0.299301 18.9222222 0.298603 18.9250000 0.299301 18.9277778 0.300699 18.9305556 0.300699 18.9333333 0.299301 18.9361111 0.297904 18.9388889 0.298603 18.9416667 0.299301 18.9444444 0.299301 18.9472222 0.298603 18.9500000 0.300699 18.9527778 0.300000 18.9555556 0.299301 18.9583333 0.297904 18.9611111 0.299301 18.9638889 0.299301 18.9666667 0.299301 18.9694444 0.301397 18.9722222 0.299301 18.9750000 0.300000 18.9777778 0.300000 18.9805556 0.300000 18.9833333 0.299301 18.9861111 0.300000 18.9888889 0.300000 18.9916667 0.299301 18.9944444 0.298603 18.9972222 0.297904 19.0000000 0.299301 19.0027778 0.299301 19.0055556 0.299301 19.0083333 0.299301 19.0111111 0.299301 19.0138889 0.299301 19.0166667 0.299301 19.0194444 0.298603 19.0222222 0.298603 19.0250000 0.299301 19.0277778 0.300000 19.0305556 0.300699 19.0333333 0.300699 19.0361111 0.301397 19.0388889 0.300000 19.0416667 0.302096 19.0444444 0.301397 19.0472222 0.302096 19.0500000 0.302096 19.0527778 0.302096 19.0555556 0.301397 19.0583333 0.301397 19.0611111 0.300000 19.0638889 0.300699 19.0666667 0.299301 19.0694444 0.298603 19.0722222 0.297205 19.0750000 0.295808 19.0777778 0.296507 19.0805556 0.295109 19.0833333 0.294410 19.0861111 0.292314 19.0888889 0.286725 19.0916667 0.283930 19.0944444 0.279738 19.0972222 0.273450 19.1000000 0.270655 19.1027778 0.265764 19.1055556 0.262969 19.1083333 0.260873 19.1111111 0.262271 19.1138889 0.262271 19.1166667 0.264367 19.1194444 0.267860 19.1222222 0.270655 19.1250000 0.276943 19.1277778 0.292314 19.1305556 0.318865 19.1333333 0.359389 19.1361111 0.395721 19.1388889 0.417380 19.1416667 0.423668 19.1444444 0.425066 19.1472222 0.429956 19.1500000 0.437642 19.1527778 0.443930 19.1555556 0.445328 19.1583333 0.441135 19.1611111 0.428559 19.1638889 0.413886 19.1666667 0.403406 19.1694444 0.397118 19.1722222 0.395022 19.1750000 0.394323 19.1777778 0.392926 19.1805556 0.392227 19.1833333 0.394323 19.1861111 0.399214 19.1888889 0.407598 19.1916667 0.411092 19.1944444 0.411790 19.1972222 0.411790 19.2000000 0.411092 19.2027778 0.411092 19.2055556 0.408996 19.2083333 0.400611 19.2111111 0.385939 19.2138889 0.367773 19.2166667 0.352402 19.2194444 0.337031 19.2222222 0.325852 19.2250000 0.317467 19.2277778 0.309083 19.2305556 0.301397 19.2333333 0.297205 19.2361111 0.299301 19.2388889 0.299301 19.2416667 0.298603 19.2444444 0.292314 19.2472222 0.291616 19.2500000 0.290218 19.2527778 0.293013 19.2555556 0.294410 19.2583333 0.292314 19.2611111 0.289520 19.2638889 0.287424 19.2666667 0.286725 19.2694444 0.288821 19.2722222 0.290917 19.2750000 0.291616 19.2777778 0.288122 19.2805556 0.286026 19.2833333 0.284629 19.2861111 0.287424 19.2888889 0.288821 19.2916667 0.289520 19.2944444 0.288122 19.2972222 0.283930 19.3000000 0.281834 19.3027778 0.286725 19.3055556 0.288122 19.3083333 0.289520 19.3111111 0.289520 19.3138889 0.284629 19.3166667 0.281834 19.3194444 0.285328 19.3222222 0.287424 19.3250000 0.289520 19.3277778 0.287424 19.3305556 0.286026 19.3333333 0.282533 19.3361111 0.284629 19.3388889 0.288122 19.3416667 0.290917 19.3444444 0.287424 19.3472222 0.285328 19.3500000 0.283930 19.3527778 0.285328 19.3555556 0.289520 19.3583333 0.292314 19.3611111 0.290917 19.3638889 0.286725 19.3666667 0.286725 19.3694444 0.286026 19.3722222 0.290218 19.3750000 0.295109 19.3777778 0.292314 19.3805556 0.288122 19.3833333 0.287424 19.3861111 0.289520 19.3888889 0.291616 19.3916667 0.294410 19.3944444 0.296507 19.3972222 0.292314 19.4000000 0.290917 19.4027778 0.292314 19.4055556 0.295109 19.4083333 0.298603 19.4111111 0.299301 19.4138889 0.297205 19.4166667 0.295109 19.4194444 0.295808 19.4222222 0.299301 19.4250000 0.302795 19.4277778 0.302096 19.4305556 0.299301 19.4333333 0.298603 19.4391111 0.300000 19.5831111 0.300000 19.5861111 0.325153 19.5888889 0.328646 19.5916667 0.332838 19.5944444 0.334236 19.5972222 0.332838 19.6000000 0.329345 19.6027778 0.330044 19.6055556 0.332838 19.6083333 0.337729 19.6111111 0.338428 19.6138889 0.338428 19.6166667 0.337031 19.6194444 0.336332 19.6222222 0.339825 19.6250000 0.343319 19.6277778 0.343319 19.6305556 0.341223 19.6333333 0.339825 19.6361111 0.339825 19.6388889 0.340524 19.6416667 0.345415 19.6444444 0.346812 19.6472222 0.342620 19.6500000 0.340524 19.6527778 0.341223 19.6555556 0.342620 19.6583333 0.346114 19.6611111 0.344017 19.6638889 0.342620 19.6666667 0.338428 19.6694444 0.339127 19.6722222 0.341223 19.6750000 0.343319 19.6777778 0.344716 19.6805556 0.341223 19.6833333 0.339127 19.6861111 0.338428 19.6888889 0.340524 19.6916667 0.344017 19.6944444 0.344017 19.6972222 0.340524 19.7000000 0.338428 19.7027778 0.338428 19.7055556 0.343319 19.7083333 0.345415 19.7111111 0.345415 19.7138889 0.342620 19.7166667 0.339825 19.7194444 0.338428 19.7222222 0.343319 19.7250000 0.346114 19.7277778 0.346114 19.7305556 0.344716 19.7333333 0.341223 19.7361111 0.340524 19.7388889 0.344716 19.7416667 0.348210 19.7444444 0.345415 19.7472222 0.343319 19.7500000 0.337729 19.7527778 0.337031 19.7555556 0.339127 19.7583333 0.339825 19.7611111 0.337729 19.7638889 0.331441 19.7666667 0.325153 19.7694444 0.322358 19.7722222 0.320262 19.7750000 0.318166 19.7777778 0.316070 19.7805556 0.312576 19.7833333 0.310480 19.7861111 0.313275 19.7888889 0.317467 19.7916667 0.321659 19.7944444 0.323057 19.7972222 0.323755 19.8000000 0.320262 19.8027778 0.319563 19.8055556 0.321659 19.8083333 0.323057 19.8111111 0.319563 19.8138889 0.318166 19.8166667 0.316769 19.8194444 0.314672 19.8222222 0.318166 19.8250000 0.318166 19.8277778 0.316769 19.8305556 0.310480 19.8333333 0.302096 19.8361111 0.297205 19.8388889 0.295109 19.8416667 0.293013 19.8444444 0.293013 19.8472222 0.290218 19.8500000 0.290218 19.8527778 0.291616 19.8555556 0.300000 19.8583333 0.310480 19.8611111 0.315371 19.8638889 0.313275 19.8666667 0.310480 19.8694444 0.307686 19.8722222 0.307686 19.8750000 0.306288 19.8777778 0.302795 19.8805556 0.293013 19.8833333 0.276943 19.8861111 0.261572 19.8888889 0.246201 19.8916667 0.229432 19.8944444 0.214760 19.8972222 0.197991 19.9000000 0.184017 19.9027778 0.172838 19.9055556 0.167948 19.9083333 0.166550 19.9111111 0.164454 19.9138889 0.162358 19.9166667 0.158166 19.9194444 0.156070 19.9222222 0.154672 19.9250000 0.158166 19.9277778 0.156769 19.9305556 0.154672 19.9333333 0.151878 19.9361111 0.150480 19.9388889 0.149782 19.9416667 0.152576 19.9444444 0.151878 19.9472222 0.150480 19.9500000 0.146288 19.9527778 0.146987 19.9555556 0.148384 19.9583333 0.148384 19.9611111 0.148384 19.9638889 0.148384 19.9666667 0.145590 19.9694444 0.146288 19.9722222 0.144192 19.9750000 0.146987 19.9777778 0.147686 19.9805556 0.147686 19.9833333 0.144891 19.9861111 0.142795 19.9888889 0.146288 19.9916667 0.148384 19.9944444 0.149083 19.9972222 0.147686 20.0000000 0.148384 20.0027778 0.146987 20.0055556 0.149083 20.0083333 0.151878 20.0111111 0.153974 20.0138889 0.152576 20.0166667 0.153275 20.0194444 0.154672 20.0222222 0.154672 20.0250000 0.156070 20.0277778 0.158865 20.0305556 0.160961 20.0333333 0.160262 20.0361111 0.160262 20.0388889 0.161659 20.0416667 0.163755 20.0444444 0.166550 20.0472222 0.167948 20.0500000 0.168646 20.0527778 0.168646 20.0555556 0.169345 20.0583333 0.172140 20.0611111 0.174236 20.0638889 0.176332 20.0666667 0.177031 20.0694444 0.178428 20.0722222 0.179825 20.0750000 0.181921 20.0777778 0.186114 20.0805556 0.186114 20.0833333 0.186812 20.0861111 0.188210 20.0888889 0.189607 20.0916667 0.193100 20.0944444 0.193100 20.0972222 0.195895 20.1000000 0.195895 20.1027778 0.197991 20.1055556 0.199389 20.1083333 0.201485 20.1111111 0.202882 20.1138889 0.204279 20.1166667 0.204279 20.1194444 0.204978 20.1222222 0.206376 20.1250000 0.206376 20.1277778 0.209170 20.1305556 0.210568 20.1333333 0.211965 20.1391111 0.300000 20.9970000 0.300000 21.0000000 0.295109 21.0027778 0.295808 21.0055556 0.299301 21.0083333 0.302795 21.0111111 0.302795 21.0138889 0.299301 21.0166667 0.296507 21.0194444 0.297205 21.0222222 0.300000 21.0250000 0.301397 21.0277778 0.302096 21.0305556 0.298603 21.0333333 0.296507 21.0361111 0.297205 21.0388889 0.300000 21.0416667 0.301397 21.0444444 0.301397 21.0472222 0.300699 21.0500000 0.297205 21.0527778 0.297205 21.0555556 0.300699 21.0583333 0.302096 21.0611111 0.302096 21.0638889 0.297904 21.0666667 0.295808 21.0694444 0.297904 21.0722222 0.300699 21.0750000 0.303493 21.0777778 0.300000 21.0805556 0.297904 21.0833333 0.295109 21.0861111 0.298603 21.0888889 0.301397 21.0916667 0.302096 21.0944444 0.300699 21.0972222 0.297904 21.1000000 0.295808 21.1027778 0.298603 21.1055556 0.301397 21.1083333 0.302795 21.1111111 0.300000 21.1138889 0.297205 21.1166667 0.297205 21.1194444 0.297904 21.1222222 0.302795 21.1250000 0.302795 21.1277778 0.302096 21.1305556 0.300000 21.1333333 0.297205 21.1361111 0.298603 21.1388889 0.302096 21.1416667 0.304192 21.1444444 0.302795 21.1472222 0.299301 21.1500000 0.297904 21.1527778 0.299301 21.1555556 0.302096 21.1583333 0.304192 21.1611111 0.302096 21.1638889 0.298603 21.1666667 0.297205 21.1694444 0.298603 21.1722222 0.302795 21.1750000 0.304891 21.1777778 0.303493 21.1805556 0.300699 21.1833333 0.299301 21.1861111 0.302096 21.1888889 0.305590 21.1916667 0.306288 21.1944444 0.303493 21.1972222 0.300000 21.2000000 0.299301 21.2027778 0.300000 21.2055556 0.297904 21.2083333 0.292314 21.2111111 0.285328 21.2138889 0.277642 21.2166667 0.273450 21.2194444 0.272052 21.2222222 0.270655 21.2250000 0.272052 21.2277778 0.270655 21.2305556 0.266463 21.2333333 0.269258 21.2361111 0.272052 21.2388889 0.277642 21.2416667 0.290218 21.2444444 0.312576 21.2472222 0.348908 21.2500000 0.389432 21.2527778 0.418079 21.2555556 0.430655 21.2583333 0.432751 21.2611111 0.434847 21.2638889 0.439039 21.2666667 0.443930 21.2694444 0.447424 21.2722222 0.445328 21.2750000 0.432052 21.2777778 0.416681 21.2805556 0.403406 21.2833333 0.397817 21.2861111 0.399913 21.2888889 0.402009 21.2916667 0.401310 21.2944444 0.398515 21.2972222 0.399913 21.3000000 0.405502 21.3027778 0.413188 21.3055556 0.418777 21.3083333 0.418777 21.3111111 0.416681 21.3138889 0.413188 21.3166667 0.410393 21.3194444 0.403406 21.3222222 0.391528 21.3250000 0.374760 21.3277778 0.355197 21.3305556 0.337031 21.3333333 0.324454 21.3361111 0.317467 21.3388889 0.312576 21.3416667 0.304891 21.3444444 0.300699 21.3472222 0.296507 21.3500000 0.296507 21.3527778 0.296507 21.3555556 0.297205 21.3583333 0.295109 21.3611111 0.292314 21.3638889 0.289520 21.3666667 0.290218 21.3694444 0.292314 21.3722222 0.291616 21.3750000 0.290917 21.3777778 0.288122 21.3805556 0.286026 21.3833333 0.289520 21.3861111 0.290917 21.3888889 0.289520 21.3916667 0.288821 21.3944444 0.287424 21.3972222 0.289520 21.4000000 0.289520 21.4027778 0.290218 21.4055556 0.288821 21.4083333 0.286725 21.4111111 0.285328 21.4138889 0.287424 21.4166667 0.288122 21.4194444 0.289520 21.4222222 0.289520 21.4250000 0.288821 21.4277778 0.286725 21.4305556 0.288122 21.4333333 0.286026 21.4361111 0.288821 21.4388889 0.288821 21.4416667 0.288122 21.4444444 0.288122 21.4472222 0.288821 21.4500000 0.288821 21.4527778 0.289520 21.4555556 0.288821 21.4583333 0.288821 21.4611111 0.290218 21.4638889 0.290218 21.4666667 0.289520 21.4694444 0.288821 21.4722222 0.290218 21.4750000 0.291616 21.4777778 0.293013 21.4805556 0.293013 21.4833333 0.290917 21.4861111 0.290917 21.4888889 0.293712 21.4916667 0.296507 21.4944444 0.298603 21.4972222 0.295109 21.5000000 0.295109 21.5027778 0.294410 21.5055556 0.296507 21.5083333 0.302096 21.5111111 0.302096 21.5138889 0.300699 21.5166667 0.297205 21.5194444 0.299301 21.5222222 0.303493 21.5250000 0.305590 21.5277778 0.306987 21.5305556 0.304192 21.5333333 0.302096 21.5361111 0.304891 21.5388889 0.308384 21.5416667 0.310480 21.5444444 0.309782 21.5472222 0.308384 21.5530000 0.300000 21.6553333 0.300000 21.6583333 0.334934 21.6611111 0.335633 21.6638889 0.334236 21.6666667 0.335633 21.6694444 0.336332 21.6722222 0.336332 21.6750000 0.338428 21.6777778 0.338428 21.6805556 0.340524 21.6833333 0.340524 21.6861111 0.339127 21.6888889 0.340524 21.6916667 0.345415 21.6944444 0.346812 21.6972222 0.344017 21.7000000 0.342620 21.7027778 0.344716 21.7055556 0.346812 21.7083333 0.348908 21.7111111 0.349607 21.7138889 0.347511 21.7166667 0.346812 21.7194444 0.345415 21.7222222 0.350306 21.7250000 0.351703 21.7277778 0.351703 21.7305556 0.348210 21.7333333 0.347511 21.7361111 0.348908 21.7388889 0.350306 21.7416667 0.352402 21.7444444 0.351004 21.7472222 0.348210 21.7500000 0.345415 21.7527778 0.347511 21.7555556 0.351004 21.7583333 0.353100 21.7611111 0.349607 21.7638889 0.346812 21.7666667 0.346812 21.7694444 0.348908 21.7722222 0.351004 21.7750000 0.352402 21.7777778 0.349607 21.7805556 0.346812 21.7833333 0.346812 21.7861111 0.348908 21.7888889 0.352402 21.7916667 0.351004 21.7944444 0.349607 21.7972222 0.346114 21.8000000 0.347511 21.8027778 0.349607 21.8055556 0.353100 21.8083333 0.351004 21.8111111 0.351004 21.8138889 0.346812 21.8166667 0.347511 21.8194444 0.351004 21.8222222 0.352402 21.8250000 0.350306 21.8277778 0.347511 21.8305556 0.341921 21.8333333 0.339825 21.8361111 0.340524 21.8388889 0.339825 21.8416667 0.339825 21.8444444 0.333537 21.8472222 0.326550 21.8500000 0.325153 21.8527778 0.324454 21.8555556 0.327948 21.8583333 0.326550 21.8611111 0.321659 21.8638889 0.319563 21.8666667 0.319563 21.8694444 0.322358 21.8722222 0.324454 21.8750000 0.324454 21.8777778 0.321659 21.8805556 0.320262 21.8833333 0.323057 21.8861111 0.327948 21.8888889 0.334236 21.8916667 0.339127 21.8944444 0.340524 21.8972222 0.341921 21.9000000 0.343319 21.9027778 0.346114 21.9055556 0.348210 21.9083333 0.346114 21.9111111 0.341223 21.9138889 0.336332 21.9166667 0.332140 21.9194444 0.328646 21.9222222 0.326550 21.9250000 0.325153 21.9277778 0.320961 21.9305556 0.319563 21.9333333 0.319563 21.9361111 0.320961 21.9388889 0.318166 21.9416667 0.314672 21.9444444 0.310480 21.9472222 0.305590 21.9500000 0.302096 21.9527778 0.293712 21.9555556 0.284629 21.9583333 0.272052 21.9611111 0.255284 21.9638889 0.236419 21.9666667 0.221048 21.9694444 0.207773 21.9722222 0.195197 21.9750000 0.184716 21.9777778 0.172140 21.9805556 0.164454 21.9833333 0.160961 21.9861111 0.162358 21.9888889 0.161659 21.9916667 0.158166 21.9944444 0.154672 21.9972222 0.151878 22.0000000 0.153974 22.0027778 0.155371 22.0055556 0.156070 22.0083333 0.152576 22.0111111 0.151878 22.0138889 0.149083 22.0166667 0.149782 22.0194444 0.151179 22.0222222 0.151179 22.0250000 0.149782 22.0277778 0.148384 22.0305556 0.147686 22.0333333 0.146288 22.0361111 0.148384 22.0388889 0.148384 22.0416667 0.146987 22.0444444 0.146288 22.0472222 0.144891 22.0500000 0.148384 22.0527778 0.149782 22.0555556 0.151878 22.0583333 0.149782 22.0611111 0.148384 22.0638889 0.148384 22.0666667 0.149782 22.0694444 0.151878 22.0722222 0.151878 22.0750000 0.152576 22.0777778 0.152576 22.0805556 0.152576 22.0833333 0.155371 22.0861111 0.156769 22.0888889 0.158166 22.0916667 0.157467 22.0944444 0.158865 22.0972222 0.160961 22.1000000 0.163057 22.1027778 0.163755 22.1055556 0.164454 22.1083333 0.165153 22.1111111 0.167249 22.1138889 0.168646 22.1166667 0.170044 22.1194444 0.172140 22.1222222 0.172838 22.1250000 0.174236 22.1277778 0.174934 22.1305556 0.178428 22.1333333 0.179127 22.1361111 0.180524 22.1388889 0.181921 22.1416667 0.184716 22.1444444 0.186114 22.1472222 0.187511 22.1500000 0.188908 22.1527778 0.190306 22.1555556 0.191703 22.1583333 0.193100 22.1611111 0.194498 22.1638889 0.195895 22.1666667 0.197991 22.1694444 0.199389 22.1722222 0.201485 22.1750000 0.204279 22.1777778 0.204978 22.1805556 0.209170 22.1833333 0.208472 22.1861111 0.209869 22.1888889 0.211266 22.1916667 0.212664 22.1944444 0.216157 22.1972222 0.217555 22.2000000 0.218253 22.2027778 0.220349 22.2055556 0.221747 22.2113333 0.300000 23.0442222 0.300000 23.0472222 0.313275 23.0500000 0.311179 23.0527778 0.310480 23.0555556 0.311878 23.0583333 0.314672 23.0611111 0.313275 23.0638889 0.310480 23.0666667 0.309782 23.0694444 0.311878 23.0722222 0.311878 23.0750000 0.313974 23.0777778 0.313974 23.0805556 0.310480 23.0833333 0.309083 23.0861111 0.310480 23.0888889 0.311878 23.0916667 0.313275 23.0944444 0.313275 23.0972222 0.311179 23.1000000 0.309083 23.1027778 0.310480 23.1055556 0.311179 23.1083333 0.313275 23.1111111 0.311179 23.1138889 0.308384 23.1166667 0.308384 23.1194444 0.309782 23.1222222 0.311179 23.1250000 0.312576 23.1277778 0.311878 23.1305556 0.309083 23.1333333 0.307686 23.1361111 0.309083 23.1388889 0.311878 23.1416667 0.312576 23.1444444 0.310480 23.1472222 0.308384 23.1500000 0.308384 23.1527778 0.307686 23.1555556 0.311179 23.1583333 0.311179 23.1611111 0.309782 23.1638889 0.308384 23.1666667 0.306987 23.1694444 0.307686 23.1722222 0.307686 23.1750000 0.311179 23.1777778 0.309782 23.1805556 0.307686 23.1833333 0.306288 23.1861111 0.307686 23.1888889 0.309782 23.1916667 0.311179 23.1944444 0.310480 23.1972222 0.307686 23.2000000 0.304891 23.2027778 0.307686 23.2055556 0.309782 23.2083333 0.309782 23.2111111 0.309083 23.2138889 0.306987 23.2166667 0.306288 23.2194444 0.306288 23.2222222 0.309083 23.2250000 0.309782 23.2277778 0.308384 23.2305556 0.305590 23.2333333 0.303493 23.2361111 0.304891 23.2388889 0.306987 23.2416667 0.307686 23.2444444 0.308384 23.2472222 0.302795 23.2500000 0.298603 23.2527778 0.297205 23.2555556 0.293712 23.2583333 0.291616 23.2611111 0.286725 23.2638889 0.281135 23.2666667 0.276943 23.2694444 0.276245 23.2722222 0.279039 23.2750000 0.282533 23.2777778 0.285328 23.2805556 0.283930 23.2833333 0.283231 23.2861111 0.293013 23.2888889 0.311179 23.2916667 0.342620 23.2944444 0.379651 23.2972222 0.410393 23.3000000 0.423668 23.3027778 0.429956 23.3055556 0.436245 23.3083333 0.442533 23.3111111 0.448122 23.3138889 0.446026 23.3166667 0.442533 23.3194444 0.434847 23.3222222 0.427162 23.3250000 0.418777 23.3277778 0.405502 23.3305556 0.397118 23.3333333 0.392926 23.3361111 0.394323 23.3388889 0.396419 23.3416667 0.397118 23.3444444 0.399913 23.3472222 0.402009 23.3500000 0.404803 23.3527778 0.407598 23.3555556 0.411092 23.3583333 0.413188 23.3611111 0.409694 23.3638889 0.404105 23.3666667 0.396419 23.3694444 0.382445 23.3722222 0.374760 23.3750000 0.360786 23.3777778 0.344017 23.3805556 0.327249 23.3833333 0.316769 23.3861111 0.310480 23.3888889 0.309083 23.3916667 0.308384 23.3944444 0.305590 23.3972222 0.300000 23.4000000 0.295808 23.4027778 0.297904 23.4055556 0.300000 23.4083333 0.298603 23.4111111 0.297205 23.4138889 0.293013 23.4166667 0.293013 23.4194444 0.293712 23.4222222 0.297205 23.4250000 0.296507 23.4277778 0.295109 23.4305556 0.291616 23.4333333 0.289520 23.4361111 0.291616 23.4388889 0.294410 23.4416667 0.295808 23.4444444 0.295109 23.4472222 0.289520 23.4500000 0.289520 23.4527778 0.290917 23.4555556 0.293712 23.4583333 0.292314 23.4611111 0.293013 23.4638889 0.290917 23.4666667 0.288821 23.4694444 0.290218 23.4722222 0.295808 23.4750000 0.294410 23.4777778 0.293712 23.4805556 0.290218 23.4833333 0.288821 23.4861111 0.291616 23.4888889 0.295808 23.4916667 0.296507 23.4944444 0.293712 23.4972222 0.290917 23.5000000 0.290917 23.5027778 0.292314 23.5055556 0.295808 23.5083333 0.294410 23.5111111 0.293712 23.5138889 0.290917 23.5166667 0.289520 23.5194444 0.291616 23.5222222 0.296507 23.5250000 0.297205 23.5277778 0.294410 23.5305556 0.292314 23.5333333 0.292314 23.5361111 0.295109 23.5388889 0.298603 23.5416667 0.300000 23.5444444 0.299301 23.5472222 0.297205 23.5500000 0.295109 23.5527778 0.297904 23.5555556 0.301397 23.5583333 0.302096 23.5611111 0.302795 23.5638889 0.298603 23.5666667 0.297904 23.5694444 0.302795 23.5722222 0.305590 23.5750000 0.307686 23.5777778 0.306987 23.5805556 0.302795 23.5833333 0.304192 23.5861111 0.306288 23.5888889 0.312576 23.5916667 0.312576 23.5944444 0.311179 23.6002222 0.300000 23.7581111 0.300000 23.7611111 0.337031 23.7638889 0.336332 23.7666667 0.336332 23.7694444 0.335633 23.7722222 0.339127 23.7750000 0.340524 23.7777778 0.341223 23.7805556 0.341223 23.7833333 0.339825 23.7861111 0.340524 23.7888889 0.341921 23.7916667 0.341921 23.7944444 0.343319 23.7972222 0.343319 23.8000000 0.341223 23.8027778 0.341921 23.8055556 0.343319 23.8083333 0.344017 23.8111111 0.344716 23.8138889 0.344017 23.8166667 0.344716 23.8194444 0.342620 23.8222222 0.344017 23.8250000 0.342620 23.8277778 0.344017 23.8305556 0.343319 23.8333333 0.344017 23.8361111 0.343319 23.8388889 0.344716 23.8416667 0.343319 23.8444444 0.343319 23.8472222 0.344017 23.8500000 0.344017 23.8527778 0.344716 23.8555556 0.345415 23.8583333 0.346114 23.8611111 0.344017 23.8638889 0.345415 23.8666667 0.346114 23.8694444 0.347511 23.8722222 0.348210 23.8750000 0.348210 23.8777778 0.347511 23.8805556 0.345415 23.8833333 0.348210 23.8861111 0.347511 23.8888889 0.352402 23.8916667 0.349607 23.8944444 0.346812 23.8972222 0.346114 23.9000000 0.348210 23.9027778 0.351004 23.9055556 0.352402 23.9083333 0.351703 23.9111111 0.348908 23.9138889 0.347511 23.9166667 0.346114 23.9194444 0.347511 23.9222222 0.349607 23.9250000 0.346114 23.9277778 0.341921 23.9305556 0.337031 23.9333333 0.332140 23.9361111 0.332838 23.9388889 0.328646 23.9416667 0.324454 23.9444444 0.319563 23.9472222 0.313275 23.9500000 0.310480 23.9527778 0.313974 23.9555556 0.318865 23.9583333 0.319563 23.9611111 0.314672 23.9638889 0.310480 23.9666667 0.308384 23.9694444 0.309083 23.9722222 0.309083 23.9750000 0.309083 23.9777778 0.306987 23.9805556 0.304192 23.9833333 0.301397 23.9861111 0.301397 23.9888889 0.302096 23.9916667 0.302795 23.9944444 0.302795 23.9972222 0.300699 24.0000000 0.297904 24.0027778 0.292314 24.0055556 0.288821 24.0083333 0.288122 24.0111111 0.285328 24.0138889 0.279738 24.0166667 0.274148 24.0194444 0.271354 24.0222222 0.272751 24.0250000 0.277642 24.0277778 0.281135 24.0305556 0.283930 24.0333333 0.290218 24.0361111 0.291616 24.0388889 0.293013 24.0416667 0.294410 24.0444444 0.290917 24.0472222 0.290218 24.0500000 0.287424 24.0527778 0.283231 24.0555556 0.276245 24.0583333 0.266463 24.0611111 0.258079 24.0638889 0.245502 24.0666667 0.232227 24.0694444 0.216856 24.0722222 0.201485 24.0750000 0.191703 24.0777778 0.181223 24.0805556 0.173537 24.0833333 0.167249 24.0861111 0.163057 24.0888889 0.161659 24.0916667 0.157467 24.0944444 0.156070 24.0972222 0.154672 24.1000000 0.154672 24.1027778 0.155371 24.1055556 0.153974 24.1083333 0.151878 24.1111111 0.149083 24.1138889 0.149782 24.1166667 0.149782 24.1194444 0.152576 24.1222222 0.150480 24.1250000 0.149083 24.1277778 0.149083 24.1305556 0.146987 24.1333333 0.146987 24.1361111 0.150480 24.1388889 0.149083 24.1416667 0.146987 24.1444444 0.146288 24.1472222 0.144192 24.1500000 0.143493 24.1527778 0.147686 24.1555556 0.148384 24.1583333 0.147686 24.1611111 0.144891 24.1638889 0.143493 24.1666667 0.146987 24.1694444 0.149083 24.1722222 0.151179 24.1750000 0.151878 24.1777778 0.149083 24.1805556 0.148384 24.1833333 0.152576 24.1861111 0.156769 24.1888889 0.158166 24.1916667 0.158166 24.1944444 0.156769 24.1972222 0.155371 24.2000000 0.158166 24.2027778 0.161659 24.2055556 0.165153 24.2083333 0.164454 24.2111111 0.161659 24.2138889 0.160961 24.2166667 0.162358 24.2194444 0.165852 24.2222222 0.167249 24.2250000 0.166550 24.2277778 0.165852 24.2305556 0.162358 24.2333333 0.165153 24.2361111 0.167948 24.2388889 0.171441 24.2416667 0.170742 24.2444444 0.170742 24.2472222 0.170044 24.2500000 0.172838 24.2527778 0.177729 24.2555556 0.179825 24.2583333 0.179825 24.2611111 0.179825 24.2638889 0.177031 24.2666667 0.178428 24.2694444 0.183319 24.2722222 0.186114 24.2750000 0.189607 24.2777778 0.188908 24.2805556 0.187511 24.2833333 0.189607 24.2861111 0.191703 24.2888889 0.197293 24.2916667 0.202183 24.2944444 0.199389 24.2972222 0.199389 24.3000000 0.199389 24.3027778 0.203581 24.3055556 0.208472 24.3083333 0.209869 24.3141111 0.300000 25.2053333 0.300000 25.2083333 0.330044 25.2111111 0.326550 25.2138889 0.324454 25.2166667 0.325153 25.2194444 0.327249 25.2222222 0.330742 25.2250000 0.328646 25.2277778 0.326550 25.2305556 0.323755 25.2333333 0.324454 25.2361111 0.326550 25.2388889 0.329345 25.2416667 0.327948 25.2444444 0.324454 25.2472222 0.321659 25.2500000 0.323057 25.2527778 0.324454 25.2555556 0.328646 25.2583333 0.327948 25.2611111 0.324454 25.2638889 0.320961 25.2666667 0.322358 25.2694444 0.323755 25.2722222 0.327948 25.2750000 0.326550 25.2777778 0.324454 25.2805556 0.320961 25.2833333 0.320262 25.2861111 0.323755 25.2888889 0.326550 25.2916667 0.327249 25.2944444 0.323755 25.2972222 0.320961 25.3000000 0.320961 25.3027778 0.323057 25.3055556 0.327948 25.3083333 0.327249 25.3111111 0.324454 25.3138889 0.320961 25.3166667 0.320961 25.3194444 0.323057 25.3222222 0.326550 25.3250000 0.326550 25.3277778 0.323057 25.3305556 0.321659 25.3333333 0.320961 25.3361111 0.323057 25.3388889 0.326550 25.3416667 0.327249 25.3444444 0.324454 25.3472222 0.321659 25.3500000 0.319563 25.3527778 0.322358 25.3555556 0.324454 25.3583333 0.325153 25.3611111 0.323755 25.3638889 0.321659 25.3666667 0.320961 25.3694444 0.321659 25.3722222 0.325852 25.3750000 0.326550 25.3777778 0.325153 25.3805556 0.322358 25.3833333 0.320262 25.3861111 0.323057 25.3888889 0.327249 25.3916667 0.328646 25.3944444 0.326550 25.3972222 0.322358 25.4000000 0.320961 25.4027778 0.324454 25.4055556 0.325153 25.4083333 0.322358 25.4111111 0.317467 25.4138889 0.309782 25.4166667 0.304891 25.4194444 0.302795 25.4222222 0.300699 25.4250000 0.298603 25.4277778 0.291616 25.4305556 0.288821 25.4333333 0.290218 25.4361111 0.293013 25.4388889 0.298603 25.4416667 0.297904 25.4444444 0.297904 25.4472222 0.299301 25.4500000 0.314672 25.4527778 0.343319 25.4555556 0.383144 25.4583333 0.415983 25.4611111 0.429956 25.4638889 0.433450 25.4666667 0.436245 25.4694444 0.443930 25.4722222 0.455109 25.4750000 0.458603 25.4777778 0.455808 25.4805556 0.448122 25.4833333 0.439039 25.4861111 0.430655 25.4888889 0.422271 25.4916667 0.415983 25.4944444 0.411790 25.4972222 0.406900 25.5000000 0.406201 25.5027778 0.406900 25.5055556 0.412489 25.5083333 0.417380 25.5111111 0.420873 25.5138889 0.420873 25.5166667 0.422969 25.5194444 0.424367 25.5222222 0.425764 25.5250000 0.419476 25.5277778 0.405502 25.5305556 0.388734 25.5333333 0.374760 25.5361111 0.362882 25.5388889 0.348210 25.5416667 0.338428 25.5444444 0.327249 25.5472222 0.320961 25.5500000 0.320961 25.5527778 0.322358 25.5555556 0.320961 25.5583333 0.319563 25.5611111 0.314672 25.5638889 0.312576 25.5666667 0.313275 25.5694444 0.315371 25.5722222 0.316070 25.5750000 0.314672 25.5777778 0.310480 25.5805556 0.309083 25.5833333 0.311878 25.5861111 0.312576 25.5888889 0.315371 25.5916667 0.312576 25.5944444 0.309083 25.5972222 0.307686 25.6000000 0.308384 25.6027778 0.311878 25.6055556 0.313974 25.6083333 0.310480 25.6111111 0.308384 25.6138889 0.306288 25.6166667 0.309083 25.6194444 0.311179 25.6222222 0.311878 25.6250000 0.309782 25.6277778 0.306987 25.6305556 0.305590 25.6333333 0.308384 25.6361111 0.311179 25.6388889 0.311878 25.6416667 0.309782 25.6444444 0.307686 25.6472222 0.306987 25.6500000 0.309083 25.6527778 0.313275 25.6555556 0.311179 25.6583333 0.311179 25.6611111 0.309083 25.6638889 0.309083 25.6666667 0.309782 25.6694444 0.313275 25.6722222 0.315371 25.6750000 0.311179 25.6777778 0.310480 25.6805556 0.310480 25.6833333 0.311878 25.6861111 0.315371 25.6888889 0.316769 25.6916667 0.313974 25.6944444 0.313275 25.6972222 0.311179 25.7000000 0.315371 25.7027778 0.317467 25.7055556 0.318865 25.7083333 0.316070 25.7111111 0.316070 25.7138889 0.314672 25.7166667 0.317467 25.7194444 0.318865 25.7222222 0.319563 25.7250000 0.318865 25.7277778 0.318166 25.7305556 0.318865 25.7333333 0.321659 25.7361111 0.322358 25.7388889 0.324454 25.7416667 0.322358 25.7444444 0.322358 25.7472222 0.322358 25.7500000 0.325153 25.7527778 0.327249 25.7555556 0.327948 25.7613333 0.300000 25.8942222 0.300000 25.8972222 0.341921 25.9000000 0.344716 25.9027778 0.348210 25.9055556 0.346114 25.9083333 0.346812 25.9111111 0.346812 25.9138889 0.346812 25.9166667 0.348210 25.9194444 0.351703 25.9222222 0.351004 25.9250000 0.351004 25.9277778 0.348210 25.9305556 0.350306 25.9333333 0.351703 25.9361111 0.353799 25.9388889 0.355197 25.9416667 0.353799 25.9444444 0.354498 25.9472222 0.354498 25.9500000 0.357293 25.9527778 0.358690 25.9555556 0.356594 25.9583333 0.357293 25.9611111 0.353799 25.9638889 0.354498 25.9666667 0.356594 25.9694444 0.357991 25.9722222 0.358690 25.9750000 0.355895 25.9777778 0.355197 25.9805556 0.354498 25.9833333 0.355895 25.9861111 0.358690 25.9888889 0.357293 25.9916667 0.352402 25.9944444 0.353100 25.9972222 0.353100 26.0000000 0.355197 26.0027778 0.357991 26.0055556 0.357991 26.0083333 0.355197 26.0111111 0.352402 26.0138889 0.353799 26.0166667 0.356594 26.0194444 0.358690 26.0222222 0.360786 26.0250000 0.357293 26.0277778 0.355895 26.0305556 0.353799 26.0333333 0.357293 26.0361111 0.359389 26.0388889 0.360087 26.0416667 0.359389 26.0444444 0.356594 26.0472222 0.356594 26.0500000 0.359389 26.0527778 0.361485 26.0555556 0.362882 26.0583333 0.358690 26.0611111 0.355197 26.0638889 0.353799 26.0666667 0.355197 26.0694444 0.353799 26.0722222 0.351703 26.0750000 0.346114 26.0777778 0.340524 26.0805556 0.335633 26.0833333 0.333537 26.0861111 0.329345 26.0888889 0.327249 26.0916667 0.321659 26.0944444 0.320262 26.0972222 0.322358 26.1000000 0.325153 26.1027778 0.331441 26.1055556 0.335633 26.1083333 0.333537 26.1111111 0.332838 26.1138889 0.334236 26.1166667 0.338428 26.1194444 0.346812 26.1222222 0.349607 26.1250000 0.351703 26.1277778 0.348210 26.1305556 0.344017 26.1333333 0.340524 26.1361111 0.340524 26.1388889 0.337031 26.1416667 0.330044 26.1444444 0.321659 26.1472222 0.318166 26.1500000 0.317467 26.1527778 0.318865 26.1555556 0.317467 26.1583333 0.313275 26.1611111 0.308384 26.1638889 0.305590 26.1666667 0.309083 26.1694444 0.313974 26.1722222 0.315371 26.1750000 0.309083 26.1777778 0.301397 26.1805556 0.293712 26.1833333 0.290218 26.1861111 0.284629 26.1888889 0.274148 26.1916667 0.257380 26.1944444 0.235721 26.1972222 0.214061 26.2000000 0.197991 26.2027778 0.189607 26.2055556 0.181223 26.2083333 0.172838 26.2111111 0.162358 26.2138889 0.157467 26.2166667 0.158166 26.2194444 0.160262 26.2222222 0.160262 26.2250000 0.156070 26.2277778 0.152576 26.2305556 0.149083 26.2333333 0.149782 26.2361111 0.153275 26.2388889 0.151179 26.2416667 0.147686 26.2444444 0.144891 26.2472222 0.143493 26.2500000 0.144192 26.2527778 0.146288 26.2555556 0.146288 26.2583333 0.143493 26.2611111 0.141397 26.2638889 0.138603 26.2666667 0.140000 26.2694444 0.140699 26.2722222 0.140699 26.2750000 0.136507 26.2777778 0.135109 26.2805556 0.135109 26.2833333 0.136507 26.2861111 0.137205 26.2888889 0.137904 26.2916667 0.137904 26.2944444 0.135808 26.2972222 0.134410 26.3000000 0.135808 26.3027778 0.137904 26.3055556 0.139301 26.3083333 0.136507 26.3111111 0.136507 26.3138889 0.135109 26.3166667 0.137205 26.3194444 0.138603 26.3222222 0.138603 26.3250000 0.140000 26.3277778 0.140000 26.3305556 0.140699 26.3333333 0.141397 26.3361111 0.144192 26.3388889 0.144891 26.3416667 0.142795 26.3444444 0.142795 26.3472222 0.146288 26.3500000 0.148384 26.3527778 0.148384 26.3555556 0.151179 26.3583333 0.151878 26.3611111 0.151179 26.3638889 0.153275 26.3666667 0.153974 26.3694444 0.155371 26.3722222 0.157467 26.3750000 0.156769 26.3777778 0.158865 26.3805556 0.161659 26.3833333 0.162358 26.3861111 0.163755 26.3888889 0.165153 26.3916667 0.163755 26.3944444 0.166550 26.3972222 0.170044 26.4000000 0.171441 26.4027778 0.172140 26.4055556 0.173537 26.4083333 0.173537 26.4111111 0.177031 26.4138889 0.177729 26.4166667 0.177729 26.4194444 0.177729 26.4222222 0.180524 26.4250000 0.182620 26.4277778 0.183319 26.4305556 0.184716 26.4333333 0.185415 26.4361111 0.184017 26.4388889 0.184716 26.4416667 0.186114 26.4444444 0.187511 26.4502222 0.300000 27.2442222 0.300000 27.2472222 0.327948 27.2500000 0.330742 27.2527778 0.330742 27.2555556 0.330742 27.2583333 0.330044 27.2611111 0.332140 27.2638889 0.331441 27.2666667 0.331441 27.2694444 0.332838 27.2722222 0.332140 27.2750000 0.332140 27.2777778 0.333537 27.2805556 0.333537 27.2833333 0.332140 27.2861111 0.331441 27.2888889 0.333537 27.2916667 0.332838 27.2944444 0.333537 27.2972222 0.334236 27.3000000 0.333537 27.3027778 0.332140 27.3055556 0.333537 27.3083333 0.334236 27.3111111 0.334934 27.3138889 0.334236 27.3166667 0.335633 27.3194444 0.334236 27.3222222 0.333537 27.3250000 0.334934 27.3277778 0.335633 27.3305556 0.334236 27.3333333 0.335633 27.3361111 0.332838 27.3388889 0.336332 27.3416667 0.337729 27.3444444 0.337729 27.3472222 0.334934 27.3500000 0.333537 27.3527778 0.334236 27.3555556 0.337031 27.3583333 0.339825 27.3611111 0.337031 27.3638889 0.335633 27.3666667 0.335633 27.3694444 0.337031 27.3722222 0.338428 27.3750000 0.339825 27.3777778 0.339127 27.3805556 0.337031 27.3833333 0.336332 27.3861111 0.337729 27.3888889 0.339825 27.3916667 0.341921 27.3944444 0.339127 27.3972222 0.337031 27.4000000 0.337031 27.4027778 0.338428 27.4055556 0.339825 27.4083333 0.342620 27.4111111 0.339825 27.4138889 0.337729 27.4166667 0.337031 27.4194444 0.339127 27.4222222 0.340524 27.4250000 0.343319 27.4277778 0.341921 27.4305556 0.338428 27.4333333 0.337729 27.4361111 0.339825 27.4388889 0.342620 27.4416667 0.341921 27.4444444 0.339825 27.4472222 0.334934 27.4500000 0.333537 27.4527778 0.332838 27.4555556 0.331441 27.4583333 0.326550 27.4611111 0.322358 27.4638889 0.316769 27.4666667 0.311878 27.4694444 0.312576 27.4722222 0.316070 27.4750000 0.320262 27.4777778 0.320262 27.4805556 0.318865 27.4833333 0.320262 27.4861111 0.328646 27.4888889 0.347511 27.4916667 0.378952 27.4944444 0.415983 27.4972222 0.445328 27.5000000 0.458603 27.5027778 0.466288 27.5055556 0.473275 27.5083333 0.478865 27.5111111 0.484454 27.5138889 0.485153 27.5166667 0.483755 27.5194444 0.478166 27.5222222 0.471179 27.5250000 0.459301 27.5277778 0.446725 27.5305556 0.436245 27.5333333 0.433450 27.5361111 0.435546 27.5388889 0.436245 27.5416667 0.436245 27.5444444 0.434847 27.5472222 0.436943 27.5500000 0.440437 27.5527778 0.445328 27.5555556 0.448122 27.5583333 0.446026 27.5611111 0.441834 27.5638889 0.434847 27.5666667 0.424367 27.5694444 0.415284 27.5722222 0.402009 27.5750000 0.385939 27.5777778 0.368472 27.5805556 0.356594 27.5833333 0.350306 27.5861111 0.350306 27.5888889 0.348908 27.5916667 0.346114 27.5944444 0.342620 27.5972222 0.338428 27.6000000 0.337729 27.6027778 0.340524 27.6055556 0.342620 27.6083333 0.340524 27.6111111 0.336332 27.6138889 0.333537 27.6166667 0.334934 27.6194444 0.338428 27.6222222 0.339127 27.6250000 0.337729 27.6277778 0.333537 27.6305556 0.331441 27.6333333 0.334934 27.6361111 0.338428 27.6388889 0.339825 27.6416667 0.337031 27.6444444 0.335633 27.6472222 0.331441 27.6500000 0.336332 27.6527778 0.337729 27.6555556 0.339127 27.6583333 0.339127 27.6611111 0.334236 27.6638889 0.331441 27.6666667 0.333537 27.6694444 0.337031 27.6722222 0.339825 27.6750000 0.336332 27.6777778 0.333537 27.6805556 0.332838 27.6833333 0.334934 27.6861111 0.337729 27.6888889 0.340524 27.6916667 0.337729 27.6944444 0.335633 27.6972222 0.334236 27.7000000 0.336332 27.7027778 0.339127 27.7055556 0.340524 27.7083333 0.339127 27.7111111 0.337031 27.7138889 0.334934 27.7166667 0.337729 27.7194444 0.341223 27.7222222 0.344017 27.7250000 0.340524 27.7277778 0.338428 27.7305556 0.337729 27.7333333 0.341223 27.7361111 0.346114 27.7388889 0.346114 27.7416667 0.344716 27.7444444 0.341223 27.7472222 0.344017 27.7500000 0.346114 27.7527778 0.348210 27.7555556 0.350306 27.7583333 0.348908 27.7611111 0.347511 27.7638889 0.348210 27.7666667 0.349607 27.7694444 0.353100 27.7722222 0.354498 27.7750000 0.352402 27.7777778 0.351703 27.7805556 0.353100 27.7833333 0.355197 27.7861111 0.357293 27.7888889 0.359389 27.7916667 0.356594 27.7944444 0.355197 27.8002222 0.300000 27.9303333 0.300000 27.9333333 0.378253 27.9361111 0.381747 27.9388889 0.382445 27.9416667 0.379651 27.9444444 0.379651 27.9472222 0.378952 27.9500000 0.382445 27.9527778 0.387336 27.9555556 0.384541 27.9583333 0.385240 27.9611111 0.382445 27.9638889 0.383144 27.9666667 0.385939 27.9694444 0.389432 27.9722222 0.390830 27.9750000 0.388734 27.9777778 0.388035 27.9805556 0.385939 27.9833333 0.390131 27.9861111 0.391528 27.9888889 0.393624 27.9916667 0.390131 27.9944444 0.389432 27.9972222 0.386638 28.0000000 0.393624 28.0027778 0.392227 28.0055556 0.392926 28.0083333 0.390131 28.0111111 0.388035 28.0138889 0.386638 28.0166667 0.390131 28.0194444 0.391528 28.0222222 0.393624 28.0250000 0.388035 28.0277778 0.388035 28.0305556 0.386638 28.0333333 0.389432 28.0361111 0.392227 28.0388889 0.392227 28.0416667 0.391528 28.0444444 0.390131 28.0472222 0.388035 28.0500000 0.390830 28.0527778 0.392227 28.0555556 0.393624 28.0583333 0.392227 28.0611111 0.389432 28.0638889 0.389432 28.0666667 0.391528 28.0694444 0.392926 28.0722222 0.397118 28.0750000 0.392926 28.0777778 0.391528 28.0805556 0.390131 28.0833333 0.394323 28.0861111 0.396419 28.0888889 0.397817 28.0916667 0.395022 28.0944444 0.391528 28.0972222 0.392227 28.1000000 0.392227 28.1027778 0.393624 28.1055556 0.392227 28.1083333 0.390131 28.1111111 0.385939 28.1138889 0.382445 28.1166667 0.382445 28.1194444 0.378253 28.1222222 0.373362 28.1250000 0.367773 28.1277778 0.360786 28.1305556 0.357293 28.1333333 0.357991 28.1361111 0.361485 28.1388889 0.363581 28.1416667 0.362183 28.1444444 0.361485 28.1472222 0.360087 28.1500000 0.363581 28.1527778 0.369170 28.1555556 0.370568 28.1583333 0.369170 28.1611111 0.366376 28.1638889 0.362183 28.1666667 0.360786 28.1694444 0.360786 28.1722222 0.362882 28.1750000 0.355895 28.1777778 0.344716 28.1805556 0.338428 28.1833333 0.332838 28.1861111 0.331441 28.1888889 0.330742 28.1916667 0.329345 28.1944444 0.325852 28.1972222 0.323057 28.2000000 0.329345 28.2027778 0.338428 28.2055556 0.346114 28.2083333 0.349607 28.2111111 0.347511 28.2138889 0.343319 28.2166667 0.344017 28.2194444 0.341223 28.2222222 0.335633 28.2250000 0.323057 28.2277778 0.304891 28.2305556 0.284629 28.2333333 0.267162 28.2361111 0.253886 28.2388889 0.242009 28.2416667 0.229432 28.2444444 0.219651 28.2472222 0.213362 28.2500000 0.213362 28.2527778 0.214061 28.2555556 0.214061 28.2583333 0.209170 28.2611111 0.207074 28.2638889 0.204978 28.2666667 0.205677 28.2694444 0.207074 28.2722222 0.205677 28.2750000 0.202882 28.2777778 0.200786 28.2805556 0.199389 28.2833333 0.201485 28.2861111 0.200786 28.2888889 0.200786 28.2916667 0.198690 28.2944444 0.195197 28.2972222 0.195895 28.3000000 0.198690 28.3027778 0.198690 28.3055556 0.198690 28.3083333 0.195197 28.3111111 0.193100 28.3138889 0.193100 28.3166667 0.194498 28.3194444 0.198690 28.3222222 0.197991 28.3250000 0.195197 28.3277778 0.193100 28.3305556 0.193799 28.3333333 0.196594 28.3361111 0.197991 28.3388889 0.199389 28.3416667 0.195895 28.3444444 0.195197 28.3472222 0.196594 28.3500000 0.200786 28.3527778 0.203581 28.3555556 0.203581 28.3583333 0.200786 28.3611111 0.200786 28.3638889 0.202183 28.3666667 0.207074 28.3694444 0.207773 28.3722222 0.205677 28.3750000 0.205677 28.3777778 0.207773 28.3805556 0.209170 28.3833333 0.211266 28.3861111 0.212664 28.3888889 0.211965 28.3916667 0.214061 28.3944444 0.214760 28.3972222 0.215459 28.4000000 0.216157 28.4027778 0.218952 28.4055556 0.217555 28.4083333 0.220349 28.4111111 0.222445 28.4138889 0.223144 28.4166667 0.225240 28.4194444 0.225939 28.4222222 0.228035 28.4250000 0.230830 28.4277778 0.231528 28.4305556 0.232227 28.4333333 0.232227 28.4361111 0.234323 28.4388889 0.235022 28.4416667 0.237817 28.4444444 0.239214 28.4472222 0.239913 28.4500000 0.242009 28.4527778 0.242009 28.4555556 0.242707 28.4583333 0.244803 28.4611111 0.248297 28.4638889 0.248996 28.4666667 0.248996 28.4694444 0.252489 28.4722222 0.251790 28.4750000 0.253188 28.4777778 0.255284 28.4805556 0.255284 28.4863333 0.300000 29.2997778 0.300000 29.3027778 0.340524 29.3055556 0.341223 29.3083333 0.342620 29.3111111 0.341921 29.3138889 0.341223 29.3166667 0.342620 29.3194444 0.342620 29.3222222 0.343319 29.3250000 0.346114 29.3277778 0.345415 29.3305556 0.344716 29.3333333 0.344716 29.3361111 0.345415 29.3388889 0.344017 29.3416667 0.344017 29.3444444 0.344716 29.3472222 0.346114 29.3500000 0.345415 29.3527778 0.346114 29.3555556 0.345415 29.3583333 0.346114 29.3611111 0.346812 29.3638889 0.344716 29.3666667 0.346812 29.3694444 0.346812 29.3722222 0.346812 29.3750000 0.347511 29.3777778 0.348210 29.3805556 0.347511 29.3833333 0.347511 29.3861111 0.347511 29.3888889 0.348210 29.3916667 0.348210 29.3944444 0.350306 29.3972222 0.348908 29.4000000 0.347511 29.4027778 0.348908 29.4055556 0.348908 29.4083333 0.350306 29.4111111 0.351004 29.4138889 0.348908 29.4166667 0.348210 29.4194444 0.348908 29.4222222 0.349607 29.4250000 0.351004 29.4277778 0.351004 29.4305556 0.350306 29.4333333 0.350306 29.4361111 0.350306 29.4388889 0.349607 29.4416667 0.352402 29.4444444 0.353799 29.4472222 0.351703 29.4500000 0.349607 29.4527778 0.350306 29.4555556 0.351004 29.4583333 0.352402 29.4611111 0.351703 29.4638889 0.350306 29.4666667 0.351004 29.4694444 0.351703 29.4722222 0.351703 29.4750000 0.352402 29.4777778 0.353100 29.4805556 0.350306 29.4833333 0.351703 29.4861111 0.351004 29.4888889 0.352402 29.4916667 0.353100 29.4944444 0.351703 29.4972222 0.351004 29.5000000 0.349607 29.5027778 0.348210 29.5055556 0.348210 29.5083333 0.347511 29.5111111 0.343319 29.5138889 0.335633 29.5166667 0.330742 29.5194444 0.328646 29.5222222 0.327249 29.5250000 0.325153 29.5277778 0.323057 29.5305556 0.323755 29.5333333 0.324454 29.5361111 0.327249 29.5388889 0.332140 29.5416667 0.334236 29.5444444 0.342620 29.5472222 0.358690 29.5500000 0.392926 29.5527778 0.432751 29.5555556 0.462795 29.5583333 0.472576 29.5611111 0.475371 29.5638889 0.476769 29.5666667 0.482358 29.5694444 0.489345 29.5722222 0.490742 29.5750000 0.482358 29.5777778 0.468384 29.5805556 0.455808 29.5833333 0.445328 29.5861111 0.443231 29.5888889 0.441834 29.5916667 0.441834 29.5944444 0.434847 29.5972222 0.434847 29.6000000 0.439738 29.6027778 0.449520 29.6055556 0.452314 29.6083333 0.451616 29.6111111 0.450218 29.6138889 0.448821 29.6166667 0.447424 29.6194444 0.444629 29.6222222 0.436245 29.6250000 0.421572 29.6277778 0.402707 29.6305556 0.385240 29.6333333 0.372664 29.6361111 0.364978 29.6388889 0.361485 29.6416667 0.354498 29.6444444 0.349607 29.6472222 0.346114 29.6500000 0.348908 29.6527778 0.349607 29.6555556 0.350306 29.6583333 0.346114 29.6611111 0.342620 29.6638889 0.341921 29.6666667 0.344017 29.6694444 0.346114 29.6722222 0.346812 29.6750000 0.342620 29.6777778 0.341223 29.6805556 0.340524 29.6833333 0.344017 29.6861111 0.346114 29.6888889 0.345415 29.6916667 0.341223 29.6944444 0.341223 29.6972222 0.340524 29.7000000 0.343319 29.7027778 0.344716 29.7055556 0.344716 29.7083333 0.341223 29.7111111 0.340524 29.7138889 0.340524 29.7166667 0.344716 29.7194444 0.344716 29.7222222 0.344017 29.7250000 0.341921 29.7277778 0.341921 29.7305556 0.341921 29.7333333 0.344716 29.7361111 0.346812 29.7388889 0.344716 29.7416667 0.341921 29.7444444 0.341223 29.7472222 0.341921 29.7500000 0.345415 29.7527778 0.346812 29.7555556 0.345415 29.7583333 0.343319 29.7611111 0.342620 29.7638889 0.343319 29.7666667 0.346812 29.7694444 0.348210 29.7722222 0.346812 29.7750000 0.344716 29.7777778 0.345415 29.7805556 0.346114 29.7833333 0.351004 29.7861111 0.350306 29.7888889 0.349607 29.7916667 0.348908 29.7944444 0.348908 29.7972222 0.350306 29.8000000 0.351703 29.8027778 0.354498 29.8055556 0.353799 29.8083333 0.353100 29.8111111 0.353100 29.8138889 0.355197 29.8166667 0.355895 29.8194444 0.356594 29.8222222 0.355895 29.8250000 0.356594 29.8277778 0.356594 29.8305556 0.357991 29.8333333 0.360786 29.8361111 0.360786 29.8388889 0.360087 29.8416667 0.360087 29.8444444 0.360087 29.8472222 0.363581 29.8500000 0.364279 29.8557778 0.300000 29.9942222 0.300000 29.9972222 0.382445 30.0000000 0.384541 30.0027778 0.387336 30.0055556 0.388035 30.0083333 0.386638 30.0111111 0.385240 30.0138889 0.385240 30.0166667 0.387336 30.0194444 0.392227 30.0222222 0.391528 30.0250000 0.390131 30.0277778 0.388734 30.0305556 0.387336 30.0333333 0.388734 30.0361111 0.393624 30.0388889 0.394323 30.0416667 0.392227 30.0444444 0.390131 30.0472222 0.389432 30.0500000 0.391528 30.0527778 0.392926 30.0555556 0.395022 30.0583333 0.396419 30.0611111 0.391528 30.0638889 0.389432 30.0666667 0.390830 30.0694444 0.395022 30.0722222 0.393624 30.0750000 0.395022 30.0777778 0.392926 30.0805556 0.390131 30.0833333 0.390830 30.0861111 0.394323 30.0888889 0.395022 30.0916667 0.394323 30.0944444 0.392926 30.0972222 0.391528 30.1000000 0.392227 30.1027778 0.394323 30.1055556 0.395022 30.1083333 0.395721 30.1111111 0.395022 30.1138889 0.391528 30.1166667 0.392926 30.1194444 0.393624 30.1222222 0.397118 30.1250000 0.397817 30.1277778 0.396419 30.1305556 0.392926 30.1333333 0.394323 30.1361111 0.395721 30.1388889 0.396419 30.1416667 0.397817 30.1444444 0.395721 30.1472222 0.395721 30.1500000 0.394323 30.1527778 0.397118 30.1555556 0.397118 30.1583333 0.395721 30.1611111 0.395721 30.1638889 0.393624 30.1666667 0.391528 30.1694444 0.391528 30.1722222 0.390131 30.1750000 0.389432 30.1777778 0.388035 30.1805556 0.382445 30.1833333 0.378253 30.1861111 0.374760 30.1888889 0.367074 30.1916667 0.366376 30.1944444 0.365677 30.1972222 0.365677 30.2000000 0.366376 30.2027778 0.369170 30.2055556 0.370568 30.2083333 0.372664 30.2111111 0.372664 30.2138889 0.372664 30.2166667 0.372664 30.2194444 0.376157 30.2222222 0.378253 30.2250000 0.381048 30.2277778 0.378952 30.2305556 0.376856 30.2333333 0.373362 30.2361111 0.371266 30.2388889 0.365677 30.2416667 0.362882 30.2444444 0.353799 30.2472222 0.346114 30.2500000 0.338428 30.2527778 0.338428 30.2555556 0.341223 30.2583333 0.341921 30.2611111 0.344017 30.2638889 0.344716 30.2666667 0.348210 30.2694444 0.352402 30.2722222 0.355197 30.2750000 0.357991 30.2777778 0.353799 30.2805556 0.352402 30.2833333 0.347511 30.2861111 0.344017 30.2888889 0.336332 30.2916667 0.328646 30.2944444 0.319563 30.2972222 0.304192 30.3000000 0.286725 30.3027778 0.267162 30.3055556 0.251790 30.3083333 0.241310 30.3111111 0.232926 30.3138889 0.226638 30.3166667 0.223843 30.3194444 0.218952 30.3222222 0.218952 30.3250000 0.216856 30.3277778 0.214760 30.3305556 0.214061 30.3333333 0.212664 30.3361111 0.212664 30.3388889 0.210568 30.3416667 0.209170 30.3444444 0.209869 30.3472222 0.209170 30.3500000 0.206376 30.3527778 0.207074 30.3555556 0.207074 30.3583333 0.204978 30.3611111 0.204279 30.3638889 0.204978 30.3666667 0.204279 30.3694444 0.204279 30.3722222 0.204978 30.3750000 0.202882 30.3777778 0.204279 30.3805556 0.204279 30.3833333 0.201485 30.3861111 0.202882 30.3888889 0.201485 30.3916667 0.204279 30.3944444 0.202882 30.3972222 0.204279 30.4000000 0.202183 30.4027778 0.204279 30.4055556 0.203581 30.4083333 0.204279 30.4111111 0.205677 30.4138889 0.204279 30.4166667 0.206376 30.4194444 0.206376 30.4222222 0.209170 30.4250000 0.209170 30.4277778 0.210568 30.4305556 0.209170 30.4333333 0.209869 30.4361111 0.211965 30.4388889 0.211266 30.4416667 0.213362 30.4444444 0.214760 30.4472222 0.216157 30.4500000 0.215459 30.4527778 0.216856 30.4555556 0.218253 30.4583333 0.221747 30.4611111 0.222445 30.4638889 0.223843 30.4666667 0.223843 30.4694444 0.224541 30.4722222 0.225939 30.4750000 0.226638 30.4777778 0.227336 30.4805556 0.228734 30.4833333 0.230830 30.4861111 0.231528 30.4888889 0.230830 30.4916667 0.232926 30.4944444 0.235022 30.4972222 0.237817 30.5000000 0.239214 30.5027778 0.241310 30.5055556 0.239913 30.5083333 0.242009 30.5111111 0.242009 30.5138889 0.243406 30.5166667 0.244803 30.5194444 0.244105 30.5222222 0.246201 30.5250000 0.248297 30.5277778 0.248996 30.5305556 0.250393 30.5333333 0.251790 30.5361111 0.251790 30.5388889 0.251092 30.5416667 0.253886 30.5444444 0.253886 30.5502222 0.300000 31.4136667 0.300000 31.4166667 0.202882 31.4194444 0.199389 31.4222222 0.200087 31.4250000 0.202882 31.4277778 0.200786 31.4305556 0.200786 31.4333333 0.200786 31.4361111 0.200786 31.4388889 0.200087 31.4416667 0.201485 31.4444444 0.200087 31.4472222 0.199389 31.4500000 0.199389 31.4527778 0.202183 31.4555556 0.200087 31.4583333 0.200786 31.4611111 0.199389 31.4638889 0.200087 31.4666667 0.200087 31.4694444 0.201485 31.4722222 0.200087 31.4750000 0.202183 31.4777778 0.201485 31.4805556 0.200087 31.4833333 0.199389 31.4861111 0.200786 31.4888889 0.202882 31.4916667 0.203581 31.4944444 0.202183 31.4972222 0.200087 31.5000000 0.201485 31.5027778 0.202183 31.5055556 0.202183 31.5083333 0.203581 31.5111111 0.204279 31.5138889 0.203581 31.5166667 0.204279 31.5194444 0.202183 31.5222222 0.204978 31.5250000 0.205677 31.5277778 0.202882 31.5305556 0.202183 31.5333333 0.201485 31.5361111 0.203581 31.5388889 0.207074 31.5416667 0.205677 31.5444444 0.204279 31.5472222 0.202882 31.5500000 0.202882 31.5527778 0.207074 31.5555556 0.207773 31.5583333 0.209869 31.5611111 0.206376 31.5638889 0.204279 31.5666667 0.204978 31.5694444 0.207773 31.5722222 0.209869 31.5750000 0.209869 31.5777778 0.207074 31.5805556 0.205677 31.5833333 0.207773 31.5861111 0.209869 31.5888889 0.212664 31.5916667 0.211266 31.5944444 0.209869 31.5972222 0.209869 31.6000000 0.211965 31.6027778 0.215459 31.6055556 0.216856 31.6083333 0.214061 31.6111111 0.212664 31.6138889 0.211266 31.6166667 0.213362 31.6194444 0.216856 31.6222222 0.216856 31.6250000 0.210568 31.6277778 0.206376 31.6305556 0.202882 31.6333333 0.202183 31.6361111 0.203581 31.6388889 0.201485 31.6416667 0.196594 31.6444444 0.195895 31.6472222 0.197293 31.6500000 0.204978 31.6527778 0.208472 31.6555556 0.211965 31.6583333 0.215459 31.6611111 0.225939 31.6638889 0.249694 31.6666667 0.288821 31.6694444 0.323057 31.6722222 0.337031 31.6750000 0.341223 31.6777778 0.341223 31.6805556 0.349607 31.6833333 0.361485 31.6861111 0.369869 31.6888889 0.371266 31.6916667 0.364279 31.6944444 0.352402 31.6972222 0.341921 31.7000000 0.337729 31.7027778 0.337031 31.7055556 0.337031 31.7083333 0.336332 31.7111111 0.333537 31.7138889 0.332140 31.7166667 0.341921 31.7194444 0.351703 31.7222222 0.355895 31.7250000 0.358690 31.7277778 0.360087 31.7305556 0.362882 31.7333333 0.364978 31.7361111 0.362183 31.7388889 0.352402 31.7416667 0.339127 31.7444444 0.324454 31.7472222 0.314672 31.7500000 0.305590 31.7527778 0.297205 31.7555556 0.290218 31.7583333 0.283930 31.7611111 0.280437 31.7638889 0.281135 31.7666667 0.285328 31.7694444 0.286026 31.7722222 0.284629 31.7750000 0.283930 31.7777778 0.283930 31.7805556 0.286725 31.7833333 0.290917 31.7861111 0.293013 31.7888889 0.291616 31.7916667 0.288122 31.7944444 0.288821 31.7972222 0.293712 31.8000000 0.295808 31.8027778 0.296507 31.8055556 0.297205 31.8083333 0.295109 31.8111111 0.297205 31.8138889 0.299301 31.8166667 0.301397 31.8194444 0.302795 31.8222222 0.302096 31.8250000 0.300699 31.8277778 0.302096 31.8305556 0.303493 31.8333333 0.306288 31.8361111 0.306987 31.8388889 0.306987 31.8416667 0.306987 31.8444444 0.305590 31.8472222 0.309083 31.8500000 0.311878 31.8527778 0.311179 31.8555556 0.311179 31.8583333 0.310480 31.8611111 0.310480 31.8638889 0.313275 31.8666667 0.316769 31.8694444 0.316070 31.8722222 0.316070 31.8750000 0.316070 31.8777778 0.316070 31.8805556 0.318166 31.8833333 0.321659 31.8861111 0.323755 31.8888889 0.323057 31.8916667 0.321659 31.8944444 0.323057 31.8972222 0.326550 31.9000000 0.329345 31.9027778 0.331441 31.9055556 0.330742 31.9083333 0.330044 31.9111111 0.330742 31.9138889 0.331441 31.9166667 0.335633 31.9194444 0.337031 31.9222222 0.336332 31.9250000 0.337031 31.9277778 0.337729 31.9305556 0.339127 31.9333333 0.343319 31.9361111 0.344017 31.9388889 0.343319 31.9416667 0.343319 31.9444444 0.343319 31.9472222 0.348908 31.9500000 0.351004 31.9527778 0.352402 31.9555556 0.352402 31.9583333 0.351703 31.9611111 0.351703 31.9638889 0.354498 31.9696667 0.300000 32.1053333 0.300000 32.1083333 0.404803 32.1111111 0.403406 32.1138889 0.408297 32.1166667 0.411092 32.1194444 0.413188 32.1222222 0.413886 32.1250000 0.411092 32.1277778 0.411092 32.1305556 0.413188 32.1333333 0.417380 32.1361111 0.418777 32.1388889 0.419476 32.1416667 0.417380 32.1444444 0.418079 32.1472222 0.418777 32.1500000 0.422271 32.1527778 0.425066 32.1555556 0.422969 32.1583333 0.421572 32.1611111 0.420873 32.1638889 0.423668 32.1666667 0.425764 32.1694444 0.429956 32.1722222 0.427860 32.1750000 0.426463 32.1777778 0.423668 32.1805556 0.423668 32.1833333 0.427162 32.1861111 0.430655 32.1888889 0.429258 32.1916667 0.426463 32.1944444 0.424367 32.1972222 0.425066 32.2000000 0.429258 32.2027778 0.430655 32.2055556 0.429258 32.2083333 0.425764 32.2111111 0.424367 32.2138889 0.425764 32.2166667 0.430655 32.2194444 0.432052 32.2222222 0.432052 32.2250000 0.427162 32.2277778 0.426463 32.2305556 0.429258 32.2333333 0.431354 32.2361111 0.434847 32.2388889 0.432751 32.2416667 0.432052 32.2444444 0.429956 32.2472222 0.433450 32.2500000 0.436245 32.2527778 0.436943 32.2555556 0.436245 32.2583333 0.432751 32.2611111 0.432052 32.2638889 0.436245 32.2666667 0.438341 32.2694444 0.438341 32.2722222 0.434847 32.2750000 0.432751 32.2777778 0.430655 32.2805556 0.432751 32.2833333 0.433450 32.2861111 0.432052 32.2888889 0.430655 32.2916667 0.425764 32.2944444 0.417380 32.2972222 0.415983 32.3000000 0.413886 32.3027778 0.410393 32.3055556 0.409694 32.3083333 0.404803 32.3111111 0.406201 32.3138889 0.407598 32.3166667 0.408297 32.3194444 0.411092 32.3222222 0.411790 32.3250000 0.414585 32.3277778 0.420175 32.3305556 0.426463 32.3333333 0.434847 32.3361111 0.440437 32.3388889 0.443930 32.3416667 0.444629 32.3444444 0.444629 32.3472222 0.442533 32.3500000 0.438341 32.3527778 0.433450 32.3555556 0.427162 32.3583333 0.420873 32.3611111 0.413188 32.3638889 0.410393 32.3666667 0.406201 32.3694444 0.403406 32.3722222 0.399214 32.3750000 0.395022 32.3777778 0.393624 32.3805556 0.388035 32.3833333 0.381048 32.3861111 0.374760 32.3888889 0.368472 32.3916667 0.359389 32.3944444 0.346812 32.3972222 0.334934 32.4000000 0.325852 32.4027778 0.311179 32.4055556 0.300000 32.4083333 0.288821 32.4111111 0.279738 32.4138889 0.272751 32.4166667 0.271354 32.4194444 0.266463 32.4222222 0.267162 32.4250000 0.265066 32.4277778 0.265066 32.4305556 0.263668 32.4333333 0.262969 32.4361111 0.265066 32.4388889 0.261572 32.4416667 0.260873 32.4444444 0.260873 32.4472222 0.260873 32.4500000 0.260175 32.4527778 0.260175 32.4555556 0.260873 32.4583333 0.260175 32.4611111 0.260175 32.4638889 0.259476 32.4666667 0.258079 32.4694444 0.258777 32.4722222 0.258777 32.4750000 0.259476 32.4777778 0.259476 32.4805556 0.257380 32.4833333 0.258777 32.4861111 0.258079 32.4888889 0.259476 32.4916667 0.259476 32.4944444 0.259476 32.4972222 0.258777 32.5000000 0.259476 32.5027778 0.261572 32.5055556 0.260175 32.5083333 0.262271 32.5111111 0.260873 32.5138889 0.261572 32.5166667 0.262969 32.5194444 0.265764 32.5222222 0.265066 32.5250000 0.265764 32.5277778 0.266463 32.5305556 0.265764 32.5333333 0.266463 32.5361111 0.269258 32.5388889 0.272052 32.5416667 0.272052 32.5444444 0.271354 32.5472222 0.272052 32.5500000 0.272751 32.5527778 0.275546 32.5555556 0.278341 32.5583333 0.279039 32.5611111 0.280437 32.5638889 0.279039 32.5666667 0.282533 32.5694444 0.283231 32.5722222 0.286026 32.5750000 0.286725 32.5777778 0.290218 32.5805556 0.288122 32.5833333 0.288821 32.5861111 0.291616 32.5888889 0.294410 32.5916667 0.294410 32.5944444 0.295808 32.5972222 0.295109 32.6000000 0.297904 32.6027778 0.299301 32.6055556 0.301397 32.6083333 0.304192 32.6111111 0.302795 32.6138889 0.304891 32.6166667 0.306288 32.6194444 0.306288 32.6222222 0.309083 32.6250000 0.312576 32.6277778 0.312576 32.6305556 0.313974 32.6333333 0.313974 32.6361111 0.316769 32.6388889 0.318166 32.6416667 0.319563 32.6444444 0.321659 32.6472222 0.321659 32.6500000 0.322358 32.6527778 0.325852 32.6555556 0.325852 32.6613333 0.300000 33.4886667 0.300000 33.4916667 0.312576 33.4944444 0.309782 33.4972222 0.311878 33.5000000 0.313974 33.5027778 0.315371 33.5055556 0.312576 33.5083333 0.309782 33.5111111 0.306288 33.5138889 0.310480 33.5166667 0.311878 33.5194444 0.313275 33.5222222 0.311179 33.5250000 0.306987 33.5277778 0.304891 33.5305556 0.305590 33.5333333 0.307686 33.5361111 0.308384 33.5388889 0.306987 33.5416667 0.302096 33.5444444 0.300699 33.5472222 0.304891 33.5500000 0.304192 33.5527778 0.304891 33.5555556 0.301397 33.5583333 0.296507 33.5611111 0.295109 33.5638889 0.296507 33.5666667 0.299301 33.5694444 0.297904 33.5722222 0.295808 33.5750000 0.292314 33.5777778 0.293013 33.5805556 0.293013 33.5833333 0.294410 33.5861111 0.293013 33.5888889 0.290917 33.5916667 0.287424 33.5944444 0.288122 33.5972222 0.290218 33.6000000 0.288821 33.6027778 0.288122 33.6055556 0.284629 33.6083333 0.281834 33.6111111 0.281834 33.6138889 0.283231 33.6166667 0.285328 33.6194444 0.283930 33.6222222 0.282533 33.6250000 0.279738 33.6277778 0.277642 33.6305556 0.277642 33.6333333 0.276943 33.6361111 0.276943 33.6388889 0.275546 33.6416667 0.275546 33.6444444 0.274847 33.6472222 0.274148 33.6500000 0.272751 33.6527778 0.271354 33.6555556 0.271354 33.6583333 0.270655 33.6611111 0.269258 33.6638889 0.268559 33.6666667 0.268559 33.6694444 0.267860 33.6722222 0.267162 33.6750000 0.265764 33.6777778 0.265066 33.6805556 0.264367 33.6833333 0.263668 33.6861111 0.262969 33.6888889 0.262271 33.6916667 0.260873 33.6944444 0.257380 33.6972222 0.253886 33.7000000 0.250393 33.7027778 0.244105 33.7055556 0.244105 33.7083333 0.239913 33.7111111 0.237118 33.7138889 0.233624 33.7166667 0.233624 33.7194444 0.235022 33.7222222 0.238515 33.7250000 0.239913 33.7277778 0.239214 33.7305556 0.244105 33.7333333 0.252489 33.7361111 0.276245 33.7388889 0.309782 33.7416667 0.339825 33.7444444 0.353100 33.7472222 0.356594 33.7500000 0.358690 33.7527778 0.362882 33.7555556 0.370568 33.7583333 0.371266 33.7611111 0.366376 33.7638889 0.358690 33.7666667 0.345415 33.7694444 0.334236 33.7722222 0.325852 33.7750000 0.320961 33.7777778 0.317467 33.7805556 0.317467 33.7833333 0.318865 33.7861111 0.322358 33.7888889 0.325153 33.7916667 0.327948 33.7944444 0.330742 33.7972222 0.330742 33.8000000 0.332838 33.8027778 0.334236 33.8055556 0.332838 33.8083333 0.323755 33.8111111 0.311878 33.8138889 0.297205 33.8166667 0.285328 33.8194444 0.276245 33.8222222 0.265066 33.8250000 0.251790 33.8277778 0.240611 33.8305556 0.234323 33.8333333 0.232926 33.8361111 0.232926 33.8388889 0.230830 33.8416667 0.227336 33.8444444 0.223144 33.8472222 0.223144 33.8500000 0.225240 33.8527778 0.226638 33.8555556 0.225240 33.8583333 0.221048 33.8611111 0.218952 33.8638889 0.218952 33.8666667 0.218952 33.8694444 0.223144 33.8722222 0.223144 33.8750000 0.218952 33.8777778 0.215459 33.8805556 0.217555 33.8833333 0.218952 33.8861111 0.221747 33.8888889 0.221048 33.8916667 0.217555 33.8944444 0.216157 33.8972222 0.216856 33.9000000 0.220349 33.9027778 0.218253 33.9055556 0.217555 33.9083333 0.216856 33.9111111 0.215459 33.9138889 0.216856 33.9166667 0.218253 33.9194444 0.219651 33.9222222 0.218952 33.9250000 0.216157 33.9277778 0.214760 33.9305556 0.215459 33.9333333 0.219651 33.9361111 0.221048 33.9388889 0.218253 33.9416667 0.215459 33.9444444 0.215459 33.9472222 0.218253 33.9500000 0.221747 33.9527778 0.221048 33.9555556 0.220349 33.9583333 0.218253 33.9611111 0.218253 33.9638889 0.221747 33.9666667 0.222445 33.9694444 0.223843 33.9722222 0.224541 33.9750000 0.222445 33.9777778 0.222445 33.9805556 0.224541 33.9833333 0.227336 33.9861111 0.228035 33.9888889 0.228035 33.9916667 0.226638 33.9944444 0.227336 33.9972222 0.230830 34.0000000 0.231528 34.0027778 0.233624 34.0055556 0.232926 34.0083333 0.231528 34.0111111 0.233624 34.0138889 0.235022 34.0166667 0.235721 34.0194444 0.237118 34.0222222 0.236419 34.0250000 0.233624 34.0277778 0.237817 34.0305556 0.239913 34.0333333 0.242009 34.0361111 0.243406 34.0388889 0.243406 34.0446667 0.300000 34.1525556 0.300000 34.1555556 0.249694 34.1583333 0.248996 34.1611111 0.248297 34.1638889 0.246201 34.1666667 0.247598 34.1694444 0.248297 34.1722222 0.250393 34.1750000 0.250393 34.1777778 0.249694 34.1805556 0.247598 34.1833333 0.247598 34.1861111 0.249694 34.1888889 0.253188 34.1916667 0.251790 34.1944444 0.248996 34.1972222 0.247598 34.2000000 0.248996 34.2027778 0.249694 34.2055556 0.253188 34.2083333 0.251092 34.2111111 0.248996 34.2138889 0.248996 34.2166667 0.250393 34.2194444 0.253188 34.2222222 0.253886 34.2250000 0.252489 34.2277778 0.250393 34.2305556 0.248297 34.2333333 0.250393 34.2361111 0.250393 34.2388889 0.249694 34.2416667 0.248996 34.2444444 0.247598 34.2472222 0.248996 34.2500000 0.247598 34.2527778 0.251092 34.2555556 0.251092 34.2583333 0.246201 34.2611111 0.244803 34.2638889 0.246900 34.2666667 0.247598 34.2694444 0.248996 34.2722222 0.244803 34.2750000 0.242707 34.2777778 0.241310 34.2805556 0.241310 34.2833333 0.244105 34.2861111 0.246201 34.2888889 0.244105 34.2916667 0.242009 34.2944444 0.238515 34.2972222 0.240611 34.3000000 0.242009 34.3027778 0.242707 34.3055556 0.241310 34.3083333 0.237118 34.3111111 0.236419 34.3138889 0.237118 34.3166667 0.237817 34.3194444 0.237817 34.3222222 0.237118 34.3250000 0.230830 34.3277778 0.230131 34.3305556 0.230131 34.3333333 0.230830 34.3361111 0.228734 34.3388889 0.223144 34.3416667 0.218253 34.3444444 0.211266 34.3472222 0.209869 34.3500000 0.209869 34.3527778 0.205677 34.3555556 0.204279 34.3583333 0.203581 34.3611111 0.209170 34.3638889 0.213362 34.3666667 0.216856 34.3694444 0.218253 34.3722222 0.219651 34.3750000 0.220349 34.3777778 0.222445 34.3805556 0.223843 34.3833333 0.220349 34.3861111 0.218253 34.3888889 0.217555 34.3916667 0.211965 34.3944444 0.203581 34.3972222 0.193799 34.4000000 0.187511 34.4027778 0.183319 34.4055556 0.180524 34.4083333 0.177031 34.4111111 0.174236 34.4138889 0.172838 34.4166667 0.172140 34.4194444 0.170742 34.4222222 0.168646 34.4250000 0.166550 34.4277778 0.166550 34.4305556 0.163755 34.4333333 0.162358 34.4361111 0.158166 34.4388889 0.149083 34.4416667 0.137205 34.4444444 0.123930 34.4472222 0.110655 34.4500000 0.096681 34.4527778 0.083406 34.4555556 0.075721 34.4583333 0.066638 34.4611111 0.056157 34.4638889 0.052664 34.4666667 0.051965 34.4694444 0.053362 34.4722222 0.054061 34.4750000 0.050000 34.4777778 0.050000 34.4805556 0.050000 34.4833333 0.050000 34.4861111 0.050000 34.4888889 0.050000 34.4916667 0.050000 34.4944444 0.050000 34.4972222 0.050000 34.5000000 0.050000 34.5027778 0.050000 34.5055556 0.050000 34.5083333 0.050000 34.5111111 0.050000 34.5138889 0.050000 34.5166667 0.050000 34.5194444 0.050000 34.5222222 0.050000 34.5250000 0.050000 34.5277778 0.050000 34.5305556 0.050000 34.5333333 0.050000 34.5361111 0.050000 34.5388889 0.050000 34.5416667 0.050000 34.5444444 0.050000 34.5472222 0.050000 34.5500000 0.050000 34.5527778 0.050000 34.5555556 0.050000 34.5583333 0.050000 34.5611111 0.050000 34.5638889 0.050000 34.5666667 0.050000 34.5694444 0.050000 34.5722222 0.050000 34.5750000 0.050000 34.5777778 0.050000 34.5805556 0.050000 34.5833333 0.050000 34.5861111 0.050000 34.5888889 0.050000 34.5916667 0.050000 34.5944444 0.050000 34.5972222 0.050000 34.6000000 0.050000 34.6027778 0.050000 34.6055556 0.050000 34.6083333 0.050000 34.6111111 0.050000 34.6138889 0.050000 34.6166667 0.050000 34.6194444 0.050000 34.6222222 0.050000 34.6250000 0.050000 34.6277778 0.050000 34.6305556 0.050000 34.6333333 0.050000 34.6361111 0.051266 34.6388889 0.050000 34.6416667 0.050000 34.6444444 0.050000 34.6472222 0.050000 34.6500000 0.051266 34.6527778 0.052664 34.6555556 0.051266 34.6583333 0.050000 34.6611111 0.053362 34.6638889 0.056856 34.6666667 0.056157 34.6694444 0.057555 34.6722222 0.056157 34.6750000 0.055459 34.6777778 0.055459 34.6805556 0.054061 34.6833333 0.058253 34.6861111 0.062445 34.6888889 0.062445 34.6916667 0.061048 34.6944444 0.060349 34.6972222 0.061747 34.7000000 0.061048 34.7027778 0.062445 34.7085556 0.300000 35.5414444 0.300000 35.5444444 0.383843 35.5472222 0.383843 35.5500000 0.385240 35.5527778 0.385939 35.5555556 0.384541 35.5583333 0.387336 35.5611111 0.388035 35.5638889 0.387336 35.5666667 0.388734 35.5694444 0.390131 35.5722222 0.389432 35.5750000 0.389432 35.5777778 0.390830 35.5805556 0.393624 35.5833333 0.392926 35.5861111 0.393624 35.5888889 0.392926 35.5916667 0.394323 35.5944444 0.396419 35.5972222 0.397817 35.6000000 0.399214 35.6027778 0.399913 35.6055556 0.397817 35.6083333 0.396419 35.6111111 0.398515 35.6138889 0.401310 35.6166667 0.404105 35.6194444 0.404803 35.6222222 0.402009 35.6250000 0.402009 35.6277778 0.402707 35.6305556 0.404803 35.6333333 0.408297 35.6361111 0.408297 35.6388889 0.406900 35.6416667 0.406201 35.6444444 0.405502 35.6472222 0.410393 35.6500000 0.413188 35.6527778 0.413886 35.6555556 0.413188 35.6583333 0.408996 35.6611111 0.410393 35.6638889 0.413188 35.6666667 0.416681 35.6694444 0.419476 35.6722222 0.415284 35.6750000 0.413886 35.6777778 0.413188 35.6805556 0.415983 35.6833333 0.420873 35.6861111 0.420175 35.6888889 0.418777 35.6916667 0.418079 35.6944444 0.415983 35.6972222 0.420175 35.7000000 0.424367 35.7027778 0.425764 35.7055556 0.422969 35.7083333 0.421572 35.7111111 0.419476 35.7138889 0.422969 35.7166667 0.429258 35.7194444 0.429258 35.7222222 0.425066 35.7250000 0.425764 35.7277778 0.422969 35.7305556 0.426463 35.7333333 0.427860 35.7361111 0.430655 35.7388889 0.427162 35.7416667 0.422969 35.7444444 0.421572 35.7472222 0.420175 35.7500000 0.419476 35.7527778 0.417380 35.7555556 0.414585 35.7583333 0.410393 35.7611111 0.406201 35.7638889 0.406201 35.7666667 0.408297 35.7694444 0.411092 35.7722222 0.412489 35.7750000 0.412489 35.7777778 0.411790 35.7805556 0.415284 35.7833333 0.420175 35.7861111 0.429258 35.7888889 0.450917 35.7916667 0.482358 35.7944444 0.515895 35.7972222 0.542445 35.8000000 0.554323 35.8027778 0.559214 35.8055556 0.562707 35.8083333 0.566900 35.8111111 0.571092 35.8138889 0.575284 35.8166667 0.575284 35.8194444 0.571092 35.8222222 0.563406 35.8250000 0.550830 35.8277778 0.540349 35.8305556 0.534760 35.8333333 0.531965 35.8361111 0.534061 35.8388889 0.533362 35.8416667 0.530568 35.8444444 0.529170 35.8472222 0.530568 35.8500000 0.537555 35.8527778 0.543843 35.8555556 0.547336 35.8583333 0.548035 35.8611111 0.545240 35.8638889 0.545240 35.8666667 0.541048 35.8694444 0.536157 35.8722222 0.527773 35.8750000 0.513799 35.8777778 0.499825 35.8805556 0.484454 35.8833333 0.473275 35.8861111 0.463493 35.8888889 0.457904 35.8916667 0.454410 35.8944444 0.450218 35.8972222 0.450917 35.9000000 0.448821 35.9027778 0.447424 35.9055556 0.446725 35.9083333 0.446725 35.9111111 0.447424 35.9138889 0.447424 35.9166667 0.447424 35.9194444 0.446026 35.9222222 0.445328 35.9250000 0.445328 35.9277778 0.445328 35.9305556 0.447424 35.9333333 0.447424 35.9361111 0.445328 35.9388889 0.444629 35.9416667 0.443231 35.9444444 0.444629 35.9472222 0.446725 35.9500000 0.448821 35.9527778 0.446725 35.9555556 0.444629 35.9583333 0.446026 35.9611111 0.445328 35.9638889 0.448821 35.9666667 0.448122 35.9694444 0.447424 35.9722222 0.446026 35.9750000 0.445328 35.9777778 0.446026 35.9805556 0.448122 35.9833333 0.450218 35.9861111 0.450917 35.9888889 0.448122 35.9916667 0.447424 35.9944444 0.446026 35.9972222 0.448821 36.0000000 0.451616 36.0027778 0.453013 36.0055556 0.450218 36.0083333 0.449520 36.0111111 0.446725 36.0138889 0.449520 36.0166667 0.453013 36.0194444 0.453712 36.0222222 0.453712 36.0250000 0.451616 36.0277778 0.448821 36.0305556 0.449520 36.0333333 0.453712 36.0361111 0.454410 36.0388889 0.457205 36.0416667 0.453712 36.0444444 0.452314 36.0472222 0.452314 36.0500000 0.453712 36.0527778 0.457205 36.0555556 0.459301 36.0583333 0.457904 36.0611111 0.456507 36.0638889 0.454410 36.0666667 0.457904 36.0694444 0.460699 36.0722222 0.462096 36.0750000 0.462096 36.0777778 0.461397 36.0805556 0.460699 36.0833333 0.462795 36.0861111 0.464891 36.0888889 0.464891 36.0916667 0.465590 36.0974444 0.300000 36.2747778 0.300000 36.2777778 0.487948 36.2805556 0.489345 36.2833333 0.492140 36.2861111 0.496332 36.2888889 0.495633 36.2916667 0.494236 36.2944444 0.491441 36.2972222 0.492140 36.3000000 0.497031 36.3027778 0.499825 36.3055556 0.499127 36.3083333 0.496332 36.3111111 0.495633 36.3138889 0.496332 36.3166667 0.499825 36.3194444 0.501223 36.3222222 0.501921 36.3250000 0.499825 36.3277778 0.497729 36.3305556 0.498428 36.3333333 0.501223 36.3361111 0.501921 36.3388889 0.502620 36.3416667 0.499127 36.3444444 0.497729 36.3472222 0.497729 36.3500000 0.499127 36.3527778 0.501921 36.3555556 0.501921 36.3583333 0.497729 36.3611111 0.495633 36.3638889 0.496332 36.3666667 0.496332 36.3694444 0.498428 36.3722222 0.497729 36.3750000 0.496332 36.3777778 0.493537 36.3805556 0.493537 36.3833333 0.494934 36.3861111 0.497031 36.3888889 0.497729 36.3916667 0.495633 36.3944444 0.493537 36.3972222 0.491441 36.4000000 0.494236 36.4027778 0.495633 36.4055556 0.495633 36.4083333 0.494236 36.4111111 0.493537 36.4138889 0.494236 36.4166667 0.494934 36.4194444 0.494934 36.4222222 0.496332 36.4250000 0.495633 36.4277778 0.494236 36.4305556 0.492140 36.4333333 0.493537 36.4361111 0.495633 36.4388889 0.493537 36.4416667 0.492838 36.4444444 0.492140 36.4472222 0.490742 36.4500000 0.489345 36.4527778 0.488646 36.4555556 0.485153 36.4583333 0.482358 36.4611111 0.479563 36.4638889 0.475371 36.4666667 0.471179 36.4694444 0.464891 36.4722222 0.461397 36.4750000 0.460000 36.4777778 0.457904 36.4805556 0.460699 36.4833333 0.464891 36.4861111 0.466288 36.4888889 0.470480 36.4916667 0.473275 36.4944444 0.473974 36.4972222 0.471878 36.5000000 0.471878 36.5027778 0.469782 36.5055556 0.468384 36.5083333 0.469782 36.5111111 0.467686 36.5138889 0.464891 36.5166667 0.463493 36.5194444 0.462096 36.5222222 0.460699 36.5250000 0.453013 36.5277778 0.444629 36.5305556 0.434847 36.5333333 0.429956 36.5361111 0.429258 36.5388889 0.429956 36.5416667 0.433450 36.5444444 0.438341 36.5472222 0.443930 36.5500000 0.450917 36.5527778 0.457904 36.5555556 0.463493 36.5583333 0.466288 36.5611111 0.466987 36.5638889 0.465590 36.5666667 0.463493 36.5694444 0.460699 36.5722222 0.454410 36.5750000 0.445328 36.5777778 0.434847 36.5805556 0.421572 36.5833333 0.409694 36.5861111 0.395022 36.5888889 0.376856 36.5916667 0.366376 36.5944444 0.356594 36.5972222 0.348210 36.6000000 0.341921 36.6027778 0.337031 36.6055556 0.331441 36.6083333 0.328646 36.6111111 0.328646 36.6138889 0.326550 36.6166667 0.327249 36.6194444 0.323755 36.6222222 0.322358 36.6250000 0.322358 36.6277778 0.320961 36.6305556 0.321659 36.6333333 0.319563 36.6361111 0.318865 36.6388889 0.316769 36.6416667 0.317467 36.6444444 0.317467 36.6472222 0.315371 36.6500000 0.315371 36.6527778 0.314672 36.6555556 0.313275 36.6583333 0.312576 36.6611111 0.313275 36.6638889 0.312576 36.6666667 0.312576 36.6694444 0.311878 36.6722222 0.309782 36.6750000 0.309083 36.6777778 0.311179 36.6805556 0.310480 36.6833333 0.309782 36.6861111 0.310480 36.6888889 0.308384 36.6916667 0.310480 36.6944444 0.310480 36.6972222 0.310480 36.7000000 0.312576 36.7027778 0.310480 36.7055556 0.311878 36.7083333 0.312576 36.7111111 0.312576 36.7138889 0.314672 36.7166667 0.312576 36.7194444 0.314672 36.7222222 0.316070 36.7250000 0.317467 36.7277778 0.318865 36.7305556 0.318865 36.7333333 0.320961 36.7361111 0.320262 36.7388889 0.323057 36.7416667 0.323057 36.7444444 0.323755 36.7472222 0.325153 36.7500000 0.327249 36.7527778 0.327249 36.7555556 0.329345 36.7583333 0.330742 36.7611111 0.330742 36.7638889 0.329345 36.7666667 0.332140 36.7694444 0.334934 36.7722222 0.337031 36.7750000 0.334934 36.7777778 0.339127 36.7805556 0.337031 36.7833333 0.338428 36.7861111 0.341223 36.7888889 0.342620 36.7916667 0.346812 36.7944444 0.346114 36.7972222 0.347511 36.8000000 0.348908 36.8027778 0.350306 36.8055556 0.353100 36.8083333 0.354498 36.8111111 0.355197 36.8138889 0.355197 36.8166667 0.357293 36.8194444 0.360087 36.8222222 0.362882 36.8250000 0.364978 36.8307778 0.300000 37.0277778 0.300000)

* ============================================================
* ANALOG SUPPLEMENTARY CIRCUITS
* ============================================================

.include "C:/Users/kadhi/OneDrive/Desktop/amux/verilogLearning/Leaky-Integrate-Fire---SNN-model-on-FPGA/experiments/frontend_optimization/complete_frontend/inverter.spice"
.include "C:/Users/kadhi/OneDrive/Desktop/amux/verilogLearning/Leaky-Integrate-Fire---SNN-model-on-FPGA/experiments/frontend_optimization/complete_frontend/bias_gen.spice"
.include "C:/Users/kadhi/OneDrive/Desktop/amux/verilogLearning/Leaky-Integrate-Fire---SNN-model-on-FPGA/experiments/frontend_optimization/complete_frontend/rpeak_detector.spice"
.include "C:/Users/kadhi/OneDrive/Desktop/amux/verilogLearning/Leaky-Integrate-Fire---SNN-model-on-FPGA/experiments/frontend_optimization/complete_frontend/pulse_gen.spice"
.include "C:/Users/kadhi/OneDrive/Desktop/amux/verilogLearning/Leaky-Integrate-Fire---SNN-model-on-FPGA/experiments/frontend_optimization/complete_frontend/long_pulse_gen.spice"
.include "C:/Users/kadhi/OneDrive/Desktop/amux/verilogLearning/Leaky-Integrate-Fire---SNN-model-on-FPGA/experiments/frontend_optimization/complete_frontend/delay_timer.spice"
.include "C:/Users/kadhi/OneDrive/Desktop/amux/verilogLearning/Leaky-Integrate-Fire---SNN-model-on-FPGA/experiments/frontend_optimization/complete_frontend/edge_buffer.spice"
.include "C:/Users/kadhi/OneDrive/Desktop/amux/verilogLearning/Leaky-Integrate-Fire---SNN-model-on-FPGA/experiments/frontend_optimization/complete_frontend/rpeak_hold.spice"
.include "C:/Users/kadhi/OneDrive/Desktop/amux/verilogLearning/Leaky-Integrate-Fire---SNN-model-on-FPGA/experiments/frontend_optimization/complete_frontend/pwave_predictor.spice"

* --- Bias generator (replaces ideal Vbias) ---
Xbias vbias vref vdd vss bias_gen
.ic V(xbias.iref)=0.3

* --- R-peak detector (polarity-adaptive) ---
Vthresh rpeak_threshold 0 0.300000
Xrpk ecg_l0 rpeak_threshold rpeak_level vdd vss vbias rpeak_detector
* Hold circuit: debounces QRS chatter
Xhold rpeak_level rpeak_level_held vdd vss vbias rpeak_hold
.ic V(xhold.hold_cap)=0
* Level-to-pulse conversion (hold output -> brief ~2ms pulse)
Xeb_rpk_in rpeak_level_held rpeak_level_sharp vdd vss edge_buffer
Xpg_rpk rpeak_level_sharp rpeak_pulse_raw vdd vss vbias pulse_gen
* Direct connection: no refractory gate (hold circuit provides debounce)
Xeb_rpk rpeak_pulse_raw rpeak_pulse vdd vss edge_buffer

* --- Delay timer (triggered by analog rpeak pulse) ---
Vth14 vth_14_node 0 0.451892
Vth69 vth_69_node 0 0.424228
Vth28 vth_28_node 0 0.445472
Vth300 vth_300_node 0 0.307413
Vth10 vth_10_node 0 0.453400
Vth_rpk_del vth_rpk_del_node 0 0.458704

Xdt rpeak_pulse trig_s14_level trig_s69_level trig_wid_level trig_bi_level trig_rr_level trig_rpk_del_level dt_sf_out vdd vss vbias vth_14_node vth_69_node vth_28_node vth_300_node vth_10_node vth_rpk_del_node delay_timer

* --- Pulse generators for delay_timer outputs ---
* External main-timer comparators (offset too large for fast timer)
* High-gain two-stage comparator: L=4 diff pair + inverter output
* Same topology as delay_timer internal comparators
Vth14_slow vth_14_slow 0 0.451892
Vth10_slow vth_10_slow 0 0.453400
Vth_rpkdel_slow vth_rpkdel_slow 0 0.458704
* S14 external comparator
XMes14_1 cne14 dt_sf_out cte14 vss sky130_fd_pr__nfet_01v8 L=4 W=2 nf=1
XMes14_2 stg1_es14 vth_14_slow cte14 vss sky130_fd_pr__nfet_01v8 L=4 W=2 nf=1
XMes14_3 cne14 cne14 vdd vdd sky130_fd_pr__pfet_01v8 L=4 W=2 nf=1
XMes14_4 stg1_es14 cne14 vdd vdd sky130_fd_pr__pfet_01v8 L=4 W=2 nf=1
XMes14_5 cte14 vbias vss vss sky130_fd_pr__nfet_01v8 L=8 W=0.42 nf=1
XMes14_6 ext_s14_level stg1_es14 vdd vdd sky130_fd_pr__pfet_01v8 L=0.5 W=8 nf=1
XMes14_7 ext_s14_level stg1_es14 vss vss sky130_fd_pr__nfet_01v8 L=0.5 W=4 nf=1
* RR external comparator
XMerr_1 cnerr dt_sf_out cterr vss sky130_fd_pr__nfet_01v8 L=4 W=2 nf=1
XMerr_2 stg1_err vth_10_slow cterr vss sky130_fd_pr__nfet_01v8 L=4 W=2 nf=1
XMerr_3 cnerr cnerr vdd vdd sky130_fd_pr__pfet_01v8 L=4 W=2 nf=1
XMerr_4 stg1_err cnerr vdd vdd sky130_fd_pr__pfet_01v8 L=4 W=2 nf=1
XMerr_5 cterr vbias vss vss sky130_fd_pr__nfet_01v8 L=8 W=0.42 nf=1
XMerr_6 ext_rr_level stg1_err vdd vdd sky130_fd_pr__pfet_01v8 L=0.5 W=8 nf=1
XMerr_7 ext_rr_level stg1_err vss vss sky130_fd_pr__nfet_01v8 L=0.5 W=4 nf=1
* RPK_DEL external comparator
XMerd_1 cnerd dt_sf_out cterd vss sky130_fd_pr__nfet_01v8 L=4 W=2 nf=1
XMerd_2 stg1_erd vth_rpkdel_slow cterd vss sky130_fd_pr__nfet_01v8 L=4 W=2 nf=1
XMerd_3 cnerd cnerd vdd vdd sky130_fd_pr__pfet_01v8 L=4 W=2 nf=1
XMerd_4 stg1_erd cnerd vdd vdd sky130_fd_pr__pfet_01v8 L=4 W=2 nf=1
XMerd_5 cterd vbias vss vss sky130_fd_pr__nfet_01v8 L=8 W=0.42 nf=1
XMerd_6 ext_rpkdel_level stg1_erd vdd vdd sky130_fd_pr__pfet_01v8 L=0.5 W=8 nf=1
XMerd_7 ext_rpkdel_level stg1_erd vss vss sky130_fd_pr__nfet_01v8 L=0.5 W=4 nf=1

Xpg_s14 ext_s14_level pg_s14_raw vdd vss vbias pulse_gen
Xpg_s69 trig_s69_level pg_s69_raw vdd vss vbias long_pulse_gen
Xpg_wid trig_wid_level pg_wid_raw vdd vss vbias long_pulse_gen
Xpg_bi  trig_bi_level  pg_bi_raw  vdd vss vbias long_pulse_gen
Xpg_rr  ext_rr_level  pg_rr_raw  vdd vss vbias pulse_gen
Xpg_rpk_del ext_rpkdel_level pg_rpk_del_raw vdd vss vbias pulse_gen

* --- Edge buffers for cleaner trigger edges ---
Xeb_s14 pg_s14_raw trig_s14 vdd vss edge_buffer
Xeb_s69 pg_s69_raw trig_s69 vdd vss edge_buffer
Xeb_wid pg_wid_raw trig_wid vdd vss edge_buffer
Xeb_bi  pg_bi_raw  trig_bi_copy vdd vss edge_buffer
Xeb_rr  pg_rr_raw  trig_rr_copy_raw vdd vss edge_buffer
* Esamp validity gate: block rr_copy when esamp holds deeply decayed value
* Valid esamp range: 0.38-0.43V. Invalid (missed beats): <0.30V. Threshold: 0.35V
Vth_esamp_ok esamp_ok_thresh 0 0.35
Xesamp_chk xrr.esamp_node esamp_ok_thresh esamp_ok_level vdd vss vbias rpeak_detector
* AND: trig_rr_copy = trig_rr_copy_raw AND esamp_ok_level
XMnand_rrc_p1 nand_rrc2 trig_rr_copy_raw vdd vdd sky130_fd_pr__pfet_01v8 L=0.15 W=2 nf=1
XMnand_rrc_p2 nand_rrc2 esamp_ok_level vdd vdd sky130_fd_pr__pfet_01v8 L=0.15 W=2 nf=1
XMnand_rrc_n1 nand_rrc2 trig_rr_copy_raw nand_mid_rrc2 vss sky130_fd_pr__nfet_01v8 L=0.15 W=1 nf=1
XMnand_rrc_n2 nand_mid_rrc2 esamp_ok_level vss vss sky130_fd_pr__nfet_01v8 L=0.15 W=1 nf=1
Xinv_nand_rrc2 nand_rrc2 trig_rr_copy vdd vss inverter_sub
Xeb_rpk_del pg_rpk_del_raw rpeak_pulse_delayed vdd vss edge_buffer

* ============================================================
* ANALOG RR_CAP (pwave_predictor + AND gate with rpeak_level)
* ============================================================
* Duplicate timer+SF for pwave_predictor (isolated from esamp loading on rr_timer)
Xinv_rpk_pre rpeak_pulse rpk_bar_pre vdd vss inverter_sub
XMpre2n vdd rpeak_pulse net_timer2 vss sky130_fd_pr__nfet_01v8 L=0.5 W=2 nf=1
XMpre2p vdd rpk_bar_pre net_timer2 vdd sky130_fd_pr__pfet_01v8 L=0.5 W=2 nf=1
XMdis2 net_timer2 vbias vss vss sky130_fd_pr__nfet_01v8 L=8 W=0.42 nf=1
XCtimer2 net_timer2 vss sky130_fd_pr__cap_mim_m3_1 W=400 L=400
XMsf2 vdd net_timer2 sf2_out vss sky130_fd_pr__nfet_01v8 L=8 W=0.42 nf=1
XMsf2_bias sf2_out vbias vss vss sky130_fd_pr__nfet_01v8 L=8 W=0.42 nf=1
* rr_cap comparator on ORIGINAL timer (esamp dip helps fast comparator reset)
Vrrc_off rrc_threshold rr_ewma 0.02
Vpwb_off vth_pw_base_node rr_ewma 0.028212800000000003
Vpwp_off vth_pw_peak_node rr_ewma 0.019812800000000002
Xpwpred_rrc rr_timer rrc_threshold rrc_pwb_unused rrc_pwp_unused rr_cap_level vth_pw_base_node vth_pw_peak_node vdd vss vbias pwave_predictor
* pw_base/pw_peak comparators on ISOLATED timer (no esamp transient)
Xpwpred_pw sf2_out rrc_threshold pw_base_cmp pw_peak_cmp pw_rrc_unused vth_pw_base_node vth_pw_peak_node vdd vss vbias pwave_predictor
* AND gate: trig_rr_cap = rr_cap_level AND NOT(rpeak_level)
Xinv_rpk rpeak_level rpeak_level_bar vdd vss inverter_sub
XMnand_p1 nand_rrc rr_cap_level vdd vdd sky130_fd_pr__pfet_01v8 L=0.15 W=2 nf=1
XMnand_p2 nand_rrc rpeak_level_bar vdd vdd sky130_fd_pr__pfet_01v8 L=0.15 W=2 nf=1
XMnand_n1 nand_rrc rr_cap_level nand_mid_rrc vss sky130_fd_pr__nfet_01v8 L=0.15 W=1 nf=1
XMnand_n2 nand_mid_rrc rpeak_level_bar vss vss sky130_fd_pr__nfet_01v8 L=0.15 W=1 nf=1
Xinv_nand_rrc nand_rrc trig_rr_cap vdd vss inverter_sub

* ============================================================
* ANALOG PW_BASE / PW_PEAK (pwave_predictor -> edge_buffer -> pulse_gen)
* ============================================================
Xeb_pwb pw_base_cmp pwb_level vdd vss edge_buffer
Xpg_pwb pwb_level trig_pw_base vdd vss vbias pulse_gen
Xeb_pwp pw_peak_cmp pwp_level vdd vss edge_buffer
Xpg_pwp pwp_level trig_pw_peak vdd vss vbias pulse_gen

* ============================================================
* FEATURE CIRCUITS
* ============================================================
.include "C:/Users/kadhi/OneDrive/Desktop/amux/verilogLearning/Leaky-Integrate-Fire---SNN-model-on-FPGA/experiments/frontend_optimization/complete_frontend/rr_timing.spice"
.include "C:/Users/kadhi/OneDrive/Desktop/amux/verilogLearning/Leaky-Integrate-Fire---SNN-model-on-FPGA/experiments/frontend_optimization/complete_frontend/beat_instability.spice"
.include "C:/Users/kadhi/OneDrive/Desktop/amux/verilogLearning/Leaky-Integrate-Fire---SNN-model-on-FPGA/experiments/frontend_optimization/complete_frontend/pwave_diff.spice"
.include "C:/Users/kadhi/OneDrive/Desktop/amux/verilogLearning/Leaky-Integrate-Fire---SNN-model-on-FPGA/experiments/frontend_optimization/complete_frontend/qrs_width.spice"
.include "C:/Users/kadhi/OneDrive/Desktop/amux/verilogLearning/Leaky-Integrate-Fire---SNN-model-on-FPGA/experiments/frontend_optimization/complete_frontend/qrs_slope.spice"
.include "C:/Users/kadhi/OneDrive/Desktop/amux/verilogLearning/Leaky-Integrate-Fire---SNN-model-on-FPGA/experiments/frontend_optimization/complete_frontend/qrs_symmetry.spice"

* F1/F2: rr_timing (ANALOG rpeak, ANALOG rr_cap via pwave_pred, analog rr_copy)
Xrr ecg_l0 trig_rr_cap rpeak_pulse trig_rr_copy f1_rr_ratio f2_rr_asym rr_timer rr_ewma vdd vss vbias rr_timing

* F3/F4: beat_instability (DELAYED rpeak, ANALOG bi_copy)
Xbi0 ecg_l0 rpeak_pulse_delayed trig_bi_copy f3_bi_l0 vdd vss vbias beat_instability
Xbi1 ecg_l1 rpeak_pulse_delayed trig_bi_copy f4_bi_l1 vdd vss vbias beat_instability

* F5: pwave_diff (ANALOG pw triggers via pwave_predictor)
Xpw ecg_l0 trig_pw_base trig_pw_peak f5_pwave vdd vss vbias pwave_diff

* F6: qrs_width (ANALOG wid trigger)
Xwid ecg_l0 trig_wid f6_width vdd vss qrs_width

* F7: qrs_slope (ANALOG s14, s69 triggers)
Xslp ecg_l0 trig_s14 trig_s69 f7_slope vdd vss vbias qrs_slope

* F8: qrs_symmetry (DELAYED rpeak pulse — captures near true R-peak)
Xsym ecg_l0 rpeak_pulse_delayed f8_symmetry vdd vss qrs_symmetry

* ============================================================
* INITIAL CONDITIONS
* ============================================================
.ic V(xrr.net_timer)=0.9
.ic V(xrr.ewma_node)=0.370200
.ic V(xrr.esamp_node)=0.370200
.ic V(xrr.prev_node)=0.370200
.ic V(net_timer2)=0.9
.ic V(xbi0.prev_node)=0.3
.ic V(xbi0.esamp_node)=0.3
.ic V(xbi1.prev_node)=0.3
.ic V(xbi1.esamp_node)=0.3
* Delay timer starts discharged: all comparators HIGH at t=0
* This lets the refractory gate pass the first rpeak through
.ic V(xdt.timer_node)=0
.ic V(xdt.timer2)=0
.ic V(rpeak_pulse_raw)=0
.ic V(rpeak_level_held)=0

.tran 0.5m 37.0278 UIC

.meas tran rrc_cmp_3 FIND V(rr_cap_level) AT=4.2422222
.meas tran rrc_cmp2_3 FIND V(rr_cap_level) AT=4.2622222
.meas tran rrc_timer_3 FIND V(rr_timer) AT=4.2422222
.meas tran rrc_ewma_3 FIND V(rr_ewma) AT=4.2422222
.meas tran rrc_thresh_3 FIND V(rrc_threshold) AT=4.2422222
.meas tran rrc_trig_3 FIND V(trig_rr_cap) AT=4.2422222
.meas tran rrc_rpklvl_3 FIND V(rpeak_level) AT=4.2422222
.meas tran rrc_esamp_3 FIND V(xrr.esamp_node) AT=4.2422222
.meas tran rrc_esamp_ok_3 FIND V(esamp_ok_level) AT=4.2422222
.meas tran rrc_cmp_max_3 MAX V(rr_cap_level) FROM=4.2122222 TO=4.2772222
.meas tran rrc_trig_max_3 MAX V(trig_rr_cap) FROM=4.2122222 TO=4.2772222
.meas tran rrc_cmp_4 FIND V(rr_cap_level) AT=4.8894444
.meas tran rrc_cmp2_4 FIND V(rr_cap_level) AT=4.9094444
.meas tran rrc_timer_4 FIND V(rr_timer) AT=4.8894444
.meas tran rrc_ewma_4 FIND V(rr_ewma) AT=4.8894444
.meas tran rrc_thresh_4 FIND V(rrc_threshold) AT=4.8894444
.meas tran rrc_trig_4 FIND V(trig_rr_cap) AT=4.8894444
.meas tran rrc_rpklvl_4 FIND V(rpeak_level) AT=4.8894444
.meas tran rrc_esamp_4 FIND V(xrr.esamp_node) AT=4.8894444
.meas tran rrc_esamp_ok_4 FIND V(esamp_ok_level) AT=4.8894444
.meas tran rrc_cmp_max_4 MAX V(rr_cap_level) FROM=4.8594444 TO=4.9244444
.meas tran rrc_trig_max_4 MAX V(trig_rr_cap) FROM=4.8594444 TO=4.9244444
.meas tran rrc_cmp_5 FIND V(rr_cap_level) AT=6.3366667
.meas tran rrc_cmp2_5 FIND V(rr_cap_level) AT=6.3566667
.meas tran rrc_timer_5 FIND V(rr_timer) AT=6.3366667
.meas tran rrc_ewma_5 FIND V(rr_ewma) AT=6.3366667
.meas tran rrc_thresh_5 FIND V(rrc_threshold) AT=6.3366667
.meas tran rrc_trig_5 FIND V(trig_rr_cap) AT=6.3366667
.meas tran rrc_rpklvl_5 FIND V(rpeak_level) AT=6.3366667
.meas tran rrc_esamp_5 FIND V(xrr.esamp_node) AT=6.3366667
.meas tran rrc_esamp_ok_5 FIND V(esamp_ok_level) AT=6.3366667
.meas tran rrc_cmp_max_5 MAX V(rr_cap_level) FROM=6.3066667 TO=6.3716667
.meas tran rrc_trig_max_5 MAX V(trig_rr_cap) FROM=6.3066667 TO=6.3716667
.meas tran rrc_cmp_6 FIND V(rr_cap_level) AT=7.0338889
.meas tran rrc_cmp2_6 FIND V(rr_cap_level) AT=7.0538889
.meas tran rrc_timer_6 FIND V(rr_timer) AT=7.0338889
.meas tran rrc_ewma_6 FIND V(rr_ewma) AT=7.0338889
.meas tran rrc_thresh_6 FIND V(rrc_threshold) AT=7.0338889
.meas tran rrc_trig_6 FIND V(trig_rr_cap) AT=7.0338889
.meas tran rrc_rpklvl_6 FIND V(rpeak_level) AT=7.0338889
.meas tran rrc_esamp_6 FIND V(xrr.esamp_node) AT=7.0338889
.meas tran rrc_esamp_ok_6 FIND V(esamp_ok_level) AT=7.0338889
.meas tran rrc_cmp_max_6 MAX V(rr_cap_level) FROM=7.0038889 TO=7.0688889
.meas tran rrc_trig_max_6 MAX V(trig_rr_cap) FROM=7.0038889 TO=7.0688889
.meas tran rrc_cmp_7 FIND V(rr_cap_level) AT=8.4727778
.meas tran rrc_cmp2_7 FIND V(rr_cap_level) AT=8.4927778
.meas tran rrc_timer_7 FIND V(rr_timer) AT=8.4727778
.meas tran rrc_ewma_7 FIND V(rr_ewma) AT=8.4727778
.meas tran rrc_thresh_7 FIND V(rrc_threshold) AT=8.4727778
.meas tran rrc_trig_7 FIND V(trig_rr_cap) AT=8.4727778
.meas tran rrc_rpklvl_7 FIND V(rpeak_level) AT=8.4727778
.meas tran rrc_esamp_7 FIND V(xrr.esamp_node) AT=8.4727778
.meas tran rrc_esamp_ok_7 FIND V(esamp_ok_level) AT=8.4727778
.meas tran rrc_cmp_max_7 MAX V(rr_cap_level) FROM=8.4427778 TO=8.5077778
.meas tran rrc_trig_max_7 MAX V(trig_rr_cap) FROM=8.4427778 TO=8.5077778
.meas tran rrc_cmp_8 FIND V(rr_cap_level) AT=9.1561111
.meas tran rrc_cmp2_8 FIND V(rr_cap_level) AT=9.1761111
.meas tran rrc_timer_8 FIND V(rr_timer) AT=9.1561111
.meas tran rrc_ewma_8 FIND V(rr_ewma) AT=9.1561111
.meas tran rrc_thresh_8 FIND V(rrc_threshold) AT=9.1561111
.meas tran rrc_trig_8 FIND V(trig_rr_cap) AT=9.1561111
.meas tran rrc_rpklvl_8 FIND V(rpeak_level) AT=9.1561111
.meas tran rrc_esamp_8 FIND V(xrr.esamp_node) AT=9.1561111
.meas tran rrc_esamp_ok_8 FIND V(esamp_ok_level) AT=9.1561111
.meas tran rrc_cmp_max_8 MAX V(rr_cap_level) FROM=9.1261111 TO=9.1911111
.meas tran rrc_trig_max_8 MAX V(trig_rr_cap) FROM=9.1261111 TO=9.1911111
.meas tran rrc_cmp_9 FIND V(rr_cap_level) AT=10.5450000
.meas tran rrc_cmp2_9 FIND V(rr_cap_level) AT=10.5650000
.meas tran rrc_timer_9 FIND V(rr_timer) AT=10.5450000
.meas tran rrc_ewma_9 FIND V(rr_ewma) AT=10.5450000
.meas tran rrc_thresh_9 FIND V(rrc_threshold) AT=10.5450000
.meas tran rrc_trig_9 FIND V(trig_rr_cap) AT=10.5450000
.meas tran rrc_rpklvl_9 FIND V(rpeak_level) AT=10.5450000
.meas tran rrc_esamp_9 FIND V(xrr.esamp_node) AT=10.5450000
.meas tran rrc_esamp_ok_9 FIND V(esamp_ok_level) AT=10.5450000
.meas tran rrc_cmp_max_9 MAX V(rr_cap_level) FROM=10.5150000 TO=10.5800000
.meas tran rrc_trig_max_9 MAX V(trig_rr_cap) FROM=10.5150000 TO=10.5800000
.meas tran tpwb_2 WHEN V(trig_pw_base)=0.45 RISE=1 TD=2.5555556
.meas tran tpwp_2 WHEN V(trig_pw_peak)=0.45 RISE=1 TD=2.5555556
.meas tran tpwb_cmp_2 WHEN V(pw_base_cmp)=0.45 RISE=1 TD=2.5555556
.meas tran tpwp_cmp_2 WHEN V(pw_peak_cmp)=0.45 RISE=1 TD=2.5555556
.meas tran pwb_sf_at_2 FIND V(sf2_out) WHEN V(pw_base_cmp)=0.45 RISE=1 TD=2.5555556
.meas tran pwb_th_2 FIND V(vth_pw_base_node) WHEN V(pw_base_cmp)=0.45 RISE=1 TD=2.5555556
.meas tran pwp_sf_at_2 FIND V(sf2_out) WHEN V(pw_peak_cmp)=0.45 RISE=1 TD=2.5555556
.meas tran pwp_th_2 FIND V(vth_pw_peak_node) WHEN V(pw_peak_cmp)=0.45 RISE=1 TD=2.5555556
.meas tran pwb_max_2 MAX V(trig_pw_base) FROM=2.6055556 TO=2.8605556
.meas tran pwp_max_2 MAX V(trig_pw_peak) FROM=2.6055556 TO=2.8605556
.meas tran sf2_at30_2 FIND V(sf2_out) AT=2.8255556
.meas tran tpwb_3 WHEN V(trig_pw_base)=0.45 RISE=1 TD=3.9722222
.meas tran tpwp_3 WHEN V(trig_pw_peak)=0.45 RISE=1 TD=3.9722222
.meas tran tpwb_cmp_3 WHEN V(pw_base_cmp)=0.45 RISE=1 TD=3.9722222
.meas tran tpwp_cmp_3 WHEN V(pw_peak_cmp)=0.45 RISE=1 TD=3.9722222
.meas tran pwb_sf_at_3 FIND V(sf2_out) WHEN V(pw_base_cmp)=0.45 RISE=1 TD=3.9722222
.meas tran pwb_th_3 FIND V(vth_pw_base_node) WHEN V(pw_base_cmp)=0.45 RISE=1 TD=3.9722222
.meas tran pwp_sf_at_3 FIND V(sf2_out) WHEN V(pw_peak_cmp)=0.45 RISE=1 TD=3.9722222
.meas tran pwp_th_3 FIND V(vth_pw_peak_node) WHEN V(pw_peak_cmp)=0.45 RISE=1 TD=3.9722222
.meas tran pwb_max_3 MAX V(trig_pw_base) FROM=4.0222222 TO=4.2772222
.meas tran pwp_max_3 MAX V(trig_pw_peak) FROM=4.0222222 TO=4.2772222
.meas tran sf2_at30_3 FIND V(sf2_out) AT=4.2422222
.meas tran tpwb_4 WHEN V(trig_pw_base)=0.45 RISE=1 TD=4.6194444
.meas tran tpwp_4 WHEN V(trig_pw_peak)=0.45 RISE=1 TD=4.6194444
.meas tran tpwb_cmp_4 WHEN V(pw_base_cmp)=0.45 RISE=1 TD=4.6194444
.meas tran tpwp_cmp_4 WHEN V(pw_peak_cmp)=0.45 RISE=1 TD=4.6194444
.meas tran pwb_sf_at_4 FIND V(sf2_out) WHEN V(pw_base_cmp)=0.45 RISE=1 TD=4.6194444
.meas tran pwb_th_4 FIND V(vth_pw_base_node) WHEN V(pw_base_cmp)=0.45 RISE=1 TD=4.6194444
.meas tran pwp_sf_at_4 FIND V(sf2_out) WHEN V(pw_peak_cmp)=0.45 RISE=1 TD=4.6194444
.meas tran pwp_th_4 FIND V(vth_pw_peak_node) WHEN V(pw_peak_cmp)=0.45 RISE=1 TD=4.6194444
.meas tran pwb_max_4 MAX V(trig_pw_base) FROM=4.6694444 TO=4.9244444
.meas tran pwp_max_4 MAX V(trig_pw_peak) FROM=4.6694444 TO=4.9244444
.meas tran sf2_at30_4 FIND V(sf2_out) AT=4.8894444
.meas tran tpwb_5 WHEN V(trig_pw_base)=0.45 RISE=1 TD=6.0666667
.meas tran tpwp_5 WHEN V(trig_pw_peak)=0.45 RISE=1 TD=6.0666667
.meas tran tpwb_cmp_5 WHEN V(pw_base_cmp)=0.45 RISE=1 TD=6.0666667
.meas tran tpwp_cmp_5 WHEN V(pw_peak_cmp)=0.45 RISE=1 TD=6.0666667
.meas tran pwb_sf_at_5 FIND V(sf2_out) WHEN V(pw_base_cmp)=0.45 RISE=1 TD=6.0666667
.meas tran pwb_th_5 FIND V(vth_pw_base_node) WHEN V(pw_base_cmp)=0.45 RISE=1 TD=6.0666667
.meas tran pwp_sf_at_5 FIND V(sf2_out) WHEN V(pw_peak_cmp)=0.45 RISE=1 TD=6.0666667
.meas tran pwp_th_5 FIND V(vth_pw_peak_node) WHEN V(pw_peak_cmp)=0.45 RISE=1 TD=6.0666667
.meas tran pwb_max_5 MAX V(trig_pw_base) FROM=6.1166667 TO=6.3716667
.meas tran pwp_max_5 MAX V(trig_pw_peak) FROM=6.1166667 TO=6.3716667
.meas tran sf2_at30_5 FIND V(sf2_out) AT=6.3366667
.meas tran tpwb_6 WHEN V(trig_pw_base)=0.45 RISE=1 TD=6.7638889
.meas tran tpwp_6 WHEN V(trig_pw_peak)=0.45 RISE=1 TD=6.7638889
.meas tran tpwb_cmp_6 WHEN V(pw_base_cmp)=0.45 RISE=1 TD=6.7638889
.meas tran tpwp_cmp_6 WHEN V(pw_peak_cmp)=0.45 RISE=1 TD=6.7638889
.meas tran pwb_sf_at_6 FIND V(sf2_out) WHEN V(pw_base_cmp)=0.45 RISE=1 TD=6.7638889
.meas tran pwb_th_6 FIND V(vth_pw_base_node) WHEN V(pw_base_cmp)=0.45 RISE=1 TD=6.7638889
.meas tran pwp_sf_at_6 FIND V(sf2_out) WHEN V(pw_peak_cmp)=0.45 RISE=1 TD=6.7638889
.meas tran pwp_th_6 FIND V(vth_pw_peak_node) WHEN V(pw_peak_cmp)=0.45 RISE=1 TD=6.7638889
.meas tran pwb_max_6 MAX V(trig_pw_base) FROM=6.8138889 TO=7.0688889
.meas tran pwp_max_6 MAX V(trig_pw_peak) FROM=6.8138889 TO=7.0688889
.meas tran sf2_at30_6 FIND V(sf2_out) AT=7.0338889
.meas tran tpwb_7 WHEN V(trig_pw_base)=0.45 RISE=1 TD=8.2027778
.meas tran tpwp_7 WHEN V(trig_pw_peak)=0.45 RISE=1 TD=8.2027778
.meas tran tpwb_cmp_7 WHEN V(pw_base_cmp)=0.45 RISE=1 TD=8.2027778
.meas tran tpwp_cmp_7 WHEN V(pw_peak_cmp)=0.45 RISE=1 TD=8.2027778
.meas tran pwb_sf_at_7 FIND V(sf2_out) WHEN V(pw_base_cmp)=0.45 RISE=1 TD=8.2027778
.meas tran pwb_th_7 FIND V(vth_pw_base_node) WHEN V(pw_base_cmp)=0.45 RISE=1 TD=8.2027778
.meas tran pwp_sf_at_7 FIND V(sf2_out) WHEN V(pw_peak_cmp)=0.45 RISE=1 TD=8.2027778
.meas tran pwp_th_7 FIND V(vth_pw_peak_node) WHEN V(pw_peak_cmp)=0.45 RISE=1 TD=8.2027778
.meas tran pwb_max_7 MAX V(trig_pw_base) FROM=8.2527778 TO=8.5077778
.meas tran pwp_max_7 MAX V(trig_pw_peak) FROM=8.2527778 TO=8.5077778
.meas tran sf2_at30_7 FIND V(sf2_out) AT=8.4727778
.meas tran tpwb_8 WHEN V(trig_pw_base)=0.45 RISE=1 TD=8.8861111
.meas tran tpwp_8 WHEN V(trig_pw_peak)=0.45 RISE=1 TD=8.8861111
.meas tran tpwb_cmp_8 WHEN V(pw_base_cmp)=0.45 RISE=1 TD=8.8861111
.meas tran tpwp_cmp_8 WHEN V(pw_peak_cmp)=0.45 RISE=1 TD=8.8861111
.meas tran pwb_sf_at_8 FIND V(sf2_out) WHEN V(pw_base_cmp)=0.45 RISE=1 TD=8.8861111
.meas tran pwb_th_8 FIND V(vth_pw_base_node) WHEN V(pw_base_cmp)=0.45 RISE=1 TD=8.8861111
.meas tran pwp_sf_at_8 FIND V(sf2_out) WHEN V(pw_peak_cmp)=0.45 RISE=1 TD=8.8861111
.meas tran pwp_th_8 FIND V(vth_pw_peak_node) WHEN V(pw_peak_cmp)=0.45 RISE=1 TD=8.8861111
.meas tran pwb_max_8 MAX V(trig_pw_base) FROM=8.9361111 TO=9.1911111
.meas tran pwp_max_8 MAX V(trig_pw_peak) FROM=8.9361111 TO=9.1911111
.meas tran sf2_at30_8 FIND V(sf2_out) AT=9.1561111
.meas tran tpwb_9 WHEN V(trig_pw_base)=0.45 RISE=1 TD=10.2750000
.meas tran tpwp_9 WHEN V(trig_pw_peak)=0.45 RISE=1 TD=10.2750000
.meas tran tpwb_cmp_9 WHEN V(pw_base_cmp)=0.45 RISE=1 TD=10.2750000
.meas tran tpwp_cmp_9 WHEN V(pw_peak_cmp)=0.45 RISE=1 TD=10.2750000
.meas tran pwb_sf_at_9 FIND V(sf2_out) WHEN V(pw_base_cmp)=0.45 RISE=1 TD=10.2750000
.meas tran pwb_th_9 FIND V(vth_pw_base_node) WHEN V(pw_base_cmp)=0.45 RISE=1 TD=10.2750000
.meas tran pwp_sf_at_9 FIND V(sf2_out) WHEN V(pw_peak_cmp)=0.45 RISE=1 TD=10.2750000
.meas tran pwp_th_9 FIND V(vth_pw_peak_node) WHEN V(pw_peak_cmp)=0.45 RISE=1 TD=10.2750000
.meas tran pwb_max_9 MAX V(trig_pw_base) FROM=10.3250000 TO=10.5800000
.meas tran pwp_max_9 MAX V(trig_pw_peak) FROM=10.3250000 TO=10.5800000
.meas tran sf2_at30_9 FIND V(sf2_out) AT=10.5450000
.meas tran f1_5 FIND V(f1_rr_ratio) AT=6.3116667
.meas tran f1_sf_5 FIND V(xrr.sf_out) AT=6.3116667
.meas tran f1_ewma_5 FIND V(xrr.ewma_node) AT=6.3116667
.meas tran f2_5 FIND V(f2_rr_asym) AT=6.7138889
.meas tran f3_5 FIND V(f3_bi_l0) AT=6.4666667
.meas tran f4_5 FIND V(f4_bi_l1) AT=6.4666667
.meas tran f5_5 FIND V(f5_pwave) AT=6.4666667
.meas tran f6_5 FIND V(f6_width) AT=6.4666667
.meas tran f7_5 FIND V(f7_slope) AT=6.4666667
.meas tran f8_5 FIND V(f8_symmetry) AT=6.4666667
.meas tran f1_6 FIND V(f1_rr_ratio) AT=7.0088889
.meas tran f1_sf_6 FIND V(xrr.sf_out) AT=7.0088889
.meas tran f1_ewma_6 FIND V(xrr.ewma_node) AT=7.0088889
.meas tran f2_6 FIND V(f2_rr_asym) AT=8.1527778
.meas tran f3_6 FIND V(f3_bi_l0) AT=7.1638889
.meas tran f4_6 FIND V(f4_bi_l1) AT=7.1638889
.meas tran f5_6 FIND V(f5_pwave) AT=7.1638889
.meas tran f6_6 FIND V(f6_width) AT=7.1638889
.meas tran f7_6 FIND V(f7_slope) AT=7.1638889
.meas tran f8_6 FIND V(f8_symmetry) AT=7.1638889
.meas tran f1_7 FIND V(f1_rr_ratio) AT=8.4477778
.meas tran f1_sf_7 FIND V(xrr.sf_out) AT=8.4477778
.meas tran f1_ewma_7 FIND V(xrr.ewma_node) AT=8.4477778
.meas tran f2_7 FIND V(f2_rr_asym) AT=8.8361111
.meas tran f3_7 FIND V(f3_bi_l0) AT=8.6027778
.meas tran f4_7 FIND V(f4_bi_l1) AT=8.6027778
.meas tran f5_7 FIND V(f5_pwave) AT=8.6027778
.meas tran f6_7 FIND V(f6_width) AT=8.6027778
.meas tran f7_7 FIND V(f7_slope) AT=8.6027778
.meas tran f8_7 FIND V(f8_symmetry) AT=8.6027778
.meas tran f1_8 FIND V(f1_rr_ratio) AT=9.1311111
.meas tran f1_sf_8 FIND V(xrr.sf_out) AT=9.1311111
.meas tran f1_ewma_8 FIND V(xrr.ewma_node) AT=9.1311111
.meas tran f2_8 FIND V(f2_rr_asym) AT=10.2250000
.meas tran f3_8 FIND V(f3_bi_l0) AT=9.2861111
.meas tran f4_8 FIND V(f4_bi_l1) AT=9.2861111
.meas tran f5_8 FIND V(f5_pwave) AT=9.2861111
.meas tran f6_8 FIND V(f6_width) AT=9.2861111
.meas tran f7_8 FIND V(f7_slope) AT=9.2861111
.meas tran f8_8 FIND V(f8_symmetry) AT=9.2861111
.meas tran f1_9 FIND V(f1_rr_ratio) AT=10.5200000
.meas tran f1_sf_9 FIND V(xrr.sf_out) AT=10.5200000
.meas tran f1_ewma_9 FIND V(xrr.ewma_node) AT=10.5200000
.meas tran f2_9 FIND V(f2_rr_asym) AT=10.8777778
.meas tran f3_9 FIND V(f3_bi_l0) AT=10.6750000
.meas tran f4_9 FIND V(f4_bi_l1) AT=10.6750000
.meas tran f5_9 FIND V(f5_pwave) AT=10.6750000
.meas tran f6_9 FIND V(f6_width) AT=10.6750000
.meas tran f7_9 FIND V(f7_slope) AT=10.6750000
.meas tran f8_9 FIND V(f8_symmetry) AT=10.6750000
.meas tran f1_10 FIND V(f1_rr_ratio) AT=11.1727778
.meas tran f1_sf_10 FIND V(xrr.sf_out) AT=11.1727778
.meas tran f1_ewma_10 FIND V(xrr.ewma_node) AT=11.1727778
.meas tran f2_10 FIND V(f2_rr_asym) AT=12.3916667
.meas tran f3_10 FIND V(f3_bi_l0) AT=11.3277778
.meas tran f4_10 FIND V(f4_bi_l1) AT=11.3277778
.meas tran f5_10 FIND V(f5_pwave) AT=11.3277778
.meas tran f6_10 FIND V(f6_width) AT=11.3277778
.meas tran f7_10 FIND V(f7_slope) AT=11.3277778
.meas tran f8_10 FIND V(f8_symmetry) AT=11.3277778
.meas tran f1_11 FIND V(f1_rr_ratio) AT=12.6866667
.meas tran f1_sf_11 FIND V(xrr.sf_out) AT=12.6866667
.meas tran f1_ewma_11 FIND V(xrr.ewma_node) AT=12.6866667
.meas tran f2_11 FIND V(f2_rr_asym) AT=13.0916667
.meas tran f3_11 FIND V(f3_bi_l0) AT=12.8416667
.meas tran f4_11 FIND V(f4_bi_l1) AT=12.8416667
.meas tran f5_11 FIND V(f5_pwave) AT=12.8416667
.meas tran f6_11 FIND V(f6_width) AT=12.8416667
.meas tran f7_11 FIND V(f7_slope) AT=12.8416667
.meas tran f8_11 FIND V(f8_symmetry) AT=12.8416667
.meas tran f1_12 FIND V(f1_rr_ratio) AT=13.3866667
.meas tran f1_sf_12 FIND V(xrr.sf_out) AT=13.3866667
.meas tran f1_ewma_12 FIND V(xrr.ewma_node) AT=13.3866667
.meas tran f2_12 FIND V(f2_rr_asym) AT=14.5361111
.meas tran f3_12 FIND V(f3_bi_l0) AT=13.5416667
.meas tran f4_12 FIND V(f4_bi_l1) AT=13.5416667
.meas tran f5_12 FIND V(f5_pwave) AT=13.5416667
.meas tran f6_12 FIND V(f6_width) AT=13.5416667
.meas tran f7_12 FIND V(f7_slope) AT=13.5416667
.meas tran f8_12 FIND V(f8_symmetry) AT=13.5416667
.meas tran f1_13 FIND V(f1_rr_ratio) AT=14.8311111
.meas tran f1_sf_13 FIND V(xrr.sf_out) AT=14.8311111
.meas tran f1_ewma_13 FIND V(xrr.ewma_node) AT=14.8311111
.meas tran f2_13 FIND V(f2_rr_asym) AT=15.2000000
.meas tran f3_13 FIND V(f3_bi_l0) AT=14.9861111
.meas tran f4_13 FIND V(f4_bi_l1) AT=14.9861111
.meas tran f5_13 FIND V(f5_pwave) AT=14.9861111
.meas tran f6_13 FIND V(f6_width) AT=14.9861111
.meas tran f7_13 FIND V(f7_slope) AT=14.9861111
.meas tran f8_13 FIND V(f8_symmetry) AT=14.9861111
.meas tran f1_14 FIND V(f1_rr_ratio) AT=15.4950000
.meas tran f1_sf_14 FIND V(xrr.sf_out) AT=15.4950000
.meas tran f1_ewma_14 FIND V(xrr.ewma_node) AT=15.4950000
.meas tran f2_14 FIND V(f2_rr_asym) AT=16.6222222
.meas tran f3_14 FIND V(f3_bi_l0) AT=15.6500000
.meas tran f4_14 FIND V(f4_bi_l1) AT=15.6500000
.meas tran f5_14 FIND V(f5_pwave) AT=15.6500000
.meas tran f6_14 FIND V(f6_width) AT=15.6500000
.meas tran f7_14 FIND V(f7_slope) AT=15.6500000
.meas tran f8_14 FIND V(f8_symmetry) AT=15.6500000
.meas tran f1_15 FIND V(f1_rr_ratio) AT=16.9172222
.meas tran f1_sf_15 FIND V(xrr.sf_out) AT=16.9172222
.meas tran f1_ewma_15 FIND V(xrr.ewma_node) AT=16.9172222
.meas tran f2_15 FIND V(f2_rr_asym) AT=17.3111111
.meas tran f3_15 FIND V(f3_bi_l0) AT=17.0722222
.meas tran f4_15 FIND V(f4_bi_l1) AT=17.0722222
.meas tran f5_15 FIND V(f5_pwave) AT=17.0722222
.meas tran f6_15 FIND V(f6_width) AT=17.0722222
.meas tran f7_15 FIND V(f7_slope) AT=17.0722222
.meas tran f8_15 FIND V(f8_symmetry) AT=17.0722222
.meas tran f1_16 FIND V(f1_rr_ratio) AT=17.6061111
.meas tran f1_sf_16 FIND V(xrr.sf_out) AT=17.6061111
.meas tran f1_ewma_16 FIND V(xrr.ewma_node) AT=17.6061111
.meas tran f2_16 FIND V(f2_rr_asym) AT=18.7861111
.meas tran f3_16 FIND V(f3_bi_l0) AT=17.7611111
.meas tran f4_16 FIND V(f4_bi_l1) AT=17.7611111
.meas tran f5_16 FIND V(f5_pwave) AT=17.7611111
.meas tran f6_16 FIND V(f6_width) AT=17.7611111
.meas tran f7_16 FIND V(f7_slope) AT=17.7611111
.meas tran f8_16 FIND V(f8_symmetry) AT=17.7611111
.meas tran f1_17 FIND V(f1_rr_ratio) AT=19.0811111
.meas tran f1_sf_17 FIND V(xrr.sf_out) AT=19.0811111
.meas tran f1_ewma_17 FIND V(xrr.ewma_node) AT=19.0811111
.meas tran f2_17 FIND V(f2_rr_asym) AT=19.4861111
.meas tran f3_17 FIND V(f3_bi_l0) AT=19.2361111
.meas tran f4_17 FIND V(f4_bi_l1) AT=19.2361111
.meas tran f5_17 FIND V(f5_pwave) AT=19.2361111
.meas tran f6_17 FIND V(f6_width) AT=19.2361111
.meas tran f7_17 FIND V(f7_slope) AT=19.2361111
.meas tran f8_17 FIND V(f8_symmetry) AT=19.2361111
.meas tran f1_18 FIND V(f1_rr_ratio) AT=19.7811111
.meas tran f1_sf_18 FIND V(xrr.sf_out) AT=19.7811111
.meas tran f1_ewma_18 FIND V(xrr.ewma_node) AT=19.7811111
.meas tran f2_18 FIND V(f2_rr_asym) AT=20.9000000
.meas tran f3_18 FIND V(f3_bi_l0) AT=19.9361111
.meas tran f4_18 FIND V(f4_bi_l1) AT=19.9361111
.meas tran f5_18 FIND V(f5_pwave) AT=19.9361111
.meas tran f6_18 FIND V(f6_width) AT=19.9361111
.meas tran f7_18 FIND V(f7_slope) AT=19.9361111
.meas tran f8_18 FIND V(f8_symmetry) AT=19.9361111
.meas tran f1_19 FIND V(f1_rr_ratio) AT=21.1950000
.meas tran f1_sf_19 FIND V(xrr.sf_out) AT=21.1950000
.meas tran f1_ewma_19 FIND V(xrr.ewma_node) AT=21.1950000
.meas tran f2_19 FIND V(f2_rr_asym) AT=21.5583333
.meas tran f3_19 FIND V(f3_bi_l0) AT=21.3500000
.meas tran f4_19 FIND V(f4_bi_l1) AT=21.3500000
.meas tran f5_19 FIND V(f5_pwave) AT=21.3500000
.meas tran f6_19 FIND V(f6_width) AT=21.3500000
.meas tran f7_19 FIND V(f7_slope) AT=21.3500000
.meas tran f8_19 FIND V(f8_symmetry) AT=21.3500000
.meas tran f1_20 FIND V(f1_rr_ratio) AT=21.8533333
.meas tran f1_sf_20 FIND V(xrr.sf_out) AT=21.8533333
.meas tran f1_ewma_20 FIND V(xrr.ewma_node) AT=21.8533333
.meas tran f2_20 FIND V(f2_rr_asym) AT=22.9472222
.meas tran f3_20 FIND V(f3_bi_l0) AT=22.0083333
.meas tran f4_20 FIND V(f4_bi_l1) AT=22.0083333
.meas tran f5_20 FIND V(f5_pwave) AT=22.0083333
.meas tran f6_20 FIND V(f6_width) AT=22.0083333
.meas tran f7_20 FIND V(f7_slope) AT=22.0083333
.meas tran f8_20 FIND V(f8_symmetry) AT=22.0083333
.meas tran f1_21 FIND V(f1_rr_ratio) AT=23.2422222
.meas tran f1_sf_21 FIND V(xrr.sf_out) AT=23.2422222
.meas tran f1_ewma_21 FIND V(xrr.ewma_node) AT=23.2422222
.meas tran f2_21 FIND V(f2_rr_asym) AT=23.6611111
.meas tran f3_21 FIND V(f3_bi_l0) AT=23.3972222
.meas tran f4_21 FIND V(f4_bi_l1) AT=23.3972222
.meas tran f5_21 FIND V(f5_pwave) AT=23.3972222
.meas tran f6_21 FIND V(f6_width) AT=23.3972222
.meas tran f7_21 FIND V(f7_slope) AT=23.3972222
.meas tran f8_21 FIND V(f8_symmetry) AT=23.3972222
.meas tran f1_22 FIND V(f1_rr_ratio) AT=23.9561111
.meas tran f1_sf_22 FIND V(xrr.sf_out) AT=23.9561111
.meas tran f1_ewma_22 FIND V(xrr.ewma_node) AT=23.9561111
.meas tran f2_22 FIND V(f2_rr_asym) AT=25.1083333
.meas tran f3_22 FIND V(f3_bi_l0) AT=24.1111111
.meas tran f4_22 FIND V(f4_bi_l1) AT=24.1111111
.meas tran f5_22 FIND V(f5_pwave) AT=24.1111111
.meas tran f6_22 FIND V(f6_width) AT=24.1111111
.meas tran f7_22 FIND V(f7_slope) AT=24.1111111
.meas tran f8_22 FIND V(f8_symmetry) AT=24.1111111
.meas tran f1_23 FIND V(f1_rr_ratio) AT=25.4033333
.meas tran f1_sf_23 FIND V(xrr.sf_out) AT=25.4033333
.meas tran f1_ewma_23 FIND V(xrr.ewma_node) AT=25.4033333
.meas tran f2_23 FIND V(f2_rr_asym) AT=25.7972222
.meas tran f3_23 FIND V(f3_bi_l0) AT=25.5583333
.meas tran f4_23 FIND V(f4_bi_l1) AT=25.5583333
.meas tran f5_23 FIND V(f5_pwave) AT=25.5583333
.meas tran f6_23 FIND V(f6_width) AT=25.5583333
.meas tran f7_23 FIND V(f7_slope) AT=25.5583333
.meas tran f8_23 FIND V(f8_symmetry) AT=25.5583333
.meas tran f1_24 FIND V(f1_rr_ratio) AT=26.0922222
.meas tran f1_sf_24 FIND V(xrr.sf_out) AT=26.0922222
.meas tran f1_ewma_24 FIND V(xrr.ewma_node) AT=26.0922222
.meas tran f2_24 FIND V(f2_rr_asym) AT=27.1472222
.meas tran f3_24 FIND V(f3_bi_l0) AT=26.2472222
.meas tran f4_24 FIND V(f4_bi_l1) AT=26.2472222
.meas tran f5_24 FIND V(f5_pwave) AT=26.2472222
.meas tran f6_24 FIND V(f6_width) AT=26.2472222
.meas tran f7_24 FIND V(f7_slope) AT=26.2472222
.meas tran f8_24 FIND V(f8_symmetry) AT=26.2472222
.meas tran f1_25 FIND V(f1_rr_ratio) AT=27.4422222
.meas tran f1_sf_25 FIND V(xrr.sf_out) AT=27.4422222
.meas tran f1_ewma_25 FIND V(xrr.ewma_node) AT=27.4422222
.meas tran f2_25 FIND V(f2_rr_asym) AT=27.8333333
.meas tran f3_25 FIND V(f3_bi_l0) AT=27.5972222
.meas tran f4_25 FIND V(f4_bi_l1) AT=27.5972222
.meas tran f5_25 FIND V(f5_pwave) AT=27.5972222
.meas tran f6_25 FIND V(f6_width) AT=27.5972222
.meas tran f7_25 FIND V(f7_slope) AT=27.5972222
.meas tran f8_25 FIND V(f8_symmetry) AT=27.5972222
.meas tran f1_26 FIND V(f1_rr_ratio) AT=28.1283333
.meas tran f1_sf_26 FIND V(xrr.sf_out) AT=28.1283333
.meas tran f1_ewma_26 FIND V(xrr.ewma_node) AT=28.1283333
.meas tran f2_26 FIND V(f2_rr_asym) AT=29.2027778
.meas tran f3_26 FIND V(f3_bi_l0) AT=28.2833333
.meas tran f4_26 FIND V(f4_bi_l1) AT=28.2833333
.meas tran f5_26 FIND V(f5_pwave) AT=28.2833333
.meas tran f6_26 FIND V(f6_width) AT=28.2833333
.meas tran f7_26 FIND V(f7_slope) AT=28.2833333
.meas tran f8_26 FIND V(f8_symmetry) AT=28.2833333
.meas tran f1_27 FIND V(f1_rr_ratio) AT=29.4977778
.meas tran f1_sf_27 FIND V(xrr.sf_out) AT=29.4977778
.meas tran f1_ewma_27 FIND V(xrr.ewma_node) AT=29.4977778
.meas tran f2_27 FIND V(f2_rr_asym) AT=29.8972222
.meas tran f3_27 FIND V(f3_bi_l0) AT=29.6527778
.meas tran f4_27 FIND V(f4_bi_l1) AT=29.6527778
.meas tran f5_27 FIND V(f5_pwave) AT=29.6527778
.meas tran f6_27 FIND V(f6_width) AT=29.6527778
.meas tran f7_27 FIND V(f7_slope) AT=29.6527778
.meas tran f8_27 FIND V(f8_symmetry) AT=29.6527778
.meas tran f1_28 FIND V(f1_rr_ratio) AT=30.1922222
.meas tran f1_sf_28 FIND V(xrr.sf_out) AT=30.1922222
.meas tran f1_ewma_28 FIND V(xrr.ewma_node) AT=30.1922222
.meas tran f2_28 FIND V(f2_rr_asym) AT=31.3166667
.meas tran f3_28 FIND V(f3_bi_l0) AT=30.3472222
.meas tran f4_28 FIND V(f4_bi_l1) AT=30.3472222
.meas tran f5_28 FIND V(f5_pwave) AT=30.3472222
.meas tran f6_28 FIND V(f6_width) AT=30.3472222
.meas tran f7_28 FIND V(f7_slope) AT=30.3472222
.meas tran f8_28 FIND V(f8_symmetry) AT=30.3472222
.meas tran f1_29 FIND V(f1_rr_ratio) AT=31.6116667
.meas tran f1_sf_29 FIND V(xrr.sf_out) AT=31.6116667
.meas tran f1_ewma_29 FIND V(xrr.ewma_node) AT=31.6116667
.meas tran f2_29 FIND V(f2_rr_asym) AT=32.0083333
.meas tran f3_29 FIND V(f3_bi_l0) AT=31.7666667
.meas tran f4_29 FIND V(f4_bi_l1) AT=31.7666667
.meas tran f5_29 FIND V(f5_pwave) AT=31.7666667
.meas tran f6_29 FIND V(f6_width) AT=31.7666667
.meas tran f7_29 FIND V(f7_slope) AT=31.7666667
.meas tran f8_29 FIND V(f8_symmetry) AT=31.7666667
.meas tran f1_30 FIND V(f1_rr_ratio) AT=32.3033333
.meas tran f1_sf_30 FIND V(xrr.sf_out) AT=32.3033333
.meas tran f1_ewma_30 FIND V(xrr.ewma_node) AT=32.3033333
.meas tran f2_30 FIND V(f2_rr_asym) AT=33.3916667
.meas tran f3_30 FIND V(f3_bi_l0) AT=32.4583333
.meas tran f4_30 FIND V(f4_bi_l1) AT=32.4583333
.meas tran f5_30 FIND V(f5_pwave) AT=32.4583333
.meas tran f6_30 FIND V(f6_width) AT=32.4583333
.meas tran f7_30 FIND V(f7_slope) AT=32.4583333
.meas tran f8_30 FIND V(f8_symmetry) AT=32.4583333
.meas tran f1_31 FIND V(f1_rr_ratio) AT=33.6866667
.meas tran f1_sf_31 FIND V(xrr.sf_out) AT=33.6866667
.meas tran f1_ewma_31 FIND V(xrr.ewma_node) AT=33.6866667
.meas tran f2_31 FIND V(f2_rr_asym) AT=34.0555556
.meas tran f3_31 FIND V(f3_bi_l0) AT=33.8416667
.meas tran f4_31 FIND V(f4_bi_l1) AT=33.8416667
.meas tran f5_31 FIND V(f5_pwave) AT=33.8416667
.meas tran f6_31 FIND V(f6_width) AT=33.8416667
.meas tran f7_31 FIND V(f7_slope) AT=33.8416667
.meas tran f8_31 FIND V(f8_symmetry) AT=33.8416667
.meas tran f1_32 FIND V(f1_rr_ratio) AT=34.3505556
.meas tran f1_sf_32 FIND V(xrr.sf_out) AT=34.3505556
.meas tran f1_ewma_32 FIND V(xrr.ewma_node) AT=34.3505556
.meas tran f2_32 FIND V(f2_rr_asym) AT=35.4444444
.meas tran f3_32 FIND V(f3_bi_l0) AT=34.5055556
.meas tran f4_32 FIND V(f4_bi_l1) AT=34.5055556
.meas tran f5_32 FIND V(f5_pwave) AT=34.5055556
.meas tran f6_32 FIND V(f6_width) AT=34.5055556
.meas tran f7_32 FIND V(f7_slope) AT=34.5055556
.meas tran f8_32 FIND V(f8_symmetry) AT=34.5055556
.meas tran f1_33 FIND V(f1_rr_ratio) AT=35.7394444
.meas tran f1_sf_33 FIND V(xrr.sf_out) AT=35.7394444
.meas tran f1_ewma_33 FIND V(xrr.ewma_node) AT=35.7394444
.meas tran f2_33 FIND V(f2_rr_asym) AT=36.1777778
.meas tran f3_33 FIND V(f3_bi_l0) AT=35.8944444
.meas tran f4_33 FIND V(f4_bi_l1) AT=35.8944444
.meas tran f5_33 FIND V(f5_pwave) AT=35.8944444
.meas tran f6_33 FIND V(f6_width) AT=35.8944444
.meas tran f7_33 FIND V(f7_slope) AT=35.8944444
.meas tran f8_33 FIND V(f8_symmetry) AT=35.8944444
.meas tran f1_34 FIND V(f1_rr_ratio) AT=36.4727778
.meas tran f1_sf_34 FIND V(xrr.sf_out) AT=36.4727778
.meas tran f1_ewma_34 FIND V(xrr.ewma_node) AT=36.4727778
.meas tran f3_34 FIND V(f3_bi_l0) AT=36.6277778
.meas tran f4_34 FIND V(f4_bi_l1) AT=36.6277778
.meas tran f5_34 FIND V(f5_pwave) AT=36.6277778
.meas tran f6_34 FIND V(f6_width) AT=36.6277778
.meas tran f7_34 FIND V(f7_slope) AT=36.6277778
.meas tran f8_34 FIND V(f8_symmetry) AT=36.6277778
.meas tran trpk_0 WHEN V(rpeak_pulse)=0.45 RISE=1 TD=0.6777778
.meas tran dtsf_0_5 FIND V(dt_sf_out) AT=0.6827778
.meas tran dtsf_0_15 FIND V(dt_sf_out) AT=0.6927778
.meas tran dtsf_0_30 FIND V(dt_sf_out) AT=0.7077778
.meas tran dtsf_0_50 FIND V(dt_sf_out) AT=0.7277778
.meas tran dtsf_0_80 FIND V(dt_sf_out) AT=0.7577778
.meas tran ts14_0 WHEN V(trig_s14)=0.45 RISE=1 TD=0.6777778
.meas tran ts69_0 WHEN V(trig_s69)=0.45 RISE=1 TD=0.6777778
.meas tran twid_0 WHEN V(trig_wid)=0.45 RISE=1 TD=0.6777778
.meas tran trpk_del_0 WHEN V(rpeak_pulse_delayed)=0.45 RISE=1 TD=0.6777778
.meas tran ts14_fall_0 WHEN V(trig_s14)=0.45 FALL=1 TD=0.6777778
.meas tran ts69_fall_0 WHEN V(trig_s69)=0.45 FALL=1 TD=0.6777778
.meas tran twid_fall_0 WHEN V(trig_wid)=0.45 FALL=1 TD=0.6777778
.meas tran trpk_del_fall_0 WHEN V(rpeak_pulse_delayed)=0.45 FALL=1 TD=0.6777778
.meas tran trrc_0 WHEN V(trig_rr_cap)=0.45 RISE=1 TD=0.6777778
.meas tran trrc_fall_0 WHEN V(trig_rr_cap)=0.45 FALL=1 TD=0.6777778
.meas tran sh14_0 FIND V(xslp.sh14) AT=0.8277778
.meas tran sh69_0 FIND V(xslp.sh69) AT=0.8277778
.meas tran bi0_curr_0 FIND V(xbi0.curr_node) AT=0.8277778
.meas tran bi0_prev_0 FIND V(xbi0.prev_node) AT=0.8277778
.meas tran bi1_curr_0 FIND V(xbi1.curr_node) AT=0.8277778
.meas tran bi1_prev_0 FIND V(xbi1.prev_node) AT=0.8277778
.meas tran ecg_at_f8cap_0 FIND V(ecg_l0) WHEN V(rpeak_pulse_delayed)=0.45 FALL=1 TD=0.6777778
.meas tran pw_shb_0 FIND V(xpw.shb) AT=0.8277778
.meas tran pw_shp_0 FIND V(xpw.shp) AT=0.8277778
.meas tran tpwb_fall_0 WHEN V(trig_pw_base)=0.45 FALL=1 TD=0.4277778
.meas tran tpwp_fall_0 WHEN V(trig_pw_peak)=0.45 FALL=1 TD=0.4277778
.meas tran trpk_1 WHEN V(rpeak_pulse)=0.45 RISE=1 TD=2.1305556
.meas tran dtsf_1_5 FIND V(dt_sf_out) AT=2.1355556
.meas tran dtsf_1_15 FIND V(dt_sf_out) AT=2.1455556
.meas tran dtsf_1_30 FIND V(dt_sf_out) AT=2.1605556
.meas tran dtsf_1_50 FIND V(dt_sf_out) AT=2.1805556
.meas tran dtsf_1_80 FIND V(dt_sf_out) AT=2.2105556
.meas tran ts14_1 WHEN V(trig_s14)=0.45 RISE=1 TD=2.1305556
.meas tran ts69_1 WHEN V(trig_s69)=0.45 RISE=1 TD=2.1305556
.meas tran twid_1 WHEN V(trig_wid)=0.45 RISE=1 TD=2.1305556
.meas tran trpk_del_1 WHEN V(rpeak_pulse_delayed)=0.45 RISE=1 TD=2.1305556
.meas tran ts14_fall_1 WHEN V(trig_s14)=0.45 FALL=1 TD=2.1305556
.meas tran ts69_fall_1 WHEN V(trig_s69)=0.45 FALL=1 TD=2.1305556
.meas tran twid_fall_1 WHEN V(trig_wid)=0.45 FALL=1 TD=2.1305556
.meas tran trpk_del_fall_1 WHEN V(rpeak_pulse_delayed)=0.45 FALL=1 TD=2.1305556
.meas tran trrc_1 WHEN V(trig_rr_cap)=0.45 RISE=1 TD=2.1305556
.meas tran trrc_fall_1 WHEN V(trig_rr_cap)=0.45 FALL=1 TD=2.1305556
.meas tran sh14_1 FIND V(xslp.sh14) AT=2.2805556
.meas tran sh69_1 FIND V(xslp.sh69) AT=2.2805556
.meas tran bi0_curr_1 FIND V(xbi0.curr_node) AT=2.2805556
.meas tran bi0_prev_1 FIND V(xbi0.prev_node) AT=2.2805556
.meas tran bi1_curr_1 FIND V(xbi1.curr_node) AT=2.2805556
.meas tran bi1_prev_1 FIND V(xbi1.prev_node) AT=2.2805556
.meas tran ecg_at_f8cap_1 FIND V(ecg_l0) WHEN V(rpeak_pulse_delayed)=0.45 FALL=1 TD=2.1305556
.meas tran pw_shb_1 FIND V(xpw.shb) AT=2.2805556
.meas tran pw_shp_1 FIND V(xpw.shp) AT=2.2805556
.meas tran tpwb_fall_1 WHEN V(trig_pw_base)=0.45 FALL=1 TD=1.8805556
.meas tran tpwp_fall_1 WHEN V(trig_pw_peak)=0.45 FALL=1 TD=1.8805556
.meas tran trpk_2 WHEN V(rpeak_pulse)=0.45 RISE=1 TD=2.8055556
.meas tran dtsf_2_5 FIND V(dt_sf_out) AT=2.8105556
.meas tran dtsf_2_15 FIND V(dt_sf_out) AT=2.8205556
.meas tran dtsf_2_30 FIND V(dt_sf_out) AT=2.8355556
.meas tran dtsf_2_50 FIND V(dt_sf_out) AT=2.8555556
.meas tran dtsf_2_80 FIND V(dt_sf_out) AT=2.8855556
.meas tran ts14_2 WHEN V(trig_s14)=0.45 RISE=1 TD=2.8055556
.meas tran ts69_2 WHEN V(trig_s69)=0.45 RISE=1 TD=2.8055556
.meas tran twid_2 WHEN V(trig_wid)=0.45 RISE=1 TD=2.8055556
.meas tran trpk_del_2 WHEN V(rpeak_pulse_delayed)=0.45 RISE=1 TD=2.8055556
.meas tran ts14_fall_2 WHEN V(trig_s14)=0.45 FALL=1 TD=2.8055556
.meas tran ts69_fall_2 WHEN V(trig_s69)=0.45 FALL=1 TD=2.8055556
.meas tran twid_fall_2 WHEN V(trig_wid)=0.45 FALL=1 TD=2.8055556
.meas tran trpk_del_fall_2 WHEN V(rpeak_pulse_delayed)=0.45 FALL=1 TD=2.8055556
.meas tran trrc_2 WHEN V(trig_rr_cap)=0.45 RISE=1 TD=2.8055556
.meas tran trrc_fall_2 WHEN V(trig_rr_cap)=0.45 FALL=1 TD=2.8055556
.meas tran sh14_2 FIND V(xslp.sh14) AT=2.9555556
.meas tran sh69_2 FIND V(xslp.sh69) AT=2.9555556
.meas tran bi0_curr_2 FIND V(xbi0.curr_node) AT=2.9555556
.meas tran bi0_prev_2 FIND V(xbi0.prev_node) AT=2.9555556
.meas tran bi1_curr_2 FIND V(xbi1.curr_node) AT=2.9555556
.meas tran bi1_prev_2 FIND V(xbi1.prev_node) AT=2.9555556
.meas tran ecg_at_f8cap_2 FIND V(ecg_l0) WHEN V(rpeak_pulse_delayed)=0.45 FALL=1 TD=2.8055556
.meas tran pw_shb_2 FIND V(xpw.shb) AT=2.9555556
.meas tran pw_shp_2 FIND V(xpw.shp) AT=2.9555556
.meas tran tpwb_fall_2 WHEN V(trig_pw_base)=0.45 FALL=1 TD=2.5555556
.meas tran tpwp_fall_2 WHEN V(trig_pw_peak)=0.45 FALL=1 TD=2.5555556
.meas tran trpk_3 WHEN V(rpeak_pulse)=0.45 RISE=1 TD=4.2222222
.meas tran dtsf_3_5 FIND V(dt_sf_out) AT=4.2272222
.meas tran dtsf_3_15 FIND V(dt_sf_out) AT=4.2372222
.meas tran dtsf_3_30 FIND V(dt_sf_out) AT=4.2522222
.meas tran dtsf_3_50 FIND V(dt_sf_out) AT=4.2722222
.meas tran dtsf_3_80 FIND V(dt_sf_out) AT=4.3022222
.meas tran ts14_3 WHEN V(trig_s14)=0.45 RISE=1 TD=4.2222222
.meas tran ts69_3 WHEN V(trig_s69)=0.45 RISE=1 TD=4.2222222
.meas tran twid_3 WHEN V(trig_wid)=0.45 RISE=1 TD=4.2222222
.meas tran trpk_del_3 WHEN V(rpeak_pulse_delayed)=0.45 RISE=1 TD=4.2222222
.meas tran ts14_fall_3 WHEN V(trig_s14)=0.45 FALL=1 TD=4.2222222
.meas tran ts69_fall_3 WHEN V(trig_s69)=0.45 FALL=1 TD=4.2222222
.meas tran twid_fall_3 WHEN V(trig_wid)=0.45 FALL=1 TD=4.2222222
.meas tran trpk_del_fall_3 WHEN V(rpeak_pulse_delayed)=0.45 FALL=1 TD=4.2222222
.meas tran trrc_3 WHEN V(trig_rr_cap)=0.45 RISE=1 TD=4.2222222
.meas tran trrc_fall_3 WHEN V(trig_rr_cap)=0.45 FALL=1 TD=4.2222222
.meas tran sh14_3 FIND V(xslp.sh14) AT=4.3722222
.meas tran sh69_3 FIND V(xslp.sh69) AT=4.3722222
.meas tran bi0_curr_3 FIND V(xbi0.curr_node) AT=4.3722222
.meas tran bi0_prev_3 FIND V(xbi0.prev_node) AT=4.3722222
.meas tran bi1_curr_3 FIND V(xbi1.curr_node) AT=4.3722222
.meas tran bi1_prev_3 FIND V(xbi1.prev_node) AT=4.3722222
.meas tran ecg_at_f8cap_3 FIND V(ecg_l0) WHEN V(rpeak_pulse_delayed)=0.45 FALL=1 TD=4.2222222
.meas tran pw_shb_3 FIND V(xpw.shb) AT=4.3722222
.meas tran pw_shp_3 FIND V(xpw.shp) AT=4.3722222
.meas tran tpwb_fall_3 WHEN V(trig_pw_base)=0.45 FALL=1 TD=3.9722222
.meas tran tpwp_fall_3 WHEN V(trig_pw_peak)=0.45 FALL=1 TD=3.9722222
.meas tran trpk_4 WHEN V(rpeak_pulse)=0.45 RISE=1 TD=4.8694444
.meas tran dtsf_4_5 FIND V(dt_sf_out) AT=4.8744444
.meas tran dtsf_4_15 FIND V(dt_sf_out) AT=4.8844444
.meas tran dtsf_4_30 FIND V(dt_sf_out) AT=4.8994444
.meas tran dtsf_4_50 FIND V(dt_sf_out) AT=4.9194444
.meas tran dtsf_4_80 FIND V(dt_sf_out) AT=4.9494444
.meas tran ts14_4 WHEN V(trig_s14)=0.45 RISE=1 TD=4.8694444
.meas tran ts69_4 WHEN V(trig_s69)=0.45 RISE=1 TD=4.8694444
.meas tran twid_4 WHEN V(trig_wid)=0.45 RISE=1 TD=4.8694444
.meas tran trpk_del_4 WHEN V(rpeak_pulse_delayed)=0.45 RISE=1 TD=4.8694444
.meas tran ts14_fall_4 WHEN V(trig_s14)=0.45 FALL=1 TD=4.8694444
.meas tran ts69_fall_4 WHEN V(trig_s69)=0.45 FALL=1 TD=4.8694444
.meas tran twid_fall_4 WHEN V(trig_wid)=0.45 FALL=1 TD=4.8694444
.meas tran trpk_del_fall_4 WHEN V(rpeak_pulse_delayed)=0.45 FALL=1 TD=4.8694444
.meas tran trrc_4 WHEN V(trig_rr_cap)=0.45 RISE=1 TD=4.8694444
.meas tran trrc_fall_4 WHEN V(trig_rr_cap)=0.45 FALL=1 TD=4.8694444
.meas tran sh14_4 FIND V(xslp.sh14) AT=5.0194444
.meas tran sh69_4 FIND V(xslp.sh69) AT=5.0194444
.meas tran bi0_curr_4 FIND V(xbi0.curr_node) AT=5.0194444
.meas tran bi0_prev_4 FIND V(xbi0.prev_node) AT=5.0194444
.meas tran bi1_curr_4 FIND V(xbi1.curr_node) AT=5.0194444
.meas tran bi1_prev_4 FIND V(xbi1.prev_node) AT=5.0194444
.meas tran ecg_at_f8cap_4 FIND V(ecg_l0) WHEN V(rpeak_pulse_delayed)=0.45 FALL=1 TD=4.8694444
.meas tran pw_shb_4 FIND V(xpw.shb) AT=5.0194444
.meas tran pw_shp_4 FIND V(xpw.shp) AT=5.0194444
.meas tran tpwb_fall_4 WHEN V(trig_pw_base)=0.45 FALL=1 TD=4.6194444
.meas tran tpwp_fall_4 WHEN V(trig_pw_peak)=0.45 FALL=1 TD=4.6194444
.meas tran trpk_5 WHEN V(rpeak_pulse)=0.45 RISE=1 TD=6.3166667
.meas tran dtsf_5_5 FIND V(dt_sf_out) AT=6.3216667
.meas tran dtsf_5_15 FIND V(dt_sf_out) AT=6.3316667
.meas tran dtsf_5_30 FIND V(dt_sf_out) AT=6.3466667
.meas tran dtsf_5_50 FIND V(dt_sf_out) AT=6.3666667
.meas tran dtsf_5_80 FIND V(dt_sf_out) AT=6.3966667
.meas tran ts14_5 WHEN V(trig_s14)=0.45 RISE=1 TD=6.3166667
.meas tran ts69_5 WHEN V(trig_s69)=0.45 RISE=1 TD=6.3166667
.meas tran twid_5 WHEN V(trig_wid)=0.45 RISE=1 TD=6.3166667
.meas tran trpk_del_5 WHEN V(rpeak_pulse_delayed)=0.45 RISE=1 TD=6.3166667
.meas tran ts14_fall_5 WHEN V(trig_s14)=0.45 FALL=1 TD=6.3166667
.meas tran ts69_fall_5 WHEN V(trig_s69)=0.45 FALL=1 TD=6.3166667
.meas tran twid_fall_5 WHEN V(trig_wid)=0.45 FALL=1 TD=6.3166667
.meas tran trpk_del_fall_5 WHEN V(rpeak_pulse_delayed)=0.45 FALL=1 TD=6.3166667
.meas tran trrc_5 WHEN V(trig_rr_cap)=0.45 RISE=1 TD=6.3166667
.meas tran trrc_fall_5 WHEN V(trig_rr_cap)=0.45 FALL=1 TD=6.3166667
.meas tran sh14_5 FIND V(xslp.sh14) AT=6.4666667
.meas tran sh69_5 FIND V(xslp.sh69) AT=6.4666667
.meas tran bi0_curr_5 FIND V(xbi0.curr_node) AT=6.4666667
.meas tran bi0_prev_5 FIND V(xbi0.prev_node) AT=6.4666667
.meas tran bi1_curr_5 FIND V(xbi1.curr_node) AT=6.4666667
.meas tran bi1_prev_5 FIND V(xbi1.prev_node) AT=6.4666667
.meas tran ecg_at_f8cap_5 FIND V(ecg_l0) WHEN V(rpeak_pulse_delayed)=0.45 FALL=1 TD=6.3166667
.meas tran pw_shb_5 FIND V(xpw.shb) AT=6.4666667
.meas tran pw_shp_5 FIND V(xpw.shp) AT=6.4666667
.meas tran tpwb_fall_5 WHEN V(trig_pw_base)=0.45 FALL=1 TD=6.0666667
.meas tran tpwp_fall_5 WHEN V(trig_pw_peak)=0.45 FALL=1 TD=6.0666667
.meas tran trpk_6 WHEN V(rpeak_pulse)=0.45 RISE=1 TD=7.0138889
.meas tran dtsf_6_5 FIND V(dt_sf_out) AT=7.0188889
.meas tran dtsf_6_15 FIND V(dt_sf_out) AT=7.0288889
.meas tran dtsf_6_30 FIND V(dt_sf_out) AT=7.0438889
.meas tran dtsf_6_50 FIND V(dt_sf_out) AT=7.0638889
.meas tran dtsf_6_80 FIND V(dt_sf_out) AT=7.0938889
.meas tran ts14_6 WHEN V(trig_s14)=0.45 RISE=1 TD=7.0138889
.meas tran ts69_6 WHEN V(trig_s69)=0.45 RISE=1 TD=7.0138889
.meas tran twid_6 WHEN V(trig_wid)=0.45 RISE=1 TD=7.0138889
.meas tran trpk_del_6 WHEN V(rpeak_pulse_delayed)=0.45 RISE=1 TD=7.0138889
.meas tran ts14_fall_6 WHEN V(trig_s14)=0.45 FALL=1 TD=7.0138889
.meas tran ts69_fall_6 WHEN V(trig_s69)=0.45 FALL=1 TD=7.0138889
.meas tran twid_fall_6 WHEN V(trig_wid)=0.45 FALL=1 TD=7.0138889
.meas tran trpk_del_fall_6 WHEN V(rpeak_pulse_delayed)=0.45 FALL=1 TD=7.0138889
.meas tran trrc_6 WHEN V(trig_rr_cap)=0.45 RISE=1 TD=7.0138889
.meas tran trrc_fall_6 WHEN V(trig_rr_cap)=0.45 FALL=1 TD=7.0138889
.meas tran sh14_6 FIND V(xslp.sh14) AT=7.1638889
.meas tran sh69_6 FIND V(xslp.sh69) AT=7.1638889
.meas tran bi0_curr_6 FIND V(xbi0.curr_node) AT=7.1638889
.meas tran bi0_prev_6 FIND V(xbi0.prev_node) AT=7.1638889
.meas tran bi1_curr_6 FIND V(xbi1.curr_node) AT=7.1638889
.meas tran bi1_prev_6 FIND V(xbi1.prev_node) AT=7.1638889
.meas tran ecg_at_f8cap_6 FIND V(ecg_l0) WHEN V(rpeak_pulse_delayed)=0.45 FALL=1 TD=7.0138889
.meas tran pw_shb_6 FIND V(xpw.shb) AT=7.1638889
.meas tran pw_shp_6 FIND V(xpw.shp) AT=7.1638889
.meas tran tpwb_fall_6 WHEN V(trig_pw_base)=0.45 FALL=1 TD=6.7638889
.meas tran tpwp_fall_6 WHEN V(trig_pw_peak)=0.45 FALL=1 TD=6.7638889
.meas tran trpk_7 WHEN V(rpeak_pulse)=0.45 RISE=1 TD=8.4527778
.meas tran dtsf_7_5 FIND V(dt_sf_out) AT=8.4577778
.meas tran dtsf_7_15 FIND V(dt_sf_out) AT=8.4677778
.meas tran dtsf_7_30 FIND V(dt_sf_out) AT=8.4827778
.meas tran dtsf_7_50 FIND V(dt_sf_out) AT=8.5027778
.meas tran dtsf_7_80 FIND V(dt_sf_out) AT=8.5327778
.meas tran ts14_7 WHEN V(trig_s14)=0.45 RISE=1 TD=8.4527778
.meas tran ts69_7 WHEN V(trig_s69)=0.45 RISE=1 TD=8.4527778
.meas tran twid_7 WHEN V(trig_wid)=0.45 RISE=1 TD=8.4527778
.meas tran trpk_del_7 WHEN V(rpeak_pulse_delayed)=0.45 RISE=1 TD=8.4527778
.meas tran ts14_fall_7 WHEN V(trig_s14)=0.45 FALL=1 TD=8.4527778
.meas tran ts69_fall_7 WHEN V(trig_s69)=0.45 FALL=1 TD=8.4527778
.meas tran twid_fall_7 WHEN V(trig_wid)=0.45 FALL=1 TD=8.4527778
.meas tran trpk_del_fall_7 WHEN V(rpeak_pulse_delayed)=0.45 FALL=1 TD=8.4527778
.meas tran trrc_7 WHEN V(trig_rr_cap)=0.45 RISE=1 TD=8.4527778
.meas tran trrc_fall_7 WHEN V(trig_rr_cap)=0.45 FALL=1 TD=8.4527778
.meas tran sh14_7 FIND V(xslp.sh14) AT=8.6027778
.meas tran sh69_7 FIND V(xslp.sh69) AT=8.6027778
.meas tran bi0_curr_7 FIND V(xbi0.curr_node) AT=8.6027778
.meas tran bi0_prev_7 FIND V(xbi0.prev_node) AT=8.6027778
.meas tran bi1_curr_7 FIND V(xbi1.curr_node) AT=8.6027778
.meas tran bi1_prev_7 FIND V(xbi1.prev_node) AT=8.6027778
.meas tran ecg_at_f8cap_7 FIND V(ecg_l0) WHEN V(rpeak_pulse_delayed)=0.45 FALL=1 TD=8.4527778
.meas tran pw_shb_7 FIND V(xpw.shb) AT=8.6027778
.meas tran pw_shp_7 FIND V(xpw.shp) AT=8.6027778
.meas tran tpwb_fall_7 WHEN V(trig_pw_base)=0.45 FALL=1 TD=8.2027778
.meas tran tpwp_fall_7 WHEN V(trig_pw_peak)=0.45 FALL=1 TD=8.2027778
.meas tran trpk_8 WHEN V(rpeak_pulse)=0.45 RISE=1 TD=9.1361111
.meas tran dtsf_8_5 FIND V(dt_sf_out) AT=9.1411111
.meas tran dtsf_8_15 FIND V(dt_sf_out) AT=9.1511111
.meas tran dtsf_8_30 FIND V(dt_sf_out) AT=9.1661111
.meas tran dtsf_8_50 FIND V(dt_sf_out) AT=9.1861111
.meas tran dtsf_8_80 FIND V(dt_sf_out) AT=9.2161111
.meas tran ts14_8 WHEN V(trig_s14)=0.45 RISE=1 TD=9.1361111
.meas tran ts69_8 WHEN V(trig_s69)=0.45 RISE=1 TD=9.1361111
.meas tran twid_8 WHEN V(trig_wid)=0.45 RISE=1 TD=9.1361111
.meas tran trpk_del_8 WHEN V(rpeak_pulse_delayed)=0.45 RISE=1 TD=9.1361111
.meas tran ts14_fall_8 WHEN V(trig_s14)=0.45 FALL=1 TD=9.1361111
.meas tran ts69_fall_8 WHEN V(trig_s69)=0.45 FALL=1 TD=9.1361111
.meas tran twid_fall_8 WHEN V(trig_wid)=0.45 FALL=1 TD=9.1361111
.meas tran trpk_del_fall_8 WHEN V(rpeak_pulse_delayed)=0.45 FALL=1 TD=9.1361111
.meas tran trrc_8 WHEN V(trig_rr_cap)=0.45 RISE=1 TD=9.1361111
.meas tran trrc_fall_8 WHEN V(trig_rr_cap)=0.45 FALL=1 TD=9.1361111
.meas tran sh14_8 FIND V(xslp.sh14) AT=9.2861111
.meas tran sh69_8 FIND V(xslp.sh69) AT=9.2861111
.meas tran bi0_curr_8 FIND V(xbi0.curr_node) AT=9.2861111
.meas tran bi0_prev_8 FIND V(xbi0.prev_node) AT=9.2861111
.meas tran bi1_curr_8 FIND V(xbi1.curr_node) AT=9.2861111
.meas tran bi1_prev_8 FIND V(xbi1.prev_node) AT=9.2861111
.meas tran ecg_at_f8cap_8 FIND V(ecg_l0) WHEN V(rpeak_pulse_delayed)=0.45 FALL=1 TD=9.1361111
.meas tran pw_shb_8 FIND V(xpw.shb) AT=9.2861111
.meas tran pw_shp_8 FIND V(xpw.shp) AT=9.2861111
.meas tran tpwb_fall_8 WHEN V(trig_pw_base)=0.45 FALL=1 TD=8.8861111
.meas tran tpwp_fall_8 WHEN V(trig_pw_peak)=0.45 FALL=1 TD=8.8861111
.meas tran trpk_9 WHEN V(rpeak_pulse)=0.45 RISE=1 TD=10.5250000
.meas tran dtsf_9_5 FIND V(dt_sf_out) AT=10.5300000
.meas tran dtsf_9_15 FIND V(dt_sf_out) AT=10.5400000
.meas tran dtsf_9_30 FIND V(dt_sf_out) AT=10.5550000
.meas tran dtsf_9_50 FIND V(dt_sf_out) AT=10.5750000
.meas tran dtsf_9_80 FIND V(dt_sf_out) AT=10.6050000
.meas tran ts14_9 WHEN V(trig_s14)=0.45 RISE=1 TD=10.5250000
.meas tran ts69_9 WHEN V(trig_s69)=0.45 RISE=1 TD=10.5250000
.meas tran twid_9 WHEN V(trig_wid)=0.45 RISE=1 TD=10.5250000
.meas tran trpk_del_9 WHEN V(rpeak_pulse_delayed)=0.45 RISE=1 TD=10.5250000
.meas tran ts14_fall_9 WHEN V(trig_s14)=0.45 FALL=1 TD=10.5250000
.meas tran ts69_fall_9 WHEN V(trig_s69)=0.45 FALL=1 TD=10.5250000
.meas tran twid_fall_9 WHEN V(trig_wid)=0.45 FALL=1 TD=10.5250000
.meas tran trpk_del_fall_9 WHEN V(rpeak_pulse_delayed)=0.45 FALL=1 TD=10.5250000
.meas tran trrc_9 WHEN V(trig_rr_cap)=0.45 RISE=1 TD=10.5250000
.meas tran trrc_fall_9 WHEN V(trig_rr_cap)=0.45 FALL=1 TD=10.5250000
.meas tran sh14_9 FIND V(xslp.sh14) AT=10.6750000
.meas tran sh69_9 FIND V(xslp.sh69) AT=10.6750000
.meas tran bi0_curr_9 FIND V(xbi0.curr_node) AT=10.6750000
.meas tran bi0_prev_9 FIND V(xbi0.prev_node) AT=10.6750000
.meas tran bi1_curr_9 FIND V(xbi1.curr_node) AT=10.6750000
.meas tran bi1_prev_9 FIND V(xbi1.prev_node) AT=10.6750000
.meas tran ecg_at_f8cap_9 FIND V(ecg_l0) WHEN V(rpeak_pulse_delayed)=0.45 FALL=1 TD=10.5250000
.meas tran pw_shb_9 FIND V(xpw.shb) AT=10.6750000
.meas tran pw_shp_9 FIND V(xpw.shp) AT=10.6750000
.meas tran tpwb_fall_9 WHEN V(trig_pw_base)=0.45 FALL=1 TD=10.2750000
.meas tran tpwp_fall_9 WHEN V(trig_pw_peak)=0.45 FALL=1 TD=10.2750000
.meas tran trpk_10 WHEN V(rpeak_pulse)=0.45 RISE=1 TD=11.1777778
.meas tran dtsf_10_5 FIND V(dt_sf_out) AT=11.1827778
.meas tran dtsf_10_15 FIND V(dt_sf_out) AT=11.1927778
.meas tran dtsf_10_30 FIND V(dt_sf_out) AT=11.2077778
.meas tran dtsf_10_50 FIND V(dt_sf_out) AT=11.2277778
.meas tran dtsf_10_80 FIND V(dt_sf_out) AT=11.2577778
.meas tran ts14_10 WHEN V(trig_s14)=0.45 RISE=1 TD=11.1777778
.meas tran ts69_10 WHEN V(trig_s69)=0.45 RISE=1 TD=11.1777778
.meas tran twid_10 WHEN V(trig_wid)=0.45 RISE=1 TD=11.1777778
.meas tran trpk_del_10 WHEN V(rpeak_pulse_delayed)=0.45 RISE=1 TD=11.1777778
.meas tran ts14_fall_10 WHEN V(trig_s14)=0.45 FALL=1 TD=11.1777778
.meas tran ts69_fall_10 WHEN V(trig_s69)=0.45 FALL=1 TD=11.1777778
.meas tran twid_fall_10 WHEN V(trig_wid)=0.45 FALL=1 TD=11.1777778
.meas tran trpk_del_fall_10 WHEN V(rpeak_pulse_delayed)=0.45 FALL=1 TD=11.1777778
.meas tran trrc_10 WHEN V(trig_rr_cap)=0.45 RISE=1 TD=11.1777778
.meas tran trrc_fall_10 WHEN V(trig_rr_cap)=0.45 FALL=1 TD=11.1777778
.meas tran sh14_10 FIND V(xslp.sh14) AT=11.3277778
.meas tran sh69_10 FIND V(xslp.sh69) AT=11.3277778
.meas tran bi0_curr_10 FIND V(xbi0.curr_node) AT=11.3277778
.meas tran bi0_prev_10 FIND V(xbi0.prev_node) AT=11.3277778
.meas tran bi1_curr_10 FIND V(xbi1.curr_node) AT=11.3277778
.meas tran bi1_prev_10 FIND V(xbi1.prev_node) AT=11.3277778
.meas tran ecg_at_f8cap_10 FIND V(ecg_l0) WHEN V(rpeak_pulse_delayed)=0.45 FALL=1 TD=11.1777778
.meas tran pw_shb_10 FIND V(xpw.shb) AT=11.3277778
.meas tran pw_shp_10 FIND V(xpw.shp) AT=11.3277778
.meas tran tpwb_fall_10 WHEN V(trig_pw_base)=0.45 FALL=1 TD=10.9277778
.meas tran tpwp_fall_10 WHEN V(trig_pw_peak)=0.45 FALL=1 TD=10.9277778
.meas tran trpk_11 WHEN V(rpeak_pulse)=0.45 RISE=1 TD=12.6916667
.meas tran dtsf_11_5 FIND V(dt_sf_out) AT=12.6966667
.meas tran dtsf_11_15 FIND V(dt_sf_out) AT=12.7066667
.meas tran dtsf_11_30 FIND V(dt_sf_out) AT=12.7216667
.meas tran dtsf_11_50 FIND V(dt_sf_out) AT=12.7416667
.meas tran dtsf_11_80 FIND V(dt_sf_out) AT=12.7716667
.meas tran ts14_11 WHEN V(trig_s14)=0.45 RISE=1 TD=12.6916667
.meas tran ts69_11 WHEN V(trig_s69)=0.45 RISE=1 TD=12.6916667
.meas tran twid_11 WHEN V(trig_wid)=0.45 RISE=1 TD=12.6916667
.meas tran trpk_del_11 WHEN V(rpeak_pulse_delayed)=0.45 RISE=1 TD=12.6916667
.meas tran ts14_fall_11 WHEN V(trig_s14)=0.45 FALL=1 TD=12.6916667
.meas tran ts69_fall_11 WHEN V(trig_s69)=0.45 FALL=1 TD=12.6916667
.meas tran twid_fall_11 WHEN V(trig_wid)=0.45 FALL=1 TD=12.6916667
.meas tran trpk_del_fall_11 WHEN V(rpeak_pulse_delayed)=0.45 FALL=1 TD=12.6916667
.meas tran trrc_11 WHEN V(trig_rr_cap)=0.45 RISE=1 TD=12.6916667
.meas tran trrc_fall_11 WHEN V(trig_rr_cap)=0.45 FALL=1 TD=12.6916667
.meas tran sh14_11 FIND V(xslp.sh14) AT=12.8416667
.meas tran sh69_11 FIND V(xslp.sh69) AT=12.8416667
.meas tran bi0_curr_11 FIND V(xbi0.curr_node) AT=12.8416667
.meas tran bi0_prev_11 FIND V(xbi0.prev_node) AT=12.8416667
.meas tran bi1_curr_11 FIND V(xbi1.curr_node) AT=12.8416667
.meas tran bi1_prev_11 FIND V(xbi1.prev_node) AT=12.8416667
.meas tran ecg_at_f8cap_11 FIND V(ecg_l0) WHEN V(rpeak_pulse_delayed)=0.45 FALL=1 TD=12.6916667
.meas tran pw_shb_11 FIND V(xpw.shb) AT=12.8416667
.meas tran pw_shp_11 FIND V(xpw.shp) AT=12.8416667
.meas tran tpwb_fall_11 WHEN V(trig_pw_base)=0.45 FALL=1 TD=12.4416667
.meas tran tpwp_fall_11 WHEN V(trig_pw_peak)=0.45 FALL=1 TD=12.4416667
.meas tran trpk_12 WHEN V(rpeak_pulse)=0.45 RISE=1 TD=13.3916667
.meas tran dtsf_12_5 FIND V(dt_sf_out) AT=13.3966667
.meas tran dtsf_12_15 FIND V(dt_sf_out) AT=13.4066667
.meas tran dtsf_12_30 FIND V(dt_sf_out) AT=13.4216667
.meas tran dtsf_12_50 FIND V(dt_sf_out) AT=13.4416667
.meas tran dtsf_12_80 FIND V(dt_sf_out) AT=13.4716667
.meas tran ts14_12 WHEN V(trig_s14)=0.45 RISE=1 TD=13.3916667
.meas tran ts69_12 WHEN V(trig_s69)=0.45 RISE=1 TD=13.3916667
.meas tran twid_12 WHEN V(trig_wid)=0.45 RISE=1 TD=13.3916667
.meas tran trpk_del_12 WHEN V(rpeak_pulse_delayed)=0.45 RISE=1 TD=13.3916667
.meas tran ts14_fall_12 WHEN V(trig_s14)=0.45 FALL=1 TD=13.3916667
.meas tran ts69_fall_12 WHEN V(trig_s69)=0.45 FALL=1 TD=13.3916667
.meas tran twid_fall_12 WHEN V(trig_wid)=0.45 FALL=1 TD=13.3916667
.meas tran trpk_del_fall_12 WHEN V(rpeak_pulse_delayed)=0.45 FALL=1 TD=13.3916667
.meas tran trrc_12 WHEN V(trig_rr_cap)=0.45 RISE=1 TD=13.3916667
.meas tran trrc_fall_12 WHEN V(trig_rr_cap)=0.45 FALL=1 TD=13.3916667
.meas tran sh14_12 FIND V(xslp.sh14) AT=13.5416667
.meas tran sh69_12 FIND V(xslp.sh69) AT=13.5416667
.meas tran bi0_curr_12 FIND V(xbi0.curr_node) AT=13.5416667
.meas tran bi0_prev_12 FIND V(xbi0.prev_node) AT=13.5416667
.meas tran bi1_curr_12 FIND V(xbi1.curr_node) AT=13.5416667
.meas tran bi1_prev_12 FIND V(xbi1.prev_node) AT=13.5416667
.meas tran ecg_at_f8cap_12 FIND V(ecg_l0) WHEN V(rpeak_pulse_delayed)=0.45 FALL=1 TD=13.3916667
.meas tran pw_shb_12 FIND V(xpw.shb) AT=13.5416667
.meas tran pw_shp_12 FIND V(xpw.shp) AT=13.5416667
.meas tran tpwb_fall_12 WHEN V(trig_pw_base)=0.45 FALL=1 TD=13.1416667
.meas tran tpwp_fall_12 WHEN V(trig_pw_peak)=0.45 FALL=1 TD=13.1416667
.meas tran trpk_13 WHEN V(rpeak_pulse)=0.45 RISE=1 TD=14.8361111
.meas tran dtsf_13_5 FIND V(dt_sf_out) AT=14.8411111
.meas tran dtsf_13_15 FIND V(dt_sf_out) AT=14.8511111
.meas tran dtsf_13_30 FIND V(dt_sf_out) AT=14.8661111
.meas tran dtsf_13_50 FIND V(dt_sf_out) AT=14.8861111
.meas tran dtsf_13_80 FIND V(dt_sf_out) AT=14.9161111
.meas tran ts14_13 WHEN V(trig_s14)=0.45 RISE=1 TD=14.8361111
.meas tran ts69_13 WHEN V(trig_s69)=0.45 RISE=1 TD=14.8361111
.meas tran twid_13 WHEN V(trig_wid)=0.45 RISE=1 TD=14.8361111
.meas tran trpk_del_13 WHEN V(rpeak_pulse_delayed)=0.45 RISE=1 TD=14.8361111
.meas tran ts14_fall_13 WHEN V(trig_s14)=0.45 FALL=1 TD=14.8361111
.meas tran ts69_fall_13 WHEN V(trig_s69)=0.45 FALL=1 TD=14.8361111
.meas tran twid_fall_13 WHEN V(trig_wid)=0.45 FALL=1 TD=14.8361111
.meas tran trpk_del_fall_13 WHEN V(rpeak_pulse_delayed)=0.45 FALL=1 TD=14.8361111
.meas tran trrc_13 WHEN V(trig_rr_cap)=0.45 RISE=1 TD=14.8361111
.meas tran trrc_fall_13 WHEN V(trig_rr_cap)=0.45 FALL=1 TD=14.8361111
.meas tran sh14_13 FIND V(xslp.sh14) AT=14.9861111
.meas tran sh69_13 FIND V(xslp.sh69) AT=14.9861111
.meas tran bi0_curr_13 FIND V(xbi0.curr_node) AT=14.9861111
.meas tran bi0_prev_13 FIND V(xbi0.prev_node) AT=14.9861111
.meas tran bi1_curr_13 FIND V(xbi1.curr_node) AT=14.9861111
.meas tran bi1_prev_13 FIND V(xbi1.prev_node) AT=14.9861111
.meas tran ecg_at_f8cap_13 FIND V(ecg_l0) WHEN V(rpeak_pulse_delayed)=0.45 FALL=1 TD=14.8361111
.meas tran pw_shb_13 FIND V(xpw.shb) AT=14.9861111
.meas tran pw_shp_13 FIND V(xpw.shp) AT=14.9861111
.meas tran tpwb_fall_13 WHEN V(trig_pw_base)=0.45 FALL=1 TD=14.5861111
.meas tran tpwp_fall_13 WHEN V(trig_pw_peak)=0.45 FALL=1 TD=14.5861111
.meas tran trpk_14 WHEN V(rpeak_pulse)=0.45 RISE=1 TD=15.5000000
.meas tran dtsf_14_5 FIND V(dt_sf_out) AT=15.5050000
.meas tran dtsf_14_15 FIND V(dt_sf_out) AT=15.5150000
.meas tran dtsf_14_30 FIND V(dt_sf_out) AT=15.5300000
.meas tran dtsf_14_50 FIND V(dt_sf_out) AT=15.5500000
.meas tran dtsf_14_80 FIND V(dt_sf_out) AT=15.5800000
.meas tran ts14_14 WHEN V(trig_s14)=0.45 RISE=1 TD=15.5000000
.meas tran ts69_14 WHEN V(trig_s69)=0.45 RISE=1 TD=15.5000000
.meas tran twid_14 WHEN V(trig_wid)=0.45 RISE=1 TD=15.5000000
.meas tran trpk_del_14 WHEN V(rpeak_pulse_delayed)=0.45 RISE=1 TD=15.5000000
.meas tran ts14_fall_14 WHEN V(trig_s14)=0.45 FALL=1 TD=15.5000000
.meas tran ts69_fall_14 WHEN V(trig_s69)=0.45 FALL=1 TD=15.5000000
.meas tran twid_fall_14 WHEN V(trig_wid)=0.45 FALL=1 TD=15.5000000
.meas tran trpk_del_fall_14 WHEN V(rpeak_pulse_delayed)=0.45 FALL=1 TD=15.5000000
.meas tran trrc_14 WHEN V(trig_rr_cap)=0.45 RISE=1 TD=15.5000000
.meas tran trrc_fall_14 WHEN V(trig_rr_cap)=0.45 FALL=1 TD=15.5000000
.meas tran sh14_14 FIND V(xslp.sh14) AT=15.6500000
.meas tran sh69_14 FIND V(xslp.sh69) AT=15.6500000
.meas tran bi0_curr_14 FIND V(xbi0.curr_node) AT=15.6500000
.meas tran bi0_prev_14 FIND V(xbi0.prev_node) AT=15.6500000
.meas tran bi1_curr_14 FIND V(xbi1.curr_node) AT=15.6500000
.meas tran bi1_prev_14 FIND V(xbi1.prev_node) AT=15.6500000
.meas tran ecg_at_f8cap_14 FIND V(ecg_l0) WHEN V(rpeak_pulse_delayed)=0.45 FALL=1 TD=15.5000000
.meas tran pw_shb_14 FIND V(xpw.shb) AT=15.6500000
.meas tran pw_shp_14 FIND V(xpw.shp) AT=15.6500000
.meas tran tpwb_fall_14 WHEN V(trig_pw_base)=0.45 FALL=1 TD=15.2500000
.meas tran tpwp_fall_14 WHEN V(trig_pw_peak)=0.45 FALL=1 TD=15.2500000
.meas tran trpk_15 WHEN V(rpeak_pulse)=0.45 RISE=1 TD=16.9222222
.meas tran dtsf_15_5 FIND V(dt_sf_out) AT=16.9272222
.meas tran dtsf_15_15 FIND V(dt_sf_out) AT=16.9372222
.meas tran dtsf_15_30 FIND V(dt_sf_out) AT=16.9522222
.meas tran dtsf_15_50 FIND V(dt_sf_out) AT=16.9722222
.meas tran dtsf_15_80 FIND V(dt_sf_out) AT=17.0022222
.meas tran ts14_15 WHEN V(trig_s14)=0.45 RISE=1 TD=16.9222222
.meas tran ts69_15 WHEN V(trig_s69)=0.45 RISE=1 TD=16.9222222
.meas tran twid_15 WHEN V(trig_wid)=0.45 RISE=1 TD=16.9222222
.meas tran trpk_del_15 WHEN V(rpeak_pulse_delayed)=0.45 RISE=1 TD=16.9222222
.meas tran ts14_fall_15 WHEN V(trig_s14)=0.45 FALL=1 TD=16.9222222
.meas tran ts69_fall_15 WHEN V(trig_s69)=0.45 FALL=1 TD=16.9222222
.meas tran twid_fall_15 WHEN V(trig_wid)=0.45 FALL=1 TD=16.9222222
.meas tran trpk_del_fall_15 WHEN V(rpeak_pulse_delayed)=0.45 FALL=1 TD=16.9222222
.meas tran trrc_15 WHEN V(trig_rr_cap)=0.45 RISE=1 TD=16.9222222
.meas tran trrc_fall_15 WHEN V(trig_rr_cap)=0.45 FALL=1 TD=16.9222222
.meas tran sh14_15 FIND V(xslp.sh14) AT=17.0722222
.meas tran sh69_15 FIND V(xslp.sh69) AT=17.0722222
.meas tran bi0_curr_15 FIND V(xbi0.curr_node) AT=17.0722222
.meas tran bi0_prev_15 FIND V(xbi0.prev_node) AT=17.0722222
.meas tran bi1_curr_15 FIND V(xbi1.curr_node) AT=17.0722222
.meas tran bi1_prev_15 FIND V(xbi1.prev_node) AT=17.0722222
.meas tran ecg_at_f8cap_15 FIND V(ecg_l0) WHEN V(rpeak_pulse_delayed)=0.45 FALL=1 TD=16.9222222
.meas tran pw_shb_15 FIND V(xpw.shb) AT=17.0722222
.meas tran pw_shp_15 FIND V(xpw.shp) AT=17.0722222
.meas tran tpwb_fall_15 WHEN V(trig_pw_base)=0.45 FALL=1 TD=16.6722222
.meas tran tpwp_fall_15 WHEN V(trig_pw_peak)=0.45 FALL=1 TD=16.6722222
.meas tran trpk_16 WHEN V(rpeak_pulse)=0.45 RISE=1 TD=17.6111111
.meas tran dtsf_16_5 FIND V(dt_sf_out) AT=17.6161111
.meas tran dtsf_16_15 FIND V(dt_sf_out) AT=17.6261111
.meas tran dtsf_16_30 FIND V(dt_sf_out) AT=17.6411111
.meas tran dtsf_16_50 FIND V(dt_sf_out) AT=17.6611111
.meas tran dtsf_16_80 FIND V(dt_sf_out) AT=17.6911111
.meas tran ts14_16 WHEN V(trig_s14)=0.45 RISE=1 TD=17.6111111
.meas tran ts69_16 WHEN V(trig_s69)=0.45 RISE=1 TD=17.6111111
.meas tran twid_16 WHEN V(trig_wid)=0.45 RISE=1 TD=17.6111111
.meas tran trpk_del_16 WHEN V(rpeak_pulse_delayed)=0.45 RISE=1 TD=17.6111111
.meas tran ts14_fall_16 WHEN V(trig_s14)=0.45 FALL=1 TD=17.6111111
.meas tran ts69_fall_16 WHEN V(trig_s69)=0.45 FALL=1 TD=17.6111111
.meas tran twid_fall_16 WHEN V(trig_wid)=0.45 FALL=1 TD=17.6111111
.meas tran trpk_del_fall_16 WHEN V(rpeak_pulse_delayed)=0.45 FALL=1 TD=17.6111111
.meas tran trrc_16 WHEN V(trig_rr_cap)=0.45 RISE=1 TD=17.6111111
.meas tran trrc_fall_16 WHEN V(trig_rr_cap)=0.45 FALL=1 TD=17.6111111
.meas tran sh14_16 FIND V(xslp.sh14) AT=17.7611111
.meas tran sh69_16 FIND V(xslp.sh69) AT=17.7611111
.meas tran bi0_curr_16 FIND V(xbi0.curr_node) AT=17.7611111
.meas tran bi0_prev_16 FIND V(xbi0.prev_node) AT=17.7611111
.meas tran bi1_curr_16 FIND V(xbi1.curr_node) AT=17.7611111
.meas tran bi1_prev_16 FIND V(xbi1.prev_node) AT=17.7611111
.meas tran ecg_at_f8cap_16 FIND V(ecg_l0) WHEN V(rpeak_pulse_delayed)=0.45 FALL=1 TD=17.6111111
.meas tran pw_shb_16 FIND V(xpw.shb) AT=17.7611111
.meas tran pw_shp_16 FIND V(xpw.shp) AT=17.7611111
.meas tran tpwb_fall_16 WHEN V(trig_pw_base)=0.45 FALL=1 TD=17.3611111
.meas tran tpwp_fall_16 WHEN V(trig_pw_peak)=0.45 FALL=1 TD=17.3611111
.meas tran trpk_17 WHEN V(rpeak_pulse)=0.45 RISE=1 TD=19.0861111
.meas tran dtsf_17_5 FIND V(dt_sf_out) AT=19.0911111
.meas tran dtsf_17_15 FIND V(dt_sf_out) AT=19.1011111
.meas tran dtsf_17_30 FIND V(dt_sf_out) AT=19.1161111
.meas tran dtsf_17_50 FIND V(dt_sf_out) AT=19.1361111
.meas tran dtsf_17_80 FIND V(dt_sf_out) AT=19.1661111
.meas tran ts14_17 WHEN V(trig_s14)=0.45 RISE=1 TD=19.0861111
.meas tran ts69_17 WHEN V(trig_s69)=0.45 RISE=1 TD=19.0861111
.meas tran twid_17 WHEN V(trig_wid)=0.45 RISE=1 TD=19.0861111
.meas tran trpk_del_17 WHEN V(rpeak_pulse_delayed)=0.45 RISE=1 TD=19.0861111
.meas tran ts14_fall_17 WHEN V(trig_s14)=0.45 FALL=1 TD=19.0861111
.meas tran ts69_fall_17 WHEN V(trig_s69)=0.45 FALL=1 TD=19.0861111
.meas tran twid_fall_17 WHEN V(trig_wid)=0.45 FALL=1 TD=19.0861111
.meas tran trpk_del_fall_17 WHEN V(rpeak_pulse_delayed)=0.45 FALL=1 TD=19.0861111
.meas tran trrc_17 WHEN V(trig_rr_cap)=0.45 RISE=1 TD=19.0861111
.meas tran trrc_fall_17 WHEN V(trig_rr_cap)=0.45 FALL=1 TD=19.0861111
.meas tran sh14_17 FIND V(xslp.sh14) AT=19.2361111
.meas tran sh69_17 FIND V(xslp.sh69) AT=19.2361111
.meas tran bi0_curr_17 FIND V(xbi0.curr_node) AT=19.2361111
.meas tran bi0_prev_17 FIND V(xbi0.prev_node) AT=19.2361111
.meas tran bi1_curr_17 FIND V(xbi1.curr_node) AT=19.2361111
.meas tran bi1_prev_17 FIND V(xbi1.prev_node) AT=19.2361111
.meas tran ecg_at_f8cap_17 FIND V(ecg_l0) WHEN V(rpeak_pulse_delayed)=0.45 FALL=1 TD=19.0861111
.meas tran pw_shb_17 FIND V(xpw.shb) AT=19.2361111
.meas tran pw_shp_17 FIND V(xpw.shp) AT=19.2361111
.meas tran tpwb_fall_17 WHEN V(trig_pw_base)=0.45 FALL=1 TD=18.8361111
.meas tran tpwp_fall_17 WHEN V(trig_pw_peak)=0.45 FALL=1 TD=18.8361111
.meas tran trpk_18 WHEN V(rpeak_pulse)=0.45 RISE=1 TD=19.7861111
.meas tran dtsf_18_5 FIND V(dt_sf_out) AT=19.7911111
.meas tran dtsf_18_15 FIND V(dt_sf_out) AT=19.8011111
.meas tran dtsf_18_30 FIND V(dt_sf_out) AT=19.8161111
.meas tran dtsf_18_50 FIND V(dt_sf_out) AT=19.8361111
.meas tran dtsf_18_80 FIND V(dt_sf_out) AT=19.8661111
.meas tran ts14_18 WHEN V(trig_s14)=0.45 RISE=1 TD=19.7861111
.meas tran ts69_18 WHEN V(trig_s69)=0.45 RISE=1 TD=19.7861111
.meas tran twid_18 WHEN V(trig_wid)=0.45 RISE=1 TD=19.7861111
.meas tran trpk_del_18 WHEN V(rpeak_pulse_delayed)=0.45 RISE=1 TD=19.7861111
.meas tran ts14_fall_18 WHEN V(trig_s14)=0.45 FALL=1 TD=19.7861111
.meas tran ts69_fall_18 WHEN V(trig_s69)=0.45 FALL=1 TD=19.7861111
.meas tran twid_fall_18 WHEN V(trig_wid)=0.45 FALL=1 TD=19.7861111
.meas tran trpk_del_fall_18 WHEN V(rpeak_pulse_delayed)=0.45 FALL=1 TD=19.7861111
.meas tran trrc_18 WHEN V(trig_rr_cap)=0.45 RISE=1 TD=19.7861111
.meas tran trrc_fall_18 WHEN V(trig_rr_cap)=0.45 FALL=1 TD=19.7861111
.meas tran sh14_18 FIND V(xslp.sh14) AT=19.9361111
.meas tran sh69_18 FIND V(xslp.sh69) AT=19.9361111
.meas tran bi0_curr_18 FIND V(xbi0.curr_node) AT=19.9361111
.meas tran bi0_prev_18 FIND V(xbi0.prev_node) AT=19.9361111
.meas tran bi1_curr_18 FIND V(xbi1.curr_node) AT=19.9361111
.meas tran bi1_prev_18 FIND V(xbi1.prev_node) AT=19.9361111
.meas tran ecg_at_f8cap_18 FIND V(ecg_l0) WHEN V(rpeak_pulse_delayed)=0.45 FALL=1 TD=19.7861111
.meas tran pw_shb_18 FIND V(xpw.shb) AT=19.9361111
.meas tran pw_shp_18 FIND V(xpw.shp) AT=19.9361111
.meas tran tpwb_fall_18 WHEN V(trig_pw_base)=0.45 FALL=1 TD=19.5361111
.meas tran tpwp_fall_18 WHEN V(trig_pw_peak)=0.45 FALL=1 TD=19.5361111
.meas tran trpk_19 WHEN V(rpeak_pulse)=0.45 RISE=1 TD=21.2000000
.meas tran dtsf_19_5 FIND V(dt_sf_out) AT=21.2050000
.meas tran dtsf_19_15 FIND V(dt_sf_out) AT=21.2150000
.meas tran dtsf_19_30 FIND V(dt_sf_out) AT=21.2300000
.meas tran dtsf_19_50 FIND V(dt_sf_out) AT=21.2500000
.meas tran dtsf_19_80 FIND V(dt_sf_out) AT=21.2800000
.meas tran ts14_19 WHEN V(trig_s14)=0.45 RISE=1 TD=21.2000000
.meas tran ts69_19 WHEN V(trig_s69)=0.45 RISE=1 TD=21.2000000
.meas tran twid_19 WHEN V(trig_wid)=0.45 RISE=1 TD=21.2000000
.meas tran trpk_del_19 WHEN V(rpeak_pulse_delayed)=0.45 RISE=1 TD=21.2000000
.meas tran ts14_fall_19 WHEN V(trig_s14)=0.45 FALL=1 TD=21.2000000
.meas tran ts69_fall_19 WHEN V(trig_s69)=0.45 FALL=1 TD=21.2000000
.meas tran twid_fall_19 WHEN V(trig_wid)=0.45 FALL=1 TD=21.2000000
.meas tran trpk_del_fall_19 WHEN V(rpeak_pulse_delayed)=0.45 FALL=1 TD=21.2000000
.meas tran trrc_19 WHEN V(trig_rr_cap)=0.45 RISE=1 TD=21.2000000
.meas tran trrc_fall_19 WHEN V(trig_rr_cap)=0.45 FALL=1 TD=21.2000000
.meas tran sh14_19 FIND V(xslp.sh14) AT=21.3500000
.meas tran sh69_19 FIND V(xslp.sh69) AT=21.3500000
.meas tran bi0_curr_19 FIND V(xbi0.curr_node) AT=21.3500000
.meas tran bi0_prev_19 FIND V(xbi0.prev_node) AT=21.3500000
.meas tran bi1_curr_19 FIND V(xbi1.curr_node) AT=21.3500000
.meas tran bi1_prev_19 FIND V(xbi1.prev_node) AT=21.3500000
.meas tran ecg_at_f8cap_19 FIND V(ecg_l0) WHEN V(rpeak_pulse_delayed)=0.45 FALL=1 TD=21.2000000
.meas tran pw_shb_19 FIND V(xpw.shb) AT=21.3500000
.meas tran pw_shp_19 FIND V(xpw.shp) AT=21.3500000
.meas tran tpwb_fall_19 WHEN V(trig_pw_base)=0.45 FALL=1 TD=20.9500000
.meas tran tpwp_fall_19 WHEN V(trig_pw_peak)=0.45 FALL=1 TD=20.9500000
.meas tran trpk_20 WHEN V(rpeak_pulse)=0.45 RISE=1 TD=21.8583333
.meas tran dtsf_20_5 FIND V(dt_sf_out) AT=21.8633333
.meas tran dtsf_20_15 FIND V(dt_sf_out) AT=21.8733333
.meas tran dtsf_20_30 FIND V(dt_sf_out) AT=21.8883333
.meas tran dtsf_20_50 FIND V(dt_sf_out) AT=21.9083333
.meas tran dtsf_20_80 FIND V(dt_sf_out) AT=21.9383333
.meas tran ts14_20 WHEN V(trig_s14)=0.45 RISE=1 TD=21.8583333
.meas tran ts69_20 WHEN V(trig_s69)=0.45 RISE=1 TD=21.8583333
.meas tran twid_20 WHEN V(trig_wid)=0.45 RISE=1 TD=21.8583333
.meas tran trpk_del_20 WHEN V(rpeak_pulse_delayed)=0.45 RISE=1 TD=21.8583333
.meas tran ts14_fall_20 WHEN V(trig_s14)=0.45 FALL=1 TD=21.8583333
.meas tran ts69_fall_20 WHEN V(trig_s69)=0.45 FALL=1 TD=21.8583333
.meas tran twid_fall_20 WHEN V(trig_wid)=0.45 FALL=1 TD=21.8583333
.meas tran trpk_del_fall_20 WHEN V(rpeak_pulse_delayed)=0.45 FALL=1 TD=21.8583333
.meas tran trrc_20 WHEN V(trig_rr_cap)=0.45 RISE=1 TD=21.8583333
.meas tran trrc_fall_20 WHEN V(trig_rr_cap)=0.45 FALL=1 TD=21.8583333
.meas tran sh14_20 FIND V(xslp.sh14) AT=22.0083333
.meas tran sh69_20 FIND V(xslp.sh69) AT=22.0083333
.meas tran bi0_curr_20 FIND V(xbi0.curr_node) AT=22.0083333
.meas tran bi0_prev_20 FIND V(xbi0.prev_node) AT=22.0083333
.meas tran bi1_curr_20 FIND V(xbi1.curr_node) AT=22.0083333
.meas tran bi1_prev_20 FIND V(xbi1.prev_node) AT=22.0083333
.meas tran ecg_at_f8cap_20 FIND V(ecg_l0) WHEN V(rpeak_pulse_delayed)=0.45 FALL=1 TD=21.8583333
.meas tran pw_shb_20 FIND V(xpw.shb) AT=22.0083333
.meas tran pw_shp_20 FIND V(xpw.shp) AT=22.0083333
.meas tran tpwb_fall_20 WHEN V(trig_pw_base)=0.45 FALL=1 TD=21.6083333
.meas tran tpwp_fall_20 WHEN V(trig_pw_peak)=0.45 FALL=1 TD=21.6083333
.meas tran trpk_21 WHEN V(rpeak_pulse)=0.45 RISE=1 TD=23.2472222
.meas tran dtsf_21_5 FIND V(dt_sf_out) AT=23.2522222
.meas tran dtsf_21_15 FIND V(dt_sf_out) AT=23.2622222
.meas tran dtsf_21_30 FIND V(dt_sf_out) AT=23.2772222
.meas tran dtsf_21_50 FIND V(dt_sf_out) AT=23.2972222
.meas tran dtsf_21_80 FIND V(dt_sf_out) AT=23.3272222
.meas tran ts14_21 WHEN V(trig_s14)=0.45 RISE=1 TD=23.2472222
.meas tran ts69_21 WHEN V(trig_s69)=0.45 RISE=1 TD=23.2472222
.meas tran twid_21 WHEN V(trig_wid)=0.45 RISE=1 TD=23.2472222
.meas tran trpk_del_21 WHEN V(rpeak_pulse_delayed)=0.45 RISE=1 TD=23.2472222
.meas tran ts14_fall_21 WHEN V(trig_s14)=0.45 FALL=1 TD=23.2472222
.meas tran ts69_fall_21 WHEN V(trig_s69)=0.45 FALL=1 TD=23.2472222
.meas tran twid_fall_21 WHEN V(trig_wid)=0.45 FALL=1 TD=23.2472222
.meas tran trpk_del_fall_21 WHEN V(rpeak_pulse_delayed)=0.45 FALL=1 TD=23.2472222
.meas tran trrc_21 WHEN V(trig_rr_cap)=0.45 RISE=1 TD=23.2472222
.meas tran trrc_fall_21 WHEN V(trig_rr_cap)=0.45 FALL=1 TD=23.2472222
.meas tran sh14_21 FIND V(xslp.sh14) AT=23.3972222
.meas tran sh69_21 FIND V(xslp.sh69) AT=23.3972222
.meas tran bi0_curr_21 FIND V(xbi0.curr_node) AT=23.3972222
.meas tran bi0_prev_21 FIND V(xbi0.prev_node) AT=23.3972222
.meas tran bi1_curr_21 FIND V(xbi1.curr_node) AT=23.3972222
.meas tran bi1_prev_21 FIND V(xbi1.prev_node) AT=23.3972222
.meas tran ecg_at_f8cap_21 FIND V(ecg_l0) WHEN V(rpeak_pulse_delayed)=0.45 FALL=1 TD=23.2472222
.meas tran pw_shb_21 FIND V(xpw.shb) AT=23.3972222
.meas tran pw_shp_21 FIND V(xpw.shp) AT=23.3972222
.meas tran tpwb_fall_21 WHEN V(trig_pw_base)=0.45 FALL=1 TD=22.9972222
.meas tran tpwp_fall_21 WHEN V(trig_pw_peak)=0.45 FALL=1 TD=22.9972222
.meas tran trpk_22 WHEN V(rpeak_pulse)=0.45 RISE=1 TD=23.9611111
.meas tran dtsf_22_5 FIND V(dt_sf_out) AT=23.9661111
.meas tran dtsf_22_15 FIND V(dt_sf_out) AT=23.9761111
.meas tran dtsf_22_30 FIND V(dt_sf_out) AT=23.9911111
.meas tran dtsf_22_50 FIND V(dt_sf_out) AT=24.0111111
.meas tran dtsf_22_80 FIND V(dt_sf_out) AT=24.0411111
.meas tran ts14_22 WHEN V(trig_s14)=0.45 RISE=1 TD=23.9611111
.meas tran ts69_22 WHEN V(trig_s69)=0.45 RISE=1 TD=23.9611111
.meas tran twid_22 WHEN V(trig_wid)=0.45 RISE=1 TD=23.9611111
.meas tran trpk_del_22 WHEN V(rpeak_pulse_delayed)=0.45 RISE=1 TD=23.9611111
.meas tran ts14_fall_22 WHEN V(trig_s14)=0.45 FALL=1 TD=23.9611111
.meas tran ts69_fall_22 WHEN V(trig_s69)=0.45 FALL=1 TD=23.9611111
.meas tran twid_fall_22 WHEN V(trig_wid)=0.45 FALL=1 TD=23.9611111
.meas tran trpk_del_fall_22 WHEN V(rpeak_pulse_delayed)=0.45 FALL=1 TD=23.9611111
.meas tran trrc_22 WHEN V(trig_rr_cap)=0.45 RISE=1 TD=23.9611111
.meas tran trrc_fall_22 WHEN V(trig_rr_cap)=0.45 FALL=1 TD=23.9611111
.meas tran sh14_22 FIND V(xslp.sh14) AT=24.1111111
.meas tran sh69_22 FIND V(xslp.sh69) AT=24.1111111
.meas tran bi0_curr_22 FIND V(xbi0.curr_node) AT=24.1111111
.meas tran bi0_prev_22 FIND V(xbi0.prev_node) AT=24.1111111
.meas tran bi1_curr_22 FIND V(xbi1.curr_node) AT=24.1111111
.meas tran bi1_prev_22 FIND V(xbi1.prev_node) AT=24.1111111
.meas tran ecg_at_f8cap_22 FIND V(ecg_l0) WHEN V(rpeak_pulse_delayed)=0.45 FALL=1 TD=23.9611111
.meas tran pw_shb_22 FIND V(xpw.shb) AT=24.1111111
.meas tran pw_shp_22 FIND V(xpw.shp) AT=24.1111111
.meas tran tpwb_fall_22 WHEN V(trig_pw_base)=0.45 FALL=1 TD=23.7111111
.meas tran tpwp_fall_22 WHEN V(trig_pw_peak)=0.45 FALL=1 TD=23.7111111
.meas tran trpk_23 WHEN V(rpeak_pulse)=0.45 RISE=1 TD=25.4083333
.meas tran dtsf_23_5 FIND V(dt_sf_out) AT=25.4133333
.meas tran dtsf_23_15 FIND V(dt_sf_out) AT=25.4233333
.meas tran dtsf_23_30 FIND V(dt_sf_out) AT=25.4383333
.meas tran dtsf_23_50 FIND V(dt_sf_out) AT=25.4583333
.meas tran dtsf_23_80 FIND V(dt_sf_out) AT=25.4883333
.meas tran ts14_23 WHEN V(trig_s14)=0.45 RISE=1 TD=25.4083333
.meas tran ts69_23 WHEN V(trig_s69)=0.45 RISE=1 TD=25.4083333
.meas tran twid_23 WHEN V(trig_wid)=0.45 RISE=1 TD=25.4083333
.meas tran trpk_del_23 WHEN V(rpeak_pulse_delayed)=0.45 RISE=1 TD=25.4083333
.meas tran ts14_fall_23 WHEN V(trig_s14)=0.45 FALL=1 TD=25.4083333
.meas tran ts69_fall_23 WHEN V(trig_s69)=0.45 FALL=1 TD=25.4083333
.meas tran twid_fall_23 WHEN V(trig_wid)=0.45 FALL=1 TD=25.4083333
.meas tran trpk_del_fall_23 WHEN V(rpeak_pulse_delayed)=0.45 FALL=1 TD=25.4083333
.meas tran trrc_23 WHEN V(trig_rr_cap)=0.45 RISE=1 TD=25.4083333
.meas tran trrc_fall_23 WHEN V(trig_rr_cap)=0.45 FALL=1 TD=25.4083333
.meas tran sh14_23 FIND V(xslp.sh14) AT=25.5583333
.meas tran sh69_23 FIND V(xslp.sh69) AT=25.5583333
.meas tran bi0_curr_23 FIND V(xbi0.curr_node) AT=25.5583333
.meas tran bi0_prev_23 FIND V(xbi0.prev_node) AT=25.5583333
.meas tran bi1_curr_23 FIND V(xbi1.curr_node) AT=25.5583333
.meas tran bi1_prev_23 FIND V(xbi1.prev_node) AT=25.5583333
.meas tran ecg_at_f8cap_23 FIND V(ecg_l0) WHEN V(rpeak_pulse_delayed)=0.45 FALL=1 TD=25.4083333
.meas tran pw_shb_23 FIND V(xpw.shb) AT=25.5583333
.meas tran pw_shp_23 FIND V(xpw.shp) AT=25.5583333
.meas tran tpwb_fall_23 WHEN V(trig_pw_base)=0.45 FALL=1 TD=25.1583333
.meas tran tpwp_fall_23 WHEN V(trig_pw_peak)=0.45 FALL=1 TD=25.1583333
.meas tran trpk_24 WHEN V(rpeak_pulse)=0.45 RISE=1 TD=26.0972222
.meas tran dtsf_24_5 FIND V(dt_sf_out) AT=26.1022222
.meas tran dtsf_24_15 FIND V(dt_sf_out) AT=26.1122222
.meas tran dtsf_24_30 FIND V(dt_sf_out) AT=26.1272222
.meas tran dtsf_24_50 FIND V(dt_sf_out) AT=26.1472222
.meas tran dtsf_24_80 FIND V(dt_sf_out) AT=26.1772222
.meas tran ts14_24 WHEN V(trig_s14)=0.45 RISE=1 TD=26.0972222
.meas tran ts69_24 WHEN V(trig_s69)=0.45 RISE=1 TD=26.0972222
.meas tran twid_24 WHEN V(trig_wid)=0.45 RISE=1 TD=26.0972222
.meas tran trpk_del_24 WHEN V(rpeak_pulse_delayed)=0.45 RISE=1 TD=26.0972222
.meas tran ts14_fall_24 WHEN V(trig_s14)=0.45 FALL=1 TD=26.0972222
.meas tran ts69_fall_24 WHEN V(trig_s69)=0.45 FALL=1 TD=26.0972222
.meas tran twid_fall_24 WHEN V(trig_wid)=0.45 FALL=1 TD=26.0972222
.meas tran trpk_del_fall_24 WHEN V(rpeak_pulse_delayed)=0.45 FALL=1 TD=26.0972222
.meas tran trrc_24 WHEN V(trig_rr_cap)=0.45 RISE=1 TD=26.0972222
.meas tran trrc_fall_24 WHEN V(trig_rr_cap)=0.45 FALL=1 TD=26.0972222
.meas tran sh14_24 FIND V(xslp.sh14) AT=26.2472222
.meas tran sh69_24 FIND V(xslp.sh69) AT=26.2472222
.meas tran bi0_curr_24 FIND V(xbi0.curr_node) AT=26.2472222
.meas tran bi0_prev_24 FIND V(xbi0.prev_node) AT=26.2472222
.meas tran bi1_curr_24 FIND V(xbi1.curr_node) AT=26.2472222
.meas tran bi1_prev_24 FIND V(xbi1.prev_node) AT=26.2472222
.meas tran ecg_at_f8cap_24 FIND V(ecg_l0) WHEN V(rpeak_pulse_delayed)=0.45 FALL=1 TD=26.0972222
.meas tran pw_shb_24 FIND V(xpw.shb) AT=26.2472222
.meas tran pw_shp_24 FIND V(xpw.shp) AT=26.2472222
.meas tran tpwb_fall_24 WHEN V(trig_pw_base)=0.45 FALL=1 TD=25.8472222
.meas tran tpwp_fall_24 WHEN V(trig_pw_peak)=0.45 FALL=1 TD=25.8472222
.meas tran trpk_25 WHEN V(rpeak_pulse)=0.45 RISE=1 TD=27.4472222
.meas tran dtsf_25_5 FIND V(dt_sf_out) AT=27.4522222
.meas tran dtsf_25_15 FIND V(dt_sf_out) AT=27.4622222
.meas tran dtsf_25_30 FIND V(dt_sf_out) AT=27.4772222
.meas tran dtsf_25_50 FIND V(dt_sf_out) AT=27.4972222
.meas tran dtsf_25_80 FIND V(dt_sf_out) AT=27.5272222
.meas tran ts14_25 WHEN V(trig_s14)=0.45 RISE=1 TD=27.4472222
.meas tran ts69_25 WHEN V(trig_s69)=0.45 RISE=1 TD=27.4472222
.meas tran twid_25 WHEN V(trig_wid)=0.45 RISE=1 TD=27.4472222
.meas tran trpk_del_25 WHEN V(rpeak_pulse_delayed)=0.45 RISE=1 TD=27.4472222
.meas tran ts14_fall_25 WHEN V(trig_s14)=0.45 FALL=1 TD=27.4472222
.meas tran ts69_fall_25 WHEN V(trig_s69)=0.45 FALL=1 TD=27.4472222
.meas tran twid_fall_25 WHEN V(trig_wid)=0.45 FALL=1 TD=27.4472222
.meas tran trpk_del_fall_25 WHEN V(rpeak_pulse_delayed)=0.45 FALL=1 TD=27.4472222
.meas tran trrc_25 WHEN V(trig_rr_cap)=0.45 RISE=1 TD=27.4472222
.meas tran trrc_fall_25 WHEN V(trig_rr_cap)=0.45 FALL=1 TD=27.4472222
.meas tran sh14_25 FIND V(xslp.sh14) AT=27.5972222
.meas tran sh69_25 FIND V(xslp.sh69) AT=27.5972222
.meas tran bi0_curr_25 FIND V(xbi0.curr_node) AT=27.5972222
.meas tran bi0_prev_25 FIND V(xbi0.prev_node) AT=27.5972222
.meas tran bi1_curr_25 FIND V(xbi1.curr_node) AT=27.5972222
.meas tran bi1_prev_25 FIND V(xbi1.prev_node) AT=27.5972222
.meas tran ecg_at_f8cap_25 FIND V(ecg_l0) WHEN V(rpeak_pulse_delayed)=0.45 FALL=1 TD=27.4472222
.meas tran pw_shb_25 FIND V(xpw.shb) AT=27.5972222
.meas tran pw_shp_25 FIND V(xpw.shp) AT=27.5972222
.meas tran tpwb_fall_25 WHEN V(trig_pw_base)=0.45 FALL=1 TD=27.1972222
.meas tran tpwp_fall_25 WHEN V(trig_pw_peak)=0.45 FALL=1 TD=27.1972222
.meas tran trpk_26 WHEN V(rpeak_pulse)=0.45 RISE=1 TD=28.1333333
.meas tran dtsf_26_5 FIND V(dt_sf_out) AT=28.1383333
.meas tran dtsf_26_15 FIND V(dt_sf_out) AT=28.1483333
.meas tran dtsf_26_30 FIND V(dt_sf_out) AT=28.1633333
.meas tran dtsf_26_50 FIND V(dt_sf_out) AT=28.1833333
.meas tran dtsf_26_80 FIND V(dt_sf_out) AT=28.2133333
.meas tran ts14_26 WHEN V(trig_s14)=0.45 RISE=1 TD=28.1333333
.meas tran ts69_26 WHEN V(trig_s69)=0.45 RISE=1 TD=28.1333333
.meas tran twid_26 WHEN V(trig_wid)=0.45 RISE=1 TD=28.1333333
.meas tran trpk_del_26 WHEN V(rpeak_pulse_delayed)=0.45 RISE=1 TD=28.1333333
.meas tran ts14_fall_26 WHEN V(trig_s14)=0.45 FALL=1 TD=28.1333333
.meas tran ts69_fall_26 WHEN V(trig_s69)=0.45 FALL=1 TD=28.1333333
.meas tran twid_fall_26 WHEN V(trig_wid)=0.45 FALL=1 TD=28.1333333
.meas tran trpk_del_fall_26 WHEN V(rpeak_pulse_delayed)=0.45 FALL=1 TD=28.1333333
.meas tran trrc_26 WHEN V(trig_rr_cap)=0.45 RISE=1 TD=28.1333333
.meas tran trrc_fall_26 WHEN V(trig_rr_cap)=0.45 FALL=1 TD=28.1333333
.meas tran sh14_26 FIND V(xslp.sh14) AT=28.2833333
.meas tran sh69_26 FIND V(xslp.sh69) AT=28.2833333
.meas tran bi0_curr_26 FIND V(xbi0.curr_node) AT=28.2833333
.meas tran bi0_prev_26 FIND V(xbi0.prev_node) AT=28.2833333
.meas tran bi1_curr_26 FIND V(xbi1.curr_node) AT=28.2833333
.meas tran bi1_prev_26 FIND V(xbi1.prev_node) AT=28.2833333
.meas tran ecg_at_f8cap_26 FIND V(ecg_l0) WHEN V(rpeak_pulse_delayed)=0.45 FALL=1 TD=28.1333333
.meas tran pw_shb_26 FIND V(xpw.shb) AT=28.2833333
.meas tran pw_shp_26 FIND V(xpw.shp) AT=28.2833333
.meas tran tpwb_fall_26 WHEN V(trig_pw_base)=0.45 FALL=1 TD=27.8833333
.meas tran tpwp_fall_26 WHEN V(trig_pw_peak)=0.45 FALL=1 TD=27.8833333
.meas tran trpk_27 WHEN V(rpeak_pulse)=0.45 RISE=1 TD=29.5027778
.meas tran dtsf_27_5 FIND V(dt_sf_out) AT=29.5077778
.meas tran dtsf_27_15 FIND V(dt_sf_out) AT=29.5177778
.meas tran dtsf_27_30 FIND V(dt_sf_out) AT=29.5327778
.meas tran dtsf_27_50 FIND V(dt_sf_out) AT=29.5527778
.meas tran dtsf_27_80 FIND V(dt_sf_out) AT=29.5827778
.meas tran ts14_27 WHEN V(trig_s14)=0.45 RISE=1 TD=29.5027778
.meas tran ts69_27 WHEN V(trig_s69)=0.45 RISE=1 TD=29.5027778
.meas tran twid_27 WHEN V(trig_wid)=0.45 RISE=1 TD=29.5027778
.meas tran trpk_del_27 WHEN V(rpeak_pulse_delayed)=0.45 RISE=1 TD=29.5027778
.meas tran ts14_fall_27 WHEN V(trig_s14)=0.45 FALL=1 TD=29.5027778
.meas tran ts69_fall_27 WHEN V(trig_s69)=0.45 FALL=1 TD=29.5027778
.meas tran twid_fall_27 WHEN V(trig_wid)=0.45 FALL=1 TD=29.5027778
.meas tran trpk_del_fall_27 WHEN V(rpeak_pulse_delayed)=0.45 FALL=1 TD=29.5027778
.meas tran trrc_27 WHEN V(trig_rr_cap)=0.45 RISE=1 TD=29.5027778
.meas tran trrc_fall_27 WHEN V(trig_rr_cap)=0.45 FALL=1 TD=29.5027778
.meas tran sh14_27 FIND V(xslp.sh14) AT=29.6527778
.meas tran sh69_27 FIND V(xslp.sh69) AT=29.6527778
.meas tran bi0_curr_27 FIND V(xbi0.curr_node) AT=29.6527778
.meas tran bi0_prev_27 FIND V(xbi0.prev_node) AT=29.6527778
.meas tran bi1_curr_27 FIND V(xbi1.curr_node) AT=29.6527778
.meas tran bi1_prev_27 FIND V(xbi1.prev_node) AT=29.6527778
.meas tran ecg_at_f8cap_27 FIND V(ecg_l0) WHEN V(rpeak_pulse_delayed)=0.45 FALL=1 TD=29.5027778
.meas tran pw_shb_27 FIND V(xpw.shb) AT=29.6527778
.meas tran pw_shp_27 FIND V(xpw.shp) AT=29.6527778
.meas tran tpwb_fall_27 WHEN V(trig_pw_base)=0.45 FALL=1 TD=29.2527778
.meas tran tpwp_fall_27 WHEN V(trig_pw_peak)=0.45 FALL=1 TD=29.2527778
.meas tran trpk_28 WHEN V(rpeak_pulse)=0.45 RISE=1 TD=30.1972222
.meas tran dtsf_28_5 FIND V(dt_sf_out) AT=30.2022222
.meas tran dtsf_28_15 FIND V(dt_sf_out) AT=30.2122222
.meas tran dtsf_28_30 FIND V(dt_sf_out) AT=30.2272222
.meas tran dtsf_28_50 FIND V(dt_sf_out) AT=30.2472222
.meas tran dtsf_28_80 FIND V(dt_sf_out) AT=30.2772222
.meas tran ts14_28 WHEN V(trig_s14)=0.45 RISE=1 TD=30.1972222
.meas tran ts69_28 WHEN V(trig_s69)=0.45 RISE=1 TD=30.1972222
.meas tran twid_28 WHEN V(trig_wid)=0.45 RISE=1 TD=30.1972222
.meas tran trpk_del_28 WHEN V(rpeak_pulse_delayed)=0.45 RISE=1 TD=30.1972222
.meas tran ts14_fall_28 WHEN V(trig_s14)=0.45 FALL=1 TD=30.1972222
.meas tran ts69_fall_28 WHEN V(trig_s69)=0.45 FALL=1 TD=30.1972222
.meas tran twid_fall_28 WHEN V(trig_wid)=0.45 FALL=1 TD=30.1972222
.meas tran trpk_del_fall_28 WHEN V(rpeak_pulse_delayed)=0.45 FALL=1 TD=30.1972222
.meas tran trrc_28 WHEN V(trig_rr_cap)=0.45 RISE=1 TD=30.1972222
.meas tran trrc_fall_28 WHEN V(trig_rr_cap)=0.45 FALL=1 TD=30.1972222
.meas tran sh14_28 FIND V(xslp.sh14) AT=30.3472222
.meas tran sh69_28 FIND V(xslp.sh69) AT=30.3472222
.meas tran bi0_curr_28 FIND V(xbi0.curr_node) AT=30.3472222
.meas tran bi0_prev_28 FIND V(xbi0.prev_node) AT=30.3472222
.meas tran bi1_curr_28 FIND V(xbi1.curr_node) AT=30.3472222
.meas tran bi1_prev_28 FIND V(xbi1.prev_node) AT=30.3472222
.meas tran ecg_at_f8cap_28 FIND V(ecg_l0) WHEN V(rpeak_pulse_delayed)=0.45 FALL=1 TD=30.1972222
.meas tran pw_shb_28 FIND V(xpw.shb) AT=30.3472222
.meas tran pw_shp_28 FIND V(xpw.shp) AT=30.3472222
.meas tran tpwb_fall_28 WHEN V(trig_pw_base)=0.45 FALL=1 TD=29.9472222
.meas tran tpwp_fall_28 WHEN V(trig_pw_peak)=0.45 FALL=1 TD=29.9472222
.meas tran trpk_29 WHEN V(rpeak_pulse)=0.45 RISE=1 TD=31.6166667
.meas tran dtsf_29_5 FIND V(dt_sf_out) AT=31.6216667
.meas tran dtsf_29_15 FIND V(dt_sf_out) AT=31.6316667
.meas tran dtsf_29_30 FIND V(dt_sf_out) AT=31.6466667
.meas tran dtsf_29_50 FIND V(dt_sf_out) AT=31.6666667
.meas tran dtsf_29_80 FIND V(dt_sf_out) AT=31.6966667
.meas tran ts14_29 WHEN V(trig_s14)=0.45 RISE=1 TD=31.6166667
.meas tran ts69_29 WHEN V(trig_s69)=0.45 RISE=1 TD=31.6166667
.meas tran twid_29 WHEN V(trig_wid)=0.45 RISE=1 TD=31.6166667
.meas tran trpk_del_29 WHEN V(rpeak_pulse_delayed)=0.45 RISE=1 TD=31.6166667
.meas tran ts14_fall_29 WHEN V(trig_s14)=0.45 FALL=1 TD=31.6166667
.meas tran ts69_fall_29 WHEN V(trig_s69)=0.45 FALL=1 TD=31.6166667
.meas tran twid_fall_29 WHEN V(trig_wid)=0.45 FALL=1 TD=31.6166667
.meas tran trpk_del_fall_29 WHEN V(rpeak_pulse_delayed)=0.45 FALL=1 TD=31.6166667
.meas tran trrc_29 WHEN V(trig_rr_cap)=0.45 RISE=1 TD=31.6166667
.meas tran trrc_fall_29 WHEN V(trig_rr_cap)=0.45 FALL=1 TD=31.6166667
.meas tran sh14_29 FIND V(xslp.sh14) AT=31.7666667
.meas tran sh69_29 FIND V(xslp.sh69) AT=31.7666667
.meas tran bi0_curr_29 FIND V(xbi0.curr_node) AT=31.7666667
.meas tran bi0_prev_29 FIND V(xbi0.prev_node) AT=31.7666667
.meas tran bi1_curr_29 FIND V(xbi1.curr_node) AT=31.7666667
.meas tran bi1_prev_29 FIND V(xbi1.prev_node) AT=31.7666667
.meas tran ecg_at_f8cap_29 FIND V(ecg_l0) WHEN V(rpeak_pulse_delayed)=0.45 FALL=1 TD=31.6166667
.meas tran pw_shb_29 FIND V(xpw.shb) AT=31.7666667
.meas tran pw_shp_29 FIND V(xpw.shp) AT=31.7666667
.meas tran tpwb_fall_29 WHEN V(trig_pw_base)=0.45 FALL=1 TD=31.3666667
.meas tran tpwp_fall_29 WHEN V(trig_pw_peak)=0.45 FALL=1 TD=31.3666667
.meas tran trpk_30 WHEN V(rpeak_pulse)=0.45 RISE=1 TD=32.3083333
.meas tran dtsf_30_5 FIND V(dt_sf_out) AT=32.3133333
.meas tran dtsf_30_15 FIND V(dt_sf_out) AT=32.3233333
.meas tran dtsf_30_30 FIND V(dt_sf_out) AT=32.3383333
.meas tran dtsf_30_50 FIND V(dt_sf_out) AT=32.3583333
.meas tran dtsf_30_80 FIND V(dt_sf_out) AT=32.3883333
.meas tran ts14_30 WHEN V(trig_s14)=0.45 RISE=1 TD=32.3083333
.meas tran ts69_30 WHEN V(trig_s69)=0.45 RISE=1 TD=32.3083333
.meas tran twid_30 WHEN V(trig_wid)=0.45 RISE=1 TD=32.3083333
.meas tran trpk_del_30 WHEN V(rpeak_pulse_delayed)=0.45 RISE=1 TD=32.3083333
.meas tran ts14_fall_30 WHEN V(trig_s14)=0.45 FALL=1 TD=32.3083333
.meas tran ts69_fall_30 WHEN V(trig_s69)=0.45 FALL=1 TD=32.3083333
.meas tran twid_fall_30 WHEN V(trig_wid)=0.45 FALL=1 TD=32.3083333
.meas tran trpk_del_fall_30 WHEN V(rpeak_pulse_delayed)=0.45 FALL=1 TD=32.3083333
.meas tran trrc_30 WHEN V(trig_rr_cap)=0.45 RISE=1 TD=32.3083333
.meas tran trrc_fall_30 WHEN V(trig_rr_cap)=0.45 FALL=1 TD=32.3083333
.meas tran sh14_30 FIND V(xslp.sh14) AT=32.4583333
.meas tran sh69_30 FIND V(xslp.sh69) AT=32.4583333
.meas tran bi0_curr_30 FIND V(xbi0.curr_node) AT=32.4583333
.meas tran bi0_prev_30 FIND V(xbi0.prev_node) AT=32.4583333
.meas tran bi1_curr_30 FIND V(xbi1.curr_node) AT=32.4583333
.meas tran bi1_prev_30 FIND V(xbi1.prev_node) AT=32.4583333
.meas tran ecg_at_f8cap_30 FIND V(ecg_l0) WHEN V(rpeak_pulse_delayed)=0.45 FALL=1 TD=32.3083333
.meas tran pw_shb_30 FIND V(xpw.shb) AT=32.4583333
.meas tran pw_shp_30 FIND V(xpw.shp) AT=32.4583333
.meas tran tpwb_fall_30 WHEN V(trig_pw_base)=0.45 FALL=1 TD=32.0583333
.meas tran tpwp_fall_30 WHEN V(trig_pw_peak)=0.45 FALL=1 TD=32.0583333
.meas tran trpk_31 WHEN V(rpeak_pulse)=0.45 RISE=1 TD=33.6916667
.meas tran dtsf_31_5 FIND V(dt_sf_out) AT=33.6966667
.meas tran dtsf_31_15 FIND V(dt_sf_out) AT=33.7066667
.meas tran dtsf_31_30 FIND V(dt_sf_out) AT=33.7216667
.meas tran dtsf_31_50 FIND V(dt_sf_out) AT=33.7416667
.meas tran dtsf_31_80 FIND V(dt_sf_out) AT=33.7716667
.meas tran ts14_31 WHEN V(trig_s14)=0.45 RISE=1 TD=33.6916667
.meas tran ts69_31 WHEN V(trig_s69)=0.45 RISE=1 TD=33.6916667
.meas tran twid_31 WHEN V(trig_wid)=0.45 RISE=1 TD=33.6916667
.meas tran trpk_del_31 WHEN V(rpeak_pulse_delayed)=0.45 RISE=1 TD=33.6916667
.meas tran ts14_fall_31 WHEN V(trig_s14)=0.45 FALL=1 TD=33.6916667
.meas tran ts69_fall_31 WHEN V(trig_s69)=0.45 FALL=1 TD=33.6916667
.meas tran twid_fall_31 WHEN V(trig_wid)=0.45 FALL=1 TD=33.6916667
.meas tran trpk_del_fall_31 WHEN V(rpeak_pulse_delayed)=0.45 FALL=1 TD=33.6916667
.meas tran trrc_31 WHEN V(trig_rr_cap)=0.45 RISE=1 TD=33.6916667
.meas tran trrc_fall_31 WHEN V(trig_rr_cap)=0.45 FALL=1 TD=33.6916667
.meas tran sh14_31 FIND V(xslp.sh14) AT=33.8416667
.meas tran sh69_31 FIND V(xslp.sh69) AT=33.8416667
.meas tran bi0_curr_31 FIND V(xbi0.curr_node) AT=33.8416667
.meas tran bi0_prev_31 FIND V(xbi0.prev_node) AT=33.8416667
.meas tran bi1_curr_31 FIND V(xbi1.curr_node) AT=33.8416667
.meas tran bi1_prev_31 FIND V(xbi1.prev_node) AT=33.8416667
.meas tran ecg_at_f8cap_31 FIND V(ecg_l0) WHEN V(rpeak_pulse_delayed)=0.45 FALL=1 TD=33.6916667
.meas tran pw_shb_31 FIND V(xpw.shb) AT=33.8416667
.meas tran pw_shp_31 FIND V(xpw.shp) AT=33.8416667
.meas tran tpwb_fall_31 WHEN V(trig_pw_base)=0.45 FALL=1 TD=33.4416667
.meas tran tpwp_fall_31 WHEN V(trig_pw_peak)=0.45 FALL=1 TD=33.4416667
.meas tran trpk_32 WHEN V(rpeak_pulse)=0.45 RISE=1 TD=34.3555556
.meas tran dtsf_32_5 FIND V(dt_sf_out) AT=34.3605556
.meas tran dtsf_32_15 FIND V(dt_sf_out) AT=34.3705556
.meas tran dtsf_32_30 FIND V(dt_sf_out) AT=34.3855556
.meas tran dtsf_32_50 FIND V(dt_sf_out) AT=34.4055556
.meas tran dtsf_32_80 FIND V(dt_sf_out) AT=34.4355556
.meas tran ts14_32 WHEN V(trig_s14)=0.45 RISE=1 TD=34.3555556
.meas tran ts69_32 WHEN V(trig_s69)=0.45 RISE=1 TD=34.3555556
.meas tran twid_32 WHEN V(trig_wid)=0.45 RISE=1 TD=34.3555556
.meas tran trpk_del_32 WHEN V(rpeak_pulse_delayed)=0.45 RISE=1 TD=34.3555556
.meas tran ts14_fall_32 WHEN V(trig_s14)=0.45 FALL=1 TD=34.3555556
.meas tran ts69_fall_32 WHEN V(trig_s69)=0.45 FALL=1 TD=34.3555556
.meas tran twid_fall_32 WHEN V(trig_wid)=0.45 FALL=1 TD=34.3555556
.meas tran trpk_del_fall_32 WHEN V(rpeak_pulse_delayed)=0.45 FALL=1 TD=34.3555556
.meas tran trrc_32 WHEN V(trig_rr_cap)=0.45 RISE=1 TD=34.3555556
.meas tran trrc_fall_32 WHEN V(trig_rr_cap)=0.45 FALL=1 TD=34.3555556
.meas tran sh14_32 FIND V(xslp.sh14) AT=34.5055556
.meas tran sh69_32 FIND V(xslp.sh69) AT=34.5055556
.meas tran bi0_curr_32 FIND V(xbi0.curr_node) AT=34.5055556
.meas tran bi0_prev_32 FIND V(xbi0.prev_node) AT=34.5055556
.meas tran bi1_curr_32 FIND V(xbi1.curr_node) AT=34.5055556
.meas tran bi1_prev_32 FIND V(xbi1.prev_node) AT=34.5055556
.meas tran ecg_at_f8cap_32 FIND V(ecg_l0) WHEN V(rpeak_pulse_delayed)=0.45 FALL=1 TD=34.3555556
.meas tran pw_shb_32 FIND V(xpw.shb) AT=34.5055556
.meas tran pw_shp_32 FIND V(xpw.shp) AT=34.5055556
.meas tran tpwb_fall_32 WHEN V(trig_pw_base)=0.45 FALL=1 TD=34.1055556
.meas tran tpwp_fall_32 WHEN V(trig_pw_peak)=0.45 FALL=1 TD=34.1055556
.meas tran trpk_33 WHEN V(rpeak_pulse)=0.45 RISE=1 TD=35.7444444
.meas tran dtsf_33_5 FIND V(dt_sf_out) AT=35.7494444
.meas tran dtsf_33_15 FIND V(dt_sf_out) AT=35.7594444
.meas tran dtsf_33_30 FIND V(dt_sf_out) AT=35.7744444
.meas tran dtsf_33_50 FIND V(dt_sf_out) AT=35.7944444
.meas tran dtsf_33_80 FIND V(dt_sf_out) AT=35.8244444
.meas tran ts14_33 WHEN V(trig_s14)=0.45 RISE=1 TD=35.7444444
.meas tran ts69_33 WHEN V(trig_s69)=0.45 RISE=1 TD=35.7444444
.meas tran twid_33 WHEN V(trig_wid)=0.45 RISE=1 TD=35.7444444
.meas tran trpk_del_33 WHEN V(rpeak_pulse_delayed)=0.45 RISE=1 TD=35.7444444
.meas tran ts14_fall_33 WHEN V(trig_s14)=0.45 FALL=1 TD=35.7444444
.meas tran ts69_fall_33 WHEN V(trig_s69)=0.45 FALL=1 TD=35.7444444
.meas tran twid_fall_33 WHEN V(trig_wid)=0.45 FALL=1 TD=35.7444444
.meas tran trpk_del_fall_33 WHEN V(rpeak_pulse_delayed)=0.45 FALL=1 TD=35.7444444
.meas tran trrc_33 WHEN V(trig_rr_cap)=0.45 RISE=1 TD=35.7444444
.meas tran trrc_fall_33 WHEN V(trig_rr_cap)=0.45 FALL=1 TD=35.7444444
.meas tran sh14_33 FIND V(xslp.sh14) AT=35.8944444
.meas tran sh69_33 FIND V(xslp.sh69) AT=35.8944444
.meas tran bi0_curr_33 FIND V(xbi0.curr_node) AT=35.8944444
.meas tran bi0_prev_33 FIND V(xbi0.prev_node) AT=35.8944444
.meas tran bi1_curr_33 FIND V(xbi1.curr_node) AT=35.8944444
.meas tran bi1_prev_33 FIND V(xbi1.prev_node) AT=35.8944444
.meas tran ecg_at_f8cap_33 FIND V(ecg_l0) WHEN V(rpeak_pulse_delayed)=0.45 FALL=1 TD=35.7444444
.meas tran pw_shb_33 FIND V(xpw.shb) AT=35.8944444
.meas tran pw_shp_33 FIND V(xpw.shp) AT=35.8944444
.meas tran tpwb_fall_33 WHEN V(trig_pw_base)=0.45 FALL=1 TD=35.4944444
.meas tran tpwp_fall_33 WHEN V(trig_pw_peak)=0.45 FALL=1 TD=35.4944444
.meas tran trpk_34 WHEN V(rpeak_pulse)=0.45 RISE=1 TD=36.4777778
.meas tran dtsf_34_5 FIND V(dt_sf_out) AT=36.4827778
.meas tran dtsf_34_15 FIND V(dt_sf_out) AT=36.4927778
.meas tran dtsf_34_30 FIND V(dt_sf_out) AT=36.5077778
.meas tran dtsf_34_50 FIND V(dt_sf_out) AT=36.5277778
.meas tran dtsf_34_80 FIND V(dt_sf_out) AT=36.5577778
.meas tran ts14_34 WHEN V(trig_s14)=0.45 RISE=1 TD=36.4777778
.meas tran ts69_34 WHEN V(trig_s69)=0.45 RISE=1 TD=36.4777778
.meas tran twid_34 WHEN V(trig_wid)=0.45 RISE=1 TD=36.4777778
.meas tran trpk_del_34 WHEN V(rpeak_pulse_delayed)=0.45 RISE=1 TD=36.4777778
.meas tran ts14_fall_34 WHEN V(trig_s14)=0.45 FALL=1 TD=36.4777778
.meas tran ts69_fall_34 WHEN V(trig_s69)=0.45 FALL=1 TD=36.4777778
.meas tran twid_fall_34 WHEN V(trig_wid)=0.45 FALL=1 TD=36.4777778
.meas tran trpk_del_fall_34 WHEN V(rpeak_pulse_delayed)=0.45 FALL=1 TD=36.4777778
.meas tran trrc_34 WHEN V(trig_rr_cap)=0.45 RISE=1 TD=36.4777778
.meas tran trrc_fall_34 WHEN V(trig_rr_cap)=0.45 FALL=1 TD=36.4777778
.meas tran sh14_34 FIND V(xslp.sh14) AT=36.6277778
.meas tran sh69_34 FIND V(xslp.sh69) AT=36.6277778
.meas tran bi0_curr_34 FIND V(xbi0.curr_node) AT=36.6277778
.meas tran bi0_prev_34 FIND V(xbi0.prev_node) AT=36.6277778
.meas tran bi1_curr_34 FIND V(xbi1.curr_node) AT=36.6277778
.meas tran bi1_prev_34 FIND V(xbi1.prev_node) AT=36.6277778
.meas tran ecg_at_f8cap_34 FIND V(ecg_l0) WHEN V(rpeak_pulse_delayed)=0.45 FALL=1 TD=36.4777778
.meas tran pw_shb_34 FIND V(xpw.shb) AT=36.6277778
.meas tran pw_shp_34 FIND V(xpw.shp) AT=36.6277778
.meas tran tpwb_fall_34 WHEN V(trig_pw_base)=0.45 FALL=1 TD=36.2277778
.meas tran tpwp_fall_34 WHEN V(trig_pw_peak)=0.45 FALL=1 TD=36.2277778
.meas tran rpk_amp_5 MAX V(rpeak_pulse) FROM=6.3578667 TO=6.3648667
.meas tran rpk_raw_5 MAX V(rpeak_pulse_raw) FROM=6.3578667 TO=6.3648667
.meas tran ecg_at_rpk_5 FIND V(ecg_l0) AT=6.3601667
.meas tran sh_sym_5 FIND V(f8_symmetry) AT=6.3648667
.meas tran bi_out_5 FIND V(f3_bi_l0) AT=6.4666667
.meas tran ecg_at_s14_5 FIND V(ecg_l0) AT=6.3806667
.meas tran rpk_amp_6 MAX V(rpeak_pulse) FROM=7.0550889 TO=7.0620889
.meas tran rpk_raw_6 MAX V(rpeak_pulse_raw) FROM=7.0550889 TO=7.0620889
.meas tran ecg_at_rpk_6 FIND V(ecg_l0) AT=7.0573889
.meas tran sh_sym_6 FIND V(f8_symmetry) AT=7.0620889
.meas tran bi_out_6 FIND V(f3_bi_l0) AT=7.1638889
.meas tran ecg_at_s14_6 FIND V(ecg_l0) AT=7.0778889
.meas tran rpk_amp_7 MAX V(rpeak_pulse) FROM=8.4939778 TO=8.5009778
.meas tran rpk_raw_7 MAX V(rpeak_pulse_raw) FROM=8.4939778 TO=8.5009778
.meas tran ecg_at_rpk_7 FIND V(ecg_l0) AT=8.4962778
.meas tran sh_sym_7 FIND V(f8_symmetry) AT=8.5009778
.meas tran bi_out_7 FIND V(f3_bi_l0) AT=8.6027778
.meas tran ecg_at_s14_7 FIND V(ecg_l0) AT=8.5167778
.meas tran rpk_amp_8 MAX V(rpeak_pulse) FROM=9.1773111 TO=9.1843111
.meas tran rpk_raw_8 MAX V(rpeak_pulse_raw) FROM=9.1773111 TO=9.1843111
.meas tran ecg_at_rpk_8 FIND V(ecg_l0) AT=9.1796111
.meas tran sh_sym_8 FIND V(f8_symmetry) AT=9.1843111
.meas tran bi_out_8 FIND V(f3_bi_l0) AT=9.2861111
.meas tran ecg_at_s14_8 FIND V(ecg_l0) AT=9.2001111
.meas tran rpk_amp_9 MAX V(rpeak_pulse) FROM=10.5662000 TO=10.5732000
.meas tran rpk_raw_9 MAX V(rpeak_pulse_raw) FROM=10.5662000 TO=10.5732000
.meas tran ecg_at_rpk_9 FIND V(ecg_l0) AT=10.5685000
.meas tran sh_sym_9 FIND V(f8_symmetry) AT=10.5732000
.meas tran bi_out_9 FIND V(f3_bi_l0) AT=10.6750000
.meas tran ecg_at_s14_9 FIND V(ecg_l0) AT=10.5890000
.meas tran rpk_amp_10 MAX V(rpeak_pulse) FROM=11.2189778 TO=11.2259778
.meas tran rpk_raw_10 MAX V(rpeak_pulse_raw) FROM=11.2189778 TO=11.2259778
.meas tran ecg_at_rpk_10 FIND V(ecg_l0) AT=11.2212778
.meas tran sh_sym_10 FIND V(f8_symmetry) AT=11.2259778
.meas tran bi_out_10 FIND V(f3_bi_l0) AT=11.3277778
.meas tran ecg_at_s14_10 FIND V(ecg_l0) AT=11.2417778
.meas tran rpk_amp_11 MAX V(rpeak_pulse) FROM=12.7328667 TO=12.7398667
.meas tran rpk_raw_11 MAX V(rpeak_pulse_raw) FROM=12.7328667 TO=12.7398667
.meas tran ecg_at_rpk_11 FIND V(ecg_l0) AT=12.7351667
.meas tran sh_sym_11 FIND V(f8_symmetry) AT=12.7398667
.meas tran bi_out_11 FIND V(f3_bi_l0) AT=12.8416667
.meas tran ecg_at_s14_11 FIND V(ecg_l0) AT=12.7556667
.meas tran rpk_amp_12 MAX V(rpeak_pulse) FROM=13.4328667 TO=13.4398667
.meas tran rpk_raw_12 MAX V(rpeak_pulse_raw) FROM=13.4328667 TO=13.4398667
.meas tran ecg_at_rpk_12 FIND V(ecg_l0) AT=13.4351667
.meas tran sh_sym_12 FIND V(f8_symmetry) AT=13.4398667
.meas tran bi_out_12 FIND V(f3_bi_l0) AT=13.5416667
.meas tran ecg_at_s14_12 FIND V(ecg_l0) AT=13.4556667
.meas tran rpk_amp_13 MAX V(rpeak_pulse) FROM=14.8773111 TO=14.8843111
.meas tran rpk_raw_13 MAX V(rpeak_pulse_raw) FROM=14.8773111 TO=14.8843111
.meas tran ecg_at_rpk_13 FIND V(ecg_l0) AT=14.8796111
.meas tran sh_sym_13 FIND V(f8_symmetry) AT=14.8843111
.meas tran bi_out_13 FIND V(f3_bi_l0) AT=14.9861111
.meas tran ecg_at_s14_13 FIND V(ecg_l0) AT=14.9001111
.meas tran rpk_amp_14 MAX V(rpeak_pulse) FROM=15.5412000 TO=15.5482000
.meas tran rpk_raw_14 MAX V(rpeak_pulse_raw) FROM=15.5412000 TO=15.5482000
.meas tran ecg_at_rpk_14 FIND V(ecg_l0) AT=15.5435000
.meas tran sh_sym_14 FIND V(f8_symmetry) AT=15.5482000
.meas tran bi_out_14 FIND V(f3_bi_l0) AT=15.6500000
.meas tran ecg_at_s14_14 FIND V(ecg_l0) AT=15.5640000

.end
