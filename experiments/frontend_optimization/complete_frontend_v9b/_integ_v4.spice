Integration test v4 - vbias=0.3V matching calibration
.lib "C:\Users\kadhi\OneDrive\Desktop\amux\verilogLearning\Leaky-Integrate-Fire---SNN-model-on-FPGA\experiments\frontend_optimization\ngspice_frontend\sky130_minimal.lib.spice" tt
.option scale=1.0u method=gear gmin=1e-15
.temp 27

.include "rpeak_detector.spice"
.include "inverter.spice"
.include "delay_timer.spice"
.include "rr_timing.spice"
.include "pwave_predictor.spice"
.include "beat_instability.spice"
.include "pwave_diff.spice"
.include "qrs_width.spice"
.include "qrs_slope.spice"
.include "qrs_symmetry.spice"

Vdd vdd 0 0.9
Vss vss 0 0

* Bias matching delay timer calibration
Vbias vbias 0 0.3
Vref vref 0 0.30

* Amplified ECG (bypassing IA)
Vecg_l0 ecg_amp_l0 0 PWL(
+ 0.000000 0.249962
+ 0.002778 0.208056
+ 0.005556 0.359998
+ 0.008333 0.249962
+ 0.011111 0.199246
+ 0.013889 0.359993
+ 0.016667 0.249962
+ 0.019444 0.202998
+ 0.022222 0.359963
+ 0.025000 0.256248
+ 0.027778 0.208081
+ 0.030556 0.360012
+ 0.033333 0.248705
+ 0.036111 0.205532
+ 0.038889 0.360002
+ 0.041667 0.254991
+ 0.044444 0.205542
+ 0.047222 0.359988
+ 0.050000 0.249962
+ 0.052778 0.205547
+ 0.055556 0.359988
+ 0.058333 0.246190
+ 0.061111 0.199241
+ 0.063889 0.359988
+ 0.066667 0.248705
+ 0.069444 0.203008
+ 0.072222 0.359978
+ 0.075000 0.247448
+ 0.077778 0.206789
+ 0.080556 0.359993
+ 0.083333 0.246190
+ 0.086111 0.205517
+ 0.088889 0.360002
+ 0.091667 0.246190
+ 0.094444 0.210561
+ 0.097222 0.360002
+ 0.100000 0.247448
+ 0.102778 0.205537
+ 0.105556 0.360002
+ 0.108333 0.242419
+ 0.111111 0.205508
+ 0.113889 0.359993
+ 0.116667 0.249962
+ 0.119444 0.201751
+ 0.122222 0.359978
+ 0.125000 0.243676
+ 0.127778 0.206775
+ 0.130556 0.359993
+ 0.133333 0.241161
+ 0.136111 0.202964
+ 0.138889 0.359988
+ 0.141667 0.242419
+ 0.144444 0.205508
+ 0.147222 0.359993
+ 0.150000 0.243676
+ 0.152778 0.209284
+ 0.155556 0.360007
+ 0.158333 0.238647
+ 0.161111 0.205488
+ 0.163889 0.359988
+ 0.166667 0.243676
+ 0.169444 0.208022
+ 0.172222 0.359993
+ 0.175000 0.246190
+ 0.177778 0.209289
+ 0.180556 0.360017
+ 0.183333 0.238647
+ 0.186111 0.218060
+ 0.188889 0.360047
+ 0.191667 0.246190
+ 0.194444 0.221866
+ 0.197222 0.360047
+ 0.200000 0.249962
+ 0.202778 0.229434
+ 0.205556 0.360096
+ 0.208333 0.251219
+ 0.211111 0.229429
+ 0.213889 0.360096
+ 0.216667 0.256248
+ 0.219444 0.225662
+ 0.222222 0.360061
+ 0.225000 0.253734
+ 0.227778 0.231958
+ 0.230556 0.360076
+ 0.233333 0.252476
+ 0.236111 0.220634
+ 0.238889 0.360056
+ 0.241667 0.249962
+ 0.244444 0.228152
+ 0.247222 0.360066
+ 0.250000 0.247448
+ 0.252778 0.216857
+ 0.255556 0.360032
+ 0.258333 0.246190
+ 0.261111 0.204231
+ 0.263889 0.359988
+ 0.266667 0.243676
+ 0.269444 0.202993
+ 0.272222 0.359983
+ 0.275000 0.242419
+ 0.277778 0.201731
+ 0.280556 0.359978
+ 0.283333 0.238647
+ 0.286111 0.194163
+ 0.288889 0.359953
+ 0.291667 0.241161
+ 0.294444 0.195430
+ 0.297222 0.359939
+ 0.300000 0.239904
+ 0.302778 0.196697
+ 0.305556 0.359958
+ 0.308333 0.231104
+ 0.311111 0.185324
+ 0.313889 0.359899
+ 0.316667 0.216017
+ 0.319444 0.165154
+ 0.322222 0.359786
+ 0.325000 0.266306
+ 0.327778 0.190598
+ 0.330556 0.380162
+ 0.333333 0.334274
+ 0.336111 0.350549
+ 0.338889 0.380938
+ 0.341667 0.432341
+ 0.344444 0.196093
+ 0.347222 0.361122
+ 0.350000 0.213508
+ 0.352778 0.278244
+ 0.355556 0.360066
+ 0.358333 0.210988
+ 0.361111 0.157645
+ 0.363889 0.359821
+ 0.366667 0.228589
+ 0.369444 0.182814
+ 0.372222 0.359904
+ 0.375000 0.228589
+ 0.377778 0.192891
+ 0.380556 0.359944
+ 0.383333 0.228589
+ 0.386111 0.189100
+ 0.388889 0.359934
+ 0.391667 0.229847
+ 0.394444 0.185343
+ 0.397222 0.359904
+ 0.400000 0.232361
+ 0.402778 0.187862
+ 0.405556 0.359924
+ 0.408333 0.229847
+ 0.411111 0.185338
+ 0.413889 0.359929
+ 0.416667 0.234875
+ 0.419444 0.189125
+ 0.422222 0.359909
+ 0.425000 0.232361
+ 0.427778 0.186610
+ 0.430556 0.359919
+ 0.433333 0.231104
+ 0.436111 0.186605
+ 0.438889 0.359924
+ 0.441667 0.236133
+ 0.444444 0.187872
+ 0.447222 0.359914
+ 0.450000 0.233618
+ 0.452778 0.189149
+ 0.455556 0.359924
+ 0.458333 0.234875
+ 0.461111 0.187858
+ 0.463889 0.359924
+ 0.466667 0.234875
+ 0.469444 0.187862
+ 0.472222 0.359899
+ 0.475000 0.231104
+ 0.477778 0.187872
+ 0.480556 0.359924
+ 0.483333 0.228589
+ 0.486111 0.186595
+ 0.488889 0.359924
+ 0.491667 0.226075
+ 0.494444 0.189100
+ 0.497222 0.359929
+ 0.500000 0.227332
+ 0.502778 0.194153
+ 0.505556 0.359939
+ 0.508333 0.227332
+ 0.511111 0.187828
+ 0.513889 0.359948
+ 0.516667 0.231104
+ 0.519444 0.194134
+ 0.522222 0.359924
+ 0.525000 0.219789
+ 0.527778 0.191590
+ 0.530556 0.359924
+ 0.533333 0.213503
+ 0.536111 0.180236
+ 0.538889 0.359904
+ 0.541667 0.207217
+ 0.544444 0.178969
+ 0.547222 0.359870
+ 0.550000 0.200931
+ 0.552778 0.172653
+ 0.555556 0.359855
+ 0.558333 0.194645
+ 0.561111 0.170114
+ 0.563889 0.359870
+ 0.566667 0.197159
+ 0.569444 0.170114
+ 0.572222 0.359855
+ 0.575000 0.199673
+ 0.577778 0.180216
+ 0.580556 0.359894
+ 0.583333 0.208474
+ 0.586111 0.185265
+ 0.588889 0.359924
+ 0.591667 0.224818
+ 0.594444 0.192872
+ 0.597222 0.359953
+ 0.600000 0.236133
+ 0.602778 0.206760
+ 0.605556 0.360002
+ 0.608333 0.239904
+ 0.611111 0.210527
+ 0.613889 0.360022
+ 0.616667 0.249962
+ 0.619444 0.215585
+ 0.622222 0.360037
+ 0.625000 0.247448
+ 0.627778 0.219371
+ 0.630556 0.360047
+ 0.633333 0.248705
+ 0.636111 0.218099
+ 0.638889 0.360037
+ 0.641667 0.247448
+ 0.644444 0.214333
+ 0.647222 0.360027
+ 0.650000 0.252476
+ 0.652778 0.218114
+ 0.655556 0.360037
+ 0.658333 0.246190
+ 0.661111 0.214323
+ 0.663889 0.360027
+ 0.666667 0.249962
+ 0.669444 0.213071
+ 0.672222 0.360017
+ 0.675000 0.246190
+ 0.677778 0.215585
+ 0.680556 0.360032
+ 0.683333 0.243676
+ 0.686111 0.214308
+ 0.688889 0.360027
+ 0.691667 0.246190
+ 0.694444 0.214308
+ 0.697222 0.360002
+ 0.700000 0.242419
+ 0.702778 0.211799
+ 0.705556 0.360007
+ 0.708333 0.242419
+ 0.711111 0.206745
+ 0.713889 0.360007
+ 0.716667 0.244933
+ 0.719444 0.209279
+ 0.722222 0.359998
+ 0.725000 0.246190
+ 0.727778 0.213071
+ 0.730556 0.360017
+ 0.733333 0.239904
+ 0.736111 0.208012
+ 0.738889 0.360012
+ 0.741667 0.241161
+ 0.744444 0.205503
+ 0.747222 0.359998
+ 0.750000 0.241161
+ 0.752778 0.209284
+ 0.755556 0.360002
+ 0.758333 0.241161
+ 0.761111 0.202983
+ 0.763889 0.360007
+ 0.766667 0.244933
+ 0.769444 0.206760
+ 0.772222 0.359988
+ 0.775000 0.246190
+ 0.777778 0.209284
+ 0.780556 0.360002
+ 0.783333 0.239904
+ 0.786111 0.208012
+ 0.788889 0.359998
+ 0.791667 0.246190
+ 0.794444 0.206770
+ 0.797222 0.359998
+ 0.800000 0.246190
+ 0.802778 0.210556
+ 0.805556 0.360007
+ 0.808333 0.244933
+ 0.811111 0.208027
+ 0.813889 0.360022
+ 0.816667 0.244933
+ 0.819444 0.221866
+ 0.822222 0.360047
+ 0.825000 0.249962
+ 0.827778 0.224410
+ 0.830556 0.360076
+ 0.833333 0.248705
+ 0.836111 0.229419
+ 0.838889 0.360091
+ 0.841667 0.256248
+ 0.844444 0.231944
+ 0.847222 0.360086
+ 0.850000 0.258762
+ 0.852778 0.233240
+ 0.855556 0.360091
+ 0.858333 0.261277
+ 0.861111 0.226944
+ 0.863889 0.360066
+ 0.866667 0.262534
+ 0.869444 0.234478
+ 0.872222 0.360106
+ 0.875000 0.253734
+ 0.877778 0.223158
+ 0.880556 0.360052
+ 0.883333 0.249962
+ 0.886111 0.206775
+ 0.888889 0.360002
+ 0.891667 0.251219
+ 0.894444 0.201756
+ 0.897222 0.359968
+ 0.900000 0.251219
+ 0.902778 0.208042
+ 0.905556 0.359993
+ 0.908333 0.241161
+ 0.911111 0.202983
+ 0.913889 0.359988
+ 0.916667 0.247448
+ 0.919444 0.202998
+ 0.922222 0.359968
+ 0.925000 0.244933
+ 0.927778 0.205532
+ 0.930556 0.359973
+ 0.933333 0.243676
+ 0.936111 0.196702
+ 0.938889 0.359968
+ 0.941667 0.236133
+ 0.944444 0.189110
+ 0.947222 0.359890
+ 0.950000 0.213503
+ 0.952778 0.162649
+ 0.955556 0.359796
+ 0.958333 0.281392
+ 0.961111 0.191929
+ 0.963889 0.380211
+ 0.966667 0.382048
+ 0.969444 0.384670
+ 0.972222 0.381051
+ 0.975000 0.426055
+ 0.977778 0.182092
+ 0.980556 0.360916
+ 0.983333 0.210993
+ 0.986111 0.182799
+ 0.988889 0.359831
+ 0.991667 0.236133
+ 0.994444 0.186640
+ 0.997222 0.359939
+ 1.000000 0.234875
+ 1.002778 0.195421
+ 1.005556 0.359958
+ 1.008333 0.231104
+ 1.011111 0.186605
+ 1.013889 0.359939
+ 1.016667 0.237390
+ 1.019444 0.191634
+ 1.022222 0.359924
+ 1.025000 0.237390
+ 1.027778 0.194173
+ 1.030556 0.359934
+ 1.033333 0.237390
+ 1.036111 0.195416
+ 1.038889 0.359958
+ 1.041667 0.241161
+ 1.044444 0.195430
+ 1.047222 0.359953
+ 1.050000 0.238647
+ 1.052778 0.195450
+ 1.055556 0.359953
+ 1.058333 0.237390
+ 1.061111 0.196678
+ 1.063889 0.359944
+ 1.066667 0.239904
+ 1.069444 0.194168
+ 1.072222 0.359944
+ 1.075000 0.241161
+ 1.077778 0.195440
+ 1.080556 0.359958
+ 1.083333 0.236133
+ 1.086111 0.194163
+ 1.088889 0.359939
+ 1.091667 0.238647
+ 1.094444 0.194173
+ 1.097222 0.359944
+ 1.100000 0.234875
+ 1.102778 0.196688
+ 1.105556 0.359948
+ 1.108333 0.237390
+ 1.111111 0.196668
+ 1.113889 0.359963
+ 1.116667 0.236133
+ 1.119444 0.196668
+ 1.122222 0.359934
+ 1.125000 0.234875
+ 1.127778 0.195416
+ 1.130556 0.359953
+ 1.133333 0.227332
+ 1.136111 0.192872
+ 1.138889 0.359958
+ 1.141667 0.224818
+ 1.144444 0.191590
+ 1.147222 0.359919
+ 1.150000 0.217274
+ 1.152778 0.195352
+ 1.155556 0.359948
+ 1.158333 0.212246
+ 1.161111 0.189021
+ 1.163889 0.359944
+ 1.166667 0.207217
+ 1.169444 0.191536
+ 1.172222 0.359929
+ 1.175000 0.205959
+ 1.177778 0.192808
+ 1.180556 0.359944
+ 1.183333 0.202188
+ 1.186111 0.189012
+ 1.188889 0.359934
+ 1.191667 0.216017
+ 1.194444 0.192837
+ 1.197222 0.359944
+ 1.200000 0.227332
+ 1.202778 0.205473
+ 1.205556 0.360002
+ 1.208333 0.239904
+ 1.211111 0.211799
+ 1.213889 0.360032
+ 1.216667 0.249962
+ 1.219444 0.216842
+ 1.222222 0.360032
+ 1.225000 0.249962
+ 1.227778 0.221881
+ 1.230556 0.360061
+ 1.233333 0.251219
+ 1.236111 0.224400
+ 1.238889 0.360066
+ 1.241667 0.254991
+ 1.244444 0.225667
+ 1.247222 0.360056
+ 1.250000 0.254991
+ 1.252778 0.226939
+ 1.255556 0.360066
+ 1.258333 0.253734
+ 1.261111 0.221881
+ 1.263889 0.360066
+ 1.266667 0.256248
+ 1.269444 0.220638
+ 1.272222 0.360042
+ 1.275000 0.252476
+ 1.277778 0.223153
+ 1.280556 0.360066
+ 1.283333 0.251219
+ 1.286111 0.220619
+ 1.288889 0.360056
+ 1.291667 0.252476
+ 1.294444 0.219357
+ 1.297222 0.360032
+ 1.300000 0.251219
+ 1.302778 0.220629
+ 1.305556 0.360042
+ 1.308333 0.244933
+ 1.311111 0.213061
+ 1.313889 0.360042
+ 1.316667 0.249962
+ 1.319444 0.214328
+ 1.322222 0.360007
+ 1.325000 0.247448
+ 1.327778 0.215585
+ 1.330556 0.360017
+ 1.333333 0.243676
+ 1.336111 0.210527
+ 1.338889 0.360032
+ 1.341667 0.248705
+ 1.344444 0.210541
+ 1.347222 0.360012
+ 1.350000 0.243676
+ 1.352778 0.213066
+ 1.355556 0.360012
+ 1.358333 0.243676
+ 1.361111 0.209284
+ 1.363889 0.360017
+ 1.366667 0.248705
+ 1.369444 0.210556
+ 1.372222 0.360007
+ 1.375000 0.249962
+ 1.377778 0.214333
+ 1.380556 0.360027
+ 1.383333 0.244933
+ 1.386111 0.210546
+ 1.388889 0.360032
+ 1.391667 0.248705
+ 1.394444 0.211808
+ 1.397222 0.360017
+ 1.400000 0.248705
+ 1.402778 0.216867
+ 1.405556 0.360032
+ 1.408333 0.247448
+ 1.411111 0.211808
+ 1.413889 0.360032
+ 1.416667 0.254991
+ 1.419444 0.215600
+ 1.422222 0.360012
+ 1.425000 0.249962
+ 1.427778 0.218109
+ 1.430556 0.360042
+ 1.433333 0.246190
+ 1.436111 0.225628
+ 1.438889 0.360096
+ 1.441667 0.251219
+ 1.444444 0.231934
+ 1.447222 0.360091
+ 1.450000 0.256248
+ 1.452778 0.238264
+ 1.455556 0.360120
+ 1.458333 0.254991
+ 1.461111 0.239497
+ 1.463889 0.360120
+ 1.466667 0.265048
+ 1.469444 0.234497
+ 1.472222 0.360096
+ 1.475000 0.263791
+ 1.477778 0.234512
+ 1.480556 0.360115
+ 1.483333 0.258762
+ 1.486111 0.247045
+ 1.488889 0.360130
+ 1.491667 0.258762
+ 1.494444 0.228192
+ 1.497222 0.360061
+ 1.500000 0.254991
+ 1.502778 0.219391
+ 1.505556 0.360032
+ 1.508333 0.249962
+ 1.511111 0.208042
+ 1.513889 0.360017
+ 1.516667 0.251219
+ 1.519444 0.210551
+ 1.522222 0.360002
+ 1.525000 0.249962
+ 1.527778 0.211823
+ 1.530556 0.360007
+ 1.533333 0.247448
+ 1.536111 0.208056
+ 1.538889 0.360007
+ 1.541667 0.249962
+ 1.544444 0.211813
+ 1.547222 0.359998
+ 1.550000 0.244933
+ 1.552778 0.206745
+ 1.555556 0.359958
+ 1.558333 0.212246
+ 1.561111 0.168916
+ 1.563889 0.359831
+ 1.566667 0.278878
+ 1.569444 0.195720
+ 1.572222 0.380211
+ 1.575000 0.399649
+ 1.577778 0.402379
+ 1.580556 0.381134
+ 1.583333 0.434856
+ 1.586111 0.173228
+ 1.588889 0.360808
+ 1.591667 0.234880
+ 1.594444 0.177839
+ 1.597222 0.359870
+ 1.600000 0.239904
+ 1.602778 0.206760
+ 1.605556 0.359988
+ 1.608333 0.236133
+ 1.611111 0.200454
+ 1.613889 0.359983
+ 1.616667 0.241161
+ 1.619444 0.199202
+ 1.622222 0.359958
+ 1.625000 0.237390
+ 1.627778 0.199197
+ 1.630556 0.359978
+ 1.633333 0.234875
+ 1.636111 0.194163
+ 1.638889 0.359963
+ 1.641667 0.237390
+ 1.644444 0.197925
+ 1.647222 0.359944
+ 1.650000 0.239904
+ 1.652778 0.199207
+ 1.655556 0.359968
+ 1.658333 0.233618
+ 1.661111 0.196688
+ 1.663889 0.359973
+ 1.666667 0.242419
+ 1.669444 0.199207
+ 1.672222 0.359953
+ 1.675000 0.238647
+ 1.677778 0.201731
+ 1.680556 0.359973
+ 1.683333 0.238647
+ 1.686111 0.199202
+ 1.688889 0.359978
+ 1.691667 0.241161
+ 1.694444 0.199192
+ 1.697222 0.359958
+ 1.700000 0.236133
+ 1.702778 0.202979
+ 1.705556 0.359978
+ 1.708333 0.233618
+ 1.711111 0.201697
+ 1.713889 0.359983
+ 1.716667 0.239904
+ 1.719444 0.200440
+ 1.722222 0.359978
+ 1.725000 0.231104
+ 1.727778 0.204216
+ 1.730556 0.359983
+ 1.733333 0.226075
+ 1.736111 0.200400
+ 1.738889 0.359978
+ 1.741667 0.222303
+ 1.744444 0.201643
+ 1.747222 0.359973
+ 1.750000 0.217274
+ 1.752778 0.202885
+ 1.755556 0.359978
+ 1.758333 0.207217
+ 1.761111 0.200341
+ 1.763889 0.359973
+ 1.766667 0.207217
+ 1.769444 0.197812
+ 1.772222 0.359958
+ 1.775000 0.204702
+ 1.777778 0.201599
+ 1.780556 0.359978
+ 1.783333 0.205959
+ 1.786111 0.197827
+ 1.788889 0.359983
+ 1.791667 0.219789
+ 1.794444 0.201657
+ 1.797222 0.359968
+ 1.800000 0.228589
+ 1.802778 0.214284
+ 1.805556 0.360027
+ 1.808333 0.233618
+ 1.811111 0.214289
+ 1.813889 0.360037
+ 1.816667 0.249962
+ 1.819444 0.220619
+ 1.822222 0.360052
+ 1.825000 0.253734
+ 1.827778 0.229459
+ 1.830556 0.360091
+ 1.833333 0.254991
+ 1.836111 0.229444
+ 1.838889 0.360096
+ 1.841667 0.257505
+ 1.844444 0.225662
+ 1.847222 0.360066
+ 1.850000 0.258762
+ 1.852778 0.228196
+ 1.855556 0.360081
+ 1.858333 0.252476
+ 1.861111 0.225657
+ 1.863889 0.360076
+ 1.866667 0.258762
+ 1.869444 0.226929
+ 1.872222 0.360061
+ 1.875000 0.253734
+ 1.877778 0.226934
+ 1.880556 0.360081
+ 1.883333 0.252476
+ 1.886111 0.225653
+ 1.888889 0.360081
+ 1.891667 0.253734
+ 1.894444 0.224395
+ 1.897222 0.360052
+ 1.900000 0.253734
+ 1.902778 0.221896
+ 1.905556 0.360052
+ 1.908333 0.246190
+ 1.911111 0.221871
+ 1.913889 0.360061
+ 1.916667 0.251219
+ 1.919444 0.218114
+ 1.922222 0.360032
+ 1.925000 0.248705
+ 1.927778 0.220619
+ 1.930556 0.360047
+ 1.933333 0.247448
+ 1.936111 0.215585
+ 1.938889 0.360047
+ 1.941667 0.248705
+ 1.944444 0.216842
+ 1.947222 0.360027
+ 1.950000 0.246190
+ 1.952778 0.220634
+ 1.955556 0.360047
+ 1.958333 0.247448
+ 1.961111 0.216832
+ 1.963889 0.360037
+ 1.966667 0.251219
+ 1.969444 0.214347
+ 1.972222 0.360032
+ 1.975000 0.249962
+ 1.977778 0.219386
+ 1.980556 0.360032
+ 1.983333 0.249962
+ 1.986111 0.218099
+ 1.988889 0.360047
+ 1.991667 0.254991
+ 1.994444 0.223148
+ 1.997222 0.360047
+ 2.000000 0.253734
+ 2.002778 0.220648
+ 2.005556 0.360042
+ 2.008333 0.252476
+ 2.011111 0.218109
+ 2.013889 0.360056
+ 2.016667 0.257505
+ 2.019444 0.216872
+ 2.022222 0.360042
+ 2.025000 0.254991
+ 2.027778 0.235725
+ 2.030556 0.360096
+ 2.033333 0.251219
+ 2.036111 0.239497
+ 2.038889 0.360125
+ 2.041667 0.258762
+ 2.044444 0.245802
+ 2.047222 0.360155
+ 2.050000 0.263791
+ 2.052778 0.252113
+ 2.055556 0.360169
+ 2.058333 0.262534
+ 2.061111 0.243322
+ 2.063889 0.360140
+ 2.066667 0.271335
+ 2.069444 0.242075
+ 2.072222 0.360125
+ 2.075000 0.265048
+ 2.077778 0.253365
+ 2.080556 0.360165
+ 2.083333 0.263791
+ 2.086111 0.231973
+ 2.088889 0.360081
+ 2.091667 0.257505
+ 2.094444 0.220648
+ 2.097222 0.360052
+ 2.100000 0.258762
+ 2.102778 0.220658
+ 2.105556 0.360056
+ 2.108333 0.254991
+ 2.111111 0.218119
+ 2.113889 0.360042
+ 2.116667 0.256248
+ 2.119444 0.219386
+ 2.122222 0.360037
+ 2.125000 0.254991
+ 2.127778 0.215614
+ 2.130556 0.360032
+ 2.133333 0.252476
+ 2.136111 0.211833
+ 2.138889 0.360027
+ 2.141667 0.252476
+ 2.144444 0.209294
+ 2.147222 0.359983
+ 2.150000 0.227332
+ 2.152778 0.184061
+ 2.155556 0.359890
+ 2.158333 0.244933
+ 2.161111 0.174205
+ 2.163889 0.380098
+ 2.166667 0.349360
+ 2.169444 0.321687
+ 2.172222 0.380830
+ 2.175000 0.441142
+ 2.177778 0.191079
+ 2.180556 0.361068
+ 2.183333 0.223565
+ 2.186111 0.228093
+ 2.188889 0.359924
+ 2.191667 0.247448
+ 2.194444 0.199236
+ 2.197222 0.359988
+ 2.200000 0.248705
+ 2.202778 0.209309
+ 2.205556 0.360002
+ 2.208333 0.243676
+ 2.211111 0.209279
+ 2.213889 0.360012
+ 2.216667 0.248705
+ 2.219444 0.211808
+ 2.222222 0.359998
+ 2.225000 0.244933
+ 2.227778 0.211808
+ 2.230556 0.360012
+ 2.233333 0.242419
+ 2.236111 0.205503
+ 2.238889 0.359988
+ 2.241667 0.247448
+ 2.244444 0.204260
+ 2.247222 0.359993
+ 2.250000 0.246190
+ 2.252778 0.208042
+ 2.255556 0.359998
+ 2.258333 0.244933
+ 2.261111 0.211794
+ 2.263889 0.360017
+ 2.266667 0.248705
+ 2.269444 0.208032
+ 2.272222 0.360002
+ 2.275000 0.247448
+ 2.277778 0.209299
+ 2.280556 0.359998
+ 2.283333 0.243676
+ 2.286111 0.206770
+ 2.288889 0.360002
+ 2.291667 0.246190
+ 2.294444 0.204246
+ 2.297222 0.359983
+ 2.300000 0.243676
+ 2.302778 0.209294
+ 2.305556 0.360007
+ 2.308333 0.239904
+ 2.311111 0.211784
+ 2.313889 0.360027
+ 2.316667 0.239904
+ 2.319444 0.207998
+ 2.322222 0.360002
+ 2.325000 0.234875
+ 2.327778 0.205488
+ 2.330556 0.360002
+ 2.333333 0.232361
+ 2.336111 0.209225
+ 2.338889 0.360007
+ 2.341667 0.229847
+ 2.344444 0.209201
+ 2.347222 0.359998
+ 2.350000 0.223560
+ 2.352778 0.211720
+ 2.355556 0.360002
+ 2.358333 0.216017
+ 2.361111 0.199109
+ 2.363889 0.359998
+ 2.366667 0.217274
+ 2.369444 0.202880
+ 2.372222 0.359968
+ 2.375000 0.214760
+ 2.377778 0.207929
+ 2.380556 0.360007
+ 2.383333 0.223560
+ 2.386111 0.205434
+ 2.388889 0.360007
+ 2.391667 0.236133
+ 2.394444 0.213031
+ 2.397222 0.360017
+ 2.400000 0.247448
+ 2.402778 0.224390
+ 2.405556 0.360061
+ 2.408333 0.246190
+ 2.411111 0.225648
+ 2.413889 0.360076
+ 2.416667 0.252476
+ 2.419444 0.228172
+ 2.422222 0.360086
+ 2.425000 0.252476
+ 2.427778 0.234473
+ 2.430556 0.360106
+ 2.433333 0.249962
+ 2.436111 0.230681
+ 2.438889 0.360096
+ 2.441667 0.252476
+ 2.444444 0.231939
+ 2.447222 0.360076
+ 2.450000 0.251219
+ 2.452778 0.228177
+ 2.455556 0.360076
+ 2.458333 0.248705
+ 2.461111 0.225643
+ 2.463889 0.360076
+ 2.466667 0.248705
+ 2.469444 0.225643
+ 2.472222 0.360061
+ 2.475000 0.246190
+ 2.477778 0.226915
+ 2.480556 0.360061
+ 2.483333 0.247448
+ 2.486111 0.225628
+ 2.488889 0.360066
+ 2.491667 0.244933
+ 2.494444 0.221851
+ 2.497222 0.360047
+ 2.500000 0.243676
+ 2.502778 0.219337
+ 2.505556 0.360037
+ 2.508333 0.238647
+ 2.511111 0.218070
+ 2.513889 0.360052
+ 2.516667 0.243676
+ 2.519444 0.215556
+ 2.522222 0.360027
+ 2.525000 0.242419
+ 2.527778 0.218085
+ 2.530556 0.360042
+ 2.533333 0.239904
+ 2.536111 0.216803
+ 2.538889 0.360047
+ 2.541667 0.246190
+ 2.544444 0.215556
+ 2.547222 0.360027
+ 2.550000 0.239904
+ 2.552778 0.219337
+ 2.555556 0.360047
+ 2.558333 0.234875
+ 2.561111 0.220565
+ 2.563889 0.360042
+ 2.566667 0.243676
+ 2.569444 0.218080
+ 2.572222 0.360032
+ 2.575000 0.239904
+ 2.577778 0.221851
+ 2.580556 0.360052
+ 2.583333 0.238647
+ 2.586111 0.214289
+ 2.588889 0.360047
+ 2.591667 0.239904
+ 2.594444 0.216798
+ 2.597222 0.360027
+ 2.600000 0.238647
+ 2.602778 0.225618
+ 2.605556 0.360091
+ 2.608333 0.236133
+ 2.611111 0.230618
+ 2.613889 0.360101
+ 2.616667 0.246190
+ 2.619444 0.240724
+ 2.622222 0.360115
+ 2.625000 0.249962
+ 2.627778 0.244506
+ 2.630556 0.360140
+ 2.633333 0.249962
+ 2.636111 0.235700
+ 2.638889 0.360120
+ 2.641667 0.251219
+ 2.644444 0.233186
+ 2.647222 0.360086
+ 2.650000 0.248705
+ 2.652778 0.241991
+ 2.655556 0.360135
+ 2.658333 0.241161
+ 2.661111 0.226885
+ 2.663889 0.360076
+ 2.666667 0.238647
+ 2.669444 0.214279
+ 2.672222 0.360012
+ 2.675000 0.239904
+ 2.677778 0.216798
+ 2.680556 0.360042
+ 2.683333 0.234875
+ 2.686111 0.213031
+ 2.688889 0.360027
+ 2.691667 0.237390
+ 2.694444 0.209255
+ 2.697222 0.360002
+ 2.700000 0.233618
+ 2.702778 0.209245
+ 2.705556 0.360002
+ 2.708333 0.231104
+ 2.711111 0.207973
+ 2.713889 0.359998
+ 2.716667 0.234875
+ 2.719444 0.207978
+ 2.722222 0.359988
+ 2.725000 0.217274
+ 2.727778 0.189066
+ 2.730556 0.359914
+ 2.733333 0.210988
+ 2.736111 0.160184
+ 2.738889 0.359865
+ 2.741667 0.297815
+ 2.744444 0.266119
+ 2.747222 0.380545
+ 2.750000 0.384567
+ 2.752778 0.169638
+ 2.755556 0.361166
+ 2.758333 0.221051
+ 2.761111 0.303374
+ 2.763889 0.360096
+ 2.766667 0.218532
+ 2.769444 0.179003
+ 2.772222 0.359919
+ 2.775000 0.224818
+ 2.777778 0.202929
+ 2.780556 0.359978
+ 2.783333 0.222303
+ 2.786111 0.195366
+ 2.788889 0.359973
+ 2.791667 0.222303
+ 2.794444 0.199138
+ 2.797222 0.359968
+ 2.800000 0.223560
+ 2.802778 0.205449
+ 2.805556 0.359973
+ 2.808333 0.223560
+ 2.811111 0.202920
+ 2.813889 0.359983
+ 2.816667 0.226075
+ 2.819444 0.199158
+ 2.822222 0.359963
+ 2.825000 0.224818
+ 2.827778 0.199153
+ 2.830556 0.359958
+ 2.833333 0.221046
+ 2.836111 0.194109
+ 2.838889 0.359963
+ 2.841667 0.228589
+ 2.844444 0.194114
+ 2.847222 0.359948
+ 2.850000 0.223560
+ 2.852778 0.200415
+ 2.855556 0.359963
+ 2.858333 0.222303
+ 2.861111 0.197891
+ 2.863889 0.359963
+ 2.866667 0.224818
+ 2.869444 0.195371
+ 2.872222 0.359948
+ 2.875000 0.221046
+ 2.877778 0.196638
+ 2.880556 0.359963
+ 2.883333 0.221046
+ 2.886111 0.194104
+ 2.888889 0.359963
+ 2.891667 0.221046
+ 2.894444 0.195352
+ 2.897222 0.359953
+ 2.900000 0.218532
+ 2.902778 0.202905
+ 2.905556 0.359973
+ 2.908333 0.214760
+ 2.911111 0.197851
+ 2.913889 0.359973
+ 2.916667 0.216017
+ 2.919444 0.197842
+ 2.922222 0.359963
+ 2.925000 0.209731
+ 2.927778 0.194065
+ 2.930556 0.359939
+ 2.933333 0.199673
+ 2.936111 0.187735
+ 2.938889 0.359929
+ 2.941667 0.193387
+ 2.944444 0.183939
+ 2.947222 0.359890
+ 2.950000 0.190873
+ 2.952778 0.188963
+ 2.955556 0.359919
+ 2.958333 0.188359
+ 2.961111 0.183919
+ 2.963889 0.359929
+ 2.966667 0.197159
+ 2.969444 0.187730
+ 2.972222 0.359924
+ 2.975000 0.207217
+ 2.977778 0.199109
+ 2.980556 0.359978
+ 2.983333 0.218532
+ 2.986111 0.205409
+ 2.988889 0.360002
+ 2.991667 0.236133
+ 2.994444 0.214279
+ 2.997222 0.360032
+ 3.000000 0.236133
+ 3.002778 0.221842
+ 3.005556 0.360052
+ 3.008333 0.238647
+ 3.011111 0.223094
+ 3.013889 0.360061
+ 3.016667 0.241161
+ 3.019444 0.224356
+ 3.022222 0.360061
+ 3.025000 0.241161
+ 3.027778 0.228152
+ 3.030556 0.360081
+ 3.033333 0.243676
+ 3.036111 0.224366
+ 3.038889 0.360076
+ 3.041667 0.243676
+ 3.044444 0.223109
+ 3.047222 0.360047
+ 3.050000 0.242419
+ 3.052778 0.225628
+ 3.055556 0.360061
+ 3.058333 0.239904
+ 3.061111 0.218075
+ 3.063889 0.360056
+ 3.066667 0.246190
+ 3.069444 0.219327
+ 3.072222 0.360047
+ 3.075000 0.242419
+ 3.077778 0.221847
+ 3.080556 0.360047
+ 3.083333 0.238647
+ 3.086111 0.218055
+ 3.088889 0.360042
+ 3.091667 0.241161
+ 3.094444 0.219322
+ 3.097222 0.360042
+ 3.100000 0.243676
+ 3.102778 0.221856
+ 3.105556 0.360052
+ 3.108333 0.234875
+ 3.111111 0.215541
+ 3.113889 0.360032
+ 3.116667 0.238647
+ 3.119444 0.214293
+ 3.122222 0.360017
+ 3.125000 0.238647
+ 3.127778 0.215560
+ 3.130556 0.360042
+ 3.133333 0.238647
+ 3.136111 0.214284
+ 3.138889 0.360042
+ 3.141667 0.239904
+ 3.144444 0.215556
+ 3.147222 0.360022
+ 3.150000 0.241161
+ 3.152778 0.218075
+ 3.155556 0.360047
+ 3.158333 0.238647
+ 3.161111 0.213021
+ 3.163889 0.360022
+ 3.166667 0.238647
+ 3.169444 0.214293
+ 3.172222 0.360017
+ 3.175000 0.239904
+ 3.177778 0.218075
+ 3.180556 0.360037
+ 3.183333 0.239904
+ 3.186111 0.216803
+ 3.188889 0.360042
+ 3.191667 0.241161
+ 3.194444 0.216803
+ 3.197222 0.360032
+ 3.200000 0.238647
+ 3.202778 0.221851
+ 3.205556 0.360056
+ 3.208333 0.239904
+ 3.211111 0.220570
+ 3.213889 0.360071
+ 3.216667 0.238647
+ 3.219444 0.226866
+ 3.222222 0.360076
+ 3.225000 0.246190
+ 3.227778 0.235691
+ 3.230556 0.360115
+ 3.233333 0.244933
+ 3.236111 0.239462
+ 3.238889 0.360135
+ 3.241667 0.252476
+ 3.244444 0.243249
+ 3.247222 0.360135
+ 3.250000 0.252476
+ 3.252778 0.242006
+ 3.255556 0.360130
+ 3.258333 0.248705
+ 3.261111 0.238225
+ 3.263889 0.360110
+ 3.266667 0.257505
+ 3.269444 0.238244
+ 3.272222 0.360096
+ 3.275000 0.252476
+ 3.277778 0.248282
+ 3.280556 0.360145
+ 3.283333 0.246190
+ 3.286111 0.226885
+ 3.288889 0.360071
+ 3.291667 0.244933
+ 3.294444 0.215575
+ 3.297222 0.360037
+ 3.300000 0.244933
+ 3.302778 0.211804
+ 3.305556 0.360032
+ 3.308333 0.241161
+ 3.311111 0.214289
+ 3.313889 0.360027
+ 3.316667 0.243676
+ 3.319444 0.215560
+ 3.322222 0.360032
+ 3.325000 0.241161
+ 3.327778 0.215570
+ 3.330556 0.360022
+ 3.333333 0.238647
+ 3.336111 0.206760
+ 3.338889 0.360022
+ 3.341667 0.242419
+ 3.344444 0.211784
+ 3.347222 0.360002
+ 3.350000 0.234875
+ 3.352778 0.206716
+ 3.355556 0.359968
+ 3.358333 0.210988
+ 3.361111 0.177697
+ 3.363889 0.359870
+ 3.366667 0.251219
+ 3.369444 0.181773
+ 3.372222 0.380142
+ 3.375000 0.374505
+ 3.377778 0.358254
+ 3.380556 0.380967
+ 3.383333 0.460000
+ 3.386111 0.208719
+ 3.388889 0.361166
+ 3.391667 0.226080
+ 3.394444 0.238112
+ 3.397222 0.359929
+ 3.400000 0.231104
+ 3.402778 0.200454
+ 3.405556 0.359993
+ 3.408333 0.231104
+ 3.411111 0.200430
+ 3.413889 0.359998
+ 3.416667 0.232361
+ 3.419444 0.201692
+ 3.422222 0.359968
+ 3.425000 0.232361
+ 3.427778 0.202959
+ 3.430556 0.359983
+ 3.433333 0.231104
+ 3.436111 0.202934
+ 3.438889 0.359978
+ 3.441667 0.231104
+ 3.444444 0.200430
+ 3.447222 0.359978
+ 3.450000 0.232361
+ 3.452778 0.205459
+ 3.455556 0.359998
+ 3.458333 0.231104
+ 3.461111 0.204206
+ 3.463889 0.359998
+ 3.466667 0.237390
+ 3.469444 0.207983
+ 3.472222 0.359993
+ 3.475000 0.233618
+ 3.477778 0.207983
+ 3.480556 0.359998
+ 3.483333 0.232361
+ 3.486111 0.205468
+ 3.488889 0.360002
+ 3.491667 0.234875
+ 3.494444 0.206721
+ 3.497222 0.359983
+ 3.500000 0.234875
+ 3.502778 0.207988
+ 3.505556 0.360007
+ 3.508333 0.229847
+ 3.511111 0.202939
+ 3.513889 0.359998
+ 3.516667 0.232361
+ 3.519444 0.205454
+ 3.522222 0.359983
+ 3.525000 0.224818
+ 3.527778 0.207958
+ 3.530556 0.359998
+ 3.533333 0.222303
+ 3.536111 0.202920
+ 3.538889 0.359988
+ 3.541667 0.221046
+ 3.544444 0.205409
+ 3.547222 0.359993
+ 3.550000 0.214760
+ 3.552778 0.207924
+ 3.555556 0.360007
+ 3.558333 0.207217
+ 3.561111 0.204103
+ 3.563889 0.359998
+ 3.566667 0.207217
+ 3.569444 0.204098
+ 3.572222 0.359973
+ 3.575000 0.199673
+ 3.577778 0.202821
+ 3.580556 0.359978
+ 3.583333 0.195902
+ 3.586111 0.201564
+ 3.588889 0.359968
+ 3.591667 0.198416
+ 3.594444 0.199050
+ 3.597222 0.359968
+ 3.600000 0.210988
+ 3.602778 0.205400
+ 3.605556 0.360002
+ 3.608333 0.217274
+ 3.611111 0.216744
+ 3.613889 0.360056
+ 3.616667 0.238647
+ 3.619444 0.224351
+ 3.622222 0.360061
+ 3.625000 0.243676
+ 3.627778 0.230662
+ 3.630556 0.360096
+ 3.633333 0.247448
+ 3.636111 0.230676
+ 3.638889 0.360101
+ 3.641667 0.254991
+ 3.644444 0.230681
+ 3.647222 0.360086
+ 3.650000 0.252476
+ 3.652778 0.234468
+ 3.655556 0.360110
+ 3.658333 0.249962
+ 3.661111 0.233196
+ 3.663889 0.360101
+ 3.666667 0.252476
+ 3.669444 0.231934
+ 3.672222 0.360086
+ 3.675000 0.252476
+ 3.677778 0.233215
+ 3.680556 0.360106
+ 3.683333 0.251219
+ 3.686111 0.229419
+ 3.688889 0.360081
+ 3.691667 0.253734
+ 3.694444 0.226910
+ 3.697222 0.360066
+ 3.700000 0.247448
+ 3.702778 0.228167
+ 3.705556 0.360081
+ 3.708333 0.246190
+ 3.711111 0.224376
+ 3.713889 0.360071
+ 3.716667 0.247448
+ 3.719444 0.224366
+ 3.722222 0.360052
+ 3.725000 0.242419
+ 3.727778 0.228152
+ 3.730556 0.360071
+ 3.733333 0.243676
+ 3.736111 0.223089
+ 3.738889 0.360056
+ 3.741667 0.243676
+ 3.744444 0.219337
+ 3.747222 0.360037
+ 3.750000 0.244933
+ 3.752778 0.223114
+ 3.755556 0.360056
+ 3.758333 0.237390
+ 3.761111 0.216813
+ 3.763889 0.360042
+ 3.766667 0.243676
+ 3.769444 0.216808
+ 3.772222 0.360032
+ 3.775000 0.239904
+ 3.777778 0.223104
+ 3.780556 0.360052
+ 3.783333 0.237390
+ 3.786111 0.218065
+ 3.788889 0.360052
+ 3.791667 0.242419
+ 3.794444 0.218050
+ 3.797222 0.360027
+ 3.800000 0.239904
+ 3.802778 0.219342
+ 3.805556 0.360047
+ 3.808333 0.236133
+ 3.811111 0.215541
+ 3.813889 0.360042
+ 3.816667 0.241161
+ 3.819444 0.216808
+ 3.822222 0.360032
+ 3.825000 0.242419
+ 3.827778 0.223114
+ 3.830556 0.360056
+ 3.833333 0.238647
+ 3.836111 0.221832
+ 3.838889 0.360056
+ 3.841667 0.243676
+ 3.844444 0.221847
+ 3.847222 0.360042
+ 3.850000 0.241161
+ 3.852778 0.225618
+ 3.855556 0.360076
+ 3.858333 0.238647
+ 3.861111 0.234404
+ 3.863889 0.360120
+ 3.866667 0.242419
+ 3.869444 0.235666
+ 3.872222 0.360106
+ 3.875000 0.247448
+ 3.877778 0.241982
+ 3.880556 0.360150
+ 3.883333 0.248705
+ 3.886111 0.244486
+ 3.888889 0.360155
+ 3.891667 0.252476
+ 3.894444 0.242016
+ 3.897222 0.360125
+ 3.900000 0.251219
+ 3.902778 0.245778
+ 3.905556 0.360140
+ 3.908333 0.253734
+ 3.911111 0.247030
+ 3.913889 0.360169
+ 3.916667 0.251219
+ 3.919444 0.234433
+ 3.922222 0.360086
+ 3.925000 0.246190
+ 3.927778 0.224376
+ 3.930556 0.360052
+ 3.933333 0.239904
+ 3.936111 0.215546
+ 3.938889 0.360027
+ 3.941667 0.241161
+ 3.944444 0.213036
+ 3.947222 0.360012
+ 3.950000 0.241161
+ 3.952778 0.214298
+ 3.955556 0.360032
+ 3.958333 0.234875
+ 3.961111 0.210492
+ 3.963889 0.360022
+ 3.966667 0.238647
+ 3.969444 0.210512
+ 3.972222 0.360012
+ 3.975000 0.237390
+ 3.977778 0.213041
+ 3.980556 0.360017
+ 3.983333 0.224818
+ 3.986111 0.196609
+ 3.988889 0.359924
+ 3.991667 0.212246
+ 3.994444 0.182735
+ 3.997222 0.359880
+ 4.000000 0.190873
+ 4.002778 0.157567
+ 4.005556 0.359781
+ 4.008333 0.263791
+ 4.011111 0.200680
+ 4.013889 0.380216
+ 4.016667 0.374505
+ 4.019444 0.367045
+ 4.022222 0.380977
+ 4.025000 0.449942
+ 4.027778 0.197370
+ 4.030556 0.361063
+ 4.033333 0.213508
+ 4.036111 0.224268
+ 4.038889 0.359919
+ 4.041667 0.229847
+ 4.044444 0.199177
+ 4.047222 0.359973
+ 4.050000 0.229847
+ 4.052778 0.202939
+ 4.055556 0.359993
+ 4.058333 0.227332
+ 4.061111 0.199158
+ 4.063889 0.359988
+ 4.066667 0.227332
+ 4.069444 0.204187
+ 4.072222 0.359978
+ 4.075000 0.228589
+ 4.077778 0.204201
+ 4.080556 0.359998
+ 4.083333 0.226075
+ 4.086111 0.201657
+ 4.088889 0.359998
+ 4.091667 0.228589
+ 4.094444 0.204196
+ 4.097222 0.359973
+ 4.100000 0.228589
+ 4.102778 0.207973
+ 4.105556 0.359998
+ 4.108333 0.226075
+ 4.111111 0.204192
+ 4.113889 0.359998
+ 4.116667 0.231104
+ 4.119444 0.199168
+ 4.122222 0.359963
+ 4.125000 0.229847
+ 4.127778 0.204216
+ 4.130556 0.359993
+ 4.133333 0.227332
+ 4.136111 0.204177
+ 4.138889 0.359998
+ 4.141667 0.231104
+ 4.144444 0.204196
+ 4.147222 0.359993
+ 4.150000 0.226075
+ 4.152778 0.205454
+ 4.155556 0.359988
+ 4.158333 0.224818
+ 4.161111 0.205434
+ 4.163889 0.359998
+ 4.166667 0.226075
+ 4.169444 0.199158
+ 4.172222 0.359973
+ 4.175000 0.221046
+ 4.177778 0.211720
+ 4.180556 0.359993
+ 4.183333 0.217274
+ 4.186111 0.200371
+ 4.188889 0.359978
+ 4.191667 0.216017
+ 4.194444 0.204128
+ 4.197222 0.359978
+ 4.200000 0.205959
+ 4.202778 0.205380
+ 4.205556 0.360002
+ 4.208333 0.202188
+ 4.211111 0.202826
+ 4.213889 0.359988
+ 4.216667 0.197159
+ 4.219444 0.197783
+ 4.222222 0.359968
+ 4.225000 0.195902
+ 4.227778 0.202807
+ 4.230556 0.359988
+ 4.233333 0.192130
+ 4.236111 0.201540
+ 4.238889 0.359983
+ 4.241667 0.203445
+ 4.244444 0.205351
+ 4.247222 0.359983
+ 4.250000 0.213503
+ 4.252778 0.214220
+ 4.255556 0.360032
+ 4.258333 0.224818
+ 4.261111 0.218011
+ 4.263889 0.360056
+ 4.266667 0.241161
+ 4.269444 0.223104
+ 4.272222 0.360076
+ 4.275000 0.242419
+ 4.277778 0.230662
+ 4.280556 0.360091
+ 4.283333 0.246190
+ 4.286111 0.224361
+ 4.288889 0.360091
+ 4.291667 0.247448
+ 4.294444 0.228147
+ 4.297222 0.360071
+ 4.300000 0.247448
+ 4.302778 0.231944
+ 4.305556 0.360106
+ 4.308333 0.246190
+ 4.311111 0.231904
+ 4.313889 0.360096
+ 4.316667 0.248705
+ 4.319444 0.225638
+ 4.322222 0.360056
+ 4.325000 0.242419
+ 4.327778 0.225628
+ 4.330556 0.360071
+ 4.333333 0.241161
+ 4.336111 0.224346
+ 4.338889 0.360071
+ 4.341667 0.243676
+ 4.344444 0.220579
+ 4.347222 0.360042
+ 4.350000 0.239904
+ 4.352778 0.225618
+ 4.355556 0.360052
+ 4.358333 0.239904
+ 4.361111 0.220565
+ 4.363889 0.360056
+ 4.366667 0.238647
+ 4.369444 0.221827
+ 4.372222 0.360027
+ 4.375000 0.238647
+ 4.377778 0.219322
+ 4.380556 0.360052
+ 4.383333 0.229847
+ 4.386111 0.215511
+ 4.388889 0.360032
+ 4.391667 0.234875
+ 4.394444 0.214269
+ 4.397222 0.360017
+ 4.400000 0.234875
+ 4.402778 0.218050
+ 4.405556 0.360037
+ 4.408333 0.231104
+ 4.411111 0.215516
+ 4.413889 0.360042
+ 4.416667 0.232361
+ 4.419444 0.215511
+ 4.422222 0.360017
+ 4.425000 0.233618
+ 4.427778 0.216798
+ 4.430556 0.360042
+ 4.433333 0.234875
+ 4.436111 0.215521
+ 4.438889 0.360032
+ 4.441667 0.229847
+ 4.444444 0.213002
+ 4.447222 0.360007
+ 4.450000 0.231104
+ 4.452778 0.215516
+ 4.455556 0.360037
+ 4.458333 0.234875
+ 4.461111 0.213017
+ 4.463889 0.360042
+ 4.466667 0.236133
+ 4.469444 0.213012
+ 4.472222 0.360032
+ 4.475000 0.232361
+ 4.477778 0.224322
+ 4.480556 0.360071
+ 4.483333 0.227332
+ 4.486111 0.229331
+ 4.488889 0.360091
+ 4.491667 0.236133
+ 4.494444 0.233132
+ 4.497222 0.360096
+ 4.500000 0.237390
+ 4.502778 0.244462
+ 4.505556 0.360140
+ 4.508333 0.238647
+ 4.511111 0.239438
+ 4.513889 0.360125
+ 4.516667 0.243676
+ 4.519444 0.235681
+ 4.522222 0.360110
+ 4.525000 0.242419
+ 4.527778 0.233176
+ 4.530556 0.360101
+ 4.533333 0.236133
+ 4.536111 0.240685
+ 4.538889 0.360145
+ 4.541667 0.233618
+ 4.544444 0.229351
+ 4.547222 0.360071
+ 4.550000 0.237390
+ 4.552778 0.228108
+ 4.555556 0.360061
+ 4.558333 0.224818
+ 4.561111 0.210473
+ 4.563889 0.360022
+ 4.566667 0.228589
+ 4.569444 0.207953
+ 4.572222 0.359993
+ 4.575000 0.226075
+ 4.577778 0.209220
+ 4.580556 0.360002
+ 4.583333 0.224818
+ 4.586111 0.205434
+ 4.588889 0.359998
+ 4.591667 0.224818
+ 4.594444 0.205429
+ 4.597222 0.359983
+ 4.600000 0.224818
+ 4.602778 0.209220
+ 4.605556 0.360002
+ 4.608333 0.213503
+ 4.611111 0.192788
+ 4.613889 0.359914
+ 4.616667 0.198416
+ 4.619444 0.160056
+ 4.622222 0.359791
+ 4.625000 0.252476
+ 4.627778 0.204378
+ 4.630556 0.380211
+ 4.633333 0.329245
+ 4.636111 0.385741
+ 4.638889 0.381051
+ 4.641667 0.364452
+ 4.644444 0.149174
+ 4.647222 0.360778
+ 4.650000 0.192135
+ 4.652778 0.202841
+ 4.655556 0.359885
+ 4.658333 0.208474
+ 4.661111 0.185255
+ 4.663889 0.359929
+ 4.666667 0.216017
+ 4.669444 0.192828
+ 4.672222 0.359934
+ 4.675000 0.212246
+ 4.677778 0.194090
+ 4.680556 0.359944
+ 4.683333 0.214760
+ 4.686111 0.196594
+ 4.688889 0.359958
+ 4.691667 0.213503
+ 4.694444 0.196584
+ 4.697222 0.359944
+ 4.700000 0.214760
+ 4.702778 0.192832
+ 4.705556 0.359953
+ 4.708333 0.213503
+ 4.711111 0.192818
+ 4.713889 0.359953
+ 4.716667 0.217274
+ 4.719444 0.195342
+ 4.722222 0.359953
+ 4.725000 0.216017
+ 4.727778 0.199138
+ 4.730556 0.359963
+ 4.733333 0.214760
+ 4.736111 0.192823
+ 4.738889 0.359939
+ 4.741667 0.216017
+ 4.744444 0.190308
+ 4.747222 0.359934
+ 4.750000 0.216017
+ 4.752778 0.192832
+ 4.755556 0.359939
+ 4.758333 0.209731
+ 4.761111 0.190293
+ 4.763889 0.359929
+ 4.766667 0.214760
+ 4.769444 0.192818
+ 4.772222 0.359939
+ 4.775000 0.212246
+ 4.777778 0.195337
+ 4.780556 0.359948
+ 4.783333 0.213503
+ 4.786111 0.190298
+ 4.788889 0.359944
+ 4.791667 0.212246
+ 4.794444 0.191551
+ 4.797222 0.359934
+ 4.800000 0.210988
+ 4.802778 0.195317
+ 4.805556 0.359944
+ 4.808333 0.204702
+ 4.811111 0.192764
+ 4.813889 0.359953
+ 4.816667 0.202188
+ 4.819444 0.191506
+ 4.822222 0.359934
+ 4.825000 0.189616
+ 4.827778 0.195254
+ 4.830556 0.359939
+ 4.833333 0.184587
+ 4.836111 0.185157
+ 4.838889 0.359914
+ 4.841667 0.187101
+ 4.844444 0.185161
+ 4.847222 0.359904
+ 4.850000 0.184587
+ 4.852778 0.187681
+ 4.855556 0.359914
+ 4.858333 0.182072
+ 4.861111 0.185157
+ 4.863889 0.359919
+ 4.866667 0.198416
+ 4.869444 0.192764
+ 4.872222 0.359948
+ 4.875000 0.203445
+ 4.877778 0.202856
+ 4.880556 0.359983
+ 4.883333 0.213503
+ 4.886111 0.206667
+ 4.888889 0.360027
+ 4.891667 0.222303
+ 4.894444 0.215467
+ 4.897222 0.360027
+ 4.900000 0.222303
+ 4.902778 0.220521
+ 4.905556 0.360047
+ 4.908333 0.222303
+ 4.911111 0.212972
+ 4.913889 0.360042
+ 4.916667 0.222303
+ 4.919444 0.219249
+ 4.922222 0.360042
+ 4.925000 0.224818
+ 4.927778 0.220530
+ 4.930556 0.360052
+ 4.933333 0.219789
+ 4.936111 0.215482
+ 4.938889 0.360037
+ 4.941667 0.223560
+ 4.944444 0.212958
+ 4.947222 0.360017
+ 4.950000 0.221046
+ 4.952778 0.216734
+ 4.955556 0.360037
+ 4.958333 0.218532
+ 4.961111 0.211691
+ 4.963889 0.360032
+ 4.966667 0.221046
+ 4.969444 0.215472
+ 4.972222 0.360032
+ 4.975000 0.214760
+ 4.977778 0.215472
+ 4.980556 0.360027
+ 4.983333 0.213503
+ 4.986111 0.209152
+ 4.988889 0.360002
+ 4.991667 0.214760
+ 4.994444 0.205390
+ 4.997222 0.359993
+ 5.000000 0.213503
+ 5.002778 0.210428
+ 5.005556 0.359998
+ 5.008333 0.210988
+ 5.011111 0.206632
+ 5.013889 0.360012
+ 5.016667 0.212246
+ 5.019444 0.207885
+ 5.022222 0.359998
+ 5.025000 0.212246
+ 5.027778 0.209161
+ 5.030556 0.360007
+ 5.033333 0.207217
+ 5.036111 0.204103
+ 5.038889 0.359988
+ 5.041667 0.213503
+ 5.044444 0.205385
+ 5.047222 0.359983
+ 5.050000 0.209731
+ 5.052778 0.211681
+ 5.055556 0.360002
+ 5.058333 0.212246
+ 5.061111 0.210394
+ 5.063889 0.360012
+ 5.066667 0.209731
+ 5.069444 0.209147
+ 5.072222 0.360002
+ 5.075000 0.213503
+ 5.077778 0.211681
+ 5.080556 0.360007
+ 5.083333 0.207217
+ 5.086111 0.206622
+ 5.088889 0.360012
+ 5.091667 0.216017
+ 5.094444 0.210414
+ 5.097222 0.359998
+ 5.100000 0.209731
+ 5.102778 0.216710
+ 5.105556 0.360037
+ 5.108333 0.207217
+ 5.111111 0.220467
+ 5.113889 0.360052
+ 5.116667 0.218532
+ 5.119444 0.225510
+ 5.122222 0.360066
+ 5.125000 0.217274
+ 5.127778 0.238112
+ 5.130556 0.360120
+ 5.133333 0.218532
+ 5.136111 0.233063
+ 5.138889 0.360106
+ 5.141667 0.224818
+ 5.144444 0.229316
+ 5.147222 0.360081
+ 5.150000 0.222303
+ 5.152778 0.226802
+ 5.155556 0.360091
+ 5.158333 0.216017
+ 5.161111 0.226772
+ 5.163889 0.360056
+ 5.166667 0.218532
+ 5.169444 0.211691
+ 5.172222 0.359998
+ 5.175000 0.209731
+ 5.177778 0.207894
+ 5.180556 0.359998
+ 5.183333 0.208474
+ 5.186111 0.205370
+ 5.188889 0.359988
+ 5.191667 0.212246
+ 5.194444 0.201608
+ 5.197222 0.359968
+ 5.200000 0.213503
+ 5.202778 0.206662
+ 5.205556 0.359983
+ 5.208333 0.212246
+ 5.211111 0.197837
+ 5.213889 0.359983
+ 5.216667 0.214760
+ 5.219444 0.200356
+ 5.222222 0.359968
+ 5.225000 0.213503
+ 5.227778 0.202870
+ 5.230556 0.359973
+ 5.233333 0.195902
+ 5.236111 0.178890
+ 5.238889 0.359875
+ 5.241667 0.188359
+ 5.244444 0.156319
+ 5.247222 0.359821
+ 5.250000 0.278878
+ 5.252778 0.248469
+ 5.255556 0.380437
+ 5.258333 0.369481
+ 5.261111 0.139460
+ 5.263889 0.381262
+ 5.266667 0.301591
+ 5.269444 0.417923
+ 5.272222 0.360454
+ 5.275000 0.190873
+ 5.277778 0.180196
+ 5.280556 0.359870
+ 5.283333 0.207217
+ 5.286111 0.189021
+ 5.288889 0.359939
+ 5.291667 0.213503
+ 5.294444 0.191546
+ 5.297222 0.359934
+ 5.300000 0.213503
+ 5.302778 0.199104
+ 5.305556 0.359958
+ 5.308333 0.207217
+ 5.311111 0.192803
+ 5.313889 0.359953
+ 5.316667 0.214760
+ 5.319444 0.194075
+ 5.322222 0.359919
+ 5.325000 0.212246
+ 5.327778 0.194085
+ 5.330556 0.359939
+ 5.333333 0.210988
+ 5.336111 0.186522
+ 5.338889 0.359939
+ 5.341667 0.213503
+ 5.344444 0.191556
+ 5.347222 0.359924
+ 5.350000 0.216017
+ 5.352778 0.190308
+ 5.355556 0.359939
+ 5.358333 0.210988
+ 5.361111 0.190298
+ 5.363889 0.359944
+ 5.366667 0.216017
+ 5.369444 0.190308
+ 5.372222 0.359924
+ 5.375000 0.216017
+ 5.377778 0.196604
+ 5.380556 0.359948
+ 5.383333 0.210988
+ 5.386111 0.190293
+ 5.388889 0.359934
+ 5.391667 0.212246
+ 5.394444 0.189041
+ 5.397222 0.359914
+ 5.400000 0.212246
+ 5.402778 0.191560
+ 5.405556 0.359934
+ 5.408333 0.205959
+ 5.411111 0.187759
+ 5.413889 0.359924
+ 5.416667 0.209731
+ 5.419444 0.191526
+ 5.422222 0.359929
+ 5.425000 0.202188
+ 5.427778 0.191536
+ 5.430556 0.359948
+ 5.433333 0.199673
+ 5.436111 0.191497
+ 5.438889 0.359934
+ 5.441667 0.197159
+ 5.444444 0.186463
+ 5.447222 0.359919
+ 5.450000 0.189616
+ 5.452778 0.187705
+ 5.455556 0.359904
+ 5.458333 0.182072
+ 5.461111 0.178856
+ 5.463889 0.359890
+ 5.466667 0.182072
+ 5.469444 0.177608
+ 5.472222 0.359865
+ 5.475000 0.179558
+ 5.477778 0.181390
+ 5.480556 0.359894
+ 5.483333 0.189616
+ 5.486111 0.185201
+ 5.488889 0.359929
+ 5.491667 0.203445
+ 5.494444 0.194045
+ 5.497222 0.359953
+ 5.500000 0.214760
+ 5.502778 0.204157
+ 5.505556 0.359993
+ 5.508333 0.221046
+ 5.511111 0.206686
+ 5.513889 0.360012
+ 5.516667 0.231104
+ 5.519444 0.213007
+ 5.522222 0.360012
+ 5.525000 0.233618
+ 5.527778 0.219298
+ 5.530556 0.360037
+ 5.533333 0.234875
+ 5.536111 0.215521
+ 5.538889 0.360037
+ 5.541667 0.236133
+ 5.544444 0.216788
+ 5.547222 0.360022
+ 5.550000 0.234875
+ 5.552778 0.218055
+ 5.555556 0.360032
+ 5.558333 0.228589
+ 5.561111 0.212992
+ )
Vecg_l1 ecg_amp_l1 0 PWL(
+ 0.000000 0.359924
+ 0.002778 0.252535
+ 0.005556 0.205658
+ 0.008333 0.359890
+ 0.011111 0.252535
+ 0.013889 0.205648
+ 0.016667 0.359909
+ 0.019444 0.246256
+ 0.022222 0.201866
+ 0.025000 0.359909
+ 0.027778 0.253790
+ 0.030556 0.209415
+ 0.033333 0.359919
+ 0.036111 0.252535
+ 0.038889 0.208179
+ 0.041667 0.359944
+ 0.044444 0.250023
+ 0.047222 0.204383
+ 0.050000 0.359919
+ 0.052778 0.252535
+ 0.055556 0.201876
+ 0.058333 0.359895
+ 0.061111 0.248768
+ 0.063889 0.203132
+ 0.066667 0.359904
+ 0.069444 0.250023
+ 0.072222 0.204383
+ 0.075000 0.359924
+ 0.077778 0.247512
+ 0.080556 0.204383
+ 0.083333 0.359909
+ 0.086111 0.248768
+ 0.088889 0.210676
+ 0.091667 0.359934
+ 0.094444 0.250023
+ 0.097222 0.209410
+ 0.100000 0.359929
+ 0.102778 0.247512
+ 0.105556 0.205638
+ 0.108333 0.359909
+ 0.111111 0.248768
+ 0.113889 0.206904
+ 0.116667 0.359919
+ 0.119444 0.241234
+ 0.122222 0.203097
+ 0.125000 0.359929
+ 0.127778 0.247512
+ 0.130556 0.204378
+ 0.133333 0.359904
+ 0.136111 0.242489
+ 0.138889 0.205628
+ 0.141667 0.359924
+ 0.144444 0.241234
+ 0.147222 0.208125
+ 0.150000 0.359939
+ 0.152778 0.247512
+ 0.155556 0.206865
+ 0.158333 0.359919
+ 0.161111 0.243745
+ 0.163889 0.209395
+ 0.166667 0.359924
+ 0.169444 0.242489
+ 0.172222 0.206874
+ 0.175000 0.359919
+ 0.177778 0.246256
+ 0.180556 0.213162
+ 0.183333 0.359948
+ 0.186111 0.243745
+ 0.188889 0.220706
+ 0.191667 0.359973
+ 0.194444 0.245001
+ 0.197222 0.224478
+ 0.200000 0.360002
+ 0.202778 0.252535
+ 0.205556 0.232017
+ 0.208333 0.360017
+ 0.211111 0.253790
+ 0.213889 0.232047
+ 0.216667 0.360017
+ 0.219444 0.252535
+ 0.222222 0.225754
+ 0.225000 0.360007
+ 0.227778 0.252535
+ 0.230556 0.223227
+ 0.233333 0.359958
+ 0.236111 0.255046
+ 0.238889 0.228270
+ 0.241667 0.360012
+ 0.244444 0.243745
+ 0.247222 0.220706
+ 0.250000 0.359968
+ 0.252778 0.248768
+ 0.255556 0.208150
+ 0.258333 0.359909
+ 0.261111 0.241234
+ 0.263889 0.204373
+ 0.266667 0.359909
+ 0.269444 0.243745
+ 0.272222 0.200586
+ 0.275000 0.359919
+ 0.277778 0.242489
+ 0.280556 0.195568
+ 0.283333 0.359860
+ 0.286111 0.237467
+ 0.288889 0.199345
+ 0.291667 0.359899
+ 0.294444 0.238722
+ 0.297222 0.194308
+ 0.300000 0.359885
+ 0.302778 0.238722
+ 0.305556 0.193047
+ 0.308333 0.359850
+ 0.311111 0.222399
+ 0.313889 0.172893
+ 0.316667 0.359796
+ 0.319444 0.218632
+ 0.322222 0.151590
+ 0.325000 0.359757
+ 0.327778 0.302840
+ 0.330556 0.247340
+ 0.333333 0.380343
+ 0.336111 0.391998
+ 0.338889 0.153577
+ 0.341667 0.381192
+ 0.344444 0.349305
+ 0.347222 0.436780
+ 0.350000 0.360493
+ 0.352778 0.198541
+ 0.355556 0.189143
+ 0.358333 0.359782
+ 0.361111 0.223654
+ 0.363889 0.170401
+ 0.366667 0.359816
+ 0.369444 0.226166
+ 0.372222 0.186710
+ 0.375000 0.359860
+ 0.377778 0.229933
+ 0.380556 0.191757
+ 0.383333 0.359860
+ 0.386111 0.228677
+ 0.388889 0.188005
+ 0.391667 0.359850
+ 0.394444 0.224910
+ 0.397222 0.182968
+ 0.400000 0.359850
+ 0.402778 0.231188
+ 0.405556 0.184228
+ 0.408333 0.359836
+ 0.411111 0.231188
+ 0.413889 0.188025
+ 0.416667 0.359850
+ 0.419444 0.228677
+ 0.422222 0.184208
+ 0.425000 0.359850
+ 0.427778 0.237467
+ 0.430556 0.184243
+ 0.433333 0.359836
+ 0.436111 0.232444
+ 0.438889 0.189261
+ 0.441667 0.359850
+ 0.444444 0.232444
+ 0.447222 0.190511
+ 0.450000 0.359850
+ 0.452778 0.233700
+ 0.455556 0.185494
+ 0.458333 0.359841
+ 0.461111 0.233700
+ 0.463889 0.191792
+ 0.466667 0.359855
+ 0.469444 0.229933
+ 0.472222 0.184218
+ 0.475000 0.359836
+ 0.477778 0.232444
+ 0.480556 0.185489
+ 0.483333 0.359841
+ 0.486111 0.229933
+ 0.488889 0.191752
+ 0.491667 0.359865
+ 0.494444 0.227421
+ 0.497222 0.190492
+ 0.500000 0.359875
+ 0.502778 0.228677
+ 0.505556 0.191752
+ 0.508333 0.359855
+ 0.511111 0.229933
+ 0.513889 0.194283
+ 0.516667 0.359875
+ 0.519444 0.223654
+ 0.522222 0.191723
+ 0.525000 0.359870
+ 0.527778 0.223654
+ 0.530556 0.184164
+ 0.533333 0.359816
+ 0.536111 0.211097
+ 0.538889 0.181643
+ 0.541667 0.359821
+ 0.544444 0.203563
+ 0.547222 0.171549
+ 0.550000 0.359806
+ 0.552778 0.198541
+ 0.555556 0.171544
+ 0.558333 0.359767
+ 0.561111 0.196029
+ 0.563889 0.172795
+ 0.566667 0.359796
+ 0.569444 0.193518
+ 0.572222 0.172775
+ 0.575000 0.359801
+ 0.577778 0.207330
+ 0.580556 0.177866
+ 0.583333 0.359816
+ 0.586111 0.217376
+ 0.588889 0.189221
+ 0.591667 0.359870
+ 0.594444 0.231188
+ 0.597222 0.198050
+ 0.600000 0.359899
+ 0.602778 0.241234
+ 0.605556 0.206865
+ 0.608333 0.359929
+ 0.611111 0.247512
+ 0.613889 0.214438
+ 0.616667 0.359973
+ 0.619444 0.246256
+ 0.622222 0.219446
+ 0.625000 0.359978
+ 0.627778 0.252535
+ 0.630556 0.218200
+ 0.633333 0.359948
+ 0.636111 0.250023
+ 0.638889 0.216959
+ 0.641667 0.359958
+ 0.644444 0.246256
+ 0.647222 0.214428
+ 0.650000 0.359968
+ 0.652778 0.251279
+ 0.655556 0.214428
+ 0.658333 0.359948
+ 0.661111 0.248768
+ 0.663889 0.216944
+ 0.666667 0.359958
+ 0.669444 0.247512
+ 0.672222 0.213158
+ 0.675000 0.359963
+ 0.677778 0.248768
+ 0.680556 0.211922
+ 0.683333 0.359944
+ 0.686111 0.250023
+ 0.688889 0.215679
+ 0.691667 0.359958
+ 0.694444 0.242489
+ 0.697222 0.209371
+ 0.700000 0.359934
+ 0.702778 0.245001
+ 0.705556 0.206879
+ 0.708333 0.359924
+ 0.711111 0.242489
+ 0.713889 0.211907
+ 0.716667 0.359944
+ 0.719444 0.242489
+ 0.722222 0.210651
+ 0.725000 0.359944
+ 0.727778 0.243745
+ 0.730556 0.209386
+ 0.733333 0.359929
+ 0.736111 0.243745
+ 0.738889 0.211907
+ 0.741667 0.359948
+ 0.744444 0.238722
+ 0.747222 0.209376
+ 0.750000 0.359944
+ 0.752778 0.242489
+ 0.755556 0.205624
+ 0.758333 0.359899
+ 0.761111 0.241234
+ 0.763889 0.209395
+ 0.766667 0.359929
+ 0.769444 0.239978
+ 0.772222 0.205619
+ 0.775000 0.359934
+ 0.777778 0.247512
+ 0.780556 0.205619
+ 0.783333 0.359919
+ 0.786111 0.245001
+ 0.788889 0.210666
+ 0.791667 0.359934
+ 0.794444 0.245001
+ 0.797222 0.206879
+ 0.800000 0.359939
+ 0.802778 0.247512
+ 0.805556 0.204378
+ 0.808333 0.359909
+ 0.811111 0.245001
+ 0.813889 0.215684
+ 0.816667 0.359963
+ 0.819444 0.245001
+ 0.822222 0.221957
+ 0.825000 0.359978
+ 0.827778 0.250023
+ 0.830556 0.230761
+ 0.833333 0.360002
+ 0.836111 0.255046
+ 0.838889 0.233307
+ 0.841667 0.360032
+ 0.844444 0.252535
+ 0.847222 0.230786
+ 0.850000 0.360017
+ 0.852778 0.261324
+ 0.855556 0.225778
+ 0.858333 0.359998
+ 0.861111 0.260069
+ 0.863889 0.225793
+ 0.866667 0.360022
+ 0.869444 0.253790
+ 0.872222 0.230776
+ 0.875000 0.359993
+ 0.877778 0.257557
+ 0.880556 0.215708
+ 0.883333 0.359944
+ 0.886111 0.251279
+ 0.888889 0.206914
+ 0.891667 0.359924
+ 0.894444 0.246256
+ 0.897222 0.200616
+ 0.900000 0.359919
+ 0.902778 0.247512
+ 0.905556 0.204368
+ 0.908333 0.359909
+ 0.911111 0.246256
+ 0.913889 0.205648
+ 0.916667 0.359914
+ 0.919444 0.245001
+ 0.922222 0.199335
+ 0.925000 0.359914
+ 0.927778 0.246256
+ 0.930556 0.199350
+ 0.933333 0.359885
+ 0.936111 0.245001
+ 0.938889 0.200601
+ 0.941667 0.359885
+ 0.944444 0.223654
+ 0.947222 0.170372
+ 0.950000 0.359767
+ 0.952778 0.222399
+ 0.955556 0.149133
+ 0.958333 0.379843
+ 0.961111 0.332976
+ 0.963889 0.268849
+ 0.966667 0.380466
+ 0.969444 0.428412
+ 0.972222 0.177528
+ 0.975000 0.381236
+ 0.977778 0.273886
+ 0.980556 0.342399
+ 0.983333 0.360071
+ 0.986111 0.232444
+ 0.988889 0.171681
+ 0.991667 0.359816
+ 0.994444 0.237467
+ 0.997222 0.191787
+ 1.000000 0.359865
+ 1.002778 0.236211
+ 1.005556 0.194283
+ 1.008333 0.359855
+ 1.011111 0.234955
+ 1.013889 0.191792
+ 1.016667 0.359865
+ 1.019444 0.234955
+ 1.022222 0.190506
+ 1.025000 0.359870
+ 1.027778 0.238722
+ 1.030556 0.193047
+ 1.033333 0.359860
+ 1.036111 0.238722
+ 1.038889 0.199335
+ 1.041667 0.359880
+ 1.044444 0.236211
+ 1.047222 0.195544
+ 1.050000 0.359885
+ 1.052778 0.242489
+ 1.055556 0.195559
+ 1.058333 0.359870
+ 1.061111 0.238722
+ 1.063889 0.195568
+ 1.066667 0.359885
+ 1.069444 0.236211
+ 1.072222 0.191787
+ 1.075000 0.359875
+ 1.077778 0.241234
+ 1.080556 0.194303
+ 1.083333 0.359865
+ 1.086111 0.237467
+ 1.088889 0.193057
+ 1.091667 0.359875
+ 1.094444 0.236211
+ 1.097222 0.194283
+ 1.100000 0.359880
+ 1.102778 0.242489
+ 1.105556 0.194298
+ 1.108333 0.359880
+ 1.111111 0.239978
+ 1.113889 0.196814
+ 1.116667 0.359890
+ 1.119444 0.232444
+ 1.122222 0.191767
+ 1.125000 0.359875
+ 1.127778 0.233700
+ 1.130556 0.191767
+ 1.133333 0.359860
+ 1.136111 0.228677
+ 1.138889 0.195524
+ 1.141667 0.359875
+ 1.144444 0.221143
+ 1.147222 0.191703
+ 1.150000 0.359865
+ 1.152778 0.217376
+ 1.155556 0.190438
+ 1.158333 0.359850
+ 1.161111 0.209842
+ 1.163889 0.192939
+ 1.166667 0.359875
+ 1.169444 0.202308
+ 1.172222 0.189143
+ 1.175000 0.359860
+ 1.177778 0.206075
+ 1.180556 0.190399
+ 1.183333 0.359850
+ 1.186111 0.211097
+ 1.188889 0.194215
+ 1.191667 0.359865
+ 1.194444 0.223654
+ 1.197222 0.199267
+ 1.200000 0.359909
+ 1.202778 0.237467
+ 1.205556 0.208120
+ 1.208333 0.359929
+ 1.211111 0.250023
+ 1.213889 0.219465
+ 1.216667 0.359963
+ 1.219444 0.247512
+ 1.222222 0.219456
+ 1.225000 0.359973
+ 1.227778 0.252535
+ 1.230556 0.221987
+ 1.233333 0.359983
+ 1.236111 0.253790
+ 1.238889 0.228275
+ 1.241667 0.359998
+ 1.244444 0.253790
+ 1.247222 0.225754
+ 1.250000 0.359993
+ 1.252778 0.257557
+ 1.255556 0.221991
+ 1.258333 0.359973
+ 1.261111 0.257557
+ 1.263889 0.224522
+ 1.266667 0.359988
+ 1.269444 0.251279
+ 1.272222 0.221977
+ 1.275000 0.359978
+ 1.277778 0.256302
+ 1.280556 0.219475
+ 1.283333 0.359968
+ 1.286111 0.252535
+ 1.288889 0.219475
+ 1.291667 0.359978
+ 1.294444 0.248768
+ 1.297222 0.215693
+ 1.300000 0.359968
+ 1.302778 0.250023
+ 1.305556 0.215689
+ 1.308333 0.359939
+ 1.311111 0.248768
+ 1.313889 0.216954
+ 1.316667 0.359953
+ 1.319444 0.243745
+ 1.322222 0.213153
+ 1.325000 0.359958
+ 1.327778 0.247512
+ 1.330556 0.211907
+ 1.333333 0.359924
+ 1.336111 0.245001
+ 1.338889 0.216949
+ 1.341667 0.359948
+ 1.344444 0.243745
+ 1.347222 0.208140
+ 1.350000 0.359948
+ 1.352778 0.247512
+ 1.355556 0.208159
+ 1.358333 0.359924
+ 1.361111 0.246256
+ 1.363889 0.211926
+ 1.366667 0.359939
+ 1.369444 0.245001
+ 1.372222 0.211907
+ 1.375000 0.359944
+ 1.377778 0.248768
+ 1.380556 0.211922
+ 1.383333 0.359939
+ 1.386111 0.251279
+ 1.388889 0.216954
+ 1.391667 0.359958
+ 1.394444 0.246256
+ 1.397222 0.215669
+ 1.400000 0.359953
+ 1.402778 0.252535
+ 1.405556 0.215684
+ 1.408333 0.359934
+ 1.411111 0.250023
+ 1.413889 0.218215
+ 1.416667 0.359958
+ 1.419444 0.248768
+ 1.422222 0.213167
+ 1.425000 0.359958
+ 1.427778 0.252535
+ 1.430556 0.218215
+ 1.433333 0.359983
+ 1.436111 0.250023
+ 1.438889 0.233283
+ 1.441667 0.360027
+ 1.444444 0.250023
+ 1.447222 0.235794
+ 1.450000 0.360056
+ 1.452778 0.258813
+ 1.455556 0.242082
+ 1.458333 0.360056
+ 1.461111 0.260069
+ 1.463889 0.238354
+ 1.466667 0.360042
+ 1.469444 0.262580
+ 1.472222 0.235838
+ 1.475000 0.360042
+ 1.477778 0.267603
+ 1.480556 0.238345
+ 1.483333 0.360056
+ 1.486111 0.260069
+ 1.488889 0.234568
+ 1.491667 0.360017
+ 1.494444 0.255046
+ 1.497222 0.220731
+ 1.500000 0.359973
+ 1.502778 0.253790
+ 1.505556 0.213177
+ 1.508333 0.359929
+ 1.511111 0.252535
+ 1.513889 0.211951
+ 1.516667 0.359944
+ 1.519444 0.246256
+ 1.522222 0.208145
+ 1.525000 0.359934
+ 1.527778 0.250023
+ 1.530556 0.206904
+ 1.533333 0.359909
+ 1.536111 0.250023
+ 1.538889 0.211931
+ 1.541667 0.359944
+ 1.544444 0.245001
+ 1.547222 0.206889
+ 1.550000 0.359934
+ 1.552778 0.231188
+ 1.555556 0.182933
+ 1.558333 0.359801
+ 1.561111 0.218632
+ 1.563889 0.159174
+ 1.566667 0.379872
+ 1.569444 0.340510
+ 1.572222 0.277677
+ 1.575000 0.380505
+ 1.577778 0.142119
+ 1.580556 0.193955
+ 1.583333 0.381270
+ 1.586111 0.263841
+ 1.588889 0.300996
+ 1.591667 0.359953
+ 1.594444 0.241234
+ 1.597222 0.193042
+ 1.600000 0.359914
+ 1.602778 0.236211
+ 1.605556 0.200571
+ 1.608333 0.359895
+ 1.611111 0.238722
+ 1.613889 0.203107
+ 1.616667 0.359904
+ 1.619444 0.234955
+ 1.622222 0.199301
+ 1.625000 0.359899
+ 1.627778 0.238722
+ 1.630556 0.198065
+ 1.633333 0.359875
+ 1.636111 0.237467
+ 1.638889 0.199326
+ 1.641667 0.359895
+ 1.644444 0.236211
+ 1.647222 0.195549
+ 1.650000 0.359890
+ 1.652778 0.238722
+ 1.655556 0.196809
+ 1.658333 0.359890
+ 1.661111 0.239978
+ 1.663889 0.201852
+ 1.666667 0.359899
+ 1.669444 0.234955
+ 1.672222 0.199316
+ 1.675000 0.359899
+ 1.677778 0.245001
+ 1.680556 0.196814
+ 1.683333 0.359885
+ 1.686111 0.238722
+ 1.688889 0.203102
+ 1.691667 0.359914
+ 1.694444 0.234955
+ 1.697222 0.199311
+ 1.700000 0.359895
+ 1.702778 0.238722
+ 1.705556 0.203083
+ 1.708333 0.359904
+ 1.711111 0.237467
+ 1.713889 0.206860
+ 1.716667 0.359914
+ 1.719444 0.232444
+ 1.722222 0.203063
+ 1.725000 0.359899
+ 1.727778 0.232444
+ 1.730556 0.201803
+ 1.733333 0.359890
+ 1.736111 0.226166
+ 1.738889 0.200527
+ 1.741667 0.359909
+ 1.744444 0.218632
+ 1.747222 0.199237
+ 1.750000 0.359895
+ 1.752778 0.213609
+ 1.755556 0.201729
+ 1.758333 0.359899
+ 1.761111 0.209842
+ 1.763889 0.200473
+ 1.766667 0.359904
+ 1.769444 0.202308
+ 1.772222 0.199188
+ 1.775000 0.359895
+ 1.777778 0.209842
+ 1.780556 0.199203
+ 1.783333 0.359895
+ 1.786111 0.213609
+ 1.788889 0.204270
+ 1.791667 0.359914
+ 1.794444 0.223654
+ 1.797222 0.208061
+ 1.800000 0.359934
+ 1.802778 0.236211
+ 1.805556 0.213123
+ 1.808333 0.359953
+ 1.811111 0.241234
+ 1.813889 0.216934
+ 1.816667 0.359963
+ 1.819444 0.247512
+ 1.822222 0.224483
+ 1.825000 0.360007
+ 1.827778 0.256302
+ 1.830556 0.227009
+ 1.833333 0.359993
+ 1.836111 0.258813
+ 1.838889 0.233317
+ 1.841667 0.360007
+ 1.844444 0.252535
+ 1.847222 0.224513
+ 1.850000 0.359998
+ 1.852778 0.258813
+ 1.855556 0.228270
+ 1.858333 0.359993
+ 1.861111 0.256302
+ 1.863889 0.228294
+ 1.866667 0.360012
+ 1.869444 0.253790
+ 1.872222 0.224483
+ 1.875000 0.359993
+ 1.877778 0.255046
+ 1.880556 0.225768
+ 1.883333 0.359983
+ 1.886111 0.253790
+ 1.888889 0.228275
+ 1.891667 0.360002
+ 1.894444 0.250023
+ 1.897222 0.221977
+ 1.900000 0.359988
+ 1.902778 0.253790
+ 1.905556 0.223223
+ 1.908333 0.359973
+ 1.911111 0.248768
+ 1.913889 0.221982
+ 1.916667 0.359988
+ 1.919444 0.248768
+ 1.922222 0.216949
+ 1.925000 0.359963
+ 1.927778 0.251279
+ 1.930556 0.216944
+ 1.933333 0.359948
+ 1.936111 0.252535
+ 1.938889 0.216969
+ 1.941667 0.359973
+ 1.944444 0.247512
+ 1.947222 0.218185
+ 1.950000 0.359983
+ 1.952778 0.251279
+ 1.955556 0.218205
+ 1.958333 0.359953
+ 1.961111 0.247512
+ 1.963889 0.219480
+ 1.966667 0.359973
+ 1.969444 0.248768
+ 1.972222 0.215693
+ 1.975000 0.359968
+ 1.977778 0.252535
+ 1.980556 0.215693
+ 1.983333 0.359958
+ 1.986111 0.253790
+ 1.988889 0.223257
+ 1.991667 0.359993
+ 1.994444 0.250023
+ 1.997222 0.218205
+ 2.000000 0.359978
+ 2.002778 0.256302
+ 2.005556 0.216974
+ 2.008333 0.359963
+ 2.011111 0.253790
+ 2.013889 0.220741
+ 2.016667 0.359983
+ 2.019444 0.253790
+ 2.022222 0.223242
+ 2.025000 0.360012
+ 2.027778 0.253790
+ 2.030556 0.235794
+ 2.033333 0.360027
+ 2.036111 0.261324
+ 2.038889 0.242102
+ 2.041667 0.360066
+ 2.044444 0.258813
+ 2.047222 0.247129
+ 2.050000 0.360096
+ 2.052778 0.266347
+ 2.055556 0.244628
+ 2.058333 0.360061
+ 2.061111 0.271370
+ 2.063889 0.243402
+ 2.066667 0.360066
+ 2.069444 0.271370
+ 2.072222 0.243382
+ 2.075000 0.360096
+ 2.077778 0.262580
+ 2.080556 0.235828
+ 2.083333 0.360022
+ 2.086111 0.261324
+ 2.088889 0.227053
+ 2.091667 0.359993
+ 2.094444 0.256302
+ 2.097222 0.216969
+ 2.100000 0.359973
+ 2.102778 0.258813
+ 2.105556 0.220750
+ 2.108333 0.359963
+ 2.111111 0.256302
+ 2.113889 0.220750
+ 2.116667 0.359978
+ 2.119444 0.252535
+ 2.122222 0.214452
+ 2.125000 0.359958
+ 2.127778 0.255046
+ 2.130556 0.214448
+ 2.133333 0.359939
+ 2.136111 0.253790
+ 2.138889 0.216983
+ 2.141667 0.359958
+ 2.144444 0.238722
+ 2.147222 0.196790
+ 2.150000 0.359855
+ 2.152778 0.218632
+ 2.155556 0.167870
+ 2.158333 0.359752
+ 2.161111 0.305351
+ 2.163889 0.236093
+ 2.166667 0.380275
+ 2.169444 0.404554
+ 2.172222 0.460000
+ 2.175000 0.381167
+ 2.177778 0.331725
+ 2.180556 0.409091
+ 2.183333 0.360331
+ 2.186111 0.245001
+ 2.188889 0.180535
+ 2.191667 0.359865
+ 2.194444 0.248768
+ 2.197222 0.206889
+ 2.200000 0.359924
+ 2.202778 0.247512
+ 2.205556 0.208145
+ 2.208333 0.359919
+ 2.211111 0.248768
+ 2.213889 0.210685
+ 2.216667 0.359944
+ 2.219444 0.242489
+ 2.222222 0.209386
+ 2.225000 0.359939
+ 2.227778 0.248768
+ 2.230556 0.208145
+ 2.233333 0.359914
+ 2.236111 0.247512
+ 2.238889 0.208159
+ 2.241667 0.359934
+ 2.244444 0.241234
+ 2.247222 0.208125
+ 2.250000 0.359924
+ 2.252778 0.250023
+ 2.255556 0.208155
+ 2.258333 0.359919
+ 2.261111 0.247512
+ 2.263889 0.213182
+ 2.266667 0.359939
+ 2.269444 0.246256
+ 2.272222 0.209400
+ 2.275000 0.359944
+ 2.277778 0.246256
+ 2.280556 0.206889
+ 2.283333 0.359909
+ 2.286111 0.247512
+ 2.288889 0.209410
+ 2.291667 0.359914
+ 2.294444 0.241234
+ 2.297222 0.204358
+ 2.300000 0.359924
+ 2.302778 0.247512
+ 2.305556 0.209391
+ 2.308333 0.359939
+ 2.311111 0.243745
+ 2.313889 0.211897
+ 2.316667 0.359934
+ 2.319444 0.234955
+ 2.322222 0.206830
+ 2.325000 0.359924
+ 2.327778 0.237467
+ 2.330556 0.205579
+ 2.333333 0.359914
+ 2.336111 0.229933
+ 2.338889 0.213109
+ 2.341667 0.359929
+ 2.344444 0.221143
+ 2.347222 0.208042
+ 2.350000 0.359939
+ 2.352778 0.222399
+ 2.355556 0.204270
+ 2.358333 0.359899
+ 2.361111 0.217376
+ 2.363889 0.205525
+ 2.366667 0.359924
+ 2.369444 0.213609
+ 2.372222 0.202985
+ 2.375000 0.359909
+ 2.377778 0.219887
+ 2.380556 0.204275
+ 2.383333 0.359914
+ 2.386111 0.229933
+ 2.388889 0.213123
+ 2.391667 0.359948
+ 2.394444 0.237467
+ 2.397222 0.216905
+ 2.400000 0.359968
+ 2.402778 0.248768
+ 2.405556 0.223227
+ 2.408333 0.359978
+ 2.411111 0.252535
+ 2.413889 0.230781
+ 2.416667 0.360017
+ 2.419444 0.250023
+ 2.422222 0.232017
+ 2.425000 0.360027
+ 2.427778 0.256302
+ 2.430556 0.232037
+ 2.433333 0.360012
+ 2.436111 0.253790
+ 2.438889 0.235804
+ 2.441667 0.360027
+ 2.444444 0.247512
+ 2.447222 0.226985
+ 2.450000 0.360012
+ 2.452778 0.251279
+ 2.455556 0.225739
+ 2.458333 0.359988
+ 2.461111 0.248768
+ 2.463889 0.228265
+ 2.466667 0.360007
+ 2.469444 0.243745
+ 2.472222 0.225709
+ 2.475000 0.359993
+ 2.477778 0.250023
+ 2.480556 0.225734
+ 2.483333 0.359988
+ 2.486111 0.245001
+ 2.488889 0.226980
+ 2.491667 0.359998
+ 2.494444 0.242489
+ 2.497222 0.220682
+ 2.500000 0.359978
+ 2.502778 0.239978
+ 2.505556 0.215659
+ 2.508333 0.359968
+ 2.511111 0.242489
+ 2.513889 0.218195
+ 2.516667 0.359968
+ 2.519444 0.239978
+ 2.522222 0.218161
+ 2.525000 0.359958
+ 2.527778 0.243745
+ 2.530556 0.216915
+ 2.533333 0.359953
+ 2.536111 0.241234
+ 2.538889 0.216925
+ 2.541667 0.359968
+ 2.544444 0.237467
+ 2.547222 0.214384
+ 2.550000 0.359958
+ 2.552778 0.239978
+ 2.555556 0.220667
+ 2.558333 0.359963
+ 2.561111 0.241234
+ 2.563889 0.216920
+ 2.566667 0.359973
+ 2.569444 0.242489
+ 2.572222 0.218170
+ 2.575000 0.359978
+ 2.577778 0.239978
+ 2.580556 0.216900
+ 2.583333 0.359953
+ 2.586111 0.246256
+ 2.588889 0.218190
+ 2.591667 0.359988
+ 2.594444 0.232444
+ 2.597222 0.215635
+ 2.600000 0.359988
+ 2.602778 0.242489
+ 2.605556 0.230712
+ 2.608333 0.360012
+ 2.611111 0.242489
+ 2.613889 0.238281
+ 2.616667 0.360056
+ 2.619444 0.245001
+ 2.622222 0.240792
+ 2.625000 0.360071
+ 2.627778 0.247512
+ 2.630556 0.243308
+ 2.633333 0.360047
+ 2.636111 0.253790
+ 2.638889 0.239566
+ 2.641667 0.360042
+ 2.644444 0.245001
+ 2.647222 0.230747
+ 2.650000 0.360032
+ 2.652778 0.246256
+ 2.655556 0.234514
+ 2.658333 0.359998
+ 2.661111 0.242489
+ 2.663889 0.221957
+ 2.666667 0.359968
+ 2.669444 0.233700
+ 2.672222 0.210607
+ 2.675000 0.359953
+ 2.677778 0.239978
+ 2.680556 0.216905
+ 2.683333 0.359948
+ 2.686111 0.242489
+ 2.688889 0.214399
+ 2.691667 0.359944
+ 2.694444 0.234955
+ 2.697222 0.208096
+ 2.700000 0.359929
+ 2.702778 0.236211
+ 2.705556 0.204334
+ 2.708333 0.359919
+ 2.711111 0.232444
+ 2.713889 0.209366
+ 2.716667 0.359934
+ 2.719444 0.228677
+ 2.722222 0.200517
+ 2.725000 0.359875
+ 2.727778 0.211097
+ 2.730556 0.177852
+ 2.733333 0.359762
+ 2.736111 0.255046
+ 2.738889 0.198242
+ 2.741667 0.380108
+ 2.744444 0.329209
+ 2.747222 0.385621
+ 2.750000 0.380966
+ 2.752778 0.359350
+ 2.755556 0.155583
+ 2.758333 0.360674
+ 2.761111 0.197290
+ 2.763889 0.191679
+ 2.766667 0.359811
+ 2.769444 0.221143
+ 2.772222 0.196746
+ 2.775000 0.359904
+ 2.777778 0.228677
+ 2.780556 0.201778
+ 2.783333 0.359890
+ 2.786111 0.222399
+ 2.788889 0.199267
+ 2.791667 0.359895
+ 2.794444 0.223654
+ 2.797222 0.203034
+ 2.800000 0.359909
+ 2.802778 0.228677
+ 2.805556 0.200532
+ 2.808333 0.359895
+ 2.811111 0.227421
+ 2.813889 0.204304
+ 2.816667 0.359904
+ 2.819444 0.223654
+ 2.822222 0.197996
+ 2.825000 0.359895
+ 2.827778 0.223654
+ 2.830556 0.198011
+ 2.833333 0.359880
+ 2.836111 0.223654
+ 2.838889 0.196765
+ 2.841667 0.359890
+ 2.844444 0.219887
+ 2.847222 0.195480
+ 2.850000 0.359904
+ 2.852778 0.224910
+ 2.855556 0.196765
+ 2.858333 0.359885
+ 2.861111 0.222399
+ 2.863889 0.199272
+ 2.866667 0.359875
+ 2.869444 0.223654
+ 2.872222 0.196755
+ 2.875000 0.359890
+ 2.877778 0.224910
+ 2.880556 0.195495
+ 2.883333 0.359875
+ 2.886111 0.223654
+ 2.888889 0.198021
+ 2.891667 0.359885
+ 2.894444 0.218632
+ 2.897222 0.196721
+ 2.900000 0.359899
+ 2.902778 0.219887
+ 2.905556 0.199252
+ 2.908333 0.359885
+ 2.911111 0.217376
+ 2.913889 0.200503
+ 2.916667 0.359895
+ 2.919444 0.208586
+ 2.922222 0.195431
+ 2.925000 0.359880
+ 2.927778 0.207330
+ 2.930556 0.190394
+ 2.933333 0.359850
+ 2.936111 0.201052
+ 2.938889 0.190379
+ 2.941667 0.359850
+ 2.944444 0.189751
+ 2.947222 0.181545
+ 2.950000 0.359841
+ 2.952778 0.191007
+ 2.955556 0.182806
+ 2.958333 0.359841
+ 2.961111 0.193518
+ 2.963889 0.189123
+ 2.966667 0.359855
+ 2.969444 0.198541
+ 2.972222 0.191639
+ 2.975000 0.359865
+ 2.977778 0.216120
+ 2.980556 0.199237
+ 2.983333 0.359909
+ 2.986111 0.227421
+ 2.988889 0.211858
+ 2.991667 0.359944
+ 2.994444 0.233700
+ 2.997222 0.214379
+ 3.000000 0.359973
+ 3.002778 0.239978
+ 3.005556 0.223188
+ 3.008333 0.359983
+ 3.011111 0.241234
+ 3.013889 0.224459
+ 3.016667 0.359993
+ 3.019444 0.238722
+ 3.022222 0.223183
+ 3.025000 0.359993
+ 3.027778 0.246256
+ 3.030556 0.225709
+ 3.033333 0.359988
+ 3.036111 0.245001
+ 3.038889 0.226970
+ 3.041667 0.360002
+ 3.044444 0.241234
+ 3.047222 0.219431
+ 3.050000 0.359978
+ 3.052778 0.245001
+ 3.055556 0.219436
+ 3.058333 0.359963
+ 3.061111 0.245001
+ 3.063889 0.223208
+ 3.066667 0.359978
+ 3.069444 0.241234
+ 3.072222 0.218166
+ 3.075000 0.359978
+ 3.077778 0.242489
+ 3.080556 0.219426
+ 3.083333 0.359963
+ 3.086111 0.241234
+ 3.088889 0.221937
+ 3.091667 0.359978
+ 3.094444 0.237467
+ 3.097222 0.219421
+ 3.100000 0.359973
+ 3.102778 0.239978
+ 3.105556 0.216905
+ 3.108333 0.359953
+ 3.111111 0.237467
+ 3.113889 0.216915
+ 3.116667 0.359968
+ 3.119444 0.236211
+ 3.122222 0.213138
+ 3.125000 0.359958
+ 3.127778 0.238722
+ 3.130556 0.213138
+ 3.133333 0.359948
+ 3.136111 0.239978
+ 3.138889 0.219431
+ 3.141667 0.359973
+ 3.144444 0.237467
+ 3.147222 0.214384
+ 3.150000 0.359978
+ 3.152778 0.241234
+ 3.155556 0.216905
+ 3.158333 0.359948
+ 3.161111 0.237467
+ 3.163889 0.215659
+ 3.166667 0.359953
+ 3.169444 0.237467
+ 3.172222 0.214394
+ 3.175000 0.359963
+ 3.177778 0.241234
+ 3.180556 0.215654
+ 3.183333 0.359953
+ 3.186111 0.242489
+ 3.188889 0.219436
+ 3.191667 0.359968
+ 3.194444 0.237467
+ 3.197222 0.216890
+ 3.200000 0.359968
+ 3.202778 0.241234
+ 3.205556 0.219426
+ 3.208333 0.359968
+ 3.211111 0.238722
+ 3.213889 0.226960
+ 3.216667 0.360012
+ 3.219444 0.239978
+ 3.222222 0.230717
+ 3.225000 0.360037
+ 3.227778 0.243745
+ 3.230556 0.235765
+ 3.233333 0.360042
+ 3.236111 0.247512
+ 3.238889 0.244584
+ 3.241667 0.360071
+ 3.244444 0.250023
+ 3.247222 0.240802
+ 3.250000 0.360056
+ 3.252778 0.250023
+ 3.255556 0.240812
+ 3.258333 0.360047
+ 3.261111 0.252535
+ 3.263889 0.243348
+ 3.266667 0.360056
+ 3.269444 0.250023
+ 3.272222 0.237040
+ 3.275000 0.360066
+ 3.277778 0.250023
+ 3.280556 0.239541
+ 3.283333 0.360017
+ 3.286111 0.247512
+ 3.288889 0.224478
+ 3.291667 0.359973
+ 3.294444 0.241234
+ 3.297222 0.211897
+ 3.300000 0.359953
+ 3.302778 0.243745
+ 3.305556 0.214399
+ 3.308333 0.359958
+ 3.311111 0.238722
+ 3.313889 0.218175
+ 3.316667 0.359973
+ 3.319444 0.238722
+ 3.322222 0.213133
+ 3.325000 0.359958
+ 3.327778 0.241234
+ 3.330556 0.213143
+ 3.333333 0.359919
+ 3.336111 0.242489
+ 3.338889 0.214418
+ 3.341667 0.359953
+ 3.344444 0.238722
+ 3.347222 0.210617
+ 3.350000 0.359934
+ 3.352778 0.222399
+ 3.355556 0.189197
+ 3.358333 0.359831
+ 3.361111 0.207330
+ 3.363889 0.167875
+ 3.366667 0.359767
+ 3.369444 0.314141
+ 3.372222 0.253727
+ 3.375000 0.380373
+ 3.377778 0.432179
+ 3.380556 0.160007
+ 3.383333 0.381231
+ 3.386111 0.348049
+ 3.388889 0.427990
+ 3.391667 0.360390
+ 3.394444 0.228677
+ 3.397222 0.181722
+ 3.400000 0.359860
+ 3.402778 0.237467
+ 3.405556 0.204324
+ 3.408333 0.359904
+ 3.411111 0.232444
+ 3.413889 0.206850
+ 3.416667 0.359909
+ 3.419444 0.228677
+ 3.422222 0.200552
+ 3.425000 0.359914
+ 3.427778 0.233700
+ 3.430556 0.204319
+ 3.433333 0.359899
+ 3.436111 0.234955
+ 3.438889 0.204334
+ 3.441667 0.359909
+ 3.444444 0.228677
+ 3.447222 0.204314
+ 3.450000 0.359919
+ 3.452778 0.231188
+ 3.455556 0.206830
+ 3.458333 0.359909
+ 3.461111 0.233700
+ 3.463889 0.208115
+ 3.466667 0.359929
+ 3.469444 0.231188
+ 3.472222 0.205570
+ 3.475000 0.359919
+ 3.477778 0.233700
+ 3.480556 0.204334
+ 3.483333 0.359909
+ 3.486111 0.233700
+ 3.488889 0.206845
+ 3.491667 0.359929
+ 3.494444 0.228677
+ 3.497222 0.201807
+ 3.500000 0.359919
+ 3.502778 0.234955
+ 3.505556 0.208086
+ 3.508333 0.359909
+ 3.511111 0.231188
+ 3.513889 0.208086
+ 3.516667 0.359934
+ 3.519444 0.226166
+ 3.522222 0.204294
+ 3.525000 0.359919
+ 3.527778 0.228677
+ 3.530556 0.204289
+ 3.533333 0.359914
+ 3.536111 0.224910
+ 3.538889 0.208066
+ 3.541667 0.359929
+ 3.544444 0.217376
+ 3.547222 0.206776
+ 3.550000 0.359934
+ 3.552778 0.214865
+ 3.555556 0.206742
+ 3.558333 0.359909
+ 3.561111 0.206075
+ 3.563889 0.205481
+ 3.566667 0.359914
+ 3.569444 0.199796
+ 3.572222 0.199169
+ 3.575000 0.359904
+ 3.577778 0.201052
+ 3.580556 0.199169
+ 3.583333 0.359885
+ 3.586111 0.197285
+ 3.588889 0.200429
+ 3.591667 0.359909
+ 3.594444 0.201052
+ 3.597222 0.200439
+ 3.600000 0.359909
+ 3.602778 0.217376
+ 3.605556 0.211809
+ 3.608333 0.359948
+ 3.611111 0.229933
+ 3.613889 0.223183
+ 3.616667 0.359988
+ 3.619444 0.237467
+ 3.622222 0.225704
+ 3.625000 0.359998
+ 3.627778 0.248768
+ 3.630556 0.228235
+ 3.633333 0.360002
+ 3.636111 0.252535
+ 3.638889 0.234558
+ 3.641667 0.360027
+ 3.644444 0.248768
+ 3.647222 0.234533
+ 3.650000 0.360042
+ 3.652778 0.253790
+ 3.655556 0.233288
+ 3.658333 0.360012
+ 3.661111 0.252535
+ 3.663889 0.233288
+ 3.666667 0.360027
+ 3.669444 0.248768
+ 3.672222 0.230752
+ 3.675000 0.360037
+ 3.677778 0.255046
+ 3.680556 0.233288
+ 3.683333 0.360007
+ 3.686111 0.252535
+ 3.688889 0.229521
+ 3.691667 0.360012
+ 3.694444 0.248768
+ 3.697222 0.226985
+ 3.700000 0.360012
+ 3.702778 0.247512
+ 3.705556 0.225739
+ 3.708333 0.359993
+ 3.711111 0.250023
+ 3.713889 0.224483
+ 3.716667 0.359998
+ 3.719444 0.241234
+ 3.722222 0.223193
+ 3.725000 0.359993
+ 3.727778 0.248768
+ 3.730556 0.221952
+ 3.733333 0.359988
+ 3.736111 0.243745
+ 3.738889 0.223208
+ 3.741667 0.359993
+ 3.744444 0.241234
+ 3.747222 0.218170
+ 3.750000 0.359968
+ 3.752778 0.242489
+ 3.755556 0.218175
+ 3.758333 0.359958
+ 3.761111 0.239978
+ 3.763889 0.220692
+ 3.766667 0.359978
+ 3.769444 0.236211
+ 3.772222 0.216905
+ 3.775000 0.359958
+ 3.777778 0.241234
+ 3.780556 0.220677
+ 3.783333 0.359963
+ 3.786111 0.239978
+ 3.788889 0.220682
+ 3.791667 0.359988
+ 3.794444 0.238722
+ 3.797222 0.216910
+ 3.800000 0.359973
+ 3.802778 0.239978
+ 3.805556 0.216915
+ 3.808333 0.359953
+ 3.811111 0.238722
+ 3.813889 0.220687
+ 3.816667 0.359983
+ 3.819444 0.238722
+ 3.822222 0.219426
+ 3.825000 0.359978
+ 3.827778 0.242489
+ 3.830556 0.221933
+ 3.833333 0.359968
+ 3.836111 0.238722
+ 3.838889 0.224454
+ 3.841667 0.359983
+ 3.844444 0.237467
+ 3.847222 0.220672
+ 3.850000 0.359993
+ 3.852778 0.242489
+ 3.855556 0.225695
+ 3.858333 0.360012
+ 3.861111 0.243745
+ 3.863889 0.235765
+ 3.866667 0.360037
+ 3.869444 0.242489
+ 3.872222 0.240773
+ 3.875000 0.360056
+ 3.877778 0.248768
+ 3.880556 0.245825
+ 3.883333 0.360066
+ 3.886111 0.248768
+ 3.888889 0.244584
+ 3.891667 0.360066
+ 3.894444 0.255046
+ 3.897222 0.239571
+ 3.900000 0.360076
+ 3.902778 0.255046
+ 3.905556 0.239571
+ 3.908333 0.360056
+ 3.911111 0.253790
+ 3.913889 0.252128
+ 3.916667 0.360071
+ 3.919444 0.245001
+ 3.922222 0.226970
+ 3.925000 0.359998
+ 3.927778 0.243745
+ 3.930556 0.218185
+ 3.933333 0.359953
+ 3.936111 0.239978
+ 3.938889 0.218175
+ 3.941667 0.359953
+ 3.944444 0.237467
+ 3.947222 0.211868
+ 3.950000 0.359948
+ 3.952778 0.238722
+ 3.955556 0.210617
+ 3.958333 0.359934
+ 3.961111 0.237467
+ 3.963889 0.211902
+ 3.966667 0.359948
+ 3.969444 0.234955
+ 3.972222 0.211858
+ 3.975000 0.359944
+ 3.977778 0.237467
+ 3.980556 0.209342
+ 3.983333 0.359904
+ 3.986111 0.216120
+ 3.988889 0.185415
+ 3.991667 0.359831
+ 3.994444 0.201052
+ 3.997222 0.175281
+ 4.000000 0.359772
+ 4.002778 0.214865
+ 4.005556 0.159134
+ 4.008333 0.379882
+ 4.011111 0.324186
+ 4.013889 0.265042
+ 4.016667 0.380422
+ 4.019444 0.427156
+ 4.022222 0.159963
+ 4.025000 0.381207
+ 4.027778 0.329214
+ 4.030556 0.402803
+ 4.033333 0.360287
+ 4.036111 0.227421
+ 4.038889 0.182968
+ 4.041667 0.359845
+ 4.044444 0.227421
+ 4.047222 0.203044
+ 4.050000 0.359909
+ 4.052778 0.226166
+ 4.055556 0.205560
+ 4.058333 0.359909
+ 4.061111 0.228677
+ 4.063889 0.205570
+ 4.066667 0.359914
+ 4.069444 0.224910
+ 4.072222 0.199267
+ 4.075000 0.359919
+ 4.077778 0.229933
+ 4.080556 0.201793
+ 4.083333 0.359899
+ 4.086111 0.227421
+ 4.088889 0.206820
+ 4.091667 0.359919
+ 4.094444 0.226166
+ 4.097222 0.203048
+ 4.100000 0.359924
+ 4.102778 0.229933
+ 4.105556 0.204319
+ 4.108333 0.359899
+ 4.111111 0.229933
+ 4.113889 0.206830
+ 4.116667 0.359914
+ 4.119444 0.228677
+ 4.122222 0.201783
+ 4.125000 0.359924
+ 4.127778 0.232444
+ 4.130556 0.206820
+ 4.133333 0.359914
+ 4.136111 0.228677
+ 4.138889 0.209346
+ 4.141667 0.359934
+ 4.144444 0.227421
+ 4.147222 0.201783
+ 4.150000 0.359924
+ 4.152778 0.227421
+ 4.155556 0.204289
+ 4.158333 0.359909
+ 4.161111 0.226166
+ 4.163889 0.205550
+ 4.166667 0.359914
+ 4.169444 0.221143
+ 4.172222 0.204270
+ 4.175000 0.359924
+ 4.177778 0.219887
+ 4.180556 0.205521
+ 4.183333 0.359895
+ 4.186111 0.216120
+ 4.188889 0.205521
+ 4.191667 0.359919
+ 4.194444 0.207330
+ 4.197222 0.204226
+ 4.200000 0.359924
+ 4.202778 0.208586
+ 4.205556 0.205476
+ 4.208333 0.359909
+ 4.211111 0.198541
+ 4.213889 0.202941
+ 4.216667 0.359899
+ 4.219444 0.193518
+ 4.222222 0.200400
+ 4.225000 0.359909
+ 4.227778 0.196029
+ 4.230556 0.204177
+ 4.233333 0.359890
+ 4.236111 0.198541
+ 4.238889 0.206712
+ 4.241667 0.359914
+ 4.244444 0.203563
+ 4.247222 0.207988
+ 4.250000 0.359939
+ 4.252778 0.221143
+ 4.255556 0.216866
+ 4.258333 0.359953
+ 4.261111 0.233700
+ 4.263889 0.224434
+ 4.266667 0.359988
+ 4.269444 0.238722
+ 4.272222 0.228216
+ 4.275000 0.360012
+ 4.277778 0.247512
+ 4.280556 0.226960
+ 4.283333 0.360002
+ 4.286111 0.250023
+ 4.288889 0.230761
+ 4.291667 0.360012
+ 4.294444 0.245001
+ 4.297222 0.226975
+ 4.300000 0.360022
+ 4.302778 0.250023
+ 4.305556 0.232002
+ 4.308333 0.360017
+ 4.311111 0.245001
+ 4.313889 0.230747
+ 4.316667 0.360012
+ 4.319444 0.241234
+ 4.322222 0.223198
+ 4.325000 0.360002
+ 4.327778 0.243745
+ 4.330556 0.225704
+ 4.333333 0.359993
+ 4.336111 0.241234
+ 4.338889 0.228235
+ 4.341667 0.359993
+ 4.344444 0.234955
+ 4.347222 0.220657
+ 4.350000 0.359988
+ 4.352778 0.241234
+ 4.355556 0.223193
+ 4.358333 0.359968
+ 4.361111 0.238722
+ 4.363889 0.223188
+ 4.366667 0.359993
+ 4.369444 0.236211
+ 4.372222 0.216885
+ 4.375000 0.359968
+ 4.377778 0.237467
+ 4.380556 0.216885
+ 4.383333 0.359948
+ 4.386111 0.232444
+ 4.388889 0.216900
+ 4.391667 0.359958
+ 4.394444 0.232444
+ 4.397222 0.213113
+ 4.400000 0.359953
+ 4.402778 0.233700
+ 4.405556 0.216890
+ 4.408333 0.359944
+ 4.411111 0.232444
+ 4.413889 0.216880
+ 4.416667 0.359968
+ 4.419444 0.229933
+ 4.422222 0.214369
+ 4.425000 0.359953
+ 4.427778 0.236211
+ 4.430556 0.215635
+ 4.433333 0.359948
+ 4.436111 0.234955
+ 4.438889 0.218146
+ 4.441667 0.359948
+ 4.444444 0.227421
+ 4.447222 0.210582
+ 4.450000 0.359948
+ 4.452778 0.234955
+ 4.455556 0.211863
+ 4.458333 0.359944
+ 4.461111 0.233700
+ 4.463889 0.218151
+ 4.466667 0.359963
+ 4.469444 0.227421
+ 4.472222 0.216871
+ 4.475000 0.359978
+ 4.477778 0.231188
+ 4.480556 0.229437
+ 4.483333 0.360017
+ 4.486111 0.232444
+ 4.488889 0.231968
+ 4.491667 0.360017
+ 4.494444 0.236211
+ 4.497222 0.235730
+ 4.500000 0.360047
+ 4.502778 0.241234
+ 4.505556 0.239497
+ 4.508333 0.360042
+ 4.511111 0.243745
+ 4.513889 0.238271
+ 4.516667 0.360052
+ 4.519444 0.242489
+ 4.522222 0.238251
+ 4.525000 0.360042
+ 4.527778 0.245001
+ 4.530556 0.231983
+ 4.533333 0.360042
+ 4.536111 0.238722
+ 4.538889 0.242018
+ 4.541667 0.360037
+ 4.544444 0.229933
+ 4.547222 0.225655
+ 4.550000 0.360007
+ 4.552778 0.234955
+ 4.555556 0.215625
+ 4.558333 0.359944
+ 4.561111 0.228677
+ 4.563889 0.213109
+ 4.566667 0.359944
+ 4.569444 0.224910
+ 4.572222 0.208052
+ 4.575000 0.359929
+ 4.577778 0.227421
+ 4.580556 0.206815
+ 4.583333 0.359914
+ 4.586111 0.227421
+ 4.588889 0.208076
+ 4.591667 0.359939
+ 4.594444 0.221143
+ 4.597222 0.203024
+ 4.600000 0.359924
+ 4.602778 0.224910
+ 4.605556 0.203019
+ 4.608333 0.359895
+ 4.611111 0.204819
+ 4.613889 0.180363
+ 4.616667 0.359792
+ 4.619444 0.206075
+ 4.622222 0.157844
+ 4.625000 0.359796
+ 4.627778 0.292716
+ 4.630556 0.263635
+ 4.633333 0.380451
+ 4.636111 0.385719
+ 4.638889 0.162259
+ 4.641667 0.381143
+ 4.644444 0.238727
+ 4.647222 0.319698
+ 4.650000 0.360091
+ 4.652778 0.208586
+ 4.655556 0.172844
+ 4.658333 0.359811
+ 4.661111 0.212353
+ 4.663889 0.192969
+ 4.666667 0.359870
+ 4.669444 0.213609
+ 4.672222 0.195451
+ 4.675000 0.359885
+ 4.677778 0.216120
+ 4.680556 0.194210
+ 4.683333 0.359860
+ 4.686111 0.214865
+ 4.688889 0.197987
+ 4.691667 0.359885
+ 4.694444 0.208586
+ 4.697222 0.195446
+ 4.700000 0.359880
+ 4.702778 0.217376
+ 4.705556 0.194210
+ 4.708333 0.359870
+ 4.711111 0.216120
+ 4.713889 0.197987
+ 4.716667 0.359890
+ 4.719444 0.212353
+ 4.722222 0.196721
+ 4.725000 0.359890
+ 4.727778 0.218632
+ 4.730556 0.192969
+ 4.733333 0.359870
+ 4.736111 0.213609
+ 4.738889 0.192954
+ 4.741667 0.359875
+ 4.744444 0.213609
+ 4.747222 0.190433
+ 4.750000 0.359865
+ 4.752778 0.216120
+ 4.755556 0.189177
+ 4.758333 0.359855
+ 4.761111 0.216120
+ 4.763889 0.190457
+ 4.766667 0.359870
+ 4.769444 0.214865
+ 4.772222 0.192949
+ 4.775000 0.359870
+ 4.777778 0.217376
+ 4.780556 0.194205
+ 4.783333 0.359855
+ 4.786111 0.213609
+ 4.788889 0.195456
+ 4.791667 0.359875
+ 4.794444 0.211097
+ 4.797222 0.192929
+ 4.800000 0.359870
+ 4.802778 0.208586
+ 4.805556 0.191669
+ 4.808333 0.359860
+ 4.811111 0.203563
+ 4.813889 0.197937
+ 4.816667 0.359880
+ 4.819444 0.193518
+ 4.822222 0.191595
+ 4.825000 0.359865
+ 4.827778 0.192262
+ 4.830556 0.187828
+ 4.833333 0.359831
+ 4.836111 0.184728
+ 4.838889 0.186568
+ 4.841667 0.359845
+ 4.844444 0.182217
+ 4.847222 0.186533
+ 4.850000 0.359841
+ 4.852778 0.183473
+ 4.855556 0.184022
+ 4.858333 0.359836
+ 4.861111 0.189751
+ 4.863889 0.190364
+ 4.866667 0.359865
+ 4.869444 0.199796
+ 4.872222 0.200434
+ 4.875000 0.359904
+ 4.877778 0.209842
+ 4.880556 0.202980
+ 4.883333 0.359919
+ 4.886111 0.224910
+ 4.888889 0.219367
+ 4.891667 0.359968
+ 4.894444 0.217376
+ 4.897222 0.214315
+ 4.900000 0.359963
+ 4.902778 0.224910
+ 4.905556 0.215605
+ 4.908333 0.359948
+ 4.911111 0.222399
+ 4.913889 0.218112
+ 4.916667 0.359968
+ 4.919444 0.222399
+ 4.922222 0.215576
+ 4.925000 0.359973
+ 4.927778 0.224910
+ 4.930556 0.219357
+ 4.933333 0.359958
+ 4.936111 0.223654
+ 4.938889 0.216856
+ 4.941667 0.359968
+ 4.944444 0.218632
+ 4.947222 0.211799
+ 4.950000 0.359958
+ 4.952778 0.222399
+ 4.955556 0.214325
+ 4.958333 0.359948
+ 4.961111 0.218632
+ 4.963889 0.220603
+ 4.966667 0.359978
+ 4.969444 0.219887
+ 4.972222 0.213055
+ 4.975000 0.359958
+ 4.977778 0.213609
+ 4.980556 0.210529
+ 4.983333 0.359924
+ 4.986111 0.212353
+ 4.988889 0.209288
+ 4.991667 0.359934
+ 4.994444 0.211097
+ 4.997222 0.209258
+ 5.000000 0.359939
+ 5.002778 0.212353
+ 5.005556 0.208012
+ 5.008333 0.359929
+ 5.011111 0.211097
+ 5.013889 0.211794
+ 5.016667 0.359939
+ 5.019444 0.209842
+ 5.022222 0.206747
+ 5.025000 0.359924
+ 5.027778 0.212353
+ 5.030556 0.208002
+ 5.033333 0.359919
+ 5.036111 0.211097
+ 5.038889 0.208022
+ 5.041667 0.359929
+ 5.044444 0.212353
+ 5.047222 0.205476
+ 5.050000 0.359929
+ 5.052778 0.211097
+ 5.055556 0.208007
+ 5.058333 0.359934
+ 5.061111 0.211097
+ 5.063889 0.210519
+ 5.066667 0.359939
+ 5.069444 0.207330
+ 5.072222 0.205486
+ 5.075000 0.359929
+ 5.077778 0.213609
+ 5.080556 0.207998
+ 5.083333 0.359929
+ 5.086111 0.208586
+ 5.088889 0.211779
+ 5.091667 0.359948
+ 5.094444 0.209842
+ 5.097222 0.206742
+ 5.100000 0.359948
+ 5.102778 0.212353
+ 5.105556 0.216792
+ 5.108333 0.359958
+ 5.111111 0.213609
+ 5.113889 0.225611
+ 5.116667 0.360012
+ 5.119444 0.216120
+ 5.122222 0.229368
+ 5.125000 0.360042
+ 5.127778 0.221143
+ 5.130556 0.234406
+ 5.133333 0.360022
+ 5.136111 0.221143
+ 5.138889 0.233175
+ 5.141667 0.360022
+ 5.144444 0.222399
+ 5.147222 0.223115
+ 5.150000 0.359998
+ 5.152778 0.221143
+ 5.155556 0.231899
+ 5.158333 0.360017
+ 5.161111 0.218632
+ 5.163889 0.220603
+ 5.166667 0.359973
+ 5.169444 0.208586
+ 5.172222 0.208007
+ 5.175000 0.359929
+ 5.177778 0.212353
+ 5.180556 0.202990
+ 5.183333 0.359909
+ 5.186111 0.209842
+ 5.188889 0.206752
+ 5.191667 0.359914
+ 5.194444 0.211097
+ 5.197222 0.200478
+ 5.200000 0.359904
+ 5.202778 0.213609
+ 5.205556 0.199227
+ 5.208333 0.359890
+ 5.211111 0.211097
+ 5.213889 0.205516
+ 5.216667 0.359909
+ 5.219444 0.213609
+ 5.222222 0.200473
+ 5.225000 0.359904
+ 5.227778 0.207330
+ 5.230556 0.194156
+ 5.233333 0.359836
+ 5.236111 0.188495
+ 5.238889 0.174011
+ 5.241667 0.359757
+ 5.244444 0.227421
+ 5.247222 0.183061
+ 5.250000 0.380044
+ 5.252778 0.315397
+ 5.255556 0.341614
+ 5.258333 0.380785
+ 5.261111 0.397020
+ 5.263889 0.187299
+ 5.266667 0.361008
+ 5.269444 0.184733
+ 5.272222 0.243039
+ 5.275000 0.359890
+ 5.277778 0.204819
+ 5.280556 0.177857
+ 5.283333 0.359831
+ 5.286111 0.211097
+ 5.288889 0.194205
+ 5.291667 0.359865
+ 5.294444 0.212353
+ 5.297222 0.195451
+ 5.300000 0.359885
+ 5.302778 0.211097
+ 5.305556 0.195460
+ 5.308333 0.359860
+ 5.311111 0.209842
+ 5.313889 0.195475
+ 5.316667 0.359875
+ 5.319444 0.208586
+ 5.322222 0.190423
+ 5.325000 0.359870
+ 5.327778 0.217376
+ 5.330556 0.187931
+ 5.333333 0.359841
+ 5.336111 0.213609
+ 5.338889 0.190448
+ 5.341667 0.359850
+ 5.344444 0.213609
+ 5.347222 0.189177
+ 5.350000 0.359860
+ 5.352778 0.217376
+ 5.355556 0.189187
+ 5.358333 0.359855
+ 5.361111 0.216120
+ 5.363889 0.192959
+ 5.366667 0.359870
+ 5.369444 0.212353
+ 5.372222 0.190433
+ 5.375000 0.359865
+ 5.377778 0.218632
+ 5.380556 0.191698
+ 5.383333 0.359850
+ 5.386111 0.208586
+ 5.388889 0.191693
+ 5.391667 0.359860
+ 5.394444 0.211097
+ 5.397222 0.187917
+ 5.400000 0.359855
+ 5.402778 0.212353
+ 5.405556 0.189172
+ 5.408333 0.359841
+ 5.411111 0.207330
+ 5.413889 0.189177
+ 5.416667 0.359860
+ 5.419444 0.203563
+ 5.422222 0.187887
+ 5.425000 0.359855
+ 5.427778 0.206075
+ 5.430556 0.194161
+ 5.433333 0.359855
+ 5.436111 0.198541
+ 5.438889 0.190384
+ 5.441667 0.359860
+ 5.444444 0.189751
+ 5.447222 0.185312
+ 5.450000 0.359860
+ 5.452778 0.188495
+ 5.455556 0.181545
+ 5.458333 0.359816
+ 5.461111 0.183473
+ 5.463889 0.179009
+ 5.466667 0.359816
+ 5.469444 0.177194
+ 5.472222 0.173977
+ 5.475000 0.359821
+ 5.477778 0.183473
+ 5.480556 0.181540
+ 5.483333 0.359826
+ 5.486111 0.199796
+ 5.488889 0.191654
+ 5.491667 0.359880
+ 5.494444 0.209842
+ 5.497222 0.199208
+ 5.500000 0.359914
+ 5.502778 0.222399
+ 5.505556 0.203039
+ 5.508333 0.359904
+ 5.511111 0.227421
+ 5.513889 0.213104
+ 5.516667 0.359948
+ 5.519444 0.232444
+ 5.522222 0.211853
+ 5.525000 0.359958
+ 5.527778 0.236211
+ 5.530556 0.215630
+ 5.533333 0.359958
+ 5.536111 0.234955
+ 5.538889 0.218156
+ 5.541667 0.359968
+ 5.544444 0.229933
+ 5.547222 0.215625
+ 5.550000 0.359958
+ 5.552778 0.236211
+ 5.555556 0.213128
+ 5.558333 0.359939
+ 5.561111 0.231188
+ )

* R-peak detector
Vthresh rpeak_threshold 0 0.4
Xrpeak ecg_amp_l0 rpeak_threshold rpeak_pulse vdd vss vbias rpeak_detector

* Delay timer
Xdelay rpeak_pulse trig_s14 trig_s69 trig_wid trig_bi_copy trig_rr_copy vdd vss vbias vth_14 vth_69 vth_83 vth_300 vth_10 delay_timer
Vth14 vth_14 0 0.4757
Vth69 vth_69 0 0.4471
Vth83 vth_83 0 0.4684
Vth300 vth_300 0 0.3269
Vth10 vth_10 0 0.2282

* RR timing (F1, F2)
Xrr ecg_amp_l0 trig_rr_cap rpeak_pulse trig_rr_copy f1_rr_ratio f2_rr_asym rr_timer_node rr_ewma_node vdd vss vbias rr_timing

* P-wave predictor
Vthpb vth_pw_base 0 0.157
Vthpp vth_pw_peak 0 0.118
Xpw rr_timer_node rr_ewma_node trig_pw_base trig_pw_peak trig_rr_cap vth_pw_base vth_pw_peak vdd vss vbias pwave_predictor

* Features
Xbi_l0 ecg_amp_l0 rpeak_pulse trig_bi_copy f3_bi_l0 vdd vss vbias beat_instability
Xbi_l1 ecg_amp_l1 rpeak_pulse trig_bi_copy f4_bi_l1 vdd vss vbias beat_instability
Xpwave ecg_amp_l0 trig_pw_base trig_pw_peak f5_pwave vdd vss vbias pwave_diff
Xwidth ecg_amp_l0 trig_wid f6_width vdd vss qrs_width
Xslope ecg_amp_l0 trig_s14 trig_s69 f7_slope vdd vss vbias qrs_slope
Xsym ecg_amp_l0 rpeak_pulse f8_symmetry vdd vss qrs_symmetry

* Initial conditions
.ic v(xdelay.timer_node) = 0.9
.ic v(xdelay.timer2) = 0.9
.ic v(xrr.net_timer) = 0.9
.ic v(xrr.ewma_node) = 0.15
.ic v(xrr.prev_node) = 0.15

.tran 0.5m 5.564 uic

.meas tran f1_rr_ratio_b1 FIND V(f1_rr_ratio) AT=0.842778
.meas tran f2_rr_asym_b1 FIND V(f2_rr_asym) AT=0.842778
.meas tran f3_bi_l0_b1 FIND V(f3_bi_l0) AT=0.842778
.meas tran f4_bi_l1_b1 FIND V(f4_bi_l1) AT=0.842778
.meas tran f5_pwave_b1 FIND V(f5_pwave) AT=0.842778
.meas tran f6_width_b1 FIND V(f6_width) AT=0.842778
.meas tran f7_slope_b1 FIND V(f7_slope) AT=0.842778
.meas tran f8_symmetry_b1 FIND V(f8_symmetry) AT=0.842778
.meas tran ecg_b1 FIND V(ecg_amp_l0) AT=0.852778
.meas tran f1_rr_ratio_b2 FIND V(f1_rr_ratio) AT=1.837222
.meas tran f2_rr_asym_b2 FIND V(f2_rr_asym) AT=1.837222
.meas tran f3_bi_l0_b2 FIND V(f3_bi_l0) AT=1.837222
.meas tran f4_bi_l1_b2 FIND V(f4_bi_l1) AT=1.837222
.meas tran f5_pwave_b2 FIND V(f5_pwave) AT=1.837222
.meas tran f6_width_b2 FIND V(f6_width) AT=1.837222
.meas tran f7_slope_b2 FIND V(f7_slope) AT=1.837222
.meas tran f8_symmetry_b2 FIND V(f8_symmetry) AT=1.837222
.meas tran ecg_b2 FIND V(ecg_amp_l0) AT=1.847222
.meas tran f1_rr_ratio_b3 FIND V(f1_rr_ratio) AT=2.681667
.meas tran f2_rr_asym_b3 FIND V(f2_rr_asym) AT=2.681667
.meas tran f3_bi_l0_b3 FIND V(f3_bi_l0) AT=2.681667
.meas tran f4_bi_l1_b3 FIND V(f4_bi_l1) AT=2.681667
.meas tran f5_pwave_b3 FIND V(f5_pwave) AT=2.681667
.meas tran f6_width_b3 FIND V(f6_width) AT=2.681667
.meas tran f7_slope_b3 FIND V(f7_slope) AT=2.681667
.meas tran f8_symmetry_b3 FIND V(f8_symmetry) AT=2.681667
.meas tran ecg_b3 FIND V(ecg_amp_l0) AT=2.691667
.meas tran f1_rr_ratio_b4 FIND V(f1_rr_ratio) AT=3.492778
.meas tran f2_rr_asym_b4 FIND V(f2_rr_asym) AT=3.492778
.meas tran f3_bi_l0_b4 FIND V(f3_bi_l0) AT=3.492778
.meas tran f4_bi_l1_b4 FIND V(f4_bi_l1) AT=3.492778
.meas tran f5_pwave_b4 FIND V(f5_pwave) AT=3.492778
.meas tran f6_width_b4 FIND V(f6_width) AT=3.492778
.meas tran f7_slope_b4 FIND V(f7_slope) AT=3.492778
.meas tran f8_symmetry_b4 FIND V(f8_symmetry) AT=3.492778
.meas tran ecg_b4 FIND V(ecg_amp_l0) AT=3.502778
.meas tran f1_rr_ratio_b5 FIND V(f1_rr_ratio) AT=4.281667
.meas tran f2_rr_asym_b5 FIND V(f2_rr_asym) AT=4.281667
.meas tran f3_bi_l0_b5 FIND V(f3_bi_l0) AT=4.281667
.meas tran f4_bi_l1_b5 FIND V(f4_bi_l1) AT=4.281667
.meas tran f5_pwave_b5 FIND V(f5_pwave) AT=4.281667
.meas tran f6_width_b5 FIND V(f6_width) AT=4.281667
.meas tran f7_slope_b5 FIND V(f7_slope) AT=4.281667
.meas tran f8_symmetry_b5 FIND V(f8_symmetry) AT=4.281667
.meas tran ecg_b5 FIND V(ecg_amp_l0) AT=4.291667
.meas tran rpk_at_1 FIND V(rpeak_pulse) AT=0.838889
.meas tran ecg_at_pk_1 FIND V(ecg_amp_l0) AT=0.838889
.meas tran rpk_at_2 FIND V(rpeak_pulse) AT=1.838889
.meas tran ecg_at_pk_2 FIND V(ecg_amp_l0) AT=1.838889
.meas tran rpk_at_3 FIND V(rpeak_pulse) AT=2.680556
.meas tran ecg_at_pk_3 FIND V(ecg_amp_l0) AT=2.680556
.meas tran rpk_at_4 FIND V(rpeak_pulse) AT=3.505556
.meas tran ecg_at_pk_4 FIND V(ecg_amp_l0) AT=3.505556
.meas tran rpk_at_5 FIND V(rpeak_pulse) AT=4.305556
.meas tran ecg_at_pk_5 FIND V(ecg_amp_l0) AT=4.305556
.meas tran tmr_2ms_b1 FIND V(xdelay.timer_node) AT=0.840889
.meas tran sf_2ms_b1 FIND V(xdelay.sf_timer) AT=0.840889
.meas tran tmr_14ms_b1 FIND V(xdelay.timer_node) AT=0.852889
.meas tran sf_14ms_b1 FIND V(xdelay.sf_timer) AT=0.852889
.meas tran tmr_28ms_b1 FIND V(xdelay.timer_node) AT=0.866889
.meas tran sf_28ms_b1 FIND V(xdelay.sf_timer) AT=0.866889
.meas tran tmr_69ms_b1 FIND V(xdelay.timer_node) AT=0.907889
.meas tran sf_69ms_b1 FIND V(xdelay.sf_timer) AT=0.907889
.meas tran tmr_192ms_b1 FIND V(xdelay.timer_node) AT=1.030889
.meas tran sf_192ms_b1 FIND V(xdelay.sf_timer) AT=1.030889
.meas tran trig_s14_b1 FIND V(trig_s14) AT=0.878889
.meas tran trig_wid_b1 FIND V(trig_wid) AT=0.868889
.meas tran trig_s69_b1 FIND V(trig_s69) AT=1.033889
.meas tran tmr_2ms_b2 FIND V(xdelay.timer_node) AT=1.840889
.meas tran sf_2ms_b2 FIND V(xdelay.sf_timer) AT=1.840889
.meas tran tmr_14ms_b2 FIND V(xdelay.timer_node) AT=1.852889
.meas tran sf_14ms_b2 FIND V(xdelay.sf_timer) AT=1.852889
.meas tran tmr_28ms_b2 FIND V(xdelay.timer_node) AT=1.866889
.meas tran sf_28ms_b2 FIND V(xdelay.sf_timer) AT=1.866889
.meas tran tmr_69ms_b2 FIND V(xdelay.timer_node) AT=1.907889
.meas tran sf_69ms_b2 FIND V(xdelay.sf_timer) AT=1.907889
.meas tran tmr_192ms_b2 FIND V(xdelay.timer_node) AT=2.030889
.meas tran sf_192ms_b2 FIND V(xdelay.sf_timer) AT=2.030889
.meas tran trig_s14_b2 FIND V(trig_s14) AT=1.878889
.meas tran trig_wid_b2 FIND V(trig_wid) AT=1.868889
.meas tran trig_s69_b2 FIND V(trig_s69) AT=2.033889
.meas tran tmr_2ms_b3 FIND V(xdelay.timer_node) AT=2.682556
.meas tran sf_2ms_b3 FIND V(xdelay.sf_timer) AT=2.682556
.meas tran tmr_14ms_b3 FIND V(xdelay.timer_node) AT=2.694556
.meas tran sf_14ms_b3 FIND V(xdelay.sf_timer) AT=2.694556
.meas tran tmr_28ms_b3 FIND V(xdelay.timer_node) AT=2.708556
.meas tran sf_28ms_b3 FIND V(xdelay.sf_timer) AT=2.708556
.meas tran tmr_69ms_b3 FIND V(xdelay.timer_node) AT=2.749556
.meas tran sf_69ms_b3 FIND V(xdelay.sf_timer) AT=2.749556
.meas tran tmr_192ms_b3 FIND V(xdelay.timer_node) AT=2.872556
.meas tran sf_192ms_b3 FIND V(xdelay.sf_timer) AT=2.872556
.meas tran trig_s14_b3 FIND V(trig_s14) AT=2.720556
.meas tran trig_wid_b3 FIND V(trig_wid) AT=2.710556
.meas tran trig_s69_b3 FIND V(trig_s69) AT=2.875556
.meas tran tmr_2ms_b4 FIND V(xdelay.timer_node) AT=3.507556
.meas tran sf_2ms_b4 FIND V(xdelay.sf_timer) AT=3.507556
.meas tran tmr_14ms_b4 FIND V(xdelay.timer_node) AT=3.519556
.meas tran sf_14ms_b4 FIND V(xdelay.sf_timer) AT=3.519556
.meas tran tmr_28ms_b4 FIND V(xdelay.timer_node) AT=3.533556
.meas tran sf_28ms_b4 FIND V(xdelay.sf_timer) AT=3.533556
.meas tran tmr_69ms_b4 FIND V(xdelay.timer_node) AT=3.574556
.meas tran sf_69ms_b4 FIND V(xdelay.sf_timer) AT=3.574556
.meas tran tmr_192ms_b4 FIND V(xdelay.timer_node) AT=3.697556
.meas tran sf_192ms_b4 FIND V(xdelay.sf_timer) AT=3.697556
.meas tran trig_s14_b4 FIND V(trig_s14) AT=3.545556
.meas tran trig_wid_b4 FIND V(trig_wid) AT=3.535556
.meas tran trig_s69_b4 FIND V(trig_s69) AT=3.700556
.meas tran tmr_2ms_b5 FIND V(xdelay.timer_node) AT=4.307556
.meas tran sf_2ms_b5 FIND V(xdelay.sf_timer) AT=4.307556
.meas tran tmr_14ms_b5 FIND V(xdelay.timer_node) AT=4.319556
.meas tran sf_14ms_b5 FIND V(xdelay.sf_timer) AT=4.319556
.meas tran tmr_28ms_b5 FIND V(xdelay.timer_node) AT=4.333556
.meas tran sf_28ms_b5 FIND V(xdelay.sf_timer) AT=4.333556
.meas tran tmr_69ms_b5 FIND V(xdelay.timer_node) AT=4.374556
.meas tran sf_69ms_b5 FIND V(xdelay.sf_timer) AT=4.374556
.meas tran tmr_192ms_b5 FIND V(xdelay.timer_node) AT=4.497556
.meas tran sf_192ms_b5 FIND V(xdelay.sf_timer) AT=4.497556
.meas tran trig_s14_b5 FIND V(trig_s14) AT=4.345556
.meas tran trig_wid_b5 FIND V(trig_wid) AT=4.335556
.meas tran trig_s69_b5 FIND V(trig_s69) AT=4.500556
.meas tran avg_idd AVG I(Vdd) FROM=0.5 TO=5.564

.control
run
.endc
.end
