IA Testbench - 1mV differential sine at 10Hz
.lib "C:/Users/kadhi/OneDrive/Desktop/amux/verilogLearning/Leaky-Integrate-Fire---SNN-model-on-FPGA/experiments/frontend_optimization/ngspice_frontend/sky130_minimal.lib.spice" tt
.option scale=1.0u method=gear gmin=1e-15

.include "ia.spice"

Vdd vdd 0 0.9
Vss vss 0 0
Vbias vbias 0 0.3
Vref vref 0 0.3

* Differential input: +/- 0.5mV around VREF
Vinp inp 0 SIN(0.3 0.5e-3 10)
Vinn inn 0 SIN(0.3 -0.5e-3 10)

Xia inp inn out vdd vss vbias vref ia

.tran 0.1m 0.5 uic

.control
run
set wr_singlescale
wrdata C:/Users/kadhi/OneDrive/Desktop/amux/verilogLearning/Leaky-Integrate-Fire---SNN-model-on-FPGA/experiments/frontend_optimization/complete_frontend/_tb_ia_data.txt v(out) v(inp) v(inn)
.endc
.end
