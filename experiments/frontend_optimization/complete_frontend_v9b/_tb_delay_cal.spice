Delay Timer Calibration
.lib "C:/Users/kadhi/OneDrive/Desktop/amux/verilogLearning/Leaky-Integrate-Fire---SNN-model-on-FPGA/experiments/frontend_optimization/ngspice_frontend/sky130_minimal.lib.spice" tt
.option scale=1.0u method=gear gmin=1e-15

.include "inverter.spice"
.include "delay_timer.spice"

Vdd vdd 0 0.9
Vss vss 0 0
Vbias vbias 0 0.3

* Single R-peak pulse at t=5ms
Vrpeak rpeak_pulse 0 PULSE(0 0.9 5m 100n 100n 0.5m 100)

* Dummy thresholds (won't affect timer behavior)
Vth14 vth_14 0 0.3
Vth69 vth_69 0 0.3
Vth83 vth_83 0 0.3
Vth300 vth_300 0 0.1
Vth10 vth_10 0 0.3

Xdelay rpeak_pulse trig_s14 trig_s69 trig_wid trig_bi_copy trig_rr_copy
+ vdd vss vbias vth_14 vth_69 vth_83 vth_300 vth_10 delay_timer

.ic v(xdelay.timer_node) = 0.9
.ic v(xdelay.timer2) = 0.9

.tran 0.5m 400m uic

.control
run
set wr_singlescale
wrdata C:/Users/kadhi/OneDrive/Desktop/amux/verilogLearning/Leaky-Integrate-Fire---SNN-model-on-FPGA/experiments/frontend_optimization/complete_frontend/_tb_delay_cal.txt v(xdelay.timer_node) v(xdelay.sf_timer) v(xdelay.timer2) v(xdelay.sf_timer2)
.endc
.end
