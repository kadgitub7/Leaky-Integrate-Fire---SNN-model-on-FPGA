* FEATURE 8: QRS Symmetry — R-peak Voltage
*
* Proxy: ECG at R-peak. Normal → high R, PVC → low/negative R.
* Transmission gate S&H (NFET+PMOS) for full-range voltage capture.
*
* Trigger: sample_r_trig (at R-peak)

.subckt qrs_symmetry ecg_in sample_r_trig sym_out vdd vss

* Transmission gate: NFET passes low voltages, PMOS passes high voltages
XMsr_n ecg_in sample_r_trig sym_out vss sky130_fd_pr__nfet_01v8 L=0.5 W=2 nf=1
XMsr_p ecg_in trig_inv sym_out vdd sky130_fd_pr__pfet_01v8 L=0.5 W=4 nf=1

* Inverter for complementary trigger
XMinv_n trig_inv sample_r_trig vss vss sky130_fd_pr__nfet_01v8 L=0.15 W=1 nf=1
XMinv_p trig_inv sample_r_trig vdd vdd sky130_fd_pr__pfet_01v8 L=0.15 W=2 nf=1

XCsr sym_out vss sky130_fd_pr__cap_mim_m3_1 W=32 L=32

.ends qrs_symmetry
