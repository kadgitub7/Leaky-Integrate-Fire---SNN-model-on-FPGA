.title analog_3way_100_b11
.lib "C:/Users/kadhi/OneDrive/Desktop/amux/verilogLearning/Leaky-Integrate-Fire---SNN-model-on-FPGA/experiments/frontend_optimization/ngspice_frontend/sky130_minimal.lib.spice" tt
.option scale=1.0u method=gear reltol=0.01 gmin=1e-15
.temp 27

Vdd vdd 0 0.9
Vss vss 0 0

* === ECG INPUTS (PWL ? the ONLY non-analog input) ===
Vecg0 ecg_l0 0 PWL(0.0000000 0.300000 0.2888889 0.244808 0.2916667 0.244251 0.2944444 0.243693 0.2972222 0.244251 0.3000000 0.246481 0.3027778 0.246481 0.3055556 0.248153 0.3083333 0.250383 0.3111111 0.250941 0.3138889 0.252056 0.3166667 0.251498 0.3194444 0.253728 0.3222222 0.255401 0.3250000 0.254286 0.3277778 0.254843 0.3305556 0.253728 0.3333333 0.253171 0.3361111 0.254843 0.3388889 0.256516 0.3416667 0.255958 0.3444444 0.257073 0.3472222 0.255401 0.3500000 0.255401 0.3527778 0.257073 0.3555556 0.257631 0.3583333 0.258188 0.3611111 0.257073 0.3638889 0.256516 0.3666667 0.257073 0.3694444 0.255958 0.3722222 0.258188 0.3750000 0.258188 0.3777778 0.257631 0.3805556 0.257073 0.3833333 0.256516 0.3861111 0.257073 0.3888889 0.258188 0.3916667 0.258188 0.3944444 0.257073 0.3972222 0.256516 0.4000000 0.256516 0.4027778 0.257631 0.4055556 0.257631 0.4083333 0.257631 0.4111111 0.255958 0.4138889 0.253171 0.4166667 0.253728 0.4194444 0.255958 0.4222222 0.257631 0.4250000 0.256516 0.4277778 0.256516 0.4305556 0.255958 0.4333333 0.253728 0.4361111 0.255401 0.4388889 0.255401 0.4416667 0.255958 0.4444444 0.255958 0.4472222 0.254843 0.4500000 0.254286 0.4527778 0.254843 0.4555556 0.255401 0.4583333 0.255958 0.4611111 0.254843 0.4638889 0.254843 0.4666667 0.253728 0.4694444 0.255401 0.4722222 0.256516 0.4750000 0.255401 0.4777778 0.254843 0.4805556 0.254286 0.4833333 0.254286 0.4861111 0.254286 0.4888889 0.255958 0.4916667 0.255401 0.4944444 0.254286 0.4972222 0.253728 0.5000000 0.253171 0.5027778 0.253728 0.5055556 0.253171 0.5083333 0.254843 0.5111111 0.253171 0.5138889 0.251498 0.5166667 0.252613 0.5194444 0.253728 0.5222222 0.255401 0.5250000 0.255958 0.5277778 0.255958 0.5305556 0.254843 0.5333333 0.254286 0.5361111 0.255401 0.5388889 0.256516 0.5416667 0.256516 0.5444444 0.257073 0.5472222 0.253728 0.5500000 0.254286 0.5527778 0.257073 0.5555556 0.258188 0.5583333 0.256516 0.5611111 0.254843 0.5638889 0.254843 0.5666667 0.254843 0.5694444 0.256516 0.5722222 0.256516 0.5750000 0.255401 0.5777778 0.255401 0.5805556 0.255401 0.5833333 0.255958 0.5861111 0.258746 0.5888889 0.260418 0.5916667 0.260976 0.5944444 0.260418 0.5972222 0.260976 0.6000000 0.261533 0.6027778 0.263206 0.6055556 0.264878 0.6083333 0.265436 0.6111111 0.267108 0.6138889 0.266551 0.6166667 0.267108 0.6194444 0.268223 0.6222222 0.269338 0.6250000 0.268780 0.6277778 0.267108 0.6305556 0.266551 0.6333333 0.265993 0.6361111 0.264321 0.6388889 0.267108 0.6416667 0.266551 0.6444444 0.266551 0.6472222 0.264321 0.6500000 0.264878 0.6527778 0.268223 0.6555556 0.271010 0.6583333 0.269895 0.6611111 0.264878 0.6638889 0.262091 0.6666667 0.259861 0.6694444 0.258188 0.6722222 0.258188 0.6750000 0.255958 0.6777778 0.256516 0.6805556 0.254286 0.6833333 0.253728 0.6861111 0.255401 0.6888889 0.255958 0.6916667 0.256516 0.6944444 0.254843 0.6972222 0.253728 0.7000000 0.254286 0.7027778 0.254843 0.7055556 0.256516 0.7083333 0.255401 0.7111111 0.254286 0.7138889 0.253728 0.7166667 0.253728 0.7194444 0.254286 0.7222222 0.255958 0.7250000 0.255401 0.7277778 0.254843 0.7305556 0.254286 0.7333333 0.252056 0.7361111 0.253171 0.7388889 0.253728 0.7416667 0.250383 0.7444444 0.246481 0.7472222 0.242021 0.7500000 0.239233 0.7527778 0.238676 0.7555556 0.235331 0.7583333 0.228084 0.7611111 0.227526 0.7638889 0.232544 0.7666667 0.243136 0.7694444 0.257631 0.7722222 0.269895 0.7750000 0.283833 0.7777778 0.302787 0.7805556 0.329547 0.7833333 0.360209 0.7861111 0.384739 0.7888889 0.393659 0.7916667 0.383624 0.7944444 0.346272 0.7972222 0.297213 0.8000000 0.257073 0.8027778 0.240348 0.8055556 0.240906 0.8083333 0.246481 0.8111111 0.250383 0.8138889 0.249268 0.8166667 0.250941 0.8194444 0.250383 0.8222222 0.253171 0.8250000 0.252613 0.8277778 0.251498 0.8305556 0.251498 0.8333333 0.251498 0.8361111 0.251498 0.8388889 0.253171 0.8416667 0.252056 0.8444444 0.252056 0.8472222 0.252056 0.8500000 0.251498 0.8527778 0.252056 0.8555556 0.253171 0.8583333 0.253171 0.8611111 0.251498 0.8638889 0.250383 0.8666667 0.250383 0.8694444 0.251498 0.8722222 0.252056 0.8750000 0.252056 0.8777778 0.251498 0.8805556 0.251498 0.8833333 0.249826 0.8861111 0.251498 0.8888889 0.252613 0.8916667 0.252056 0.8944444 0.250941 0.8972222 0.250383 0.9000000 0.250941 0.9027778 0.252613 0.9055556 0.253171 0.9083333 0.253728 0.9111111 0.252056 0.9138889 0.252056 0.9166667 0.252056 0.9194444 0.252613 0.9222222 0.254286 0.9250000 0.254286 0.9277778 0.253171 0.9305556 0.251498 0.9333333 0.251498 0.9361111 0.252613 0.9388889 0.253728 0.9416667 0.252056 0.9444444 0.252056 0.9472222 0.250941 0.9500000 0.252056 0.9527778 0.251498 0.9555556 0.253728 0.9583333 0.253728 0.9611111 0.252613 0.9638889 0.251498 0.9666667 0.250941 0.9694444 0.253171 0.9722222 0.253728 0.9750000 0.253171 0.9777778 0.252613 0.9805556 0.251498 0.9833333 0.252056 0.9861111 0.252613 0.9888889 0.252613 0.9916667 0.253171 0.9944444 0.253171 0.9972222 0.252056 1.0000000 0.250941 1.0027778 0.250941 1.0055556 0.251498 1.0083333 0.250383 1.0111111 0.249826 1.0138889 0.249268 1.0166667 0.248153 1.0194444 0.249826 1.0222222 0.252056 1.0250000 0.250383 1.0277778 0.249268 1.0305556 0.248711 1.0333333 0.248711 1.0361111 0.249826 1.0388889 0.250941 1.0416667 0.250941 1.0444444 0.250383 1.0472222 0.249826 1.0500000 0.250383 1.0527778 0.252056 1.0555556 0.253728 1.0583333 0.254843 1.0611111 0.255401 1.0638889 0.255958 1.0666667 0.255958 1.0694444 0.257631 1.0722222 0.259861 1.0750000 0.260418 1.0777778 0.260418 1.0805556 0.260976 1.0833333 0.261533 1.0861111 0.263206 1.0888889 0.264321 1.0916667 0.263206 1.0944444 0.263763 1.0972222 0.263763 1.1000000 0.263206 1.1027778 0.264878 1.1055556 0.265436 1.1083333 0.265436 1.1111111 0.265436 1.1138889 0.265436 1.1166667 0.264321 1.1194444 0.264878 1.1222222 0.265993 1.1250000 0.265993 1.1277778 0.265436 1.1305556 0.264321 1.1333333 0.264321 1.1361111 0.265993 1.1388889 0.266551 1.1416667 0.265436 1.1444444 0.264878 1.1472222 0.263763 1.1500000 0.263206 1.1527778 0.264878 1.1555556 0.265436 1.1583333 0.264878 1.1611111 0.264321 1.1638889 0.263763 1.1666667 0.262648 1.1694444 0.262648 1.1722222 0.263763 1.1750000 0.263763 1.1777778 0.262091 1.1805556 0.262091 1.1833333 0.262091 1.1861111 0.263206 1.1888889 0.264878 1.1916667 0.263763 1.1944444 0.262648 1.1972222 0.261533 1.2000000 0.260976 1.2027778 0.261533 1.2055556 0.263206 1.2083333 0.260976 1.2111111 0.262091 1.2138889 0.260976 1.2166667 0.259861 1.2194444 0.259861 1.2222222 0.261533 1.2250000 0.261533 1.2277778 0.260976 1.2305556 0.259861 1.2333333 0.259303 1.2361111 0.259861 1.2388889 0.261533 1.2416667 0.260418 1.2444444 0.259861 1.2472222 0.258188 1.2500000 0.258188 1.2527778 0.259861 1.2555556 0.260418 1.2583333 0.259861 1.2611111 0.261533 1.2638889 0.259861 1.2666667 0.258746 1.2694444 0.259861 1.2722222 0.261533 1.2750000 0.260976 1.2777778 0.260418 1.2805556 0.260418 1.2833333 0.258746 1.2861111 0.260418 1.2888889 0.261533 1.2916667 0.260976 1.2944444 0.259861 1.2972222 0.259861 1.3000000 0.259303 1.3027778 0.260418 1.3055556 0.260976 1.3083333 0.260976 1.3111111 0.261533 1.3138889 0.260418 1.3166667 0.259861 1.3194444 0.261533 1.3222222 0.262648 1.3250000 0.261533 1.3277778 0.261533 1.3305556 0.260418 1.3333333 0.260418 1.3361111 0.260976 1.3388889 0.263206 1.3416667 0.264321 1.3444444 0.264321 1.3472222 0.263206 1.3500000 0.265993 1.3527778 0.267108 1.3555556 0.268223 1.3583333 0.269895 1.3611111 0.269338 1.3638889 0.268223 1.3666667 0.267666 1.3694444 0.269895 1.3722222 0.271010 1.3750000 0.272125 1.3777778 0.272683 1.3805556 0.272125 1.3833333 0.272683 1.3861111 0.273240 1.3888889 0.274913 1.3916667 0.274355 1.3944444 0.273240 1.3972222 0.271568 1.4000000 0.270453 1.4027778 0.271568 1.4055556 0.272125 1.4083333 0.272683 1.4111111 0.270453 1.4138889 0.269338 1.4166667 0.268780 1.4194444 0.271010 1.4222222 0.274355 1.4250000 0.276028 1.4277778 0.274355 1.4305556 0.269895 1.4333333 0.267108 1.4361111 0.266551 1.4388889 0.267108 1.4416667 0.263763 1.4444444 0.263763 1.4472222 0.261533 1.4500000 0.260418 1.4527778 0.260418 1.4555556 0.261533 1.4583333 0.261533 1.4611111 0.259861 1.4638889 0.259303 1.4666667 0.257073 1.4694444 0.258746 1.4722222 0.258188 1.4750000 0.258188 1.4777778 0.257631 1.4805556 0.257631 1.4833333 0.256516 1.4861111 0.258188 1.4888889 0.258188 1.4916667 0.258746 1.4944444 0.256516 1.4972222 0.257631 1.5000000 0.257631 1.5027778 0.258188 1.5055556 0.259861 1.5083333 0.259861 1.5111111 0.258188 1.5138889 0.257631 1.5166667 0.256516 1.5194444 0.255958 1.5222222 0.254286 1.5250000 0.248711 1.5277778 0.245366 1.5305556 0.244808 1.5333333 0.243693 1.5361111 0.242021 1.5388889 0.237561 1.5416667 0.234774 1.5444444 0.238676 1.5472222 0.252056 1.5500000 0.267666 1.5527778 0.287735 1.5555556 0.310035 1.5583333 0.341254 1.5611111 0.373031 1.5638889 0.396446 1.5666667 0.402578 1.5694444 0.390314 1.5722222 0.354077 1.5750000 0.303345 1.5777778 0.260418 1.5805556 0.243693 1.5833333 0.242021 1.5861111 0.249268 1.5888889 0.254843 1.5916667 0.258188 1.5944444 0.256516 1.5972222 0.254843 1.6000000 0.253171 1.6027778 0.253728 1.6055556 0.255401 1.6083333 0.253728 1.6111111 0.253728 1.6138889 0.252613 1.6166667 0.252613 1.6194444 0.253728 1.6222222 0.254286 1.6250000 0.254286 1.6277778 0.253728 1.6305556 0.252056 1.6333333 0.252613 1.6361111 0.254286 1.6388889 0.254843 1.6416667 0.255958 1.6444444 0.254286 1.6472222 0.253728 1.6500000 0.253171 1.6527778 0.254286 1.6555556 0.255401 1.6583333 0.254843 1.6611111 0.254843 1.6638889 0.253728 1.6666667 0.253728 1.6694444 0.254286 1.6722222 0.255958 1.6750000 0.254286 1.6777778 0.254843 1.6805556 0.253728 1.6833333 0.253171 1.6861111 0.253728 1.6888889 0.253171 1.6916667 0.253728 1.6944444 0.253728 1.6972222 0.253171 1.7000000 0.252613 1.7027778 0.253171 1.7055556 0.255401 1.7083333 0.253728 1.7111111 0.253728 1.7138889 0.253171 1.7166667 0.252613 1.7194444 0.254843 1.7222222 0.253171 1.7250000 0.254286 1.7277778 0.254286 1.7305556 0.252613 1.7333333 0.252056 1.7361111 0.253171 1.7388889 0.253728 1.7416667 0.255401 1.7444444 0.253728 1.7472222 0.253728 1.7500000 0.252056 1.7527778 0.254843 1.7555556 0.255401 1.7583333 0.255401 1.7611111 0.254286 1.7638889 0.252613 1.7666667 0.252056 1.7694444 0.254286 1.7722222 0.254286 1.7750000 0.255958 1.7777778 0.254286 1.7805556 0.253171 1.7833333 0.254286 1.7861111 0.255401 1.7888889 0.254843 1.7916667 0.254843 1.7944444 0.253728 1.7972222 0.252056 1.8000000 0.253171 1.8027778 0.253728 1.8055556 0.255958 1.8083333 0.254843 1.8111111 0.253728 1.8138889 0.252613 1.8166667 0.252056 1.8194444 0.253728 1.8222222 0.255958 1.8250000 0.255958 1.8277778 0.255401 1.8305556 0.254843 1.8333333 0.254843 1.8361111 0.255958 1.8388889 0.259303 1.8416667 0.259861 1.8444444 0.260418 1.8472222 0.260418 1.8500000 0.260976 1.8527778 0.262091 1.8555556 0.262648 1.8583333 0.264321 1.8611111 0.264321 1.8638889 0.264878 1.8666667 0.264321 1.8694444 0.265436 1.8722222 0.267666 1.8750000 0.266551 1.8777778 0.265993 1.8805556 0.265436 1.8833333 0.265436 1.8861111 0.265993 1.8888889 0.265993 1.8916667 0.265993 1.8944444 0.265436 1.8972222 0.265436 1.9000000 0.263763 1.9027778 0.265436 1.9055556 0.267108 1.9083333 0.265993 1.9111111 0.264878 1.9138889 0.265436 1.9166667 0.263763 1.9194444 0.264878 1.9222222 0.266551 1.9250000 0.265993 1.9277778 0.265436 1.9305556 0.264321 1.9333333 0.262648 1.9361111 0.265436 1.9388889 0.265993 1.9416667 0.265993 1.9444444 0.264321 1.9472222 0.264321 1.9500000 0.263206 1.9527778 0.264878 1.9555556 0.265993 1.9583333 0.265436 1.9611111 0.263206 1.9638889 0.263206 1.9666667 0.262091 1.9694444 0.263763 1.9722222 0.263206 1.9750000 0.263763 1.9777778 0.262648 1.9805556 0.261533 1.9833333 0.262091 1.9861111 0.262091 1.9888889 0.262648 1.9916667 0.262648 1.9944444 0.262091 1.9972222 0.260418 2.0000000 0.259861 2.0027778 0.260418 2.0055556 0.262091 2.0083333 0.261533 2.0111111 0.259861 2.0138889 0.259861 2.0166667 0.259861 2.0194444 0.260976 2.0222222 0.262648 2.0250000 0.261533 2.0277778 0.260976 2.0305556 0.259861 2.0333333 0.259861 2.0361111 0.259303 2.0388889 0.261533 2.0416667 0.262091 2.0444444 0.260418 2.0472222 0.260976 2.0500000 0.259861 2.0527778 0.260976 2.0555556 0.261533 2.0583333 0.260976 2.0611111 0.260418 2.0638889 0.259861 2.0666667 0.259861 2.0694444 0.261533 2.0722222 0.263206 2.0750000 0.262091 2.0777778 0.260976 2.0805556 0.260418 2.0833333 0.261533 2.0861111 0.262648 2.0888889 0.263206 2.0916667 0.263206 2.0944444 0.262648 2.0972222 0.260976 2.1000000 0.260976 2.1027778 0.261533 2.1055556 0.263763 2.1083333 0.264878 2.1111111 0.263206 2.1138889 0.264878 2.1166667 0.265993 2.1194444 0.268223 2.1222222 0.270453 2.1250000 0.269338 2.1277778 0.268223 2.1305556 0.267666 2.1333333 0.269338 2.1361111 0.271010 2.1388889 0.273240 2.1416667 0.273240 2.1444444 0.272125 2.1472222 0.273798 2.1500000 0.273798 2.1527778 0.275470 2.1555556 0.275470 2.1583333 0.274913 2.1611111 0.274355 2.1638889 0.273798 2.1666667 0.272683 2.1694444 0.273240 2.1722222 0.274355 2.1750000 0.273240 2.1777778 0.273240 2.1805556 0.271568 2.1833333 0.271568 2.1861111 0.272125 2.1888889 0.272683 2.1916667 0.273798 2.1944444 0.275470 2.1972222 0.274913 2.2000000 0.271010 2.2027778 0.268780 2.2055556 0.267666 2.2083333 0.267108 2.2111111 0.264321 2.2138889 0.262648 2.2166667 0.261533 2.2194444 0.261533 2.2222222 0.262091 2.2250000 0.261533 2.2277778 0.259861 2.2305556 0.259303 2.2333333 0.259303 2.2361111 0.261533 2.2388889 0.261533 2.2416667 0.260976 2.2444444 0.260976 2.2472222 0.259303 2.2500000 0.259303 2.2527778 0.259861 2.2555556 0.261533 2.2583333 0.260976 2.2611111 0.259861 2.2638889 0.258746 2.2666667 0.257073 2.2694444 0.258746 2.2722222 0.259303 2.2750000 0.259861 2.2777778 0.258746 2.2805556 0.258746 2.2833333 0.258188 2.2861111 0.258188 2.2888889 0.254843 2.2916667 0.249826 2.2944444 0.247038 2.2972222 0.243693 2.3000000 0.239233 2.3027778 0.235889 2.3055556 0.240906 2.3083333 0.252056 2.3111111 0.266551 2.3138889 0.280488 2.3166667 0.301672 2.3194444 0.332892 2.3222222 0.364111 2.3250000 0.385854 2.3277778 0.397003 2.3305556 0.394216 2.3333333 0.365226 2.3361111 0.321742 2.3388889 0.279373 2.3416667 0.254286 2.3444444 0.245366 2.3472222 0.247596 2.3500000 0.253171 2.3527778 0.256516 2.3555556 0.257631 2.3583333 0.255958 2.3611111 0.254286 2.3638889 0.254843 2.3666667 0.254286 2.3694444 0.256516 2.3722222 0.256516 2.3750000 0.255401 2.3777778 0.255958 2.3805556 0.255958 2.3833333 0.255401 2.3861111 0.257073 2.3888889 0.258188 2.3916667 0.258188 2.3944444 0.257073 2.3972222 0.255958 2.4000000 0.254843 2.4027778 0.255958 2.4055556 0.257073 2.4083333 0.257073 2.4111111 0.255401 2.4138889 0.254843 2.4166667 0.254286 2.4194444 0.255401 2.4222222 0.255958 2.4250000 0.257073 2.4277778 0.255401 2.4305556 0.254843 2.4333333 0.255401 2.4361111 0.256516 2.4388889 0.255401 2.4416667 0.255958 2.4444444 0.256516 2.4472222 0.255401 2.4500000 0.254843 2.4527778 0.255401 2.4555556 0.255958 2.4583333 0.255958 2.4611111 0.255401 2.4638889 0.254286 2.4666667 0.253728 2.4694444 0.254286 2.4722222 0.255958 2.4750000 0.256516 2.4777778 0.255401 2.4805556 0.256516 2.4833333 0.254843 2.4861111 0.256516 2.4888889 0.258188 2.4916667 0.257631 2.4944444 0.257073 2.4972222 0.255958 2.5000000 0.254843 2.5027778 0.256516 2.5055556 0.257073 2.5083333 0.255958 2.5111111 0.255958 2.5138889 0.255401 2.5166667 0.255401 2.5194444 0.255958 2.5222222 0.256516 2.5250000 0.255958 2.5277778 0.255958 2.5305556 0.254843 2.5333333 0.253171 2.5361111 0.254843 2.5388889 0.257073 2.5416667 0.257073 2.5444444 0.258188 2.5472222 0.257631 2.5500000 0.255958 2.5527778 0.256516 2.5555556 0.258746 2.5583333 0.258188 2.5611111 0.257073 2.5638889 0.255958 2.5666667 0.255401 2.5694444 0.256516 2.5722222 0.257073 2.5750000 0.255401 2.5777778 0.254843 2.5805556 0.254843 2.5833333 0.253171 2.5861111 0.253728 2.5888889 0.256516 2.5916667 0.255958 2.5944444 0.255401 2.5972222 0.253728 2.6000000 0.252613 2.6027778 0.253728 2.6055556 0.255401 2.6083333 0.255958 2.6111111 0.255401 2.6138889 0.255401 2.6166667 0.255958 2.6194444 0.257073 2.6222222 0.258188 2.6250000 0.259861 2.6277778 0.260418 2.6305556 0.260976 2.6333333 0.263763 2.6361111 0.264878 2.6388889 0.265436 2.6416667 0.266551 2.6444444 0.265993 2.6472222 0.266551 2.6500000 0.265993 2.6527778 0.265993 2.6555556 0.266551 2.6583333 0.266551 2.6611111 0.265436 2.6638889 0.264878 2.6666667 0.264878 2.6694444 0.265993 2.6722222 0.266551 2.6750000 0.267108 2.6777778 0.265436 2.6805556 0.264878 2.6833333 0.265436 2.6861111 0.266551 2.6888889 0.267108 2.6916667 0.265993 2.6944444 0.264321 2.6972222 0.262648 2.7000000 0.262648 2.7027778 0.263206 2.7055556 0.263763 2.7083333 0.264321 2.7111111 0.264878 2.7138889 0.264878 2.7166667 0.265436 2.7194444 0.264878 2.7222222 0.265436 2.7250000 0.265436 2.7277778 0.264321 2.7305556 0.263763 2.7333333 0.262648 2.7361111 0.264321 2.7388889 0.264321 2.7416667 0.264321 2.7444444 0.262091 2.7472222 0.262648 2.7500000 0.260976 2.7527778 0.262648 2.7555556 0.263206 2.7583333 0.262648 2.7611111 0.261533 2.7638889 0.260976 2.7666667 0.260418 2.7694444 0.260418 2.7722222 0.261533 2.7750000 0.261533 2.7777778 0.262648 2.7805556 0.261533 2.7833333 0.261533 2.7861111 0.261533 2.7888889 0.262091 2.7916667 0.260418 2.7944444 0.260976 2.7972222 0.258188 2.8000000 0.259303 2.8027778 0.260976 2.8055556 0.260976 2.8083333 0.261533 2.8111111 0.261533 2.8138889 0.259861 2.8166667 0.258746 2.8194444 0.259861 2.8222222 0.261533 2.8250000 0.262091 2.8277778 0.260976 2.8305556 0.259861 2.8333333 0.259861 2.8361111 0.259303 2.8388889 0.260418 2.8416667 0.261533 2.8444444 0.262091 2.8472222 0.260976 2.8500000 0.260418 2.8527778 0.261533 2.8555556 0.262091 2.8583333 0.262091 2.8611111 0.261533 2.8638889 0.260418 2.8666667 0.259861 2.8694444 0.260418 2.8722222 0.260976 2.8750000 0.261533 2.8777778 0.260976 2.8805556 0.259303 2.8833333 0.259303 2.8861111 0.260418 2.8888889 0.262648 2.8916667 0.262648 2.8944444 0.263206 2.8972222 0.263206 2.9000000 0.263206 2.9027778 0.265993 2.9055556 0.266551 2.9083333 0.267666 2.9111111 0.267108 2.9138889 0.266551 2.9166667 0.267108 2.9194444 0.269338 2.9222222 0.270453 2.9250000 0.271568 2.9277778 0.271010 2.9305556 0.270453 2.9333333 0.271568 2.9361111 0.271568 2.9388889 0.272683 2.9416667 0.272683 2.9444444 0.271568 2.9472222 0.271010 2.9500000 0.270453 2.9527778 0.270453 2.9555556 0.271568 2.9583333 0.270453 2.9611111 0.270453 2.9638889 0.267666 2.9666667 0.269895 2.9694444 0.271010 2.9722222 0.273798 2.9750000 0.272125 2.9777778 0.267108 2.9805556 0.265436 2.9833333 0.263763 2.9861111 0.263763 2.9888889 0.263763 2.9916667 0.262648 2.9944444 0.261533 2.9972222 0.260418 3.0000000 0.259861 3.0027778 0.262091 3.0055556 0.260976 3.0083333 0.261533 3.0111111 0.259861 3.0138889 0.259303 3.0166667 0.257631 3.0194444 0.258746 3.0222222 0.257631 3.0250000 0.259303 3.0277778 0.258746 3.0305556 0.257073 3.0333333 0.257631 3.0361111 0.259303 3.0388889 0.259303 3.0416667 0.258746 3.0444444 0.259861 3.0472222 0.257631 3.0500000 0.258188 3.0527778 0.259861 3.0555556 0.259303 3.0583333 0.259303 3.0611111 0.259861 3.0638889 0.259303 3.0666667 0.258188 3.0694444 0.256516 3.0722222 0.253728 3.0750000 0.250941 3.0777778 0.247038 3.0805556 0.245366 3.0833333 0.241463 3.0861111 0.237561 3.0888889 0.235889 3.0916667 0.241463 3.0944444 0.253171 3.0972222 0.267108 3.1000000 0.286063 3.1027778 0.308920 3.1055556 0.336794 3.1083333 0.366341 3.1111111 0.386411 3.1138889 0.397561 3.1166667 0.392544 3.1194444 0.371359 3.1222222 0.337352 3.1250000 0.301115 3.1277778 0.274355 3.1305556 0.256516 3.1333333 0.247596 3.1361111 0.243693 3.1388889 0.240906 3.1416667 0.243136 3.1444444 0.247038 3.1472222 0.250383 3.1500000 0.253171 3.1527778 0.253171 3.1555556 0.253728 3.1583333 0.254286 3.1611111 0.254286 3.1638889 0.253171 3.1666667 0.253171 3.1694444 0.255401 3.1722222 0.255958 3.1750000 0.255958 3.1777778 0.255401 3.1805556 0.253171 3.1833333 0.252056 3.1861111 0.252056 3.1888889 0.254286 3.1916667 0.255401 3.1944444 0.254843 3.1972222 0.253728 3.2000000 0.254286 3.2027778 0.254286 3.2055556 0.253728 3.2083333 0.253171 3.2111111 0.252056 3.2138889 0.252613 3.2166667 0.253171 3.2194444 0.253728 3.2222222 0.254286 3.2250000 0.253171 3.2277778 0.253171 3.2305556 0.252056 3.2333333 0.252056 3.2361111 0.253728 3.2388889 0.253728 3.2416667 0.254843 3.2444444 0.253728 3.2472222 0.252613 3.2500000 0.252613 3.2527778 0.253728 3.2555556 0.253728 3.2583333 0.254286 3.2611111 0.254286 3.2638889 0.253171 3.2666667 0.252613 3.2694444 0.252613 3.2722222 0.253728 3.2750000 0.253171 3.2777778 0.253728 3.2805556 0.252056 3.2833333 0.252056 3.2861111 0.252056 3.2888889 0.253171 3.2916667 0.253171 3.2944444 0.253171 3.2972222 0.252056 3.3000000 0.250941 3.3027778 0.252613 3.3055556 0.254286 3.3083333 0.254843 3.3111111 0.253171 3.3138889 0.252056 3.3166667 0.252613 3.3194444 0.253728 3.3222222 0.254286 3.3250000 0.254286 3.3277778 0.253728 3.3305556 0.254843 3.3333333 0.253171 3.3361111 0.253171 3.3388889 0.253728 3.3416667 0.254286 3.3444444 0.252056 3.3472222 0.250941 3.3500000 0.249268 3.3527778 0.250941 3.3555556 0.249826 3.3583333 0.250383 3.3611111 0.249268 3.3638889 0.248711 3.3666667 0.248153 3.3694444 0.248711 3.3722222 0.249826 3.3750000 0.249268 3.3777778 0.248711 3.3805556 0.245923 3.3833333 0.247596 3.3861111 0.248711 3.3888889 0.249268 3.3916667 0.249826 3.3944444 0.249268 3.3972222 0.249268 3.4000000 0.249826 3.4027778 0.250941 3.4055556 0.252613 3.4083333 0.252613 3.4111111 0.252613 3.4138889 0.254843 3.4166667 0.254286 3.4194444 0.255958 3.4222222 0.257631 3.4250000 0.257073 3.4277778 0.257073 3.4305556 0.257073 3.4333333 0.259303 3.4361111 0.259303 3.4388889 0.260976 3.4416667 0.260976 3.4444444 0.262091 3.4472222 0.260418 3.4500000 0.263206 3.4527778 0.264321 3.4555556 0.265993 3.4583333 0.265436 3.4611111 0.264321 3.4638889 0.264321 3.4666667 0.264321 3.4694444 0.265993 3.4722222 0.266551 3.4750000 0.267666 3.4777778 0.267666 3.4805556 0.265993 3.4833333 0.265436 3.4861111 0.267108 3.4888889 0.267666 3.4916667 0.265436 3.4944444 0.265993 3.4972222 0.264321 3.5000000 0.263763 3.5027778 0.265993 3.5055556 0.267666 3.5083333 0.266551 3.5111111 0.265993 3.5138889 0.264878 3.5166667 0.265436 3.5194444 0.266551 3.5222222 0.266551 3.5250000 0.267108 3.5277778 0.265993 3.5305556 0.265436 3.5333333 0.265436 3.5361111 0.266551 3.5388889 0.266551 3.5416667 0.265993 3.5444444 0.264878 3.5472222 0.263206 3.5500000 0.263763 3.5527778 0.264321 3.5555556 0.265436 3.5583333 0.264878 3.5611111 0.263763 3.5638889 0.262091 3.5666667 0.263206 3.5694444 0.263206 3.5722222 0.264321 3.5750000 0.263763 3.5777778 0.263206 3.5805556 0.262091 3.5833333 0.262648 3.5861111 0.262648 3.5888889 0.263206 3.5916667 0.263763 3.5944444 0.262091 3.5972222 0.261533 3.6000000 0.262091 3.6027778 0.263206 3.6055556 0.263206 3.6083333 0.263763 3.6111111 0.264878 3.6138889 0.262091 3.6166667 0.262091 3.6194444 0.263763 3.6222222 0.264321 3.6250000 0.264321 3.6277778 0.264321 3.6305556 0.263206 3.6333333 0.262091 3.6361111 0.262648 3.6388889 0.263206 3.6416667 0.263206 3.6444444 0.264321 3.6472222 0.263206 3.6500000 0.263763 3.6527778 0.264321 3.6555556 0.264321 3.6583333 0.264321 3.6611111 0.263206 3.6638889 0.263206 3.6666667 0.263763 3.6694444 0.264321 3.6722222 0.265993 3.6750000 0.265436 3.6777778 0.264878 3.6805556 0.263763 3.6833333 0.263763 3.6861111 0.264321 3.6888889 0.265993 3.6916667 0.265993 3.6944444 0.265993 3.6972222 0.265993 3.7000000 0.267108 3.7027778 0.268780 3.7055556 0.268780 3.7083333 0.271010 3.7111111 0.271568 3.7138889 0.269338 3.7166667 0.269338 3.7194444 0.271010 3.7222222 0.271568 3.7250000 0.272125 3.7277778 0.272125 3.7305556 0.272125 3.7333333 0.272125 3.7361111 0.273798 3.7388889 0.274913 3.7416667 0.273798 3.7444444 0.276028 3.7472222 0.276028 3.7500000 0.274913 3.7527778 0.277143 3.7555556 0.277700 3.7583333 0.277143 3.7611111 0.276028 3.7638889 0.274355 3.7666667 0.273240 3.7694444 0.273798 3.7722222 0.275470 3.7750000 0.276028 3.7777778 0.275470 3.7805556 0.273240 3.7833333 0.272683 3.7861111 0.273798 3.7888889 0.277700 3.7916667 0.278815 3.7944444 0.277143 3.7972222 0.273240 3.8000000 0.270453 3.8027778 0.270453 3.8055556 0.268780 3.8083333 0.267666 3.8111111 0.265993 3.8138889 0.264878 3.8166667 0.263206 3.8194444 0.263763 3.8222222 0.264878 3.8250000 0.265993 3.8277778 0.264878 3.8305556 0.264321 3.8333333 0.262648 3.8361111 0.263206 3.8388889 0.263763 3.8416667 0.263206 3.8444444 0.262648 3.8472222 0.261533 3.8500000 0.260976 3.8527778 0.263206 3.8555556 0.263206 3.8583333 0.263763 3.8611111 0.260418 3.8638889 0.262648 3.8666667 0.262091 3.8694444 0.264321 3.8722222 0.264321 3.8750000 0.263763 3.8777778 0.263206 3.8805556 0.262648 3.8833333 0.262091 3.8861111 0.262091 3.8888889 0.260976 3.8916667 0.255401 3.8944444 0.253171 3.8972222 0.248711 3.9000000 0.245923 3.9027778 0.242021 3.9055556 0.239233 3.9083333 0.240906 3.9111111 0.250383 3.9138889 0.264321 3.9166667 0.279930 3.9194444 0.298328 3.9222222 0.320070 3.9250000 0.348502 3.9277778 0.374704 3.9305556 0.392544 3.9333333 0.400906 3.9361111 0.399233 3.9388889 0.380279 3.9416667 0.343484 3.9444444 0.299443 3.9472222 0.267108 3.9500000 0.251498 3.9527778 0.249268 3.9555556 0.253171 3.9583333 0.257631 3.9611111 0.260418 3.9638889 0.259861 3.9666667 0.259303 3.9694444 0.259303 3.9722222 0.260976 3.9750000 0.260418 3.9777778 0.259861 3.9805556 0.258746 3.9833333 0.258188 3.9861111 0.258746 3.9888889 0.259303 3.9916667 0.258746 3.9944444 0.258188 3.9972222 0.257631 4.0000000 0.257073 4.0027778 0.258188 4.0055556 0.258746 4.0083333 0.258746 4.0111111 0.259303 4.0138889 0.257631 4.0166667 0.256516 4.0194444 0.258746 4.0222222 0.259303 4.0250000 0.259303 4.0277778 0.258746 4.0305556 0.258746 4.0333333 0.257631 4.0361111 0.258746 4.0388889 0.259861 4.0416667 0.259303 4.0444444 0.258188 4.0472222 0.259303 4.0500000 0.259303 4.0527778 0.259861 4.0555556 0.260418 4.0583333 0.261533 4.0611111 0.260418 4.0638889 0.259303 4.0666667 0.258188 4.0694444 0.258746 4.0722222 0.259861 4.0750000 0.259861 4.0777778 0.258746 4.0805556 0.257073 4.0833333 0.256516 4.0861111 0.257073 4.0888889 0.258188 4.0916667 0.259861 4.0944444 0.258746 4.0972222 0.257631 4.1000000 0.257631 4.1027778 0.257631 4.1055556 0.258746 4.1083333 0.258746 4.1111111 0.258746 4.1138889 0.257073 4.1166667 0.258188 4.1194444 0.258188 4.1222222 0.259303 4.1250000 0.259303 4.1277778 0.259303 4.1305556 0.258188 4.1333333 0.258188 4.1361111 0.259861 4.1388889 0.260418 4.1416667 0.261533 4.1444444 0.259861 4.1472222 0.258746 4.1500000 0.259861 4.1527778 0.259303 4.1555556 0.259861 4.1583333 0.260418 4.1611111 0.259861 4.1638889 0.259303 4.1666667 0.259303 4.1694444 0.258746 4.1722222 0.260418 4.1750000 0.258188 4.1777778 0.258188 4.1805556 0.257631 4.1833333 0.257631 4.1861111 0.258188 4.1888889 0.258746 4.1916667 0.258746 4.1944444 0.258188 4.1972222 0.257073 4.2000000 0.255401 4.2027778 0.255958 4.2055556 0.257073 4.2083333 0.257073 4.2111111 0.255958 4.2138889 0.254843 4.2166667 0.255958 4.2194444 0.255958 4.2222222 0.257631 4.2250000 0.256516 4.2277778 0.257073 4.2305556 0.256516 4.2333333 0.257073 4.2361111 0.257631 4.2388889 0.259303 4.2416667 0.259861 4.2444444 0.260976 4.2472222 0.259861 4.2500000 0.260418 4.2527778 0.262648 4.2555556 0.264321 4.2583333 0.265993 4.2611111 0.265436 4.2638889 0.265993 4.2666667 0.266551 4.2694444 0.267108 4.2722222 0.268223 4.2750000 0.268780 4.2777778 0.269895 4.2805556 0.269895 4.2833333 0.269338 4.2861111 0.271010 4.2888889 0.273240 4.2916667 0.272683 4.2944444 0.271568 4.2972222 0.271010 4.3000000 0.269338 4.3027778 0.271568 4.3055556 0.271568 4.3083333 0.270453 4.3111111 0.269895 4.3138889 0.269895 4.3166667 0.269338 4.3194444 0.271010 4.3222222 0.271568 4.3250000 0.271568 4.3277778 0.270453 4.3305556 0.269895 4.3333333 0.269895 4.3361111 0.271010 4.3388889 0.271568 4.3416667 0.271010 4.3444444 0.271568 4.3472222 0.269895 4.3500000 0.269338 4.3527778 0.270453 4.3555556 0.269338 4.3583333 0.269895 4.3611111 0.269895 4.3638889 0.268780 4.3666667 0.268223 4.3694444 0.269338 4.3722222 0.271010 4.3750000 0.270453 4.3777778 0.271010 4.3805556 0.269338 4.3833333 0.269338 4.3861111 0.269338 4.3888889 0.269895 4.3916667 0.269895 4.3944444 0.268780 4.3972222 0.268223 4.4000000 0.268223 4.4027778 0.268223 4.4055556 0.268223 4.4083333 0.267666 4.4111111 0.265436 4.4138889 0.266551 4.4166667 0.265993 4.4194444 0.265436 4.4222222 0.267666 4.4250000 0.268223 4.4277778 0.267108 4.4305556 0.265436 4.4333333 0.265993 4.4361111 0.265993 4.4388889 0.267666 4.4416667 0.268223 4.4444444 0.267666 4.4472222 0.265436 4.4500000 0.265436 4.4527778 0.265993 4.4555556 0.267108 4.4583333 0.266551 4.4611111 0.265436 4.4638889 0.265436 4.4666667 0.263206 4.4694444 0.264878 4.4722222 0.265993 4.4750000 0.265993 4.4777778 0.264878 4.4805556 0.264878 4.4833333 0.263763 4.4861111 0.264321 4.4888889 0.265436 4.4916667 0.265436 4.4944444 0.265436 4.4972222 0.265436 4.5000000 0.265993 4.5027778 0.265436 4.5055556 0.265993 4.5083333 0.266551 4.5111111 0.265993 4.5138889 0.265436 4.5166667 0.264878 4.5194444 0.265993 4.5222222 0.265436 4.5250000 0.265993 4.5277778 0.264878 4.5305556 0.264878 4.5333333 0.265436 4.5361111 0.265436 4.5388889 0.267108 4.5416667 0.265993 4.5444444 0.265993 4.5472222 0.265436 4.5500000 0.265993 4.5527778 0.267666 4.5555556 0.269338 4.5583333 0.272125 4.5611111 0.271010 4.5638889 0.271010 4.5666667 0.272125 4.5694444 0.273240 4.5722222 0.274355 4.5750000 0.274355 4.5777778 0.276585 4.5805556 0.275470 4.5833333 0.276585 4.5861111 0.278815 4.5888889 0.279373 4.5916667 0.278815 4.5944444 0.277700 4.5972222 0.277143 4.6000000 0.274913 4.6027778 0.277143 4.6055556 0.277700 4.6083333 0.277143 4.6111111 0.274913 4.6138889 0.273798 4.6166667 0.272125 4.6194444 0.274913 4.6222222 0.275470 4.6250000 0.276585 4.6277778 0.274355 4.6305556 0.272125 4.6333333 0.272683 4.6361111 0.276585 4.6388889 0.280488 4.6416667 0.278815 4.6444444 0.275470 4.6472222 0.272125 4.6500000 0.268780 4.6527778 0.269338 4.6555556 0.268780 4.6583333 0.267108 4.6611111 0.264878 4.6638889 0.264321 4.6666667 0.262648 4.6694444 0.262091 4.6722222 0.263763 4.6750000 0.264321 4.6777778 0.264878 4.6805556 0.263206 4.6833333 0.262648 4.6861111 0.262648 4.6888889 0.261533 4.6916667 0.263763 4.6944444 0.261533 4.6972222 0.262091 4.7000000 0.260976 4.7027778 0.261533 4.7055556 0.261533 4.7083333 0.260976 4.7111111 0.259861 4.7138889 0.259861 4.7166667 0.260418 4.7194444 0.260976 4.7222222 0.262091 4.7250000 0.260976 4.7277778 0.260976 4.7305556 0.259861 4.7333333 0.259303 4.7361111 0.256516 4.7388889 0.253171 4.7416667 0.250941 4.7444444 0.247596 4.7472222 0.245923 4.7500000 0.240348 4.7527778 0.236446 4.7555556 0.238676 4.7583333 0.248153 4.7611111 0.261533 4.7638889 0.276028 4.7666667 0.289965 4.7694444 0.312822 4.7722222 0.341254 4.7750000 0.369686 4.7777778 0.391429 4.7805556 0.401463 4.7833333 0.395889 4.7861111 0.375261 4.7888889 0.336794 4.7916667 0.294983 4.7944444 0.263206 4.7972222 0.248711 4.8000000 0.245923 4.8027778 0.251498 4.8055556 0.255958 4.8083333 0.258188 4.8111111 0.257073 4.8138889 0.257073 4.8166667 0.255401 4.8194444 0.257073 4.8222222 0.258746 4.8250000 0.258188 4.8277778 0.257073 4.8305556 0.256516 4.8333333 0.255958 4.8361111 0.255401 4.8388889 0.257073 4.8416667 0.257073 4.8444444 0.257073 4.8472222 0.255958 4.8500000 0.255958 4.8527778 0.255958 4.8555556 0.256516 4.8583333 0.254843 4.8611111 0.255401 4.8638889 0.255958 4.8666667 0.254843 4.8694444 0.255958 4.8722222 0.255958 4.8750000 0.256516 4.8777778 0.254843 4.8805556 0.254843 4.8833333 0.253728 4.8861111 0.255401 4.8888889 0.255958 4.8916667 0.257631 4.8944444 0.256516 4.8972222 0.255958 4.9000000 0.255401 4.9027778 0.257073 4.9055556 0.257631 4.9083333 0.258746 4.9111111 0.257073 4.9138889 0.255401 4.9166667 0.254843 4.9194444 0.257073 4.9222222 0.258188 4.9250000 0.257631 4.9277778 0.257631 4.9305556 0.255401 4.9333333 0.257073 4.9361111 0.257073 4.9388889 0.257631 4.9416667 0.258188 4.9444444 0.257631 4.9472222 0.255958 4.9500000 0.254843 4.9527778 0.256516 4.9555556 0.256516 4.9583333 0.257073 4.9611111 0.256516 4.9638889 0.255958 4.9666667 0.254843 4.9694444 0.255958 4.9722222 0.257631 4.9750000 0.257631 4.9777778 0.257073 4.9805556 0.255401 4.9833333 0.255958 4.9861111 0.255958 4.9888889 0.257631 4.9916667 0.257631 4.9944444 0.257073 4.9972222 0.255401 5.0000000 0.254843 5.0027778 0.256516 5.0055556 0.257631 5.0083333 0.257631 5.0111111 0.258188 5.0138889 0.257073 5.0166667 0.256516 5.0194444 0.256516 5.0222222 0.258188 5.0250000 0.258188 5.0277778 0.256516 5.0305556 0.255958 5.0333333 0.255401 5.0361111 0.255958 5.0388889 0.255958 5.0416667 0.257073 5.0444444 0.257631 5.0472222 0.256516 5.0500000 0.254843 5.0527778 0.255401 5.0555556 0.257073 5.0583333 0.257073 5.0611111 0.255958 5.0638889 0.255958 5.0666667 0.255401 5.0694444 0.255958 5.0722222 0.257073 5.0750000 0.257631 5.0777778 0.256516 5.0805556 0.257631 5.0833333 0.257073 5.0861111 0.258188 5.0888889 0.260976 5.0916667 0.261533 5.0944444 0.262091 5.0972222 0.260976 5.1000000 0.261533 5.1027778 0.263763 5.1055556 0.264878 5.1083333 0.265436 5.1111111 0.264878 5.1138889 0.264321 5.1166667 0.264878 5.1194444 0.267108 5.1222222 0.267108 5.1250000 0.268223 5.1277778 0.268223 5.1305556 0.265993 5.1333333 0.266551 5.1361111 0.267666 5.1388889 0.268780 5.1416667 0.270453 5.1444444 0.268223 5.1472222 0.268780 5.1500000 0.268223 5.1527778 0.268223 5.1555556 0.270453 5.1583333 0.269338 5.1611111 0.269895 5.1638889 0.269338 5.1666667 0.267666 5.1694444 0.268780 5.1722222 0.268223 5.1750000 0.269338 5.1777778 0.268223 5.1805556 0.266551 5.1833333 0.265993 5.1861111 0.267108 5.1888889 0.269338 5.1916667 0.265993 5.1944444 0.267108 5.1972222 0.264878 5.2000000 0.264321 5.2027778 0.265436 5.2055556 0.265993 5.2083333 0.267108 5.2111111 0.267666 5.2138889 0.266551 5.2166667 0.264878 5.2194444 0.266551 5.2222222 0.267108 5.2250000 0.267666 5.2277778 0.265993 5.2305556 0.264878 5.2333333 0.263763 5.2361111 0.264321 5.2388889 0.265993 5.2416667 0.266551 5.2444444 0.265436 5.2472222 0.264878 5.2500000 0.263763 5.2527778 0.264321 5.2555556 0.264321 5.2583333 0.264321 5.2611111 0.263763 5.2638889 0.262648 5.2666667 0.262091 5.2694444 0.262091 5.2722222 0.262648 5.2750000 0.263763 5.2777778 0.262648 5.2805556 0.262091 5.2833333 0.261533 5.2861111 0.262648 5.2888889 0.263763 5.2916667 0.263206 5.2944444 0.262648 5.2972222 0.262091 5.3000000 0.260976 5.3027778 0.261533 5.3055556 0.263206 5.3083333 0.263206 5.3111111 0.262091 5.3138889 0.259861 5.3166667 0.261533 5.3194444 0.263206 5.3222222 0.262091 5.3250000 0.263763 5.3277778 0.262648 5.3305556 0.262648 5.3333333 0.261533 5.3361111 0.262648 5.3388889 0.263206 5.3416667 0.263206 5.3444444 0.262648 5.3472222 0.261533 5.3500000 0.262091 5.3527778 0.262648 5.3555556 0.263206 5.3583333 0.264321 5.3611111 0.263206 5.3638889 0.262091 5.3666667 0.262091 5.3694444 0.263206 5.3722222 0.263763 5.3750000 0.264321 5.3777778 0.264878 5.3805556 0.264878 5.3833333 0.267108 5.3861111 0.268780 5.3888889 0.269895 5.3916667 0.271010 5.3944444 0.269338 5.3972222 0.269895 5.4000000 0.267666 5.4027778 0.269338 5.4055556 0.272125 5.4083333 0.273798 5.4111111 0.273798 5.4138889 0.271568 5.4166667 0.273240 5.4194444 0.274913 5.4222222 0.274355 5.4250000 0.274355 5.4277778 0.273240 5.4305556 0.271568 5.4333333 0.272125 5.4361111 0.273798 5.4388889 0.273798 5.4416667 0.273240 5.4444444 0.272125 5.4472222 0.272125 5.4500000 0.273240 5.4527778 0.275470 5.4555556 0.273240 5.4583333 0.270453 5.4611111 0.267666 5.4638889 0.265993 5.4666667 0.264321 5.4694444 0.262091 5.4722222 0.263763 5.4750000 0.262648 5.4777778 0.262648 5.4805556 0.260976 5.4833333 0.259303 5.4861111 0.260976 5.4888889 0.262091 5.4916667 0.261533 5.4944444 0.259861 5.4972222 0.258746 5.5000000 0.258188 5.5027778 0.258188 5.5055556 0.258746 5.5083333 0.258746 5.5111111 0.258746 5.5138889 0.259303 5.5166667 0.258746 5.5194444 0.259303 5.5222222 0.260976 5.5250000 0.260976 5.5277778 0.258746 5.5305556 0.257631 5.5333333 0.255958 5.5361111 0.257073 5.5388889 0.258188 5.5416667 0.258188 5.5444444 0.255958 5.5472222 0.250941 5.5500000 0.247038 5.5527778 0.243693 5.5555556 0.242021 5.5583333 0.239233 5.5611111 0.233659 5.5638889 0.233101 5.5666667 0.240348 5.5694444 0.254286 5.5722222 0.268780 5.5750000 0.286620 5.5777778 0.312265 5.5805556 0.340139 5.5833333 0.368014 5.5861111 0.388084 5.5888889 0.395331 5.5916667 0.388641 5.5944444 0.362439 5.5972222 0.326760 5.6000000 0.291638 5.6027778 0.263763 5.6055556 0.247596 5.6083333 0.242021 5.6111111 0.242578 5.6138889 0.247038 5.6166667 0.250941 5.6194444 0.252613 5.6222222 0.252613 5.6250000 0.251498 5.6277778 0.253728 5.6305556 0.253171 5.6333333 0.252056 5.6361111 0.253171 5.6388889 0.253728 5.6416667 0.253728 5.6444444 0.253171 5.6472222 0.250941 5.6500000 0.251498 5.6527778 0.252056 5.6555556 0.252613 5.6583333 0.253728 5.6611111 0.253171 5.6638889 0.253171 5.6666667 0.252056 5.6694444 0.251498 5.6722222 0.253728 5.6750000 0.253728 5.6777778 0.252613 5.6805556 0.253171 5.6833333 0.250383 5.6861111 0.249826 5.6888889 0.250941 5.6916667 0.252056 5.6944444 0.252056 5.6972222 0.251498 5.7000000 0.251498 5.7027778 0.251498 5.7055556 0.252056 5.7083333 0.252056 5.7111111 0.252613 5.7138889 0.251498 5.7166667 0.250383 5.7194444 0.251498 5.7222222 0.252056 5.7250000 0.252056 5.7277778 0.252056 5.7305556 0.252056 5.7333333 0.250383 5.7361111 0.251498 5.7388889 0.252613 5.7416667 0.252613 5.7444444 0.252613 5.7472222 0.253171 5.7500000 0.252056 5.7527778 0.252613 5.7555556 0.253728 5.7583333 0.253171 5.7611111 0.252613 5.7638889 0.251498 5.7666667 0.250941 5.7694444 0.250383 5.7722222 0.252056 5.7750000 0.250941 5.7777778 0.250941 5.7805556 0.250383 5.7833333 0.250941 5.7861111 0.252613 5.7888889 0.252056 5.7916667 0.251498 5.7944444 0.251498 5.7972222 0.249268 5.8000000 0.250383 5.8027778 0.250383 5.8055556 0.252056 5.8083333 0.252056 5.8111111 0.251498 5.8138889 0.250941 5.8166667 0.250941 5.8194444 0.252056 5.8222222 0.252613 5.8250000 0.252056 5.8277778 0.250941 5.8305556 0.248153 5.8333333 0.249268 5.8361111 0.249268 5.8388889 0.249826 5.8416667 0.250383 5.8444444 0.250383 5.8472222 0.248711 5.8500000 0.247596 5.8527778 0.247038 5.8555556 0.248153 5.8583333 0.247596 5.8611111 0.247596 5.8638889 0.247596 5.8666667 0.245923 5.8694444 0.247596 5.8722222 0.247038 5.8750000 0.248153 5.8777778 0.247596 5.8805556 0.248153 5.8833333 0.247038 5.8861111 0.250383 5.8888889 0.252613 5.8916667 0.254286 5.8944444 0.255401 5.8972222 0.255401 5.9000000 0.254843 5.9027778 0.256516 5.9055556 0.257631 5.9083333 0.259861 5.9111111 0.259861 5.9138889 0.258188 5.9166667 0.258188 5.9194444 0.259303 5.9222222 0.259861 5.9250000 0.260976 5.9277778 0.259303 5.9305556 0.259861 5.9333333 0.260418 5.9361111 0.260418 5.9388889 0.260976 5.9416667 0.261533 5.9444444 0.260976 5.9472222 0.260418 5.9500000 0.260418 5.9527778 0.260976 5.9555556 0.263206 5.9583333 0.261533 5.9611111 0.260976 5.9638889 0.259861 5.9666667 0.259303 5.9694444 0.259861 5.9722222 0.260418 5.9750000 0.260418 5.9777778 0.260418 5.9805556 0.259861 5.9833333 0.258746 5.9861111 0.259303 5.9888889 0.259861 5.9916667 0.259303 5.9944444 0.258746 5.9972222 0.258188 6.0000000 0.257631 6.0027778 0.257631 6.0055556 0.259303 6.0083333 0.258188 6.0111111 0.256516 6.0138889 0.256516 6.0166667 0.256516 6.0194444 0.257631 6.0222222 0.258188 6.0250000 0.258188 6.0277778 0.257631 6.0305556 0.256516 6.0333333 0.254286 6.0361111 0.254286 6.0388889 0.255401 6.0416667 0.256516 6.0444444 0.255401 6.0472222 0.255401 6.0500000 0.252613 6.0527778 0.252613 6.0555556 0.254286 6.0583333 0.255958 6.0611111 0.255401 6.0638889 0.254843 6.0666667 0.254286 6.0694444 0.254286 6.0722222 0.256516 6.0750000 0.256516 6.0777778 0.255401 6.0805556 0.254286 6.0833333 0.252613 6.0861111 0.253728 6.0888889 0.254843 6.0916667 0.256516 6.0944444 0.255401 6.0972222 0.254286 6.1000000 0.253728 6.1027778 0.254286 6.1055556 0.255401 6.1083333 0.254843 6.1111111 0.253728 6.1138889 0.252056 6.1166667 0.251498 6.1194444 0.250941 6.1222222 0.253728 6.1250000 0.254843 6.1277778 0.255401 6.1305556 0.253728 6.1333333 0.254286 6.1361111 0.253728 6.1388889 0.256516 6.1416667 0.255958 6.1444444 0.255958 6.1472222 0.255401 6.1500000 0.254843 6.1527778 0.255401 6.1555556 0.257073 6.1583333 0.257073 6.1611111 0.255958 6.1638889 0.256516 6.1666667 0.257631 6.1694444 0.261533 6.1722222 0.261533 6.1750000 0.262091 6.1777778 0.262648 6.1805556 0.260418 6.1833333 0.261533 6.1861111 0.263763 6.1888889 0.264878 6.1916667 0.266551 6.1944444 0.267666 6.1972222 0.266551 6.2000000 0.265436 6.2027778 0.265436 6.2055556 0.264878 6.2083333 0.265993 6.2111111 0.263206 6.2138889 0.262648 6.2166667 0.263206 6.2194444 0.262648 6.2222222 0.262648 6.2250000 0.263763 6.2277778 0.264321 6.2305556 0.263763 6.2333333 0.264878 6.2361111 0.263206 6.2388889 0.262091 6.2416667 0.260976 6.2444444 0.258188 6.2472222 0.254286 6.2500000 0.253728 6.2527778 0.254286 6.2555556 0.255401 6.2583333 0.254843 6.2611111 0.253728 6.2638889 0.253171 6.2666667 0.253171 6.2694444 0.253728 6.2722222 0.254286 6.2750000 0.254843 6.2777778 0.251498 6.2805556 0.252056 6.2833333 0.250383 6.2861111 0.252056 6.2888889 0.252613 6.2916667 0.252613 6.2944444 0.252056 6.2972222 0.250383 6.3000000 0.249268 6.3027778 0.250941 6.3055556 0.252613 6.3083333 0.253171 6.3111111 0.252056 6.3138889 0.252613 6.3166667 0.249826 6.3194444 0.248153 6.3222222 0.246481 6.3250000 0.243136 6.3277778 0.240348 6.3305556 0.233659 6.3333333 0.227526 6.3361111 0.228641 6.3388889 0.237561 6.3416667 0.253171 6.3444444 0.271010 6.3472222 0.290523 6.3500000 0.318955 6.3527778 0.353519 6.3555556 0.378606 6.3583333 0.390871 6.3611111 0.381951 6.3638889 0.347944 6.3666667 0.300557 6.3694444 0.263206 6.3722222 0.245366 6.3750000 0.238676 6.3777778 0.235331 6.3805556 0.237003 6.3833333 0.241463 6.3861111 0.247596 6.3888889 0.250383 6.3916667 0.248711 6.3944444 0.248711 6.3972222 0.248153 6.4000000 0.246481 6.4027778 0.247596 6.4055556 0.249268 6.4083333 0.250383 6.4111111 0.250383 6.4138889 0.248711 6.4166667 0.247038 6.4194444 0.248153 6.4222222 0.247596 6.4250000 0.248153 6.4277778 0.247596 6.4305556 0.247596 6.4333333 0.247038 6.4361111 0.248153 6.4388889 0.250383 6.4416667 0.249268 6.4444444 0.249268 6.4472222 0.249268 6.4500000 0.247038 6.4527778 0.249268 6.4555556 0.248153 6.4583333 0.249268 6.4611111 0.248153 6.4638889 0.247038 6.4666667 0.248153 6.4694444 0.247596 6.4722222 0.248153 6.4750000 0.248711 6.4777778 0.249826 6.4805556 0.248153 6.4833333 0.247038 6.4861111 0.248711 6.4888889 0.248711 6.4916667 0.248153 6.4944444 0.248711 6.4972222 0.247038 6.5000000 0.246481 6.5027778 0.248153 6.5055556 0.249268 6.5083333 0.250941 6.5111111 0.248153 6.5138889 0.249268 6.5166667 0.247596 6.5194444 0.249268 6.5222222 0.248711 6.5250000 0.249826 6.5277778 0.248711 6.5305556 0.248153 6.5333333 0.246481 6.5361111 0.247038 6.5388889 0.248153 6.5416667 0.248153 6.5444444 0.248153 6.5472222 0.248153 6.5500000 0.247038 6.5527778 0.247596 6.5555556 0.248711 6.5583333 0.249268 6.5611111 0.248153 6.5638889 0.247596 6.5666667 0.246481 6.5694444 0.248711 6.5722222 0.247596 6.5750000 0.248711 6.5777778 0.248711 6.5805556 0.245923 6.5833333 0.245923 6.5861111 0.246481 6.5888889 0.247596 6.5916667 0.246481 6.5944444 0.245366 6.5972222 0.244808 6.6000000 0.242021 6.6027778 0.244808 6.6055556 0.246481 6.6083333 0.247038 6.6111111 0.245923 6.6138889 0.244808 6.6166667 0.244251 6.6194444 0.243693 6.6222222 0.245366 6.6250000 0.245923 6.6277778 0.245366 6.6305556 0.242578 6.6333333 0.243693 6.6361111 0.243136 6.6388889 0.245366 6.6416667 0.246481 6.6444444 0.248153 6.6472222 0.247596 6.6500000 0.250383 6.6527778 0.252056 6.6555556 0.253171 6.6583333 0.254286 6.6611111 0.254286 6.6638889 0.254286 6.6666667 0.255958 6.6694444 0.257073 6.6722222 0.259303 6.6750000 0.259861 6.6777778 0.260976 6.6805556 0.260418 6.6833333 0.259861 6.6861111 0.260976 6.6888889 0.261533 6.6916667 0.261533 6.6944444 0.260976 6.6972222 0.259303 6.7000000 0.259861 6.7027778 0.260418 6.7055556 0.261533 6.7083333 0.263763 6.7111111 0.262648 6.7138889 0.261533 6.7166667 0.262091 6.7194444 0.262648 6.7222222 0.263206 6.7250000 0.265436 6.7277778 0.262648 6.7305556 0.262648 6.7333333 0.259303 6.7361111 0.262091 6.7388889 0.263206 6.7416667 0.263206 6.7444444 0.263206 6.7472222 0.262091 6.7500000 0.260418 6.7527778 0.261533 6.7555556 0.262091 6.7583333 0.262648 6.7611111 0.262091 6.7638889 0.259861 6.7666667 0.259861 6.7694444 0.260418 6.7722222 0.262091 6.7750000 0.262648 6.7777778 0.261533 6.7805556 0.260418 6.7833333 0.260418 6.7861111 0.260976 6.7888889 0.260976 6.7916667 0.260976 6.7944444 0.260418 6.7972222 0.259861 6.8000000 0.259861 6.8027778 0.260976 6.8055556 0.260976 6.8083333 0.261533 6.8111111 0.261533 6.8138889 0.261533 6.8166667 0.259303 6.8194444 0.260418 6.8222222 0.260976 6.8250000 0.259861 6.8277778 0.259861 6.8305556 0.259861 6.8333333 0.258746 6.8361111 0.259303 6.8388889 0.260976 6.8416667 0.259861 6.8444444 0.260976 6.8472222 0.260418 6.8500000 0.259861 6.8527778 0.260418 6.8555556 0.260976 6.8583333 0.261533 6.8611111 0.260418 6.8638889 0.260976 6.8666667 0.259303 6.8694444 0.259861 6.8722222 0.260976 6.8750000 0.260976 6.8777778 0.262091 6.8805556 0.261533 6.8833333 0.260418 6.8861111 0.262091 6.8888889 0.263206 6.8916667 0.262648 6.8944444 0.261533 6.8972222 0.261533 6.9000000 0.259861 6.9027778 0.260976 6.9055556 0.261533 6.9083333 0.262648 6.9111111 0.262091 6.9138889 0.260976 6.9166667 0.260418 6.9194444 0.262091 6.9222222 0.262648 6.9250000 0.263206 6.9277778 0.263206 6.9305556 0.263763 6.9333333 0.262648 6.9361111 0.264321 6.9388889 0.265993 6.9416667 0.267666 6.9444444 0.268223 6.9472222 0.267108 6.9500000 0.267108 6.9527778 0.268780 6.9555556 0.270453 6.9583333 0.271568 6.9611111 0.272125 6.9638889 0.273240 6.9666667 0.272125 6.9694444 0.273240 6.9722222 0.275470 6.9750000 0.275470 6.9777778 0.274355 6.9805556 0.272683 6.9833333 0.272125 6.9861111 0.271568 6.9888889 0.273240 6.9916667 0.273240 6.9944444 0.272125 6.9972222 0.271010 7.0000000 0.268780 7.0027778 0.273240 7.0055556 0.275470 7.0083333 0.276585 7.0111111 0.273798 7.0138889 0.268780 7.0166667 0.265436 7.0194444 0.265993 7.0222222 0.265993 7.0250000 0.263763 7.0277778 0.263206 7.0305556 0.262091 7.0333333 0.260418 7.0361111 0.261533 7.0388889 0.261533 7.0416667 0.262648 7.0444444 0.262091 7.0472222 0.260976 7.0500000 0.259861 7.0527778 0.259303 7.0555556 0.260418 7.0583333 0.258746 7.0611111 0.259861 7.0638889 0.259303 7.0666667 0.257631 7.0694444 0.259303 7.0722222 0.259861 7.0750000 0.259861 7.0777778 0.259861 7.0805556 0.259303 7.0833333 0.258746 7.0861111 0.260418 7.0888889 0.260976 7.0916667 0.259861 7.0944444 0.257631 7.0972222 0.254286 7.1000000 0.248153 7.1027778 0.245923 7.1055556 0.244251 7.1083333 0.241463 7.1111111 0.237003 7.1138889 0.238676 7.1166667 0.247038 7.1194444 0.263206 7.1222222 0.282718 7.1250000 0.303902 7.1277778 0.331777 7.1305556 0.363554 7.1333333 0.388084 7.1361111 0.404808 7.1388889 0.404808 7.1416667 0.380279 7.1444444 0.333449 7.1472222 0.287178 7.1500000 0.255401 7.1527778 0.245366 7.1555556 0.248153 7.1583333 0.254286 7.1611111 0.259861 7.1638889 0.259303 7.1666667 0.257631 7.1694444 0.257631 7.1722222 0.258188 7.1750000 0.257631 7.1777778 0.258188 7.1805556 0.256516 7.1833333 0.255958 7.1861111 0.254843 7.1888889 0.257073 7.1916667 0.256516 7.1944444 0.256516 7.1972222 0.254843 7.2000000 0.255401 7.2027778 0.255958 7.2055556 0.256516 7.2083333 0.257073 7.2111111 0.255958 7.2138889 0.254286 7.2166667 0.254843 7.2194444 0.255401 7.2222222 0.255958 7.2250000 0.257631 7.2277778 0.257073 7.2305556 0.255401 7.2333333 0.254843 7.2361111 0.254843 7.2388889 0.257073 7.2416667 0.258746 7.2444444 0.257631 7.2472222 0.257073 7.2500000 0.255958 7.2527778 0.256516 7.2555556 0.257631 7.2583333 0.257073 7.2611111 0.257073 7.2638889 0.256516 7.2666667 0.255401 7.2694444 0.257631 7.2722222 0.257631 7.2750000 0.258746 7.2777778 0.257073 7.2805556 0.256516 7.2833333 0.255958 7.2861111 0.257073 7.2888889 0.257073 7.2916667 0.257631 7.2944444 0.258746 7.2972222 0.257073 7.3000000 0.256516 7.3027778 0.257073 7.3055556 0.258188 7.3083333 0.258188 7.3111111 0.257631 7.3138889 0.257631 7.3166667 0.257073 7.3194444 0.259303 7.3222222 0.258746 7.3250000 0.258746 7.3277778 0.258188 7.3305556 0.257073 7.3333333 0.256516 7.3361111 0.257631 7.3388889 0.259303 7.3416667 0.258188 7.3444444 0.257631 7.3472222 0.256516 7.3500000 0.255958 7.3527778 0.258188 7.3555556 0.257631 7.3583333 0.257631 7.3611111 0.258188 7.3638889 0.256516 7.3666667 0.256516 7.3694444 0.257631 7.3722222 0.258188 7.3750000 0.257631 7.3777778 0.258188 7.3805556 0.257073 7.3833333 0.255958 7.3861111 0.257073 7.3888889 0.257631 7.3916667 0.257631 7.3944444 0.257073 7.3972222 0.256516 7.4000000 0.256516 7.4027778 0.257631 7.4055556 0.258188 7.4083333 0.259303 7.4111111 0.259303 7.4138889 0.257631 7.4166667 0.257073 7.4194444 0.257073 7.4222222 0.259303 7.4250000 0.260976 7.4277778 0.260418 7.4305556 0.259861 7.4333333 0.260976 7.4361111 0.262091 7.4388889 0.264321 7.4416667 0.265436 7.4444444 0.265993 7.4472222 0.266551 7.4500000 0.265436 7.4527778 0.266551 7.4555556 0.268223 7.4583333 0.269338 7.4611111 0.268223 7.4638889 0.268223 7.4666667 0.267666 7.4694444 0.270453 7.4722222 0.269895 7.4750000 0.268780 7.4777778 0.270453 7.4805556 0.270453 7.4833333 0.269338 7.4861111 0.270453 7.4888889 0.270453 7.4916667 0.272125 7.4944444 0.270453 7.4972222 0.269895 7.5000000 0.268223 7.5027778 0.269895 7.5055556 0.269895 7.5083333 0.270453 7.5111111 0.269338 7.5138889 0.269338 7.5166667 0.267666 7.5194444 0.268780 7.5222222 0.268780 7.5250000 0.269338 7.5277778 0.267666 7.5305556 0.267666 7.5333333 0.265436 7.5361111 0.268223 7.5388889 0.268223 7.5416667 0.268223 7.5444444 0.267666 7.5472222 0.266551 7.5500000 0.266551 7.5527778 0.266551 7.5555556 0.265993 7.5583333 0.266551 7.5611111 0.265436 7.5638889 0.265993 7.5666667 0.265436 7.5694444 0.265993 7.5722222 0.267108 7.5750000 0.267108 7.5777778 0.267666 7.5805556 0.267108 7.5833333 0.264878 7.5861111 0.265993 7.5888889 0.265436 7.5916667 0.265993 7.5944444 0.265436 7.5972222 0.264321 7.6000000 0.263206 7.6027778 0.264321 7.6055556 0.264878 7.6083333 0.265993 7.6111111 0.265436 7.6138889 0.265436 7.6166667 0.263763 7.6194444 0.264878 7.6222222 0.264878 7.6250000 0.265436 7.6277778 0.265436 7.6305556 0.263763 7.6333333 0.262648 7.6361111 0.264321 7.6388889 0.264878 7.6416667 0.265436 7.6444444 0.264321 7.6472222 0.263763 7.6500000 0.263206 7.6527778 0.265436 7.6555556 0.265436 7.6583333 0.265436 7.6611111 0.264878 7.6638889 0.264878 7.6666667 0.264321 7.6694444 0.265436 7.6722222 0.264878 7.6750000 0.264878 7.6777778 0.264878 7.6805556 0.264321 7.6833333 0.264321 7.6861111 0.264878 7.6888889 0.265436 7.6916667 0.265436 7.6944444 0.265993 7.6972222 0.264878 7.7000000 0.264321 7.7027778 0.263206 7.7055556 0.265436 7.7083333 0.265993 7.7111111 0.266551 7.7138889 0.267108 7.7166667 0.269895 7.7194444 0.271010 7.7222222 0.272125 7.7250000 0.274355 7.7277778 0.274355 7.7305556 0.273798 7.7333333 0.273240 7.7361111 0.274355 7.7388889 0.275470 7.7416667 0.278815 7.7444444 0.277700 7.7472222 0.277143 7.7500000 0.276028 7.7527778 0.277700 7.7555556 0.277143 7.7583333 0.277143 7.7611111 0.276585 7.7638889 0.274913 7.7666667 0.273240 7.7694444 0.273240 7.7722222 0.274913 7.7750000 0.275470 7.7777778 0.273240 7.7805556 0.273240 7.7833333 0.274355 7.7861111 0.277143 7.7888889 0.278815 7.7916667 0.277143 7.7944444 0.273798 7.7972222 0.271010 7.8000000 0.269338 7.8027778 0.268780 7.8055556 0.267108 7.8083333 0.265436 7.8111111 0.265993 7.8138889 0.263206 7.8166667 0.263206 7.8194444 0.262648 7.8222222 0.263763 7.8250000 0.263763 7.8277778 0.263763 7.8305556 0.262648 7.8333333 0.261533 7.8361111 0.262648 7.8388889 0.263763 7.8416667 0.263763 7.8444444 0.263206 7.8472222 0.262091 7.8500000 0.260418 7.8527778 0.260976 7.8555556 0.262091 7.8583333 0.262648 7.8611111 0.262091 7.8638889 0.260976 7.8666667 0.260418 7.8694444 0.262091 7.8722222 0.262648 7.8750000 0.262648 7.8777778 0.262648 7.8805556 0.261533 7.8833333 0.260976 7.8861111 0.258746 7.8888889 0.254843 7.8916667 0.250383 7.8944444 0.248153 7.8972222 0.243693 7.9000000 0.238118 7.9027778 0.235889 7.9055556 0.242021 7.9083333 0.254843 7.9111111 0.272125 7.9138889 0.287735 7.9166667 0.308362 7.9194444 0.340139 7.9222222 0.369129 7.9250000 0.389756 7.9277778 0.400348 7.9305556 0.392544 7.9333333 0.359094 7.9361111 0.311150 7.9388889 0.269895 7.9416667 0.248711 7.9444444 0.244808 7.9472222 0.249268 7.9500000 0.256516 7.9527778 0.256516 7.9555556 0.257631 7.9583333 0.257631 7.9611111 0.258188 7.9638889 0.257073 7.9666667 0.257631 7.9694444 0.257631 7.9722222 0.258746 7.9750000 0.258188 7.9777778 0.259303 7.9805556 0.257631 7.9833333 0.256516 7.9861111 0.257631 7.9888889 0.258188 7.9916667 0.259861 7.9944444 0.259303 7.9972222 0.257073 8.0000000 0.257073 8.0027778 0.258188 8.0055556 0.257631 8.0083333 0.257073 8.0111111 0.257073 8.0138889 0.256516 8.0166667 0.257073 8.0194444 0.257631 8.0222222 0.258188 8.0250000 0.259861 8.0277778 0.257631 8.0305556 0.257631 8.0333333 0.257073 8.0361111 0.257631 8.0388889 0.258746 8.0416667 0.258746 8.0444444 0.258746 8.0472222 0.257631 8.0500000 0.257073 8.0527778 0.258746 8.0555556 0.258746 8.0583333 0.259303 8.0611111 0.259303 8.0638889 0.258746 8.0666667 0.257631 8.0694444 0.258188 8.0722222 0.259861 8.0750000 0.259861 8.0777778 0.259861 8.0805556 0.258188 8.0833333 0.257631 8.0861111 0.258188 8.0888889 0.258746 8.0916667 0.260976 8.0944444 0.259861 8.0972222 0.258746 8.1000000 0.258188 8.1027778 0.259861 8.1055556 0.259861 8.1083333 0.259861 8.1111111 0.260418 8.1138889 0.259303 8.1166667 0.258188 8.1194444 0.259861 8.1222222 0.259861 8.1250000 0.260976 8.1277778 0.260976 8.1305556 0.259861 8.1333333 0.258188 8.1361111 0.260418 8.1388889 0.260976 8.1416667 0.261533 8.1444444 0.261533 8.1472222 0.259861 8.1500000 0.258746 8.1527778 0.258746 8.1555556 0.259861 8.1583333 0.260418 8.1611111 0.259303 8.1638889 0.258188 8.1666667 0.257073 8.1694444 0.257631 8.1722222 0.258188 8.1750000 0.259861 8.1777778 0.259861 8.1805556 0.258188 8.1833333 0.257073 8.1861111 0.259303 8.1888889 0.261533 8.1916667 0.260418 8.1944444 0.260976 8.1972222 0.259861 8.2000000 0.258746 8.2027778 0.258746 8.2055556 0.261533 8.2083333 0.260976 8.2111111 0.262091 8.2138889 0.262091 8.2166667 0.262091 8.2194444 0.262648 8.2222222 0.264878 8.2250000 0.267108 8.2277778 0.267108 8.2305556 0.266551 8.2333333 0.266551 8.2361111 0.269338 8.2388889 0.269338 8.2416667 0.270453 8.2444444 0.269338 8.2472222 0.269338 8.2500000 0.269895 8.2527778 0.269895 8.2555556 0.271010 8.2583333 0.271568 8.2611111 0.271010 8.2638889 0.271010 8.2666667 0.270453 8.2694444 0.271010 8.2722222 0.272125 8.2750000 0.270453 8.2777778 0.271010 8.2805556 0.270453 8.2833333 0.269895 8.2861111 0.269895 8.2888889 0.271568 8.2916667 0.269895 8.2944444 0.269895 8.2972222 0.268223 8.3000000 0.267108 8.3027778 0.268780 8.3055556 0.268223 8.3083333 0.269338 8.3111111 0.268780 8.3138889 0.268780 8.3166667 0.267666 8.3194444 0.268223 8.3222222 0.268223 8.3250000 0.267666 8.3277778 0.268223 8.3305556 0.267108 8.3333333 0.265993 8.3361111 0.265436 8.3388889 0.267108 8.3416667 0.268223 8.3444444 0.267666 8.3472222 0.268223 8.3500000 0.267108 8.3527778 0.266551 8.3555556 0.266551 8.3583333 0.267666 8.3611111 0.264321 8.3638889 0.264321 8.3666667 0.263206 8.3694444 0.262648 8.3722222 0.264878 8.3750000 0.265436 8.3777778 0.265436 8.3805556 0.263763 8.3833333 0.262648 8.3861111 0.263206 8.3888889 0.264321 8.3916667 0.263763 8.3944444 0.264321 8.3972222 0.261533 8.4000000 0.260976 8.4027778 0.262648 8.4055556 0.263763 8.4083333 0.263763 8.4111111 0.262648 8.4138889 0.263763 8.4166667 0.261533 8.4194444 0.262091 8.4222222 0.262091 8.4250000 0.262648 8.4277778 0.260976 8.4305556 0.261533 8.4333333 0.260976 8.4361111 0.263763 8.4388889 0.264321 8.4416667 0.264878 8.4444444 0.264321 8.4472222 0.263763 8.4500000 0.262648 8.4527778 0.264321 8.4555556 0.264878 8.4583333 0.264878 8.4611111 0.264321 8.4638889 0.262091 8.4666667 0.260976 8.4694444 0.261533 8.4722222 0.263763 8.4750000 0.263206 8.4777778 0.263763 8.4805556 0.263206 8.4833333 0.263206 8.4861111 0.263763 8.4888889 0.265436 8.4916667 0.266551 8.4944444 0.267108 8.4972222 0.267666 8.5000000 0.269338 8.5027778 0.268223 8.5055556 0.270453 8.5083333 0.271010 8.5111111 0.271010 8.5138889 0.269895 8.5166667 0.271010 8.5194444 0.273240 8.5222222 0.275470 8.5250000 0.273798 8.5277778 0.274355 8.5305556 0.274355 8.5333333 0.271568 8.5361111 0.273240 8.5388889 0.274913 8.5416667 0.273798 8.5444444 0.273240 8.5472222 0.273798 8.5500000 0.272125 8.5527778 0.272683 8.5555556 0.272683 8.5583333 0.270453 8.5611111 0.270453 8.5638889 0.273798 8.5666667 0.272683 8.5694444 0.275470 8.5722222 0.272125 8.5750000 0.270453 8.5777778 0.268223 8.5805556 0.267108 8.5833333 0.265436 8.5861111 0.264321 8.5888889 0.262091 8.5916667 0.262091 8.5944444 0.260976 8.5972222 0.259861 8.6000000 0.259303 8.6027778 0.258746 8.6055556 0.259303 8.6083333 0.259861 8.6111111 0.259861 8.6138889 0.259303 8.6166667 0.258188 8.6194444 0.258746 8.6222222 0.259861 8.6250000 0.259861 8.6277778 0.259303 8.6305556 0.259861 8.6333333 0.258746 8.6361111 0.258188 8.6388889 0.258188 8.6416667 0.257631 8.6444444 0.257631 8.6472222 0.257631 8.6500000 0.257073 8.6527778 0.257073 8.6555556 0.258188 8.6583333 0.257631 8.6611111 0.255401 8.6638889 0.253171 8.6666667 0.248711 8.6694444 0.245923 8.6722222 0.245366 8.6750000 0.243693 8.6777778 0.238118 8.6805556 0.231429 8.6833333 0.231429 8.6861111 0.236446 8.6888889 0.247038 8.6916667 0.257073 8.6944444 0.264878 8.6972222 0.273240 8.7000000 0.285505 8.7027778 0.304460 8.7055556 0.327317 8.7083333 0.353519 8.7111111 0.374704 8.7138889 0.386969 8.7166667 0.389199 8.7194444 0.373589 8.7222222 0.341254 8.7250000 0.302230 8.7277778 0.269338 8.7305556 0.249268 8.7333333 0.240906 8.7361111 0.242578 8.7388889 0.246481 8.7416667 0.252056 8.7444444 0.252056 8.7472222 0.252613 8.7500000 0.250941 8.7527778 0.252056 8.7555556 0.253171 8.7583333 0.254843 8.7611111 0.252056 8.7638889 0.249826 8.7666667 0.250383 8.7694444 0.252056 8.7722222 0.252613 8.7750000 0.253171 8.7777778 0.253728 8.7805556 0.252056 8.7833333 0.252056 8.7861111 0.251498 8.7888889 0.253171 8.7916667 0.252056 8.7944444 0.252056 8.7972222 0.250941 8.8000000 0.249826 8.8027778 0.251498 8.8055556 0.252613 8.8083333 0.253171 8.8111111 0.252613 8.8138889 0.250941 8.8166667 0.249268 8.8194444 0.249826 8.8222222 0.250383 8.8250000 0.250941 8.8277778 0.251498 8.8305556 0.253171 8.8333333 0.251498 8.8361111 0.252056 8.8388889 0.252613 8.8416667 0.252613 8.8444444 0.251498 8.8472222 0.250941 8.8500000 0.250941 8.8527778 0.250383 8.8555556 0.252056 8.8583333 0.252056 8.8611111 0.252056 8.8638889 0.250941 8.8666667 0.250383 8.8694444 0.250941 8.8722222 0.251498 8.8750000 0.251498 8.8777778 0.250941 8.8805556 0.250941 8.8833333 0.250383 8.8861111 0.249826 8.8888889 0.250941 8.8916667 0.252613 8.8944444 0.250941 8.8972222 0.251498 8.9000000 0.250941 8.9027778 0.250383 8.9055556 0.250383 8.9083333 0.252056 8.9111111 0.252613 8.9138889 0.252056 8.9166667 0.250383 8.9194444 0.251498 8.9222222 0.252613 8.9250000 0.251498 8.9277778 0.251498 8.9305556 0.249268 8.9333333 0.249826 8.9361111 0.249268 8.9388889 0.251498 8.9416667 0.252056 8.9444444 0.252056 8.9472222 0.251498 8.9500000 0.249268 8.9527778 0.249826 8.9555556 0.250383 8.9583333 0.251498 8.9611111 0.250383 8.9638889 0.249826 8.9666667 0.248711 8.9694444 0.248711 8.9722222 0.248711 8.9750000 0.248153 8.9777778 0.247596 8.9805556 0.246481 8.9833333 0.245923 8.9861111 0.245923 8.9888889 0.248711 8.9916667 0.247596 8.9944444 0.246481 8.9972222 0.246481 9.0000000 0.246481 9.0027778 0.247038 9.0055556 0.248711 9.0083333 0.250941 9.0111111 0.251498 9.0138889 0.250941 9.0166667 0.251498 9.0194444 0.254843 9.0222222 0.255401 9.0250000 0.257073 9.0277778 0.255958 9.0305556 0.257073 9.0333333 0.256516 9.0361111 0.258746 9.0388889 0.259303 9.0416667 0.260976 9.0444444 0.260976 9.0472222 0.260418 9.0500000 0.258188 9.0527778 0.259861 9.0555556 0.261533 9.0583333 0.261533 9.0611111 0.260976 9.0638889 0.261533 9.0666667 0.261533 9.0694444 0.262091 9.0722222 0.260976 9.0750000 0.260976 9.0777778 0.260976 9.0805556 0.259861 9.0833333 0.259303 9.0861111 0.259861 9.0888889 0.259861 9.0916667 0.259861 9.0944444 0.259303 9.0972222 0.259303 9.1000000 0.259861 9.1027778 0.260976 9.1055556 0.261533 9.1083333 0.262091 9.1111111 0.260418 9.1138889 0.260418 9.1166667 0.259303 9.1194444 0.260418 9.1222222 0.259861 9.1250000 0.259861 9.1277778 0.259303 9.1305556 0.258188 9.1333333 0.256516 9.1361111 0.257631 9.1388889 0.259303 9.1416667 0.260976 9.1444444 0.259861 9.1472222 0.257073 9.1500000 0.256516 9.1527778 0.257631 9.1555556 0.258188 9.1583333 0.258188 9.1611111 0.257631 9.1638889 0.255958 9.1666667 0.254286 9.1694444 0.255958 9.1722222 0.257073 9.1750000 0.257631 9.1777778 0.257073 9.1805556 0.256516 9.1833333 0.255958 9.1861111 0.256516 9.1888889 0.257073 9.1916667 0.257631 9.1944444 0.255958 9.1972222 0.255958 9.2000000 0.255401 9.2027778 0.255401 9.2055556 0.255401 9.2083333 0.255958 9.2111111 0.255958 9.2138889 0.256516 9.2166667 0.257073 9.2194444 0.257631 9.2222222 0.258746 9.2250000 0.259861 9.2277778 0.258188 9.2305556 0.257631 9.2333333 0.255401 9.2361111 0.256516 9.2388889 0.255958 9.2416667 0.257073 9.2444444 0.257073 9.2472222 0.257073 9.2500000 0.256516 9.2527778 0.256516 9.2555556 0.257631 9.2583333 0.256516 9.2611111 0.255958 9.2638889 0.256516 9.2666667 0.255958 9.2694444 0.255401 9.2722222 0.254843 9.2750000 0.255958 9.2777778 0.256516 9.2805556 0.257073 9.2833333 0.256516 9.2861111 0.257631 9.2888889 0.261533 9.2916667 0.263206 9.2944444 0.263763 9.2972222 0.262648 9.3000000 0.262648 9.3027778 0.262648 9.3055556 0.264878 9.3083333 0.266551 9.3111111 0.267666 9.3138889 0.266551 9.3166667 0.265436 9.3194444 0.265436 9.3222222 0.267666 9.3250000 0.268780 9.3277778 0.268223 9.3305556 0.266551 9.3333333 0.266551 9.3361111 0.267108 9.3388889 0.267666 9.3416667 0.267666 9.3444444 0.268223 9.3472222 0.267666 9.3500000 0.264321 9.3527778 0.263763 9.3555556 0.265436 9.3583333 0.266551 9.3611111 0.268223 9.3638889 0.268223 9.3666667 0.267108 9.3694444 0.263763 9.3722222 0.264321 9.3750000 0.261533 9.3777778 0.259303 9.3805556 0.257073 9.3833333 0.254843 9.3861111 0.254286 9.3888889 0.255958 9.3916667 0.255958 9.3944444 0.254843 9.3972222 0.254843 9.4000000 0.252613 9.4027778 0.254286 9.4055556 0.254843 9.4083333 0.254286 9.4111111 0.252613 9.4138889 0.252613 9.4166667 0.250941 9.4194444 0.252613 9.4222222 0.253171 9.4250000 0.253728 9.4277778 0.253728 9.4305556 0.254286 9.4333333 0.253728 9.4361111 0.253728 9.4388889 0.254286 9.4416667 0.254286 9.4444444 0.255401 9.4472222 0.254286 9.4500000 0.253728 9.4527778 0.253728 9.4555556 0.253171 9.4583333 0.250383 9.4611111 0.245923 9.4638889 0.243136 9.4666667 0.242578 9.4694444 0.243693 9.4722222 0.246481 9.4750000 0.245366 9.4777778 0.240348 9.4805556 0.235331 9.4833333 0.230871 9.4861111 0.231429 9.4888889 0.237561 9.4916667 0.248711 9.4944444 0.261533 9.4972222 0.276028 9.5000000 0.293310 9.5027778 0.318955 9.5055556 0.349059 9.5083333 0.375819 9.5111111 0.390871 9.5138889 0.393101 9.5166667 0.376376 9.5194444 0.339024 9.5222222 0.297213 9.5250000 0.265993 9.5277778 0.248153 9.5305556 0.241463 9.5333333 0.239791 9.5361111 0.243136 9.5388889 0.250383 9.5416667 0.251498 9.5444444 0.250941 9.5472222 0.249826 9.5500000 0.248711 9.5527778 0.250941 9.5555556 0.250383 9.5583333 0.251498 9.5611111 0.250941 9.5638889 0.249826 9.5666667 0.249268 9.5694444 0.248153 9.5722222 0.250383 9.5750000 0.250941 9.5777778 0.249268 9.5805556 0.249826 9.5833333 0.247596 9.5861111 0.250941 9.5888889 0.251498 9.5916667 0.250383 9.5944444 0.251498 9.5972222 0.250383 9.6000000 0.249826 9.6027778 0.249268 9.6055556 0.250941 9.6083333 0.251498 9.6111111 0.251498 9.6138889 0.252056 9.6166667 0.249826 9.6194444 0.250941 9.6222222 0.252056 9.6250000 0.252613 9.6277778 0.252613 9.6305556 0.251498 9.6333333 0.250383 9.6361111 0.250383 9.6388889 0.252613 9.6416667 0.254286 9.6444444 0.252613 9.6472222 0.252056 9.6500000 0.249826 9.6527778 0.251498 9.6555556 0.250941 9.6583333 0.251498 9.6611111 0.250941 9.6638889 0.252056 9.6666667 0.250941 9.6694444 0.252056 9.6722222 0.252056 9.6750000 0.251498 9.6777778 0.252056 9.6805556 0.250383 9.6833333 0.250941 9.6861111 0.252056 9.6888889 0.253728 9.6916667 0.253728 9.6944444 0.252613 9.6972222 0.252613 9.7000000 0.252056 9.7027778 0.252056 9.7055556 0.253171 9.7083333 0.253728 9.7111111 0.253171 9.7138889 0.252056 9.7166667 0.252056 9.7194444 0.253171 9.7222222 0.252613 9.7250000 0.252613 9.7277778 0.253728 9.7305556 0.250941 9.7333333 0.250383 9.7361111 0.250941 9.7388889 0.252056 9.7416667 0.252056 9.7444444 0.252056 9.7472222 0.250383 9.7500000 0.248711 9.7527778 0.249826 9.7555556 0.250941 9.7583333 0.250941 9.7611111 0.251498 9.7638889 0.250383 9.7666667 0.248711 9.7694444 0.248711 9.7722222 0.249268 9.7750000 0.249268 9.7777778 0.249268 9.7805556 0.249268 9.7833333 0.248711 9.7861111 0.248711 9.7888889 0.249826 9.7916667 0.250941 9.7944444 0.249268 9.7972222 0.249268 9.8000000 0.249268 9.8027778 0.250383 9.8055556 0.252613 9.8083333 0.253728 9.8111111 0.256516 9.8138889 0.257073 9.8166667 0.256516 9.8194444 0.259303 9.8222222 0.260418 9.8250000 0.262648 9.8277778 0.264878 9.8305556 0.263763 9.8333333 0.263763 9.8361111 0.265436 9.8388889 0.265436 9.8416667 0.267666 9.8444444 0.267108 9.8472222 0.266551 9.8500000 0.265993 9.8527778 0.267666 9.8555556 0.269338 9.8583333 0.269895 9.8611111 0.269338 9.8638889 0.267666 9.8666667 0.267666 9.8694444 0.267666 9.8722222 0.268780 9.8750000 0.268223 9.8777778 0.268780 9.8805556 0.268223 9.8833333 0.267108 9.8861111 0.267108 9.8888889 0.268223 9.8916667 0.269338 9.8944444 0.268780 9.8972222 0.268780 9.9000000 0.268223 9.9027778 0.268223 9.9055556 0.268780 9.9083333 0.270453 9.9111111 0.270453 9.9138889 0.267666 9.9166667 0.267666 9.9194444 0.266551 9.9222222 0.268780 9.9250000 0.268780 9.9277778 0.268780 9.9305556 0.268223 9.9333333 0.266551 9.9361111 0.265993 9.9388889 0.267108 9.9416667 0.267108 9.9444444 0.268223 9.9472222 0.267108 9.9500000 0.265993 9.9527778 0.267666 9.9555556 0.267108 9.9583333 0.267666 9.9611111 0.266551 9.9638889 0.265436 9.9666667 0.264321 9.9694444 0.264878 9.9722222 0.266551 9.9750000 0.267666 9.9777778 0.266551 9.9805556 0.266551 9.9833333 0.264321 9.9861111 0.264878 9.9888889 0.267666 9.9916667 0.267108 9.9944444 0.267108 9.9972222 0.266551 10.0000000 0.265993 10.0027778 0.265436 10.0055556 0.264878 10.0083333 0.266551 10.0111111 0.267108 10.0138889 0.265436 10.0166667 0.264878 10.0194444 0.265993 10.0222222 0.267108 10.0250000 0.266551 10.0277778 0.265993 10.0305556 0.264878 10.0333333 0.264878 10.0361111 0.264878 10.0388889 0.265436 10.0416667 0.265993 10.0444444 0.267108 10.0472222 0.265436 10.0500000 0.265993 10.0527778 0.267108 10.0555556 0.267108 10.0583333 0.267666 10.0611111 0.267666 10.0638889 0.266551 10.0666667 0.265436 10.0694444 0.265993 10.0722222 0.267666 10.0750000 0.267666 10.0777778 0.268780 10.0805556 0.267666 10.0833333 0.267108 10.0861111 0.267108 10.0888889 0.267666 10.0916667 0.269338 10.0944444 0.267666 10.0972222 0.267666 10.1000000 0.266551 10.1027778 0.266551 10.1055556 0.268223 10.1083333 0.268223 10.1111111 0.267666 10.1138889 0.267666 10.1166667 0.268780 10.1194444 0.271010 10.1222222 0.272683 10.1250000 0.274913 10.1277778 0.273798 10.1305556 0.274355 10.1333333 0.272683 10.1361111 0.274355 10.1388889 0.276585 10.1416667 0.277143 10.1444444 0.278815 10.1472222 0.277700 10.1500000 0.278258 10.1527778 0.279930 10.1555556 0.279373 10.1583333 0.279373 10.1611111 0.279930 10.1638889 0.277143 10.1666667 0.275470 10.1694444 0.275470 10.1722222 0.276585 10.1750000 0.277143 10.1777778 0.276028 10.1805556 0.273798 10.1833333 0.274355 10.1861111 0.276585 10.1888889 0.279930 10.1916667 0.280488 10.1944444 0.278258 10.1972222 0.275470 10.2000000 0.272125 10.2027778 0.272125 10.2055556 0.271010 10.2083333 0.269895 10.2111111 0.268780 10.2138889 0.267666 10.2166667 0.265993 10.2194444 0.265993 10.2222222 0.266551 10.2250000 0.267108 10.2277778 0.267108 10.2305556 0.265993 10.2333333 0.265993 10.2361111 0.266551 10.2388889 0.267108 10.2416667 0.266551 10.2444444 0.265993 10.2472222 0.264878 10.2500000 0.263206 10.2527778 0.263763 10.2555556 0.265436 10.2583333 0.265993 10.2611111 0.264878 10.2638889 0.265436 10.2666667 0.263206 10.2694444 0.263763 10.2722222 0.264878 10.2750000 0.265436 10.2777778 0.264878 10.2805556 0.264878 10.2833333 0.263206 10.2861111 0.262091 10.2888889 0.260418 10.2916667 0.257073 10.2944444 0.253171 10.2972222 0.249826 10.3000000 0.247038 10.3027778 0.244251 10.3055556 0.242578 10.3083333 0.247038 10.3111111 0.258746 10.3138889 0.274913 10.3166667 0.289965 10.3194444 0.312265 10.3222222 0.340697 10.3250000 0.373589 10.3277778 0.395331 10.3305556 0.408711 10.3333333 0.407038 10.3361111 0.384739 10.3388889 0.342927 10.3416667 0.296655 10.3444444 0.262648 10.3472222 0.249268 10.3500000 0.250383 10.3527778 0.257073 10.3555556 0.262091 10.3583333 0.263763 10.3611111 0.262648 10.3638889 0.261533 10.3666667 0.262091 10.3694444 0.261533 10.3722222 0.263763 10.3750000 0.263763 10.3777778 0.263763 10.3805556 0.262648 10.3833333 0.259303 10.3861111 0.260418 10.3888889 0.263206 10.3916667 0.263763 10.3944444 0.261533 10.3972222 0.260976 10.4000000 0.259861 10.4027778 0.259861 10.4055556 0.259303 10.4083333 0.260976 10.4111111 0.260418 10.4138889 0.259303 10.4166667 0.258746 10.4194444 0.258746 10.4222222 0.259861 10.4250000 0.260976 10.4277778 0.259861 10.4305556 0.260418 10.4333333 0.259861 10.4361111 0.259861 10.4388889 0.260976 10.4416667 0.260976 10.4444444 0.259861 10.4472222 0.259861 10.4500000 0.259861 10.4527778 0.260418 10.4555556 0.261533 10.4583333 0.262091 10.4611111 0.262091 10.4638889 0.261533 10.4666667 0.260418 10.4694444 0.260418 10.4722222 0.262091 10.4750000 0.263763 10.4777778 0.261533 10.4805556 0.261533 10.4833333 0.260418 10.4861111 0.260976 10.4888889 0.262091 10.4916667 0.263206 10.4944444 0.262648 10.4972222 0.262648 10.5000000 0.259303 10.5027778 0.261533 10.5055556 0.263206 10.5083333 0.262648 10.5111111 0.264321 10.5138889 0.263763 10.5166667 0.262091 10.5194444 0.262091 10.5222222 0.261533 10.5250000 0.263763 10.5277778 0.264321 10.5305556 0.262648 10.5333333 0.261533 10.5361111 0.262648 10.5388889 0.262648 10.5416667 0.263763 10.5444444 0.262091 10.5472222 0.262091 10.5500000 0.261533 10.5527778 0.262091 10.5555556 0.263206 10.5583333 0.263206 10.5611111 0.263206 10.5638889 0.262648 10.5666667 0.260976 10.5694444 0.260976 10.5722222 0.260976 10.5750000 0.262648 10.5777778 0.260976 10.5805556 0.262091 10.5833333 0.260418 10.5861111 0.259861 10.5888889 0.262091 10.5916667 0.262648 10.5944444 0.261533 10.5972222 0.260976 10.6000000 0.259303 10.6027778 0.260418 10.6055556 0.260418 10.6083333 0.261533 10.6111111 0.260976 10.6138889 0.260976 10.6166667 0.260418 10.6194444 0.259861 10.6222222 0.262091 10.6250000 0.260976 10.6277778 0.262648 10.6305556 0.263763 10.6333333 0.261533 10.6361111 0.264321 10.6388889 0.265436 10.6416667 0.266551 10.6444444 0.269338 10.6472222 0.269338 10.6500000 0.268223 10.6527778 0.269338 10.6555556 0.270453 10.6583333 0.272125 10.6611111 0.271010 10.6638889 0.270453 10.6666667 0.270453 10.6694444 0.271010 10.6722222 0.272683 10.6750000 0.273798 10.6777778 0.274355 10.6805556 0.273798 10.6833333 0.272683 10.6861111 0.273240 10.6888889 0.273240 10.6916667 0.274355 10.6944444 0.272683 10.6972222 0.273240 10.7000000 0.272683 10.7027778 0.272125 10.7055556 0.273798 10.7083333 0.273798 10.7111111 0.273240 10.7138889 0.273240 10.7166667 0.271568 10.7194444 0.272683 10.7222222 0.273798 10.7250000 0.274913 10.7277778 0.273240 10.7305556 0.272683 10.7333333 0.272125 10.7361111 0.271010 10.7388889 0.272683 10.7416667 0.272683 10.7444444 0.272683 10.7472222 0.271568 10.7500000 0.271010 10.7527778 0.270453 10.7555556 0.272125 10.7583333 0.272683 10.7611111 0.272125 10.7638889 0.270453 10.7666667 0.269895 10.7694444 0.269895 10.7722222 0.270453 10.7750000 0.269895 10.7777778 0.271010 10.7805556 0.269338 10.7833333 0.267666 10.7861111 0.269338 10.7888889 0.269338 10.7916667 0.268780 10.7944444 0.268223 10.7972222 0.267108 10.8000000 0.265993 10.8027778 0.267108 10.8055556 0.267108 10.8083333 0.267666 10.8111111 0.268223 10.8138889 0.268223 10.8166667 0.266551 10.8194444 0.266551 10.8222222 0.267108 10.8250000 0.267666 10.8277778 0.267108 10.8305556 0.266551 10.8333333 0.265993 10.8361111 0.266551 10.8388889 0.267108 10.8416667 0.268780 10.8444444 0.268780 10.8472222 0.267666 10.8500000 0.266551 10.8527778 0.267108 10.8555556 0.269895 10.8583333 0.269338 10.8611111 0.267666 10.8638889 0.267108 10.8666667 0.266551 10.8694444 0.266551 10.8722222 0.266551 10.8750000 0.267666 10.8777778 0.267666 10.8805556 0.267108 10.8833333 0.267108 10.8861111 0.265993 10.8888889 0.267666 10.8916667 0.267666 10.8944444 0.268223 10.8972222 0.267666 10.9000000 0.266551 10.9027778 0.268223 10.9055556 0.268223 10.9083333 0.269895 10.9111111 0.268780 10.9138889 0.268780 10.9166667 0.267666 10.9194444 0.268780 10.9222222 0.269338 10.9250000 0.269895 10.9277778 0.272125 10.9305556 0.273240 10.9333333 0.274355 10.9361111 0.275470 10.9388889 0.274913 10.9416667 0.276585 10.9444444 0.276585 10.9472222 0.276028 10.9500000 0.276028 10.9527778 0.277700 10.9555556 0.279373 10.9583333 0.279373 10.9611111 0.279373 10.9638889 0.280488 10.9666667 0.279930 10.9694444 0.278815 10.9722222 0.279373 10.9750000 0.279373 10.9777778 0.279373 10.9805556 0.277700 10.9833333 0.274913 10.9861111 0.275470 10.9888889 0.276585 10.9916667 0.278258 10.9944444 0.277143 10.9972222 0.275470 11.0000000 0.274355 11.0027778 0.276585 11.0055556 0.279930 11.0083333 0.282160 11.0111111 0.278258 11.0138889 0.276028 11.0166667 0.272125 11.0194444 0.272125 11.0222222 0.270453 11.0250000 0.269895 11.0277778 0.267666 11.0305556 0.267108 11.0333333 0.266551 11.0361111 0.266551 11.0388889 0.265993 11.0416667 0.268223 11.0444444 0.267108 11.0472222 0.265993 11.0500000 0.264878 11.0527778 0.263763 11.0555556 0.267108 11.0583333 0.266551 11.0611111 0.264321 11.0638889 0.265436 11.0666667 0.262648 11.0694444 0.263206 11.0722222 0.263763 11.0750000 0.264878 11.0777778 0.264878 11.0805556 0.264321 11.0833333 0.262091 11.0861111 0.262648 11.0888889 0.264878 11.0916667 0.264878 11.0944444 0.263763 11.0972222 0.263763 11.1000000 0.260976 11.1027778 0.260418 11.1055556 0.258188 11.1083333 0.255401 11.1111111 0.252056 11.1138889 0.252056 11.1166667 0.248153 11.1194444 0.243136 11.1222222 0.239233 11.1250000 0.241463 11.1277778 0.249826 11.1305556 0.262648 11.1333333 0.275470 11.1361111 0.291638 11.1388889 0.316167 11.1416667 0.345714 11.1444444 0.376376 11.1472222 0.393101 11.1500000 0.400348 11.1527778 0.392544 11.1555556 0.365784 11.1583333 0.324530 11.1611111 0.282160 11.1638889 0.254843 11.1666667 0.247038 11.1694444 0.249826 11.1722222 0.256516 11.1750000 0.261533 11.1777778 0.261533 11.1805556 0.259861 11.1833333 0.259861 11.1861111 0.259303 11.1888889 0.260418 11.1916667 0.262091 11.1944444 0.262091 11.1972222 0.259861 11.2000000 0.258746 11.2027778 0.258188 11.2055556 0.260418 11.2083333 0.260976 11.2111111 0.259861 11.2138889 0.259861 11.2166667 0.260418 11.2194444 0.261533 11.2222222 0.260418 11.2250000 0.261533 11.2277778 0.260976 11.2305556 0.260418 11.2333333 0.260418 11.2361111 0.260418 11.2388889 0.260418 11.2416667 0.261533 11.2444444 0.262091 11.2472222 0.262091 11.2500000 0.259303 11.2527778 0.260976 11.2555556 0.261533 11.2583333 0.261533 11.2611111 0.260976 11.2638889 0.259861 11.2666667 0.259303 11.2694444 0.259861 11.2722222 0.260418 11.2750000 0.262648 11.2777778 0.261533 11.2805556 0.260976 11.2833333 0.259303 11.2861111 0.260976 11.2888889 0.260418 11.2916667 0.260976 11.2944444 0.261533 11.2972222 0.259861 11.3000000 0.258746 11.3027778 0.259861 11.3055556 0.259861 11.3083333 0.262091 11.3111111 0.261533 11.3138889 0.259861 11.3166667 0.259303 11.3194444 0.259861 11.3222222 0.262091 11.3250000 0.263206 11.3277778 0.262091 11.3305556 0.260976 11.3333333 0.260418 11.3361111 0.260976 11.3388889 0.260976 11.3416667 0.261533 11.3444444 0.262091 11.3472222 0.261533 11.3500000 0.260976 11.3527778 0.260976 11.3555556 0.263206 11.3583333 0.262091 11.3611111 0.261533 11.3638889 0.261533 11.3666667 0.259303 11.3694444 0.260976 11.3722222 0.260976 11.3750000 0.262648 11.3777778 0.261533 11.3805556 0.260976 11.3833333 0.259303 11.3861111 0.260976 11.3888889 0.262091 11.3916667 0.262648 11.3944444 0.261533 11.3972222 0.260976 11.4000000 0.258746 11.4027778 0.260418 11.4055556 0.260976 11.4083333 0.262648 11.4111111 0.261533 11.4138889 0.259861 11.4166667 0.259861 11.4194444 0.259861 11.4222222 0.260418 11.4250000 0.262091 11.4277778 0.261533 11.4305556 0.261533 11.4333333 0.258746 11.4361111 0.259861 11.4388889 0.260418 11.4416667 0.262648 11.4444444 0.262648 11.4472222 0.261533 11.4500000 0.260976 11.4527778 0.260418 11.4555556 0.262091 11.4583333 0.264321 11.4611111 0.263763 11.4638889 0.264878 11.4666667 0.264878 11.4694444 0.265436 11.4722222 0.267108 11.4750000 0.269895 11.4777778 0.270453 11.4805556 0.269338 11.4833333 0.269338 11.4861111 0.269895 11.4888889 0.269895 11.4916667 0.272125 11.4944444 0.271568 11.4972222 0.271568 11.5000000 0.270453 11.5027778 0.271010 11.5055556 0.272683 11.5083333 0.271568 11.5111111 0.272125 11.5138889 0.270453 11.5166667 0.270453 11.5194444 0.270453 11.5222222 0.272125 11.5250000 0.271010 11.5277778 0.271010 11.5305556 0.269338 11.5333333 0.268780 11.5361111 0.269338 11.5388889 0.268780 11.5416667 0.269895 11.5444444 0.270453 11.5472222 0.269895 11.5500000 0.266551 11.5527778 0.267666 11.5555556 0.269895 11.5583333 0.271010 11.5611111 0.271010 11.5638889 0.269895 11.5666667 0.268780 11.5694444 0.269338 11.5722222 0.270453 11.5750000 0.271010 11.5777778 0.268780 11.5805556 0.268223 11.5833333 0.266551 11.5861111 0.266551 11.5888889 0.267108 11.5916667 0.268780 11.5944444 0.268780 11.5972222 0.269338 11.6000000 0.267108 11.6027778 0.267108 11.6055556 0.267666 11.6083333 0.267108 11.6111111 0.267108 11.6138889 0.265993 11.6166667 0.263763 11.6194444 0.265993 11.6222222 0.265436 11.6250000 0.265436 11.6277778 0.266551 11.6305556 0.264878 11.6333333 0.264321 11.6361111 0.264878 11.6388889 0.264878 11.6416667 0.265993 11.6444444 0.265993 11.6472222 0.263763 11.6500000 0.262091 11.6527778 0.262648 11.6555556 0.264321 11.6583333 0.265993 11.6611111 0.264878 11.6638889 0.264878 11.6666667 0.263206 11.6694444 0.262091 11.6722222 0.263206 11.6750000 0.264321 11.6777778 0.264878 11.6805556 0.263763 11.6833333 0.262091 11.6861111 0.263206 11.6888889 0.263763 11.6916667 0.264878 11.6944444 0.264878 11.6972222 0.264878 11.7000000 0.263206 11.7027778 0.264321 11.7055556 0.263763 11.7083333 0.264878 11.7111111 0.264878 11.7138889 0.264321 11.7166667 0.261533 11.7194444 0.264321 11.7222222 0.263763 11.7250000 0.264878 11.7277778 0.264321 11.7305556 0.263763 11.7333333 0.262648 11.7361111 0.264321 11.7388889 0.265993 11.7416667 0.268223 11.7444444 0.269895 11.7472222 0.269895 11.7500000 0.269338 11.7527778 0.269895 11.7555556 0.270453 11.7583333 0.271010 11.7611111 0.272125 11.7638889 0.272125 11.7666667 0.272125 11.7694444 0.273798 11.7722222 0.275470 11.7750000 0.275470 11.7777778 0.276585 11.7805556 0.275470 11.7833333 0.273240 11.7861111 0.272683 11.7888889 0.272125 11.7916667 0.273240 11.7944444 0.273240 11.7972222 0.271010 11.8000000 0.271010 11.8027778 0.269338 11.8055556 0.270453 11.8083333 0.273798 11.8111111 0.274913 11.8138889 0.274913 11.8166667 0.271010 11.8194444 0.268223 11.8222222 0.268223 11.8250000 0.269338 11.8277778 0.267666 11.8305556 0.265436 11.8333333 0.262648 11.8361111 0.262648 11.8388889 0.263206 11.8416667 0.262648 11.8444444 0.262091 11.8472222 0.260418 11.8500000 0.258746 11.8527778 0.259303 11.8555556 0.260418 11.8583333 0.260418 11.8611111 0.261533 11.8638889 0.260418 11.8666667 0.258188 11.8694444 0.258188 11.8722222 0.259303 11.8750000 0.259303 11.8777778 0.258746 11.8805556 0.257631 11.8833333 0.256516 11.8861111 0.257631 11.8888889 0.258746 11.8916667 0.260418 11.8944444 0.259861 11.8972222 0.260418 11.9000000 0.259303 11.9027778 0.258746 11.9055556 0.259303 11.9083333 0.259303 11.9111111 0.257631 11.9138889 0.254286 11.9166667 0.249826 11.9194444 0.247038 11.9222222 0.245923 11.9250000 0.243693 11.9277778 0.238118 11.9305556 0.234216 11.9333333 0.238118 11.9361111 0.250383 11.9388889 0.265436 11.9416667 0.283275 11.9444444 0.304460 11.9472222 0.333449 11.9500000 0.361882 11.9527778 0.381394 11.9555556 0.389756 11.9583333 0.378049 11.9611111 0.347944 11.9638889 0.306690 11.9666667 0.272683 11.9694444 0.253171 11.9722222 0.245366 11.9750000 0.245923 11.9777778 0.249268 11.9805556 0.252613 11.9833333 0.253171 11.9861111 0.253171 11.9888889 0.253171 11.9916667 0.255401 11.9944444 0.255401 11.9972222 0.253728 12.0000000 0.253728 12.0027778 0.254843 12.0055556 0.254286 12.0083333 0.257073 12.0111111 0.254843 12.0138889 0.254286 12.0166667 0.252613 12.0194444 0.253728 12.0222222 0.254286 12.0250000 0.253728 12.0277778 0.253171 12.0305556 0.251498 12.0333333 0.252613 12.0361111 0.254286 12.0388889 0.256516 12.0416667 0.256516 12.0444444 0.255401 12.0472222 0.253728 12.0500000 0.254286 12.0527778 0.256516 12.0555556 0.255401 12.0583333 0.255401 12.0611111 0.254286 12.0638889 0.253728 12.0666667 0.253171 12.0694444 0.253728 12.0722222 0.254843 12.0750000 0.255401 12.0777778 0.254843 12.0805556 0.253171 12.0833333 0.252056 12.0861111 0.253728 12.0888889 0.254843 12.0916667 0.256516 12.0944444 0.255958 12.0972222 0.254843 12.1000000 0.254843 12.1027778 0.254286 12.1055556 0.254843 12.1083333 0.255401 12.1111111 0.255401 12.1138889 0.253171 12.1166667 0.252056 12.1194444 0.252613 12.1222222 0.252613 12.1250000 0.253728 12.1277778 0.254843 12.1305556 0.253728 12.1333333 0.253728 12.1361111 0.252613 12.1388889 0.253171 12.1416667 0.253728 12.1444444 0.254286 12.1472222 0.253728 12.1500000 0.253171 12.1527778 0.253728 12.1555556 0.254843 12.1583333 0.255401 12.1611111 0.255958 12.1638889 0.256516 12.1666667 0.253171 12.1694444 0.254843 12.1722222 0.256516 12.1750000 0.254843 12.1777778 0.254843 12.1805556 0.253728 12.1833333 0.252056 12.1861111 0.253171 12.1888889 0.252056 12.1916667 0.252613 12.1944444 0.253171 12.1972222 0.252056 12.2000000 0.250941 12.2027778 0.250383 12.2055556 0.250383 12.2083333 0.252056 12.2111111 0.252613 12.2138889 0.250383 12.2166667 0.249268 12.2194444 0.250383 12.2222222 0.249826 12.2250000 0.252056 12.2277778 0.252056 12.2305556 0.252056 12.2333333 0.251498 12.2361111 0.252056 12.2388889 0.252613 12.2416667 0.253171 12.2444444 0.251498 12.2472222 0.252056 12.2500000 0.253171 12.2527778 0.255401 12.2555556 0.257073 12.2583333 0.258746 12.2611111 0.260418 12.2638889 0.261533 12.2666667 0.261533 12.2694444 0.261533 12.2722222 0.261533 12.2750000 0.263763 12.2777778 0.264321 12.2805556 0.263763 12.2833333 0.263763 12.2861111 0.263763 12.2888889 0.263206 12.2916667 0.264321 12.2944444 0.265436 12.2972222 0.264321 12.3000000 0.263763 12.3027778 0.264321 12.3055556 0.265436 12.3083333 0.265993 12.3111111 0.266551 12.3138889 0.266551 12.3166667 0.265993 12.3194444 0.266551 12.3222222 0.267666 12.3250000 0.266551 12.3277778 0.265436 12.3305556 0.264878 12.3333333 0.264321 12.3361111 0.263206 12.3388889 0.264321 12.3416667 0.264321 12.3444444 0.263763 12.3472222 0.264878 12.3500000 0.262648 12.3527778 0.263206 12.3555556 0.264878 12.3583333 0.264878 12.3611111 0.263206 12.3638889 0.263763 12.3666667 0.262648 12.3694444 0.262648 12.3722222 0.263206 12.3750000 0.263763 12.3777778 0.263763 12.3805556 0.262648 12.3833333 0.259861 12.3861111 0.260418 12.3888889 0.261533 12.3916667 0.260976 12.3944444 0.262091 12.3972222 0.261533 12.4000000 0.260418 12.4027778 0.260976 12.4055556 0.261533 12.4083333 0.260976 12.4111111 0.261533 12.4138889 0.259303 12.4166667 0.258746 12.4194444 0.258746 12.4222222 0.260418 12.4250000 0.261533 12.4277778 0.261533 12.4305556 0.260976 12.4333333 0.257073 12.4361111 0.258746 12.4388889 0.259861 12.4416667 0.260976 12.4444444 0.260418 12.4472222 0.258746 12.4500000 0.258746 12.4527778 0.259303 12.4555556 0.258188 12.4583333 0.260418 12.4611111 0.260418 12.4638889 0.259303 12.4666667 0.257631 12.4694444 0.259861 12.4722222 0.260418 12.4750000 0.259861 12.4777778 0.259861 12.4805556 0.257631 12.4833333 0.258746 12.4861111 0.260418 12.4888889 0.260976 12.4916667 0.260418 12.4944444 0.260976 12.4972222 0.260418 12.5000000 0.257631 12.5027778 0.257631 12.5055556 0.260418 12.5083333 0.262648 12.5111111 0.262648 12.5138889 0.261533 12.5166667 0.260418 12.5194444 0.260976 12.5222222 0.263206 12.5250000 0.264878 12.5277778 0.266551 12.5305556 0.265993 12.5333333 0.265993 12.5361111 0.265436 12.5388889 0.266551 12.5416667 0.268780 12.5444444 0.269338 12.5472222 0.269338 12.5500000 0.270453 12.5527778 0.270453 12.5555556 0.271568 12.5583333 0.272125 12.5611111 0.271568 12.5638889 0.269895 12.5666667 0.267108 12.5694444 0.267108 12.5722222 0.269338 12.5750000 0.271010 12.5777778 0.270453 12.5805556 0.268223 12.5833333 0.267108 12.5861111 0.266551 12.5888889 0.270453 12.5916667 0.273240 12.5944444 0.273240 12.5972222 0.269895 12.6000000 0.265436 12.6027778 0.264321 12.6055556 0.263206 12.6083333 0.262648 12.6111111 0.260976 12.6138889 0.258746 12.6166667 0.257073 12.6194444 0.255958 12.6222222 0.258188 12.6250000 0.258746 12.6277778 0.258188 12.6305556 0.257631 12.6333333 0.256516 12.6361111 0.257073 12.6388889 0.256516 12.6416667 0.258188 12.6444444 0.258746 12.6472222 0.258188 12.6500000 0.256516 12.6527778 0.257073 12.6555556 0.257631 12.6583333 0.258746 12.6611111 0.258746 12.6638889 0.257631 12.6666667 0.255958 12.6694444 0.256516 12.6722222 0.257073 12.6750000 0.257073 12.6777778 0.258188 12.6805556 0.257073 12.6833333 0.255958 12.6861111 0.254843 12.6888889 0.253728 12.6916667 0.250383 12.6944444 0.246481 12.6972222 0.243693 12.7000000 0.239791 12.7027778 0.234216 12.7055556 0.236446 12.7083333 0.245366 12.7111111 0.260976 12.7138889 0.276585 12.7166667 0.293868 12.7194444 0.321185 12.7222222 0.353519 12.7250000 0.379721 12.7277778 0.394216 12.7305556 0.392544 12.7333333 0.366341 12.7361111 0.318955 12.7388889 0.277700 12.7416667 0.254286 12.7444444 0.245923 12.7472222 0.244251 12.7500000 0.248711 12.7527778 0.252613 12.7555556 0.254286 12.7583333 0.255401 12.7611111 0.255958 12.7638889 0.254843 12.7666667 0.254286 12.7694444 0.254843 12.7722222 0.255958 12.7750000 0.255958 12.7777778 0.255401 12.7805556 0.255958 12.7833333 0.254286 12.7861111 0.255958 12.7888889 0.256516 12.7916667 0.256516 12.7944444 0.256516 12.7972222 0.255958 12.8000000 0.254843 12.8027778 0.254843 12.8055556 0.256516 12.8083333 0.257073 12.8111111 0.256516 12.8138889 0.255958 12.8166667 0.254843 12.8194444 0.255958 12.8222222 0.256516 12.8250000 0.256516 12.8277778 0.255958 12.8305556 0.256516 12.8333333 0.255401 12.8361111 0.256516 12.8388889 0.256516 12.8416667 0.258188 12.8444444 0.258188 12.8472222 0.257073 12.8500000 0.257073 12.8527778 0.257073 12.8555556 0.257073 12.8583333 0.258746 12.8611111 0.258746 12.8638889 0.258188 12.8666667 0.257631 12.8694444 0.257073 12.8722222 0.257631 12.8750000 0.258746 12.8777778 0.256516 12.8805556 0.257631 12.8833333 0.255401 12.8861111 0.256516 12.8888889 0.257631 12.8916667 0.258746 12.8944444 0.257631 12.8972222 0.256516 12.9000000 0.256516 12.9027778 0.257631 12.9055556 0.257631 12.9083333 0.258746 12.9111111 0.258188 12.9138889 0.258746 12.9166667 0.257631 12.9194444 0.257073 12.9222222 0.257631 12.9250000 0.258746 12.9277778 0.259303 12.9305556 0.258188 12.9333333 0.256516 12.9361111 0.255958 12.9388889 0.257631 12.9416667 0.257631 12.9444444 0.257073 12.9472222 0.255958 12.9500000 0.253171 12.9527778 0.255401 12.9555556 0.255401)
Vecg1 ecg_l1 0 PWL(0.0000000 0.300000 0.2888889 0.259303 0.2916667 0.259303 0.2944444 0.258746 0.2972222 0.260976 0.3000000 0.262091 0.3027778 0.263763 0.3055556 0.264878 0.3083333 0.266551 0.3111111 0.266551 0.3138889 0.267108 0.3166667 0.268780 0.3194444 0.270453 0.3222222 0.271010 0.3250000 0.270453 0.3277778 0.269895 0.3305556 0.269338 0.3333333 0.271568 0.3361111 0.273798 0.3388889 0.274355 0.3416667 0.273798 0.3444444 0.274355 0.3472222 0.272125 0.3500000 0.272683 0.3527778 0.274355 0.3555556 0.273798 0.3583333 0.275470 0.3611111 0.274355 0.3638889 0.273798 0.3666667 0.274355 0.3694444 0.275470 0.3722222 0.274355 0.3750000 0.274913 0.3777778 0.273240 0.3805556 0.272125 0.3833333 0.273240 0.3861111 0.274355 0.3888889 0.276028 0.3916667 0.277143 0.3944444 0.272683 0.3972222 0.273240 0.4000000 0.273240 0.4027778 0.274913 0.4055556 0.274355 0.4083333 0.275470 0.4111111 0.274355 0.4138889 0.272683 0.4166667 0.273798 0.4194444 0.273240 0.4222222 0.274355 0.4250000 0.273240 0.4277778 0.272683 0.4305556 0.271568 0.4333333 0.273798 0.4361111 0.275470 0.4388889 0.275470 0.4416667 0.273240 0.4444444 0.273240 0.4472222 0.271568 0.4500000 0.272125 0.4527778 0.273798 0.4555556 0.274913 0.4583333 0.273240 0.4611111 0.272125 0.4638889 0.272125 0.4666667 0.272125 0.4694444 0.272125 0.4722222 0.273240 0.4750000 0.274913 0.4777778 0.273798 0.4805556 0.272125 0.4833333 0.272125 0.4861111 0.273240 0.4888889 0.273798 0.4916667 0.272683 0.4944444 0.272683 0.4972222 0.272125 0.5000000 0.274355 0.5027778 0.274355 0.5055556 0.274913 0.5083333 0.273240 0.5111111 0.273240 0.5138889 0.273240 0.5166667 0.274355 0.5194444 0.274355 0.5222222 0.274355 0.5250000 0.275470 0.5277778 0.273798 0.5305556 0.273240 0.5333333 0.273240 0.5361111 0.276028 0.5388889 0.275470 0.5416667 0.274913 0.5444444 0.273240 0.5472222 0.274355 0.5500000 0.275470 0.5527778 0.276585 0.5555556 0.274913 0.5583333 0.276585 0.5611111 0.274913 0.5638889 0.273798 0.5666667 0.276028 0.5694444 0.275470 0.5722222 0.276585 0.5750000 0.275470 0.5777778 0.275470 0.5805556 0.276028 0.5833333 0.274355 0.5861111 0.275470 0.5888889 0.275470 0.5916667 0.276585 0.5944444 0.275470 0.5972222 0.274355 0.6000000 0.276028 0.6027778 0.277700 0.6055556 0.277143 0.6083333 0.278258 0.6111111 0.277143 0.6138889 0.277700 0.6166667 0.279373 0.6194444 0.281045 0.6222222 0.280488 0.6250000 0.281045 0.6277778 0.278815 0.6305556 0.280488 0.6333333 0.282718 0.6361111 0.283833 0.6388889 0.283833 0.6416667 0.282718 0.6444444 0.281603 0.6472222 0.281603 0.6500000 0.282160 0.6527778 0.283275 0.6555556 0.281603 0.6583333 0.281603 0.6611111 0.281603 0.6638889 0.279373 0.6666667 0.279930 0.6694444 0.280488 0.6722222 0.279373 0.6750000 0.279373 0.6777778 0.278815 0.6805556 0.279373 0.6833333 0.279373 0.6861111 0.280488 0.6888889 0.279930 0.6916667 0.279930 0.6944444 0.278815 0.6972222 0.278258 0.7000000 0.278815 0.7027778 0.279930 0.7055556 0.278815 0.7083333 0.279930 0.7111111 0.278258 0.7138889 0.276585 0.7166667 0.278258 0.7194444 0.279930 0.7222222 0.280488 0.7250000 0.279930 0.7277778 0.279373 0.7305556 0.277143 0.7333333 0.279373 0.7361111 0.278258 0.7388889 0.277143 0.7416667 0.274355 0.7444444 0.271010 0.7472222 0.268780 0.7500000 0.266551 0.7527778 0.263763 0.7555556 0.262091 0.7583333 0.267108 0.7611111 0.273798 0.7638889 0.284390 0.7666667 0.297213 0.7694444 0.306132 0.7722222 0.313937 0.7750000 0.320627 0.7777778 0.330662 0.7805556 0.342369 0.7833333 0.355749 0.7861111 0.364669 0.7888889 0.354077 0.7916667 0.321742 0.7944444 0.283275 0.7972222 0.265436 0.8000000 0.268780 0.8027778 0.276028 0.8055556 0.277143 0.8083333 0.277700 0.8111111 0.278258 0.8138889 0.277700 0.8166667 0.277143 0.8194444 0.278258 0.8222222 0.277700 0.8250000 0.277143 0.8277778 0.275470 0.8305556 0.276028 0.8333333 0.277700 0.8361111 0.278815 0.8388889 0.277700 0.8416667 0.277700 0.8444444 0.276028 0.8472222 0.276585 0.8500000 0.276585 0.8527778 0.278815 0.8555556 0.279373 0.8583333 0.279373 0.8611111 0.277700 0.8638889 0.276585 0.8666667 0.277143 0.8694444 0.278815 0.8722222 0.279373 0.8750000 0.279930 0.8777778 0.278258 0.8805556 0.277700 0.8833333 0.278815 0.8861111 0.278815 0.8888889 0.278815 0.8916667 0.279930 0.8944444 0.278258 0.8972222 0.278258 0.9000000 0.279373 0.9027778 0.279930 0.9055556 0.279373 0.9083333 0.278815 0.9111111 0.278258 0.9138889 0.277143 0.9166667 0.279373 0.9194444 0.278815 0.9222222 0.279373 0.9250000 0.279930 0.9277778 0.279373 0.9305556 0.276585 0.9333333 0.278258 0.9361111 0.277700 0.9388889 0.278815 0.9416667 0.278815 0.9444444 0.277700 0.9472222 0.276585 0.9500000 0.278258 0.9527778 0.278815 0.9555556 0.277143 0.9583333 0.277143 0.9611111 0.276028 0.9638889 0.274913 0.9666667 0.276585 0.9694444 0.276585 0.9722222 0.276585 0.9750000 0.275470 0.9777778 0.273798 0.9805556 0.273240 0.9833333 0.273240 0.9861111 0.274355 0.9888889 0.273240 0.9916667 0.273240 0.9944444 0.270453 0.9972222 0.268780 1.0000000 0.268780 1.0027778 0.269338 1.0055556 0.269338 1.0083333 0.268780 1.0111111 0.267666 1.0138889 0.267666 1.0166667 0.265436 1.0194444 0.265436 1.0222222 0.265993 1.0250000 0.264321 1.0277778 0.263206 1.0305556 0.263206 1.0333333 0.263763 1.0361111 0.263763 1.0388889 0.265436 1.0416667 0.264878 1.0444444 0.264321 1.0472222 0.264878 1.0500000 0.266551 1.0527778 0.269338 1.0555556 0.270453 1.0583333 0.271568 1.0611111 0.271568 1.0638889 0.272683 1.0666667 0.274913 1.0694444 0.276585 1.0722222 0.278815 1.0750000 0.279930 1.0777778 0.279373 1.0805556 0.279373 1.0833333 0.281045 1.0861111 0.282160 1.0888889 0.284948 1.0916667 0.285505 1.0944444 0.283275 1.0972222 0.283275 1.1000000 0.284390 1.1027778 0.286063 1.1055556 0.284390 1.1083333 0.284948 1.1111111 0.284948 1.1138889 0.284948 1.1166667 0.285505 1.1194444 0.286063 1.1222222 0.286620 1.1250000 0.285505 1.1277778 0.283833 1.1305556 0.284948 1.1333333 0.284390 1.1361111 0.286620 1.1388889 0.284948 1.1416667 0.285505 1.1444444 0.284390 1.1472222 0.284390 1.1500000 0.283833 1.1527778 0.286063 1.1555556 0.286063 1.1583333 0.285505 1.1611111 0.283275 1.1638889 0.283275 1.1666667 0.284390 1.1694444 0.284948 1.1722222 0.284948 1.1750000 0.283275 1.1777778 0.282718 1.1805556 0.281603 1.1833333 0.283833 1.1861111 0.283275 1.1888889 0.283833 1.1916667 0.283275 1.1944444 0.282718 1.1972222 0.281603 1.2000000 0.281603 1.2027778 0.282160 1.2055556 0.283275 1.2083333 0.282718 1.2111111 0.282160 1.2138889 0.279930 1.2166667 0.281045 1.2194444 0.281603 1.2222222 0.281045 1.2250000 0.281603 1.2277778 0.281045 1.2305556 0.280488 1.2333333 0.280488 1.2361111 0.282160 1.2388889 0.282718 1.2416667 0.281045 1.2444444 0.280488 1.2472222 0.279930 1.2500000 0.281045 1.2527778 0.283275 1.2555556 0.282160 1.2583333 0.282718 1.2611111 0.280488 1.2638889 0.279373 1.2666667 0.281045 1.2694444 0.281603 1.2722222 0.283275 1.2750000 0.281603 1.2777778 0.281603 1.2805556 0.280488 1.2833333 0.282160 1.2861111 0.281045 1.2888889 0.282160 1.2916667 0.282160 1.2944444 0.281045 1.2972222 0.279930 1.3000000 0.281603 1.3027778 0.282160 1.3055556 0.283275 1.3083333 0.282160 1.3111111 0.280488 1.3138889 0.281045 1.3166667 0.282160 1.3194444 0.283833 1.3222222 0.283275 1.3250000 0.282718 1.3277778 0.281045 1.3305556 0.281045 1.3333333 0.282160 1.3361111 0.282718 1.3388889 0.283833 1.3416667 0.282160 1.3444444 0.282718 1.3472222 0.282160 1.3500000 0.282160 1.3527778 0.283833 1.3555556 0.282718 1.3583333 0.283275 1.3611111 0.281045 1.3638889 0.281603 1.3666667 0.282718 1.3694444 0.285505 1.3722222 0.286063 1.3750000 0.285505 1.3777778 0.286063 1.3805556 0.284948 1.3833333 0.286063 1.3861111 0.287735 1.3888889 0.285505 1.3916667 0.287735 1.3944444 0.287178 1.3972222 0.286063 1.4000000 0.287735 1.4027778 0.289965 1.4055556 0.289965 1.4083333 0.288293 1.4111111 0.288850 1.4138889 0.287735 1.4166667 0.288293 1.4194444 0.289965 1.4222222 0.290523 1.4250000 0.289408 1.4277778 0.286063 1.4305556 0.284390 1.4333333 0.285505 1.4361111 0.286620 1.4388889 0.286063 1.4416667 0.286063 1.4444444 0.284390 1.4472222 0.282160 1.4500000 0.282718 1.4527778 0.283833 1.4555556 0.285505 1.4583333 0.284948 1.4611111 0.283833 1.4638889 0.282718 1.4666667 0.283275 1.4694444 0.281603 1.4722222 0.283833 1.4750000 0.283275 1.4777778 0.282718 1.4805556 0.281603 1.4833333 0.282160 1.4861111 0.284390 1.4888889 0.283275 1.4916667 0.282160 1.4944444 0.281045 1.4972222 0.280488 1.5000000 0.282160 1.5027778 0.283275 1.5055556 0.283833 1.5083333 0.283833 1.5111111 0.282718 1.5138889 0.280488 1.5166667 0.278258 1.5194444 0.277143 1.5222222 0.276028 1.5250000 0.272683 1.5277778 0.269338 1.5305556 0.268223 1.5333333 0.265993 1.5361111 0.265993 1.5388889 0.268780 1.5416667 0.279930 1.5444444 0.293310 1.5472222 0.307247 1.5500000 0.320070 1.5527778 0.332892 1.5555556 0.346829 1.5583333 0.362439 1.5611111 0.375819 1.5638889 0.380279 1.5666667 0.367456 1.5694444 0.333449 1.5722222 0.293868 1.5750000 0.274913 1.5777778 0.276028 1.5805556 0.279373 1.5833333 0.278815 1.5861111 0.278815 1.5888889 0.280488 1.5916667 0.278815 1.5944444 0.277700 1.5972222 0.276585 1.6000000 0.276585 1.6027778 0.278258 1.6055556 0.278258 1.6083333 0.276028 1.6111111 0.274913 1.6138889 0.276028 1.6166667 0.276028 1.6194444 0.277143 1.6222222 0.278258 1.6250000 0.278258 1.6277778 0.276585 1.6305556 0.274355 1.6333333 0.275470 1.6361111 0.277700 1.6388889 0.277700 1.6416667 0.277700 1.6444444 0.276585 1.6472222 0.275470 1.6500000 0.274913 1.6527778 0.277700 1.6555556 0.276028 1.6583333 0.277143 1.6611111 0.275470 1.6638889 0.276585 1.6666667 0.276585 1.6694444 0.277143 1.6722222 0.277700 1.6750000 0.276585 1.6777778 0.275470 1.6805556 0.274913 1.6833333 0.276585 1.6861111 0.278258 1.6888889 0.278258 1.6916667 0.276028 1.6944444 0.275470 1.6972222 0.275470 1.7000000 0.274913 1.7027778 0.278258 1.7055556 0.277143 1.7083333 0.276585 1.7111111 0.275470 1.7138889 0.273240 1.7166667 0.274913 1.7194444 0.275470 1.7222222 0.276585 1.7250000 0.274913 1.7277778 0.274355 1.7305556 0.273240 1.7333333 0.273798 1.7361111 0.274913 1.7388889 0.274355 1.7416667 0.274355 1.7444444 0.272125 1.7472222 0.271568 1.7500000 0.271568 1.7527778 0.273798 1.7555556 0.273798 1.7583333 0.272125 1.7611111 0.269338 1.7638889 0.268223 1.7666667 0.268780 1.7694444 0.269895 1.7722222 0.269895 1.7750000 0.269338 1.7777778 0.267108 1.7805556 0.264878 1.7833333 0.264878 1.7861111 0.264878 1.7888889 0.264878 1.7916667 0.264321 1.7944444 0.262648 1.7972222 0.261533 1.8000000 0.263206 1.8027778 0.262091 1.8055556 0.262091 1.8083333 0.262091 1.8111111 0.262091 1.8138889 0.260418 1.8166667 0.261533 1.8194444 0.263206 1.8222222 0.263763 1.8250000 0.264878 1.8277778 0.265436 1.8305556 0.265436 1.8333333 0.268780 1.8361111 0.272125 1.8388889 0.273798 1.8416667 0.274355 1.8444444 0.273798 1.8472222 0.274913 1.8500000 0.276028 1.8527778 0.278258 1.8555556 0.279373 1.8583333 0.281045 1.8611111 0.279930 1.8638889 0.281045 1.8666667 0.280488 1.8694444 0.282718 1.8722222 0.282718 1.8750000 0.283275 1.8777778 0.282160 1.8805556 0.281603 1.8833333 0.283833 1.8861111 0.283833 1.8888889 0.284948 1.8916667 0.283833 1.8944444 0.283275 1.8972222 0.281603 1.9000000 0.281603 1.9027778 0.284390 1.9055556 0.283275 1.9083333 0.284390 1.9111111 0.283833 1.9138889 0.282718 1.9166667 0.283833 1.9194444 0.283833 1.9222222 0.283275 1.9250000 0.281603 1.9277778 0.282718 1.9305556 0.281045 1.9333333 0.282160 1.9361111 0.283833 1.9388889 0.283275 1.9416667 0.281045 1.9444444 0.281045 1.9472222 0.281045 1.9500000 0.281045 1.9527778 0.282160 1.9555556 0.283275 1.9583333 0.281045 1.9611111 0.281045 1.9638889 0.279930 1.9666667 0.281045 1.9694444 0.282718 1.9722222 0.281603 1.9750000 0.281603 1.9777778 0.280488 1.9805556 0.279373 1.9833333 0.279930 1.9861111 0.280488 1.9888889 0.280488 1.9916667 0.280488 1.9944444 0.279930 1.9972222 0.279373 2.0000000 0.279930 2.0027778 0.281045 2.0055556 0.280488 2.0083333 0.281045 2.0111111 0.279373 2.0138889 0.278815 2.0166667 0.278815 2.0194444 0.280488 2.0222222 0.281603 2.0250000 0.279373 2.0277778 0.278815 2.0305556 0.278258 2.0333333 0.281045 2.0361111 0.279930 2.0388889 0.281045 2.0416667 0.281045 2.0444444 0.279373 2.0472222 0.278258 2.0500000 0.279373 2.0527778 0.279373 2.0555556 0.280488 2.0583333 0.281045 2.0611111 0.281045 2.0638889 0.277700 2.0666667 0.280488 2.0694444 0.281603 2.0722222 0.280488 2.0750000 0.281603 2.0777778 0.281045 2.0805556 0.279373 2.0833333 0.280488 2.0861111 0.281045 2.0888889 0.281603 2.0916667 0.280488 2.0944444 0.280488 2.0972222 0.278815 2.1000000 0.281045 2.1027778 0.282160 2.1055556 0.281603 2.1083333 0.282160 2.1111111 0.281045 2.1138889 0.279373 2.1166667 0.279930 2.1194444 0.281045 2.1222222 0.282160 2.1250000 0.281603 2.1277778 0.281045 2.1305556 0.282160 2.1333333 0.281045 2.1361111 0.283833 2.1388889 0.283275 2.1416667 0.283275 2.1444444 0.284948 2.1472222 0.283275 2.1500000 0.285505 2.1527778 0.284948 2.1555556 0.286620 2.1583333 0.286620 2.1611111 0.286620 2.1638889 0.285505 2.1666667 0.286063 2.1694444 0.286063 2.1722222 0.287735 2.1750000 0.288293 2.1777778 0.288293 2.1805556 0.286620 2.1833333 0.288293 2.1861111 0.288850 2.1888889 0.287735 2.1916667 0.287735 2.1944444 0.286063 2.1972222 0.283833 2.2000000 0.284948 2.2027778 0.284948 2.2055556 0.286063 2.2083333 0.284390 2.2111111 0.282160 2.2138889 0.281603 2.2166667 0.281603 2.2194444 0.282718 2.2222222 0.284390 2.2250000 0.284390 2.2277778 0.282160 2.2305556 0.281045 2.2333333 0.280488 2.2361111 0.282718 2.2388889 0.282718 2.2416667 0.282160 2.2444444 0.281603 2.2472222 0.281045 2.2500000 0.281603 2.2527778 0.282718 2.2555556 0.282160 2.2583333 0.282160 2.2611111 0.280488 2.2638889 0.279373 2.2666667 0.279930 2.2694444 0.281603 2.2722222 0.282718 2.2750000 0.280488 2.2777778 0.279373 2.2805556 0.278258 2.2833333 0.277700 2.2861111 0.276028 2.2888889 0.274355 2.2916667 0.270453 2.2944444 0.267666 2.2972222 0.262648 2.3000000 0.264878 2.3027778 0.273798 2.3055556 0.289408 2.3083333 0.303345 2.3111111 0.311150 2.3138889 0.321742 2.3166667 0.334564 2.3194444 0.347387 2.3222222 0.361324 2.3250000 0.369686 2.3277778 0.366899 2.3305556 0.339582 2.3333333 0.301115 2.3361111 0.274913 2.3388889 0.271568 2.3416667 0.275470 2.3444444 0.276585 2.3472222 0.276028 2.3500000 0.277143 2.3527778 0.279373 2.3555556 0.279373 2.3583333 0.279930 2.3611111 0.276585 2.3638889 0.276585 2.3666667 0.276028 2.3694444 0.277700 2.3722222 0.278258 2.3750000 0.277700 2.3777778 0.276585 2.3805556 0.276028 2.3833333 0.276028 2.3861111 0.277143 2.3888889 0.278258 2.3916667 0.276585 2.3944444 0.276585 2.3972222 0.274913 2.4000000 0.274913 2.4027778 0.277700 2.4055556 0.277700 2.4083333 0.277700 2.4111111 0.277143 2.4138889 0.276028 2.4166667 0.276585 2.4194444 0.277143 2.4222222 0.276585 2.4250000 0.276585 2.4277778 0.277700 2.4305556 0.276028 2.4333333 0.276585 2.4361111 0.278815 2.4388889 0.279373 2.4416667 0.277143 2.4444444 0.275470 2.4472222 0.275470 2.4500000 0.276585 2.4527778 0.276585 2.4555556 0.277143 2.4583333 0.277143 2.4611111 0.276028 2.4638889 0.274355 2.4666667 0.274913 2.4694444 0.276585 2.4722222 0.277143 2.4750000 0.276585 2.4777778 0.275470 2.4805556 0.274913 2.4833333 0.276028 2.4861111 0.275470 2.4888889 0.277700 2.4916667 0.277143 2.4944444 0.276028 2.4972222 0.273240 2.5000000 0.274913 2.5027778 0.276028 2.5055556 0.274355 2.5083333 0.274355 2.5111111 0.273240 2.5138889 0.272125 2.5166667 0.271010 2.5194444 0.272125 2.5222222 0.271568 2.5250000 0.269895 2.5277778 0.267666 2.5305556 0.267666 2.5333333 0.267666 2.5361111 0.268780 2.5388889 0.270453 2.5416667 0.269338 2.5444444 0.268780 2.5472222 0.266551 2.5500000 0.265436 2.5527778 0.267108 2.5555556 0.265993 2.5583333 0.265436 2.5611111 0.264321 2.5638889 0.263206 2.5666667 0.263763 2.5694444 0.264878 2.5722222 0.262648 2.5750000 0.262091 2.5777778 0.259861 2.5805556 0.259861 2.5833333 0.260418 2.5861111 0.260976 2.5888889 0.262091 2.5916667 0.262648 2.5944444 0.260418 2.5972222 0.259303 2.6000000 0.261533 2.6027778 0.262091 2.6055556 0.264878 2.6083333 0.264878 2.6111111 0.265436 2.6138889 0.265993 2.6166667 0.266551 2.6194444 0.269338 2.6222222 0.270453 2.6250000 0.271010 2.6277778 0.272125 2.6305556 0.272683 2.6333333 0.274355 2.6361111 0.275470 2.6388889 0.277143 2.6416667 0.277143 2.6444444 0.277700 2.6472222 0.277700 2.6500000 0.277143 2.6527778 0.278815 2.6555556 0.279373 2.6583333 0.278815 2.6611111 0.278258 2.6638889 0.277143 2.6666667 0.278258 2.6694444 0.278258 2.6722222 0.279373 2.6750000 0.278815 2.6777778 0.278258 2.6805556 0.276585 2.6833333 0.277143 2.6861111 0.278258 2.6888889 0.278258 2.6916667 0.277143 2.6944444 0.277143 2.6972222 0.275470 2.7000000 0.275470 2.7027778 0.277143 2.7055556 0.279373 2.7083333 0.276585 2.7111111 0.276028 2.7138889 0.274913 2.7166667 0.276028 2.7194444 0.278258 2.7222222 0.277143 2.7250000 0.278815 2.7277778 0.277700 2.7305556 0.274355 2.7333333 0.274913 2.7361111 0.277700 2.7388889 0.276585 2.7416667 0.276585 2.7444444 0.276028 2.7472222 0.275470 2.7500000 0.276028 2.7527778 0.276028 2.7555556 0.275470 2.7583333 0.276585 2.7611111 0.273798 2.7638889 0.274913 2.7666667 0.274913 2.7694444 0.276028 2.7722222 0.275470 2.7750000 0.275470 2.7777778 0.275470 2.7805556 0.273240 2.7833333 0.273240 2.7861111 0.274355 2.7888889 0.274913 2.7916667 0.274913 2.7944444 0.273798 2.7972222 0.270453 2.8000000 0.273240 2.8027778 0.274913 2.8055556 0.275470 2.8083333 0.275470 2.8111111 0.274355 2.8138889 0.273240 2.8166667 0.273240 2.8194444 0.274913 2.8222222 0.274913 2.8250000 0.274913 2.8277778 0.273798 2.8305556 0.272683 2.8333333 0.273240 2.8361111 0.274913 2.8388889 0.274913 2.8416667 0.276028 2.8444444 0.274355 2.8472222 0.274355 2.8500000 0.273798 2.8527778 0.274913 2.8555556 0.275470 2.8583333 0.275470 2.8611111 0.274355 2.8638889 0.273798 2.8666667 0.273798 2.8694444 0.276028 2.8722222 0.275470 2.8750000 0.274913 2.8777778 0.273798 2.8805556 0.273240 2.8833333 0.274913 2.8861111 0.276028 2.8888889 0.277143 2.8916667 0.276585 2.8944444 0.275470 2.8972222 0.273240 2.9000000 0.273798 2.9027778 0.275470 2.9055556 0.276028 2.9083333 0.274913 2.9111111 0.274355 2.9138889 0.274913 2.9166667 0.276585 2.9194444 0.277143 2.9222222 0.276028 2.9250000 0.277700 2.9277778 0.276585 2.9305556 0.276028 2.9333333 0.277700 2.9361111 0.278258 2.9388889 0.278815 2.9416667 0.279373 2.9444444 0.277700 2.9472222 0.277143 2.9500000 0.278258 2.9527778 0.279373 2.9555556 0.281603 2.9583333 0.281045 2.9611111 0.279930 2.9638889 0.278815 2.9666667 0.278258 2.9694444 0.277700 2.9722222 0.278815 2.9750000 0.276585 2.9777778 0.276585 2.9805556 0.276585 2.9833333 0.277143 2.9861111 0.279373 2.9888889 0.278258 2.9916667 0.277143 2.9944444 0.275470 2.9972222 0.274913 3.0000000 0.274913 3.0027778 0.274355 3.0055556 0.274913 3.0083333 0.275470 3.0111111 0.273240 3.0138889 0.272683 3.0166667 0.271010 3.0194444 0.273240 3.0222222 0.274913 3.0250000 0.274355 3.0277778 0.272683 3.0305556 0.271568 3.0333333 0.272683 3.0361111 0.273798 3.0388889 0.273798 3.0416667 0.273240 3.0444444 0.271568 3.0472222 0.272683 3.0500000 0.273240 3.0527778 0.273240 3.0555556 0.275470 3.0583333 0.274355 3.0611111 0.273798 3.0638889 0.271010 3.0666667 0.270453 3.0694444 0.269338 3.0722222 0.268223 3.0750000 0.265993 3.0777778 0.264321 3.0805556 0.259861 3.0833333 0.259303 3.0861111 0.264321 3.0888889 0.272683 3.0916667 0.284390 3.0944444 0.295540 3.0972222 0.301672 3.1000000 0.309477 3.1027778 0.318955 3.1055556 0.331220 3.1083333 0.344042 3.1111111 0.351847 3.1138889 0.344599 3.1166667 0.323415 3.1194444 0.292753 3.1222222 0.266551 3.1250000 0.250383 3.1277778 0.247038 3.1305556 0.249268 3.1333333 0.254286 3.1361111 0.260976 3.1388889 0.263206 3.1416667 0.263763 3.1444444 0.267108 3.1472222 0.265993 3.1500000 0.265993 3.1527778 0.266551 3.1555556 0.268780 3.1583333 0.268223 3.1611111 0.267108 3.1638889 0.266551 3.1666667 0.267108 3.1694444 0.266551 3.1722222 0.269895 3.1750000 0.268780 3.1777778 0.265993 3.1805556 0.265436 3.1833333 0.265993 3.1861111 0.267108 3.1888889 0.269338 3.1916667 0.269338 3.1944444 0.269895 3.1972222 0.267108 3.2000000 0.269338 3.2027778 0.268223 3.2055556 0.268223 3.2083333 0.269338 3.2111111 0.266551 3.2138889 0.268223 3.2166667 0.269338 3.2194444 0.270453 3.2222222 0.271568 3.2250000 0.269895 3.2277778 0.267666 3.2305556 0.267108 3.2333333 0.267666 3.2361111 0.269338 3.2388889 0.270453 3.2416667 0.268780 3.2444444 0.269338 3.2472222 0.268780 3.2500000 0.268780 3.2527778 0.270453 3.2555556 0.269895 3.2583333 0.270453 3.2611111 0.268223 3.2638889 0.267666 3.2666667 0.268223 3.2694444 0.268223 3.2722222 0.268780 3.2750000 0.268223 3.2777778 0.268223 3.2805556 0.266551 3.2833333 0.267108 3.2861111 0.268223 3.2888889 0.269895 3.2916667 0.269338 3.2944444 0.267108 3.2972222 0.265993 3.3000000 0.267666 3.3027778 0.267108 3.3055556 0.268223 3.3083333 0.267108 3.3111111 0.266551 3.3138889 0.264321 3.3166667 0.265993 3.3194444 0.265993 3.3222222 0.267108 3.3250000 0.264878 3.3277778 0.264321 3.3305556 0.262091 3.3333333 0.262648 3.3361111 0.263206 3.3388889 0.263763 3.3416667 0.261533 3.3444444 0.259861 3.3472222 0.258746 3.3500000 0.259303 3.3527778 0.259861 3.3555556 0.260418 3.3583333 0.258746 3.3611111 0.257073 3.3638889 0.255958 3.3666667 0.254843 3.3694444 0.255958 3.3722222 0.255958 3.3750000 0.255401 3.3777778 0.253728 3.3805556 0.253728 3.3833333 0.254286 3.3861111 0.255401 3.3888889 0.255401 3.3916667 0.254286 3.3944444 0.254286 3.3972222 0.253728 3.4000000 0.257073 3.4027778 0.259303 3.4055556 0.260976 3.4083333 0.260976 3.4111111 0.262091 3.4138889 0.260976 3.4166667 0.262091 3.4194444 0.265436 3.4222222 0.266551 3.4250000 0.267108 3.4277778 0.266551 3.4305556 0.266551 3.4333333 0.269338 3.4361111 0.269895 3.4388889 0.272125 3.4416667 0.271568 3.4444444 0.271568 3.4472222 0.271568 3.4500000 0.271568 3.4527778 0.274355 3.4555556 0.274913 3.4583333 0.274913 3.4611111 0.273798 3.4638889 0.273240 3.4666667 0.275470 3.4694444 0.274913 3.4722222 0.277143 3.4750000 0.276585 3.4777778 0.276028 3.4805556 0.275470 3.4833333 0.275470 3.4861111 0.277143 3.4888889 0.276585 3.4916667 0.277143 3.4944444 0.275470 3.4972222 0.275470 3.5000000 0.275470 3.5027778 0.276585 3.5055556 0.276585 3.5083333 0.277143 3.5111111 0.276585 3.5138889 0.274913 3.5166667 0.273798 3.5194444 0.275470 3.5222222 0.276585 3.5250000 0.277143 3.5277778 0.275470 3.5305556 0.276028 3.5333333 0.275470 3.5361111 0.276028 3.5388889 0.276585 3.5416667 0.275470 3.5444444 0.275470 3.5472222 0.274355 3.5500000 0.275470 3.5527778 0.276028 3.5555556 0.276585 3.5583333 0.275470 3.5611111 0.273798 3.5638889 0.273798 3.5666667 0.274913 3.5694444 0.276585 3.5722222 0.276585 3.5750000 0.276585 3.5777778 0.274355 3.5805556 0.273240 3.5833333 0.274355 3.5861111 0.276028 3.5888889 0.276585 3.5916667 0.275470 3.5944444 0.275470 3.5972222 0.274355 3.6000000 0.274913 3.6027778 0.275470 3.6055556 0.276028 3.6083333 0.275470 3.6111111 0.274913 3.6138889 0.273240 3.6166667 0.275470 3.6194444 0.276028 3.6222222 0.277143 3.6250000 0.276585 3.6277778 0.276028 3.6305556 0.275470 3.6333333 0.275470 3.6361111 0.277143 3.6388889 0.276585 3.6416667 0.278258 3.6444444 0.277700 3.6472222 0.276028 3.6500000 0.274913 3.6527778 0.277700 3.6555556 0.278815 3.6583333 0.278258 3.6611111 0.277143 3.6638889 0.275470 3.6666667 0.277700 3.6694444 0.278258 3.6722222 0.278258 3.6750000 0.278258 3.6777778 0.277143 3.6805556 0.277143 3.6833333 0.277700 3.6861111 0.278258 3.6888889 0.278258 3.6916667 0.280488 3.6944444 0.277143 3.6972222 0.276585 3.7000000 0.277143 3.7027778 0.279373 3.7055556 0.279373 3.7083333 0.279373 3.7111111 0.277700 3.7138889 0.277143 3.7166667 0.278258 3.7194444 0.279930 3.7222222 0.279373 3.7250000 0.279373 3.7277778 0.278815 3.7305556 0.278258 3.7333333 0.279930 3.7361111 0.279930 3.7388889 0.281603 3.7416667 0.281603 3.7444444 0.282160 3.7472222 0.281045 3.7500000 0.281603 3.7527778 0.283275 3.7555556 0.282718 3.7583333 0.282718 3.7611111 0.283275 3.7638889 0.282718 3.7666667 0.283833 3.7694444 0.285505 3.7722222 0.286620 3.7750000 0.286620 3.7777778 0.283833 3.7805556 0.284390 3.7833333 0.283833 3.7861111 0.285505 3.7888889 0.285505 3.7916667 0.285505 3.7944444 0.282718 3.7972222 0.281045 3.8000000 0.282160 3.8027778 0.282160 3.8055556 0.282718 3.8083333 0.282718 3.8111111 0.281045 3.8138889 0.279930 3.8166667 0.279930 3.8194444 0.280488 3.8222222 0.279930 3.8250000 0.279930 3.8277778 0.278258 3.8305556 0.277700 3.8333333 0.278258 3.8361111 0.279930 3.8388889 0.281045 3.8416667 0.280488 3.8444444 0.278258 3.8472222 0.278258 3.8500000 0.278258 3.8527778 0.279930 3.8555556 0.279373 3.8583333 0.280488 3.8611111 0.278258 3.8638889 0.277700 3.8666667 0.278258 3.8694444 0.278815 3.8722222 0.278815 3.8750000 0.278815 3.8777778 0.277143 3.8805556 0.276585 3.8833333 0.276585 3.8861111 0.276028 3.8888889 0.275470 3.8916667 0.272125 3.8944444 0.269895 3.8972222 0.265993 3.9000000 0.266551 3.9027778 0.268780 3.9055556 0.274355 3.9083333 0.284948 3.9111111 0.295540 3.9138889 0.305575 3.9166667 0.317282 3.9194444 0.328432 3.9222222 0.339024 3.9250000 0.350174 3.9277778 0.356864 3.9305556 0.361324 3.9333333 0.357422 3.9361111 0.342927 3.9388889 0.318955 3.9416667 0.292753 3.9444444 0.279373 3.9472222 0.275470 3.9500000 0.276585 3.9527778 0.278258 3.9555556 0.278815 3.9583333 0.278258 3.9611111 0.277700 3.9638889 0.276028 3.9666667 0.276028 3.9694444 0.276585 3.9722222 0.276585 3.9750000 0.274913 3.9777778 0.274913 3.9805556 0.273798 3.9833333 0.273798 3.9861111 0.274913 3.9888889 0.274913 3.9916667 0.275470 3.9944444 0.273798 3.9972222 0.273240 4.0000000 0.273798 4.0027778 0.274913 4.0055556 0.276028 4.0083333 0.276028 4.0111111 0.273240 4.0138889 0.272683 4.0166667 0.273798 4.0194444 0.274355 4.0222222 0.275470 4.0250000 0.274913 4.0277778 0.274913 4.0305556 0.273240 4.0333333 0.273240 4.0361111 0.275470 4.0388889 0.276028 4.0416667 0.276028 4.0444444 0.274913 4.0472222 0.274355 4.0500000 0.273240 4.0527778 0.274913 4.0555556 0.276028 4.0583333 0.275470 4.0611111 0.275470 4.0638889 0.274355 4.0666667 0.274913 4.0694444 0.276028 4.0722222 0.276028 4.0750000 0.275470 4.0777778 0.274355 4.0805556 0.274355 4.0833333 0.275470 4.0861111 0.275470 4.0888889 0.276028 4.0916667 0.276028 4.0944444 0.273798 4.0972222 0.272683 4.1000000 0.273798 4.1027778 0.273240 4.1055556 0.274913 4.1083333 0.274355 4.1111111 0.274355 4.1138889 0.272683 4.1166667 0.273240 4.1194444 0.274913 4.1222222 0.273240 4.1250000 0.273798 4.1277778 0.272125 4.1305556 0.271010 4.1333333 0.273240 4.1361111 0.273240 4.1388889 0.273240 4.1416667 0.272125 4.1444444 0.270453 4.1472222 0.269338 4.1500000 0.268223 4.1527778 0.269338 4.1555556 0.270453 4.1583333 0.268780 4.1611111 0.267666 4.1638889 0.265436 4.1666667 0.265993 4.1694444 0.267108 4.1722222 0.265993 4.1750000 0.265436 4.1777778 0.263763 4.1805556 0.262648 4.1833333 0.264878 4.1861111 0.264878 4.1888889 0.262648 4.1916667 0.262091 4.1944444 0.261533 4.1972222 0.258746 4.2000000 0.258746 4.2027778 0.259861 4.2055556 0.260418 4.2083333 0.259861 4.2111111 0.258188 4.2138889 0.258188 4.2166667 0.257631 4.2194444 0.259861 4.2222222 0.259303 4.2250000 0.258188 4.2277778 0.259303 4.2305556 0.258746 4.2333333 0.260976 4.2361111 0.263206 4.2388889 0.263206 4.2416667 0.264878 4.2444444 0.265436 4.2472222 0.265993 4.2500000 0.268780 4.2527778 0.270453 4.2555556 0.272125 4.2583333 0.274355 4.2611111 0.273798 4.2638889 0.274913 4.2666667 0.276585 4.2694444 0.278815 4.2722222 0.279373 4.2750000 0.281045 4.2777778 0.279930 4.2805556 0.279930 4.2833333 0.279930 4.2861111 0.281603 4.2888889 0.283833 4.2916667 0.281603 4.2944444 0.281603 4.2972222 0.281603 4.3000000 0.281603 4.3027778 0.283275 4.3055556 0.282718 4.3083333 0.282718 4.3111111 0.282160 4.3138889 0.281603 4.3166667 0.282160 4.3194444 0.282718 4.3222222 0.283275 4.3250000 0.283275 4.3277778 0.282718 4.3305556 0.281045 4.3333333 0.281603 4.3361111 0.282718 4.3388889 0.282718 4.3416667 0.282160 4.3444444 0.281603 4.3472222 0.279930 4.3500000 0.281045 4.3527778 0.281603 4.3555556 0.282160 4.3583333 0.282160 4.3611111 0.280488 4.3638889 0.279373 4.3666667 0.279373 4.3694444 0.281045 4.3722222 0.281603 4.3750000 0.281603 4.3777778 0.279930 4.3805556 0.279373 4.3833333 0.279373 4.3861111 0.279930 4.3888889 0.281045 4.3916667 0.281603 4.3944444 0.279373 4.3972222 0.278815 4.4000000 0.279373 4.4027778 0.279930 4.4055556 0.281045 4.4083333 0.279930 4.4111111 0.279930 4.4138889 0.277143 4.4166667 0.278258 4.4194444 0.278258 4.4222222 0.281045 4.4250000 0.280488 4.4277778 0.277700 4.4305556 0.277143 4.4333333 0.278815 4.4361111 0.278258 4.4388889 0.278258 4.4416667 0.278258 4.4444444 0.277700 4.4472222 0.276028 4.4500000 0.277700 4.4527778 0.279930 4.4555556 0.278815 4.4583333 0.279373 4.4611111 0.277143 4.4638889 0.277700 4.4666667 0.278258 4.4694444 0.278258 4.4722222 0.281045 4.4750000 0.279373 4.4777778 0.278815 4.4805556 0.277143 4.4833333 0.279373 4.4861111 0.278815 4.4888889 0.280488 4.4916667 0.279373 4.4944444 0.279373 4.4972222 0.278258 4.5000000 0.279373 4.5027778 0.279930 4.5055556 0.280488 4.5083333 0.280488 4.5111111 0.279373 4.5138889 0.277700 4.5166667 0.279373 4.5194444 0.279930 4.5222222 0.280488 4.5250000 0.279930 4.5277778 0.277700 4.5305556 0.279373 4.5333333 0.278258 4.5361111 0.279930 4.5388889 0.281045 4.5416667 0.280488 4.5444444 0.279930 4.5472222 0.278815 4.5500000 0.278258 4.5527778 0.279373 4.5555556 0.280488 4.5583333 0.279930 4.5611111 0.279373 4.5638889 0.278258 4.5666667 0.279930 4.5694444 0.281045 4.5722222 0.282160 4.5750000 0.282718 4.5777778 0.282718 4.5805556 0.281603 4.5833333 0.282160 4.5861111 0.283833 4.5888889 0.284390 4.5916667 0.284390 4.5944444 0.283833 4.5972222 0.282718 4.6000000 0.283275 4.6027778 0.283833 4.6055556 0.284948 4.6083333 0.284948 4.6111111 0.284948 4.6138889 0.283275 4.6166667 0.286620 4.6194444 0.286063 4.6222222 0.287735 4.6250000 0.287178 4.6277778 0.286063 4.6305556 0.284948 4.6333333 0.284390 4.6361111 0.285505 4.6388889 0.285505 4.6416667 0.284390 4.6444444 0.283275 4.6472222 0.281603 4.6500000 0.283275 4.6527778 0.283275 4.6555556 0.283275 4.6583333 0.283833 4.6611111 0.281045 4.6638889 0.279373 4.6666667 0.281045 4.6694444 0.282160 4.6722222 0.283275 4.6750000 0.281603 4.6777778 0.281603 4.6805556 0.279373 4.6833333 0.280488 4.6861111 0.281603 4.6888889 0.282160 4.6916667 0.282160 4.6944444 0.280488 4.6972222 0.278258 4.7000000 0.279373 4.7027778 0.279930 4.7055556 0.281603 4.7083333 0.281045 4.7111111 0.281045 4.7138889 0.278815 4.7166667 0.279930 4.7194444 0.280488 4.7222222 0.281603 4.7250000 0.281045 4.7277778 0.278815 4.7305556 0.277700 4.7333333 0.276028 4.7361111 0.274913 4.7388889 0.273240 4.7416667 0.270453 4.7444444 0.267666 4.7472222 0.264321 4.7500000 0.264878 4.7527778 0.272683 4.7555556 0.281603 4.7583333 0.294425 4.7611111 0.304460 4.7638889 0.312822 4.7666667 0.324530 4.7694444 0.337909 4.7722222 0.349059 4.7750000 0.360209 4.7777778 0.365226 4.7805556 0.360209 4.7833333 0.341254 4.7861111 0.314495 4.7888889 0.291080 4.7916667 0.280488 4.7944444 0.279373 4.7972222 0.277143 4.8000000 0.278258 4.8027778 0.277700 4.8055556 0.279373 4.8083333 0.278815 4.8111111 0.277143 4.8138889 0.274355 4.8166667 0.276028 4.8194444 0.277700 4.8222222 0.276028 4.8250000 0.276028 4.8277778 0.273240 4.8305556 0.273798 4.8333333 0.274355 4.8361111 0.275470 4.8388889 0.276028 4.8416667 0.276028 4.8444444 0.273240 4.8472222 0.273798 4.8500000 0.274913 4.8527778 0.273798 4.8555556 0.276585 4.8583333 0.275470 4.8611111 0.274355 4.8638889 0.273240 4.8666667 0.273240 4.8694444 0.275470 4.8722222 0.274355 4.8750000 0.274913 4.8777778 0.274355 4.8805556 0.273240 4.8833333 0.273798 4.8861111 0.276028 4.8888889 0.276585 4.8916667 0.275470 4.8944444 0.273798 4.8972222 0.273240 4.9000000 0.273798 4.9027778 0.275470 4.9055556 0.274355 4.9083333 0.275470 4.9111111 0.274913 4.9138889 0.273798 4.9166667 0.274355 4.9194444 0.274355 4.9222222 0.276028 4.9250000 0.275470 4.9277778 0.273798 4.9305556 0.272683 4.9333333 0.273240 4.9361111 0.274355 4.9388889 0.275470 4.9416667 0.275470 4.9444444 0.273798 4.9472222 0.272683 4.9500000 0.273240 4.9527778 0.273240 4.9555556 0.273798 4.9583333 0.273240 4.9611111 0.273240 4.9638889 0.272125 4.9666667 0.273240 4.9694444 0.273798 4.9722222 0.273798 4.9750000 0.272683 4.9777778 0.271568 4.9805556 0.270453 4.9833333 0.270453 4.9861111 0.271568 4.9888889 0.271568 4.9916667 0.272125 4.9944444 0.270453 4.9972222 0.269338 5.0000000 0.269338 5.0027778 0.269338 5.0055556 0.269338 5.0083333 0.269338 5.0111111 0.268223 5.0138889 0.265436 5.0166667 0.266551 5.0194444 0.267108 5.0222222 0.267108 5.0250000 0.265436 5.0277778 0.264321 5.0305556 0.262648 5.0333333 0.263206 5.0361111 0.263763 5.0388889 0.263763 5.0416667 0.263206 5.0444444 0.261533 5.0472222 0.259303 5.0500000 0.259861 5.0527778 0.260976 5.0555556 0.261533 5.0583333 0.261533 5.0611111 0.259861 5.0638889 0.258746 5.0666667 0.259303 5.0694444 0.261533 5.0722222 0.262091 5.0750000 0.263763 5.0777778 0.263763 5.0805556 0.263763 5.0833333 0.266551 5.0861111 0.268223 5.0888889 0.268780 5.0916667 0.270453 5.0944444 0.269895 5.0972222 0.269895 5.1000000 0.272125 5.1027778 0.274913 5.1055556 0.276585 5.1083333 0.276585 5.1111111 0.277143 5.1138889 0.276028 5.1166667 0.277143 5.1194444 0.278815 5.1222222 0.279930 5.1250000 0.280488 5.1277778 0.278815 5.1305556 0.278815 5.1333333 0.278815 5.1361111 0.281603 5.1388889 0.282160 5.1416667 0.280488 5.1444444 0.281045 5.1472222 0.279373 5.1500000 0.279930 5.1527778 0.282160 5.1555556 0.282160 5.1583333 0.282160 5.1611111 0.279930 5.1638889 0.278815 5.1666667 0.279930 5.1694444 0.281045 5.1722222 0.282160 5.1750000 0.282160 5.1777778 0.280488 5.1805556 0.279930 5.1833333 0.279930 5.1861111 0.281045 5.1888889 0.281045 5.1916667 0.280488 5.1944444 0.279930 5.1972222 0.278815 5.2000000 0.279930 5.2027778 0.279930 5.2055556 0.281603 5.2083333 0.279373 5.2111111 0.278815 5.2138889 0.277143 5.2166667 0.278258 5.2194444 0.279930 5.2222222 0.280488 5.2250000 0.278258 5.2277778 0.277700 5.2305556 0.276585 5.2333333 0.277700 5.2361111 0.278815 5.2388889 0.278258 5.2416667 0.277700 5.2444444 0.277143 5.2472222 0.276585 5.2500000 0.276028 5.2527778 0.278815 5.2555556 0.278815 5.2583333 0.278815 5.2611111 0.278258 5.2638889 0.276585 5.2666667 0.276028 5.2694444 0.278258 5.2722222 0.278815 5.2750000 0.278815 5.2777778 0.277143 5.2805556 0.276585 5.2833333 0.276585 5.2861111 0.277143 5.2888889 0.278258 5.2916667 0.277700 5.2944444 0.277143 5.2972222 0.276585 5.3000000 0.277143 5.3027778 0.277700 5.3055556 0.278815 5.3083333 0.278258 5.3111111 0.276585 5.3138889 0.275470 5.3166667 0.276585 5.3194444 0.278258 5.3222222 0.279373 5.3250000 0.278258 5.3277778 0.277700 5.3305556 0.276028 5.3333333 0.277143 5.3361111 0.278815 5.3388889 0.280488 5.3416667 0.279373 5.3444444 0.278258 5.3472222 0.277700 5.3500000 0.277700 5.3527778 0.278815 5.3555556 0.279930 5.3583333 0.280488 5.3611111 0.278258 5.3638889 0.279373 5.3666667 0.278258 5.3694444 0.278815 5.3722222 0.278815 5.3750000 0.278258 5.3777778 0.277700 5.3805556 0.277143 5.3833333 0.277700 5.3861111 0.279373 5.3888889 0.280488 5.3916667 0.279373 5.3944444 0.279373 5.3972222 0.278815 5.4000000 0.279930 5.4027778 0.281603 5.4055556 0.282160 5.4083333 0.282160 5.4111111 0.282718 5.4138889 0.282160 5.4166667 0.282160 5.4194444 0.283275 5.4222222 0.283833 5.4250000 0.284948 5.4277778 0.285505 5.4305556 0.284390 5.4333333 0.284390 5.4361111 0.286620 5.4388889 0.285505 5.4416667 0.286063 5.4444444 0.284948 5.4472222 0.283275 5.4500000 0.283833 5.4527778 0.283833 5.4555556 0.284390 5.4583333 0.284390 5.4611111 0.281045 5.4638889 0.279930 5.4666667 0.280488 5.4694444 0.282160 5.4722222 0.282160 5.4750000 0.281603 5.4777778 0.281603 5.4805556 0.278815 5.4833333 0.278815 5.4861111 0.279930 5.4888889 0.280488 5.4916667 0.280488 5.4944444 0.279373 5.4972222 0.278258 5.5000000 0.277700 5.5027778 0.279930 5.5055556 0.279373 5.5083333 0.279373 5.5111111 0.277143 5.5138889 0.277143 5.5166667 0.277700 5.5194444 0.279373 5.5222222 0.280488 5.5250000 0.279373 5.5277778 0.277700 5.5305556 0.276585 5.5333333 0.276028 5.5361111 0.277700 5.5388889 0.278815 5.5416667 0.277700 5.5444444 0.273240 5.5472222 0.270453 5.5500000 0.266551 5.5527778 0.265436 5.5555556 0.262648 5.5583333 0.263206 5.5611111 0.267666 5.5638889 0.276028 5.5666667 0.288293 5.5694444 0.298885 5.5722222 0.307247 5.5750000 0.317840 5.5777778 0.327317 5.5805556 0.339024 5.5833333 0.350732 5.5861111 0.356864 5.5888889 0.353519 5.5916667 0.330105 5.5944444 0.297770 5.5972222 0.273240 5.6000000 0.263763 5.6027778 0.265436 5.6055556 0.271568 5.6083333 0.273798 5.6111111 0.273798 5.6138889 0.271568 5.6166667 0.273240 5.6194444 0.273798 5.6222222 0.274355 5.6250000 0.274355 5.6277778 0.272683 5.6305556 0.272683 5.6333333 0.272125 5.6361111 0.272683 5.6388889 0.274355 5.6416667 0.274355 5.6444444 0.273240 5.6472222 0.272125 5.6500000 0.271010 5.6527778 0.273798 5.6555556 0.274355 5.6583333 0.274913 5.6611111 0.273798 5.6638889 0.273798 5.6666667 0.273798 5.6694444 0.274355 5.6722222 0.275470 5.6750000 0.274355 5.6777778 0.273240 5.6805556 0.272683 5.6833333 0.272683 5.6861111 0.274355 5.6888889 0.273798 5.6916667 0.274355 5.6944444 0.272683 5.6972222 0.271568 5.7000000 0.272683 5.7027778 0.273798 5.7055556 0.273798 5.7083333 0.273240 5.7111111 0.272125 5.7138889 0.273240 5.7166667 0.271568 5.7194444 0.273798 5.7222222 0.274913 5.7250000 0.274355 5.7277778 0.273798 5.7305556 0.272683 5.7333333 0.272125 5.7361111 0.272125 5.7388889 0.272683 5.7416667 0.273240 5.7444444 0.271568 5.7472222 0.271568 5.7500000 0.272683 5.7527778 0.273240 5.7555556 0.273240 5.7583333 0.272683 5.7611111 0.272125 5.7638889 0.271568 5.7666667 0.272683 5.7694444 0.273798 5.7722222 0.273798 5.7750000 0.271010 5.7777778 0.271010 5.7805556 0.269338 5.7833333 0.268223 5.7861111 0.270453 5.7888889 0.271010 5.7916667 0.271568 5.7944444 0.269338 5.7972222 0.267666 5.8000000 0.266551 5.8027778 0.268223 5.8055556 0.268223 5.8083333 0.268223 5.8111111 0.267108 5.8138889 0.266551 5.8166667 0.266551 5.8194444 0.266551 5.8222222 0.266551 5.8250000 0.265993 5.8277778 0.264878 5.8305556 0.263206 5.8333333 0.262648 5.8361111 0.263763 5.8388889 0.263763 5.8416667 0.263206 5.8444444 0.262648 5.8472222 0.260976 5.8500000 0.261533 5.8527778 0.261533 5.8555556 0.262648 5.8583333 0.262648 5.8611111 0.261533 5.8638889 0.259861 5.8666667 0.261533 5.8694444 0.262648 5.8722222 0.262648 5.8750000 0.263763 5.8777778 0.263763 5.8805556 0.264321 5.8833333 0.265993 5.8861111 0.267666 5.8888889 0.271010 5.8916667 0.271568 5.8944444 0.271568 5.8972222 0.272125 5.9000000 0.272683 5.9027778 0.273240 5.9055556 0.276028 5.9083333 0.277143 5.9111111 0.276028 5.9138889 0.276028 5.9166667 0.276585 5.9194444 0.277700 5.9222222 0.279373 5.9250000 0.278815 5.9277778 0.277700 5.9305556 0.277143 5.9333333 0.278815 5.9361111 0.277143 5.9388889 0.278258 5.9416667 0.277143 5.9444444 0.276028 5.9472222 0.276585 5.9500000 0.276585 5.9527778 0.278815 5.9555556 0.278258 5.9583333 0.278815 5.9611111 0.277143 5.9638889 0.274913 5.9666667 0.274913 5.9694444 0.277700 5.9722222 0.278815 5.9750000 0.277700 5.9777778 0.278258 5.9805556 0.276028 5.9833333 0.276585 5.9861111 0.276028 5.9888889 0.276028 5.9916667 0.277143 5.9944444 0.275470 5.9972222 0.274913 6.0000000 0.274913 6.0027778 0.275470 6.0055556 0.276028 6.0083333 0.276585 6.0111111 0.275470 6.0138889 0.274913 6.0166667 0.275470 6.0194444 0.275470 6.0222222 0.274913 6.0250000 0.275470 6.0277778 0.274355 6.0305556 0.273240 6.0333333 0.273240 6.0361111 0.274355 6.0388889 0.274355 6.0416667 0.273798 6.0444444 0.272683 6.0472222 0.272125 6.0500000 0.273240 6.0527778 0.274913 6.0555556 0.276028 6.0583333 0.273798 6.0611111 0.273798 6.0638889 0.273798 6.0666667 0.274355 6.0694444 0.276028 6.0722222 0.276585 6.0750000 0.275470 6.0777778 0.272683 6.0805556 0.273240 6.0833333 0.272683 6.0861111 0.274355 6.0888889 0.274913 6.0916667 0.274913 6.0944444 0.274355 6.0972222 0.273240 6.1000000 0.272125 6.1027778 0.273798 6.1055556 0.273240 6.1083333 0.273240 6.1111111 0.272683 6.1138889 0.271010 6.1166667 0.273240 6.1194444 0.274913 6.1222222 0.273798 6.1250000 0.274355 6.1277778 0.273240 6.1305556 0.272125 6.1333333 0.272125 6.1361111 0.273240 6.1388889 0.274913 6.1416667 0.275470 6.1444444 0.274355 6.1472222 0.272683 6.1500000 0.272683 6.1527778 0.273798 6.1555556 0.273798 6.1583333 0.272683 6.1611111 0.272683 6.1638889 0.271568 6.1666667 0.272125 6.1694444 0.273240 6.1722222 0.273798 6.1750000 0.274355 6.1777778 0.272683 6.1805556 0.272125 6.1833333 0.273240 6.1861111 0.275470 6.1888889 0.276028 6.1916667 0.277700 6.1944444 0.276585 6.1972222 0.274355 6.2000000 0.274913 6.2027778 0.277143 6.2055556 0.277700 6.2083333 0.277700 6.2111111 0.278815 6.2138889 0.277700 6.2166667 0.276585 6.2194444 0.278258 6.2222222 0.279373 6.2250000 0.279373 6.2277778 0.278815 6.2305556 0.274355 6.2333333 0.276028 6.2361111 0.274913 6.2388889 0.275470 6.2416667 0.274355 6.2444444 0.274355 6.2472222 0.273240 6.2500000 0.274355 6.2527778 0.274355 6.2555556 0.273798 6.2583333 0.272683 6.2611111 0.270453 6.2638889 0.270453 6.2666667 0.270453 6.2694444 0.272683 6.2722222 0.273240 6.2750000 0.273240 6.2777778 0.272683 6.2805556 0.269895 6.2833333 0.270453 6.2861111 0.272125 6.2888889 0.272683 6.2916667 0.272683 6.2944444 0.269895 6.2972222 0.268780 6.3000000 0.271010 6.3027778 0.271568 6.3055556 0.271568 6.3083333 0.273240 6.3111111 0.271568 6.3138889 0.269895 6.3166667 0.270453 6.3194444 0.268223 6.3222222 0.264878 6.3250000 0.263206 6.3277778 0.259303 6.3305556 0.258746 6.3333333 0.263206 6.3361111 0.274913 6.3388889 0.285505 6.3416667 0.294425 6.3444444 0.301115 6.3472222 0.308362 6.3500000 0.320627 6.3527778 0.334007 6.3555556 0.339582 6.3583333 0.332334 6.3611111 0.303902 6.3638889 0.272125 6.3666667 0.255958 6.3694444 0.255401 6.3722222 0.261533 6.3750000 0.263763 6.3777778 0.264878 6.3805556 0.265436 6.3833333 0.267108 6.3861111 0.268223 6.3888889 0.268780 6.3916667 0.268780 6.3944444 0.266551 6.3972222 0.265993 6.4000000 0.265993 6.4027778 0.269338 6.4055556 0.269895 6.4083333 0.268780 6.4111111 0.268780 6.4138889 0.266551 6.4166667 0.266551 6.4194444 0.267666 6.4222222 0.269338 6.4250000 0.270453 6.4277778 0.269338 6.4305556 0.267108 6.4333333 0.267666 6.4361111 0.269338 6.4388889 0.268780 6.4416667 0.269895 6.4444444 0.268223 6.4472222 0.269338 6.4500000 0.268223 6.4527778 0.268223 6.4555556 0.270453 6.4583333 0.269895 6.4611111 0.268223 6.4638889 0.267666 6.4666667 0.269338 6.4694444 0.269338 6.4722222 0.270453 6.4750000 0.269895 6.4777778 0.269338 6.4805556 0.268223 6.4833333 0.268780 6.4861111 0.269338 6.4888889 0.269895 6.4916667 0.269895 6.4944444 0.267666 6.4972222 0.267108 6.5000000 0.267666 6.5027778 0.268780 6.5055556 0.270453 6.5083333 0.269338 6.5111111 0.267108 6.5138889 0.266551 6.5166667 0.268223 6.5194444 0.269338 6.5222222 0.268780 6.5250000 0.267666 6.5277778 0.268223 6.5305556 0.266551 6.5333333 0.266551 6.5361111 0.267666 6.5388889 0.267666 6.5416667 0.267108 6.5444444 0.265993 6.5472222 0.263763 6.5500000 0.264321 6.5527778 0.265436 6.5555556 0.265993 6.5583333 0.265993 6.5611111 0.264321 6.5638889 0.262648 6.5666667 0.263206 6.5694444 0.264321 6.5722222 0.263206 6.5750000 0.262648 6.5777778 0.262091 6.5805556 0.258746 6.5833333 0.259861 6.5861111 0.258746 6.5888889 0.258188 6.5916667 0.259303 6.5944444 0.257073 6.5972222 0.255958 6.6000000 0.257073 6.6027778 0.256516 6.6055556 0.257631 6.6083333 0.257073 6.6111111 0.255958 6.6138889 0.254286 6.6166667 0.254843 6.6194444 0.255401 6.6222222 0.256516 6.6250000 0.255401 6.6277778 0.255401 6.6305556 0.256516 6.6333333 0.255958 6.6361111 0.257631 6.6388889 0.258746 6.6416667 0.260418 6.6444444 0.259861 6.6472222 0.262091 6.6500000 0.264878 6.6527778 0.265993 6.6555556 0.268223 6.6583333 0.268780 6.6611111 0.269895 6.6638889 0.268223 6.6666667 0.271010 6.6694444 0.273798 6.6722222 0.276028 6.6750000 0.274913 6.6777778 0.274913 6.6805556 0.276028 6.6833333 0.273798 6.6861111 0.276585 6.6888889 0.278258 6.6916667 0.278258 6.6944444 0.277700 6.6972222 0.276028 6.7000000 0.277700 6.7027778 0.277700 6.7055556 0.278815 6.7083333 0.278815 6.7111111 0.278815 6.7138889 0.277143 6.7166667 0.278258 6.7194444 0.279373 6.7222222 0.277700 6.7250000 0.278815 6.7277778 0.277700 6.7305556 0.277700 6.7333333 0.276585 6.7361111 0.278815 6.7388889 0.278815 6.7416667 0.278258 6.7444444 0.277143 6.7472222 0.276028 6.7500000 0.276028 6.7527778 0.278258 6.7555556 0.278815 6.7583333 0.277700 6.7611111 0.278258 6.7638889 0.276585 6.7666667 0.276028 6.7694444 0.276585 6.7722222 0.277700 6.7750000 0.277700 6.7777778 0.276585 6.7805556 0.275470 6.7833333 0.277143 6.7861111 0.277700 6.7888889 0.278258 6.7916667 0.277700 6.7944444 0.276585 6.7972222 0.276028 6.8000000 0.276585 6.8027778 0.276585 6.8055556 0.278815 6.8083333 0.277700 6.8111111 0.276028 6.8138889 0.274913 6.8166667 0.276028 6.8194444 0.277143 6.8222222 0.278258 6.8250000 0.276585 6.8277778 0.276585 6.8305556 0.274913 6.8333333 0.274355 6.8361111 0.276028 6.8388889 0.277143 6.8416667 0.276028 6.8444444 0.276028 6.8472222 0.274355 6.8500000 0.275470 6.8527778 0.277143 6.8555556 0.276585 6.8583333 0.276028 6.8611111 0.274913 6.8638889 0.276028 6.8666667 0.276028 6.8694444 0.276585 6.8722222 0.276585 6.8750000 0.277143 6.8777778 0.276585 6.8805556 0.275470 6.8833333 0.276028 6.8861111 0.277143 6.8888889 0.278815 6.8916667 0.279373 6.8944444 0.277700 6.8972222 0.274913 6.9000000 0.276585 6.9027778 0.277700 6.9055556 0.277700 6.9083333 0.277143 6.9111111 0.278258 6.9138889 0.276585 6.9166667 0.276585 6.9194444 0.277700 6.9222222 0.278815 6.9250000 0.278258 6.9277778 0.276585 6.9305556 0.276028 6.9333333 0.275470 6.9361111 0.277143 6.9388889 0.277143 6.9416667 0.277143 6.9444444 0.277700 6.9472222 0.276028 6.9500000 0.276028 6.9527778 0.277700 6.9555556 0.279930 6.9583333 0.278815 6.9611111 0.278815 6.9638889 0.279930 6.9666667 0.279373 6.9694444 0.280488 6.9722222 0.282718 6.9750000 0.281045 6.9777778 0.279373 6.9805556 0.279930 6.9833333 0.280488 6.9861111 0.282718 6.9888889 0.284390 6.9916667 0.284390 6.9944444 0.282160 6.9972222 0.282160 7.0000000 0.282718 7.0027778 0.282718 7.0055556 0.283833 7.0083333 0.281603 7.0111111 0.279930 7.0138889 0.278815 7.0166667 0.279373 7.0194444 0.279930 7.0222222 0.279930 7.0250000 0.279930 7.0277778 0.278815 7.0305556 0.276028 7.0333333 0.277700 7.0361111 0.278258 7.0388889 0.278258 7.0416667 0.277700 7.0444444 0.277143 7.0472222 0.276585 7.0500000 0.277143 7.0527778 0.278815 7.0555556 0.278815 7.0583333 0.278815 7.0611111 0.276028 7.0638889 0.276028 7.0666667 0.276028 7.0694444 0.276585 7.0722222 0.278258 7.0750000 0.278258 7.0777778 0.277143 7.0805556 0.276585 7.0833333 0.276585 7.0861111 0.276585 7.0888889 0.277143 7.0916667 0.276585 7.0944444 0.272683 7.0972222 0.268780 7.1000000 0.267108 7.1027778 0.263763 7.1055556 0.262648 7.1083333 0.263206 7.1111111 0.268223 7.1138889 0.281045 7.1166667 0.296655 7.1194444 0.310035 7.1222222 0.322857 7.1250000 0.335679 7.1277778 0.348502 7.1305556 0.360767 7.1333333 0.369686 7.1361111 0.367456 7.1388889 0.342927 7.1416667 0.304460 7.1444444 0.276585 7.1472222 0.269895 7.1500000 0.272683 7.1527778 0.274355 7.1555556 0.274913 7.1583333 0.274913 7.1611111 0.275470 7.1638889 0.273240 7.1666667 0.273798 7.1694444 0.273240 7.1722222 0.274355 7.1750000 0.273798 7.1777778 0.272125 7.1805556 0.272125 7.1833333 0.271568 7.1861111 0.273240 7.1888889 0.272683 7.1916667 0.274355 7.1944444 0.272125 7.1972222 0.271010 7.2000000 0.271010 7.2027778 0.272125 7.2055556 0.272683 7.2083333 0.273240 7.2111111 0.271568 7.2138889 0.271568 7.2166667 0.272125 7.2194444 0.272683 7.2222222 0.272683 7.2250000 0.273240 7.2277778 0.271568 7.2305556 0.271568 7.2333333 0.271568 7.2361111 0.272683 7.2388889 0.274355 7.2416667 0.273798 7.2444444 0.273240 7.2472222 0.272125 7.2500000 0.271010 7.2527778 0.273240 7.2555556 0.274355 7.2583333 0.274355 7.2611111 0.273240 7.2638889 0.272125 7.2666667 0.272125 7.2694444 0.273240 7.2722222 0.273798 7.2750000 0.274355 7.2777778 0.273240 7.2805556 0.271010 7.2833333 0.271568 7.2861111 0.273798 7.2888889 0.273798 7.2916667 0.272683 7.2944444 0.271568 7.2972222 0.270453 7.3000000 0.271010 7.3027778 0.272683 7.3055556 0.273240 7.3083333 0.273240 7.3111111 0.269338 7.3138889 0.269895 7.3166667 0.269338 7.3194444 0.271010 7.3222222 0.271568 7.3250000 0.271010 7.3277778 0.269338 7.3305556 0.267666 7.3333333 0.267108 7.3361111 0.267666 7.3388889 0.269338 7.3416667 0.267666 7.3444444 0.266551 7.3472222 0.265436 7.3500000 0.265436 7.3527778 0.265436 7.3555556 0.265436 7.3583333 0.264321 7.3611111 0.263763 7.3638889 0.262648 7.3666667 0.261533 7.3694444 0.262091 7.3722222 0.263763 7.3750000 0.262091 7.3777778 0.260976 7.3805556 0.259861 7.3833333 0.259303 7.3861111 0.259861 7.3888889 0.260976 7.3916667 0.259861 7.3944444 0.258188 7.3972222 0.258188 7.4000000 0.257631 7.4027778 0.260418 7.4055556 0.259303 7.4083333 0.259303 7.4111111 0.258746 7.4138889 0.258188 7.4166667 0.259861 7.4194444 0.262091 7.4222222 0.262648 7.4250000 0.265436 7.4277778 0.265993 7.4305556 0.264878 7.4333333 0.267108 7.4361111 0.269338 7.4388889 0.271010 7.4416667 0.274355 7.4444444 0.272683 7.4472222 0.274355 7.4500000 0.274355 7.4527778 0.277143 7.4555556 0.278815 7.4583333 0.277700 7.4611111 0.277700 7.4638889 0.278815 7.4666667 0.278815 7.4694444 0.279930 7.4722222 0.280488 7.4750000 0.281045 7.4777778 0.279373 7.4805556 0.278815 7.4833333 0.279373 7.4861111 0.279930 7.4888889 0.281603 7.4916667 0.281045 7.4944444 0.281045 7.4972222 0.278815 7.5000000 0.278815 7.5027778 0.279373 7.5055556 0.282160 7.5083333 0.282160 7.5111111 0.280488 7.5138889 0.278815 7.5166667 0.278815 7.5194444 0.279930 7.5222222 0.281045 7.5250000 0.279930 7.5277778 0.278815 7.5305556 0.277700 7.5333333 0.277700 7.5361111 0.279373 7.5388889 0.279373 7.5416667 0.278258 7.5444444 0.277700 7.5472222 0.276585 7.5500000 0.277700 7.5527778 0.278815 7.5555556 0.279930 7.5583333 0.278258 7.5611111 0.277143 7.5638889 0.274913 7.5666667 0.276028 7.5694444 0.276585 7.5722222 0.277700 7.5750000 0.277143 7.5777778 0.276585 7.5805556 0.276028 7.5833333 0.276028 7.5861111 0.275470 7.5888889 0.276585 7.5916667 0.277143 7.5944444 0.277700 7.5972222 0.276028 7.6000000 0.274913 7.6027778 0.276028 7.6055556 0.276028 7.6083333 0.276585 7.6111111 0.274913 7.6138889 0.274355 7.6166667 0.274913 7.6194444 0.275470 7.6222222 0.275470 7.6250000 0.276028 7.6277778 0.273798 7.6305556 0.273798 7.6333333 0.274355 7.6361111 0.275470 7.6388889 0.277700 7.6416667 0.276028 7.6444444 0.274355 7.6472222 0.274355 7.6500000 0.274355 7.6527778 0.275470 7.6555556 0.277143 7.6583333 0.276028 7.6611111 0.275470 7.6638889 0.274913 7.6666667 0.274355 7.6694444 0.276028 7.6722222 0.277143 7.6750000 0.277143 7.6777778 0.276585 7.6805556 0.274913 7.6833333 0.274913 7.6861111 0.277143 7.6888889 0.277700 7.6916667 0.277143 7.6944444 0.277700 7.6972222 0.275470 7.7000000 0.275470 7.7027778 0.277143 7.7055556 0.277143 7.7083333 0.277143 7.7111111 0.277700 7.7138889 0.276028 7.7166667 0.276585 7.7194444 0.277700 7.7222222 0.277700 7.7250000 0.277700 7.7277778 0.277700 7.7305556 0.277143 7.7333333 0.277143 7.7361111 0.279373 7.7388889 0.281045 7.7416667 0.280488 7.7444444 0.279930 7.7472222 0.279373 7.7500000 0.278258 7.7527778 0.281603 7.7555556 0.282160 7.7583333 0.281603 7.7611111 0.282160 7.7638889 0.282718 7.7666667 0.282718 7.7694444 0.283275 7.7722222 0.284948 7.7750000 0.283275 7.7777778 0.283833 7.7805556 0.282718 7.7833333 0.282160 7.7861111 0.281603 7.7888889 0.282718 7.7916667 0.280488 7.7944444 0.280488 7.7972222 0.279930 7.8000000 0.279373 7.8027778 0.279373 7.8055556 0.281045 7.8083333 0.280488 7.8111111 0.278258 7.8138889 0.276028 7.8166667 0.276585 7.8194444 0.277143 7.8222222 0.278258 7.8250000 0.278258 7.8277778 0.277700 7.8305556 0.277700 7.8333333 0.276585 7.8361111 0.278258 7.8388889 0.277700 7.8416667 0.277143 7.8444444 0.276585 7.8472222 0.276585 7.8500000 0.274913 7.8527778 0.276585 7.8555556 0.278258 7.8583333 0.276585 7.8611111 0.276585 7.8638889 0.274913 7.8666667 0.274913 7.8694444 0.276028 7.8722222 0.277700 7.8750000 0.277143 7.8777778 0.276028 7.8805556 0.274913 7.8833333 0.272683 7.8861111 0.269895 7.8888889 0.267666 7.8916667 0.264321 7.8944444 0.260976 7.8972222 0.258188 7.9000000 0.263206 7.9027778 0.274913 7.9055556 0.289965 7.9083333 0.302230 7.9111111 0.312822 7.9138889 0.322300 7.9166667 0.336237 7.9194444 0.350732 7.9222222 0.363554 7.9250000 0.368014 7.9277778 0.355749 7.9305556 0.323972 7.9333333 0.285505 7.9361111 0.271010 7.9388889 0.272125 7.9416667 0.274355 7.9444444 0.273798 7.9472222 0.272683 7.9500000 0.274913 7.9527778 0.273798 7.9555556 0.273798 7.9583333 0.272125 7.9611111 0.272683 7.9638889 0.271568 7.9666667 0.272683 7.9694444 0.272125 7.9722222 0.274355 7.9750000 0.272125 7.9777778 0.272125 7.9805556 0.271568 7.9833333 0.271010 7.9861111 0.271568 7.9888889 0.273798 7.9916667 0.273798 7.9944444 0.271568 7.9972222 0.271010 8.0000000 0.271568 8.0027778 0.272125 8.0055556 0.272683 8.0083333 0.273240 8.0111111 0.272683 8.0138889 0.272125 8.0166667 0.272683 8.0194444 0.272683 8.0222222 0.274913 8.0250000 0.272125 8.0277778 0.272125 8.0305556 0.272125 8.0333333 0.272125 8.0361111 0.272125 8.0388889 0.274355 8.0416667 0.273798 8.0444444 0.272125 8.0472222 0.272125 8.0500000 0.271568 8.0527778 0.272125 8.0555556 0.274355 8.0583333 0.274355 8.0611111 0.272683 8.0638889 0.271568 8.0666667 0.270453 8.0694444 0.272683 8.0722222 0.274355 8.0750000 0.273240 8.0777778 0.271568 8.0805556 0.271568 8.0833333 0.271010 8.0861111 0.272125 8.0888889 0.272683 8.0916667 0.270453 8.0944444 0.271010 8.0972222 0.269338 8.1000000 0.271010 8.1027778 0.271010 8.1055556 0.272683 8.1083333 0.272683 8.1111111 0.269895 8.1138889 0.269338 8.1166667 0.269338 8.1194444 0.269338 8.1222222 0.270453 8.1250000 0.268780 8.1277778 0.267666 8.1305556 0.266551 8.1333333 0.265993 8.1361111 0.267108 8.1388889 0.265993 8.1416667 0.265436 8.1444444 0.264321 8.1472222 0.262648 8.1500000 0.262091 8.1527778 0.262648 8.1555556 0.261533 8.1583333 0.262091 8.1611111 0.260418 8.1638889 0.259303 8.1666667 0.258746 8.1694444 0.260418 8.1722222 0.260418 8.1750000 0.259303 8.1777778 0.258188 8.1805556 0.257073 8.1833333 0.257631 8.1861111 0.259303 8.1888889 0.260418 8.1916667 0.260418 8.1944444 0.261533 8.1972222 0.260418 8.2000000 0.262648 8.2027778 0.263206 8.2055556 0.267108 8.2083333 0.268223 8.2111111 0.268223 8.2138889 0.267108 8.2166667 0.269895 8.2194444 0.271010 8.2222222 0.273240 8.2250000 0.272683 8.2277778 0.273240 8.2305556 0.273798 8.2333333 0.275470 8.2361111 0.277143 8.2388889 0.279930 8.2416667 0.278258 8.2444444 0.277143 8.2472222 0.275470 8.2500000 0.277143 8.2527778 0.278258 8.2555556 0.280488 8.2583333 0.278815 8.2611111 0.278815 8.2638889 0.278258 8.2666667 0.277700 8.2694444 0.278258 8.2722222 0.279373 8.2750000 0.279373 8.2777778 0.278815 8.2805556 0.277143 8.2833333 0.277700 8.2861111 0.278815 8.2888889 0.279373 8.2916667 0.278258 8.2944444 0.277700 8.2972222 0.275470 8.3000000 0.274913 8.3027778 0.278258 8.3055556 0.277700 8.3083333 0.277143 8.3111111 0.277143 8.3138889 0.276028 8.3166667 0.276028 8.3194444 0.278815 8.3222222 0.278258 8.3250000 0.278258 8.3277778 0.276585 8.3305556 0.274355 8.3333333 0.275470 8.3361111 0.276585 8.3388889 0.277700 8.3416667 0.277700 8.3444444 0.276585 8.3472222 0.275470 8.3500000 0.274355 8.3527778 0.274355 8.3555556 0.276028 8.3583333 0.275470 8.3611111 0.273240 8.3638889 0.274355 8.3666667 0.274913 8.3694444 0.275470 8.3722222 0.275470 8.3750000 0.274913 8.3777778 0.274355 8.3805556 0.273798 8.3833333 0.273240 8.3861111 0.273798 8.3888889 0.274913 8.3916667 0.274913 8.3944444 0.274913 8.3972222 0.274913 8.4000000 0.273798 8.4027778 0.273798 8.4055556 0.275470 8.4083333 0.273240 8.4111111 0.272683 8.4138889 0.272125 8.4166667 0.272125 8.4194444 0.273240 8.4222222 0.275470 8.4250000 0.274913 8.4277778 0.273240 8.4305556 0.273798 8.4333333 0.272125 8.4361111 0.273798 8.4388889 0.275470 8.4416667 0.273798 8.4444444 0.273798 8.4472222 0.272683 8.4500000 0.274355 8.4527778 0.275470 8.4555556 0.276028 8.4583333 0.273798 8.4611111 0.273240 8.4638889 0.273240 8.4666667 0.273240 8.4694444 0.274355 8.4722222 0.276585 8.4750000 0.274913 8.4777778 0.272683 8.4805556 0.272683 8.4833333 0.273798 8.4861111 0.273798 8.4888889 0.275470 8.4916667 0.274913 8.4944444 0.273240 8.4972222 0.272125 8.5000000 0.271010 8.5027778 0.272683 8.5055556 0.274913 8.5083333 0.274913 8.5111111 0.274355 8.5138889 0.274355 8.5166667 0.274913 8.5194444 0.276028 8.5222222 0.274913 8.5250000 0.276585 8.5277778 0.276028 8.5305556 0.276028 8.5333333 0.274913 8.5361111 0.277143 8.5388889 0.277700 8.5416667 0.278815 8.5444444 0.279373 8.5472222 0.278258 8.5500000 0.276585 8.5527778 0.278815 8.5555556 0.278815 8.5583333 0.279373 8.5611111 0.278815 8.5638889 0.276585 8.5666667 0.275470 8.5694444 0.275470 8.5722222 0.276585 8.5750000 0.275470 8.5777778 0.274355 8.5805556 0.273798 8.5833333 0.273240 8.5861111 0.274913 8.5888889 0.276585 8.5916667 0.273798 8.5944444 0.271568 8.5972222 0.271010 8.6000000 0.271010 8.6027778 0.272683 8.6055556 0.273798 8.6083333 0.272683 8.6111111 0.272683 8.6138889 0.271010 8.6166667 0.270453 8.6194444 0.272125 8.6222222 0.272125 8.6250000 0.271568 8.6277778 0.271010 8.6305556 0.271010 8.6333333 0.271568 8.6361111 0.271568 8.6388889 0.271568 8.6416667 0.271010 8.6444444 0.270453 8.6472222 0.269338 8.6500000 0.269895 8.6527778 0.271010 8.6555556 0.272125 8.6583333 0.268780 8.6611111 0.267108 8.6638889 0.262091 8.6666667 0.260976 8.6694444 0.258746 8.6722222 0.258746 8.6750000 0.255958 8.6777778 0.255401 8.6805556 0.259861 8.6833333 0.268223 8.6861111 0.277143 8.6888889 0.286063 8.6916667 0.291080 8.6944444 0.296098 8.6972222 0.297770 8.7000000 0.303345 8.7027778 0.312265 8.7055556 0.322857 8.7083333 0.331777 8.7111111 0.340697 8.7138889 0.338467 8.7166667 0.317840 8.7194444 0.288293 8.7222222 0.264878 8.7250000 0.255401 8.7277778 0.256516 8.7305556 0.259861 8.7333333 0.262091 8.7361111 0.264878 8.7388889 0.266551 8.7416667 0.265993 8.7444444 0.265436 8.7472222 0.264878 8.7500000 0.263206 8.7527778 0.265993 8.7555556 0.266551 8.7583333 0.266551 8.7611111 0.264321 8.7638889 0.264321 8.7666667 0.264321 8.7694444 0.264321 8.7722222 0.265436 8.7750000 0.265436 8.7777778 0.263763 8.7805556 0.263206 8.7833333 0.265436 8.7861111 0.265993 8.7888889 0.265993 8.7916667 0.265993 8.7944444 0.265436 8.7972222 0.263763 8.8000000 0.263206 8.8027778 0.264878 8.8055556 0.265993 8.8083333 0.265436 8.8111111 0.263763 8.8138889 0.263763 8.8166667 0.263206 8.8194444 0.264878 8.8222222 0.267108 8.8250000 0.267666 8.8277778 0.265993 8.8305556 0.264878 8.8333333 0.264321 8.8361111 0.264321 8.8388889 0.266551 8.8416667 0.266551 8.8444444 0.265436 8.8472222 0.264878 8.8500000 0.265436 8.8527778 0.265436 8.8555556 0.265993 8.8583333 0.263763 8.8611111 0.263763 8.8638889 0.264321 8.8666667 0.264321 8.8694444 0.263763 8.8722222 0.264321 8.8750000 0.263763 8.8777778 0.261533 8.8805556 0.261533 8.8833333 0.262091 8.8861111 0.263763 8.8888889 0.264321 8.8916667 0.262648 8.8944444 0.261533 8.8972222 0.260418 8.9000000 0.259861 8.9027778 0.262091 8.9055556 0.262091 8.9083333 0.262091 8.9111111 0.260976 8.9138889 0.260418 8.9166667 0.259861 8.9194444 0.259303 8.9222222 0.259303 8.9250000 0.258188 8.9277778 0.257073 8.9305556 0.256516 8.9333333 0.256516 8.9361111 0.256516 8.9388889 0.258188 8.9416667 0.257073 8.9444444 0.254286 8.9472222 0.253728 8.9500000 0.252613 8.9527778 0.254286 8.9555556 0.255401 8.9583333 0.253728 8.9611111 0.253171 8.9638889 0.252613 8.9666667 0.252056 8.9694444 0.250941 8.9722222 0.250941 8.9750000 0.250941 8.9777778 0.249826 8.9805556 0.250941 8.9833333 0.251498 8.9861111 0.250941 8.9888889 0.252056 8.9916667 0.250383 8.9944444 0.250941 8.9972222 0.252613 9.0000000 0.252613 9.0027778 0.255401 9.0055556 0.255958 9.0083333 0.255958 9.0111111 0.255958 9.0138889 0.257631 9.0166667 0.259303 9.0194444 0.260976 9.0222222 0.262648 9.0250000 0.263206 9.0277778 0.265436 9.0305556 0.264878 9.0333333 0.264878 9.0361111 0.267108 9.0388889 0.267666 9.0416667 0.267108 9.0444444 0.266551 9.0472222 0.267108 9.0500000 0.267108 9.0527778 0.267666 9.0555556 0.269338 9.0583333 0.268223 9.0611111 0.268780 9.0638889 0.267108 9.0666667 0.265993 9.0694444 0.268223 9.0722222 0.268780 9.0750000 0.267666 9.0777778 0.266551 9.0805556 0.265993 9.0833333 0.265436 9.0861111 0.267666 9.0888889 0.268223 9.0916667 0.265993 9.0944444 0.265436 9.0972222 0.265993 9.1000000 0.266551 9.1027778 0.267666 9.1055556 0.267666 9.1083333 0.264878 9.1111111 0.264321 9.1138889 0.263763 9.1166667 0.264878 9.1194444 0.265993 9.1222222 0.267108 9.1250000 0.267666 9.1277778 0.265993 9.1305556 0.264321 9.1333333 0.264321 9.1361111 0.265436 9.1388889 0.265436 9.1416667 0.265993 9.1444444 0.264878 9.1472222 0.262648 9.1500000 0.264321 9.1527778 0.265436 9.1555556 0.264878 9.1583333 0.264321 9.1611111 0.262091 9.1638889 0.261533 9.1666667 0.262091 9.1694444 0.264321 9.1722222 0.264878 9.1750000 0.264321 9.1777778 0.264321 9.1805556 0.262648 9.1833333 0.262648 9.1861111 0.263763 9.1888889 0.264321 9.1916667 0.262091 9.1944444 0.261533 9.1972222 0.259861 9.2000000 0.260976 9.2027778 0.261533 9.2055556 0.264321 9.2083333 0.264321 9.2111111 0.263206 9.2138889 0.264321 9.2166667 0.262648 9.2194444 0.263206 9.2222222 0.263206 9.2250000 0.264321 9.2277778 0.263763 9.2305556 0.263206 9.2333333 0.262648 9.2361111 0.263763 9.2388889 0.264878 9.2416667 0.263206 9.2444444 0.262648 9.2472222 0.262091 9.2500000 0.262091 9.2527778 0.262648 9.2555556 0.263763 9.2583333 0.263206 9.2611111 0.262648 9.2638889 0.261533 9.2666667 0.261533 9.2694444 0.260418 9.2722222 0.263763 9.2750000 0.261533 9.2777778 0.260976 9.2805556 0.260976 9.2833333 0.261533 9.2861111 0.263763 9.2888889 0.262091 9.2916667 0.260976 9.2944444 0.260418 9.2972222 0.259303 9.3000000 0.260418 9.3027778 0.263763 9.3055556 0.265993 9.3083333 0.264321 9.3111111 0.263763 9.3138889 0.262648 9.3166667 0.262648 9.3194444 0.263763 9.3222222 0.265993 9.3250000 0.265436 9.3277778 0.265436 9.3305556 0.265436 9.3333333 0.265436 9.3361111 0.268223 9.3388889 0.269338 9.3416667 0.268223 9.3444444 0.267666 9.3472222 0.266551 9.3500000 0.267666 9.3527778 0.268223 9.3555556 0.268223 9.3583333 0.266551 9.3611111 0.266551 9.3638889 0.264321 9.3666667 0.263206 9.3694444 0.264878 9.3722222 0.265993 9.3750000 0.264321 9.3777778 0.263763 9.3805556 0.262648 9.3833333 0.262648 9.3861111 0.262091 9.3888889 0.262648 9.3916667 0.263763 9.3944444 0.261533 9.3972222 0.261533 9.4000000 0.262091 9.4027778 0.260418 9.4055556 0.263206 9.4083333 0.262091 9.4111111 0.261533 9.4138889 0.260418 9.4166667 0.260418 9.4194444 0.262648 9.4222222 0.263206 9.4250000 0.262091 9.4277778 0.261533 9.4305556 0.259861 9.4333333 0.259303 9.4361111 0.260418 9.4388889 0.262648 9.4416667 0.262648 9.4444444 0.261533 9.4472222 0.262091 9.4500000 0.259303 9.4527778 0.259861 9.4555556 0.257631 9.4583333 0.256516 9.4611111 0.254286 9.4638889 0.254286 9.4666667 0.254286 9.4694444 0.254843 9.4722222 0.254286 9.4750000 0.250383 9.4777778 0.247038 9.4805556 0.247038 9.4833333 0.251498 9.4861111 0.262648 9.4888889 0.273240 9.4916667 0.281603 9.4944444 0.288850 9.4972222 0.294425 9.5000000 0.301115 9.5027778 0.314495 9.5055556 0.326202 9.5083333 0.334564 9.5111111 0.330662 9.5138889 0.308920 9.5166667 0.276028 9.5194444 0.253728 9.5222222 0.248153 9.5250000 0.249826 9.5277778 0.252613 9.5305556 0.254286 9.5333333 0.255958 9.5361111 0.257631 9.5388889 0.260418 9.5416667 0.260418 9.5444444 0.259303 9.5472222 0.258746 9.5500000 0.258188 9.5527778 0.259303 9.5555556 0.260418 9.5583333 0.259861 9.5611111 0.259861 9.5638889 0.258188 9.5666667 0.258188 9.5694444 0.260976 9.5722222 0.261533 9.5750000 0.261533 9.5777778 0.259303 9.5805556 0.258746 9.5833333 0.259303 9.5861111 0.260418 9.5888889 0.259861 9.5916667 0.260976 9.5944444 0.259303 9.5972222 0.259861 9.6000000 0.259861 9.6027778 0.259861 9.6055556 0.261533 9.6083333 0.260976 9.6111111 0.260976 9.6138889 0.261533 9.6166667 0.260976 9.6194444 0.262648 9.6222222 0.262648 9.6250000 0.262091 9.6277778 0.261533 9.6305556 0.259861 9.6333333 0.259861 9.6361111 0.262091 9.6388889 0.263763 9.6416667 0.262648 9.6444444 0.262648 9.6472222 0.261533 9.6500000 0.262091 9.6527778 0.262648 9.6555556 0.263206 9.6583333 0.262648 9.6611111 0.261533 9.6638889 0.261533 9.6666667 0.262091 9.6694444 0.262648 9.6722222 0.263206 9.6750000 0.262648 9.6777778 0.262648 9.6805556 0.260976 9.6833333 0.262091 9.6861111 0.263206 9.6888889 0.264321 9.6916667 0.263206 9.6944444 0.262091 9.6972222 0.260976 9.7000000 0.260976 9.7027778 0.262648 9.7055556 0.263206 9.7083333 0.262091 9.7111111 0.261533 9.7138889 0.260418 9.7166667 0.259861 9.7194444 0.260976 9.7222222 0.261533 9.7250000 0.260418 9.7277778 0.258746 9.7305556 0.257631 9.7333333 0.257073 9.7361111 0.257073 9.7388889 0.257073 9.7416667 0.255958 9.7444444 0.254843 9.7472222 0.254286 9.7500000 0.253171 9.7527778 0.253728 9.7555556 0.254843 9.7583333 0.253728 9.7611111 0.252613 9.7638889 0.250383 9.7666667 0.250383 9.7694444 0.250383 9.7722222 0.252056 9.7750000 0.250941 9.7777778 0.250941 9.7805556 0.248711 9.7833333 0.250941 9.7861111 0.252613 9.7888889 0.253171 9.7916667 0.252613 9.7944444 0.251498 9.7972222 0.251498 9.8000000 0.252613 9.8027778 0.255401 9.8055556 0.258746 9.8083333 0.258746 9.8111111 0.259303 9.8138889 0.259861 9.8166667 0.262091 9.8194444 0.263206 9.8222222 0.265993 9.8250000 0.267666 9.8277778 0.267666 9.8305556 0.267666 9.8333333 0.268223 9.8361111 0.270453 9.8388889 0.271568 9.8416667 0.271010 9.8444444 0.269895 9.8472222 0.271010 9.8500000 0.271568 9.8527778 0.272125 9.8555556 0.273240 9.8583333 0.272125 9.8611111 0.272125 9.8638889 0.271568 9.8666667 0.272125 9.8694444 0.272683 9.8722222 0.274355 9.8750000 0.273240 9.8777778 0.272125 9.8805556 0.270453 9.8833333 0.271568 9.8861111 0.272683 9.8888889 0.273798 9.8916667 0.272683 9.8944444 0.272125 9.8972222 0.271010 9.9000000 0.271010 9.9027778 0.272125 9.9055556 0.272683 9.9083333 0.273240 9.9111111 0.270453 9.9138889 0.270453 9.9166667 0.271010 9.9194444 0.271010 9.9222222 0.272125 9.9250000 0.271568 9.9277778 0.271010 9.9305556 0.270453 9.9333333 0.269338 9.9361111 0.269895 9.9388889 0.272125 9.9416667 0.271568 9.9444444 0.270453 9.9472222 0.269895 9.9500000 0.269338 9.9527778 0.270453 9.9555556 0.272125 9.9583333 0.271568 9.9611111 0.270453 9.9638889 0.269895 9.9666667 0.268780 9.9694444 0.269895 9.9722222 0.271010 9.9750000 0.270453 9.9777778 0.267666 9.9805556 0.268780 9.9833333 0.268223 9.9861111 0.268780 9.9888889 0.270453 9.9916667 0.269338 9.9944444 0.268223 9.9972222 0.267108 10.0000000 0.268223 10.0027778 0.268223 10.0055556 0.270453 10.0083333 0.269895 10.0111111 0.268223 10.0138889 0.268780 10.0166667 0.267666 10.0194444 0.269338 10.0222222 0.270453 10.0250000 0.269895 10.0277778 0.268780 10.0305556 0.268223 10.0333333 0.268223 10.0361111 0.270453 10.0388889 0.271010 10.0416667 0.269895 10.0444444 0.268223 10.0472222 0.268223 10.0500000 0.268223 10.0527778 0.269338 10.0555556 0.270453 10.0583333 0.268780 10.0611111 0.269895 10.0638889 0.269338 10.0666667 0.268223 10.0694444 0.269895 10.0722222 0.270453 10.0750000 0.270453 10.0777778 0.270453 10.0805556 0.268780 10.0833333 0.269338 10.0861111 0.269895 10.0888889 0.272125 10.0916667 0.270453 10.0944444 0.270453 10.0972222 0.269338 10.1000000 0.269338 10.1027778 0.269895 10.1055556 0.272125 10.1083333 0.272125 10.1111111 0.269895 10.1138889 0.269338 10.1166667 0.268223 10.1194444 0.269895 10.1222222 0.271568 10.1250000 0.269338 10.1277778 0.269338 10.1305556 0.269338 10.1333333 0.270453 10.1361111 0.271568 10.1388889 0.273240 10.1416667 0.272683 10.1444444 0.272683 10.1472222 0.272683 10.1500000 0.272683 10.1527778 0.273798 10.1555556 0.274355 10.1583333 0.276028 10.1611111 0.275470 10.1638889 0.273798 10.1666667 0.276028 10.1694444 0.276028 10.1722222 0.278815 10.1750000 0.277143 10.1777778 0.277143 10.1805556 0.276028 10.1833333 0.277143 10.1861111 0.276028 10.1888889 0.277143 10.1916667 0.274913 10.1944444 0.272683 10.1972222 0.272683 10.2000000 0.273798 10.2027778 0.272683 10.2055556 0.275470 10.2083333 0.273240 10.2111111 0.271010 10.2138889 0.271010 10.2166667 0.271568 10.2194444 0.271010 10.2222222 0.272125 10.2250000 0.271568 10.2277778 0.271010 10.2305556 0.269895 10.2333333 0.269338 10.2361111 0.269895 10.2388889 0.271010 10.2416667 0.271568 10.2444444 0.270453 10.2472222 0.269895 10.2500000 0.268780 10.2527778 0.270453 10.2555556 0.271568 10.2583333 0.271568 10.2611111 0.268780 10.2638889 0.268223 10.2666667 0.268223 10.2694444 0.270453 10.2722222 0.271568 10.2750000 0.271568 10.2777778 0.272125 10.2805556 0.269338 10.2833333 0.268780 10.2861111 0.267666 10.2888889 0.264878 10.2916667 0.261533 10.2944444 0.258188 10.2972222 0.255958 10.3000000 0.254286 10.3027778 0.260976 10.3055556 0.272683 10.3083333 0.286063 10.3111111 0.297770 10.3138889 0.307805 10.3166667 0.320627 10.3194444 0.334564 10.3222222 0.350732 10.3250000 0.361324 10.3277778 0.367456 10.3305556 0.360209 10.3333333 0.330662 10.3361111 0.295540 10.3388889 0.272683 10.3416667 0.265993 10.3444444 0.268223 10.3472222 0.268223 10.3500000 0.267108 10.3527778 0.269338 10.3555556 0.269338 10.3583333 0.268780 10.3611111 0.266551 10.3638889 0.265436 10.3666667 0.265993 10.3694444 0.267108 10.3722222 0.267108 10.3750000 0.267666 10.3777778 0.266551 10.3805556 0.264878 10.3833333 0.264878 10.3861111 0.265436 10.3888889 0.266551 10.3916667 0.265993 10.3944444 0.265993 10.3972222 0.264321 10.4000000 0.264878 10.4027778 0.265993 10.4055556 0.268223 10.4083333 0.266551 10.4111111 0.265993 10.4138889 0.264878 10.4166667 0.264321 10.4194444 0.265436 10.4222222 0.266551 10.4250000 0.266551 10.4277778 0.266551 10.4305556 0.265993 10.4333333 0.264878 10.4361111 0.264878 10.4388889 0.267108 10.4416667 0.266551 10.4444444 0.265993 10.4472222 0.265436 10.4500000 0.265436 10.4527778 0.268223 10.4555556 0.267666 10.4583333 0.266551 10.4611111 0.266551 10.4638889 0.264878 10.4666667 0.267666 10.4694444 0.268223 10.4722222 0.267108 10.4750000 0.269338 10.4777778 0.267108 10.4805556 0.265993 10.4833333 0.264321 10.4861111 0.265993 10.4888889 0.267108 10.4916667 0.267666 10.4944444 0.265993 10.4972222 0.264878 10.5000000 0.264321 10.5027778 0.265993 10.5055556 0.265436 10.5083333 0.265436 10.5111111 0.264321 10.5138889 0.263206 10.5166667 0.264878 10.5194444 0.264878 10.5222222 0.266551 10.5250000 0.265436 10.5277778 0.263763 10.5305556 0.260976 10.5333333 0.262091 10.5361111 0.262091 10.5388889 0.263206 10.5416667 0.263206 10.5444444 0.262091 10.5472222 0.260418 10.5500000 0.259861 10.5527778 0.260418 10.5555556 0.260418 10.5583333 0.260976 10.5611111 0.257631 10.5638889 0.257631 10.5666667 0.256516 10.5694444 0.257073 10.5722222 0.257631 10.5750000 0.255958 10.5777778 0.254843 10.5805556 0.253171 10.5833333 0.252613 10.5861111 0.253171 10.5888889 0.254843 10.5916667 0.253728 10.5944444 0.253171 10.5972222 0.250383 10.6000000 0.250941 10.6027778 0.251498 10.6055556 0.253171 10.6083333 0.253171 10.6111111 0.253171 10.6138889 0.251498 10.6166667 0.253171 10.6194444 0.254843 10.6222222 0.255401 10.6250000 0.255958 10.6277778 0.257073 10.6305556 0.257631 10.6333333 0.258188 10.6361111 0.261533 10.6388889 0.264878 10.6416667 0.265436 10.6444444 0.265436 10.6472222 0.264321 10.6500000 0.266551 10.6527778 0.268780 10.6555556 0.270453 10.6583333 0.271568 10.6611111 0.270453 10.6638889 0.270453 10.6666667 0.269895 10.6694444 0.272125 10.6722222 0.273798 10.6750000 0.273798 10.6777778 0.272125 10.6805556 0.272125 10.6833333 0.272683 10.6861111 0.273240 10.6888889 0.275470 10.6916667 0.273798 10.6944444 0.272683 10.6972222 0.272125 10.7000000 0.271568 10.7027778 0.273240 10.7055556 0.274355 10.7083333 0.273798 10.7111111 0.273240 10.7138889 0.273240 10.7166667 0.272125 10.7194444 0.273798 10.7222222 0.273798 10.7250000 0.273240 10.7277778 0.272683 10.7305556 0.272683 10.7333333 0.271568 10.7361111 0.272683 10.7388889 0.273798 10.7416667 0.273798 10.7444444 0.272683 10.7472222 0.271010 10.7500000 0.271010 10.7527778 0.271568 10.7555556 0.273240 10.7583333 0.272683 10.7611111 0.271568 10.7638889 0.269338 10.7666667 0.270453 10.7694444 0.270453 10.7722222 0.271568 10.7750000 0.271010 10.7777778 0.270453 10.7805556 0.269895 10.7833333 0.271010 10.7861111 0.269895 10.7888889 0.270453 10.7916667 0.270453 10.7944444 0.269895 10.7972222 0.269338 10.8000000 0.269895 10.8027778 0.271568 10.8055556 0.270453 10.8083333 0.268780 10.8111111 0.268780 10.8138889 0.267666 10.8166667 0.267108 10.8194444 0.268780 10.8222222 0.269895 10.8250000 0.270453 10.8277778 0.267666 10.8305556 0.266551 10.8333333 0.264878 10.8361111 0.268223 10.8388889 0.268223 10.8416667 0.268223 10.8444444 0.269338 10.8472222 0.267666 10.8500000 0.267666 10.8527778 0.267666 10.8555556 0.268780 10.8583333 0.268780 10.8611111 0.267666 10.8638889 0.267108 10.8666667 0.268223 10.8694444 0.268780 10.8722222 0.271010 10.8750000 0.270453 10.8777778 0.268780 10.8805556 0.267666 10.8833333 0.267108 10.8861111 0.269895 10.8888889 0.271010 10.8916667 0.271010 10.8944444 0.269338 10.8972222 0.268780 10.9000000 0.268223 10.9027778 0.269895 10.9055556 0.271010 10.9083333 0.270453 10.9111111 0.269338 10.9138889 0.269338 10.9166667 0.269895 10.9194444 0.270453 10.9222222 0.271010 10.9250000 0.269895 10.9277778 0.268780 10.9305556 0.268780 10.9333333 0.269895 10.9361111 0.269338 10.9388889 0.273240 10.9416667 0.270453 10.9444444 0.271568 10.9472222 0.271010 10.9500000 0.271010 10.9527778 0.271568 10.9555556 0.273240 10.9583333 0.274355 10.9611111 0.274355 10.9638889 0.273240 10.9666667 0.272683 10.9694444 0.273798 10.9722222 0.274913 10.9750000 0.273798 10.9777778 0.272125 10.9805556 0.273798 10.9833333 0.275470 10.9861111 0.277143 10.9888889 0.277143 10.9916667 0.276585 10.9944444 0.275470 10.9972222 0.274355 11.0000000 0.275470 11.0027778 0.276028 11.0055556 0.276585 11.0083333 0.274913 11.0111111 0.273798 11.0138889 0.272683 11.0166667 0.272125 11.0194444 0.273798 11.0222222 0.274913 11.0250000 0.273240 11.0277778 0.273240 11.0305556 0.271568 11.0333333 0.270453 11.0361111 0.271010 11.0388889 0.272683 11.0416667 0.271568 11.0444444 0.269895 11.0472222 0.268780 11.0500000 0.269338 11.0527778 0.269895 11.0555556 0.270453 11.0583333 0.271010 11.0611111 0.269895 11.0638889 0.269338 11.0666667 0.268223 11.0694444 0.268780 11.0722222 0.269895 11.0750000 0.269895 11.0777778 0.268780 11.0805556 0.269338 11.0833333 0.269338 11.0861111 0.269895 11.0888889 0.270453 11.0916667 0.269895 11.0944444 0.269338 11.0972222 0.266551 11.1000000 0.264878 11.1027778 0.263206 11.1055556 0.262648 11.1083333 0.260976 11.1111111 0.256516 11.1138889 0.253171 11.1166667 0.250383 11.1194444 0.253728 11.1222222 0.263763 11.1250000 0.275470 11.1277778 0.288293 11.1305556 0.300000 11.1333333 0.309477 11.1361111 0.321742 11.1388889 0.336237 11.1416667 0.348502 11.1444444 0.358537 11.1472222 0.359652 11.1500000 0.346272 11.1527778 0.313380 11.1555556 0.281603 11.1583333 0.264321 11.1611111 0.261533 11.1638889 0.264321 11.1666667 0.265993 11.1694444 0.265436 11.1722222 0.268780 11.1750000 0.268223 11.1777778 0.267108 11.1805556 0.264878 11.1833333 0.263206 11.1861111 0.264321 11.1888889 0.265993 11.1916667 0.265993 11.1944444 0.265436 11.1972222 0.264321 11.2000000 0.264321 11.2027778 0.264878 11.2055556 0.266551 11.2083333 0.265436 11.2111111 0.264321 11.2138889 0.263763 11.2166667 0.264878 11.2194444 0.264321 11.2222222 0.266551 11.2250000 0.267108 11.2277778 0.266551 11.2305556 0.263763 11.2333333 0.263763 11.2361111 0.264321 11.2388889 0.267108 11.2416667 0.264878 11.2444444 0.265436 11.2472222 0.264321 11.2500000 0.264321 11.2527778 0.265436 11.2555556 0.266551 11.2583333 0.266551 11.2611111 0.265993 11.2638889 0.265993 11.2666667 0.264878 11.2694444 0.265993 11.2722222 0.265993 11.2750000 0.266551 11.2777778 0.267108 11.2805556 0.267108 11.2833333 0.267108 11.2861111 0.267108 11.2888889 0.267666 11.2916667 0.265993 11.2944444 0.264878 11.2972222 0.264878 11.3000000 0.264321 11.3027778 0.267108 11.3055556 0.268223 11.3083333 0.267666 11.3111111 0.267108 11.3138889 0.264878 11.3166667 0.265436 11.3194444 0.267108 11.3222222 0.267108 11.3250000 0.266551 11.3277778 0.267108 11.3305556 0.265993 11.3333333 0.265436 11.3361111 0.266551 11.3388889 0.267108 11.3416667 0.264878 11.3444444 0.264321 11.3472222 0.264321 11.3500000 0.264321 11.3527778 0.263763 11.3555556 0.264321 11.3583333 0.263206 11.3611111 0.262648 11.3638889 0.259861 11.3666667 0.260976 11.3694444 0.260976 11.3722222 0.262091 11.3750000 0.261533 11.3777778 0.259861 11.3805556 0.258188 11.3833333 0.257073 11.3861111 0.258188 11.3888889 0.258746 11.3916667 0.258746 11.3944444 0.257073 11.3972222 0.255958 11.4000000 0.254843 11.4027778 0.255958 11.4055556 0.255958 11.4083333 0.254286 11.4111111 0.253171 11.4138889 0.252613 11.4166667 0.253728 11.4194444 0.253171 11.4222222 0.255401 11.4250000 0.254843 11.4277778 0.254843 11.4305556 0.253728 11.4333333 0.252056 11.4361111 0.253171 11.4388889 0.255401 11.4416667 0.255401 11.4444444 0.256516 11.4472222 0.257073 11.4500000 0.257631 11.4527778 0.259861 11.4555556 0.262648 11.4583333 0.262648 11.4611111 0.264878 11.4638889 0.264878 11.4666667 0.264878 11.4694444 0.268780 11.4722222 0.271010 11.4750000 0.270453 11.4777778 0.272125 11.4805556 0.269338 11.4833333 0.269895 11.4861111 0.272125 11.4888889 0.273798 11.4916667 0.273798 11.4944444 0.274913 11.4972222 0.273240 11.5000000 0.272683 11.5027778 0.273240 11.5055556 0.274913 11.5083333 0.274913 11.5111111 0.275470 11.5138889 0.275470 11.5166667 0.274355 11.5194444 0.274355 11.5222222 0.276028 11.5250000 0.274913 11.5277778 0.274913 11.5305556 0.273240 11.5333333 0.273798 11.5361111 0.274355 11.5388889 0.274913 11.5416667 0.273798 11.5444444 0.273798 11.5472222 0.273240 11.5500000 0.272683 11.5527778 0.273798 11.5555556 0.274913 11.5583333 0.272683 11.5611111 0.273798 11.5638889 0.273240 11.5666667 0.271568 11.5694444 0.270453 11.5722222 0.273240 11.5750000 0.272683 11.5777778 0.272125 11.5805556 0.271568 11.5833333 0.269895 11.5861111 0.271010 11.5888889 0.271568 11.5916667 0.271010 11.5944444 0.272125 11.5972222 0.269895 11.6000000 0.268780 11.6027778 0.272125 11.6055556 0.272125 11.6083333 0.272125 11.6111111 0.271568 11.6138889 0.269338 11.6166667 0.270453 11.6194444 0.270453 11.6222222 0.272125 11.6250000 0.271568 11.6277778 0.271010 11.6305556 0.269895 11.6333333 0.269895 11.6361111 0.269895 11.6388889 0.270453 11.6416667 0.269895 11.6444444 0.267666 11.6472222 0.267108 11.6500000 0.268780 11.6527778 0.268223 11.6555556 0.269895 11.6583333 0.269895 11.6611111 0.268780 11.6638889 0.267666 11.6666667 0.267666 11.6694444 0.268780 11.6722222 0.270453 11.6750000 0.271010 11.6777778 0.269895 11.6805556 0.268780 11.6833333 0.268223 11.6861111 0.268780 11.6888889 0.269338 11.6916667 0.269895 11.6944444 0.269338 11.6972222 0.267666 11.7000000 0.269338 11.7027778 0.269338 11.7055556 0.270453 11.7083333 0.269338 11.7111111 0.269338 11.7138889 0.267108 11.7166667 0.268223 11.7194444 0.270453 11.7222222 0.271010 11.7250000 0.271010 11.7277778 0.269895 11.7305556 0.268780 11.7333333 0.267108 11.7361111 0.269338 11.7388889 0.269895 11.7416667 0.269338 11.7444444 0.268780 11.7472222 0.269895 11.7500000 0.269338 11.7527778 0.270453 11.7555556 0.272683 11.7583333 0.271568 11.7611111 0.271568 11.7638889 0.270453 11.7666667 0.271010 11.7694444 0.272683 11.7722222 0.273798 11.7750000 0.273240 11.7777778 0.272125 11.7805556 0.271568 11.7833333 0.272125 11.7861111 0.274355 11.7888889 0.277143 11.7916667 0.276028 11.7944444 0.275470 11.7972222 0.273798 11.8000000 0.274355 11.8027778 0.274355 11.8055556 0.276028 11.8083333 0.274913 11.8111111 0.273240 11.8138889 0.271010 11.8166667 0.271568 11.8194444 0.270453 11.8222222 0.272683 11.8250000 0.271568 11.8277778 0.271010 11.8305556 0.269338 11.8333333 0.269895 11.8361111 0.271568 11.8388889 0.271568 11.8416667 0.269895 11.8444444 0.268223 11.8472222 0.267108 11.8500000 0.267108 11.8527778 0.269338 11.8555556 0.269895 11.8583333 0.270453 11.8611111 0.270453 11.8638889 0.267108 11.8666667 0.267108 11.8694444 0.268780 11.8722222 0.268223 11.8750000 0.268780 11.8777778 0.268780 11.8805556 0.268780 11.8833333 0.267108 11.8861111 0.268780 11.8888889 0.270453 11.8916667 0.268223 11.8944444 0.269338 11.8972222 0.267666 11.9000000 0.267666 11.9027778 0.268780 11.9055556 0.269338 11.9083333 0.267666 11.9111111 0.265993 11.9138889 0.261533 11.9166667 0.259303 11.9194444 0.257073 11.9222222 0.255401 11.9250000 0.254286 11.9277778 0.258188 11.9305556 0.267666 11.9333333 0.279373 11.9361111 0.291080 11.9388889 0.298885 11.9416667 0.307805 11.9444444 0.318397 11.9472222 0.328990 11.9500000 0.340139 11.9527778 0.339582 11.9555556 0.322857 11.9583333 0.288850 11.9611111 0.261533 11.9638889 0.250383 11.9666667 0.253171 11.9694444 0.259861 11.9722222 0.262091 11.9750000 0.264321 11.9777778 0.264878 11.9805556 0.264321 11.9833333 0.263763 11.9861111 0.264321 11.9888889 0.265993 11.9916667 0.264878 11.9944444 0.263763 11.9972222 0.263206 12.0000000 0.263763 12.0027778 0.264878 12.0055556 0.265436 12.0083333 0.263206 12.0111111 0.263763 12.0138889 0.262648 12.0166667 0.264321 12.0194444 0.263763 12.0222222 0.264878 12.0250000 0.263763 12.0277778 0.263206 12.0305556 0.263763 12.0333333 0.263206 12.0361111 0.264878 12.0388889 0.263763 12.0416667 0.264878 12.0444444 0.264878 12.0472222 0.263763 12.0500000 0.264321 12.0527778 0.264878 12.0555556 0.264878 12.0583333 0.264321 12.0611111 0.263763 12.0638889 0.263206 12.0666667 0.263206 12.0694444 0.264321 12.0722222 0.264878 12.0750000 0.265436 12.0777778 0.263206 12.0805556 0.262648 12.0833333 0.261533 12.0861111 0.262091 12.0888889 0.264321 12.0916667 0.264321 12.0944444 0.263206 12.0972222 0.261533 12.1000000 0.261533 12.1027778 0.262091 12.1055556 0.263206 12.1083333 0.263206 12.1111111 0.262648 12.1138889 0.260976 12.1166667 0.262091 12.1194444 0.263206 12.1222222 0.263763 12.1250000 0.263763 12.1277778 0.260976 12.1305556 0.260418 12.1333333 0.259861 12.1361111 0.259861 12.1388889 0.263206 12.1416667 0.262648 12.1444444 0.260976 12.1472222 0.259303 12.1500000 0.260418 12.1527778 0.260418 12.1555556 0.261533 12.1583333 0.260418 12.1611111 0.259861 12.1638889 0.258746 12.1666667 0.257631 12.1694444 0.257631 12.1722222 0.256516 12.1750000 0.257631 12.1777778 0.257073 12.1805556 0.256516 12.1833333 0.254286 12.1861111 0.255958 12.1888889 0.256516 12.1916667 0.255401 12.1944444 0.252613 12.1972222 0.249826 12.2000000 0.248711 12.2027778 0.249826 12.2055556 0.252613 12.2083333 0.250941 12.2111111 0.248711 12.2138889 0.249268 12.2166667 0.248711 12.2194444 0.248153 12.2222222 0.249826 12.2250000 0.250941 12.2277778 0.250941 12.2305556 0.249826 12.2333333 0.249268 12.2361111 0.249826 12.2388889 0.253171 12.2416667 0.253728 12.2444444 0.253171 12.2472222 0.254843 12.2500000 0.254843 12.2527778 0.256516 12.2555556 0.259861 12.2583333 0.260976 12.2611111 0.262091 12.2638889 0.262091 12.2666667 0.263206 12.2694444 0.263206 12.2722222 0.266551 12.2750000 0.265436 12.2777778 0.265993 12.2805556 0.264878 12.2833333 0.263763 12.2861111 0.265993 12.2888889 0.267666 12.2916667 0.266551 12.2944444 0.267108 12.2972222 0.265436 12.3000000 0.265436 12.3027778 0.267108 12.3055556 0.268223 12.3083333 0.267108 12.3111111 0.266551 12.3138889 0.266551 12.3166667 0.267108 12.3194444 0.267108 12.3222222 0.267666 12.3250000 0.268223 12.3277778 0.267108 12.3305556 0.264878 12.3333333 0.264321 12.3361111 0.265436 12.3388889 0.266551 12.3416667 0.267666 12.3444444 0.267108 12.3472222 0.266551 12.3500000 0.265993 12.3527778 0.264878 12.3555556 0.268223 12.3583333 0.265993 12.3611111 0.265993 12.3638889 0.264878 12.3666667 0.264878 12.3694444 0.267108 12.3722222 0.267108 12.3750000 0.266551 12.3777778 0.265993 12.3805556 0.265436 12.3833333 0.263206 12.3861111 0.263206 12.3888889 0.265436 12.3916667 0.264321 12.3944444 0.263763 12.3972222 0.263206 12.4000000 0.262648 12.4027778 0.263763 12.4055556 0.265436 12.4083333 0.263206 12.4111111 0.263206 12.4138889 0.261533 12.4166667 0.262648 12.4194444 0.262091 12.4222222 0.262648 12.4250000 0.261533 12.4277778 0.262091 12.4305556 0.260976 12.4333333 0.262091 12.4361111 0.263206 12.4388889 0.263763 12.4416667 0.263206 12.4444444 0.260976 12.4472222 0.261533 12.4500000 0.261533 12.4527778 0.262091 12.4555556 0.263206 12.4583333 0.263206 12.4611111 0.262648 12.4638889 0.261533 12.4666667 0.262091 12.4694444 0.262648 12.4722222 0.263763 12.4750000 0.263763 12.4777778 0.262091 12.4805556 0.261533 12.4833333 0.262648 12.4861111 0.264878 12.4888889 0.264321 12.4916667 0.263763 12.4944444 0.262648 12.4972222 0.262091 12.5000000 0.261533 12.5027778 0.262091 12.5055556 0.263763 12.5083333 0.262648 12.5111111 0.261533 12.5138889 0.261533 12.5166667 0.261533 12.5194444 0.263763 12.5222222 0.263206 12.5250000 0.262648 12.5277778 0.262648 12.5305556 0.260976 12.5333333 0.260418 12.5361111 0.262648 12.5388889 0.264321 12.5416667 0.264878 12.5444444 0.264321 12.5472222 0.263763 12.5500000 0.263763 12.5527778 0.265436 12.5555556 0.267108 12.5583333 0.267108 12.5611111 0.265993 12.5638889 0.267108 12.5666667 0.267666 12.5694444 0.267666 12.5722222 0.268780 12.5750000 0.267666 12.5777778 0.268223 12.5805556 0.267108 12.5833333 0.268223 12.5861111 0.267108 12.5888889 0.268780 12.5916667 0.267108 12.5944444 0.265993 12.5972222 0.264878 12.6000000 0.263206 12.6027778 0.265436 12.6055556 0.265993 12.6083333 0.265993 12.6111111 0.265436 12.6138889 0.263206 12.6166667 0.261533 12.6194444 0.264321 12.6222222 0.264321 12.6250000 0.264321 12.6277778 0.262648 12.6305556 0.262648 12.6333333 0.262648 12.6361111 0.263206 12.6388889 0.263763 12.6416667 0.263206 12.6444444 0.263763 12.6472222 0.261533 12.6500000 0.262648 12.6527778 0.263763 12.6555556 0.264878 12.6583333 0.264321 12.6611111 0.263763 12.6638889 0.262091 12.6666667 0.262091 12.6694444 0.262091 12.6722222 0.264321 12.6750000 0.264321 12.6777778 0.263206 12.6805556 0.262648 12.6833333 0.262091 12.6861111 0.260418 12.6888889 0.258746 12.6916667 0.258188 12.6944444 0.254843 12.6972222 0.253171 12.7000000 0.254843 12.7027778 0.263206 12.7055556 0.274913 12.7083333 0.282718 12.7111111 0.291080 12.7138889 0.297770 12.7166667 0.305575 12.7194444 0.316725 12.7222222 0.327317 12.7250000 0.332334 12.7277778 0.325087 12.7305556 0.299443 12.7333333 0.273798 12.7361111 0.258746 12.7388889 0.256516 12.7416667 0.260418 12.7444444 0.260976 12.7472222 0.260418 12.7500000 0.260976 12.7527778 0.262091 12.7555556 0.263206 12.7583333 0.262648 12.7611111 0.263206 12.7638889 0.261533 12.7666667 0.261533 12.7694444 0.261533 12.7722222 0.264321 12.7750000 0.263763 12.7777778 0.264321 12.7805556 0.263206 12.7833333 0.263206 12.7861111 0.263206 12.7888889 0.264321 12.7916667 0.264321 12.7944444 0.263206 12.7972222 0.263206 12.8000000 0.261533 12.8027778 0.264878 12.8055556 0.265993 12.8083333 0.264878 12.8111111 0.264321 12.8138889 0.264321 12.8166667 0.263206 12.8194444 0.264878 12.8222222 0.265436 12.8250000 0.265436 12.8277778 0.264878 12.8305556 0.264321 12.8333333 0.263206 12.8361111 0.264321 12.8388889 0.265993 12.8416667 0.265436 12.8444444 0.266551 12.8472222 0.264878 12.8500000 0.264878 12.8527778 0.265993 12.8555556 0.265993 12.8583333 0.267108 12.8611111 0.266551 12.8638889 0.264321 12.8666667 0.264321 12.8694444 0.265993 12.8722222 0.264878 12.8750000 0.265993 12.8777778 0.265993 12.8805556 0.265436 12.8833333 0.264321 12.8861111 0.264878 12.8888889 0.266551 12.8916667 0.265436 12.8944444 0.264321 12.8972222 0.263763 12.9000000 0.263206 12.9027778 0.264878 12.9055556 0.264878 12.9083333 0.264321 12.9111111 0.263206 12.9138889 0.261533 12.9166667 0.260976 12.9194444 0.262648 12.9222222 0.263206 12.9250000 0.262648 12.9277778 0.260976 12.9305556 0.258746 12.9333333 0.258188 12.9361111 0.259303 12.9388889 0.260418 12.9416667 0.257073 12.9444444 0.258746 12.9472222 0.255401 12.9500000 0.254286 12.9527778 0.253728 12.9555556 0.254843)

* === THRESHOLD VOLTAGES (set by resistor ladder in ASIC) ===
Vth_rpeak rpeak_threshold 0 0.3472
Vth14  vth_14_fast 0 0.276549
Vth69  vth_69      0 0.446868
Vth28  vth_28      0 0.468409
Vth300 vth_300     0 0.327676
Vth10  vth_10      0 0.325957
* Adaptive pwave thresholds (from EWMA-predicted RR, post-R)
Vth_pwb vth_pw_base 0 PWL(0.0000000 0.300000 0.7898889 0.414215 1.5676667 0.414240 2.3287778 0.414278 3.1148889 0.414337 3.9343333 0.414364 4.7815556 0.414348 5.5898889 0.414296 6.3593333 0.414295 7.1371111 0.414344 7.9287778 0.414381 8.7148889 0.414399 9.5121111 0.414425 10.3315556 0.414436 11.1510000 0.414419 11.9565556 0.414402 12.9555556 0.414402)
Vth_pwp vth_pw_peak 0 PWL(0.0000000 0.300000 0.7898889 0.409665 1.5676667 0.409692 2.3287778 0.409733 3.1148889 0.409796 3.9343333 0.409824 4.7815556 0.409807 5.5898889 0.409752 6.3593333 0.409751 7.1371111 0.409802 7.9287778 0.409842 8.7148889 0.409862 9.5121111 0.409889 10.3315556 0.409901 11.1510000 0.409882 11.9565556 0.409864 12.9555556 0.409864)
Vth_rrc vth_rr_cap  0 PWL(0.0000000 0.300000 0.7898889 0.397120 1.5676667 0.397153 2.3287778 0.397204 3.1148889 0.397283 3.9343333 0.397318 4.7815556 0.397296 5.5898889 0.397229 6.3593333 0.397227 7.1371111 0.397291 7.9287778 0.397340 8.7148889 0.397365 9.5121111 0.397399 10.3315556 0.397414 11.1510000 0.397391 11.9565556 0.397368 12.9555556 0.397368)

* === SUBCIRCUIT INCLUDES ===
.include "C:/Users/kadhi/OneDrive/Desktop/amux/verilogLearning/Leaky-Integrate-Fire---SNN-model-on-FPGA/experiments/frontend_optimization/complete_frontend_v9b/inverter.spice"
.include "C:/Users/kadhi/OneDrive/Desktop/amux/verilogLearning/Leaky-Integrate-Fire---SNN-model-on-FPGA/experiments/frontend_optimization/complete_frontend_v9b/bias_gen.spice"
.include "C:/Users/kadhi/OneDrive/Desktop/amux/verilogLearning/Leaky-Integrate-Fire---SNN-model-on-FPGA/experiments/frontend_optimization/complete_frontend_v9b/rpeak_detector.spice"
.include "C:/Users/kadhi/OneDrive/Desktop/amux/verilogLearning/Leaky-Integrate-Fire---SNN-model-on-FPGA/experiments/frontend_optimization/complete_frontend_v9b/rpeak_hold.spice"
.include "C:/Users/kadhi/OneDrive/Desktop/amux/verilogLearning/Leaky-Integrate-Fire---SNN-model-on-FPGA/experiments/frontend_optimization/complete_frontend_v9b/true_peak_detector.spice"
.include "C:/Users/kadhi/OneDrive/Desktop/amux/verilogLearning/Leaky-Integrate-Fire---SNN-model-on-FPGA/experiments/frontend_optimization/complete_frontend_v9b/delay_timer.spice"
.include "C:/Users/kadhi/OneDrive/Desktop/amux/verilogLearning/Leaky-Integrate-Fire---SNN-model-on-FPGA/experiments/frontend_optimization/complete_frontend_v9b/pulse_gen.spice"
.include "C:/Users/kadhi/OneDrive/Desktop/amux/verilogLearning/Leaky-Integrate-Fire---SNN-model-on-FPGA/experiments/frontend_optimization/complete_frontend_v9b/long_pulse_gen.spice"
.include "C:/Users/kadhi/OneDrive/Desktop/amux/verilogLearning/Leaky-Integrate-Fire---SNN-model-on-FPGA/experiments/frontend_optimization/complete_frontend_v9b/edge_buffer.spice"
.include "C:/Users/kadhi/OneDrive/Desktop/amux/verilogLearning/Leaky-Integrate-Fire---SNN-model-on-FPGA/experiments/frontend_optimization/complete_frontend_v9b/rr_timing.spice"
.include "C:/Users/kadhi/OneDrive/Desktop/amux/verilogLearning/Leaky-Integrate-Fire---SNN-model-on-FPGA/experiments/frontend_optimization/complete_frontend_v9b/beat_instability.spice"
.include "C:/Users/kadhi/OneDrive/Desktop/amux/verilogLearning/Leaky-Integrate-Fire---SNN-model-on-FPGA/experiments/frontend_optimization/complete_frontend_v9b/pwave_diff.spice"
.include "C:/Users/kadhi/OneDrive/Desktop/amux/verilogLearning/Leaky-Integrate-Fire---SNN-model-on-FPGA/experiments/frontend_optimization/complete_frontend_v9b/qrs_width.spice"
.include "C:/Users/kadhi/OneDrive/Desktop/amux/verilogLearning/Leaky-Integrate-Fire---SNN-model-on-FPGA/experiments/frontend_optimization/complete_frontend_v9b/qrs_slope.spice"
.include "C:/Users/kadhi/OneDrive/Desktop/amux/verilogLearning/Leaky-Integrate-Fire---SNN-model-on-FPGA/experiments/frontend_optimization/complete_frontend_v9b/qrs_symmetry.spice"

* ============================================================
* FULLY ANALOG FRONTEND WITH TRUE PEAK DETECTOR
* ============================================================

* 1. BIAS GENERATOR
Xbias vbias vref vdd vss bias_gen

* 2. R-PEAK DETECTION CHAIN
*    Step 1: Threshold comparator on QRS upslope
Xrpeak ecg_l0 rpeak_threshold rpeak_level vdd vss vbias rpeak_detector
*    Step 2: Hold circuit -> ~300ms ARM window
Xrpk_hold rpeak_level rpeak_level_held vdd vss vbias rpeak_hold
*    Step 3: True peak detector finds actual R-peak apex (SR latch output)
Xtpd ecg_l0 rpeak_level_held peak_detected vdd vss vbias true_peak_detector
*    Step 4: pulse_gen converts level to brief trigger pulse
Xpg_rpk peak_detected true_rpeak_pulse vdd vss vbias pulse_gen

* 3. DELAY TIMER (driven by true_rpeak_pulse, ~5ms after annotation)
* vth_rpk_del unused with true peak detector but pin must be connected
Vth_rpkdel vth_rpk_del 0 0.48
Xdt true_rpeak_pulse dt_s14_lev dt_s69_lev dt_wid_lev dt_bi_lev dt_rr_lev dt_rpk_del_unused dt_sf_out vdd vss vbias vth_14_fast vth_69 vth_28 vth_300 vth_10 vth_rpk_del delay_timer

* 4. EDGE BUFFERS + PULSE GENERATORS
Xpg_s14 dt_s14_lev trig_s14 vdd vss vbias pulse_gen
Xpg_rr  dt_rr_lev  trig_rr_copy vdd vss vbias long_pulse_gen

Xeb_wid dt_wid_lev wid_sharp vdd vss edge_buffer
Xpg_wid wid_sharp  trig_wid  vdd vss vbias pulse_gen

Xeb_s69 dt_s69_lev s69_sharp vdd vss edge_buffer
Xpg_s69 s69_sharp  trig_s69  vdd vss vbias pulse_gen

Xeb_bi  dt_bi_lev  bi_sharp  vdd vss edge_buffer
Xpg_bi  bi_sharp   trig_bi_copy vdd vss vbias long_pulse_gen

* 5. PWAVE PREDICTION COMPARATORS (on rr_timing timer SF)
* Post-R pwave: comparators watch rr_timer (320pF, long intervals)
* not delay_timer (100pF, short intervals) since 0.75*EWMA_RR ~ 500-700ms
XMcpwb1 cnpwb vth_pw_base ctpwb vss sky130_fd_pr__nfet_01v8 L=4 W=2 nf=1
XMcpwb2 pw_base_lev rr_timer ctpwb vss sky130_fd_pr__nfet_01v8 L=4 W=2 nf=1
XMcpwb3 cnpwb cnpwb vdd vdd sky130_fd_pr__pfet_01v8 L=4 W=2 nf=1
XMcpwb4 pw_base_lev cnpwb vdd vdd sky130_fd_pr__pfet_01v8 L=4 W=2 nf=1
XMcpwb5 ctpwb vbias vss vss sky130_fd_pr__nfet_01v8 L=8 W=0.42 nf=1

XMcpwp1 cnpwp vth_pw_peak ctpwp vss sky130_fd_pr__nfet_01v8 L=4 W=2 nf=1
XMcpwp2 pw_peak_lev rr_timer ctpwp vss sky130_fd_pr__nfet_01v8 L=4 W=2 nf=1
XMcpwp3 cnpwp cnpwp vdd vdd sky130_fd_pr__pfet_01v8 L=4 W=2 nf=1
XMcpwp4 pw_peak_lev cnpwp vdd vdd sky130_fd_pr__pfet_01v8 L=4 W=2 nf=1
XMcpwp5 ctpwp vbias vss vss sky130_fd_pr__nfet_01v8 L=8 W=0.42 nf=1

XMcrrc1 cnrrc vth_rr_cap ctrrc vss sky130_fd_pr__nfet_01v8 L=4 W=2 nf=1
XMcrrc2 rr_cap_lev rr_timer ctrrc vss sky130_fd_pr__nfet_01v8 L=4 W=2 nf=1
XMcrrc3 cnrrc cnrrc vdd vdd sky130_fd_pr__pfet_01v8 L=4 W=2 nf=1
XMcrrc4 rr_cap_lev cnrrc vdd vdd sky130_fd_pr__pfet_01v8 L=4 W=2 nf=1
XMcrrc5 ctrrc vbias vss vss sky130_fd_pr__nfet_01v8 L=8 W=0.42 nf=1

* 5b. EDGE BUFFERS + PULSE GENERATORS for pwave prediction
Xeb_pwb pw_base_lev pwb_sharp vdd vss edge_buffer
Xpg_pwb pwb_sharp   trig_pw_base vdd vss vbias pulse_gen

Xeb_pwp pw_peak_lev pwp_sharp vdd vss edge_buffer
Xpg_pwp pwp_sharp   trig_pw_peak vdd vss vbias pulse_gen

* rr_cap: use comparator level directly (not pulse_gen!)
* rr_cap_lev stays HIGH from threshold crossing (~R-55ms) until timer reset
* This provides the ~55ms window needed for SF-driven S&H settling (RC~22ms)
Xeb_rrc rr_cap_lev  trig_rr_cap vdd vss edge_buffer

* ============================================================
* 6. FEATURE CIRCUITS ? ALL driven by ANALOG triggers
* ============================================================

* F1 & F2: RR Timing (true_rpeak_pulse precharges timer)
Xrr ecg_l0 trig_rr_cap true_rpeak_pulse trig_rr_copy f1_rr_ratio f2_rr_asym rr_timer rr_ewma vdd vss vbias rr_timing

* F3: Beat Instability L0 (captures at true R-peak via true_rpeak_pulse)
Xbi0 ecg_l0 true_rpeak_pulse trig_bi_copy f3_bi_l0 vdd vss vbias beat_instability
* F4: Beat Instability L1
Xbi1 ecg_l1 true_rpeak_pulse trig_bi_copy f4_bi_l1 vdd vss vbias beat_instability

* F5: P-wave Difference L0 (post-R pwave triggers)
Xpw ecg_l0 trig_pw_base trig_pw_peak f5_pwave vdd vss vbias pwave_diff

* F6: QRS Width L0
Xwid ecg_l0 trig_wid f6_width vdd vss qrs_width

* F7: QRS Slope L0
Xslp ecg_l0 trig_s14 trig_s69 f7_slope vdd vss vbias qrs_slope

* F8: QRS Symmetry L0 (captures at true R-peak via true_rpeak_pulse)
Xsym ecg_l0 true_rpeak_pulse f8_symmetry vdd vss qrs_symmetry

* === INITIAL CONDITIONS ===
.ic V(xbias.iref)=0.3
.ic V(xrr.ewma_node)=0.370962
.ic V(xrr.esamp_node)=0.370867
.ic V(xrr.prev_node)=0.411731
.ic V(xbi0.prev_node)=0.365372
.ic V(xbi0.esamp_node)=0.368606
.ic V(xbi1.prev_node)=0.303008
.ic V(xbi1.esamp_node)=0.340953
.ic V(xtpd.peak_hold)=0.30

.tran 0.5m 12.9556 0 0.2m

.meas tran f1_2 FIND V(f1_rr_ratio) AT=2.3177778
.meas tran f2_2 FIND V(f2_rr_asym) AT=3.0488889
.meas tran f3_2 FIND V(f3_bi_l0) AT=2.4277778
.meas tran f4_2 FIND V(f4_bi_l1) AT=2.4277778
.meas tran f6_2 FIND V(f6_width) AT=2.4277778
.meas tran f7_2 FIND V(f7_slope) AT=2.4277778
.meas tran f8_2 FIND V(f8_symmetry) AT=2.4277778
.meas tran f5_2 FIND V(f5_pwave) AT=3.0239416
.meas tran f1_3 FIND V(f1_rr_ratio) AT=3.1038889
.meas tran f2_3 FIND V(f2_rr_asym) AT=3.8683333
.meas tran f3_3 FIND V(f3_bi_l0) AT=3.2138889
.meas tran f4_3 FIND V(f4_bi_l1) AT=3.2138889
.meas tran f6_3 FIND V(f6_width) AT=3.2138889
.meas tran f7_3 FIND V(f7_slope) AT=3.2138889
.meas tran f8_3 FIND V(f8_symmetry) AT=3.2138889
.meas tran f5_3 FIND V(f5_pwave) AT=3.8094936
.meas tran f1_4 FIND V(f1_rr_ratio) AT=3.9233333
.meas tran f2_4 FIND V(f2_rr_asym) AT=4.7155556
.meas tran f3_4 FIND V(f3_bi_l0) AT=4.0333333
.meas tran f4_4 FIND V(f4_bi_l1) AT=4.0333333
.meas tran f6_4 FIND V(f6_width) AT=4.0333333
.meas tran f7_4 FIND V(f7_slope) AT=4.0333333
.meas tran f8_4 FIND V(f8_symmetry) AT=4.0333333
.meas tran f5_4 FIND V(f5_pwave) AT=4.6286873
.meas tran f1_5 FIND V(f1_rr_ratio) AT=4.7705556
.meas tran f2_5 FIND V(f2_rr_asym) AT=5.5238889
.meas tran f3_5 FIND V(f3_bi_l0) AT=4.8805556
.meas tran f4_5 FIND V(f4_bi_l1) AT=4.8805556
.meas tran f6_5 FIND V(f6_width) AT=4.8805556
.meas tran f7_5 FIND V(f7_slope) AT=4.8805556
.meas tran f8_5 FIND V(f8_symmetry) AT=4.8805556
.meas tran f5_5 FIND V(f5_pwave) AT=5.4760625
.meas tran f1_6 FIND V(f1_rr_ratio) AT=5.5788889
.meas tran f2_6 FIND V(f2_rr_asym) AT=6.2933333
.meas tran f3_6 FIND V(f3_bi_l0) AT=5.6888889
.meas tran f4_6 FIND V(f4_bi_l1) AT=5.6888889
.meas tran f6_6 FIND V(f6_width) AT=5.6888889
.meas tran f7_6 FIND V(f7_slope) AT=5.6888889
.meas tran f8_6 FIND V(f8_symmetry) AT=5.6888889
.meas tran f5_6 FIND V(f5_pwave) AT=6.2848799
.meas tran f1_7 FIND V(f1_rr_ratio) AT=6.3483333
.meas tran f2_7 FIND V(f2_rr_asym) AT=7.0711111
.meas tran f3_7 FIND V(f3_bi_l0) AT=6.4583333
.meas tran f4_7 FIND V(f4_bi_l1) AT=6.4583333
.meas tran f6_7 FIND V(f6_width) AT=6.4583333
.meas tran f7_7 FIND V(f7_slope) AT=6.4583333
.meas tran f8_7 FIND V(f8_symmetry) AT=6.4583333
.meas tran f5_7 FIND V(f5_pwave) AT=7.0543345
.meas tran f1_8 FIND V(f1_rr_ratio) AT=7.1261111
.meas tran f2_8 FIND V(f2_rr_asym) AT=7.8627778
.meas tran f3_8 FIND V(f3_bi_l0) AT=7.2361111
.meas tran f4_8 FIND V(f4_bi_l1) AT=7.2361111
.meas tran f6_8 FIND V(f6_width) AT=7.2361111
.meas tran f7_8 FIND V(f7_slope) AT=7.2361111
.meas tran f8_8 FIND V(f8_symmetry) AT=7.2361111
.meas tran f5_8 FIND V(f5_pwave) AT=7.8316556
.meas tran f1_9 FIND V(f1_rr_ratio) AT=7.9177778
.meas tran f2_9 FIND V(f2_rr_asym) AT=8.6488889
.meas tran f3_9 FIND V(f3_bi_l0) AT=8.0277778
.meas tran f4_9 FIND V(f4_bi_l1) AT=8.0277778
.meas tran f6_9 FIND V(f6_width) AT=8.0277778
.meas tran f7_9 FIND V(f7_slope) AT=8.0277778
.meas tran f8_9 FIND V(f8_symmetry) AT=8.0277778
.meas tran f5_9 FIND V(f5_pwave) AT=8.6229724
.meas tran f1_10 FIND V(f1_rr_ratio) AT=8.7038889
.meas tran f2_10 FIND V(f2_rr_asym) AT=9.4461111
.meas tran f3_10 FIND V(f3_bi_l0) AT=8.8138889
.meas tran f4_10 FIND V(f4_bi_l1) AT=8.8138889
.meas tran f6_10 FIND V(f6_width) AT=8.8138889
.meas tran f7_10 FIND V(f7_slope) AT=8.8138889
.meas tran f8_10 FIND V(f8_symmetry) AT=8.8138889
.meas tran f5_10 FIND V(f5_pwave) AT=9.4089056
.meas tran f1_11 FIND V(f1_rr_ratio) AT=9.5011111
.meas tran f2_11 FIND V(f2_rr_asym) AT=10.2655556
.meas tran f3_11 FIND V(f3_bi_l0) AT=9.6111111
.meas tran f4_11 FIND V(f4_bi_l1) AT=9.6111111
.meas tran f6_11 FIND V(f6_width) AT=9.6111111
.meas tran f7_11 FIND V(f7_slope) AT=9.6111111
.meas tran f8_11 FIND V(f8_symmetry) AT=9.6111111
.meas tran f5_11 FIND V(f5_pwave) AT=10.2058859
.meas tran f1_12 FIND V(f1_rr_ratio) AT=10.3205556
.meas tran f2_12 FIND V(f2_rr_asym) AT=11.0850000
.meas tran f3_12 FIND V(f3_bi_l0) AT=10.4305556
.meas tran f4_12 FIND V(f4_bi_l1) AT=10.4305556
.meas tran f6_12 FIND V(f6_width) AT=10.4305556
.meas tran f7_12 FIND V(f7_slope) AT=10.4305556
.meas tran f8_12 FIND V(f8_symmetry) AT=10.4305556
.meas tran f5_12 FIND V(f5_pwave) AT=11.0252254
.meas tran f1_13 FIND V(f1_rr_ratio) AT=11.1400000
.meas tran f2_13 FIND V(f2_rr_asym) AT=11.8905556
.meas tran f3_13 FIND V(f3_bi_l0) AT=11.2500000
.meas tran f4_13 FIND V(f4_bi_l1) AT=11.2500000
.meas tran f6_13 FIND V(f6_width) AT=11.2500000
.meas tran f7_13 FIND V(f7_slope) AT=11.2500000
.meas tran f8_13 FIND V(f8_symmetry) AT=11.2500000
.meas tran f5_13 FIND V(f5_pwave) AT=11.8448331
.meas tran f1_14 FIND V(f1_rr_ratio) AT=11.9455556
.meas tran f3_14 FIND V(f3_bi_l0) AT=12.0555556
.meas tran f4_14 FIND V(f4_bi_l1) AT=12.0555556
.meas tran f6_14 FIND V(f6_width) AT=12.0555556
.meas tran f7_14 FIND V(f7_slope) AT=12.0555556
.meas tran f8_14 FIND V(f8_symmetry) AT=12.0555556
.meas tran f5_14 FIND V(f5_pwave) AT=12.6505495

.meas tran ic_rr_ewma FIND V(xrr.ewma_node) AT=12.0555556
.meas tran ic_rr_esamp FIND V(xrr.esamp_node) AT=12.0555556
.meas tran ic_rr_prev FIND V(xrr.prev_node) AT=12.0555556
.meas tran ic_bi0_prev FIND V(xbi0.prev_node) AT=12.0555556
.meas tran ic_bi0_esamp FIND V(xbi0.esamp_node) AT=12.0555556
.meas tran ic_bi1_prev FIND V(xbi1.prev_node) AT=12.0555556
.meas tran ic_bi1_esamp FIND V(xbi1.esamp_node) AT=12.0555556

.end
