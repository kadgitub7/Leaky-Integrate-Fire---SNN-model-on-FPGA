.title pwave_diff_cf_test_109
.lib "C:\Users\kadhi\OneDrive\Desktop\amux\verilogLearning\Leaky-Integrate-Fire---SNN-model-on-FPGA\experiments\frontend_optimization\ngspice_frontend\sky130_minimal.lib.spice" tt
.option scale=1.0u method=gear reltol=0.01 gmin=1e-15
.temp 27
.include "pwave_diff.spice"

Vdd vdd 0 0.9
Vss vss 0 0
Vbias vbias 0 0.300
Vecg ecg_in 0 PWL(0.0000000 0.300000 1.7450000 0.300000 1.7500000 0.281221 1.7527778 0.280970 1.7555556 0.281721 1.7583333 0.280219 1.7611111 0.280720 1.7638889 0.280469 1.7666667 0.279218 1.7694444 0.280469 1.7722222 0.281471 1.7750000 0.281972 1.7777778 0.281721 1.7805556 0.280469 1.7833333 0.278967 1.7861111 0.278216 1.7888889 0.277465 1.7916667 0.275712 1.7944444 0.274460 1.7972222 0.272707 1.8000000 0.270955 1.8027778 0.270203 1.8055556 0.269703 1.8083333 0.269202 1.8111111 0.268951 1.8138889 0.267950 1.8166667 0.267950 1.8194444 0.268451 1.8222222 0.268200 1.8250000 0.267449 1.8277778 0.266948 1.8305556 0.265947 1.8333333 0.266197 1.8361111 0.266448 1.8388889 0.266698 1.8416667 0.267199 1.8444444 0.266948 1.8472222 0.265947 1.8500000 0.265196 1.8527778 0.265696 1.8555556 0.265696 1.8583333 0.265446 1.8611111 0.266197 1.8638889 0.265696 1.8666667 0.265696 1.8694444 0.265696 1.8722222 0.266448 1.8750000 0.266698 1.8777778 0.266948 1.8805556 0.265947 1.8833333 0.265696 1.8861111 0.265947 1.8888889 0.266698 1.8916667 0.266948 1.8944444 0.265947 1.8972222 0.265196 1.9000000 0.265696 1.9027778 0.266698 1.9055556 0.267449 1.9083333 0.267449 1.9111111 0.267199 1.9138889 0.266698 1.9166667 0.266698 1.9194444 0.267199 1.9222222 0.267950 1.9250000 0.267950 1.9277778 0.267449 1.9305556 0.266698 1.9333333 0.267449 1.9361111 0.267449 1.9388889 0.266448 1.9416667 0.265696 1.9444444 0.264194 1.9472222 0.264695 1.9500000 0.266197 1.9527778 0.270203 1.9555556 0.275462 1.9583333 0.280720 1.9611111 0.285728 1.9638889 0.289734 1.9666667 0.291236 1.9694444 0.292989 1.9722222 0.296244 1.9750000 0.301002 1.9777778 0.305258 1.9805556 0.309515 1.9833333 0.313020 1.9861111 0.316025 1.9888889 0.318779 1.9916667 0.319030 1.9944444 0.318028 1.9972222 0.317527 2.0000000 0.316275 2.0027778 0.315775 2.0055556 0.315023 2.0083333 0.311518 2.0111111 0.307261 2.0138889 0.302754 2.0166667 0.299750 2.0194444 0.297246 2.0222222 0.292739 2.0250000 0.287480 2.0277778 0.279468 2.0305556 0.272207 2.0333333 0.264945 2.0361111 0.259186 2.0388889 0.253678 2.0416667 0.249421 2.0444444 0.245915 2.0472222 0.243662 2.0500000 0.242160 2.0527778 0.241909 2.0555556 0.241909 2.0583333 0.242160 2.0611111 0.242160 2.0638889 0.241659 2.0666667 0.243161 2.0694444 0.244914 2.0722222 0.247167 2.0750000 0.248169 2.0777778 0.249171 2.0805556 0.249421 2.0833333 0.250673 2.0861111 0.251925 2.0888889 0.253177 2.0916667 0.254930 2.0944444 0.255180 2.0972222 0.254429 2.1000000 0.255931 2.1027778 0.256682 2.1055556 0.258685 2.1083333 0.259186 2.1111111 0.259437 2.1138889 0.259186 2.1166667 0.258936 2.1194444 0.258685 2.1222222 0.259437 2.1250000 0.258936 2.1277778 0.258685 2.1305556 0.258685 2.1333333 0.259186 2.1361111 0.258936 2.1388889 0.259437 2.1416667 0.259437 2.1444444 0.259186 2.1472222 0.258435 2.1500000 0.258936 2.1527778 0.259437 2.1555556 0.259687 2.1583333 0.259687 2.1611111 0.259186 2.1638889 0.258685 2.1666667 0.258185 2.1694444 0.258936 2.1722222 0.260188 2.1750000 0.260188 2.1777778 0.259687 2.1805556 0.259687 2.1833333 0.259186 2.1861111 0.260188 2.1888889 0.259937 2.1916667 0.260689 2.1944444 0.260939 2.1972222 0.260438 2.2000000 0.260939 2.2027778 0.261440 2.2055556 0.262441 2.2083333 0.262441 2.2111111 0.262191 2.2138889 0.262692 2.2166667 0.263944 2.2194444 0.265446 2.2222222 0.265446 2.2250000 0.265947 2.2277778 0.265696 2.2305556 0.265696 2.2333333 0.266698 2.2361111 0.267950 2.2388889 0.269202 2.2416667 0.269703 2.2444444 0.269452 2.2472222 0.269452 2.2500000 0.270203 2.2527778 0.270203 2.2555556 0.271205 2.2583333 0.272707 2.2611111 0.273208 2.2638889 0.272707 2.2666667 0.274210 2.2694444 0.274961 2.2722222 0.275462 2.2750000 0.276213 2.2777778 0.276964 2.2805556 0.276964 2.2833333 0.277465 2.2861111 0.278216 2.2888889 0.278967 2.2916667 0.278967 2.2944444 0.278717 2.2972222 0.279969 2.3050000 0.300000 2.4005556 0.300000 2.4055556 0.283725 2.4083333 0.282723 2.4111111 0.281972 2.4138889 0.280720 2.4166667 0.281471 2.4194444 0.282222 2.4222222 0.282222 2.4250000 0.281721 2.4277778 0.281721 2.4305556 0.281221 2.4333333 0.279718 2.4361111 0.278216 2.4388889 0.277465 2.4416667 0.275462 2.4444444 0.273208 2.4472222 0.270704 2.4500000 0.270704 2.4527778 0.270203 2.4555556 0.269953 2.4583333 0.269452 2.4611111 0.269202 2.4638889 0.269202 2.4666667 0.269202 2.4694444 0.268951 2.4722222 0.269703 2.4750000 0.269703 2.4777778 0.268951 2.4805556 0.268701 2.4833333 0.268701 2.4861111 0.268701 2.4888889 0.269452 2.4916667 0.270203 2.4944444 0.269452 2.4972222 0.269452 2.5000000 0.269452 2.5027778 0.269953 2.5055556 0.270454 2.5083333 0.270203 2.5111111 0.270454 2.5138889 0.269452 2.5166667 0.268951 2.5194444 0.269953 2.5222222 0.270704 2.5250000 0.270203 2.5277778 0.269703 2.5305556 0.269452 2.5333333 0.269202 2.5361111 0.269703 2.5388889 0.270955 2.5416667 0.270203 2.5444444 0.270203 2.5472222 0.269953 2.5500000 0.269953 2.5527778 0.270203 2.5555556 0.270955 2.5583333 0.271205 2.5611111 0.270955 2.5638889 0.270704 2.5666667 0.271205 2.5694444 0.271706 2.5722222 0.272457 2.5750000 0.272207 2.5777778 0.271706 2.5805556 0.270454 2.5833333 0.270955 2.5861111 0.271706 2.5888889 0.272207 2.5916667 0.271455 2.5944444 0.271205 2.5972222 0.270454 2.6000000 0.271455 2.6027778 0.274710 2.6055556 0.279718 2.6083333 0.285978 2.6111111 0.292488 2.6138889 0.300000 2.6166667 0.305759 2.6194444 0.307261 2.6222222 0.307011 2.6250000 0.307512 2.6277778 0.308764 2.6305556 0.310266 2.6333333 0.312520 2.6361111 0.316025 2.6388889 0.320532 2.6416667 0.323036 2.6444444 0.324038 2.6472222 0.323787 2.6500000 0.323537 2.6527778 0.324038 2.6555556 0.323787 2.6583333 0.322034 2.6611111 0.317527 2.6638889 0.312770 2.6666667 0.308513 2.6694444 0.304507 2.6722222 0.301753 2.6750000 0.297246 2.6777778 0.290986 2.6805556 0.282973 2.6833333 0.275712 2.6861111 0.269452 2.6888889 0.264695 2.6916667 0.259186 2.6944444 0.254178 2.6972222 0.249171 2.7000000 0.246917 2.7027778 0.245915 2.7055556 0.245665 2.7083333 0.245665 2.7111111 0.245415 2.7138889 0.245915 2.7166667 0.246166 2.7194444 0.247167 2.7222222 0.248169 2.7250000 0.248670 2.7277778 0.250423 2.7305556 0.251674 2.7333333 0.253678 2.7361111 0.255430 2.7388889 0.257183 2.7416667 0.258185 2.7444444 0.258435 2.7472222 0.259186 2.7500000 0.260939 2.7527778 0.262191 2.7555556 0.263944 2.7583333 0.264945 2.7611111 0.265446 2.7638889 0.265696 2.7666667 0.266197 2.7694444 0.267199 2.7722222 0.267199 2.7750000 0.267700 2.7777778 0.266948 2.7805556 0.265696 2.7833333 0.265947 2.7861111 0.266948 2.7888889 0.267700 2.7916667 0.267449 2.7944444 0.266948 2.7972222 0.265947 2.8000000 0.265196 2.8027778 0.265696 2.8055556 0.265947 2.8083333 0.266197 2.8111111 0.265947 2.8138889 0.265196 2.8166667 0.264194 2.8194444 0.264444 2.8222222 0.265947 2.8250000 0.265947 2.8277778 0.265696 2.8305556 0.265196 2.8333333 0.264695 2.8361111 0.266197 2.8388889 0.266698 2.8416667 0.265947 2.8444444 0.265196 2.8472222 0.265196 2.8500000 0.265696 2.8527778 0.266197 2.8555556 0.266197 2.8583333 0.266698 2.8611111 0.266948 2.8638889 0.266948 2.8666667 0.267199 2.8694444 0.267950 2.8722222 0.268451 2.8750000 0.268951 2.8777778 0.268951 2.8805556 0.268951 2.8833333 0.269452 2.8861111 0.269703 2.8888889 0.270203 2.8916667 0.270454 2.8944444 0.270704 2.8972222 0.270955 2.9000000 0.271455 2.9027778 0.273208 2.9055556 0.274210 2.9083333 0.274460 2.9111111 0.275211 2.9138889 0.274710 2.9166667 0.276213 2.9194444 0.276213 2.9222222 0.277465 2.9250000 0.278216 2.9277778 0.278967 2.9305556 0.278216 2.9333333 0.279468 2.9361111 0.280720 2.9388889 0.280970 2.9416667 0.281221 2.9444444 0.280970 2.9472222 0.281471 2.9500000 0.281972 2.9527778 0.282723 2.9605556 0.300000 3.0727778 0.300000 3.0777778 0.287981 3.0805556 0.286980 3.0833333 0.286729 3.0861111 0.286729 3.0888889 0.286729 3.0916667 0.286980 3.0944444 0.286980 3.0972222 0.287230 3.1000000 0.286980 3.1027778 0.286479 3.1055556 0.285227 3.1083333 0.283975 3.1111111 0.282473 3.1138889 0.280970 3.1166667 0.279468 3.1194444 0.278466 3.1222222 0.277214 3.1250000 0.277214 3.1277778 0.276213 3.1305556 0.275211 3.1333333 0.274710 3.1361111 0.275211 3.1388889 0.275462 3.1416667 0.275462 3.1444444 0.275712 3.1472222 0.275462 3.1500000 0.275211 3.1527778 0.274710 3.1555556 0.274961 3.1583333 0.274460 3.1611111 0.273709 3.1638889 0.273959 3.1666667 0.274460 3.1694444 0.275462 3.1722222 0.275462 3.1750000 0.275462 3.1777778 0.274961 3.1805556 0.274460 3.1833333 0.274210 3.1861111 0.273709 3.1888889 0.274710 3.1916667 0.274710 3.1944444 0.274460 3.1972222 0.274210 3.2000000 0.274460 3.2027778 0.274961 3.2055556 0.275462 3.2083333 0.274961 3.2111111 0.275712 3.2138889 0.274961 3.2166667 0.274710 3.2194444 0.274210 3.2222222 0.274460 3.2250000 0.275462 3.2277778 0.275962 3.2305556 0.276213 3.2333333 0.276213 3.2361111 0.276463 3.2388889 0.276213 3.2416667 0.275962 3.2444444 0.276213 3.2472222 0.275462 3.2500000 0.275211 3.2527778 0.276463 3.2555556 0.276714 3.2583333 0.277214 3.2611111 0.276714 3.2638889 0.275962 3.2666667 0.275211 3.2694444 0.275962 3.2722222 0.276213 3.2750000 0.276714 3.2777778 0.278717 3.2805556 0.281972 3.2833333 0.287731 3.2861111 0.294742 3.2888889 0.301753 3.2916667 0.307011 3.2944444 0.311768 3.2972222 0.314022 3.3000000 0.315274 3.3027778 0.316526 3.3055556 0.319030 3.3083333 0.322034 3.3111111 0.325790 3.3138889 0.328294 3.3166667 0.332801 3.3194444 0.335806 3.3222222 0.336557 3.3250000 0.336056 3.3277778 0.334304 3.3305556 0.331800 3.3333333 0.329296 3.3361111 0.326541 3.3388889 0.322786 3.3416667 0.317277 3.3444444 0.312019 3.3472222 0.308013 3.3500000 0.303505 3.3527778 0.298498 3.3555556 0.292989 3.3583333 0.286980 3.3611111 0.280469 3.3638889 0.272958 3.3666667 0.266448 3.3694444 0.260939 3.3722222 0.256682 3.3750000 0.251925 3.3777778 0.246667 3.3805556 0.242911 3.3833333 0.241659 3.3861111 0.241408 3.3888889 0.242410 3.3916667 0.243412 3.3944444 0.243412 3.3972222 0.243412 3.4000000 0.244163 3.4027778 0.245415 3.4055556 0.247418 3.4083333 0.249171 3.4111111 0.249171 3.4138889 0.250673 3.4166667 0.252676 3.4194444 0.254429 3.4222222 0.256182 3.4250000 0.257684 3.4277778 0.258685 3.4305556 0.259186 3.4333333 0.260689 3.4361111 0.262191 3.4388889 0.263192 3.4416667 0.264194 3.4444444 0.265196 3.4472222 0.264695 3.4500000 0.264194 3.4527778 0.264695 3.4555556 0.265947 3.4583333 0.266448 3.4611111 0.265446 3.4638889 0.265196 3.4666667 0.265696 3.4694444 0.266197 3.4722222 0.266698 3.4750000 0.266448 3.4777778 0.265696 3.4805556 0.265696 3.4833333 0.266197 3.4861111 0.266197 3.4888889 0.266197 3.4916667 0.265446 3.4944444 0.265947 3.4972222 0.265696 3.5000000 0.265446 3.5027778 0.265696 3.5055556 0.265696 3.5083333 0.265446 3.5111111 0.265446 3.5138889 0.264945 3.5166667 0.265696 3.5194444 0.265947 3.5222222 0.266448 3.5250000 0.266698 3.5277778 0.266448 3.5305556 0.265947 3.5333333 0.265196 3.5361111 0.265446 3.5388889 0.266948 3.5416667 0.267199 3.5444444 0.267199 3.5472222 0.267950 3.5500000 0.267950 3.5527778 0.268951 3.5555556 0.269452 3.5583333 0.269953 3.5611111 0.270454 3.5638889 0.270454 3.5666667 0.270955 3.5694444 0.271706 3.5722222 0.273208 3.5750000 0.273709 3.5777778 0.273459 3.5805556 0.273709 3.5833333 0.275462 3.5861111 0.276964 3.5888889 0.278216 3.5916667 0.278466 3.5944444 0.278967 3.5972222 0.278466 3.6000000 0.278717 3.6027778 0.280219 3.6055556 0.280720 3.6083333 0.281471 3.6111111 0.281972 3.6138889 0.282222 3.6166667 0.283224 3.6194444 0.283975 3.6222222 0.284977 3.6250000 0.284977 3.6327778 0.300000 3.7088889 0.300000 3.7138889 0.289734 3.7166667 0.290736 3.7194444 0.290986 3.7222222 0.291236 3.7250000 0.290485 3.7277778 0.289984 3.7305556 0.289233 3.7333333 0.289233 3.7361111 0.288732 3.7388889 0.288983 3.7416667 0.288732 3.7444444 0.287981 3.7472222 0.286729 3.7500000 0.287480 3.7527778 0.287981 3.7555556 0.288983 3.7583333 0.287480 3.7611111 0.285477 3.7638889 0.283725 3.7666667 0.282723 3.7694444 0.282723 3.7722222 0.281471 3.7750000 0.280219 3.7777778 0.278216 3.7805556 0.276964 3.7833333 0.276714 3.7861111 0.276463 3.7888889 0.276463 3.7916667 0.277214 3.7944444 0.276714 3.7972222 0.276213 3.8000000 0.275462 3.8027778 0.276463 3.8055556 0.275462 3.8083333 0.275712 3.8111111 0.275962 3.8138889 0.274460 3.8166667 0.275462 3.8194444 0.276213 3.8222222 0.276714 3.8250000 0.275712 3.8277778 0.274961 3.8305556 0.275211 3.8333333 0.275462 3.8361111 0.275211 3.8388889 0.275211 3.8416667 0.274710 3.8444444 0.274210 3.8472222 0.272958 3.8500000 0.272958 3.8527778 0.273959 3.8555556 0.274210 3.8583333 0.274710 3.8611111 0.275211 3.8638889 0.274961 3.8666667 0.274961 3.8694444 0.275962 3.8722222 0.275462 3.8750000 0.275211 3.8777778 0.275712 3.8805556 0.275211 3.8833333 0.275211 3.8861111 0.276463 3.8888889 0.277214 3.8916667 0.277465 3.8944444 0.278717 3.8972222 0.280219 3.9000000 0.281972 3.9027778 0.282473 3.9055556 0.281721 3.9083333 0.280469 3.9111111 0.277966 3.9138889 0.275462 3.9166667 0.274210 3.9194444 0.274460 3.9222222 0.277715 3.9250000 0.283224 3.9277778 0.289484 3.9305556 0.295493 3.9333333 0.301502 3.9361111 0.305759 3.9388889 0.309014 3.9416667 0.309515 3.9444444 0.312269 3.9472222 0.314523 3.9500000 0.316526 3.9527778 0.318028 3.9555556 0.320532 3.9583333 0.321283 3.9611111 0.321784 3.9638889 0.320031 3.9666667 0.318279 3.9694444 0.318028 3.9722222 0.317027 3.9750000 0.315023 3.9777778 0.310767 3.9805556 0.307762 3.9833333 0.304507 3.9861111 0.302254 3.9888889 0.299249 3.9916667 0.295493 3.9944444 0.290736 3.9972222 0.283975 4.0000000 0.277715 4.0027778 0.272207 4.0055556 0.267700 4.0083333 0.262441 4.0111111 0.256432 4.0138889 0.251925 4.0166667 0.250673 4.0194444 0.251674 4.0222222 0.252676 4.0250000 0.252676 4.0277778 0.250673 4.0305556 0.249671 4.0333333 0.250172 4.0361111 0.252175 4.0388889 0.255430 4.0416667 0.257934 4.0444444 0.259186 4.0472222 0.258185 4.0500000 0.257433 4.0527778 0.256682 4.0555556 0.256682 4.0583333 0.258185 4.0611111 0.260689 4.0638889 0.264194 4.0666667 0.267199 4.0694444 0.267950 4.0722222 0.267700 4.0750000 0.266448 4.0777778 0.265696 4.0805556 0.265446 4.0833333 0.266698 4.0861111 0.268200 4.0888889 0.269202 4.0916667 0.269202 4.0944444 0.269202 4.0972222 0.269202 4.1000000 0.268951 4.1027778 0.269452 4.1055556 0.269953 4.1083333 0.270203 4.1111111 0.269202 4.1138889 0.268701 4.1166667 0.268200 4.1194444 0.268200 4.1222222 0.267700 4.1250000 0.269202 4.1277778 0.268951 4.1305556 0.268451 4.1333333 0.268200 4.1361111 0.268701 4.1388889 0.269953 4.1416667 0.270203 4.1444444 0.269953 4.1472222 0.269953 4.1500000 0.269953 4.1527778 0.270203 4.1555556 0.271455 4.1583333 0.271455 4.1611111 0.271205 4.1638889 0.271706 4.1666667 0.272707 4.1694444 0.273208 4.1722222 0.273709 4.1750000 0.273459 4.1777778 0.272707 4.1805556 0.272457 4.1833333 0.272958 4.1861111 0.273959 4.1888889 0.273959 4.1916667 0.274710 4.1944444 0.275211 4.1972222 0.274710 4.2000000 0.275462 4.2027778 0.276213 4.2055556 0.277966 4.2083333 0.278216 4.2111111 0.278216 4.2138889 0.278967 4.2166667 0.279969 4.2194444 0.280720 4.2222222 0.281471 4.2250000 0.282222 4.2277778 0.282473 4.2305556 0.282473 4.2333333 0.283224 4.2361111 0.283975 4.2388889 0.284476 4.2416667 0.285978 4.2444444 0.285728 4.2472222 0.285477 4.2500000 0.286228 4.2527778 0.286729 4.2555556 0.287731 4.2583333 0.287981 4.2611111 0.287731 4.2688889 0.300000 4.3338889 0.300000 4.3388889 0.292488 4.3416667 0.292488 4.3444444 0.293239 4.3472222 0.292739 4.3500000 0.292739 4.3527778 0.293239 4.3555556 0.292739 4.3583333 0.292238 4.3611111 0.291487 4.3638889 0.289984 4.3666667 0.289734 4.3694444 0.289734 4.3722222 0.290235 4.3750000 0.290986 4.3777778 0.290235 4.3805556 0.290736 4.3833333 0.291987 4.3861111 0.291987 4.3888889 0.291487 4.3916667 0.288732 4.3944444 0.286479 4.3972222 0.285477 4.4000000 0.284476 4.4027778 0.284476 4.4055556 0.283224 4.4083333 0.282222 4.4111111 0.280469 4.4138889 0.279468 4.4166667 0.278967 4.4194444 0.278216 4.4222222 0.278967 4.4250000 0.279218 4.4277778 0.277966 4.4305556 0.277715 4.4333333 0.277214 4.4361111 0.278216 4.4388889 0.278466 4.4416667 0.278967 4.4444444 0.278216 4.4472222 0.277465 4.4500000 0.277214 4.4527778 0.277715 4.4555556 0.277715 4.4583333 0.278717 4.4611111 0.278216 4.4638889 0.278216 4.4666667 0.277715 4.4694444 0.278466 4.4722222 0.278967 4.4750000 0.278717 4.4777778 0.278466 4.4805556 0.277966 4.4833333 0.278216 4.4861111 0.279218 4.4888889 0.279718 4.4916667 0.279468 4.4944444 0.279218 4.4972222 0.278216 4.5000000 0.278967 4.5027778 0.279468 4.5055556 0.278967 4.5083333 0.279468 4.5111111 0.277966 4.5138889 0.277465 4.5166667 0.277966 4.5194444 0.279718 4.5222222 0.279468 4.5250000 0.279969 4.5277778 0.279468 4.5305556 0.279718 4.5333333 0.278967 4.5361111 0.278967 4.5388889 0.278466 4.5416667 0.278216 4.5444444 0.277715 4.5472222 0.279218 4.5500000 0.283725 4.5527778 0.290736 4.5555556 0.296495 4.5583333 0.300000 4.5611111 0.301252 4.5638889 0.301753 4.5666667 0.304757 4.5694444 0.309264 4.5722222 0.315023 4.5750000 0.319280 4.5777778 0.321784 4.5805556 0.321534 4.5833333 0.321784 4.5861111 0.321534 4.5888889 0.321534 4.5916667 0.320282 4.5944444 0.318028 4.5972222 0.313772 4.6000000 0.310516 4.6027778 0.308013 4.6055556 0.305759 4.6083333 0.302254 4.6111111 0.297746 4.6138889 0.291487 4.6166667 0.285477 4.6194444 0.279468 4.6222222 0.273208 4.6250000 0.266448 4.6277778 0.261189 4.6305556 0.257183 4.6333333 0.255430 4.6361111 0.254178 4.6388889 0.253928 4.6416667 0.253928 4.6444444 0.255180 4.6472222 0.254679 4.6500000 0.253928 4.6527778 0.254930 4.6555556 0.257433 4.6583333 0.259937 4.6611111 0.260939 4.6638889 0.261690 4.6666667 0.262191 4.6694444 0.263944 4.6722222 0.266197 4.6750000 0.267449 4.6777778 0.267700 4.6805556 0.268451 4.6833333 0.269703 4.6861111 0.270454 4.6888889 0.270704 4.6916667 0.271205 4.6944444 0.271205 4.6972222 0.270955 4.7000000 0.271205 4.7027778 0.271956 4.7055556 0.272207 4.7083333 0.271455 4.7111111 0.270704 4.7138889 0.269953 4.7166667 0.270955 4.7194444 0.271205 4.7222222 0.271455 4.7250000 0.271455 4.7277778 0.271205 4.7305556 0.270203 4.7333333 0.271205 4.7361111 0.271956 4.7388889 0.271956 4.7416667 0.271706 4.7444444 0.271205 4.7472222 0.270704 4.7500000 0.270955 4.7527778 0.271706 4.7555556 0.271956 4.7583333 0.272207 4.7611111 0.271455 4.7638889 0.270955 4.7666667 0.271706 4.7694444 0.272207 4.7722222 0.273208 4.7750000 0.273709 4.7777778 0.272457 4.7805556 0.273208 4.7833333 0.273959 4.7861111 0.274460 4.7888889 0.274961 4.7916667 0.275712 4.7944444 0.275211 4.7972222 0.275462 4.8000000 0.275962 4.8027778 0.276714 4.8055556 0.277715 4.8083333 0.278216 4.8111111 0.279218 4.8138889 0.279218 4.8166667 0.279969 4.8194444 0.280720 4.8222222 0.280219 4.8250000 0.281221 4.8277778 0.282473 4.8305556 0.282973 4.8333333 0.282973 4.8361111 0.284726 4.8388889 0.285227 4.8416667 0.286228 4.8444444 0.285978 4.8472222 0.286228 4.8500000 0.287230 4.8527778 0.287731 4.8555556 0.288482 4.8583333 0.288732 4.8611111 0.288482 4.8638889 0.288732 4.8666667 0.289734 4.8694444 0.289984 4.8722222 0.291236 4.8750000 0.290986 4.8777778 0.291236 4.8805556 0.292238 4.8833333 0.291737 4.8861111 0.292989 4.8938889 0.300000 4.9338889 0.300000 4.9388889 0.296244 4.9416667 0.296495 4.9444444 0.295743 4.9472222 0.294491 4.9500000 0.294742 4.9527778 0.295493 4.9555556 0.295243 4.9583333 0.294992 4.9611111 0.294241 4.9638889 0.293239 4.9666667 0.292989 4.9694444 0.292739 4.9722222 0.292989 4.9750000 0.293239 4.9777778 0.292989 4.9805556 0.292238 4.9833333 0.291737 4.9861111 0.290485 4.9888889 0.289484 4.9916667 0.287731 4.9944444 0.286729 4.9972222 0.284977 5.0000000 0.283975 5.0027778 0.282473 5.0055556 0.282222 5.0083333 0.281221 5.0111111 0.279718 5.0138889 0.279718 5.0166667 0.279969 5.0194444 0.280219 5.0222222 0.279969 5.0250000 0.279969 5.0277778 0.279468 5.0305556 0.278967 5.0333333 0.278967 5.0361111 0.279718 5.0388889 0.279468 5.0416667 0.279718 5.0444444 0.279468 5.0472222 0.278466 5.0500000 0.278717 5.0527778 0.279718 5.0555556 0.280469 5.0583333 0.279969 5.0611111 0.279718 5.0638889 0.278717 5.0666667 0.279218 5.0694444 0.280469 5.0722222 0.279969 5.0750000 0.280469 5.0777778 0.280219 5.0805556 0.279969 5.0833333 0.279718 5.0861111 0.279718 5.0888889 0.279969 5.0916667 0.280219 5.0944444 0.279468 5.0972222 0.278717 5.1000000 0.279718 5.1027778 0.280469 5.1055556 0.280970 5.1083333 0.281221 5.1111111 0.279969 5.1138889 0.279718 5.1166667 0.280219 5.1194444 0.281471 5.1222222 0.281721 5.1250000 0.281972 5.1277778 0.280970 5.1305556 0.280219 5.1333333 0.279718 5.1361111 0.279718 5.1388889 0.279218 5.1416667 0.278967 5.1444444 0.278717 5.1472222 0.281221 5.1500000 0.287230 5.1527778 0.293239 5.1555556 0.299249 5.1583333 0.303005 5.1611111 0.304006 5.1638889 0.304507 5.1666667 0.308013 5.1694444 0.313521 5.1722222 0.319781 5.1750000 0.324538 5.1777778 0.327793 5.1805556 0.329546 5.1833333 0.330798 5.1861111 0.330798 5.1888889 0.330297 5.1916667 0.329045 5.1944444 0.326291 5.1972222 0.321534 5.2000000 0.317778 5.2027778 0.314773 5.2055556 0.312019 5.2083333 0.308263 5.2111111 0.303005 5.2138889 0.295243 5.2166667 0.287230 5.2194444 0.279969 5.2222222 0.273709 5.2250000 0.267449 5.2277778 0.261690 5.2305556 0.258185 5.2333333 0.256432 5.2361111 0.255931 5.2388889 0.256432 5.2416667 0.255931 5.2444444 0.255931 5.2472222 0.255430 5.2500000 0.255931 5.2527778 0.256432 5.2555556 0.258185 5.2583333 0.260188 5.2611111 0.260689 5.2638889 0.261941 5.2666667 0.263443 5.2694444 0.264695 5.2722222 0.266448 5.2750000 0.267449 5.2777778 0.267449 5.2805556 0.268200 5.2833333 0.269703 5.2861111 0.271205 5.2888889 0.272207 5.2916667 0.272457 5.2944444 0.272207 5.2972222 0.271956 5.3000000 0.272958 5.3027778 0.272958 5.3055556 0.272707 5.3083333 0.272707 5.3111111 0.272958 5.3138889 0.272457 5.3166667 0.271956 5.3194444 0.272707 5.3222222 0.273208 5.3250000 0.273459 5.3277778 0.272958 5.3305556 0.271956 5.3333333 0.272457 5.3361111 0.272707 5.3388889 0.273208 5.3416667 0.273459 5.3444444 0.272707 5.3472222 0.272207 5.3500000 0.272207 5.3527778 0.272958 5.3555556 0.273709 5.3583333 0.274210 5.3611111 0.273959 5.3638889 0.273208 5.3666667 0.273709 5.3694444 0.274961 5.3722222 0.275211 5.3750000 0.275462 5.3777778 0.275211 5.3805556 0.275211 5.3833333 0.275211 5.3861111 0.276714 5.3888889 0.276714 5.3916667 0.277465 5.3944444 0.276964 5.3972222 0.276964 5.4000000 0.278216 5.4027778 0.279218 5.4055556 0.278967 5.4083333 0.279718 5.4111111 0.279468 5.4138889 0.279468 5.4166667 0.280970 5.4194444 0.281721 5.4222222 0.283474 5.4250000 0.283725 5.4277778 0.284225 5.4305556 0.284225 5.4333333 0.284225 5.4361111 0.285728 5.4388889 0.286980 5.4416667 0.287981 5.4444444 0.288482 5.4472222 0.288232 5.4500000 0.288232 5.4527778 0.288983 5.4555556 0.289734 5.4583333 0.290736 5.4611111 0.289984 5.4638889 0.289984 5.4666667 0.290986 5.4694444 0.291987 5.4722222 0.293490 5.4750000 0.294241 5.4777778 0.294241 5.4805556 0.293239 5.4833333 0.293490 5.4861111 0.293740 5.4938889 0.300000 5.5616667 0.300000 5.5666667 0.296495 5.5694444 0.296995 5.5722222 0.296995 5.5750000 0.296995 5.5777778 0.296244 5.5805556 0.294742 5.5833333 0.294241 5.5861111 0.294241 5.5888889 0.294241 5.5916667 0.294491 5.5944444 0.294491 5.5972222 0.293239 5.6000000 0.292238 5.6027778 0.291236 5.6055556 0.289984 5.6083333 0.288983 5.6111111 0.287731 5.6138889 0.286980 5.6166667 0.287230 5.6194444 0.286980 5.6222222 0.285978 5.6250000 0.283975 5.6277778 0.282473 5.6305556 0.281721 5.6333333 0.282973 5.6361111 0.286729 5.6388889 0.289734 5.6416667 0.290736 5.6444444 0.288732 5.6472222 0.284977 5.6500000 0.281972 5.6527778 0.279718 5.6555556 0.278216 5.6583333 0.277214 5.6611111 0.276213 5.6638889 0.276213 5.6666667 0.277214 5.6694444 0.277715 5.6722222 0.278717 5.6750000 0.279969 5.6777778 0.280219 5.6805556 0.279969 5.6833333 0.278717 5.6861111 0.278466 5.6888889 0.279218 5.6916667 0.280469 5.6944444 0.280720 5.6972222 0.279468 5.7000000 0.278717 5.7027778 0.278717 5.7055556 0.279969 5.7083333 0.281221 5.7111111 0.282222 5.7138889 0.282222 5.7166667 0.282723 5.7194444 0.283474 5.7222222 0.285227 5.7250000 0.286228 5.7277778 0.286980 5.7305556 0.285728 5.7333333 0.285728 5.7361111 0.284977 5.7388889 0.283474 5.7416667 0.282473 5.7444444 0.282473 5.7472222 0.283725 5.7500000 0.284225 5.7527778 0.283474 5.7555556 0.282222 5.7583333 0.282222 5.7611111 0.283725 5.7638889 0.288232 5.7666667 0.292739 5.7694444 0.296495 5.7722222 0.297997 5.7750000 0.300250 5.7777778 0.303255 5.7805556 0.307011 5.7833333 0.311518 5.7861111 0.316526 5.7888889 0.320282 5.7916667 0.321784 5.7944444 0.323036 5.7972222 0.326041 5.8000000 0.331299 5.8027778 0.334804 5.8055556 0.335055 5.8083333 0.332551 5.8111111 0.329797 5.8138889 0.328795 5.8166667 0.329797 5.8194444 0.330047 5.8222222 0.327543 5.8250000 0.323787 5.8277778 0.320282 5.8305556 0.316526 5.8333333 0.313271 5.8361111 0.309765 5.8388889 0.305008 5.8416667 0.297746 5.8444444 0.289233 5.8472222 0.279718 5.8500000 0.271956 5.8527778 0.265446 5.8555556 0.262441 5.8583333 0.259937 5.8611111 0.257433 5.8638889 0.253928 5.8666667 0.252676 5.8694444 0.252175 5.8722222 0.252676 5.8750000 0.254178 5.8777778 0.253427 5.8805556 0.253928 5.8833333 0.256682 5.8861111 0.259437 5.8888889 0.261440 5.8916667 0.262942 5.8944444 0.264194 5.8972222 0.265947 5.9000000 0.266698 5.9027778 0.268951 5.9055556 0.269953 5.9083333 0.270454 5.9111111 0.270704 5.9138889 0.271956 5.9166667 0.274710 5.9194444 0.275962 5.9222222 0.276213 5.9250000 0.275962 5.9277778 0.275462 5.9305556 0.277214 5.9333333 0.278717 5.9361111 0.279218 5.9388889 0.280469 5.9416667 0.282222 5.9444444 0.281972 5.9472222 0.278717 5.9500000 0.275712 5.9527778 0.273709 5.9555556 0.274710 5.9583333 0.273459 5.9611111 0.271956 5.9638889 0.268951 5.9666667 0.268200 5.9694444 0.268451 5.9722222 0.269202 5.9750000 0.269202 5.9777778 0.269703 5.9805556 0.269703 5.9833333 0.269703 5.9861111 0.269452 5.9888889 0.270203 5.9916667 0.270454 5.9944444 0.270203 5.9972222 0.270454 6.0000000 0.271205 6.0027778 0.271706 6.0055556 0.271706 6.0083333 0.273709 6.0111111 0.274210 6.0138889 0.274710 6.0166667 0.274961 6.0194444 0.275211 6.0222222 0.276213 6.0250000 0.277465 6.0277778 0.277966 6.0305556 0.278967 6.0333333 0.279969 6.0361111 0.283224 6.0388889 0.285978 6.0416667 0.287480 6.0444444 0.286479 6.0472222 0.283474 6.0500000 0.279468 6.0527778 0.277715 6.0555556 0.278967 6.0583333 0.282222 6.0611111 0.285728 6.0638889 0.288232 6.0666667 0.289984 6.0694444 0.289734 6.0722222 0.290736 6.0750000 0.292488 6.0777778 0.292739 6.0805556 0.291236 6.0833333 0.289734 6.0861111 0.290736 6.0888889 0.292238 6.0916667 0.294241 6.0944444 0.294241 6.0972222 0.293740 6.1000000 0.293991 6.1027778 0.292488 6.1055556 0.291737 6.1083333 0.290986 6.1111111 0.290235 6.1138889 0.288732 6.1216667 0.300000 6.1783333 0.300000 6.1833333 0.293991 6.1861111 0.291487 6.1888889 0.290235 6.1916667 0.292488 6.1944444 0.294742 6.1972222 0.296995 6.2000000 0.298498 6.2027778 0.297246 6.2055556 0.296745 6.2083333 0.295994 6.2111111 0.294742 6.2138889 0.292238 6.2166667 0.289233 6.2194444 0.285978 6.2222222 0.285227 6.2250000 0.285477 6.2277778 0.285728 6.2305556 0.284726 6.2333333 0.284476 6.2361111 0.283975 6.2388889 0.284476 6.2416667 0.284977 6.2444444 0.285978 6.2472222 0.284476 6.2500000 0.283975 6.2527778 0.284977 6.2555556 0.287230 6.2583333 0.288232 6.2611111 0.285728 6.2638889 0.281721 6.2666667 0.279969 6.2694444 0.279718 6.2722222 0.282222 6.2750000 0.281471 6.2777778 0.279718 6.2805556 0.277966 6.2833333 0.278717 6.2861111 0.279969 6.2888889 0.281471 6.2916667 0.282473 6.2944444 0.282473 6.2972222 0.282222 6.3000000 0.282473 6.3027778 0.282973 6.3055556 0.282473 6.3083333 0.282473 6.3111111 0.281471 6.3138889 0.282473 6.3166667 0.282973 6.3194444 0.283224 6.3222222 0.283224 6.3250000 0.283474 6.3277778 0.283975 6.3305556 0.283725 6.3333333 0.283975 6.3361111 0.284225 6.3388889 0.285728 6.3416667 0.285978 6.3444444 0.285477 6.3472222 0.285978 6.3500000 0.286729 6.3527778 0.287981 6.3555556 0.288482 6.3583333 0.286479 6.3611111 0.284977 6.3638889 0.282723 6.3666667 0.281721 6.3694444 0.281972 6.3722222 0.282723 6.3750000 0.282973 6.3777778 0.283224 6.3805556 0.284476 6.3833333 0.288232 6.3861111 0.294491 6.3888889 0.299750 6.3916667 0.304257 6.3944444 0.308263 6.3972222 0.310266 6.4000000 0.310016 6.4027778 0.310016 6.4055556 0.312520 6.4083333 0.317277 6.4111111 0.322285 6.4138889 0.327042 6.4166667 0.331800 6.4194444 0.336307 6.4222222 0.339812 6.4250000 0.340313 6.4277778 0.339562 6.4305556 0.337809 6.4333333 0.337308 6.4361111 0.336307 6.4388889 0.334053 6.4416667 0.328545 6.4444444 0.324288 6.4472222 0.321283 6.4500000 0.318028 6.4527778 0.314523 6.4555556 0.310016 6.4583333 0.303255 6.4611111 0.296244 6.4638889 0.289233 6.4666667 0.283725 6.4694444 0.278466 6.4722222 0.273459 6.4750000 0.269202 6.4777778 0.265196 6.4805556 0.262692 6.4833333 0.261189 6.4861111 0.260689 6.4888889 0.259937 6.4916667 0.259937 6.4944444 0.260188 6.4972222 0.260188 6.5000000 0.259937 6.5027778 0.259437 6.5055556 0.260689 6.5083333 0.261690 6.5111111 0.263693 6.5138889 0.265196 6.5166667 0.267199 6.5194444 0.268701 6.5222222 0.269703 6.5250000 0.270454 6.5277778 0.270454 6.5305556 0.270454 6.5333333 0.271956 6.5361111 0.273208 6.5388889 0.274460 6.5416667 0.276213 6.5444444 0.276213 6.5472222 0.276964 6.5500000 0.277465 6.5527778 0.278216 6.5555556 0.278967 6.5583333 0.278967 6.5611111 0.277966 6.5638889 0.278216 6.5666667 0.278717 6.5694444 0.278967 6.5722222 0.278216 6.5750000 0.278717 6.5777778 0.278216 6.5805556 0.277966 6.5833333 0.277465 6.5861111 0.278216 6.5888889 0.278466 6.5916667 0.277966 6.5944444 0.277715 6.5972222 0.276964 6.6000000 0.277465 6.6027778 0.277966 6.6055556 0.278466 6.6083333 0.278717 6.6111111 0.277966 6.6138889 0.277465 6.6166667 0.277966 6.6194444 0.278717 6.6222222 0.278717 6.6250000 0.279218 6.6277778 0.278717 6.6305556 0.277966 6.6333333 0.278717 6.6361111 0.278967 6.6388889 0.279468 6.6416667 0.279718 6.6444444 0.279218 6.6472222 0.279468 6.6500000 0.279718 6.6527778 0.280720 6.6555556 0.281972 6.6583333 0.282222 6.6611111 0.281721 6.6638889 0.281721 6.6666667 0.282973 6.6694444 0.283975 6.6722222 0.284726 6.6750000 0.284726 6.6777778 0.285227 6.6805556 0.285477 6.6833333 0.286729 6.6861111 0.288232 6.6888889 0.288732 6.6916667 0.288983 6.6944444 0.288732 6.6972222 0.287981 6.7000000 0.289233 6.7027778 0.290485 6.7055556 0.291987 6.7083333 0.292989 6.7111111 0.293239 6.7138889 0.293239 6.7166667 0.293991 6.7194444 0.295243 6.7222222 0.295994 6.7250000 0.296244 6.7277778 0.296244 6.7305556 0.296244 6.7383333 0.300000 6.8255556 0.300000 6.8305556 0.303005 6.8333333 0.303505 6.8361111 0.303255 6.8388889 0.303005 6.8416667 0.303255 6.8444444 0.303005 6.8472222 0.302754 6.8500000 0.303005 6.8527778 0.304006 6.8555556 0.303756 6.8583333 0.302754 6.8611111 0.301002 6.8638889 0.299249 6.8666667 0.297496 6.8694444 0.296745 6.8722222 0.295493 6.8750000 0.294491 6.8777778 0.293239 6.8805556 0.291236 6.8833333 0.290235 6.8861111 0.289484 6.8888889 0.289484 6.8916667 0.289484 6.8944444 0.288983 6.8972222 0.287731 6.9000000 0.287480 6.9027778 0.288232 6.9055556 0.288983 6.9083333 0.288482 6.9111111 0.288482 6.9138889 0.287981 6.9166667 0.287731 6.9194444 0.288232 6.9222222 0.288482 6.9250000 0.288232 6.9277778 0.287981 6.9305556 0.287230 6.9333333 0.287480 6.9361111 0.288482 6.9388889 0.288232 6.9416667 0.287981 6.9444444 0.286729 6.9472222 0.287230 6.9500000 0.286980 6.9527778 0.287480 6.9555556 0.288482 6.9583333 0.288232 6.9611111 0.288232 6.9638889 0.287981 6.9666667 0.288482 6.9694444 0.288732 6.9722222 0.288232 6.9750000 0.287981 6.9777778 0.287981 6.9805556 0.287981 6.9833333 0.288983 6.9861111 0.289233 6.9888889 0.289734 6.9916667 0.289484 6.9944444 0.289233 6.9972222 0.288983 7.0000000 0.288732 7.0027778 0.289484 7.0055556 0.289484 7.0083333 0.289484 7.0111111 0.289233 7.0138889 0.288232 7.0166667 0.287230 7.0194444 0.286980 7.0222222 0.286729 7.0250000 0.286729 7.0277778 0.286479 7.0305556 0.287480 7.0333333 0.292238 7.0361111 0.297997 7.0388889 0.302504 7.0416667 0.307512 7.0444444 0.310767 7.0472222 0.313772 7.0500000 0.316025 7.0527778 0.319531 7.0555556 0.324538 7.0583333 0.329797 7.0611111 0.334554 7.0638889 0.339061 7.0666667 0.343067 7.0694444 0.346823 7.0722222 0.348576 7.0750000 0.349077 7.0777778 0.347574 7.0805556 0.347074 7.0833333 0.345822 7.0861111 0.344069 7.0888889 0.340063 7.0916667 0.334304 7.0944444 0.329296 7.0972222 0.324789 7.1000000 0.320532 7.1027778 0.315775 7.1055556 0.310016 7.1083333 0.303505 7.1111111 0.294992 7.1138889 0.286729 7.1166667 0.281221 7.1194444 0.275962 7.1222222 0.270454 7.1250000 0.265947 7.1277778 0.262441 7.1305556 0.260438 7.1333333 0.258685 7.1361111 0.258435 7.1388889 0.258185 7.1416667 0.258185 7.1444444 0.258435 7.1472222 0.257684 7.1500000 0.257684 7.1527778 0.258936 7.1555556 0.261189 7.1583333 0.262191 7.1611111 0.263443 7.1638889 0.264945 7.1666667 0.266448 7.1694444 0.267449 7.1722222 0.268701 7.1750000 0.269452 7.1777778 0.269703 7.1805556 0.270454 7.1833333 0.272207 7.1861111 0.274210 7.1888889 0.275462 7.1916667 0.275462 7.1944444 0.275962 7.1972222 0.275462 7.2000000 0.276714 7.2027778 0.277214 7.2055556 0.277214 7.2083333 0.277715 7.2111111 0.277465 7.2138889 0.276964 7.2166667 0.276714 7.2194444 0.276964 7.2222222 0.276714 7.2250000 0.277214 7.2277778 0.276213 7.2305556 0.276213 7.2333333 0.276213 7.2361111 0.276964 7.2388889 0.276714 7.2416667 0.276964 7.2444444 0.276213 7.2472222 0.275712 7.2500000 0.275211 7.2527778 0.275712 7.2555556 0.275962 7.2583333 0.275962 7.2611111 0.274961 7.2638889 0.274460 7.2666667 0.274710 7.2694444 0.275462 7.2722222 0.275462 7.2750000 0.275211 7.2777778 0.275211 7.2805556 0.274961 7.2833333 0.274961 7.2861111 0.275712 7.2888889 0.276463 7.2916667 0.276213 7.2944444 0.276463 7.2972222 0.276213 7.3000000 0.276463 7.3027778 0.277465 7.3055556 0.278216 7.3083333 0.278216 7.3111111 0.278216 7.3138889 0.278466 7.3166667 0.279218 7.3194444 0.279468 7.3222222 0.280469 7.3250000 0.280469 7.3277778 0.280720 7.3305556 0.280720 7.3333333 0.281221 7.3361111 0.281721 7.3388889 0.283224 7.3416667 0.284225 7.3444444 0.284476 7.3472222 0.284225 7.3500000 0.284726 7.3527778 0.285728 7.3555556 0.287230 7.3583333 0.287731 7.3611111 0.288232 7.3638889 0.287981 7.3666667 0.288732 7.3694444 0.289233 7.3722222 0.291236 7.3750000 0.291987 7.3777778 0.292739 7.3855556 0.300000 7.4811111 0.300000 7.4861111 0.299750 7.4888889 0.299750 7.4916667 0.299750 7.4944444 0.298498 7.4972222 0.298247 7.5000000 0.298247 7.5027778 0.298247 7.5055556 0.298498 7.5083333 0.298247 7.5111111 0.296995 7.5138889 0.296745 7.5166667 0.297496 7.5194444 0.297997 7.5222222 0.297746 7.5250000 0.296995 7.5277778 0.295243 7.5305556 0.293239 7.5333333 0.291987 7.5361111 0.290986 7.5388889 0.289984 7.5416667 0.288732 7.5444444 0.286729 7.5472222 0.285477 7.5500000 0.283975 7.5527778 0.283725 7.5555556 0.283224 7.5583333 0.282723 7.5611111 0.281972 7.5638889 0.280720 7.5666667 0.281471 7.5694444 0.281972 7.5722222 0.283224 7.5750000 0.282723 7.5777778 0.282723 7.5805556 0.281972 7.5833333 0.281721 7.5861111 0.282473 7.5888889 0.283224 7.5916667 0.282973 7.5944444 0.282222 7.5972222 0.281721 7.6000000 0.281972 7.6027778 0.282723 7.6055556 0.283224 7.6083333 0.282723 7.6111111 0.281972 7.6138889 0.281721 7.6166667 0.281972 7.6194444 0.282473 7.6222222 0.283224 7.6250000 0.282723 7.6277778 0.282473 7.6305556 0.281221 7.6333333 0.282473 7.6361111 0.282973 7.6388889 0.283975 7.6416667 0.283725 7.6444444 0.283224 7.6472222 0.282723 7.6500000 0.282723 7.6527778 0.282973 7.6555556 0.283474 7.6583333 0.284726 7.6611111 0.284225 7.6638889 0.283474 7.6666667 0.283474 7.6694444 0.284476 7.6722222 0.284225 7.6750000 0.284476 7.6777778 0.283725 7.6805556 0.282222 7.6833333 0.282473 7.6861111 0.284726 7.6888889 0.288983 7.6916667 0.294491 7.6944444 0.301002 7.6972222 0.306009 7.7000000 0.310016 7.7027778 0.314272 7.7055556 0.317277 7.7083333 0.319781 7.7111111 0.321534 7.7138889 0.324789 7.7166667 0.328294 7.7194444 0.332801 7.7222222 0.337058 7.7250000 0.340313 7.7277778 0.341064 7.7305556 0.339812 7.7333333 0.337809 7.7361111 0.336557 7.7388889 0.335055 7.7416667 0.332551 7.7444444 0.328044 7.7472222 0.322285 7.7500000 0.318279 7.7527778 0.314773 7.7555556 0.310516 7.7583333 0.305509 7.7611111 0.300250 7.7638889 0.292488 7.7666667 0.284726 7.7694444 0.277465 7.7722222 0.272207 7.7750000 0.266948 7.7777778 0.261440 7.7805556 0.256432 7.7833333 0.253678 7.7861111 0.252426 7.7888889 0.251424 7.7916667 0.251925 7.7944444 0.251174 7.7972222 0.251174 7.8000000 0.252426 7.8027778 0.252926 7.8055556 0.254178 7.8083333 0.255180 7.8111111 0.256933 7.8138889 0.257934 7.8166667 0.258936 7.8194444 0.261189 7.8222222 0.262441 7.8250000 0.263944 7.8277778 0.263693 7.8305556 0.264695 7.8333333 0.265696 7.8361111 0.267950 7.8388889 0.269452 7.8416667 0.269452 7.8444444 0.269953 7.8472222 0.269452 7.8500000 0.271205 7.8527778 0.272707 7.8555556 0.273459 7.8583333 0.273459 7.8611111 0.272707 7.8638889 0.272207 7.8666667 0.271956 7.8694444 0.272207 7.8722222 0.272457 7.8750000 0.272707 7.8777778 0.271956 7.8805556 0.271706 7.8833333 0.271706 7.8861111 0.271706 7.8888889 0.272958 7.8916667 0.271956 7.8944444 0.271706 7.8972222 0.270955 7.9000000 0.271706 7.9027778 0.272207 7.9055556 0.272958 7.9083333 0.272457 7.9111111 0.271956 7.9138889 0.271956 7.9166667 0.272707 7.9194444 0.272958 7.9222222 0.273709 7.9250000 0.273208 7.9277778 0.273208 7.9305556 0.272707 7.9333333 0.273208 7.9361111 0.273709 7.9388889 0.274460 7.9416667 0.274710 7.9444444 0.274961 7.9472222 0.274961 7.9500000 0.276213 7.9527778 0.276964 7.9555556 0.278216 7.9583333 0.278216 7.9611111 0.277715 7.9638889 0.277715 7.9666667 0.278967 7.9694444 0.279468 7.9722222 0.280219 7.9750000 0.280720 7.9777778 0.279969 7.9805556 0.280970 7.9833333 0.281471 7.9861111 0.281972 7.9888889 0.282973 7.9916667 0.283975 7.9944444 0.283725 7.9972222 0.283474 8.0000000 0.284225 8.0027778 0.285728 8.0055556 0.286729 8.0083333 0.287230 8.0111111 0.288482 8.0138889 0.288732 8.0166667 0.289484 8.0194444 0.289734 8.0222222 0.291236 8.0250000 0.291236 8.0277778 0.291987 8.0305556 0.291236 8.0333333 0.291487 8.0411111 0.300000 8.1311111 0.300000 8.1361111 0.296244 8.1388889 0.296745 8.1416667 0.296495 8.1444444 0.296244 8.1472222 0.295243 8.1500000 0.294742 8.1527778 0.295493 8.1555556 0.295994 8.1583333 0.295994 8.1611111 0.295493 8.1638889 0.294491 8.1666667 0.293490 8.1694444 0.293239 8.1722222 0.291487 8.1750000 0.290736 8.1777778 0.288732 8.1805556 0.286729 8.1833333 0.285477 8.1861111 0.284726 8.1888889 0.283725 8.1916667 0.282973 8.1944444 0.281721 8.1972222 0.281972 8.2000000 0.282222 8.2027778 0.282473 8.2055556 0.282222 8.2083333 0.281972 8.2111111 0.281721 8.2138889 0.281221 8.2166667 0.281721 8.2194444 0.281721 8.2222222 0.282473 8.2250000 0.281972 8.2277778 0.280970 8.2305556 0.281471 8.2333333 0.281471 8.2361111 0.282473 8.2388889 0.282222 8.2416667 0.281221 8.2444444 0.280970 8.2472222 0.280219 8.2500000 0.280970 8.2527778 0.281721 8.2555556 0.282222 8.2583333 0.283224 8.2611111 0.282222 8.2638889 0.281721 8.2666667 0.281721 8.2694444 0.281471 8.2722222 0.282222 8.2750000 0.281972 8.2777778 0.281972 8.2805556 0.281471 8.2833333 0.281972 8.2861111 0.281721 8.2888889 0.282473 8.2916667 0.282473 8.2944444 0.282723 8.2972222 0.281471 8.3000000 0.281721 8.3027778 0.282222 8.3055556 0.282473 8.3083333 0.282723 8.3111111 0.282973 8.3138889 0.283474 8.3166667 0.283725 8.3194444 0.283975 8.3222222 0.283224 8.3250000 0.281972 8.3277778 0.280970 8.3305556 0.280469 8.3333333 0.281721 8.3361111 0.283975 8.3388889 0.289734 8.3416667 0.295994 8.3444444 0.301252 8.3472222 0.304257 8.3500000 0.307261 8.3527778 0.308513 8.3555556 0.309765 8.3583333 0.312019 8.3611111 0.314773 8.3638889 0.317778 8.3666667 0.321534 8.3694444 0.325540 8.3722222 0.329296 8.3750000 0.329797 8.3777778 0.329546 8.3805556 0.327543 8.3833333 0.327293 8.3861111 0.327042 8.3888889 0.326541 8.3916667 0.325290 8.3944444 0.321784 8.3972222 0.318028 8.4000000 0.315023 8.4027778 0.311768 8.4055556 0.308764 8.4083333 0.305509 8.4111111 0.300000 8.4138889 0.293740 8.4166667 0.287731 8.4194444 0.282222 8.4222222 0.276714 8.4250000 0.270203 8.4277778 0.264945 8.4305556 0.260438 8.4333333 0.257934 8.4361111 0.257183 8.4388889 0.256682 8.4416667 0.256432 8.4444444 0.255681 8.4472222 0.255430 8.4500000 0.255430 8.4527778 0.256182 8.4555556 0.257183 8.4583333 0.257934 8.4611111 0.258685 8.4638889 0.260438 8.4666667 0.262191 8.4694444 0.263693 8.4722222 0.264695 8.4750000 0.265446 8.4777778 0.265696 8.4805556 0.266448 8.4833333 0.268200 8.4861111 0.269953 8.4888889 0.270704 8.4916667 0.271205 8.4944444 0.271706 8.4972222 0.271455 8.5000000 0.271956 8.5027778 0.272958 8.5055556 0.273709 8.5083333 0.273459 8.5111111 0.272958 8.5138889 0.272958 8.5166667 0.272707 8.5194444 0.272958 8.5222222 0.273459 8.5250000 0.272958 8.5277778 0.272707 8.5305556 0.271956 8.5333333 0.271455 8.5361111 0.272457 8.5388889 0.273459 8.5416667 0.273709 8.5444444 0.273208 8.5472222 0.272457 8.5500000 0.271956 8.5527778 0.272958 8.5555556 0.273208 8.5583333 0.273208 8.5611111 0.273208 8.5638889 0.273208 8.5666667 0.272958 8.5694444 0.272707 8.5722222 0.272207 8.5750000 0.272457 8.5777778 0.272707 8.5805556 0.272707 8.5833333 0.273208 8.5861111 0.273709 8.5888889 0.274460 8.5916667 0.274710 8.5944444 0.275712 8.5972222 0.274961 8.6000000 0.275712 8.6027778 0.276964 8.6055556 0.278216 8.6083333 0.277966 8.6111111 0.277966 8.6138889 0.278216 8.6166667 0.279218 8.6194444 0.279969 8.6222222 0.280219 8.6250000 0.280970 8.6277778 0.280469 8.6305556 0.281471 8.6333333 0.282473 8.6361111 0.283474 8.6388889 0.284225 8.6416667 0.284476 8.6444444 0.284977 8.6472222 0.284726 8.6500000 0.285477 8.6527778 0.286228 8.6555556 0.287480 8.6583333 0.288482 8.6611111 0.288482 8.6638889 0.287731 8.6666667 0.288482 8.6694444 0.289484 8.6722222 0.290736 8.6750000 0.291737 8.6777778 0.291737 8.6805556 0.291236 8.6833333 0.291737 8.6911111 0.300000 8.7616667 0.300000 8.7666667 0.297496 8.7694444 0.297746 8.7722222 0.298247 8.7750000 0.298498 8.7777778 0.297246 8.7805556 0.296244 8.7833333 0.295243 8.7861111 0.293991 8.7888889 0.293740 8.7916667 0.293490 8.7944444 0.292989 8.7972222 0.292989 8.8000000 0.293239 8.8027778 0.293239 8.8055556 0.291987 8.8083333 0.290986 8.8111111 0.289233 8.8138889 0.289233 8.8166667 0.289233 8.8194444 0.289233 8.8222222 0.287731 8.8250000 0.284476 8.8277778 0.280720 8.8305556 0.279718 8.8333333 0.280970 8.8361111 0.282723 8.8388889 0.283474 8.8416667 0.282973 8.8444444 0.280219 8.8472222 0.277966 8.8500000 0.278216 8.8527778 0.278717 8.8555556 0.279718 8.8583333 0.280219 8.8611111 0.279969 8.8638889 0.279468 8.8666667 0.280219 8.8694444 0.280469 8.8722222 0.280219 8.8750000 0.280469 8.8777778 0.280219 8.8805556 0.279969 8.8833333 0.280720 8.8861111 0.280469 8.8888889 0.281471 8.8916667 0.280970 8.8944444 0.280720 8.8972222 0.280469 8.9000000 0.280720 8.9027778 0.281471 8.9055556 0.282222 8.9083333 0.281721 8.9111111 0.280970 8.9138889 0.280970 8.9166667 0.280720 8.9194444 0.281471 8.9222222 0.282222 8.9250000 0.281471 8.9277778 0.281221 8.9305556 0.281721 8.9333333 0.282222 8.9361111 0.282473 8.9388889 0.282723 8.9416667 0.282973 8.9444444 0.282973 8.9472222 0.282222 8.9500000 0.281471 8.9527778 0.281972 8.9555556 0.280720 8.9583333 0.280469 8.9611111 0.279718 8.9638889 0.279468 8.9666667 0.281471 8.9694444 0.285477 8.9722222 0.291487 8.9750000 0.296745 8.9777778 0.300751 8.9805556 0.302754 8.9833333 0.304006 8.9861111 0.305759 8.9888889 0.309765 8.9916667 0.313772 8.9944444 0.318279 8.9972222 0.321784 9.0000000 0.325290 9.0027778 0.328545 9.0055556 0.330548 9.0083333 0.331299 9.0111111 0.330548 9.0138889 0.330047 9.0166667 0.330047 9.0194444 0.328294 9.0222222 0.325790 9.0250000 0.321283 9.0277778 0.317027 9.0305556 0.313772 9.0333333 0.311518 9.0361111 0.308513 9.0388889 0.303255 9.0416667 0.297496 9.0444444 0.290235 9.0472222 0.283474 9.0500000 0.276714 9.0527778 0.270955 9.0555556 0.266698 9.0583333 0.263693 9.0611111 0.260689 9.0638889 0.258685 9.0666667 0.257433 9.0694444 0.257183 9.0722222 0.256933 9.0750000 0.257934 9.0777778 0.257433 9.0805556 0.256432 9.0833333 0.256432 9.0861111 0.257684 9.0888889 0.259437 9.0916667 0.261189 9.0944444 0.262191 9.0972222 0.261941 9.1000000 0.264194 9.1027778 0.265196 9.1055556 0.265947 9.1083333 0.267449 9.1111111 0.267950 9.1138889 0.269202 9.1166667 0.270203 9.1194444 0.271455 9.1222222 0.272707 9.1250000 0.272958 9.1277778 0.273459 9.1305556 0.272457 9.1333333 0.272958 9.1361111 0.273959 9.1388889 0.274460 9.1416667 0.274961 9.1444444 0.274210 9.1472222 0.273459 9.1500000 0.273959 9.1527778 0.274460 9.1555556 0.274710 9.1583333 0.273709 9.1611111 0.273208 9.1638889 0.272457 9.1666667 0.272457 9.1694444 0.272707 9.1722222 0.273208 9.1750000 0.273709 9.1777778 0.273208 9.1805556 0.272707 9.1833333 0.272707 9.1861111 0.273459 9.1888889 0.273459 9.1916667 0.272958 9.1944444 0.273208 9.1972222 0.272457 9.2000000 0.272707 9.2027778 0.273208 9.2055556 0.273709 9.2083333 0.273709 9.2111111 0.273459 9.2138889 0.273709 9.2166667 0.273959 9.2194444 0.274460 9.2222222 0.275712 9.2250000 0.275712 9.2277778 0.275211 9.2305556 0.274961 9.2333333 0.276213 9.2361111 0.276964 9.2388889 0.278216 9.2416667 0.278216 9.2444444 0.278717 9.2472222 0.279468 9.2500000 0.280469 9.2527778 0.281721 9.2555556 0.281972 9.2583333 0.282473 9.2611111 0.283224 9.2638889 0.282723 9.2666667 0.282723 9.2694444 0.283474 9.2722222 0.283725 9.2750000 0.283975 9.2777778 0.284225 9.2805556 0.283975 9.2833333 0.284726 9.2861111 0.284977 9.2888889 0.285728 9.2916667 0.287981 9.2944444 0.289984 9.2972222 0.291487 9.3000000 0.291737 9.3027778 0.291487 9.3055556 0.290485 9.3083333 0.289233 9.3111111 0.287731 9.3138889 0.288232 9.3216667 0.300000 9.3950000 0.300000 9.4000000 0.298247 9.4027778 0.298247 9.4055556 0.298748 9.4083333 0.297496 9.4111111 0.296495 9.4138889 0.296244 9.4166667 0.296244 9.4194444 0.296995 9.4222222 0.296995 9.4250000 0.297246 9.4277778 0.296495 9.4305556 0.296495 9.4333333 0.296495 9.4361111 0.295743 9.4388889 0.294742 9.4416667 0.292238 9.4444444 0.290736 9.4472222 0.288983 9.4500000 0.287731 9.4527778 0.286228 9.4555556 0.285477 9.4583333 0.284476 9.4611111 0.283725 9.4638889 0.281972 9.4666667 0.282473 9.4694444 0.282222 9.4722222 0.282222 9.4750000 0.281972 9.4777778 0.281972 9.4805556 0.281221 9.4833333 0.280219 9.4861111 0.281471 9.4888889 0.281221 9.4916667 0.281471 9.4944444 0.280970 9.4972222 0.279969 9.5000000 0.280469 9.5027778 0.280970 9.5055556 0.281471 9.5083333 0.281221 9.5111111 0.279969 9.5138889 0.279969 9.5166667 0.280720 9.5194444 0.280970 9.5222222 0.281721 9.5250000 0.281721 9.5277778 0.280469 9.5305556 0.280720 9.5333333 0.281221 9.5361111 0.281721 9.5388889 0.282473 9.5416667 0.281972 9.5444444 0.281471 9.5472222 0.281221 9.5500000 0.281721 9.5527778 0.281721 9.5555556 0.281972 9.5583333 0.282473 9.5611111 0.282222 9.5638889 0.281972 9.5666667 0.282222 9.5694444 0.282723 9.5722222 0.283224 9.5750000 0.283224 9.5777778 0.282473 9.5805556 0.281972 9.5833333 0.281471 9.5861111 0.281972 9.5888889 0.281221 9.5916667 0.279718 9.5944444 0.278717 9.5972222 0.278717 9.6000000 0.280970 9.6027778 0.284977 9.6055556 0.289984 9.6083333 0.295493 9.6111111 0.300250 9.6138889 0.303756 9.6166667 0.306260 9.6194444 0.308263 9.6222222 0.312269 9.6250000 0.317277 9.6277778 0.322786 9.6305556 0.326792 9.6333333 0.332050 9.6361111 0.336307 9.6388889 0.339311 9.6416667 0.341064 9.6444444 0.341064 9.6472222 0.339812 9.6500000 0.338811 9.6527778 0.337809 9.6555556 0.335055 9.6583333 0.330047 9.6611111 0.325039 9.6638889 0.320532 9.6666667 0.316526 9.6694444 0.313521 9.6722222 0.308513 9.6750000 0.302504 9.6777778 0.294742 9.6805556 0.286729 9.6833333 0.280720 9.6861111 0.274961 9.6888889 0.268951 9.6916667 0.262692 9.6944444 0.259437 9.6972222 0.256933 9.7000000 0.255180 9.7027778 0.254679 9.7055556 0.254930 9.7083333 0.254930 9.7111111 0.254178 9.7138889 0.253427 9.7166667 0.254178 9.7194444 0.255180 9.7222222 0.257183 9.7250000 0.258936 9.7277778 0.260689 9.7305556 0.261189 9.7333333 0.262692 9.7361111 0.264194 9.7388889 0.264444 9.7416667 0.265947 9.7444444 0.266448 9.7472222 0.266448 9.7500000 0.268200 9.7527778 0.269452 9.7555556 0.270955 9.7583333 0.271706 9.7611111 0.271205 9.7638889 0.271455 9.7666667 0.272207 9.7694444 0.272707 9.7722222 0.272707 9.7750000 0.273459 9.7777778 0.272707 9.7805556 0.271956 9.7833333 0.272457 9.7861111 0.273208 9.7888889 0.273208 9.7916667 0.272707 9.7944444 0.272457 9.7972222 0.272207 9.8000000 0.271956 9.8027778 0.272207 9.8055556 0.272207 9.8083333 0.271956 9.8111111 0.271455 9.8138889 0.270955 9.8166667 0.271706 9.8194444 0.272457 9.8222222 0.272457 9.8250000 0.272457 9.8277778 0.271956 9.8305556 0.271205 9.8333333 0.271706 9.8361111 0.271956 9.8388889 0.272207 9.8416667 0.272958 9.8444444 0.272457 9.8472222 0.272457 9.8500000 0.271956 9.8527778 0.272707 9.8555556 0.273459 9.8583333 0.274210 9.8611111 0.274210 9.8638889 0.273709 9.8666667 0.274710 9.8694444 0.275462 9.8722222 0.275712 9.8750000 0.276463 9.8777778 0.276964 9.8805556 0.276714 9.8833333 0.277465 9.8861111 0.278466 9.8888889 0.279468 9.8916667 0.280219 9.8944444 0.280219 9.8972222 0.280469 9.9000000 0.280720 9.9027778 0.281721 9.9055556 0.283975 9.9083333 0.283975 9.9111111 0.284476 9.9138889 0.283975 9.9166667 0.285227 9.9194444 0.286228 9.9222222 0.286729 9.9250000 0.286729 9.9277778 0.287480 9.9305556 0.287731 9.9333333 0.288232 9.9361111 0.289484 9.9388889 0.290235 9.9416667 0.290736 9.9444444 0.290986 9.9472222 0.290736 9.9550000 0.300000 10.0144444 0.300000 10.0194444 0.298247 10.0222222 0.298998 10.0250000 0.299499 10.0277778 0.298998 10.0305556 0.298498 10.0333333 0.298247 10.0361111 0.298498 10.0388889 0.298748 10.0416667 0.298498 10.0444444 0.298247 10.0472222 0.297246 10.0500000 0.296745 10.0527778 0.296495 10.0555556 0.297246 10.0583333 0.296495 10.0611111 0.296495 10.0638889 0.295994 10.0666667 0.295994 10.0694444 0.296244 10.0722222 0.295243 10.0750000 0.293991 10.0777778 0.291987 10.0805556 0.288983 10.0833333 0.287981 10.0861111 0.286729 10.0888889 0.286228 10.0916667 0.284977 10.0944444 0.283224 10.0972222 0.282222 10.1000000 0.282473 10.1027778 0.281972 10.1055556 0.282222 10.1083333 0.281972 10.1111111 0.280970 10.1138889 0.279718 10.1166667 0.279969 10.1194444 0.280720 10.1222222 0.281221 10.1250000 0.281471 10.1277778 0.280970 10.1305556 0.280219 10.1333333 0.280469 10.1361111 0.280970 10.1388889 0.280970 10.1416667 0.280720 10.1444444 0.280469 10.1472222 0.280219 10.1500000 0.280469 10.1527778 0.280970 10.1555556 0.280970 10.1583333 0.280469 10.1611111 0.280219 10.1638889 0.279218 10.1666667 0.280219 10.1694444 0.280720 10.1722222 0.281471 10.1750000 0.281471 10.1777778 0.281471 10.1805556 0.280469 10.1833333 0.280219 10.1861111 0.280219 10.1888889 0.280970 10.1916667 0.281221 10.1944444 0.280970 10.1972222 0.280219 10.2000000 0.280720 10.2027778 0.281221 10.2055556 0.281721 10.2083333 0.281471 10.2111111 0.281221 10.2138889 0.279969 10.2166667 0.279718 10.2194444 0.278717 10.2222222 0.279218 10.2250000 0.279969 10.2277778 0.281471 10.2305556 0.287230 10.2333333 0.294992 10.2361111 0.303505 10.2388889 0.309264 10.2416667 0.313521 10.2444444 0.316025 10.2472222 0.318779 10.2500000 0.324538 10.2527778 0.330548 10.2555556 0.335806 10.2583333 0.341064 10.2611111 0.345070 10.2638889 0.346072 10.2666667 0.346573 10.2694444 0.345571 10.2722222 0.344319 10.2750000 0.340814 10.2777778 0.335305 10.2805556 0.328545 10.2833333 0.322034 10.2861111 0.316275 10.2888889 0.312019 10.2916667 0.305509 10.2944444 0.298748 10.2972222 0.289734 10.3000000 0.281221 10.3027778 0.274210 10.3055556 0.267700 10.3083333 0.260689 10.3111111 0.254930 10.3138889 0.250923 10.3166667 0.249421 10.3194444 0.248419 10.3222222 0.247919 10.3250000 0.248920 10.3277778 0.249171 10.3305556 0.248670 10.3333333 0.249421 10.3361111 0.250423 10.3388889 0.252175 10.3416667 0.254679 10.3444444 0.256432 10.3472222 0.257934 10.3500000 0.258435 10.3527778 0.260438 10.3555556 0.260939 10.3583333 0.262441 10.3611111 0.263192 10.3638889 0.264194 10.3666667 0.265696 10.3694444 0.267199 10.3722222 0.268451 10.3750000 0.268951 10.3777778 0.268951 10.3805556 0.268200 10.3833333 0.268701 10.3861111 0.269452 10.3888889 0.269703 10.3916667 0.269452 10.3944444 0.268701 10.3972222 0.268451 10.4000000 0.268200 10.4027778 0.268451 10.4055556 0.268951 10.4083333 0.268701 10.4111111 0.267950 10.4138889 0.267950 10.4166667 0.267950 10.4194444 0.267700 10.4222222 0.267950 10.4250000 0.267700 10.4277778 0.268200 10.4305556 0.267449 10.4333333 0.267449 10.4361111 0.268451 10.4388889 0.268451 10.4416667 0.268701 10.4444444 0.267950 10.4472222 0.267700 10.4500000 0.268200 10.4527778 0.268701 10.4555556 0.269452 10.4583333 0.269452 10.4611111 0.269202 10.4638889 0.269202 10.4666667 0.270203 10.4694444 0.270955 10.4722222 0.271706 10.4750000 0.271455 10.4777778 0.271706 10.4805556 0.272457 10.4833333 0.273459 10.4861111 0.274460 10.4888889 0.275462 10.4916667 0.275211 10.4944444 0.276213 10.4972222 0.275962 10.5000000 0.276964 10.5027778 0.277966 10.5055556 0.278967 10.5083333 0.279718 10.5111111 0.280219 10.5138889 0.280720 10.5166667 0.281221 10.5194444 0.281972 10.5222222 0.283474 10.5250000 0.284726 10.5277778 0.284726 10.5305556 0.283725 10.5333333 0.284977 10.5361111 0.285978 10.5388889 0.287230 10.5416667 0.287981 10.5444444 0.288232 10.5472222 0.288732 10.5500000 0.289233 10.5527778 0.289734 10.5555556 0.290736 10.5583333 0.291487 10.5611111 0.291487 10.5638889 0.291737 10.5666667 0.292739 10.5744444 0.300000 10.6144444 0.300000 10.6194444 0.295994 10.6222222 0.296495 10.6250000 0.295493 10.6277778 0.295243 10.6305556 0.294992 10.6333333 0.295243 10.6361111 0.294992 10.6388889 0.294491 10.6416667 0.293740 10.6444444 0.292989 10.6472222 0.292488 10.6500000 0.292739 10.6527778 0.292989 10.6555556 0.293991 10.6583333 0.293490 10.6611111 0.292238 10.6638889 0.290736 10.6666667 0.288983 10.6694444 0.288232 10.6722222 0.286729 10.6750000 0.284476 10.6777778 0.281972 10.6805556 0.279718 10.6833333 0.279468 10.6861111 0.279718 10.6888889 0.278967 10.6916667 0.278967 10.6944444 0.278216 10.6972222 0.276964 10.7000000 0.277214 10.7027778 0.277715 10.7055556 0.277465 10.7083333 0.277715 10.7111111 0.277214 10.7138889 0.276714 10.7166667 0.276964 10.7194444 0.276964 10.7222222 0.276964 10.7250000 0.276964 10.7277778 0.276463 10.7305556 0.275962 10.7333333 0.276213 10.7361111 0.276714 10.7388889 0.277465 10.7416667 0.277465 10.7444444 0.277715 10.7472222 0.277715 10.7500000 0.277966 10.7527778 0.277715 10.7555556 0.277715 10.7583333 0.277214 10.7611111 0.277465 10.7638889 0.277465 10.7666667 0.277715 10.7694444 0.277966 10.7722222 0.278466 10.7750000 0.278717 10.7777778 0.278466 10.7805556 0.277715 10.7833333 0.277966 10.7861111 0.278967 10.7888889 0.278967 10.7916667 0.279468 10.7944444 0.279218 10.7972222 0.278967 10.8000000 0.279468 10.8027778 0.278967 10.8055556 0.279218 10.8083333 0.279468 10.8111111 0.279468 10.8138889 0.277715 10.8166667 0.277715 10.8194444 0.278216 10.8222222 0.279218 10.8250000 0.281471 10.8277778 0.285978 10.8305556 0.291987 10.8333333 0.299249 10.8361111 0.305008 10.8388889 0.309765 10.8416667 0.313020 10.8444444 0.313772 10.8472222 0.315274 10.8500000 0.319280 10.8527778 0.324288 10.8555556 0.328795 10.8583333 0.332050 10.8611111 0.334804 10.8638889 0.334804 10.8666667 0.333803 10.8694444 0.332050 10.8722222 0.330548 10.8750000 0.328545 10.8777778 0.325290 10.8805556 0.320031 10.8833333 0.315524 10.8861111 0.311268 10.8888889 0.306761 10.8916667 0.302754 10.8944444 0.297496 10.8972222 0.290485 10.9000000 0.282723 10.9027778 0.275962 10.9055556 0.269703 10.9083333 0.263192 10.9111111 0.257183 10.9138889 0.252676 10.9166667 0.249922 10.9194444 0.249171 10.9222222 0.248419 10.9250000 0.248419 10.9277778 0.248419 10.9305556 0.248419 10.9333333 0.248670 10.9361111 0.249671 10.9388889 0.251424 10.9416667 0.253177 10.9444444 0.254679 10.9472222 0.255681 10.9500000 0.257433 10.9527778 0.258936 10.9555556 0.259437 10.9583333 0.260188 10.9611111 0.260939 10.9638889 0.262191 10.9666667 0.264444 10.9694444 0.265947 10.9722222 0.266948 10.9750000 0.267449 10.9777778 0.267199 10.9805556 0.267449 10.9833333 0.268200 10.9861111 0.268701 10.9888889 0.268701 10.9916667 0.268701 10.9944444 0.268951 10.9972222 0.267950 11.0000000 0.267950 11.0027778 0.268451 11.0055556 0.269452 11.0083333 0.268701 11.0111111 0.268701 11.0138889 0.267449 11.0166667 0.268451 11.0194444 0.268701 11.0222222 0.268951 11.0250000 0.268451 11.0277778 0.267950 11.0305556 0.267700 11.0333333 0.267950 11.0361111 0.268701 11.0388889 0.269703 11.0416667 0.268701 11.0444444 0.268701 11.0472222 0.268451 11.0500000 0.269202 11.0527778 0.269452 11.0555556 0.270203 11.0583333 0.270955 11.0611111 0.270704 11.0638889 0.270704 11.0666667 0.271455 11.0694444 0.272207 11.0722222 0.272707 11.0750000 0.273459 11.0777778 0.273709 11.0805556 0.274210 11.0833333 0.274961 11.0861111 0.276213 11.0888889 0.277214 11.0916667 0.277465 11.0944444 0.278466 11.0972222 0.278216 11.1000000 0.278717 11.1027778 0.280219 11.1055556 0.281221 11.1083333 0.281972 11.1111111 0.282723 11.1138889 0.282723 11.1166667 0.283725 11.1194444 0.284726 11.1222222 0.285728 11.1250000 0.286228 11.1277778 0.286729 11.1305556 0.286729 11.1333333 0.287731 11.1361111 0.288482 11.1388889 0.289233 11.1416667 0.289984 11.1444444 0.290235 11.1472222 0.290235 11.1500000 0.290986 11.1527778 0.291487 11.1555556 0.292488 11.1583333 0.292739 11.1611111 0.292739 11.1638889 0.293490 11.1666667 0.293239 11.1744444 0.300000 11.1977778 0.300000 11.2027778 0.294241 11.2055556 0.294992 11.2083333 0.295743 11.2111111 0.295743 11.2138889 0.294992 11.2166667 0.295743 11.2194444 0.295493 11.2222222 0.295493 11.2250000 0.295493 11.2277778 0.294491 11.2305556 0.293740 11.2333333 0.293740 11.2361111 0.294241 11.2388889 0.293991 11.2416667 0.293991 11.2444444 0.293239 11.2472222 0.292989 11.2500000 0.292989 11.2527778 0.292238 11.2555556 0.291487 11.2583333 0.289484 11.2611111 0.287731 11.2638889 0.286228 11.2666667 0.284726 11.2694444 0.283975 11.2722222 0.282473 11.2750000 0.281221 11.2777778 0.280469 11.2805556 0.279218 11.2833333 0.279218 11.2861111 0.279468 11.2888889 0.279468 11.2916667 0.279468 11.2944444 0.279218 11.2972222 0.278717 11.3000000 0.278717 11.3027778 0.278717 11.3055556 0.279218 11.3083333 0.278717 11.3111111 0.278717 11.3138889 0.278216 11.3166667 0.278466 11.3194444 0.279218 11.3222222 0.279468 11.3250000 0.279218 11.3277778 0.278717 11.3305556 0.278466 11.3333333 0.278216 11.3361111 0.278466 11.3388889 0.279468 11.3416667 0.279718 11.3444444 0.278216 11.3472222 0.279468 11.3500000 0.279218 11.3527778 0.279218 11.3555556 0.279718 11.3583333 0.279718 11.3611111 0.278967 11.3638889 0.278717 11.3666667 0.279718 11.3694444 0.279969 11.3722222 0.280219 11.3750000 0.280720 11.3777778 0.280720 11.3805556 0.280219 11.3833333 0.280720 11.3861111 0.281221 11.3888889 0.281471 11.3916667 0.281221 11.3944444 0.280469 11.3972222 0.278967 11.4000000 0.278967 11.4027778 0.279218 11.4055556 0.280469 11.4083333 0.284726 11.4111111 0.290736 11.4138889 0.296745 11.4166667 0.302003 11.4194444 0.305509 11.4222222 0.307011 11.4250000 0.307762 11.4277778 0.310767 11.4305556 0.315274 11.4333333 0.320282 11.4361111 0.324789 11.4388889 0.328795 11.4416667 0.331549 11.4444444 0.332801 11.4472222 0.332050 11.4500000 0.331549 11.4527778 0.331299 11.4555556 0.331299 11.4583333 0.328795 11.4611111 0.325039 11.4638889 0.320031 11.4666667 0.316275 11.4694444 0.314022 11.4722222 0.310516 11.4750000 0.307261 11.4777778 0.302003 11.4805556 0.295493 11.4833333 0.288732 11.4861111 0.280970 11.4888889 0.275712 11.4916667 0.268701 11.4944444 0.262942 11.4972222 0.258936 11.5000000 0.256432 11.5027778 0.255681 11.5055556 0.254930 11.5083333 0.253678 11.5111111 0.253427 11.5138889 0.253177 11.5166667 0.254178 11.5194444 0.254178 11.5222222 0.255180 11.5250000 0.256432 11.5277778 0.257433 11.5305556 0.258936 11.5333333 0.260438 11.5361111 0.262692 11.5388889 0.263443 11.5416667 0.264194 11.5444444 0.263944 11.5472222 0.265196 11.5500000 0.266948 11.5527778 0.268451 11.5555556 0.269703 11.5583333 0.270203 11.5611111 0.270454 11.5638889 0.270704 11.5666667 0.271455 11.5694444 0.271455 11.5722222 0.272207 11.5750000 0.272207 11.5777778 0.271956 11.5805556 0.270955 11.5833333 0.271455 11.5861111 0.271455 11.5888889 0.271706 11.5916667 0.271455 11.5944444 0.271706 11.5972222 0.270704 11.6000000 0.271205 11.6027778 0.271205 11.6055556 0.271706 11.6083333 0.271205 11.6111111 0.270704 11.6138889 0.270203 11.6166667 0.270704 11.6194444 0.270704 11.6222222 0.270955 11.6250000 0.270704 11.6277778 0.270454 11.6305556 0.270704 11.6333333 0.270704 11.6361111 0.271706 11.6388889 0.272207 11.6416667 0.272457 11.6444444 0.271956 11.6472222 0.271706 11.6500000 0.272457 11.6527778 0.273208 11.6555556 0.273959 11.6583333 0.273959 11.6611111 0.273959 11.6638889 0.273959 11.6666667 0.274710 11.6694444 0.275712 11.6722222 0.276964 11.6750000 0.276964 11.6777778 0.277465 11.6805556 0.276964 11.6833333 0.277966 11.6861111 0.279468 11.6888889 0.280970 11.6916667 0.280970 11.6944444 0.281972 11.6972222 0.281972 11.7000000 0.282973 11.7027778 0.283975 11.7055556 0.284476 11.7083333 0.285728 11.7111111 0.285477 11.7138889 0.285978 11.7166667 0.286980 11.7194444 0.288232 11.7222222 0.288983 11.7250000 0.289484 11.7277778 0.289734 11.7305556 0.289984 11.7333333 0.290986 11.7361111 0.291487 11.7388889 0.292488 11.7416667 0.292989 11.7444444 0.292739 11.7472222 0.292739 11.7500000 0.293991 11.7577778 0.300000 11.8033333 0.300000 11.8083333 0.298998 11.8111111 0.298498 11.8138889 0.298498 11.8166667 0.298247 11.8194444 0.297496 11.8222222 0.298498 11.8250000 0.298247 11.8277778 0.297997 11.8305556 0.297246 11.8333333 0.296745 11.8361111 0.296244 11.8388889 0.296495 11.8416667 0.296495 11.8444444 0.296244 11.8472222 0.295743 11.8500000 0.296495 11.8527778 0.295994 11.8555556 0.295493 11.8583333 0.292989 11.8611111 0.291236 11.8638889 0.289233 11.8666667 0.287731 11.8694444 0.286980 11.8722222 0.286228 11.8750000 0.284977 11.8777778 0.282973 11.8805556 0.282222 11.8833333 0.282473 11.8861111 0.282973 11.8888889 0.282222 11.8916667 0.282222 11.8944444 0.280970 11.8972222 0.280720 11.9000000 0.280720 11.9027778 0.281221 11.9055556 0.280970 11.9083333 0.281221 11.9111111 0.281471 11.9138889 0.281221 11.9166667 0.280720 11.9194444 0.281471 11.9222222 0.281721 11.9250000 0.281721 11.9277778 0.281221 11.9305556 0.280970 11.9333333 0.281471 11.9361111 0.281972 11.9388889 0.282222 11.9416667 0.282473 11.9444444 0.281471 11.9472222 0.280970 11.9500000 0.281721 11.9527778 0.281471 11.9555556 0.282222 11.9583333 0.281721 11.9611111 0.282222 11.9638889 0.282473 11.9666667 0.282473 11.9694444 0.282973 11.9722222 0.283474 11.9750000 0.283474 11.9777778 0.283224 11.9805556 0.282973 11.9833333 0.282973 11.9861111 0.283725 11.9888889 0.284726 11.9916667 0.283975 11.9944444 0.283224 11.9972222 0.281972 12.0000000 0.281221 12.0027778 0.280970 12.0055556 0.280219 12.0083333 0.281221 12.0111111 0.282723 12.0138889 0.286479 12.0166667 0.293740 12.0194444 0.299750 12.0222222 0.304257 12.0250000 0.306260 12.0277778 0.307261 12.0305556 0.309264 12.0333333 0.314773 12.0361111 0.320282 12.0388889 0.326291 12.0416667 0.330798 12.0444444 0.334804 12.0472222 0.337308 12.0500000 0.339311 12.0527778 0.340563 12.0555556 0.341064 12.0583333 0.340814 12.0611111 0.338811 12.0638889 0.335806 12.0666667 0.331299 12.0694444 0.326541 12.0722222 0.322786 12.0750000 0.319531 12.0777778 0.314523 12.0805556 0.308013 12.0833333 0.302754 12.0861111 0.296495 12.0888889 0.288983 12.0916667 0.280970 12.0944444 0.273208 12.0972222 0.267199 12.1000000 0.262942 12.1027778 0.261189 12.1055556 0.259687 12.1083333 0.257684 12.1111111 0.256933 12.1138889 0.255931 12.1166667 0.256182 12.1194444 0.256432 12.1222222 0.256682 12.1250000 0.256682 12.1277778 0.257433 12.1305556 0.257934 12.1333333 0.260438 12.1361111 0.262441 12.1388889 0.264194 12.1416667 0.264695 12.1444444 0.264945 12.1472222 0.265696 12.1500000 0.267199 12.1527778 0.268451 12.1555556 0.270454 12.1583333 0.270955 12.1611111 0.271455 12.1638889 0.271706 12.1666667 0.272958 12.1694444 0.273709 12.1722222 0.274710 12.1750000 0.274710 12.1777778 0.274460 12.1805556 0.274210 12.1833333 0.274210 12.1861111 0.274460 12.1888889 0.274710 12.1916667 0.274460 12.1944444 0.274210 12.1972222 0.273208 12.2000000 0.273459 12.2027778 0.273459 12.2055556 0.274210 12.2083333 0.273959 12.2111111 0.273709 12.2138889 0.272958 12.2166667 0.273208 12.2194444 0.274210 12.2222222 0.274210 12.2250000 0.273959 12.2277778 0.273208 12.2305556 0.272707 12.2333333 0.273959 12.2361111 0.274460 12.2388889 0.274710 12.2416667 0.273959 12.2444444 0.273959 12.2472222 0.273709 12.2500000 0.274710 12.2527778 0.275211 12.2555556 0.274961 12.2583333 0.275211 12.2611111 0.274961 12.2638889 0.274961 12.2666667 0.275962 12.2694444 0.276964 12.2722222 0.277214 12.2750000 0.277465 12.2777778 0.277465 12.2805556 0.277465 12.2833333 0.278216 12.2861111 0.279718 12.2888889 0.280469 12.2916667 0.281221 12.2944444 0.281221 12.2972222 0.281221 12.3000000 0.282222 12.3027778 0.283224 12.3055556 0.284225 12.3083333 0.284977 12.3111111 0.285477 12.3138889 0.284977 12.3166667 0.285728 12.3194444 0.287230 12.3222222 0.287981 12.3250000 0.288482 12.3277778 0.288983 12.3305556 0.288983 12.3333333 0.289984 12.3361111 0.290736 12.3388889 0.292488 12.3416667 0.291987 12.3444444 0.292488 12.3472222 0.292488 12.3500000 0.293991 12.3527778 0.294742 12.3555556 0.294992 12.3633333 0.300000 12.4144444 0.300000 12.4194444 0.302504 12.4222222 0.302003 12.4250000 0.302254 12.4277778 0.301753 12.4305556 0.300751 12.4333333 0.301252 12.4361111 0.302254 12.4388889 0.302254 12.4416667 0.301252 12.4444444 0.300751 12.4472222 0.300000 12.4500000 0.300000 12.4527778 0.300000 12.4555556 0.299750 12.4583333 0.299750 12.4611111 0.299750 12.4638889 0.298247 12.4666667 0.298247 12.4694444 0.297496 12.4722222 0.296495 12.4750000 0.294241 12.4777778 0.292488 12.4805556 0.290986 12.4833333 0.289233 12.4861111 0.287981 12.4888889 0.286228 12.4916667 0.285227 12.4944444 0.284476 12.4972222 0.283975 12.5000000 0.283725 12.5027778 0.283975 12.5055556 0.283474 12.5083333 0.283224 12.5111111 0.282973 12.5138889 0.282222 12.5166667 0.282723 12.5194444 0.282723 12.5222222 0.282973 12.5250000 0.282973 12.5277778 0.282473 12.5305556 0.281721 12.5333333 0.282473 12.5361111 0.282723 12.5388889 0.282973 12.5416667 0.283224 12.5444444 0.282973 12.5472222 0.282222 12.5500000 0.281972 12.5527778 0.282723 12.5555556 0.283474 12.5583333 0.283474 12.5611111 0.282973 12.5638889 0.282723 12.5666667 0.282973 12.5694444 0.283224 12.5722222 0.283725 12.5750000 0.283474 12.5777778 0.282973 12.5805556 0.283474 12.5833333 0.283725 12.5861111 0.284726 12.5888889 0.284476 12.5916667 0.283975 12.5944444 0.283474 12.5972222 0.284225 12.6000000 0.284476 12.6027778 0.284977 12.6055556 0.284225 12.6083333 0.283474 12.6111111 0.281721 12.6138889 0.280219 12.6166667 0.279718 12.6194444 0.280720 12.6222222 0.283975 12.6250000 0.289233 12.6277778 0.295493 12.6305556 0.301502 12.6333333 0.305759 12.6361111 0.309264 12.6388889 0.311518 12.6416667 0.314773 12.6444444 0.319531 12.6472222 0.325039 12.6500000 0.331049 12.6527778 0.336056 12.6555556 0.340814 12.6583333 0.344570 12.6611111 0.346573 12.6638889 0.346823 12.6666667 0.347324 12.6694444 0.346573 12.6722222 0.344820 12.6750000 0.340563 12.6777778 0.334304 12.6805556 0.328044 12.6833333 0.323787 12.6861111 0.320031 12.6888889 0.315023 12.6916667 0.308263 12.6944444 0.299499 12.6972222 0.291236 12.7000000 0.282473 12.7027778 0.276213 12.7055556 0.269202 12.7083333 0.263443 12.7111111 0.260188 12.7138889 0.257433 12.7166667 0.256432 12.7194444 0.255180 12.7222222 0.254679 12.7250000 0.254930 12.7277778 0.254930 12.7305556 0.254679 12.7333333 0.254429 12.7361111 0.256432 12.7388889 0.257934 12.7416667 0.259937 12.7444444 0.260689 12.7472222 0.262191 12.7500000 0.263693 12.7527778 0.265196 12.7555556 0.266197 12.7583333 0.267199 12.7611111 0.267449 12.7638889 0.268451 12.7666667 0.269703 12.7694444 0.271455 12.7722222 0.272207 12.7750000 0.272958 12.7777778 0.272707 12.7805556 0.272707 12.7833333 0.273208 12.7861111 0.274210 12.7888889 0.274210 12.7916667 0.273959 12.7944444 0.272958 12.7972222 0.272207 12.8000000 0.272958 12.8027778 0.272707 12.8055556 0.273208 12.8083333 0.272707 12.8111111 0.271956 12.8138889 0.272457 12.8166667 0.272207 12.8194444 0.272707 12.8222222 0.272457 12.8250000 0.272457 12.8277778 0.271706 12.8305556 0.271205 12.8333333 0.271956 12.8361111 0.272457 12.8388889 0.272207 12.8416667 0.272207 12.8444444 0.271956 12.8472222 0.271956 12.8500000 0.272707 12.8527778 0.273208 12.8555556 0.272958 12.8583333 0.273208 12.8611111 0.272958 12.8638889 0.272958 12.8666667 0.273208 12.8694444 0.274210 12.8722222 0.274710 12.8750000 0.274710 12.8777778 0.274460 12.8805556 0.274460 12.8833333 0.275462 12.8861111 0.276463 12.8888889 0.277465 12.8916667 0.277715 12.8944444 0.277966 12.8972222 0.277966 12.9000000 0.278466 12.9027778 0.279718 12.9055556 0.280970 12.9083333 0.281221 12.9111111 0.280970 12.9138889 0.281221 12.9166667 0.282222 12.9194444 0.283725 12.9222222 0.284726 12.9250000 0.285227 12.9277778 0.285477 12.9305556 0.285227 12.9333333 0.286228 12.9361111 0.287230 12.9388889 0.287981 12.9416667 0.288482 12.9444444 0.289233 12.9472222 0.289734 12.9500000 0.290235 12.9527778 0.290986 12.9555556 0.291987 12.9583333 0.292488 12.9611111 0.292739 12.9638889 0.292989 12.9666667 0.293991 12.9744444 0.300000 13.0533333 0.300000 13.0583333 0.299499 13.0611111 0.298998 13.0638889 0.297746 13.0666667 0.297246 13.0694444 0.297997 13.0722222 0.297997 13.0750000 0.297246 13.0777778 0.296745 13.0805556 0.296495 13.0833333 0.297246 13.0861111 0.297496 13.0888889 0.296995 13.0916667 0.294742 13.0944444 0.292488 13.0972222 0.290986 13.1000000 0.289734 13.1027778 0.289233 13.1055556 0.287480 13.1083333 0.285978 13.1111111 0.284476 13.1138889 0.283224 13.1166667 0.282473 13.1194444 0.282973 13.1222222 0.282723 13.1250000 0.282222 13.1277778 0.281471 13.1305556 0.280970 13.1333333 0.280720 13.1361111 0.281221 13.1388889 0.281471 13.1416667 0.280970 13.1444444 0.280469 13.1472222 0.280219 13.1500000 0.280720 13.1527778 0.281221 13.1555556 0.280970 13.1583333 0.280720 13.1611111 0.280469 13.1638889 0.279969 13.1666667 0.279969 13.1694444 0.280970 13.1722222 0.281221 13.1750000 0.280469 13.1777778 0.280219 13.1805556 0.279718 13.1833333 0.279969 13.1861111 0.281221 13.1888889 0.281721 13.1916667 0.281471 13.1944444 0.280970 13.1972222 0.280720 13.2000000 0.281471 13.2027778 0.281471 13.2055556 0.281721 13.2083333 0.281471 13.2111111 0.280720 13.2138889 0.280970 13.2166667 0.281972 13.2194444 0.282222 13.2222222 0.282473 13.2250000 0.282473 13.2277778 0.282723 13.2305556 0.282473 13.2333333 0.282222 13.2361111 0.282973 13.2388889 0.283474 13.2416667 0.282473 13.2444444 0.281972 13.2472222 0.280970 13.2500000 0.279969 13.2527778 0.280219 13.2555556 0.280219 13.2583333 0.280469 13.2611111 0.282473 13.2638889 0.286228 13.2666667 0.293490 13.2694444 0.300751 13.2722222 0.307261 13.2750000 0.312269 13.2777778 0.315775 13.2805556 0.317527 13.2833333 0.320782 13.2861111 0.326291 13.2888889 0.331800 13.2916667 0.337058 13.2944444 0.341315 13.2972222 0.345822 13.3000000 0.350579 13.3027778 0.352833 13.3055556 0.353333 13.3083333 0.352081 13.3111111 0.350829 13.3138889 0.348576 13.3166667 0.344570 13.3194444 0.339311 13.3222222 0.332551 13.3250000 0.326291 13.3277778 0.321033 13.3305556 0.315274 13.3333333 0.309765 13.3361111 0.304507 13.3388889 0.296995 13.3416667 0.287731 13.3444444 0.279218 13.3472222 0.271455 13.3500000 0.265196 13.3527778 0.259437 13.3555556 0.254679 13.3583333 0.251174 13.3611111 0.249421 13.3638889 0.247418 13.3666667 0.247668 13.3694444 0.248169 13.3722222 0.248920 13.3750000 0.248419 13.3777778 0.248169 13.3805556 0.248419 13.3833333 0.250423 13.3861111 0.253177 13.3888889 0.255180 13.3916667 0.256182 13.3944444 0.257934 13.3972222 0.258435 13.4000000 0.260438 13.4027778 0.261440 13.4055556 0.262692 13.4083333 0.264194 13.4111111 0.264695 13.4138889 0.265696 13.4166667 0.266948 13.4194444 0.267700 13.4222222 0.268701 13.4250000 0.268200 13.4277778 0.267950 13.4305556 0.268200 13.4333333 0.268200 13.4361111 0.268451 13.4388889 0.269202 13.4416667 0.268701 13.4444444 0.268200 13.4472222 0.268200 13.4500000 0.267700 13.4527778 0.268951 13.4555556 0.269202 13.4583333 0.268200 13.4611111 0.267950 13.4638889 0.267199 13.4666667 0.266948 13.4694444 0.267950 13.4722222 0.267700 13.4750000 0.267950 13.4777778 0.267449 13.4805556 0.266698 13.4833333 0.267199 13.4861111 0.268451 13.4888889 0.268200 13.4916667 0.267449 13.4944444 0.266948 13.4972222 0.266197 13.5000000 0.266698 13.5027778 0.267700 13.5055556 0.267950 13.5083333 0.267700 13.5111111 0.268200 13.5138889 0.268200 13.5166667 0.268451 13.5194444 0.270203 13.5222222 0.270454 13.5250000 0.270704 13.5277778 0.270955 13.5305556 0.271205 13.5333333 0.271455 13.5361111 0.272207 13.5388889 0.272958 13.5416667 0.273709 13.5444444 0.273959 13.5472222 0.274210 13.5500000 0.274961 13.5527778 0.275962 13.5555556 0.276964 13.5583333 0.277966 13.5611111 0.278466 13.5638889 0.278466 13.5666667 0.279468 13.5694444 0.280219 13.5722222 0.281972 13.5750000 0.282473 13.5777778 0.282723 13.5805556 0.283725 13.5833333 0.284476 13.5861111 0.285477 13.5888889 0.286228 13.5916667 0.286479 13.5944444 0.286479 13.5972222 0.286228 13.6000000 0.287480 13.6027778 0.288482 13.6055556 0.289484 13.6133333 0.300000 13.7033333 0.300000 13.7083333 0.295994 13.7111111 0.295243 13.7138889 0.294241 13.7166667 0.294491 13.7194444 0.294742 13.7222222 0.294992 13.7250000 0.295493 13.7277778 0.294491 13.7305556 0.292989 13.7333333 0.293239 13.7361111 0.291987 13.7388889 0.291487 13.7416667 0.289484 13.7444444 0.287731 13.7472222 0.285728 13.7500000 0.284726 13.7527778 0.283474 13.7555556 0.281972 13.7583333 0.280970 13.7611111 0.279969 13.7638889 0.278967 13.7666667 0.278967 13.7694444 0.279468 13.7722222 0.279468 13.7750000 0.279218 13.7777778 0.278466 13.7805556 0.277966 13.7833333 0.278216 13.7861111 0.278717 13.7888889 0.278466 13.7916667 0.278717 13.7944444 0.278216 13.7972222 0.277214 13.8000000 0.277465 13.8027778 0.277715 13.8055556 0.277966 13.8083333 0.277966 13.8111111 0.277214 13.8138889 0.276714 13.8166667 0.277214 13.8194444 0.277715 13.8222222 0.277214 13.8250000 0.277715 13.8277778 0.277465 13.8305556 0.277715 13.8333333 0.277715 13.8361111 0.278717 13.8388889 0.278967 13.8416667 0.278466 13.8444444 0.278466 13.8472222 0.278717 13.8500000 0.278717 13.8527778 0.279468 13.8555556 0.278717 13.8583333 0.278967 13.8611111 0.278466 13.8638889 0.278216 13.8666667 0.278466 13.8694444 0.279218 13.8722222 0.280469 13.8750000 0.280219 13.8777778 0.279718 13.8805556 0.278967 13.8833333 0.279218 13.8861111 0.279969 13.8888889 0.280219 13.8916667 0.279718 13.8944444 0.278466 13.8972222 0.277465 13.9000000 0.278216 13.9027778 0.279718 13.9055556 0.281221 13.9083333 0.283975 13.9111111 0.288482 13.9138889 0.295493 13.9166667 0.301502 13.9194444 0.306761 13.9222222 0.311518 13.9250000 0.313271 13.9277778 0.314272 13.9305556 0.316275 13.9333333 0.320532 13.9361111 0.325790 13.9388889 0.330047 13.9416667 0.333803 13.9444444 0.336307 13.9472222 0.338560 13.9500000 0.340313 13.9527778 0.340313 13.9555556 0.339061 13.9583333 0.337809 13.9611111 0.336056 13.9638889 0.334304 13.9666667 0.330798 13.9694444 0.327042 13.9722222 0.322285 13.9750000 0.318279 13.9777778 0.314523 13.9805556 0.310266 13.9833333 0.307011 13.9861111 0.302504 13.9888889 0.297746 13.9916667 0.290736 13.9944444 0.282973 13.9972222 0.276213 14.0000000 0.270704 14.0027778 0.265446 14.0055556 0.260939 14.0083333 0.256432 14.0111111 0.252926 14.0138889 0.250673 14.0166667 0.249922 14.0194444 0.249922 14.0222222 0.249421 14.0250000 0.249671 14.0277778 0.249171 14.0305556 0.249171 14.0333333 0.249922 14.0361111 0.251174 14.0388889 0.252426 14.0416667 0.254429 14.0444444 0.255681 14.0472222 0.256933 14.0500000 0.258185 14.0527778 0.260438 14.0555556 0.261440 14.0583333 0.261690 14.0611111 0.262692 14.0638889 0.263443 14.0666667 0.265446 14.0694444 0.266698 14.0722222 0.267449 14.0750000 0.267700 14.0777778 0.267700 14.0805556 0.268451 14.0833333 0.268701 14.0861111 0.269452 14.0888889 0.270454 14.0916667 0.269703 14.0944444 0.268951 14.0972222 0.268451 14.1000000 0.268451 14.1027778 0.269202 14.1055556 0.269202 14.1083333 0.268701 14.1111111 0.268200 14.1138889 0.267199 14.1166667 0.268451 14.1194444 0.269452 14.1222222 0.268701 14.1250000 0.268951 14.1277778 0.268200 14.1305556 0.267700 14.1333333 0.268200 14.1361111 0.268200 14.1388889 0.269202 14.1416667 0.269202 14.1444444 0.268951 14.1472222 0.268451 14.1500000 0.268451 14.1527778 0.269202 14.1555556 0.269703 14.1583333 0.269202 14.1611111 0.269202 14.1638889 0.269452 14.1666667 0.269953 14.1694444 0.270203 14.1722222 0.271455 14.1750000 0.271205 14.1777778 0.271205 14.1805556 0.270955 14.1833333 0.272207 14.1861111 0.273459 14.1888889 0.273959 14.1916667 0.274961 14.1944444 0.274210 14.1972222 0.274460 14.2000000 0.275962 14.2027778 0.277214 14.2055556 0.277966 14.2083333 0.278967 14.2111111 0.279969 14.2138889 0.280219 14.2166667 0.280219 14.2194444 0.280970 14.2222222 0.282723 14.2250000 0.283224 14.2277778 0.283474 14.2305556 0.284225 14.2333333 0.285227 14.2361111 0.285978 14.2388889 0.286479 14.2416667 0.287731 14.2444444 0.288232 14.2472222 0.288232 14.2500000 0.289233 14.2527778 0.289484 14.2555556 0.290736 14.2633333 0.300000 14.9583333 0.300000)
Vbt bt 0 PWL(0.0000000 0.000000 1.7934444 0.000000 1.7944444 0.900000 1.7949444 0.900000 1.7959444 0.000000 2.4490000 0.000000 2.4500000 0.900000 2.4505000 0.900000 2.4515000 0.000000 3.1212222 0.000000 3.1222222 0.900000 3.1227222 0.900000 3.1237222 0.000000 3.7573333 0.000000 3.7583333 0.900000 3.7588333 0.900000 3.7598333 0.000000 4.3823333 0.000000 4.3833333 0.900000 4.3838333 0.900000 4.3848333 0.000000 4.9823333 0.000000 4.9833333 0.900000 4.9838333 0.900000 4.9848333 0.000000 5.6101111 0.000000 5.6111111 0.900000 5.6116111 0.900000 5.6126111 0.000000 6.2267778 0.000000 6.2277778 0.900000 6.2282778 0.900000 6.2292778 0.000000 6.8740000 0.000000 6.8750000 0.900000 6.8755000 0.900000 6.8765000 0.000000 7.5295556 0.000000 7.5305556 0.900000 7.5310556 0.900000 7.5320556 0.000000 8.1795556 0.000000 8.1805556 0.900000 8.1810556 0.900000 8.1820556 0.000000 8.8101111 0.000000 8.8111111 0.900000 8.8116111 0.900000 8.8126111 0.000000 9.4434444 0.000000 9.4444444 0.900000 9.4449444 0.900000 9.4459444 0.000000 10.0628889 0.000000 10.0638889 0.900000 10.0643889 0.900000 10.0653889 0.000000 10.6628889 0.000000 10.6638889 0.900000 10.6643889 0.900000 10.6653889 0.000000 11.2462222 0.000000 11.2472222 0.900000 11.2477222 0.900000 11.2487222 0.000000 11.8517778 0.000000 11.8527778 0.900000 11.8532778 0.900000 11.8542778 0.000000 12.4628889 0.000000 12.4638889 0.900000 12.4643889 0.900000 12.4653889 0.000000 13.1017778 0.000000 13.1027778 0.900000 13.1032778 0.900000 13.1042778 0.000000 13.7517778 0.000000 13.7527778 0.900000 13.7532778 0.900000 13.7542778 0.000000 14.9583333 0.000000)
Vpt pt 0 PWL(0.0000000 0.000000 1.8684444 0.000000 1.8694444 0.900000 1.8699444 0.900000 1.8709444 0.000000 2.5240000 0.000000 2.5250000 0.900000 2.5255000 0.900000 2.5265000 0.000000 3.1962222 0.000000 3.1972222 0.900000 3.1977222 0.900000 3.1987222 0.000000 3.8323333 0.000000 3.8333333 0.900000 3.8338333 0.900000 3.8348333 0.000000 4.4573333 0.000000 4.4583333 0.900000 4.4588333 0.900000 4.4598333 0.000000 5.0573333 0.000000 5.0583333 0.900000 5.0588333 0.900000 5.0598333 0.000000 5.6851111 0.000000 5.6861111 0.900000 5.6866111 0.900000 5.6876111 0.000000 6.3017778 0.000000 6.3027778 0.900000 6.3032778 0.900000 6.3042778 0.000000 6.9490000 0.000000 6.9500000 0.900000 6.9505000 0.900000 6.9515000 0.000000 7.6045556 0.000000 7.6055556 0.900000 7.6060556 0.900000 7.6070556 0.000000 8.2545556 0.000000 8.2555556 0.900000 8.2560556 0.900000 8.2570556 0.000000 8.8851111 0.000000 8.8861111 0.900000 8.8866111 0.900000 8.8876111 0.000000 9.5184444 0.000000 9.5194444 0.900000 9.5199444 0.900000 9.5209444 0.000000 10.1378889 0.000000 10.1388889 0.900000 10.1393889 0.900000 10.1403889 0.000000 10.7378889 0.000000 10.7388889 0.900000 10.7393889 0.900000 10.7403889 0.000000 11.3212222 0.000000 11.3222222 0.900000 11.3227222 0.900000 11.3237222 0.000000 11.9267778 0.000000 11.9277778 0.900000 11.9282778 0.900000 11.9292778 0.000000 12.5378889 0.000000 12.5388889 0.900000 12.5393889 0.900000 12.5403889 0.000000 13.1767778 0.000000 13.1777778 0.900000 13.1782778 0.900000 13.1792778 0.000000 13.8267778 0.000000 13.8277778 0.900000 13.8282778 0.900000 13.8292778 0.000000 14.9583333 0.000000)

Xpw ecg_in bt pt pw_out vdd vss vbias pwave_diff

.tran 0.5m 14.9583

.meas tran pw_b0 FIND V(pw_out) AT=1.8899444
.meas tran pw_b1 FIND V(pw_out) AT=2.5455000
.meas tran pw_b2 FIND V(pw_out) AT=3.2177222
.meas tran pw_b3 FIND V(pw_out) AT=3.8538333
.meas tran pw_b4 FIND V(pw_out) AT=4.4788333
.meas tran pw_b5 FIND V(pw_out) AT=5.0788333
.meas tran pw_b6 FIND V(pw_out) AT=5.7066111
.meas tran pw_b7 FIND V(pw_out) AT=6.3232778
.meas tran pw_b8 FIND V(pw_out) AT=6.9705000
.meas tran pw_b9 FIND V(pw_out) AT=7.6260556
.meas tran pw_b10 FIND V(pw_out) AT=8.2760556
.meas tran pw_b11 FIND V(pw_out) AT=8.9066111
.meas tran pw_b12 FIND V(pw_out) AT=9.5399444
.meas tran pw_b13 FIND V(pw_out) AT=10.1593889
.meas tran pw_b14 FIND V(pw_out) AT=10.7593889
.meas tran pw_b15 FIND V(pw_out) AT=11.3427222
.meas tran pw_b16 FIND V(pw_out) AT=11.9482778
.meas tran pw_b17 FIND V(pw_out) AT=12.5593889
.meas tran pw_b18 FIND V(pw_out) AT=13.1982778
.meas tran pw_b19 FIND V(pw_out) AT=13.8482778

.end
