.title trigger_diagnostic_100
.lib "C:/Users/kadhi/OneDrive/Desktop/amux/verilogLearning/Leaky-Integrate-Fire---SNN-model-on-FPGA/experiments/frontend_optimization/ngspice_frontend/sky130_minimal.lib.spice" tt
.option scale=1.0u method=gear reltol=0.01 gmin=1e-15
.temp 27

Vdd vdd 0 0.9
Vss vss 0 0

Vecg0 ecg_l0 0 PWL(0.0000000 0.300000 0.3138889 0.262648 0.3166667 0.262091 0.3194444 0.264878 0.3222222 0.266551 0.3250000 0.266551 0.3277778 0.267666 0.3305556 0.267108 0.3333333 0.267666 0.3361111 0.268223 0.3388889 0.269338 0.3416667 0.271568 0.3444444 0.272125 0.3472222 0.272125 0.3500000 0.270453 0.3527778 0.271568 0.3555556 0.272683 0.3583333 0.274355 0.3611111 0.272683 0.3638889 0.272683 0.3666667 0.271568 0.3694444 0.271568 0.3722222 0.273240 0.3750000 0.272125 0.3777778 0.271568 0.3805556 0.272683 0.3833333 0.271568 0.3861111 0.272125 0.3888889 0.272125 0.3916667 0.270453 0.3944444 0.271010 0.3972222 0.271010 0.4000000 0.270453 0.4027778 0.269895 0.4055556 0.270453 0.4083333 0.271010 0.4111111 0.269338 0.4138889 0.268780 0.4166667 0.267666 0.4194444 0.269338 0.4222222 0.269895 0.4250000 0.271010 0.4277778 0.268780 0.4305556 0.268780 0.4333333 0.268223 0.4361111 0.269338 0.4388889 0.269338 0.4416667 0.270453 0.4444444 0.269895 0.4472222 0.268223 0.4500000 0.267666 0.4527778 0.268780 0.4555556 0.269338 0.4583333 0.268223 0.4611111 0.268780 0.4638889 0.266551 0.4666667 0.266551 0.4694444 0.265993 0.4722222 0.267108 0.4750000 0.266551 0.4777778 0.265436 0.4805556 0.265436 0.4833333 0.265993 0.4861111 0.267108 0.4888889 0.268223 0.4916667 0.268223 0.4944444 0.267666 0.4972222 0.267108 0.5000000 0.265436 0.5027778 0.267666 0.5055556 0.267108 0.5083333 0.266551 0.5111111 0.265993 0.5138889 0.265436 0.5166667 0.263763 0.5194444 0.265436 0.5222222 0.266551 0.5250000 0.267666 0.5277778 0.265436 0.5305556 0.263763 0.5333333 0.263206 0.5361111 0.264878 0.5388889 0.266551 0.5416667 0.265993 0.5444444 0.265436 0.5472222 0.264321 0.5500000 0.263206 0.5527778 0.263763 0.5555556 0.264878 0.5583333 0.265436 0.5611111 0.265993 0.5638889 0.265993 0.5666667 0.265436 0.5694444 0.266551 0.5722222 0.265993 0.5750000 0.267666 0.5777778 0.266551 0.5805556 0.266551 0.5833333 0.265993 0.5861111 0.265993 0.5888889 0.267666 0.5916667 0.268780 0.5944444 0.267108 0.5972222 0.265993 0.6000000 0.264878 0.6027778 0.265993 0.6055556 0.267108 0.6083333 0.267666 0.6111111 0.268780 0.6138889 0.269895 0.6166667 0.269338 0.6194444 0.269338 0.6222222 0.269895 0.6250000 0.272125 0.6277778 0.272125 0.6305556 0.271568 0.6333333 0.274913 0.6361111 0.275470 0.6388889 0.277143 0.6416667 0.277700 0.6444444 0.277143 0.6472222 0.276028 0.6500000 0.274355 0.6527778 0.275470 0.6555556 0.274913 0.6583333 0.274913 0.6611111 0.274913 0.6638889 0.274355 0.6666667 0.273798 0.6694444 0.273240 0.6722222 0.273798 0.6750000 0.275470 0.6777778 0.276585 0.6805556 0.277143 0.6833333 0.272683 0.6861111 0.268223 0.6888889 0.268223 0.6916667 0.266551 0.6944444 0.265436 0.6972222 0.263206 0.7000000 0.263206 0.7027778 0.263763 0.7055556 0.264878 0.7083333 0.264321 0.7111111 0.264878 0.7138889 0.263763 0.7166667 0.262091 0.7194444 0.261533 0.7222222 0.262091 0.7250000 0.262091 0.7277778 0.260976 0.7305556 0.261533 0.7333333 0.260418 0.7361111 0.263206 0.7388889 0.262648 0.7416667 0.263206 0.7444444 0.264321 0.7472222 0.261533 0.7500000 0.260418 0.7527778 0.262091 0.7555556 0.263206 0.7583333 0.263763 0.7611111 0.263206 0.7638889 0.260976 0.7666667 0.259303 0.7694444 0.259861 0.7722222 0.257631 0.7750000 0.252613 0.7777778 0.250383 0.7805556 0.247038 0.7833333 0.243136 0.7861111 0.240348 0.7888889 0.243693 0.7916667 0.253728 0.7944444 0.266551 0.7972222 0.282160 0.8000000 0.298328 0.8027778 0.326202 0.8055556 0.354634 0.8083333 0.380279 0.8111111 0.397561 0.8138889 0.404808 0.8166667 0.400906 0.8194444 0.384181 0.8222222 0.354634 0.8250000 0.318397 0.8277778 0.287735 0.8305556 0.269895 0.8333333 0.256516 0.8361111 0.249826 0.8388889 0.247038 0.8416667 0.249268 0.8444444 0.252613 0.8472222 0.256516 0.8500000 0.256516 0.8527778 0.257073 0.8555556 0.256516 0.8583333 0.257631 0.8611111 0.257631 0.8638889 0.257631 0.8666667 0.255958 0.8694444 0.257073 0.8722222 0.257073 0.8750000 0.257073 0.8777778 0.258188 0.8805556 0.255958 0.8833333 0.254286 0.8861111 0.254286 0.8888889 0.255401 0.8916667 0.255958 0.8944444 0.256516 0.8972222 0.254843 0.9000000 0.255958 0.9027778 0.257073 0.9055556 0.258188 0.9083333 0.256516 0.9111111 0.256516 0.9138889 0.254843 0.9166667 0.254286 0.9194444 0.254286 0.9222222 0.256516 0.9250000 0.256516 0.9277778 0.255958 0.9305556 0.254843 0.9333333 0.253728 0.9361111 0.255401 0.9388889 0.254286 0.9416667 0.254843 0.9444444 0.254286 0.9472222 0.253728 0.9500000 0.254286 0.9527778 0.255401 0.9555556 0.255401 0.9583333 0.255958 0.9611111 0.256516 0.9638889 0.254843 0.9666667 0.254286 0.9694444 0.256516 0.9722222 0.256516 0.9750000 0.257073 0.9777778 0.257073 0.9805556 0.254286 0.9833333 0.254843 0.9861111 0.255958 0.9888889 0.256516 0.9916667 0.258188 0.9944444 0.256516 0.9972222 0.255958 1.0000000 0.254286 1.0027778 0.255401 1.0055556 0.256516 1.0083333 0.256516 1.0111111 0.257073 1.0138889 0.254843 1.0166667 0.253728 1.0194444 0.253728 1.0222222 0.255401 1.0250000 0.255958 1.0277778 0.254843 1.0305556 0.253728 1.0333333 0.253171 1.0361111 0.253171 1.0388889 0.254286 1.0416667 0.253728 1.0444444 0.252613 1.0472222 0.253171 1.0500000 0.251498 1.0527778 0.252056 1.0555556 0.252056 1.0583333 0.253171 1.0611111 0.252056 1.0638889 0.249826 1.0666667 0.249268 1.0694444 0.249826 1.0722222 0.251498 1.0750000 0.250383 1.0777778 0.249826 1.0805556 0.249268 1.0833333 0.247596 1.0861111 0.248711 1.0888889 0.249268 1.0916667 0.249826 1.0944444 0.249268 1.0972222 0.247596 1.1000000 0.247038 1.1027778 0.248711 1.1055556 0.249826 1.1083333 0.250383 1.1111111 0.250941 1.1138889 0.251498 1.1166667 0.250941 1.1194444 0.254286 1.1222222 0.255958 1.1250000 0.258746 1.1277778 0.259303 1.1305556 0.259861 1.1333333 0.259303 1.1361111 0.262091 1.1388889 0.263763 1.1416667 0.264878 1.1444444 0.264321 1.1472222 0.263206 1.1500000 0.263206 1.1527778 0.264321 1.1555556 0.265436 1.1583333 0.266551 1.1611111 0.266551 1.1638889 0.264321 1.1666667 0.264321 1.1694444 0.264878 1.1722222 0.265993 1.1750000 0.265993 1.1777778 0.267108 1.1805556 0.264321 1.1833333 0.263206 1.1861111 0.265993 1.1888889 0.265436 1.1916667 0.266551 1.1944444 0.266551 1.1972222 0.264321 1.2000000 0.263763 1.2027778 0.265436 1.2055556 0.265993 1.2083333 0.264878 1.2111111 0.265993 1.2138889 0.264878 1.2166667 0.264878 1.2194444 0.265436 1.2222222 0.267108 1.2250000 0.267666 1.2277778 0.265993 1.2305556 0.265436 1.2333333 0.264321 1.2361111 0.264878 1.2388889 0.266551 1.2416667 0.264878 1.2444444 0.264878 1.2472222 0.264878 1.2500000 0.263206 1.2527778 0.264878 1.2555556 0.264321 1.2583333 0.264878 1.2611111 0.263763 1.2638889 0.262648 1.2666667 0.262091 1.2694444 0.262648 1.2722222 0.262648 1.2750000 0.263206 1.2777778 0.263763 1.2805556 0.261533 1.2833333 0.260976 1.2861111 0.261533 1.2888889 0.262648 1.2916667 0.263206 1.2944444 0.263206 1.2972222 0.261533 1.3000000 0.261533 1.3027778 0.261533 1.3055556 0.264321 1.3083333 0.263206 1.3111111 0.262648 1.3138889 0.262091 1.3166667 0.260418 1.3194444 0.262648 1.3222222 0.263206 1.3250000 0.263206 1.3277778 0.262648 1.3305556 0.260418 1.3333333 0.259861 1.3361111 0.260418 1.3388889 0.260976 1.3416667 0.262091 1.3444444 0.261533 1.3472222 0.261533 1.3500000 0.261533 1.3527778 0.261533 1.3555556 0.263206 1.3583333 0.263206 1.3611111 0.262648 1.3638889 0.261533 1.3666667 0.260976 1.3694444 0.260976 1.3722222 0.262091 1.3750000 0.263206 1.3777778 0.261533 1.3805556 0.261533 1.3833333 0.260418 1.3861111 0.260976 1.3888889 0.262091 1.3916667 0.263206 1.3944444 0.262091 1.3972222 0.262091 1.4000000 0.262091 1.4027778 0.263206 1.4055556 0.262648 1.4083333 0.263206 1.4111111 0.262648 1.4138889 0.261533 1.4166667 0.261533 1.4194444 0.262091 1.4222222 0.263206 1.4250000 0.264878 1.4277778 0.267108 1.4305556 0.266551 1.4333333 0.267108 1.4361111 0.268223 1.4388889 0.269338 1.4416667 0.270453 1.4444444 0.270453 1.4472222 0.270453 1.4500000 0.271568 1.4527778 0.272125 1.4555556 0.273240 1.4583333 0.274913 1.4611111 0.276028 1.4638889 0.273240 1.4666667 0.272683 1.4694444 0.273240 1.4722222 0.272683 1.4750000 0.273798 1.4777778 0.272683 1.4805556 0.272125 1.4833333 0.269338 1.4861111 0.269338 1.4888889 0.270453 1.4916667 0.272125 1.4944444 0.274913 1.4972222 0.275470 1.5000000 0.274355 1.5027778 0.270453 1.5055556 0.269895 1.5083333 0.268780 1.5111111 0.268223 1.5138889 0.265993 1.5166667 0.264321 1.5194444 0.262091 1.5222222 0.263206 1.5250000 0.262648 1.5277778 0.262648 1.5305556 0.260418 1.5333333 0.258746 1.5361111 0.259861 1.5388889 0.261533 1.5416667 0.260976 1.5444444 0.260418 1.5472222 0.259303 1.5500000 0.258188 1.5527778 0.257631 1.5555556 0.258746 1.5583333 0.259303 1.5611111 0.259303 1.5638889 0.257631 1.5666667 0.257073 1.5694444 0.257631 1.5722222 0.258188 1.5750000 0.260418 1.5777778 0.258746 1.5805556 0.256516 1.5833333 0.254843 1.5861111 0.254286 1.5888889 0.251498 1.5916667 0.248153 1.5944444 0.245366 1.5972222 0.242021 1.6000000 0.238118 1.6027778 0.236446 1.6055556 0.241463 1.6083333 0.254843 1.6111111 0.272125 1.6138889 0.289965 1.6166667 0.313380 1.6194444 0.345714 1.6222222 0.376934 1.6250000 0.398676 1.6277778 0.407038 1.6305556 0.394774 1.6333333 0.357979 1.6361111 0.305575 1.6388889 0.264321 1.6416667 0.244251 1.6444444 0.243693 1.6472222 0.250383 1.6500000 0.253728 1.6527778 0.255958 1.6555556 0.256516 1.6583333 0.255958 1.6611111 0.256516 1.6638889 0.255958 1.6666667 0.254843 1.6694444 0.255958 1.6722222 0.254843 1.6750000 0.256516 1.6777778 0.255958 1.6805556 0.255958 1.6833333 0.254286 1.6861111 0.254843 1.6888889 0.255401 1.6916667 0.255401 1.6944444 0.253728 1.6972222 0.254843 1.7000000 0.253171 1.7027778 0.253728 1.7055556 0.254843 1.7083333 0.254843 1.7111111 0.253171 1.7138889 0.253171 1.7166667 0.251498 1.7194444 0.253171 1.7222222 0.254286 1.7250000 0.254286 1.7277778 0.254843 1.7305556 0.252613 1.7333333 0.252056 1.7361111 0.253171 1.7388889 0.253728 1.7416667 0.254286 1.7444444 0.254286 1.7472222 0.252613 1.7500000 0.253171 1.7527778 0.255401 1.7555556 0.255958 1.7583333 0.255401 1.7611111 0.255401 1.7638889 0.255958 1.7666667 0.253728 1.7694444 0.254843 1.7722222 0.256516 1.7750000 0.255401 1.7777778 0.255401 1.7805556 0.253728 1.7833333 0.252613 1.7861111 0.252613 1.7888889 0.253728 1.7916667 0.253728 1.7944444 0.254286 1.7972222 0.252613 1.8000000 0.252613 1.8027778 0.253171 1.8055556 0.253728 1.8083333 0.255401 1.8111111 0.255401 1.8138889 0.254286 1.8166667 0.252613 1.8194444 0.254286 1.8222222 0.254843 1.8250000 0.255958 1.8277778 0.255401 1.8305556 0.255401 1.8333333 0.254843 1.8361111 0.257073 1.8388889 0.255401 1.8416667 0.256516 1.8444444 0.256516 1.8472222 0.255401 1.8500000 0.253728 1.8527778 0.254843 1.8555556 0.254843 1.8583333 0.254286 1.8611111 0.253728 1.8638889 0.253171 1.8666667 0.253171 1.8694444 0.252613 1.8722222 0.253728 1.8750000 0.253728 1.8777778 0.254286 1.8805556 0.251498 1.8833333 0.252056 1.8861111 0.251498 1.8888889 0.253171 1.8916667 0.253171 1.8944444 0.253171 1.8972222 0.253171 1.9000000 0.252613 1.9027778 0.252613 1.9055556 0.253728 1.9083333 0.255958 1.9111111 0.255958 1.9138889 0.256516 1.9166667 0.258188 1.9194444 0.259861 1.9222222 0.262091 1.9250000 0.262648 1.9277778 0.263206 1.9305556 0.262648 1.9333333 0.262648 1.9361111 0.263763 1.9388889 0.264321 1.9416667 0.265993 1.9444444 0.265993 1.9472222 0.264878 1.9500000 0.265436 1.9527778 0.265993 1.9555556 0.266551 1.9583333 0.266551 1.9611111 0.266551 1.9638889 0.265436 1.9666667 0.265436 1.9694444 0.265436 1.9722222 0.264878 1.9750000 0.266551 1.9777778 0.265993 1.9805556 0.264878 1.9833333 0.264321 1.9861111 0.263763 1.9888889 0.265436 1.9916667 0.265993 1.9944444 0.265993 1.9972222 0.264321 2.0000000 0.263763 2.0027778 0.265993 2.0055556 0.265436 2.0083333 0.267108 2.0111111 0.265436 2.0138889 0.263763 2.0166667 0.263206 2.0194444 0.264321 2.0222222 0.264321 2.0250000 0.264321 2.0277778 0.263763 2.0305556 0.260976 2.0333333 0.260976 2.0361111 0.262091 2.0388889 0.262648 2.0416667 0.263206 2.0444444 0.262648 2.0472222 0.262091 2.0500000 0.259861 2.0527778 0.260976 2.0555556 0.260976 2.0583333 0.260418 2.0611111 0.259861 2.0638889 0.260418 2.0666667 0.259303 2.0694444 0.260418 2.0722222 0.260976 2.0750000 0.262091 2.0777778 0.260418 2.0805556 0.260976 2.0833333 0.259303 2.0861111 0.259303 2.0888889 0.260976 2.0916667 0.260418 2.0944444 0.260976 2.0972222 0.258746 2.1000000 0.257631 2.1027778 0.258746 2.1055556 0.259861 2.1083333 0.259303 2.1111111 0.259861 2.1138889 0.259303 2.1166667 0.257631 2.1194444 0.258746 2.1222222 0.259303 2.1250000 0.260976 2.1277778 0.260976 2.1305556 0.260976 2.1333333 0.258746 2.1361111 0.259303 2.1388889 0.261533 2.1416667 0.261533 2.1444444 0.262091 2.1472222 0.260418 2.1500000 0.259303 2.1527778 0.259861 2.1555556 0.260418 2.1583333 0.260418 2.1611111 0.260418 2.1638889 0.258188 2.1666667 0.257073 2.1694444 0.260418 2.1722222 0.259861 2.1750000 0.260418 2.1777778 0.259861 2.1805556 0.259861 2.1833333 0.258746 2.1861111 0.259861 2.1888889 0.261533 2.1916667 0.260418 2.1944444 0.261533 2.1972222 0.261533 2.2000000 0.261533 2.2027778 0.262091 2.2055556 0.265436 2.2083333 0.265993 2.2111111 0.265993 2.2138889 0.265436 2.2166667 0.265993 2.2194444 0.267666 2.2222222 0.268223 2.2250000 0.269338 2.2277778 0.268780 2.2305556 0.268780 2.2333333 0.269338 2.2361111 0.270453 2.2388889 0.271568 2.2416667 0.272683 2.2444444 0.271010 2.2472222 0.270453 2.2500000 0.269338 2.2527778 0.268780 2.2555556 0.270453 2.2583333 0.269895 2.2611111 0.269338 2.2638889 0.268780 2.2666667 0.269338 2.2694444 0.268780 2.2722222 0.269338 2.2750000 0.270453 2.2777778 0.271568 2.2805556 0.273240 2.2833333 0.271010 2.2861111 0.268780 2.2888889 0.265436 2.2916667 0.265436 2.2944444 0.261533 2.2972222 0.259861 2.3000000 0.257631 2.3027778 0.257073 2.3055556 0.257631 2.3083333 0.258746 2.3111111 0.258188 2.3138889 0.257073 2.3166667 0.256516 2.3194444 0.255958 2.3222222 0.257073 2.3250000 0.257073 2.3277778 0.257073 2.3305556 0.255958 2.3333333 0.254843 2.3361111 0.255401 2.3388889 0.258188 2.3416667 0.258188 2.3444444 0.256516 2.3472222 0.255958 2.3500000 0.253728 2.3527778 0.254843 2.3555556 0.255401 2.3583333 0.256516 2.3611111 0.254843 2.3638889 0.252613 2.3666667 0.248711 2.3694444 0.247038 2.3722222 0.243693 2.3750000 0.243136 2.3777778 0.241463 2.3805556 0.239791 2.3833333 0.233101 2.3861111 0.228084 2.3888889 0.229756 2.3916667 0.235889 2.3944444 0.244808 2.3972222 0.257073 2.4000000 0.269895 2.4027778 0.287178 2.4055556 0.310035 2.4083333 0.341254 2.4111111 0.370801 2.4138889 0.390314 2.4166667 0.395889 2.4194444 0.385854 2.4222222 0.352962 2.4250000 0.307247 2.4277778 0.265993 2.4305556 0.244251 2.4333333 0.242021 2.4361111 0.247038 2.4388889 0.254286 2.4416667 0.256516 2.4444444 0.256516 2.4472222 0.255401 2.4500000 0.254286 2.4527778 0.254843 2.4555556 0.257073 2.4583333 0.256516 2.4611111 0.255958 2.4638889 0.254843 2.4666667 0.254286 2.4694444 0.254843 2.4722222 0.255401 2.4750000 0.256516 2.4777778 0.255958 2.4805556 0.254286 2.4833333 0.253728 2.4861111 0.254286 2.4888889 0.255958 2.4916667 0.254843 2.4944444 0.254286 2.4972222 0.254843 2.5000000 0.254843 2.5027778 0.254286 2.5055556 0.256516 2.5083333 0.257073 2.5111111 0.256516 2.5138889 0.255958 2.5166667 0.255401 2.5194444 0.255401 2.5222222 0.255401 2.5250000 0.255958 2.5277778 0.255958 2.5305556 0.254843 2.5333333 0.254843 2.5361111 0.255401 2.5388889 0.255958 2.5416667 0.257073 2.5444444 0.258188 2.5472222 0.257073 2.5500000 0.255958 2.5527778 0.256516 2.5555556 0.257073 2.5583333 0.258188 2.5611111 0.257073 2.5638889 0.255958 2.5666667 0.255958 2.5694444 0.257073 2.5722222 0.258188 2.5750000 0.258188 2.5777778 0.257073 2.5805556 0.255958 2.5833333 0.256516 2.5861111 0.256516 2.5888889 0.259303 2.5916667 0.258188 2.5944444 0.257073 2.5972222 0.255958 2.6000000 0.257631 2.6027778 0.257073 2.6055556 0.258188 2.6083333 0.257631 2.6111111 0.256516 2.6138889 0.257631 2.6166667 0.258188 2.6194444 0.258188 2.6222222 0.258188 2.6250000 0.258188 2.6277778 0.257631 2.6305556 0.256516 2.6333333 0.256516 2.6361111 0.259303 2.6388889 0.258746 2.6416667 0.258188 2.6444444 0.257073 2.6472222 0.256516 2.6500000 0.256516 2.6527778 0.258188 2.6555556 0.259303 2.6583333 0.257073 2.6611111 0.257631 2.6638889 0.256516 2.6666667 0.258188 2.6694444 0.258188 2.6722222 0.259303 2.6750000 0.258746 2.6777778 0.257073 2.6805556 0.255958 2.6833333 0.257073 2.6861111 0.257073 2.6888889 0.258746 2.6916667 0.259303 2.6944444 0.258746 2.6972222 0.258188 2.7000000 0.260976 2.7027778 0.262648 2.7055556 0.264321 2.7083333 0.264878 2.7111111 0.264321 2.7138889 0.263763 2.7166667 0.264878 2.7194444 0.267108 2.7222222 0.268223 2.7250000 0.266551 2.7277778 0.267108 2.7305556 0.268223 2.7333333 0.268223 2.7361111 0.268780 2.7388889 0.269895 2.7416667 0.268780 2.7444444 0.267666 2.7472222 0.267108 2.7500000 0.267108 2.7527778 0.267666 2.7555556 0.268780 2.7583333 0.267666 2.7611111 0.267108 2.7638889 0.265436 2.7666667 0.267108 2.7694444 0.268223 2.7722222 0.268780 2.7750000 0.269338 2.7777778 0.267108 2.7805556 0.265993 2.7833333 0.266551 2.7861111 0.267108 2.7888889 0.267108 2.7916667 0.268223 2.7944444 0.266551 2.7972222 0.265993 2.8000000 0.266551 2.8027778 0.267108 2.8055556 0.266551 2.8083333 0.265993 2.8111111 0.264878 2.8138889 0.265436 2.8166667 0.264878 2.8194444 0.267108 2.8222222 0.266551 2.8250000 0.265436 2.8277778 0.263206 2.8305556 0.262091 2.8333333 0.263206 2.8361111 0.264321 2.8388889 0.264321 2.8416667 0.264878 2.8444444 0.263763 2.8472222 0.262648 2.8500000 0.263206 2.8527778 0.264878 2.8555556 0.264321 2.8583333 0.264321 2.8611111 0.263206 2.8638889 0.261533 2.8666667 0.262091 2.8694444 0.262648 2.8722222 0.263206 2.8750000 0.262648 2.8777778 0.261533 2.8805556 0.260976 2.8833333 0.261533 2.8861111 0.262091 2.8888889 0.262648 2.8916667 0.262648 2.8944444 0.263206 2.8972222 0.262648 2.9000000 0.262091 2.9027778 0.262648 2.9055556 0.264321 2.9083333 0.262091 2.9111111 0.262091 2.9138889 0.260976 2.9166667 0.259303 2.9194444 0.259861 2.9222222 0.261533 2.9250000 0.261533 2.9277778 0.260976 2.9305556 0.260976 2.9333333 0.260976 2.9361111 0.262091 2.9388889 0.262091 2.9416667 0.261533 2.9444444 0.261533 2.9472222 0.257631 2.9500000 0.259861 2.9527778 0.259861 2.9555556 0.261533 2.9583333 0.261533 2.9611111 0.260976 2.9638889 0.260418 2.9666667 0.261533 2.9694444 0.263206 2.9722222 0.263206 2.9750000 0.262648 2.9777778 0.262648 2.9805556 0.262091 2.9833333 0.263206 2.9861111 0.264321 2.9888889 0.267666 2.9916667 0.267666 2.9944444 0.266551 2.9972222 0.265993 3.0000000 0.268223 3.0027778 0.268780 3.0055556 0.269338 3.0083333 0.268780 3.0111111 0.269338 3.0138889 0.269895 3.0166667 0.270453 3.0194444 0.272125 3.0222222 0.274355 3.0250000 0.272683 3.0277778 0.273240 3.0305556 0.271568 3.0333333 0.271568 3.0361111 0.272683 3.0388889 0.273798 3.0416667 0.271568 3.0444444 0.270453 3.0472222 0.271010 3.0500000 0.271568 3.0527778 0.269895 3.0555556 0.270453 3.0583333 0.268780 3.0611111 0.271568 3.0638889 0.272125 3.0666667 0.272683 3.0694444 0.270453 3.0722222 0.268780 3.0750000 0.266551 3.0777778 0.264878 3.0805556 0.263763 3.0833333 0.262648 3.0861111 0.261533 3.0888889 0.263206 3.0916667 0.262648 3.0944444 0.261533 3.0972222 0.259861 3.1000000 0.260976 3.1027778 0.262091 3.1055556 0.262648 3.1083333 0.261533 3.1111111 0.259861 3.1138889 0.259303 3.1166667 0.258188 3.1194444 0.258746 3.1222222 0.259303 3.1250000 0.259303 3.1277778 0.257631 3.1305556 0.258188 3.1333333 0.258188 3.1361111 0.259303 3.1388889 0.258746 3.1416667 0.259861 3.1444444 0.258746 3.1472222 0.257631 3.1500000 0.259303 3.1527778 0.259861 3.1555556 0.260976 3.1583333 0.260418 3.1611111 0.258746 3.1638889 0.257073 3.1666667 0.255958 3.1694444 0.252056 3.1722222 0.250383 3.1750000 0.245923 3.1777778 0.242578 3.1805556 0.237003 3.1833333 0.238118 3.1861111 0.247038 3.1888889 0.260418 3.1916667 0.275470 3.1944444 0.293868 3.1972222 0.320627 3.2000000 0.352962 3.2027778 0.378606 3.2055556 0.391429 3.2083333 0.386969 3.2111111 0.359652 3.2138889 0.316167 3.2166667 0.277700 3.2194444 0.253171 3.2222222 0.244251 3.2250000 0.246481 3.2277778 0.249826 3.2305556 0.254286 3.2333333 0.255401 3.2361111 0.256516 3.2388889 0.256516 3.2416667 0.255401 3.2444444 0.254843 3.2472222 0.252613 3.2500000 0.252613 3.2527778 0.254843 3.2555556 0.255958 3.2583333 0.254843 3.2611111 0.254843 3.2638889 0.253728 3.2666667 0.254843 3.2694444 0.257073 3.2722222 0.256516 3.2750000 0.255958 3.2777778 0.255958 3.2805556 0.255958 3.2833333 0.255958 3.2861111 0.257073 3.2888889 0.256516 3.2916667 0.256516 3.2944444 0.255401 3.2972222 0.252613 3.3000000 0.254286 3.3027778 0.255401 3.3055556 0.255958 3.3083333 0.255401 3.3111111 0.254843 3.3138889 0.252613 3.3166667 0.253728 3.3194444 0.254843 3.3222222 0.254843 3.3250000 0.254843 3.3277778 0.254286 3.3305556 0.253728 3.3333333 0.254843 3.3361111 0.253171 3.3388889 0.254843 3.3416667 0.254286 3.3444444 0.254286 3.3472222 0.253171 3.3500000 0.253728 3.3527778 0.254843 3.3555556 0.255958 3.3583333 0.255958 3.3611111 0.255958 3.3638889 0.255401 3.3666667 0.255958 3.3694444 0.255958 3.3722222 0.254843 3.3750000 0.254843 3.3777778 0.253171 3.3805556 0.251498 3.3833333 0.253728 3.3861111 0.254843 3.3888889 0.255958 3.3916667 0.256516 3.3944444 0.253728 3.3972222 0.254843 3.4000000 0.254843 3.4027778 0.255401 3.4055556 0.255958 3.4083333 0.255958 3.4111111 0.254843 3.4138889 0.253171 3.4166667 0.253728 3.4194444 0.255401 3.4222222 0.255958 3.4250000 0.255401 3.4277778 0.254843 3.4305556 0.252613 3.4333333 0.252613 3.4361111 0.252613 3.4388889 0.253171 3.4416667 0.252613 3.4444444 0.249826 3.4472222 0.250383 3.4500000 0.249826 3.4527778 0.251498 3.4555556 0.250383 3.4583333 0.247596 3.4611111 0.249268 3.4638889 0.248711 3.4666667 0.250941 3.4694444 0.251498 3.4722222 0.252613 3.4750000 0.252056 3.4777778 0.250383 3.4805556 0.249826 3.4833333 0.250383 3.4861111 0.252056 3.4888889 0.253171 3.4916667 0.254286 3.4944444 0.252613 3.4972222 0.253171 3.5000000 0.254843 3.5027778 0.257631 3.5055556 0.258746 3.5083333 0.259303 3.5111111 0.259303 3.5138889 0.259303 3.5166667 0.261533 3.5194444 0.263206 3.5222222 0.264878 3.5250000 0.265993 3.5277778 0.265993 3.5305556 0.264321 3.5333333 0.265436 3.5361111 0.265436 3.5388889 0.265993 3.5416667 0.265436 3.5444444 0.264878 3.5472222 0.264321 3.5500000 0.264878 3.5527778 0.265993 3.5555556 0.265993 3.5583333 0.267108 3.5611111 0.265436 3.5638889 0.264321 3.5666667 0.265436 3.5694444 0.264878 3.5722222 0.267108 3.5750000 0.266551 3.5777778 0.265993 3.5805556 0.266551 3.5833333 0.268223 3.5861111 0.268780 3.5888889 0.267666 3.5916667 0.267108 3.5944444 0.265993 3.5972222 0.263763 3.6000000 0.265993 3.6027778 0.266551 3.6055556 0.266551 3.6083333 0.264878 3.6111111 0.263763 3.6138889 0.262648 3.6166667 0.263763 3.6194444 0.264878 3.6222222 0.264321 3.6250000 0.262648 3.6277778 0.263206 3.6305556 0.262091 3.6333333 0.263763 3.6361111 0.263763 3.6388889 0.264321 3.6416667 0.264878 3.6444444 0.262648 3.6472222 0.262648 3.6500000 0.261533 3.6527778 0.262648 3.6555556 0.263763 3.6583333 0.263206 3.6611111 0.264878 3.6638889 0.262648 3.6666667 0.263206 3.6694444 0.263206 3.6722222 0.263206 3.6750000 0.263206 3.6777778 0.262648 3.6805556 0.262091 3.6833333 0.263206 3.6861111 0.264321 3.6888889 0.264878 3.6916667 0.263763 3.6944444 0.262648 3.6972222 0.260418 3.7000000 0.261533 3.7027778 0.262091 3.7055556 0.262648 3.7083333 0.264321 3.7111111 0.263763 3.7138889 0.260976 3.7166667 0.263206 3.7194444 0.264878 3.7222222 0.264878 3.7250000 0.263206 3.7277778 0.263206 3.7305556 0.262648 3.7333333 0.262648 3.7361111 0.263206 3.7388889 0.263206 3.7416667 0.263206 3.7444444 0.262091 3.7472222 0.262091 3.7500000 0.262091 3.7527778 0.263763 3.7555556 0.263763 3.7583333 0.263763 3.7611111 0.261533 3.7638889 0.260976 3.7666667 0.262091 3.7694444 0.263206 3.7722222 0.264321 3.7750000 0.265436 3.7777778 0.265993 3.7805556 0.265993 3.7833333 0.269338 3.7861111 0.269895 3.7888889 0.271568 3.7916667 0.271010 3.7944444 0.270453 3.7972222 0.271010 3.8000000 0.272125 3.8027778 0.273798 3.8055556 0.273798 3.8083333 0.275470 3.8111111 0.273798 3.8138889 0.273798 3.8166667 0.275470 3.8194444 0.274355 3.8222222 0.274913 3.8250000 0.273798 3.8277778 0.272683 3.8305556 0.271568 3.8333333 0.273240 3.8361111 0.274355 3.8388889 0.274355 3.8416667 0.272125 3.8444444 0.271568 3.8472222 0.272125 3.8500000 0.274355 3.8527778 0.277143 3.8555556 0.278258 3.8583333 0.276585 3.8611111 0.274355 3.8638889 0.269895 3.8666667 0.269895 3.8694444 0.268223 3.8722222 0.268223 3.8750000 0.265436 3.8777778 0.263206 3.8805556 0.262091 3.8833333 0.262091 3.8861111 0.261533 3.8888889 0.260976 3.8916667 0.260976 3.8944444 0.262091 3.8972222 0.260418 3.9000000 0.261533 3.9027778 0.262091 3.9055556 0.262091 3.9083333 0.261533 3.9111111 0.260418 3.9138889 0.258746 3.9166667 0.260418 3.9194444 0.258746 3.9222222 0.261533 3.9250000 0.262091 3.9277778 0.259861 3.9305556 0.257631 3.9333333 0.259861 3.9361111 0.261533 3.9388889 0.260976 3.9416667 0.260976 3.9444444 0.260418 3.9472222 0.257631 3.9500000 0.256516 3.9527778 0.255958 3.9555556 0.252613 3.9583333 0.249268 3.9611111 0.247038 3.9638889 0.243136 3.9666667 0.239233 3.9694444 0.239791 3.9722222 0.244808 3.9750000 0.254843 3.9777778 0.267108 3.9805556 0.282160 3.9833333 0.304460 3.9861111 0.335122 3.9888889 0.366341 3.9916667 0.389199 3.9944444 0.398676 3.9972222 0.388641 4.0000000 0.357979 4.0027778 0.314495 4.0055556 0.276028 4.0083333 0.252613 4.0111111 0.244251 4.0138889 0.245366 4.0166667 0.249826 4.0194444 0.255401 4.0222222 0.256516 4.0250000 0.255958 4.0277778 0.255958 4.0305556 0.255401 4.0333333 0.256516 4.0361111 0.257631 4.0388889 0.257073 4.0416667 0.257073 4.0444444 0.255401 4.0472222 0.254286 4.0500000 0.254286 4.0527778 0.256516 4.0555556 0.256516 4.0583333 0.254843 4.0611111 0.254843 4.0638889 0.253728 4.0666667 0.254286 4.0694444 0.255958 4.0722222 0.255958 4.0750000 0.255401 4.0777778 0.253728 4.0805556 0.253728 4.0833333 0.253728 4.0861111 0.255401 4.0888889 0.256516 4.0916667 0.256516 4.0944444 0.254286 4.0972222 0.253728 4.1000000 0.254843 4.1027778 0.255958 4.1055556 0.255958 4.1083333 0.255958 4.1111111 0.254843 4.1138889 0.254286 4.1166667 0.254286 4.1194444 0.255401 4.1222222 0.256516 4.1250000 0.255958 4.1277778 0.254286 4.1305556 0.252613 4.1333333 0.253728 4.1361111 0.254843 4.1388889 0.254286 4.1416667 0.254843 4.1444444 0.253728 4.1472222 0.252613 4.1500000 0.252613 4.1527778 0.254286 4.1555556 0.255958 4.1583333 0.256516 4.1611111 0.255401 4.1638889 0.254286 4.1666667 0.254286 4.1694444 0.255401 4.1722222 0.256516 4.1750000 0.254286 4.1777778 0.253171 4.1805556 0.253171 4.1833333 0.253728 4.1861111 0.253728 4.1888889 0.254843 4.1916667 0.253171 4.1944444 0.253728 4.1972222 0.252613 4.2000000 0.254286 4.2027778 0.255401 4.2055556 0.254843 4.2083333 0.255401 4.2111111 0.255401 4.2138889 0.254286 4.2166667 0.255401 4.2194444 0.255958 4.2222222 0.255958 4.2250000 0.254843 4.2277778 0.254286 4.2305556 0.252613 4.2333333 0.252613 4.2361111 0.254286 4.2388889 0.254286 4.2416667 0.253171 4.2444444 0.252056 4.2472222 0.250383 4.2500000 0.250941 4.2527778 0.251498 4.2555556 0.252056 4.2583333 0.252056 4.2611111 0.249826 4.2638889 0.250383 4.2666667 0.250383 4.2694444 0.251498 4.2722222 0.251498 4.2750000 0.250383 4.2777778 0.250941 4.2805556 0.249826 4.2833333 0.252056 4.2861111 0.252056 4.2888889 0.253728 4.2916667 0.255401 4.2944444 0.255401 4.2972222 0.257073 4.3000000 0.259303 4.3027778 0.262648 4.3055556 0.263206 4.3083333 0.263763 4.3111111 0.263206 4.3138889 0.263206 4.3166667 0.265436 4.3194444 0.267108 4.3222222 0.268223 4.3250000 0.267666 4.3277778 0.267666 4.3305556 0.265436 4.3333333 0.267108 4.3361111 0.268223 4.3388889 0.268780 4.3416667 0.266551 4.3444444 0.267666 4.3472222 0.267108 4.3500000 0.267666 4.3527778 0.268780 4.3555556 0.269338 4.3583333 0.269338 4.3611111 0.267666 4.3638889 0.267666 4.3666667 0.268223 4.3694444 0.269895 4.3722222 0.269895 4.3750000 0.269895 4.3777778 0.269338 4.3805556 0.267666 4.3833333 0.268223 4.3861111 0.269338 4.3888889 0.269338 4.3916667 0.267666 4.3944444 0.267108 4.3972222 0.265993 4.4000000 0.267108 4.4027778 0.267108 4.4055556 0.268223 4.4083333 0.267666 4.4111111 0.266551 4.4138889 0.265993 4.4166667 0.265436 4.4194444 0.267108 4.4222222 0.266551 4.4250000 0.265993 4.4277778 0.265436 4.4305556 0.263763 4.4333333 0.263763 4.4361111 0.264878 4.4388889 0.265436 4.4416667 0.264878 4.4444444 0.264878 4.4472222 0.263763 4.4500000 0.264321 4.4527778 0.265436 4.4555556 0.264321 4.4583333 0.264878 4.4611111 0.263206 4.4638889 0.263206 4.4666667 0.264321 4.4694444 0.265436 4.4722222 0.265436 4.4750000 0.265436 4.4777778 0.263206 4.4805556 0.262648 4.4833333 0.263206 4.4861111 0.264321 4.4888889 0.263763 4.4916667 0.263763 4.4944444 0.263206 4.4972222 0.262648 4.5000000 0.263206 4.5027778 0.263763 4.5055556 0.263763 4.5083333 0.264321 4.5111111 0.263763 4.5138889 0.263206 4.5166667 0.263763 4.5194444 0.264878 4.5222222 0.265993 4.5250000 0.263763 4.5277778 0.264878 4.5305556 0.262648 4.5333333 0.263206 4.5361111 0.265436 4.5388889 0.264321 4.5416667 0.263206 4.5444444 0.263206 4.5472222 0.262648 4.5500000 0.263206 4.5527778 0.263206 4.5555556 0.264321 4.5583333 0.264321 4.5611111 0.263206 4.5638889 0.263206 4.5666667 0.263763 4.5694444 0.264878 4.5722222 0.264878 4.5750000 0.264878 4.5777778 0.263206 4.5805556 0.263206 4.5833333 0.264321 4.5861111 0.264878 4.5888889 0.265993 4.5916667 0.265993 4.5944444 0.267108 4.5972222 0.264878 4.6000000 0.266551 4.6027778 0.269338 4.6055556 0.271568 4.6083333 0.271568 4.6111111 0.271010 4.6138889 0.270453 4.6166667 0.271568 4.6194444 0.273798 4.6222222 0.274355 4.6250000 0.274913 4.6277778 0.275470 4.6305556 0.275470 4.6333333 0.276028 4.6361111 0.277700 4.6388889 0.277143 4.6416667 0.277143 4.6444444 0.274913 4.6472222 0.273798 4.6500000 0.273240 4.6527778 0.274355 4.6555556 0.276028 4.6583333 0.273240 4.6611111 0.273240 4.6638889 0.272125 4.6666667 0.273798 4.6694444 0.276585 4.6722222 0.277700 4.6750000 0.275470 4.6777778 0.271568 4.6805556 0.269338 4.6833333 0.268223 4.6861111 0.266551 4.6888889 0.265993 4.6916667 0.264321 4.6944444 0.263206 4.6972222 0.263763 4.7000000 0.264321 4.7027778 0.263206 4.7055556 0.263206 4.7083333 0.262648 4.7111111 0.262091 4.7138889 0.261533 4.7166667 0.262091 4.7194444 0.262648 4.7222222 0.264321 4.7250000 0.263763 4.7277778 0.262648 4.7305556 0.261533 4.7333333 0.261533 4.7361111 0.261533 4.7388889 0.262648 4.7416667 0.262091 4.7444444 0.261533 4.7472222 0.260418 4.7500000 0.262091 4.7527778 0.262091 4.7555556 0.262091 4.7583333 0.262091 4.7611111 0.261533 4.7638889 0.260418 4.7666667 0.259303 4.7694444 0.258746 4.7722222 0.254843 4.7750000 0.250383 4.7777778 0.246481 4.7805556 0.244808 4.7833333 0.242021 4.7861111 0.240348 4.7888889 0.243693 4.7916667 0.253728 4.7944444 0.268780 4.7972222 0.284948 4.8000000 0.307247 4.8027778 0.333449 4.8055556 0.364669 4.8083333 0.390314 4.8111111 0.405366 4.8138889 0.402578 4.8166667 0.386411 4.8194444 0.349617 4.8222222 0.302230 4.8250000 0.267108 4.8277778 0.250383 4.8305556 0.247596 4.8333333 0.252613 4.8361111 0.257631 4.8388889 0.259861 4.8416667 0.259861 4.8444444 0.258746 4.8472222 0.257631 4.8500000 0.257631 4.8527778 0.258188 4.8555556 0.258746 4.8583333 0.259303 4.8611111 0.258746 4.8638889 0.257073 4.8666667 0.257073 4.8694444 0.258188 4.8722222 0.258746 4.8750000 0.258746 4.8777778 0.257073 4.8805556 0.255958 4.8833333 0.257073 4.8861111 0.257073 4.8888889 0.256516 4.8916667 0.257073 4.8944444 0.255958 4.8972222 0.254286 4.9000000 0.255401 4.9027778 0.255958 4.9055556 0.257631 4.9083333 0.255958 4.9111111 0.255958 4.9138889 0.255401 4.9166667 0.255401 4.9194444 0.255958 4.9222222 0.256516 4.9250000 0.256516 4.9277778 0.255958 4.9305556 0.254843 4.9333333 0.256516 4.9361111 0.257073 4.9388889 0.258188 4.9416667 0.258188 4.9444444 0.257631 4.9472222 0.256516 4.9500000 0.257073 4.9527778 0.258746 4.9555556 0.258746 4.9583333 0.258746 4.9611111 0.258188 4.9638889 0.257073 4.9666667 0.258746 4.9694444 0.256516 4.9722222 0.258188 4.9750000 0.258746 4.9777778 0.257631 4.9805556 0.256516 4.9833333 0.256516 4.9861111 0.257073 4.9888889 0.258188 4.9916667 0.258188 4.9944444 0.257073 4.9972222 0.255958 5.0000000 0.256516 5.0027778 0.257073 5.0055556 0.258188 5.0083333 0.257631 5.0111111 0.257073 5.0138889 0.256516 5.0166667 0.257631 5.0194444 0.257631 5.0222222 0.258746 5.0250000 0.258746 5.0277778 0.259303 5.0305556 0.256516 5.0333333 0.259303 5.0361111 0.259303 5.0388889 0.259861 5.0416667 0.258188 5.0444444 0.257631 5.0472222 0.255401 5.0500000 0.256516 5.0527778 0.258188 5.0555556 0.258188 5.0583333 0.258746 5.0611111 0.257073 5.0638889 0.256516 5.0666667 0.256516 5.0694444 0.256516 5.0722222 0.256516 5.0750000 0.258188 5.0777778 0.257073 5.0805556 0.255958 5.0833333 0.257631 5.0861111 0.258746 5.0888889 0.258188 5.0916667 0.258188 5.0944444 0.256516 5.0972222 0.254843 5.1000000 0.258188 5.1027778 0.258746 5.1055556 0.259861 5.1083333 0.258188 5.1111111 0.257073 5.1138889 0.257631 5.1166667 0.258746 5.1194444 0.259861 5.1222222 0.261533 5.1250000 0.261533 5.1277778 0.263206 5.1305556 0.263206 5.1333333 0.264878 5.1361111 0.265436 5.1388889 0.267108 5.1416667 0.268223 5.1444444 0.268223 5.1472222 0.267108 5.1500000 0.268780 5.1527778 0.269895 5.1555556 0.268780 5.1583333 0.268780 5.1611111 0.268780 5.1638889 0.267666 5.1666667 0.267666 5.1694444 0.268780 5.1722222 0.269338 5.1750000 0.268780 5.1777778 0.268223 5.1805556 0.267666 5.1833333 0.267666 5.1861111 0.268780 5.1888889 0.268780 5.1916667 0.268223 5.1944444 0.267666 5.1972222 0.266551 5.2000000 0.267108 5.2027778 0.268223 5.2055556 0.268780 5.2083333 0.268223 5.2111111 0.268223 5.2138889 0.267108 5.2166667 0.268223 5.2194444 0.268780 5.2222222 0.269338 5.2250000 0.268780 5.2277778 0.267666 5.2305556 0.265436 5.2333333 0.265993 5.2361111 0.268223 5.2388889 0.269895 5.2416667 0.269895 5.2444444 0.269338 5.2472222 0.268223 5.2500000 0.268223 5.2527778 0.269895 5.2555556 0.270453 5.2583333 0.270453 5.2611111 0.270453 5.2638889 0.268780 5.2666667 0.270453 5.2694444 0.272683 5.2722222 0.273798 5.2750000 0.273798 5.2777778 0.272125 5.2805556 0.272125 5.2833333 0.272683 5.2861111 0.276028 5.2888889 0.275470 5.2916667 0.272683 5.2944444 0.271568 5.2972222 0.274355 5.3000000 0.277143 5.3027778 0.276585 5.3055556 0.275470 5.3083333 0.274355 5.3111111 0.273240 5.3138889 0.273240 5.3166667 0.272683 5.3194444 0.272125 5.3222222 0.269895 5.3250000 0.268223 5.3277778 0.264878 5.3305556 0.264321 5.3333333 0.264321 5.3361111 0.265436 5.3388889 0.263206 5.3416667 0.262091 5.3444444 0.261533 5.3472222 0.259861 5.3500000 0.259303 5.3527778 0.259861 5.3555556 0.260976 5.3583333 0.260418 5.3611111 0.258188 5.3638889 0.257073 5.3666667 0.258188 5.3694444 0.258746 5.3722222 0.259303 5.3750000 0.259303 5.3777778 0.258746 5.3805556 0.257631 5.3833333 0.259861 5.3861111 0.260976 5.3888889 0.260418 5.3916667 0.260418 5.3944444 0.260976 5.3972222 0.259303 5.4000000 0.260976 5.4027778 0.260976 5.4055556 0.262091 5.4083333 0.260418 5.4111111 0.260976 5.4138889 0.258188 5.4166667 0.259303 5.4194444 0.258188 5.4222222 0.255401 5.4250000 0.252056 5.4277778 0.247038 5.4305556 0.242021 5.4333333 0.242021 5.4361111 0.238676 5.4388889 0.236446 5.4416667 0.239791 5.4444444 0.250383 5.4472222 0.265993 5.4500000 0.284390 5.4527778 0.302787 5.4555556 0.328990 5.4583333 0.356864 5.4611111 0.381951 5.4638889 0.394216 5.4666667 0.397561 5.4694444 0.381951 5.4722222 0.344599 5.4750000 0.297213 5.4777778 0.262648 5.4805556 0.246481 5.4833333 0.247596 5.4861111 0.253728 5.4888889 0.258188 5.4916667 0.259303 5.4944444 0.257073 5.4972222 0.255401 5.5000000 0.257631 5.5027778 0.256516 5.5055556 0.258188 5.5083333 0.257073 5.5111111 0.255958 5.5138889 0.254843 5.5166667 0.256516 5.5194444 0.257631 5.5222222 0.257073 5.5250000 0.257073 5.5277778 0.255958 5.5305556 0.255401 5.5333333 0.254843 5.5361111 0.255401 5.5388889 0.256516 5.5416667 0.256516 5.5444444 0.255958 5.5472222 0.255401 5.5500000 0.256516 5.5527778 0.257073 5.5555556 0.256516 5.5583333 0.257073 5.5611111 0.254286 5.5638889 0.253171 5.5666667 0.254843 5.5694444 0.254286 5.5722222 0.256516 5.5750000 0.256516 5.5777778 0.256516 5.5805556 0.255401 5.5833333 0.255401 5.5861111 0.256516 5.5888889 0.258188 5.5916667 0.257631 5.5944444 0.255958 5.5972222 0.255401 5.6000000 0.256516 5.6027778 0.255401 5.6055556 0.256516 5.6083333 0.255958 5.6111111 0.254286 5.6138889 0.253728 5.6166667 0.254843 5.6194444 0.257073 5.6222222 0.257073 5.6250000 0.257631 5.6277778 0.255401 5.6305556 0.255401 5.6333333 0.255958 5.6361111 0.256516 5.6388889 0.257631 5.6416667 0.258188 5.6444444 0.255958 5.6472222 0.255958 5.6500000 0.257073 5.6527778 0.257631 5.6555556 0.258188 5.6583333 0.257073 5.6611111 0.256516 5.6638889 0.255401 5.6666667 0.255401 5.6694444 0.257073 5.6722222 0.257631 5.6750000 0.255958 5.6777778 0.256516 5.6805556 0.255401 5.6833333 0.255958 5.6861111 0.257073 5.6888889 0.257631 5.6916667 0.257073 5.6944444 0.255958 5.6972222 0.254843 5.7000000 0.255401 5.7027778 0.256516 5.7055556 0.257631 5.7083333 0.257631 5.7111111 0.257073 5.7138889 0.254843 5.7166667 0.255958 5.7194444 0.255401 5.7222222 0.256516 5.7250000 0.255401 5.7277778 0.254843 5.7305556 0.252613 5.7333333 0.253171 5.7361111 0.254843 5.7388889 0.255401 5.7416667 0.254843 5.7444444 0.254843 5.7472222 0.253728 5.7500000 0.255401 5.7527778 0.256516 5.7555556 0.257631 5.7583333 0.257073 5.7611111 0.255958 5.7638889 0.254843 5.7666667 0.256516 5.7694444 0.258746 5.7722222 0.258746 5.7750000 0.258746 5.7777778 0.257073 5.7805556 0.258746 5.7833333 0.260418 5.7861111 0.261533 5.7888889 0.262091 5.7916667 0.262648 5.7944444 0.262091 5.7972222 0.260418 5.8000000 0.262648 5.8027778 0.263763 5.8055556 0.265436 5.8083333 0.265993 5.8111111 0.265993 5.8138889 0.264321 5.8166667 0.264878 5.8194444 0.265436 5.8222222 0.265993 5.8250000 0.265993 5.8277778 0.263206 5.8305556 0.263763 5.8333333 0.261533 5.8361111 0.263763 5.8388889 0.264878 5.8416667 0.264878 5.8444444 0.265993 5.8472222 0.265436 5.8500000 0.265436 5.8527778 0.266551 5.8555556 0.265993 5.8583333 0.265993 5.8611111 0.264878 5.8638889 0.264321 5.8666667 0.263763 5.8694444 0.264878 5.8722222 0.265993 5.8750000 0.264878 5.8777778 0.263763 5.8805556 0.263763 5.8833333 0.263206 5.8861111 0.264878 5.8888889 0.264878 5.8916667 0.265436 5.8944444 0.263206 5.8972222 0.262091 5.9000000 0.262648 5.9027778 0.263206 5.9055556 0.261533 5.9083333 0.260418 5.9111111 0.259303 5.9138889 0.258746 5.9166667 0.261533 5.9194444 0.262091 5.9222222 0.262091 5.9250000 0.261533 5.9277778 0.259861 5.9305556 0.259303 5.9333333 0.259861 5.9361111 0.259861 5.9388889 0.261533 5.9416667 0.260418 5.9444444 0.259303 5.9472222 0.260976 5.9500000 0.259861 5.9527778 0.260976 5.9555556 0.262091 5.9583333 0.261533 5.9611111 0.260418 5.9638889 0.258746 5.9666667 0.260976 5.9694444 0.260976 5.9722222 0.260976 5.9750000 0.261533 5.9777778 0.260976 5.9805556 0.260418 5.9833333 0.259861 5.9861111 0.261533 5.9888889 0.260418 5.9916667 0.260976 5.9944444 0.259861 5.9972222 0.258746 6.0000000 0.260418 6.0027778 0.260418 6.0055556 0.260976 6.0083333 0.260418 6.0111111 0.259861 6.0138889 0.256516 6.0166667 0.257073 6.0194444 0.259861 6.0222222 0.259861 6.0250000 0.258746 6.0277778 0.258746 6.0305556 0.256516 6.0333333 0.258188 6.0361111 0.258746 6.0388889 0.260976 6.0416667 0.262091 6.0444444 0.261533 6.0472222 0.259861 6.0500000 0.259861 6.0527778 0.260976 6.0555556 0.260976 6.0583333 0.262648 6.0611111 0.259861 6.0638889 0.259303 6.0666667 0.259303 6.0694444 0.259861 6.0722222 0.259861 6.0750000 0.259303 6.0777778 0.258188 6.0805556 0.257073 6.0833333 0.257073 6.0861111 0.259303 6.0888889 0.258746 6.0916667 0.258188 6.0944444 0.258746 6.0972222 0.258188 6.1000000 0.259303 6.1027778 0.260418 6.1055556 0.260418 6.1083333 0.259861 6.1111111 0.259303 6.1138889 0.258746 6.1166667 0.259861 6.1194444 0.260976 6.1222222 0.262091 6.1250000 0.261533 6.1277778 0.262091 6.1305556 0.260976 6.1333333 0.261533 6.1361111 0.260976 6.1388889 0.259861 6.1416667 0.260976 6.1444444 0.259861 6.1472222 0.258746 6.1500000 0.259861 6.1527778 0.259861 6.1555556 0.260418 6.1583333 0.259861 6.1611111 0.258188 6.1638889 0.258188 6.1666667 0.258746 6.1694444 0.260976 6.1722222 0.260418 6.1750000 0.259861 6.1777778 0.259303 6.1805556 0.258188 6.1833333 0.258746 6.1861111 0.259303 6.1888889 0.259861 6.1916667 0.260418 6.1944444 0.259861 6.1972222 0.259861 6.2000000 0.260976 6.2027778 0.262091 6.2055556 0.261533 6.2083333 0.261533 6.2111111 0.260418 6.2138889 0.259861 6.2166667 0.259861 6.2194444 0.259303 6.2222222 0.261533 6.2250000 0.260418 6.2277778 0.260976 6.2305556 0.259861 6.2333333 0.260418 6.2361111 0.259861 6.2388889 0.261533 6.2416667 0.262648 6.2444444 0.263206 6.2472222 0.263206 6.2500000 0.265436 6.2527778 0.265993 6.2555556 0.266551 6.2583333 0.265993 6.2611111 0.267108 6.2638889 0.265993 6.2666667 0.268223 6.2694444 0.269338 6.2722222 0.270453 6.2750000 0.271568 6.2777778 0.271568 6.2805556 0.271010 6.2833333 0.270453 6.2861111 0.271568 6.2888889 0.271568 6.2916667 0.271010 6.2944444 0.268780 6.2972222 0.267666 6.3000000 0.268780 6.3027778 0.269895 6.3055556 0.271568 6.3083333 0.269338 6.3111111 0.267666 6.3138889 0.264321 6.3166667 0.266551 6.3194444 0.267108 6.3222222 0.269895 6.3250000 0.270453 6.3277778 0.269895 6.3305556 0.268223 6.3333333 0.266551 6.3361111 0.265436 6.3388889 0.264878 6.3416667 0.264321 6.3444444 0.260976 6.3472222 0.258746 6.3500000 0.259303 6.3527778 0.259303 6.3555556 0.259303 6.3583333 0.258746 6.3611111 0.258746 6.3638889 0.258746 6.3666667 0.257631 6.3694444 0.259861 6.3722222 0.258188 6.3750000 0.258188 6.3777778 0.255401 6.3805556 0.253171 6.3833333 0.254843 6.3861111 0.255401 6.3888889 0.257073 6.3916667 0.257631 6.3944444 0.255401 6.3972222 0.253728 6.4000000 0.254843 6.4027778 0.255958 6.4055556 0.255958 6.4083333 0.255958 6.4111111 0.254286 6.4138889 0.252056 6.4166667 0.250941 6.4194444 0.249268 6.4222222 0.245366 6.4250000 0.245923 6.4277778 0.242021 6.4305556 0.236446 6.4333333 0.235889 6.4361111 0.241463 6.4388889 0.253171 6.4416667 0.265993 6.4444444 0.278815 6.4472222 0.297770 6.4500000 0.324530 6.4527778 0.354077 6.4555556 0.379721 6.4583333 0.394216 6.4611111 0.398676 6.4638889 0.388084 6.4666667 0.362439 6.4694444 0.325087 6.4722222 0.292195 6.4750000 0.268223 6.4777778 0.252613 6.4805556 0.244251 6.4833333 0.238676 6.4861111 0.240348 6.4888889 0.244251 6.4916667 0.248153 6.4944444 0.249826 6.4972222 0.249826 6.5000000 0.251498 6.5027778 0.253171 6.5055556 0.254286 6.5083333 0.254286 6.5111111 0.253728 6.5138889 0.253171 6.5166667 0.252613 6.5194444 0.253171 6.5222222 0.252056 6.5250000 0.252056 6.5277778 0.250941 6.5305556 0.249826 6.5333333 0.249826 6.5361111 0.252056 6.5388889 0.252056 6.5416667 0.252056 6.5444444 0.250383 6.5472222 0.250383 6.5500000 0.250941 6.5527778 0.252613 6.5555556 0.252056 6.5583333 0.252056 6.5611111 0.252613 6.5638889 0.250383 6.5666667 0.250383 6.5694444 0.252056 6.5722222 0.251498 6.5750000 0.251498 6.5777778 0.250383 6.5805556 0.250383 6.5833333 0.251498 6.5861111 0.252056 6.5888889 0.252613 6.5916667 0.252056 6.5944444 0.252056 6.5972222 0.250941 6.6000000 0.253171 6.6027778 0.252056 6.6055556 0.252613 6.6083333 0.252056 6.6111111 0.250941 6.6138889 0.250941 6.6166667 0.252056 6.6194444 0.252056 6.6222222 0.253728 6.6250000 0.252613 6.6277778 0.252056 6.6305556 0.249268 6.6333333 0.250383 6.6361111 0.250383 6.6388889 0.252056 6.6416667 0.252056 6.6444444 0.250941 6.6472222 0.250941 6.6500000 0.251498 6.6527778 0.252056 6.6555556 0.253728 6.6583333 0.253728 6.6611111 0.252613 6.6638889 0.252613 6.6666667 0.253171 6.6694444 0.254843 6.6722222 0.254843 6.6750000 0.253728 6.6777778 0.253728 6.6805556 0.252613 6.6833333 0.252056 6.6861111 0.254843 6.6888889 0.254843 6.6916667 0.254843 6.6944444 0.254843 6.6972222 0.252056 6.7000000 0.253728 6.7027778 0.254286 6.7055556 0.253728 6.7083333 0.252056 6.7111111 0.250383 6.7138889 0.248153 6.7166667 0.248711 6.7194444 0.249826 6.7222222 0.249268 6.7250000 0.248711 6.7277778 0.248153 6.7305556 0.245923 6.7333333 0.244808 6.7361111 0.247038 6.7388889 0.245366 6.7416667 0.244251 6.7444444 0.244808 6.7472222 0.242578 6.7500000 0.244251 6.7527778 0.245923 6.7555556 0.245366 6.7583333 0.245923 6.7611111 0.244251 6.7638889 0.244251 6.7666667 0.245366 6.7694444 0.246481 6.7722222 0.248711 6.7750000 0.248711 6.7777778 0.247596 6.7805556 0.248153 6.7833333 0.250941 6.7861111 0.252056 6.7888889 0.252613 6.7916667 0.254286 6.7944444 0.254286 6.7972222 0.255401 6.8000000 0.256516 6.8027778 0.257631 6.8055556 0.260418 6.8083333 0.260976 6.8111111 0.260418 6.8138889 0.260976 6.8166667 0.262091 6.8194444 0.263206 6.8222222 0.263763 6.8250000 0.265993 6.8277778 0.264321 6.8305556 0.264878 6.8333333 0.265993 6.8361111 0.266551 6.8388889 0.265993 6.8416667 0.265993 6.8444444 0.265436 6.8472222 0.263206 6.8500000 0.265436 6.8527778 0.264878 6.8555556 0.264878 6.8583333 0.264321 6.8611111 0.263763 6.8638889 0.263763 6.8666667 0.263763 6.8694444 0.265436 6.8722222 0.265436 6.8750000 0.264878 6.8777778 0.263763 6.8805556 0.263206 6.8833333 0.263763 6.8861111 0.263763 6.8888889 0.264878 6.8916667 0.264321 6.8944444 0.263206 6.8972222 0.262648 6.9000000 0.263206 6.9027778 0.264878 6.9055556 0.264321 6.9083333 0.264321 6.9111111 0.262648 6.9138889 0.262648 6.9166667 0.263763 6.9194444 0.263763 6.9222222 0.264321 6.9250000 0.264321 6.9277778 0.263763 6.9305556 0.260976 6.9333333 0.261533 6.9361111 0.261533 6.9388889 0.262648 6.9416667 0.261533 6.9444444 0.260418 6.9472222 0.260418 6.9500000 0.260418 6.9527778 0.261533 6.9555556 0.262648 6.9583333 0.262648 6.9611111 0.261533 6.9638889 0.260418 6.9666667 0.262091 6.9694444 0.262648 6.9722222 0.263206 6.9750000 0.262648 6.9777778 0.261533 6.9805556 0.260976 6.9833333 0.260976 6.9861111 0.262091 6.9888889 0.262648 6.9916667 0.263206 6.9944444 0.259861 6.9972222 0.260418 7.0000000 0.261533 7.0027778 0.262648 7.0055556 0.261533 7.0083333 0.260976 7.0111111 0.259861 7.0138889 0.257631 7.0166667 0.258746 7.0194444 0.261533 7.0222222 0.261533 7.0250000 0.260976 7.0277778 0.260418 7.0305556 0.259303 7.0333333 0.259861 7.0361111 0.261533 7.0388889 0.261533 7.0416667 0.260976 7.0444444 0.259861 7.0472222 0.259861 7.0500000 0.260976 7.0527778 0.260418 7.0555556 0.262091 7.0583333 0.261533 7.0611111 0.260418 7.0638889 0.260418 7.0666667 0.260418 7.0694444 0.262091 7.0722222 0.262091 7.0750000 0.261533 7.0777778 0.259303 7.0805556 0.258746 7.0833333 0.260976 7.0861111 0.263206 7.0888889 0.264321 7.0916667 0.264878 7.0944444 0.267108 7.0972222 0.265993 7.1000000 0.267108 7.1027778 0.266551 7.1055556 0.268223 7.1083333 0.269338 7.1111111 0.271010 7.1138889 0.269338 7.1166667 0.270453 7.1194444 0.271010 7.1222222 0.272125 7.1250000 0.272683 7.1277778 0.271568 7.1305556 0.270453 7.1333333 0.271010 7.1361111 0.271010 7.1388889 0.272125 7.1416667 0.271010 7.1444444 0.268780 7.1472222 0.268780 7.1500000 0.269338 7.1527778 0.268223 7.1555556 0.268780 7.1583333 0.271568 7.1611111 0.272683 7.1638889 0.272683 7.1666667 0.271010 7.1694444 0.268223 7.1722222 0.267666 7.1750000 0.266551 7.1777778 0.264321 7.1805556 0.262648 7.1833333 0.260418 7.1861111 0.260976 7.1888889 0.260418 7.1916667 0.260418 7.1944444 0.258188 7.1972222 0.257073 7.2000000 0.257631 7.2027778 0.259861 7.2055556 0.260976 7.2083333 0.259861 7.2111111 0.259303 7.2138889 0.258746 7.2166667 0.258746 7.2194444 0.259303 7.2222222 0.259861 7.2250000 0.259303 7.2277778 0.258746 7.2305556 0.257073 7.2333333 0.257073 7.2361111 0.259303 7.2388889 0.259861 7.2416667 0.257631 7.2444444 0.257073 7.2472222 0.255958 7.2500000 0.255958 7.2527778 0.257073 7.2555556 0.257631 7.2583333 0.255958 7.2611111 0.252613 7.2638889 0.248153 7.2666667 0.244251 7.2694444 0.242578 7.2722222 0.240906 7.2750000 0.237561 7.2777778 0.234774 7.2805556 0.240906 7.2833333 0.254286 7.2861111 0.271568 7.2888889 0.288293 7.2916667 0.311707 7.2944444 0.339582 7.2972222 0.366899 7.3000000 0.390314 7.3027778 0.399233 7.3055556 0.392544 7.3083333 0.364669 7.3111111 0.320627 7.3138889 0.277143 7.3166667 0.249826 7.3194444 0.241463 7.3222222 0.244808 7.3250000 0.248153 7.3277778 0.251498 7.3305556 0.253728 7.3333333 0.253728 7.3361111 0.253728 7.3388889 0.255401 7.3416667 0.255958 7.3444444 0.254843 7.3472222 0.252613 7.3500000 0.251498 7.3527778 0.253728 7.3555556 0.253728 7.3583333 0.253728 7.3611111 0.253728 7.3638889 0.252056 7.3666667 0.253171 7.3694444 0.254286 7.3722222 0.254843 7.3750000 0.253171 7.3777778 0.254286 7.3805556 0.253171 7.3833333 0.255401 7.3861111 0.255958 7.3888889 0.257073 7.3916667 0.255401 7.3944444 0.255401 7.3972222 0.255401 7.4000000 0.255401 7.4027778 0.255958 7.4055556 0.255401 7.4083333 0.255401 7.4111111 0.255401 7.4138889 0.254286 7.4166667 0.255958 7.4194444 0.254286 7.4222222 0.255401 7.4250000 0.255958 7.4277778 0.254843 7.4305556 0.254286 7.4333333 0.253728 7.4361111 0.254843 7.4388889 0.255401 7.4416667 0.255958 7.4444444 0.254843 7.4472222 0.253728 7.4500000 0.254843 7.4527778 0.253728 7.4555556 0.254286 7.4583333 0.254843 7.4611111 0.254843 7.4638889 0.254286 7.4666667 0.254843 7.4694444 0.255401 7.4722222 0.255958 7.4750000 0.254843 7.4777778 0.254843 7.4805556 0.255401 7.4833333 0.255958 7.4861111 0.256516 7.4888889 0.255958 7.4916667 0.256516 7.4944444 0.255958 7.4972222 0.253171 7.5000000 0.253728 7.5027778 0.254843 7.5055556 0.255401 7.5083333 0.255401 7.5111111 0.253728 7.5138889 0.253171 7.5166667 0.254286 7.5194444 0.255958 7.5222222 0.255401 7.5250000 0.254843 7.5277778 0.253728 7.5305556 0.251498 7.5333333 0.253728 7.5361111 0.253728 7.5388889 0.255401 7.5416667 0.254843 7.5444444 0.253171 7.5472222 0.252056 7.5500000 0.252613 7.5527778 0.254286 7.5555556 0.254286 7.5583333 0.254843 7.5611111 0.253728 7.5638889 0.252613 7.5666667 0.252613 7.5694444 0.253171 7.5722222 0.254286 7.5750000 0.254286 7.5777778 0.253171 7.5805556 0.252056 7.5833333 0.252613 7.5861111 0.253171 7.5888889 0.254843 7.5916667 0.253728 7.5944444 0.254286 7.5972222 0.254286 7.6000000 0.257073 7.6027778 0.258746 7.6055556 0.259861 7.6083333 0.260976 7.6111111 0.260976 7.6138889 0.260976 7.6166667 0.262648 7.6194444 0.264321 7.6222222 0.265993 7.6250000 0.264878 7.6277778 0.264878 7.6305556 0.264321 7.6333333 0.265993 7.6361111 0.265993 7.6388889 0.267108 7.6416667 0.267666 7.6444444 0.267108 7.6472222 0.267108 7.6500000 0.268223 7.6527778 0.268223 7.6555556 0.269895 7.6583333 0.268780 7.6611111 0.268780 7.6638889 0.267108 7.6666667 0.268780 7.6694444 0.268223 7.6722222 0.269338 7.6750000 0.268223 7.6777778 0.267108 7.6805556 0.265993 7.6833333 0.267108 7.6861111 0.268223 7.6888889 0.268223 7.6916667 0.267666 7.6944444 0.266551 7.6972222 0.265436 7.7000000 0.267108 7.7027778 0.266551 7.7055556 0.267666 7.7083333 0.268223 7.7111111 0.265993 7.7138889 0.265436 7.7166667 0.266551 7.7194444 0.267108 7.7222222 0.265993 7.7250000 0.266551 7.7277778 0.265993 7.7305556 0.264321 7.7333333 0.264321 7.7361111 0.265436 7.7388889 0.266551 7.7416667 0.265436 7.7444444 0.264321 7.7472222 0.262091 7.7500000 0.263206 7.7527778 0.265436 7.7555556 0.264878 7.7583333 0.263763 7.7611111 0.263763 7.7638889 0.261533 7.7666667 0.263206 7.7694444 0.264321 7.7722222 0.264321 7.7750000 0.262648 7.7777778 0.262648 7.7805556 0.260418 7.7833333 0.262091 7.7861111 0.264321 7.7888889 0.264878 7.7916667 0.263206 7.7944444 0.262091 7.7972222 0.262091 7.8000000 0.260976 7.8027778 0.263206 7.8055556 0.263206 7.8083333 0.262091 7.8111111 0.260976 7.8138889 0.260418 7.8166667 0.261533 7.8194444 0.262648 7.8222222 0.262648 7.8250000 0.262091 7.8277778 0.262091 7.8305556 0.261533 7.8333333 0.262648 7.8361111 0.262648 7.8388889 0.263763 7.8416667 0.263763 7.8444444 0.262648 7.8472222 0.262091 7.8500000 0.262091 7.8527778 0.264321 7.8555556 0.264878 7.8583333 0.264321 7.8611111 0.262648 7.8638889 0.262648 7.8666667 0.264321 7.8694444 0.263763 7.8722222 0.264878 7.8750000 0.264321 7.8777778 0.264321 7.8805556 0.261533 7.8833333 0.262648 7.8861111 0.264321 7.8888889 0.265436 7.8916667 0.264321 7.8944444 0.264321 7.8972222 0.262091 7.9000000 0.263206 7.9027778 0.264321 7.9055556 0.265436 7.9083333 0.265436 7.9111111 0.265436 7.9138889 0.267108 7.9166667 0.268780 7.9194444 0.271568 7.9222222 0.272125 7.9250000 0.272125 7.9277778 0.271568 7.9305556 0.271010 7.9333333 0.273240 7.9361111 0.275470 7.9388889 0.274355 7.9416667 0.274355 7.9444444 0.276028 7.9472222 0.275470 7.9500000 0.274913 7.9527778 0.274355 7.9555556 0.274355 7.9583333 0.273798 7.9611111 0.272683 7.9638889 0.271568 7.9666667 0.273240 7.9694444 0.273798 7.9722222 0.272683 7.9750000 0.273798 7.9777778 0.274355 7.9805556 0.275470 7.9833333 0.278258 7.9861111 0.275470 7.9888889 0.272683 7.9916667 0.271010 7.9944444 0.269895 7.9972222 0.267666 8.0000000 0.266551 8.0027778 0.265993 8.0055556 0.265993 8.0083333 0.264321 8.0111111 0.263206 8.0138889 0.260976 8.0166667 0.260976 8.0194444 0.262648 8.0222222 0.262648 8.0250000 0.262648 8.0277778 0.262091 8.0305556 0.260976 8.0333333 0.260976 8.0361111 0.261533 8.0388889 0.262648 8.0416667 0.261533 8.0444444 0.260418 8.0472222 0.258746 8.0500000 0.260976 8.0527778 0.261533 8.0555556 0.262648 8.0583333 0.262648 8.0611111 0.262648 8.0638889 0.260418 8.0666667 0.260418 8.0694444 0.261533 8.0722222 0.260418 8.0750000 0.255958 8.0777778 0.249826 8.0805556 0.246481 8.0833333 0.243693 8.0861111 0.241463 8.0888889 0.239233 8.0916667 0.244251 8.0944444 0.255958 8.0972222 0.271568 8.1000000 0.292195 8.1027778 0.316167 8.1055556 0.347387 8.1083333 0.376376 8.1111111 0.397561 8.1138889 0.403136 8.1166667 0.388641 8.1194444 0.352404 8.1222222 0.302230 8.1250000 0.263763 8.1277778 0.247596 8.1305556 0.245923 8.1333333 0.254286 8.1361111 0.259303 8.1388889 0.260418 8.1416667 0.259303 8.1444444 0.257631 8.1472222 0.257073 8.1500000 0.257631 8.1527778 0.258746 8.1555556 0.258746 8.1583333 0.258188 8.1611111 0.257073 8.1638889 0.255958 8.1666667 0.257073 8.1694444 0.257631 8.1722222 0.257073 8.1750000 0.258188 8.1777778 0.256516 8.1805556 0.254843 8.1833333 0.254843 8.1861111 0.256516 8.1888889 0.257073 8.1916667 0.257073 8.1944444 0.256516 8.1972222 0.254286 8.2000000 0.255401 8.2027778 0.256516 8.2055556 0.257073 8.2083333 0.257073 8.2111111 0.255958 8.2138889 0.256516 8.2166667 0.255958 8.2194444 0.257631 8.2222222 0.258188 8.2250000 0.257631 8.2277778 0.257073 8.2305556 0.255401 8.2333333 0.257073 8.2361111 0.257631 8.2388889 0.258188 8.2416667 0.257631 8.2444444 0.255958 8.2472222 0.255958 8.2500000 0.257073 8.2527778 0.258188 8.2555556 0.258746 8.2583333 0.259303 8.2611111 0.257073 8.2638889 0.255958 8.2666667 0.257073 8.2694444 0.257073 8.2722222 0.258746 8.2750000 0.258188 8.2777778 0.258746 8.2805556 0.258188 8.2833333 0.258188 8.2861111 0.258746 8.2888889 0.260418 8.2916667 0.259303 8.2944444 0.257631 8.2972222 0.258188 8.3000000 0.258746 8.3027778 0.257631 8.3055556 0.259303 8.3083333 0.258746 8.3111111 0.258188 8.3138889 0.256516 8.3166667 0.257631 8.3194444 0.258188 8.3222222 0.257631 8.3250000 0.258746 8.3277778 0.258188 8.3305556 0.257631 8.3333333 0.257073 8.3361111 0.257073 8.3388889 0.258746 8.3416667 0.258188 8.3444444 0.258188 8.3472222 0.257631 8.3500000 0.257631 8.3527778 0.257631 8.3555556 0.257631 8.3583333 0.258188 8.3611111 0.256516 8.3638889 0.255958 8.3666667 0.257073 8.3694444 0.257073 8.3722222 0.258188 8.3750000 0.258188 8.3777778 0.257073 8.3805556 0.257073 8.3833333 0.256516 8.3861111 0.258746 8.3888889 0.259303 8.3916667 0.259303 8.3944444 0.258188 8.3972222 0.257073 8.4000000 0.260976 8.4027778 0.261533 8.4055556 0.263763 8.4083333 0.263763 8.4111111 0.263206 8.4138889 0.263763 8.4166667 0.263763 8.4194444 0.264878 8.4222222 0.264878 8.4250000 0.264878 8.4277778 0.266551 8.4305556 0.266551 8.4333333 0.268223 8.4361111 0.269895 8.4388889 0.270453 8.4416667 0.271010 8.4444444 0.269338 8.4472222 0.268223 8.4500000 0.270453 8.4527778 0.271568 8.4555556 0.272125 8.4583333 0.269895 8.4611111 0.268780 8.4638889 0.268223 8.4666667 0.268223 8.4694444 0.268780 8.4722222 0.269895 8.4750000 0.269895 8.4777778 0.269895 8.4805556 0.268223 8.4833333 0.268780 8.4861111 0.269338 8.4888889 0.269895 8.4916667 0.270453 8.4944444 0.269338 8.4972222 0.267666 8.5000000 0.268223 8.5027778 0.268223 8.5055556 0.269338 8.5083333 0.269895 8.5111111 0.268780 8.5138889 0.267108 8.5166667 0.268780 8.5194444 0.269895 8.5222222 0.269895 8.5250000 0.269338 8.5277778 0.268223 8.5305556 0.266551 8.5333333 0.267108 8.5361111 0.267666 8.5388889 0.267108 8.5416667 0.266551 8.5444444 0.267666 8.5472222 0.265993 8.5500000 0.267108 8.5527778 0.267666 8.5555556 0.267108 8.5583333 0.267666 8.5611111 0.265436 8.5638889 0.264321 8.5666667 0.264878 8.5694444 0.264878 8.5722222 0.266551 8.5750000 0.265993 8.5777778 0.264878 8.5805556 0.263206 8.5833333 0.264321 8.5861111 0.265993 8.5888889 0.264878 8.5916667 0.265993 8.5944444 0.264878 8.5972222 0.263763 8.6000000 0.265436 8.6027778 0.267108 8.6055556 0.266551 8.6083333 0.265993 8.6111111 0.265436 8.6138889 0.263763 8.6166667 0.264878 8.6194444 0.264878 8.6222222 0.265993 8.6250000 0.265993 8.6277778 0.263763 8.6305556 0.264321 8.6333333 0.264321 8.6361111 0.265436 8.6388889 0.265993 8.6416667 0.264321 8.6444444 0.264321 8.6472222 0.264321 8.6500000 0.265436 8.6527778 0.265993 8.6555556 0.267666 8.6583333 0.268223 8.6611111 0.267666 8.6638889 0.265993 8.6666667 0.265436 8.6694444 0.266551 8.6722222 0.266551 8.6750000 0.265436 8.6777778 0.264878 8.6805556 0.264878 8.6833333 0.265436 8.6861111 0.267108 8.6888889 0.266551 8.6916667 0.267108 8.6944444 0.264878 8.6972222 0.265436 8.7000000 0.267666 8.7027778 0.270453 8.7055556 0.273240 8.7083333 0.271568 8.7111111 0.273240 8.7138889 0.272125 8.7166667 0.274913 8.7194444 0.274913 8.7222222 0.276028 8.7250000 0.276585 8.7277778 0.277700 8.7305556 0.278258 8.7333333 0.278258 8.7361111 0.279930 8.7388889 0.280488 8.7416667 0.279930 8.7444444 0.277143 8.7472222 0.276028 8.7500000 0.276585 8.7527778 0.276585 8.7555556 0.276585 8.7583333 0.276585 8.7611111 0.276028 8.7638889 0.274913 8.7666667 0.276585 8.7694444 0.279930 8.7722222 0.281045 8.7750000 0.279373 8.7777778 0.273240 8.7805556 0.271568 8.7833333 0.271568 8.7861111 0.269895 8.7888889 0.269338 8.7916667 0.268223 8.7944444 0.266551 8.7972222 0.266551 8.8000000 0.264878 8.8027778 0.265993 8.8055556 0.266551 8.8083333 0.267108 8.8111111 0.266551 8.8138889 0.264878 8.8166667 0.265436 8.8194444 0.265436 8.8222222 0.266551 8.8250000 0.266551 8.8277778 0.265993 8.8305556 0.264878 8.8333333 0.263763 8.8361111 0.264321 8.8388889 0.264321 8.8416667 0.264321 8.8444444 0.263763 8.8472222 0.262091 8.8500000 0.262648 8.8527778 0.263763 8.8555556 0.264878 8.8583333 0.264321 8.8611111 0.261533 8.8638889 0.258746 8.8666667 0.255958 8.8694444 0.252613 8.8722222 0.250383 8.8750000 0.248153 8.8777778 0.243136 8.8805556 0.240906 8.8833333 0.245923 8.8861111 0.258746 8.8888889 0.273798 8.8916667 0.289965 8.8944444 0.311707 8.8972222 0.341812 8.9000000 0.373031 8.9027778 0.391429 8.9055556 0.396446 8.9083333 0.381951 8.9111111 0.350174 8.9138889 0.306690 8.9166667 0.269895 8.9194444 0.252056 8.9222222 0.248711 8.9250000 0.253728 8.9277778 0.257073 8.9305556 0.259303 8.9333333 0.260418 8.9361111 0.260418 8.9388889 0.261533 8.9416667 0.260976 8.9444444 0.260976 8.9472222 0.259861 8.9500000 0.261533 8.9527778 0.262091 8.9555556 0.262091 8.9583333 0.262648 8.9611111 0.262648 8.9638889 0.260418 8.9666667 0.261533 8.9694444 0.262091 8.9722222 0.262648 8.9750000 0.262091 8.9777778 0.260976 8.9805556 0.259303 8.9833333 0.259861 8.9861111 0.259303 8.9888889 0.260976 8.9916667 0.261533 8.9944444 0.259303 8.9972222 0.259861 9.0000000 0.260976 9.0027778 0.260418 9.0055556 0.260976 9.0083333 0.260418 9.0111111 0.260976 9.0138889 0.259861 9.0166667 0.262648 9.0194444 0.262648 9.0222222 0.263206 9.0250000 0.262091 9.0277778 0.260976 9.0305556 0.260976 9.0333333 0.261533 9.0361111 0.262648 9.0388889 0.261533 9.0416667 0.260418 9.0444444 0.260418 9.0472222 0.258746 9.0500000 0.260418 9.0527778 0.260976 9.0555556 0.261533 9.0583333 0.259303 9.0611111 0.259303 9.0638889 0.258746 9.0666667 0.259303 9.0694444 0.260418 9.0722222 0.261533 9.0750000 0.261533 9.0777778 0.261533 9.0805556 0.262091 9.0833333 0.262648 9.0861111 0.263763 9.0888889 0.262648 9.0916667 0.261533 9.0944444 0.260976 9.0972222 0.260976 9.1000000 0.260418 9.1027778 0.260418 9.1055556 0.259861 9.1083333 0.260976 9.1111111 0.259861 9.1138889 0.259303 9.1166667 0.261533 9.1194444 0.261533 9.1222222 0.263206 9.1250000 0.260976 9.1277778 0.261533 9.1305556 0.260418 9.1333333 0.260976 9.1361111 0.262091 9.1388889 0.262648 9.1416667 0.260976 9.1444444 0.259303 9.1472222 0.257631 9.1500000 0.257073 9.1527778 0.260418 9.1555556 0.259861 9.1583333 0.260418 9.1611111 0.258746 9.1638889 0.257073 9.1666667 0.258746 9.1694444 0.258746 9.1722222 0.260976 9.1750000 0.261533 9.1777778 0.259303 9.1805556 0.259303 9.1833333 0.259861 9.1861111 0.261533 9.1888889 0.263206 9.1916667 0.263206 9.1944444 0.263206 9.1972222 0.262648 9.2000000 0.264878 9.2027778 0.265436 9.2055556 0.268223 9.2083333 0.267666 9.2111111 0.267666 9.2138889 0.266551 9.2166667 0.268780 9.2194444 0.269338 9.2222222 0.271010 9.2250000 0.271010 9.2277778 0.269895 9.2305556 0.270453 9.2333333 0.271568 9.2361111 0.272125 9.2388889 0.272683 9.2416667 0.272683 9.2444444 0.271568 9.2472222 0.270453 9.2500000 0.271010 9.2527778 0.271568 9.2555556 0.273240 9.2583333 0.272125 9.2611111 0.271568 9.2638889 0.269338 9.2666667 0.269338 9.2694444 0.270453 9.2722222 0.269895 9.2750000 0.269338 9.2777778 0.268780 9.2805556 0.267666 9.2833333 0.268780 9.2861111 0.269338 9.2888889 0.269895 9.2916667 0.269895 9.2944444 0.268780 9.2972222 0.267666 9.3000000 0.268780 9.3027778 0.268223 9.3055556 0.269338 9.3083333 0.267666 9.3111111 0.268780 9.3138889 0.267666 9.3166667 0.268780 9.3194444 0.268223 9.3222222 0.269338 9.3250000 0.268780 9.3277778 0.267108 9.3305556 0.265993 9.3333333 0.266551 9.3361111 0.266551 9.3388889 0.265993 9.3416667 0.264878 9.3444444 0.264321 9.3472222 0.265436 9.3500000 0.265436 9.3527778 0.266551 9.3555556 0.265436 9.3583333 0.265436 9.3611111 0.264321 9.3638889 0.263763 9.3666667 0.265436 9.3694444 0.264321 9.3722222 0.265436 9.3750000 0.265436 9.3777778 0.264878 9.3805556 0.263763 9.3833333 0.264878 9.3861111 0.265993 9.3888889 0.264878 9.3916667 0.265436 9.3944444 0.264321 9.3972222 0.263763 9.4000000 0.263763 9.4027778 0.264321 9.4055556 0.265993 9.4083333 0.265993 9.4111111 0.266551 9.4138889 0.264878 9.4166667 0.266551 9.4194444 0.265436 9.4222222 0.264878 9.4250000 0.265993 9.4277778 0.265436 9.4305556 0.264321 9.4333333 0.265436 9.4361111 0.266551 9.4388889 0.267108 9.4416667 0.266551 9.4444444 0.264878 9.4472222 0.263763 9.4500000 0.263763 9.4527778 0.265993 9.4555556 0.265436 9.4583333 0.267666 9.4611111 0.264878 9.4638889 0.263763 9.4666667 0.264321 9.4694444 0.267666 9.4722222 0.268780 9.4750000 0.271010 9.4777778 0.271010 9.4805556 0.270453 9.4833333 0.271010 9.4861111 0.272125 9.4888889 0.274355 9.4916667 0.275470 9.4944444 0.275470 9.4972222 0.273798 9.5000000 0.275470 9.5027778 0.277143 9.5055556 0.277143 9.5083333 0.276585 9.5111111 0.276585 9.5138889 0.274355 9.5166667 0.273240 9.5194444 0.274355 9.5222222 0.274913 9.5250000 0.273798 9.5277778 0.272125 9.5305556 0.270453 9.5333333 0.271010 9.5361111 0.272683 9.5388889 0.276028 9.5416667 0.276028 9.5444444 0.272683 9.5472222 0.268780 9.5500000 0.269338 9.5527778 0.269338 9.5555556 0.267108 9.5583333 0.265436 9.5611111 0.263763 9.5638889 0.262091 9.5666667 0.262091 9.5694444 0.263763 9.5722222 0.264878 9.5750000 0.265436 9.5777778 0.264878 9.5805556 0.263206 9.5833333 0.263206 9.5861111 0.263763 9.5888889 0.263763 9.5916667 0.262648 9.5944444 0.261533 9.5972222 0.260976 9.6000000 0.260976 9.6027778 0.260976 9.6055556 0.261533 9.6083333 0.260976 9.6111111 0.259303 9.6138889 0.259861 9.6166667 0.260976 9.6194444 0.260418 9.6222222 0.261533 9.6250000 0.261533 9.6277778 0.260976 9.6305556 0.259303 9.6333333 0.257631 9.6361111 0.254843 9.6388889 0.252613 9.6416667 0.250941 9.6444444 0.247596 9.6472222 0.242021 9.6500000 0.239791 9.6527778 0.245366 9.6555556 0.256516 9.6583333 0.271010 9.6611111 0.287178 9.6638889 0.309477 9.6666667 0.340139 9.6694444 0.368571 9.6722222 0.386969 9.6750000 0.393101 9.6777778 0.380279 9.6805556 0.345714 9.6833333 0.303345 9.6861111 0.271568 9.6888889 0.253728 9.6916667 0.247596 9.6944444 0.248153 9.6972222 0.251498 9.7000000 0.255958 9.7027778 0.258188 9.7055556 0.258746 9.7083333 0.258188 9.7111111 0.258188 9.7138889 0.256516 9.7166667 0.255401 9.7194444 0.257631 9.7222222 0.257073 9.7250000 0.257073 9.7277778 0.257073 9.7305556 0.257073 9.7333333 0.258746 9.7361111 0.258746 9.7388889 0.259861 9.7416667 0.257631 9.7444444 0.257631 9.7472222 0.257073 9.7500000 0.258746 9.7527778 0.258746 9.7555556 0.259303 9.7583333 0.258188 9.7611111 0.257073 9.7638889 0.256516 9.7666667 0.256516 9.7694444 0.257073 9.7722222 0.257073 9.7750000 0.255958 9.7777778 0.256516 9.7805556 0.255401 9.7833333 0.254843 9.7861111 0.256516 9.7888889 0.255958 9.7916667 0.256516 9.7944444 0.254843 9.7972222 0.254843 9.8000000 0.255401 9.8027778 0.258188 9.8055556 0.257631 9.8083333 0.256516 9.8111111 0.255958 9.8138889 0.255958 9.8166667 0.256516 9.8194444 0.256516 9.8222222 0.257073 9.8250000 0.254843 9.8277778 0.255401 9.8305556 0.254843 9.8333333 0.255958 9.8361111 0.256516 9.8388889 0.255958 9.8416667 0.256516 9.8444444 0.255401 9.8472222 0.254843 9.8500000 0.254843 9.8527778 0.256516 9.8555556 0.256516 9.8583333 0.255958 9.8611111 0.255401 9.8638889 0.255401 9.8666667 0.255958 9.8694444 0.257631 9.8722222 0.258746 9.8750000 0.257631 9.8777778 0.257073 9.8805556 0.255958 9.8833333 0.256516 9.8861111 0.257631 9.8888889 0.257631 9.8916667 0.257073 9.8944444 0.256516 9.8972222 0.256516 9.9000000 0.255401 9.9027778 0.255401 9.9055556 0.254843 9.9083333 0.253728 9.9111111 0.253171 9.9138889 0.252056 9.9166667 0.252056 9.9194444 0.252613 9.9222222 0.253171 9.9250000 0.252056 9.9277778 0.250383 9.9305556 0.248153 9.9333333 0.249268 9.9361111 0.250941 9.9388889 0.252613 9.9416667 0.251498 9.9444444 0.249826 9.9472222 0.250941 9.9500000 0.250383 9.9527778 0.252613 9.9555556 0.252613 9.9583333 0.252613 9.9611111 0.252056 9.9638889 0.252056 9.9666667 0.253728 9.9694444 0.253728 9.9722222 0.257073 9.9750000 0.258188 9.9777778 0.257073 9.9805556 0.258746 9.9833333 0.259861 9.9861111 0.260976 9.9888889 0.262648 9.9916667 0.262648 9.9944444 0.263763 9.9972222 0.264321 10.0000000 0.263763 10.0027778 0.265993 10.0055556 0.267108 10.0083333 0.266551 10.0111111 0.267666 10.0138889 0.267108 10.0166667 0.267666 10.0194444 0.267666 10.0222222 0.268223 10.0250000 0.268223 10.0277778 0.268223 10.0305556 0.267666 10.0333333 0.267666 10.0361111 0.268223 10.0388889 0.269895 10.0416667 0.269895 10.0444444 0.268780 10.0472222 0.267666 10.0500000 0.268223 10.0527778 0.269338 10.0555556 0.269338 10.0583333 0.269338 10.0611111 0.267666 10.0638889 0.265993 10.0666667 0.265993 10.0694444 0.266551 10.0722222 0.268780 10.0750000 0.267666 10.0777778 0.265993 10.0805556 0.264878 10.0833333 0.265436 10.0861111 0.267108 10.0888889 0.267666 10.0916667 0.266551 10.0944444 0.265993 10.0972222 0.265993 10.1000000 0.265436 10.1027778 0.266551 10.1055556 0.267108 10.1083333 0.265993 10.1111111 0.265993 10.1138889 0.264878 10.1166667 0.265436 10.1194444 0.265436 10.1222222 0.267108 10.1250000 0.266551 10.1277778 0.265993 10.1305556 0.265436 10.1333333 0.265993 10.1361111 0.265993 10.1388889 0.267108 10.1416667 0.266551 10.1444444 0.264878 10.1472222 0.263763 10.1500000 0.264321 10.1527778 0.264321 10.1555556 0.264878 10.1583333 0.265436 10.1611111 0.263763 10.1638889 0.262648 10.1666667 0.263206 10.1694444 0.264321 10.1722222 0.264321 10.1750000 0.265436 10.1777778 0.263206 10.1805556 0.263206 10.1833333 0.263763 10.1861111 0.265436 10.1888889 0.265993 10.1916667 0.265993 10.1944444 0.264321 10.1972222 0.263206 10.2000000 0.263763 10.2027778 0.266551 10.2055556 0.265436 10.2083333 0.265993 10.2111111 0.264878 10.2138889 0.263206 10.2166667 0.263206 10.2194444 0.263206 10.2222222 0.264321 10.2250000 0.263763 10.2277778 0.263763 10.2305556 0.262648 10.2333333 0.263763 10.2361111 0.264878 10.2388889 0.265436 10.2416667 0.264878 10.2444444 0.264321 10.2472222 0.263763 10.2500000 0.264878 10.2527778 0.265436 10.2555556 0.265993 10.2583333 0.265436 10.2611111 0.264878 10.2638889 0.264321 10.2666667 0.264878 10.2694444 0.265436 10.2722222 0.267108 10.2750000 0.267108 10.2777778 0.265993 10.2805556 0.265436 10.2833333 0.266551 10.2861111 0.268780 10.2888889 0.269338 10.2916667 0.270453 10.2944444 0.269338 10.2972222 0.269338 10.3000000 0.271010 10.3027778 0.273240 10.3055556 0.273240 10.3083333 0.273798 10.3111111 0.273240 10.3138889 0.273798 10.3166667 0.274913 10.3194444 0.276028 10.3222222 0.277143 10.3250000 0.277143 10.3277778 0.276585 10.3305556 0.276028 10.3333333 0.275470 10.3361111 0.275470 10.3388889 0.276028 10.3416667 0.275470 10.3444444 0.275470 10.3472222 0.274355 10.3500000 0.274355 10.3527778 0.273240 10.3555556 0.276585 10.3583333 0.275470 10.3611111 0.274355 10.3638889 0.271568 10.3666667 0.273798 10.3694444 0.276585 10.3722222 0.278815 10.3750000 0.277143 10.3777778 0.274913 10.3805556 0.271010 10.3833333 0.269338 10.3861111 0.268780 10.3888889 0.268223 10.3916667 0.265993 10.3944444 0.264321 10.3972222 0.264878 10.4000000 0.262648 10.4027778 0.263763 10.4055556 0.262648 10.4083333 0.264321 10.4111111 0.263763 10.4138889 0.264321 10.4166667 0.263763 10.4194444 0.263763 10.4222222 0.265436 10.4250000 0.265993 10.4277778 0.264321 10.4305556 0.264321 10.4333333 0.263206 10.4361111 0.264321 10.4388889 0.264321 10.4416667 0.263206 10.4444444 0.263206 10.4472222 0.259861 10.4500000 0.260418 10.4527778 0.263206 10.4555556 0.263763 10.4583333 0.263763 10.4611111 0.262648 10.4638889 0.260976 10.4666667 0.262091 10.4694444 0.261533 10.4722222 0.260418 10.4750000 0.257073 10.4777778 0.252613 10.4805556 0.249826 10.4833333 0.247596 10.4861111 0.245923 10.4888889 0.243136 10.4916667 0.242578 10.4944444 0.249268 10.4972222 0.263763 10.5000000 0.281603 10.5027778 0.301115 10.5055556 0.327875 10.5083333 0.357422 10.5111111 0.382509 10.5138889 0.398676 10.5166667 0.404251 10.5194444 0.393101 10.5222222 0.358537 10.5250000 0.313380 10.5277778 0.274355 10.5305556 0.252613 10.5333333 0.249268 10.5361111 0.253171 10.5388889 0.257631 10.5416667 0.259861 10.5444444 0.259303 10.5472222 0.258188 10.5500000 0.257631 10.5527778 0.260418 10.5555556 0.260418 10.5583333 0.258746 10.5611111 0.258188 10.5638889 0.257073 10.5666667 0.257631 10.5694444 0.259303 10.5722222 0.258746 10.5750000 0.258746 10.5777778 0.259303 10.5805556 0.257631 10.5833333 0.258746 10.5861111 0.258188 10.5888889 0.259303 10.5916667 0.258746 10.5944444 0.257631 10.5972222 0.258188 10.6000000 0.259303 10.6027778 0.259861 10.6055556 0.259861 10.6083333 0.260418 10.6111111 0.260418 10.6138889 0.258746 10.6166667 0.259303 10.6194444 0.260418 10.6222222 0.260976 10.6250000 0.260976 10.6277778 0.260976 10.6305556 0.259861 10.6333333 0.259861 10.6361111 0.259861 10.6388889 0.260976 10.6416667 0.260418 10.6444444 0.259303 10.6472222 0.258746 10.6500000 0.259861 10.6527778 0.260976 10.6555556 0.260418 10.6583333 0.260976 10.6611111 0.260418 10.6638889 0.258746 10.6666667 0.258188 10.6694444 0.259861 10.6722222 0.260976 10.6750000 0.261533)
Vecg1 ecg_l1 0 PWL(0.0000000 0.300000 0.3138889 0.272125 0.3166667 0.273798 0.3194444 0.275470 0.3222222 0.278258 0.3250000 0.278815 0.3277778 0.278815 0.3305556 0.278815 0.3333333 0.279930 0.3361111 0.282160 0.3388889 0.283833 0.3416667 0.283275 0.3444444 0.282160 0.3472222 0.282160 0.3500000 0.282718 0.3527778 0.283833 0.3555556 0.284390 0.3583333 0.282160 0.3611111 0.283275 0.3638889 0.280488 0.3666667 0.281045 0.3694444 0.282160 0.3722222 0.282160 0.3750000 0.283275 0.3777778 0.282718 0.3805556 0.282160 0.3833333 0.281045 0.3861111 0.282718 0.3888889 0.282718 0.3916667 0.283275 0.3944444 0.281603 0.3972222 0.280488 0.4000000 0.281603 0.4027778 0.281603 0.4055556 0.282160 0.4083333 0.282160 0.4111111 0.279930 0.4138889 0.280488 0.4166667 0.279373 0.4194444 0.281603 0.4222222 0.283275 0.4250000 0.283275 0.4277778 0.281045 0.4305556 0.279373 0.4333333 0.278258 0.4361111 0.278815 0.4388889 0.278815 0.4416667 0.279373 0.4444444 0.278815 0.4472222 0.276585 0.4500000 0.278258 0.4527778 0.278815 0.4555556 0.279930 0.4583333 0.277143 0.4611111 0.276028 0.4638889 0.274913 0.4666667 0.276585 0.4694444 0.277143 0.4722222 0.278258 0.4750000 0.277700 0.4777778 0.278258 0.4805556 0.276585 0.4833333 0.276028 0.4861111 0.277143 0.4888889 0.279373 0.4916667 0.278258 0.4944444 0.278258 0.4972222 0.275470 0.5000000 0.275470 0.5027778 0.276585 0.5055556 0.276028 0.5083333 0.275470 0.5111111 0.275470 0.5138889 0.274913 0.5166667 0.276585 0.5194444 0.277700 0.5222222 0.276585 0.5250000 0.274913 0.5277778 0.274355 0.5305556 0.274913 0.5333333 0.275470 0.5361111 0.274355 0.5388889 0.276585 0.5416667 0.276028 0.5444444 0.276028 0.5472222 0.274355 0.5500000 0.276028 0.5527778 0.275470 0.5555556 0.277143 0.5583333 0.277143 0.5611111 0.276585 0.5638889 0.276028 0.5666667 0.274913 0.5694444 0.276028 0.5722222 0.276028 0.5750000 0.276028 0.5777778 0.274913 0.5805556 0.274913 0.5833333 0.274913 0.5861111 0.277143 0.5888889 0.278258 0.5916667 0.276585 0.5944444 0.276585 0.5972222 0.276028 0.6000000 0.273798 0.6027778 0.274355 0.6055556 0.275470 0.6083333 0.275470 0.6111111 0.274355 0.6138889 0.274913 0.6166667 0.274355 0.6194444 0.276028 0.6222222 0.278258 0.6250000 0.278258 0.6277778 0.278815 0.6305556 0.277700 0.6333333 0.278258 0.6361111 0.279930 0.6388889 0.281045 0.6416667 0.279930 0.6444444 0.280488 0.6472222 0.278258 0.6500000 0.278258 0.6527778 0.281045 0.6555556 0.280488 0.6583333 0.280488 0.6611111 0.279930 0.6638889 0.279373 0.6666667 0.279373 0.6694444 0.280488 0.6722222 0.280488 0.6750000 0.280488 0.6777778 0.278815 0.6805556 0.277143 0.6833333 0.277700 0.6861111 0.277143 0.6888889 0.277143 0.6916667 0.276028 0.6944444 0.276028 0.6972222 0.274913 0.7000000 0.276028 0.7027778 0.276585 0.7055556 0.277700 0.7083333 0.276028 0.7111111 0.274913 0.7138889 0.272683 0.7166667 0.272683 0.7194444 0.272125 0.7222222 0.274913 0.7250000 0.274355 0.7277778 0.273798 0.7305556 0.273240 0.7333333 0.273798 0.7361111 0.273798 0.7388889 0.275470 0.7416667 0.274355 0.7444444 0.273240 0.7472222 0.273240 0.7500000 0.272683 0.7527778 0.274913 0.7555556 0.274913 0.7583333 0.273798 0.7611111 0.272125 0.7638889 0.269895 0.7666667 0.268780 0.7694444 0.267666 0.7722222 0.266551 0.7750000 0.263206 0.7777778 0.259861 0.7805556 0.260418 0.7833333 0.265993 0.7861111 0.277143 0.7888889 0.291080 0.7916667 0.301672 0.7944444 0.307247 0.7972222 0.312822 0.8000000 0.321185 0.8027778 0.333449 0.8055556 0.345714 0.8083333 0.355192 0.8111111 0.354077 0.8138889 0.340139 0.8166667 0.311707 0.8194444 0.281603 0.8222222 0.260976 0.8250000 0.249826 0.8277778 0.247596 0.8305556 0.249826 0.8333333 0.255958 0.8361111 0.261533 0.8388889 0.265436 0.8416667 0.267108 0.8444444 0.268223 0.8472222 0.267108 0.8500000 0.267108 0.8527778 0.268780 0.8555556 0.268223 0.8583333 0.268223 0.8611111 0.268223 0.8638889 0.267666 0.8666667 0.269338 0.8694444 0.269338 0.8722222 0.269338 0.8750000 0.269895 0.8777778 0.268223 0.8805556 0.267108 0.8833333 0.267666 0.8861111 0.269338 0.8888889 0.270453 0.8916667 0.270453 0.8944444 0.269338 0.8972222 0.267108 0.9000000 0.267666 0.9027778 0.268223 0.9055556 0.269895 0.9083333 0.270453 0.9111111 0.269338 0.9138889 0.268780 0.9166667 0.268780 0.9194444 0.269895 0.9222222 0.270453 0.9250000 0.269895 0.9277778 0.269895 0.9305556 0.268780 0.9333333 0.269895 0.9361111 0.270453 0.9388889 0.270453 0.9416667 0.270453 0.9444444 0.269895 0.9472222 0.268223 0.9500000 0.268223 0.9527778 0.270453 0.9555556 0.270453 0.9583333 0.271568 0.9611111 0.269338 0.9638889 0.269338 0.9666667 0.268780 0.9694444 0.269895 0.9722222 0.270453 0.9750000 0.269338 0.9777778 0.268223 0.9805556 0.268780 0.9833333 0.268780 0.9861111 0.269338 0.9888889 0.269338 0.9916667 0.269338 0.9944444 0.268223 0.9972222 0.267108 1.0000000 0.267108 1.0027778 0.269338 1.0055556 0.269338 1.0083333 0.268223 1.0111111 0.267666 1.0138889 0.264878 1.0166667 0.264878 1.0194444 0.265993 1.0222222 0.267666 1.0250000 0.265436 1.0277778 0.264321 1.0305556 0.264321 1.0333333 0.262648 1.0361111 0.263206 1.0388889 0.263763 1.0416667 0.261533 1.0444444 0.260976 1.0472222 0.259303 1.0500000 0.258746 1.0527778 0.260418 1.0555556 0.259861 1.0583333 0.258746 1.0611111 0.256516 1.0638889 0.255958 1.0666667 0.255401 1.0694444 0.256516 1.0722222 0.257073 1.0750000 0.256516 1.0777778 0.255401 1.0805556 0.254286 1.0833333 0.253171 1.0861111 0.254843 1.0888889 0.254286 1.0916667 0.254286 1.0944444 0.255401 1.0972222 0.254843 1.1000000 0.256516 1.1027778 0.257073 1.1055556 0.259303 1.1083333 0.260418 1.1111111 0.261533 1.1138889 0.260418 1.1166667 0.263206 1.1194444 0.267108 1.1222222 0.269338 1.1250000 0.269895 1.1277778 0.271010 1.1305556 0.270453 1.1333333 0.270453 1.1361111 0.272683 1.1388889 0.274913 1.1416667 0.276585 1.1444444 0.276028 1.1472222 0.276028 1.1500000 0.277143 1.1527778 0.278258 1.1555556 0.279373 1.1583333 0.279373 1.1611111 0.278258 1.1638889 0.278258 1.1666667 0.278258 1.1694444 0.279373 1.1722222 0.281045 1.1750000 0.279373 1.1777778 0.278258 1.1805556 0.278258 1.1833333 0.278258 1.1861111 0.279373 1.1888889 0.280488 1.1916667 0.280488 1.1944444 0.279373 1.1972222 0.278258 1.2000000 0.278258 1.2027778 0.278258 1.2055556 0.279930 1.2083333 0.279373 1.2111111 0.278815 1.2138889 0.278258 1.2166667 0.278258 1.2194444 0.278815 1.2222222 0.279373 1.2250000 0.279373 1.2277778 0.278815 1.2305556 0.277700 1.2333333 0.276028 1.2361111 0.278258 1.2388889 0.279373 1.2416667 0.279373 1.2444444 0.279373 1.2472222 0.277700 1.2500000 0.277143 1.2527778 0.278815 1.2555556 0.278815 1.2583333 0.277700 1.2611111 0.277700 1.2638889 0.278258 1.2666667 0.275470 1.2694444 0.277143 1.2722222 0.278815 1.2750000 0.277700 1.2777778 0.275470 1.2805556 0.274355 1.2833333 0.276585 1.2861111 0.277143 1.2888889 0.277700 1.2916667 0.278258 1.2944444 0.275470 1.2972222 0.274913 1.3000000 0.274913 1.3027778 0.276028 1.3055556 0.277143 1.3083333 0.277143 1.3111111 0.276028 1.3138889 0.274913 1.3166667 0.275470 1.3194444 0.274913 1.3222222 0.278258 1.3250000 0.276028 1.3277778 0.275470 1.3305556 0.276028 1.3333333 0.274913 1.3361111 0.276028 1.3388889 0.276585 1.3416667 0.276585 1.3444444 0.274913 1.3472222 0.274355 1.3500000 0.275470 1.3527778 0.276585 1.3555556 0.277143 1.3583333 0.277700 1.3611111 0.277143 1.3638889 0.275470 1.3666667 0.274355 1.3694444 0.276028 1.3722222 0.277143 1.3750000 0.277700 1.3777778 0.274355 1.3805556 0.275470 1.3833333 0.276028 1.3861111 0.277143 1.3888889 0.277700 1.3916667 0.277143 1.3944444 0.275470 1.3972222 0.275470 1.4000000 0.274913 1.4027778 0.277143 1.4055556 0.277700 1.4083333 0.277700 1.4111111 0.276585 1.4138889 0.274355 1.4166667 0.276028 1.4194444 0.277700 1.4222222 0.277700 1.4250000 0.277143 1.4277778 0.276585 1.4305556 0.276028 1.4333333 0.275470 1.4361111 0.277143 1.4388889 0.277700 1.4416667 0.278258 1.4444444 0.277143 1.4472222 0.277143 1.4500000 0.277143 1.4527778 0.279930 1.4555556 0.281045 1.4583333 0.278815 1.4611111 0.278815 1.4638889 0.277700 1.4666667 0.279373 1.4694444 0.281603 1.4722222 0.283833 1.4750000 0.283833 1.4777778 0.281045 1.4805556 0.280488 1.4833333 0.281045 1.4861111 0.281603 1.4888889 0.283275 1.4916667 0.282160 1.4944444 0.280488 1.4972222 0.278815 1.5000000 0.278815 1.5027778 0.279373 1.5055556 0.279373 1.5083333 0.280488 1.5111111 0.278258 1.5138889 0.276028 1.5166667 0.277143 1.5194444 0.277700 1.5222222 0.278258 1.5250000 0.277143 1.5277778 0.276585 1.5305556 0.275470 1.5333333 0.276028 1.5361111 0.276585 1.5388889 0.277143 1.5416667 0.277700 1.5444444 0.276585 1.5472222 0.275470 1.5500000 0.275470 1.5527778 0.275470 1.5555556 0.277700 1.5583333 0.277143 1.5611111 0.276028 1.5638889 0.274913 1.5666667 0.275470 1.5694444 0.276028 1.5722222 0.277143 1.5750000 0.275470 1.5777778 0.274913 1.5805556 0.273240 1.5833333 0.271010 1.5861111 0.268780 1.5888889 0.266551 1.5916667 0.261533 1.5944444 0.258188 1.5972222 0.261533 1.6000000 0.271010 1.6027778 0.286063 1.6055556 0.302787 1.6083333 0.316167 1.6111111 0.328990 1.6138889 0.341812 1.6166667 0.356307 1.6194444 0.370801 1.6222222 0.378606 1.6250000 0.368014 1.6277778 0.335679 1.6305556 0.294983 1.6333333 0.272125 1.6361111 0.269895 1.6388889 0.273240 1.6416667 0.273240 1.6444444 0.272125 1.6472222 0.271568 1.6500000 0.272683 1.6527778 0.272683 1.6555556 0.272683 1.6583333 0.271568 1.6611111 0.271010 1.6638889 0.271010 1.6666667 0.269895 1.6694444 0.272683 1.6722222 0.272683 1.6750000 0.272125 1.6777778 0.270453 1.6805556 0.269895 1.6833333 0.269895 1.6861111 0.270453 1.6888889 0.271010 1.6916667 0.271010 1.6944444 0.269895 1.6972222 0.268780 1.7000000 0.268780 1.7027778 0.269895 1.7055556 0.271568 1.7083333 0.270453 1.7111111 0.268780 1.7138889 0.267666 1.7166667 0.269338 1.7194444 0.270453 1.7222222 0.271568 1.7250000 0.271010 1.7277778 0.271010 1.7305556 0.268780 1.7333333 0.268780 1.7361111 0.270453 1.7388889 0.271010 1.7416667 0.271568 1.7444444 0.271010 1.7472222 0.269338 1.7500000 0.269895 1.7527778 0.269338 1.7555556 0.270453 1.7583333 0.270453 1.7611111 0.269895 1.7638889 0.268780 1.7666667 0.268223 1.7694444 0.268780 1.7722222 0.271568 1.7750000 0.269895 1.7777778 0.268780 1.7805556 0.267666 1.7833333 0.267666 1.7861111 0.269895 1.7888889 0.269895 1.7916667 0.268223 1.7944444 0.266551 1.7972222 0.266551 1.8000000 0.266551 1.8027778 0.267108 1.8055556 0.269338 1.8083333 0.267108 1.8111111 0.266551 1.8138889 0.265436 1.8166667 0.265436 1.8194444 0.264878 1.8222222 0.265436 1.8250000 0.265436 1.8277778 0.262648 1.8305556 0.261533 1.8333333 0.260418 1.8361111 0.260976 1.8388889 0.261533 1.8416667 0.259861 1.8444444 0.258746 1.8472222 0.258188 1.8500000 0.257073 1.8527778 0.258746 1.8555556 0.258746 1.8583333 0.257073 1.8611111 0.255401 1.8638889 0.253728 1.8666667 0.254843 1.8694444 0.254286 1.8722222 0.256516 1.8750000 0.254843 1.8777778 0.254286 1.8805556 0.252613 1.8833333 0.253171 1.8861111 0.254286 1.8888889 0.254843 1.8916667 0.255401 1.8944444 0.255401 1.8972222 0.254843 1.9000000 0.257073 1.9027778 0.259303 1.9055556 0.261533 1.9083333 0.262648 1.9111111 0.263763 1.9138889 0.265436 1.9166667 0.267108 1.9194444 0.269338 1.9222222 0.271568 1.9250000 0.272125 1.9277778 0.273240 1.9305556 0.272683 1.9333333 0.274355 1.9361111 0.277143 1.9388889 0.277700 1.9416667 0.277700 1.9444444 0.277143 1.9472222 0.276585 1.9500000 0.275470 1.9527778 0.278258 1.9555556 0.278815 1.9583333 0.277700 1.9611111 0.277700 1.9638889 0.276585 1.9666667 0.277700 1.9694444 0.278815 1.9722222 0.280488 1.9750000 0.277700 1.9777778 0.277143 1.9805556 0.276585 1.9833333 0.277700 1.9861111 0.277700 1.9888889 0.279930 1.9916667 0.278815 1.9944444 0.278815 1.9972222 0.277143 2.0000000 0.277143 2.0027778 0.278258 2.0055556 0.279373 2.0083333 0.278815 2.0111111 0.278815 2.0138889 0.276585 2.0166667 0.276585 2.0194444 0.277143 2.0222222 0.277143 2.0250000 0.277700 2.0277778 0.276028 2.0305556 0.274913 2.0333333 0.276585 2.0361111 0.276585 2.0388889 0.276585 2.0416667 0.276028 2.0444444 0.274913 2.0472222 0.274913 2.0500000 0.274355 2.0527778 0.276585 2.0555556 0.276585 2.0583333 0.274355 2.0611111 0.272125 2.0638889 0.272125 2.0666667 0.272683 2.0694444 0.274355 2.0722222 0.276028 2.0750000 0.274355 2.0777778 0.273240 2.0805556 0.272683 2.0833333 0.272683 2.0861111 0.273240 2.0888889 0.276028 2.0916667 0.274913 2.0944444 0.273240 2.0972222 0.273240 2.1000000 0.272683 2.1027778 0.273240 2.1055556 0.274355 2.1083333 0.273798 2.1111111 0.273240 2.1138889 0.274355 2.1166667 0.272125 2.1194444 0.274913 2.1222222 0.276028 2.1250000 0.274355 2.1277778 0.273240 2.1305556 0.272125 2.1333333 0.270453 2.1361111 0.274355 2.1388889 0.275470 2.1416667 0.273798 2.1444444 0.274913 2.1472222 0.273798 2.1500000 0.273798 2.1527778 0.274913 2.1555556 0.274913 2.1583333 0.276028 2.1611111 0.274913 2.1638889 0.273798 2.1666667 0.274355 2.1694444 0.274913 2.1722222 0.274913 2.1750000 0.274913 2.1777778 0.274913 2.1805556 0.274355 2.1833333 0.274355 2.1861111 0.276028 2.1888889 0.276585 2.1916667 0.274913 2.1944444 0.273240 2.1972222 0.273798 2.2000000 0.273240 2.2027778 0.274913 2.2055556 0.276028 2.2083333 0.275470 2.2111111 0.275470 2.2138889 0.274355 2.2166667 0.274355 2.2194444 0.277143 2.2222222 0.277700 2.2250000 0.277143 2.2277778 0.278258 2.2305556 0.276585 2.2333333 0.277143 2.2361111 0.278815 2.2388889 0.279373 2.2416667 0.277700 2.2444444 0.278258 2.2472222 0.277700 2.2500000 0.278815 2.2527778 0.281045 2.2555556 0.284390 2.2583333 0.281603 2.2611111 0.281603 2.2638889 0.279373 2.2666667 0.279930 2.2694444 0.281045 2.2722222 0.283275 2.2750000 0.281603 2.2777778 0.279930 2.2805556 0.277700 2.2833333 0.276585 2.2861111 0.276585 2.2888889 0.279373 2.2916667 0.278815 2.2944444 0.277700 2.2972222 0.276028 2.3000000 0.275470 2.3027778 0.276585 2.3055556 0.278258 2.3083333 0.277143 2.3111111 0.275470 2.3138889 0.274913 2.3166667 0.274355 2.3194444 0.275470 2.3222222 0.276585 2.3250000 0.276585 2.3277778 0.274355 2.3305556 0.273798 2.3333333 0.274355 2.3361111 0.274913 2.3388889 0.276028 2.3416667 0.275470 2.3444444 0.275470 2.3472222 0.274355 2.3500000 0.273240 2.3527778 0.275470 2.3555556 0.274913 2.3583333 0.273798 2.3611111 0.272125 2.3638889 0.268780 2.3666667 0.265993 2.3694444 0.263763 2.3722222 0.261533 2.3750000 0.258188 2.3777778 0.253728 2.3805556 0.252613 2.3833333 0.257073 2.3861111 0.267108 2.3888889 0.279930 2.3916667 0.292753 2.3944444 0.303902 2.3972222 0.314495 2.4000000 0.326760 2.4027778 0.341254 2.4055556 0.355192 2.4083333 0.368014 2.4111111 0.373031 2.4138889 0.360767 2.4166667 0.325645 2.4194444 0.288293 2.4222222 0.268780 2.4250000 0.268223 2.4277778 0.271568 2.4305556 0.271568 2.4333333 0.271010 2.4361111 0.274355 2.4388889 0.275470 2.4416667 0.272683 2.4444444 0.271568 2.4472222 0.271010 2.4500000 0.272125 2.4527778 0.273798 2.4555556 0.272683 2.4583333 0.272683 2.4611111 0.271010 2.4638889 0.270453 2.4666667 0.270453 2.4694444 0.271010 2.4722222 0.273240 2.4750000 0.272683 2.4777778 0.271010 2.4805556 0.269895 2.4833333 0.269895 2.4861111 0.271568 2.4888889 0.271568 2.4916667 0.272125 2.4944444 0.270453 2.4972222 0.269895 2.5000000 0.269895 2.5027778 0.270453 2.5055556 0.272125 2.5083333 0.272683 2.5111111 0.270453 2.5138889 0.269895 2.5166667 0.271010 2.5194444 0.271568 2.5222222 0.272683 2.5250000 0.272125 2.5277778 0.271010 2.5305556 0.269895 2.5333333 0.271010 2.5361111 0.271568 2.5388889 0.272125 2.5416667 0.271568 2.5444444 0.271568 2.5472222 0.269338 2.5500000 0.269895 2.5527778 0.270453 2.5555556 0.271010 2.5583333 0.271010 2.5611111 0.269338 2.5638889 0.269895 2.5666667 0.271010 2.5694444 0.272683 2.5722222 0.271568 2.5750000 0.270453 2.5777778 0.270453 2.5805556 0.269895 2.5833333 0.270453 2.5861111 0.271010 2.5888889 0.269895 2.5916667 0.270453 2.5944444 0.269895 2.5972222 0.268780 2.6000000 0.268223 2.6027778 0.268780 2.6055556 0.268223 2.6083333 0.267666 2.6111111 0.265436 2.6138889 0.265993 2.6166667 0.266551 2.6194444 0.266551 2.6222222 0.265436 2.6250000 0.263763 2.6277778 0.262091 2.6305556 0.262091 2.6333333 0.263763 2.6361111 0.264321 2.6388889 0.260418 2.6416667 0.259861 2.6444444 0.257631 2.6472222 0.257073 2.6500000 0.258188 2.6527778 0.259303 2.6555556 0.258188 2.6583333 0.257073 2.6611111 0.256516 2.6638889 0.255958 2.6666667 0.257073 2.6694444 0.258188 2.6722222 0.258188 2.6750000 0.258188 2.6777778 0.257631 2.6805556 0.259303 2.6833333 0.261533 2.6861111 0.262648 2.6888889 0.264878 2.6916667 0.265436 2.6944444 0.265993 2.6972222 0.267666 2.7000000 0.269895 2.7027778 0.271568 2.7055556 0.272125 2.7083333 0.272683 2.7111111 0.273798 2.7138889 0.273798 2.7166667 0.274913 2.7194444 0.275470 2.7222222 0.278258 2.7250000 0.276028 2.7277778 0.274355 2.7305556 0.276028 2.7333333 0.277143 2.7361111 0.278258 2.7388889 0.277700 2.7416667 0.278258 2.7444444 0.278258 2.7472222 0.277143 2.7500000 0.278258 2.7527778 0.279930 2.7555556 0.278815 2.7583333 0.277143 2.7611111 0.276585 2.7638889 0.277143 2.7666667 0.279930 2.7694444 0.279373 2.7722222 0.278815 2.7750000 0.277143 2.7777778 0.276028 2.7805556 0.276028 2.7833333 0.276028 2.7861111 0.278815 2.7888889 0.276585 2.7916667 0.277700 2.7944444 0.276028 2.7972222 0.275470 2.8000000 0.274913 2.8027778 0.276028 2.8055556 0.276028 2.8083333 0.274355 2.8111111 0.274913 2.8138889 0.274913 2.8166667 0.276585 2.8194444 0.276585 2.8222222 0.276028 2.8250000 0.274355 2.8277778 0.273798 2.8305556 0.274355 2.8333333 0.275470 2.8361111 0.276028 2.8388889 0.274355 2.8416667 0.273798 2.8444444 0.272125 2.8472222 0.272683 2.8500000 0.273240 2.8527778 0.275470 2.8555556 0.274355 2.8583333 0.274355 2.8611111 0.273798 2.8638889 0.273240 2.8666667 0.273798 2.8694444 0.275470 2.8722222 0.274355 2.8750000 0.273240 2.8777778 0.271568 2.8805556 0.272683 2.8833333 0.273798 2.8861111 0.275470 2.8888889 0.274355 2.8916667 0.273240 2.8944444 0.272125 2.8972222 0.271568 2.9000000 0.273240 2.9027778 0.274913 2.9055556 0.274355 2.9083333 0.273798 2.9111111 0.273240 2.9138889 0.272683 2.9166667 0.273798 2.9194444 0.274355 2.9222222 0.273798 2.9250000 0.273240 2.9277778 0.272683 2.9305556 0.273798 2.9333333 0.273798 2.9361111 0.274355 2.9388889 0.273240 2.9416667 0.273798 2.9444444 0.272683 2.9472222 0.272125 2.9500000 0.274355 2.9527778 0.276585 2.9555556 0.274355 2.9583333 0.273798 2.9611111 0.272683 2.9638889 0.272125 2.9666667 0.272683 2.9694444 0.274355 2.9722222 0.274355 2.9750000 0.273798 2.9777778 0.272125 2.9805556 0.272125 2.9833333 0.273240 2.9861111 0.274913 2.9888889 0.274355 2.9916667 0.273798 2.9944444 0.273240 2.9972222 0.272683 3.0000000 0.273240 3.0027778 0.274913 3.0055556 0.274913 3.0083333 0.274355 3.0111111 0.274355 3.0138889 0.274913 3.0166667 0.277143 3.0194444 0.276585 3.0222222 0.275470 3.0250000 0.277143 3.0277778 0.275470 3.0305556 0.275470 3.0333333 0.276585 3.0361111 0.278815 3.0388889 0.279930 3.0416667 0.279930 3.0444444 0.279373 3.0472222 0.278815 3.0500000 0.278815 3.0527778 0.279373 3.0555556 0.277143 3.0583333 0.277700 3.0611111 0.275470 3.0638889 0.275470 3.0666667 0.275470 3.0694444 0.276585 3.0722222 0.274913 3.0750000 0.275470 3.0777778 0.273240 3.0805556 0.272683 3.0833333 0.273798 3.0861111 0.274355 3.0888889 0.272683 3.0916667 0.272683 3.0944444 0.272125 3.0972222 0.271568 3.1000000 0.274355 3.1027778 0.274913 3.1055556 0.274355 3.1083333 0.272683 3.1111111 0.271568 3.1138889 0.270453 3.1166667 0.271568 3.1194444 0.272683 3.1222222 0.271010 3.1250000 0.272125 3.1277778 0.271010 3.1305556 0.269895 3.1333333 0.273240 3.1361111 0.272683 3.1388889 0.272125 3.1416667 0.272125 3.1444444 0.272125 3.1472222 0.270453 3.1500000 0.271568 3.1527778 0.272683 3.1555556 0.271568 3.1583333 0.270453 3.1611111 0.268780 3.1638889 0.265993 3.1666667 0.264321 3.1694444 0.260976 3.1722222 0.257631 3.1750000 0.256516 3.1777778 0.261533 3.1805556 0.273240 3.1833333 0.287735 3.1861111 0.297770 3.1888889 0.304460 3.1916667 0.312265 3.1944444 0.324530 3.1972222 0.339024 3.2000000 0.349059 3.2027778 0.344042 3.2055556 0.317282 3.2083333 0.281045 3.2111111 0.257631 3.2138889 0.254286 3.2166667 0.260418 3.2194444 0.264321 3.2222222 0.265993 3.2250000 0.266551 3.2277778 0.267108 3.2305556 0.267108 3.2333333 0.268223 3.2361111 0.266551 3.2388889 0.265436 3.2416667 0.265993 3.2444444 0.265993 3.2472222 0.267108 3.2500000 0.269895 3.2527778 0.269895 3.2555556 0.268223 3.2583333 0.265993 3.2611111 0.265436 3.2638889 0.266551 3.2666667 0.267666 3.2694444 0.269338 3.2722222 0.268223 3.2750000 0.268223 3.2777778 0.265993 3.2805556 0.267666 3.2833333 0.267666 3.2861111 0.268223 3.2888889 0.268223 3.2916667 0.267666 3.2944444 0.266551 3.2972222 0.267108 3.3000000 0.268223 3.3027778 0.269338 3.3055556 0.267666 3.3083333 0.267108 3.3111111 0.269338 3.3138889 0.268223 3.3166667 0.268223 3.3194444 0.271010 3.3222222 0.269895 3.3250000 0.270453 3.3277778 0.268223 3.3305556 0.267666 3.3333333 0.267108 3.3361111 0.268780 3.3388889 0.267666 3.3416667 0.267108 3.3444444 0.266551 3.3472222 0.265436 3.3500000 0.265993 3.3527778 0.267108 3.3555556 0.266551 3.3583333 0.268780 3.3611111 0.267666 3.3638889 0.265993 3.3666667 0.267666 3.3694444 0.268223 3.3722222 0.265993 3.3750000 0.265436 3.3777778 0.264878 3.3805556 0.265993 3.3833333 0.267108 3.3861111 0.267666 3.3888889 0.267108 3.3916667 0.266551 3.3944444 0.265993 3.3972222 0.263763 3.4000000 0.265436 3.4027778 0.266551 3.4055556 0.265436 3.4083333 0.262648 3.4111111 0.262091 3.4138889 0.260976 3.4166667 0.260418 3.4194444 0.262091 3.4222222 0.260976 3.4250000 0.259303 3.4277778 0.257631 3.4305556 0.255401 3.4333333 0.257073 3.4361111 0.257631 3.4388889 0.256516 3.4416667 0.255401 3.4444444 0.254843 3.4472222 0.254843 3.4500000 0.254843 3.4527778 0.253728 3.4555556 0.253728 3.4583333 0.253171 3.4611111 0.253728 3.4638889 0.252613 3.4666667 0.254286 3.4694444 0.255958 3.4722222 0.257073 3.4750000 0.254843 3.4777778 0.255958 3.4805556 0.255958 3.4833333 0.258188 3.4861111 0.258746 3.4888889 0.258188 3.4916667 0.258188 3.4944444 0.258746 3.4972222 0.259861 3.5000000 0.261533 3.5027778 0.264321 3.5055556 0.265993 3.5083333 0.265993 3.5111111 0.266551 3.5138889 0.268223 3.5166667 0.269338 3.5194444 0.271010 3.5222222 0.272683 3.5250000 0.272683 3.5277778 0.272125 3.5305556 0.271568 3.5333333 0.272683 3.5361111 0.274355 3.5388889 0.273798 3.5416667 0.272683 3.5444444 0.271568 3.5472222 0.271568 3.5500000 0.274913 3.5527778 0.274355 3.5555556 0.273798 3.5583333 0.273240 3.5611111 0.272125 3.5638889 0.272683 3.5666667 0.274913 3.5694444 0.276028 3.5722222 0.275470 3.5750000 0.273240 3.5777778 0.272125 3.5805556 0.271568 3.5833333 0.272683 3.5861111 0.273240 3.5888889 0.273798 3.5916667 0.272683 3.5944444 0.271568 3.5972222 0.272125 3.6000000 0.273798 3.6027778 0.274355 3.6055556 0.272125 3.6083333 0.271010 3.6111111 0.269338 3.6138889 0.268780 3.6166667 0.269338 3.6194444 0.271010 3.6222222 0.269895 3.6250000 0.271568 3.6277778 0.270453 3.6305556 0.271568 3.6333333 0.270453 3.6361111 0.271010 3.6388889 0.270453 3.6416667 0.270453 3.6444444 0.269338 3.6472222 0.269895 3.6500000 0.270453 3.6527778 0.271568 3.6555556 0.271568 3.6583333 0.270453 3.6611111 0.269338 3.6638889 0.267666 3.6666667 0.269338 3.6694444 0.271010 3.6722222 0.269895 3.6750000 0.270453 3.6777778 0.269895 3.6805556 0.270453 3.6833333 0.270453 3.6861111 0.272125 3.6888889 0.270453 3.6916667 0.270453 3.6944444 0.269895 3.6972222 0.269895 3.7000000 0.270453 3.7027778 0.271568 3.7055556 0.271010 3.7083333 0.271568 3.7111111 0.269895 3.7138889 0.269895 3.7166667 0.268223 3.7194444 0.270453 3.7222222 0.271010 3.7250000 0.270453 3.7277778 0.269895 3.7305556 0.270453 3.7333333 0.271010 3.7361111 0.272125 3.7388889 0.270453 3.7416667 0.270453 3.7444444 0.269895 3.7472222 0.270453 3.7500000 0.271568 3.7527778 0.272683 3.7555556 0.271568 3.7583333 0.269338 3.7611111 0.269338 3.7638889 0.269338 3.7666667 0.271568 3.7694444 0.271568 3.7722222 0.271010 3.7750000 0.270453 3.7777778 0.268223 3.7805556 0.268780 3.7833333 0.270453 3.7861111 0.271010 3.7888889 0.271568 3.7916667 0.272125 3.7944444 0.271568 3.7972222 0.272125 3.8000000 0.273240 3.8027778 0.274355 3.8055556 0.273798 3.8083333 0.274913 3.8111111 0.273798 3.8138889 0.273240 3.8166667 0.274913 3.8194444 0.276028 3.8222222 0.273798 3.8250000 0.274355 3.8277778 0.274913 3.8305556 0.276028 3.8333333 0.277143 3.8361111 0.277700 3.8388889 0.276585 3.8416667 0.274913 3.8444444 0.274355 3.8472222 0.274913 3.8500000 0.276028 3.8527778 0.276585 3.8555556 0.273798 3.8583333 0.273240 3.8611111 0.271568 3.8638889 0.272683 3.8666667 0.273798 3.8694444 0.274355 3.8722222 0.273798 3.8750000 0.272683 3.8777778 0.269895 3.8805556 0.271010 3.8833333 0.272125 3.8861111 0.273240 3.8888889 0.273240 3.8916667 0.271568 3.8944444 0.271010 3.8972222 0.270453 3.9000000 0.271568 3.9027778 0.272683 3.9055556 0.272683 3.9083333 0.271010 3.9111111 0.271568 3.9138889 0.271010 3.9166667 0.271568 3.9194444 0.273240 3.9222222 0.273240 3.9250000 0.271010 3.9277778 0.271010 3.9305556 0.272125 3.9333333 0.273240 3.9361111 0.273798 3.9388889 0.273240 3.9416667 0.271568 3.9444444 0.269895 3.9472222 0.268223 3.9500000 0.267666 3.9527778 0.265436 3.9555556 0.263206 3.9583333 0.259303 3.9611111 0.258746 3.9638889 0.260976 3.9666667 0.271010 3.9694444 0.284948 3.9722222 0.297770 3.9750000 0.303902 3.9777778 0.310592 3.9805556 0.320627 3.9833333 0.335122 3.9861111 0.350174 3.9888889 0.357422 3.9916667 0.350174 3.9944444 0.319512 3.9972222 0.279930 4.0000000 0.257073 4.0027778 0.255958 4.0055556 0.261533 4.0083333 0.265436 4.0111111 0.267666 4.0138889 0.269338 4.0166667 0.270453 4.0194444 0.273798 4.0222222 0.272125 4.0250000 0.270453 4.0277778 0.271568 4.0305556 0.272683 4.0333333 0.273240 4.0361111 0.273240 4.0388889 0.272125 4.0416667 0.271010 4.0444444 0.270453 4.0472222 0.269338 4.0500000 0.271568 4.0527778 0.273240 4.0555556 0.272683 4.0583333 0.271010 4.0611111 0.271010 4.0638889 0.270453 4.0666667 0.272125 4.0694444 0.272125 4.0722222 0.272683 4.0750000 0.272125 4.0777778 0.270453 4.0805556 0.271568 4.0833333 0.272125 4.0861111 0.272683 4.0888889 0.272683 4.0916667 0.271568 4.0944444 0.271010 4.0972222 0.272125 4.1000000 0.273240 4.1027778 0.276028 4.1055556 0.274355 4.1083333 0.272125 4.1111111 0.272125 4.1138889 0.271568 4.1166667 0.273240 4.1194444 0.275470 4.1222222 0.273798 4.1250000 0.273798 4.1277778 0.273240 4.1305556 0.271568 4.1333333 0.272683 4.1361111 0.274913 4.1388889 0.274355 4.1416667 0.273798 4.1444444 0.273240 4.1472222 0.273240 4.1500000 0.273240 4.1527778 0.274355 4.1555556 0.272683 4.1583333 0.271568 4.1611111 0.272125 4.1638889 0.272125 4.1666667 0.273798 4.1694444 0.273240 4.1722222 0.273798 4.1750000 0.271568 4.1777778 0.271568 4.1805556 0.271568 4.1833333 0.272125 4.1861111 0.273798 4.1888889 0.271010 4.1916667 0.271568 4.1944444 0.269895 4.1972222 0.268223 4.2000000 0.268223 4.2027778 0.268780 4.2055556 0.268223 4.2083333 0.268223 4.2111111 0.265993 4.2138889 0.267108 4.2166667 0.268223 4.2194444 0.267666 4.2222222 0.265993 4.2250000 0.264321 4.2277778 0.262648 4.2305556 0.262091 4.2333333 0.264878 4.2361111 0.264878 4.2388889 0.263206 4.2416667 0.261533 4.2444444 0.260976 4.2472222 0.260418 4.2500000 0.259303 4.2527778 0.260418 4.2555556 0.259303 4.2583333 0.258746 4.2611111 0.258188 4.2638889 0.258188 4.2666667 0.258746 4.2694444 0.260418 4.2722222 0.259861 4.2750000 0.262091 4.2777778 0.262091 4.2805556 0.263206 4.2833333 0.264878 4.2861111 0.267666 4.2888889 0.269338 4.2916667 0.270453 4.2944444 0.271010 4.2972222 0.272683 4.3000000 0.274913 4.3027778 0.277143 4.3055556 0.277700 4.3083333 0.278815 4.3111111 0.277700 4.3138889 0.279373 4.3166667 0.280488 4.3194444 0.282160 4.3222222 0.282718 4.3250000 0.281603 4.3277778 0.282160 4.3305556 0.281045 4.3333333 0.283275 4.3361111 0.283833 4.3388889 0.283275 4.3416667 0.283833 4.3444444 0.283833 4.3472222 0.282718 4.3500000 0.283275 4.3527778 0.284948 4.3555556 0.283833 4.3583333 0.283833 4.3611111 0.283275 4.3638889 0.283833 4.3666667 0.284390 4.3694444 0.285505 4.3722222 0.284948 4.3750000 0.284390 4.3777778 0.283833 4.3805556 0.281603 4.3833333 0.282718 4.3861111 0.283833 4.3888889 0.283275 4.3916667 0.282160 4.3944444 0.282160 4.3972222 0.282160 4.4000000 0.283833 4.4027778 0.284390 4.4055556 0.283275 4.4083333 0.281603 4.4111111 0.281045 4.4138889 0.281603 4.4166667 0.281603 4.4194444 0.283275 4.4222222 0.283275 4.4250000 0.281603 4.4277778 0.281045 4.4305556 0.279930 4.4333333 0.281603 4.4361111 0.282718 4.4388889 0.282160 4.4416667 0.281603 4.4444444 0.280488 4.4472222 0.279930 4.4500000 0.281603 4.4527778 0.283275 4.4555556 0.281045 4.4583333 0.281045 4.4611111 0.279373 4.4638889 0.280488 4.4666667 0.280488 4.4694444 0.282160 4.4722222 0.281603 4.4750000 0.281045 4.4777778 0.279930 4.4805556 0.280488 4.4833333 0.281045 4.4861111 0.282160 4.4888889 0.282160 4.4916667 0.281045 4.4944444 0.278815 4.4972222 0.281603 4.5000000 0.282160 4.5027778 0.282718 4.5055556 0.282160 4.5083333 0.282718 4.5111111 0.281603 4.5138889 0.279373 4.5166667 0.280488 4.5194444 0.283275 4.5222222 0.282718 4.5250000 0.281603 4.5277778 0.281045 4.5305556 0.281045 4.5333333 0.281603 4.5361111 0.283275 4.5388889 0.282160 4.5416667 0.281045 4.5444444 0.280488 4.5472222 0.279930 4.5500000 0.282718 4.5527778 0.283275 4.5555556 0.283833 4.5583333 0.282160 4.5611111 0.281603 4.5638889 0.282160 4.5666667 0.282160 4.5694444 0.283833 4.5722222 0.283275 4.5750000 0.283275 4.5777778 0.282160 4.5805556 0.282160 4.5833333 0.283275 4.5861111 0.283275 4.5888889 0.283275 4.5916667 0.282718 4.5944444 0.282160 4.5972222 0.282160 4.6000000 0.283275 4.6027778 0.285505 4.6055556 0.283275 4.6083333 0.282718 4.6111111 0.282160 4.6138889 0.283275 4.6166667 0.286063 4.6194444 0.286620 4.6222222 0.287178 4.6250000 0.286063 4.6277778 0.284948 4.6305556 0.284390 4.6333333 0.285505 4.6361111 0.288293 4.6388889 0.288293 4.6416667 0.288850 4.6444444 0.288293 4.6472222 0.289965 4.6500000 0.291080 4.6527778 0.291638 4.6555556 0.289965 4.6583333 0.289965 4.6611111 0.288850 4.6638889 0.288850 4.6666667 0.289408 4.6694444 0.289965 4.6722222 0.287735 4.6750000 0.286063 4.6777778 0.285505 4.6805556 0.286620 4.6833333 0.286620 4.6861111 0.287735 4.6888889 0.287735 4.6916667 0.286620 4.6944444 0.285505 4.6972222 0.284390 4.7000000 0.283833 4.7027778 0.286063 4.7055556 0.285505 4.7083333 0.283275 4.7111111 0.283833 4.7138889 0.284390 4.7166667 0.284390 4.7194444 0.286620 4.7222222 0.284948 4.7250000 0.283833 4.7277778 0.282160 4.7305556 0.283275 4.7333333 0.284948 4.7361111 0.286063 4.7388889 0.284948 4.7416667 0.283833 4.7444444 0.283275 4.7472222 0.282160 4.7500000 0.283833 4.7527778 0.284948 4.7555556 0.284948 4.7583333 0.286063 4.7611111 0.282160 4.7638889 0.280488 4.7666667 0.278258 4.7694444 0.276585 4.7722222 0.274355 4.7750000 0.269895 4.7777778 0.267666 4.7805556 0.268780 4.7833333 0.278258 4.7861111 0.294425 4.7888889 0.309477 4.7916667 0.321742 4.7944444 0.334007 4.7972222 0.346829 4.8000000 0.362997 4.8027778 0.378606 4.8055556 0.389199 4.8083333 0.388641 4.8111111 0.366341 4.8138889 0.326202 4.8166667 0.291638 4.8194444 0.278815 4.8222222 0.279373 4.8250000 0.282718 4.8277778 0.281045 4.8305556 0.281603 4.8333333 0.282718 4.8361111 0.283833 4.8388889 0.282718 4.8416667 0.278815 4.8444444 0.277700 4.8472222 0.278258 4.8500000 0.280488 4.8527778 0.280488 4.8555556 0.279930 4.8583333 0.279373 4.8611111 0.277700 4.8638889 0.278258 4.8666667 0.277700 4.8694444 0.278258 4.8722222 0.278815 4.8750000 0.278258 4.8777778 0.277700 4.8805556 0.277700 4.8833333 0.278815 4.8861111 0.279930 4.8888889 0.279373 4.8916667 0.278258 4.8944444 0.276585 4.8972222 0.276585 4.9000000 0.280488 4.9027778 0.278815 4.9055556 0.279373 4.9083333 0.279373 4.9111111 0.278258 4.9138889 0.277700 4.9166667 0.278258 4.9194444 0.279930 4.9222222 0.278815 4.9250000 0.278258 4.9277778 0.278815 4.9305556 0.278258 4.9333333 0.280488 4.9361111 0.280488 4.9388889 0.279373 4.9416667 0.278815 4.9444444 0.278258 4.9472222 0.278815 4.9500000 0.279373 4.9527778 0.281045 4.9555556 0.281045 4.9583333 0.278815 4.9611111 0.277700 4.9638889 0.277700 4.9666667 0.279930 4.9694444 0.280488 4.9722222 0.278258 4.9750000 0.280488 4.9777778 0.278815 4.9805556 0.278815 4.9833333 0.278815 4.9861111 0.279930 4.9888889 0.278815 4.9916667 0.276585 4.9944444 0.277143 4.9972222 0.277700 5.0000000 0.276585 5.0027778 0.278258 5.0055556 0.277143 5.0083333 0.276028 5.0111111 0.274355 5.0138889 0.276028 5.0166667 0.274913 5.0194444 0.277143 5.0222222 0.276028 5.0250000 0.273798 5.0277778 0.272683 5.0305556 0.272683 5.0333333 0.273240 5.0361111 0.272683 5.0388889 0.273798 5.0416667 0.271010 5.0444444 0.270453 5.0472222 0.269895 5.0500000 0.270453 5.0527778 0.270453 5.0555556 0.269895 5.0583333 0.268223 5.0611111 0.266551 5.0638889 0.267108 5.0666667 0.267108 5.0694444 0.267108 5.0722222 0.265993 5.0750000 0.265436 5.0777778 0.264321 5.0805556 0.263763 5.0833333 0.264321 5.0861111 0.265436 5.0888889 0.264321 5.0916667 0.264321 5.0944444 0.263763 5.0972222 0.265436 5.1000000 0.268780 5.1027778 0.268780 5.1055556 0.268780 5.1083333 0.270453 5.1111111 0.270453 5.1138889 0.272125 5.1166667 0.274913 5.1194444 0.277700 5.1222222 0.278258 5.1250000 0.278815 5.1277778 0.279930 5.1305556 0.281045 5.1333333 0.283275 5.1361111 0.284948 5.1388889 0.287178 5.1416667 0.286063 5.1444444 0.285505 5.1472222 0.286620 5.1500000 0.288293 5.1527778 0.288850 5.1555556 0.288850 5.1583333 0.288850 5.1611111 0.287178 5.1638889 0.286620 5.1666667 0.288293 5.1694444 0.288850 5.1722222 0.288293 5.1750000 0.287178 5.1777778 0.286620 5.1805556 0.287735 5.1833333 0.288293 5.1861111 0.289408 5.1888889 0.288850 5.1916667 0.287735 5.1944444 0.286620 5.1972222 0.286620 5.2000000 0.287178 5.2027778 0.288293 5.2055556 0.288293 5.2083333 0.289408 5.2111111 0.288293 5.2138889 0.286620 5.2166667 0.287178 5.2194444 0.288293 5.2222222 0.287735 5.2250000 0.286063 5.2277778 0.287178 5.2305556 0.285505 5.2333333 0.287178 5.2361111 0.289408 5.2388889 0.288850 5.2416667 0.287735 5.2444444 0.287178 5.2472222 0.287178 5.2500000 0.288293 5.2527778 0.288850 5.2555556 0.287735 5.2583333 0.288850 5.2611111 0.288850 5.2638889 0.288293 5.2666667 0.289408 5.2694444 0.289408 5.2722222 0.289408 5.2750000 0.287735 5.2777778 0.287178 5.2805556 0.287735 5.2833333 0.288293 5.2861111 0.288293 5.2888889 0.287178 5.2916667 0.287178 5.2944444 0.284948 5.2972222 0.286063 5.3000000 0.284948 5.3027778 0.286063 5.3055556 0.285505 5.3083333 0.283275 5.3111111 0.282718 5.3138889 0.281603 5.3166667 0.281603 5.3194444 0.281045 5.3222222 0.280488 5.3250000 0.281045 5.3277778 0.280488 5.3305556 0.281045 5.3333333 0.281603 5.3361111 0.282160 5.3388889 0.282160 5.3416667 0.281045 5.3444444 0.279930 5.3472222 0.281045 5.3500000 0.282718 5.3527778 0.282718 5.3555556 0.282160 5.3583333 0.282160 5.3611111 0.280488 5.3638889 0.281045 5.3666667 0.282718 5.3694444 0.283275 5.3722222 0.282160 5.3750000 0.282718 5.3777778 0.281603 5.3805556 0.282160 5.3833333 0.283275 5.3861111 0.283275 5.3888889 0.283833 5.3916667 0.282718 5.3944444 0.281603 5.3972222 0.282718 5.4000000 0.284948 5.4027778 0.285505 5.4055556 0.283833 5.4083333 0.282718 5.4111111 0.282160 5.4138889 0.282160 5.4166667 0.280488 5.4194444 0.278815 5.4222222 0.273798 5.4250000 0.272125 5.4277778 0.267108 5.4305556 0.264878 5.4333333 0.267108 5.4361111 0.278815 5.4388889 0.290523 5.4416667 0.306690 5.4444444 0.319512 5.4472222 0.329547 5.4500000 0.342369 5.4527778 0.354077 5.4555556 0.365784 5.4583333 0.374146 5.4611111 0.374146 5.4638889 0.355749 5.4666667 0.322857 5.4694444 0.291638 5.4722222 0.276028 5.4750000 0.277143 5.4777778 0.279930 5.4805556 0.280488 5.4833333 0.281603 5.4861111 0.283833 5.4888889 0.283833 5.4916667 0.282160 5.4944444 0.281603 5.4972222 0.281045 5.5000000 0.282718 5.5027778 0.282718 5.5055556 0.282718 5.5083333 0.281045 5.5111111 0.280488 5.5138889 0.281045 5.5166667 0.282718 5.5194444 0.282718 5.5222222 0.282160 5.5250000 0.281603 5.5277778 0.279930 5.5305556 0.280488 5.5333333 0.281045 5.5361111 0.282160 5.5388889 0.282160 5.5416667 0.281045 5.5444444 0.279930 5.5472222 0.279930 5.5500000 0.281045 5.5527778 0.281603 5.5555556 0.281603 5.5583333 0.280488 5.5611111 0.279930 5.5638889 0.279373 5.5666667 0.281045 5.5694444 0.282160 5.5722222 0.281603 5.5750000 0.280488 5.5777778 0.280488 5.5805556 0.280488 5.5833333 0.279930 5.5861111 0.281045 5.5888889 0.282160 5.5916667 0.281045 5.5944444 0.279930 5.5972222 0.279373 5.6000000 0.281045 5.6027778 0.282160 5.6055556 0.279930 5.6083333 0.279930 5.6111111 0.279373 5.6138889 0.279373 5.6166667 0.281603 5.6194444 0.282718 5.6222222 0.281045 5.6250000 0.280488 5.6277778 0.278258 5.6305556 0.278258 5.6333333 0.278815 5.6361111 0.280488 5.6388889 0.280488 5.6416667 0.278815 5.6444444 0.278815 5.6472222 0.278815 5.6500000 0.279373 5.6527778 0.278815 5.6555556 0.276028 5.6583333 0.275470 5.6611111 0.276028 5.6638889 0.274913 5.6666667 0.276028 5.6694444 0.277700 5.6722222 0.274355 5.6750000 0.274913 5.6777778 0.272683 5.6805556 0.273240 5.6833333 0.272683 5.6861111 0.275470 5.6888889 0.272683 5.6916667 0.271010 5.6944444 0.268780 5.6972222 0.268780 5.7000000 0.268223 5.7027778 0.269895 5.7055556 0.268223 5.7083333 0.267108 5.7111111 0.265993 5.7138889 0.265993 5.7166667 0.264878 5.7194444 0.265993 5.7222222 0.265436 5.7250000 0.263206 5.7277778 0.263763 5.7305556 0.263206 5.7333333 0.264878 5.7361111 0.265436 5.7388889 0.264878 5.7416667 0.265436 5.7444444 0.264321 5.7472222 0.265993 5.7500000 0.267666 5.7527778 0.269338 5.7555556 0.269895 5.7583333 0.270453 5.7611111 0.270453 5.7638889 0.271568 5.7666667 0.272683 5.7694444 0.274913 5.7722222 0.276028 5.7750000 0.276028 5.7777778 0.276028 5.7805556 0.276585 5.7833333 0.277143 5.7861111 0.279373 5.7888889 0.279930 5.7916667 0.278815 5.7944444 0.278815 5.7972222 0.281045 5.8000000 0.282718 5.8027778 0.284390 5.8055556 0.283833 5.8083333 0.281603 5.8111111 0.282160 5.8138889 0.282160 5.8166667 0.283275 5.8194444 0.283833 5.8222222 0.284390 5.8250000 0.283275 5.8277778 0.283275 5.8305556 0.281045 5.8333333 0.282718 5.8361111 0.283833 5.8388889 0.285505 5.8416667 0.284390 5.8444444 0.283275 5.8472222 0.283833 5.8500000 0.283275 5.8527778 0.284948 5.8555556 0.284390 5.8583333 0.282718 5.8611111 0.283275 5.8638889 0.281603 5.8666667 0.283833 5.8694444 0.283833 5.8722222 0.282718 5.8750000 0.282160 5.8777778 0.282160 5.8805556 0.280488 5.8833333 0.282718 5.8861111 0.282718 5.8888889 0.283275 5.8916667 0.282160 5.8944444 0.281603 5.8972222 0.281603 5.9000000 0.280488 5.9027778 0.281603 5.9055556 0.281603 5.9083333 0.281603 5.9111111 0.281045 5.9138889 0.281603 5.9166667 0.282160 5.9194444 0.282160 5.9222222 0.281603 5.9250000 0.281045 5.9277778 0.278258 5.9305556 0.279373 5.9333333 0.279930 5.9361111 0.281045 5.9388889 0.281603 5.9416667 0.279373 5.9444444 0.279930 5.9472222 0.279373 5.9500000 0.281045 5.9527778 0.280488 5.9555556 0.280488 5.9583333 0.280488 5.9611111 0.279930 5.9638889 0.280488 5.9666667 0.282718 5.9694444 0.282160 5.9722222 0.281045 5.9750000 0.279930 5.9777778 0.277700 5.9805556 0.278258 5.9833333 0.281603 5.9861111 0.282160 5.9888889 0.282160 5.9916667 0.281603 5.9944444 0.279373 5.9972222 0.278815 6.0000000 0.279930 6.0027778 0.281045 6.0055556 0.281045 6.0083333 0.281045 6.0111111 0.279930 6.0138889 0.279930 6.0166667 0.281045 6.0194444 0.279930 6.0222222 0.279930 6.0250000 0.277700 6.0277778 0.278258 6.0305556 0.278258 6.0333333 0.282718 6.0361111 0.283833 6.0388889 0.281603 6.0416667 0.279930 6.0444444 0.279373 6.0472222 0.279930 6.0500000 0.281045 6.0527778 0.282160 6.0555556 0.282160 6.0583333 0.281045 6.0611111 0.279930 6.0638889 0.278815 6.0666667 0.279930 6.0694444 0.281603 6.0722222 0.281045 6.0750000 0.279373 6.0777778 0.278258 6.0805556 0.279373 6.0833333 0.279373 6.0861111 0.279373 6.0888889 0.279373 6.0916667 0.278815 6.0944444 0.279930 6.0972222 0.278815 6.1000000 0.278815 6.1027778 0.279930 6.1055556 0.278815 6.1083333 0.278815 6.1111111 0.278258 6.1138889 0.278258 6.1166667 0.279373 6.1194444 0.280488 6.1222222 0.278258 6.1250000 0.279930 6.1277778 0.279930 6.1305556 0.279373 6.1333333 0.278815 6.1361111 0.280488 6.1388889 0.278815 6.1416667 0.278815 6.1444444 0.276585 6.1472222 0.277143 6.1500000 0.279373 6.1527778 0.279930 6.1555556 0.279930 6.1583333 0.278815 6.1611111 0.276028 6.1638889 0.275470 6.1666667 0.277143 6.1694444 0.278258 6.1722222 0.278815 6.1750000 0.278258 6.1777778 0.276028 6.1805556 0.273798 6.1833333 0.276585 6.1861111 0.277700 6.1888889 0.276585 6.1916667 0.277143 6.1944444 0.276028 6.1972222 0.276028 6.2000000 0.277143 6.2027778 0.277700 6.2055556 0.278815 6.2083333 0.275470 6.2111111 0.274913 6.2138889 0.274913 6.2166667 0.277143 6.2194444 0.277700 6.2222222 0.277143 6.2250000 0.277143 6.2277778 0.276585 6.2305556 0.276585 6.2333333 0.278258 6.2361111 0.278258 6.2388889 0.278258 6.2416667 0.277700 6.2444444 0.274913 6.2472222 0.274913 6.2500000 0.277143 6.2527778 0.278815 6.2555556 0.278258 6.2583333 0.278815 6.2611111 0.277700 6.2638889 0.279373 6.2666667 0.279930 6.2694444 0.281603 6.2722222 0.281045 6.2750000 0.279930 6.2777778 0.280488 6.2805556 0.281045 6.2833333 0.281603 6.2861111 0.283275 6.2888889 0.282718 6.2916667 0.281603 6.2944444 0.281045 6.2972222 0.281603 6.3000000 0.281603 6.3027778 0.282718 6.3055556 0.281045 6.3083333 0.279930 6.3111111 0.281045 6.3138889 0.281603 6.3166667 0.282160 6.3194444 0.282160 6.3222222 0.279930 6.3250000 0.278815 6.3277778 0.277143 6.3305556 0.278815 6.3333333 0.278815 6.3361111 0.281045 6.3388889 0.279373 6.3416667 0.278815 6.3444444 0.278258 6.3472222 0.274913 6.3500000 0.276028 6.3527778 0.277700 6.3555556 0.277143 6.3583333 0.277143 6.3611111 0.277143 6.3638889 0.275470 6.3666667 0.276585 6.3694444 0.276585 6.3722222 0.276585 6.3750000 0.276028 6.3777778 0.274913 6.3805556 0.273798 6.3833333 0.274355 6.3861111 0.277143 6.3888889 0.276028 6.3916667 0.274913 6.3944444 0.274913 6.3972222 0.275470 6.4000000 0.275470 6.4027778 0.276028 6.4055556 0.274913 6.4083333 0.274913 6.4111111 0.271568 6.4138889 0.269338 6.4166667 0.267666 6.4194444 0.267666 6.4222222 0.264878 6.4250000 0.263206 6.4277778 0.265993 6.4305556 0.272683 6.4333333 0.287178 6.4361111 0.297213 6.4388889 0.303345 6.4416667 0.308920 6.4444444 0.317282 6.4472222 0.329547 6.4500000 0.342927 6.4527778 0.355749 6.4555556 0.360767 6.4583333 0.350174 6.4611111 0.323972 6.4638889 0.289965 6.4666667 0.263763 6.4694444 0.256516 6.4722222 0.257073 6.4750000 0.259303 6.4777778 0.262648 6.4805556 0.267108 6.4833333 0.268223 6.4861111 0.269895 6.4888889 0.270453 6.4916667 0.269895 6.4944444 0.269338 6.4972222 0.268223 6.5000000 0.270453 6.5027778 0.272125 6.5055556 0.271010 6.5083333 0.271010 6.5111111 0.270453 6.5138889 0.269895 6.5166667 0.270453 6.5194444 0.272683 6.5222222 0.271010 6.5250000 0.271568 6.5277778 0.268780 6.5305556 0.271010 6.5333333 0.272125 6.5361111 0.272125 6.5388889 0.271568 6.5416667 0.271568 6.5444444 0.271010 6.5472222 0.271010 6.5500000 0.271568 6.5527778 0.274913 6.5555556 0.273240 6.5583333 0.272683 6.5611111 0.270453 6.5638889 0.269338 6.5666667 0.272125 6.5694444 0.272683 6.5722222 0.274355 6.5750000 0.273240 6.5777778 0.271568 6.5805556 0.272125 6.5833333 0.272125 6.5861111 0.272683 6.5888889 0.273798 6.5916667 0.273240 6.5944444 0.272125 6.5972222 0.272125 6.6000000 0.272683 6.6027778 0.275470 6.6055556 0.272683 6.6083333 0.272683 6.6111111 0.273240 6.6138889 0.271568 6.6166667 0.272683 6.6194444 0.274913 6.6222222 0.273240 6.6250000 0.272125 6.6277778 0.271010 6.6305556 0.270453 6.6333333 0.271568 6.6361111 0.273240 6.6388889 0.272125 6.6416667 0.272125 6.6444444 0.270453 6.6472222 0.271010 6.6500000 0.271010 6.6527778 0.270453 6.6555556 0.269338 6.6583333 0.269895 6.6611111 0.269895 6.6638889 0.269895 6.6666667 0.269895 6.6694444 0.272683 6.6722222 0.270453 6.6750000 0.270453 6.6777778 0.269895 6.6805556 0.268223 6.6833333 0.271010 6.6861111 0.272683 6.6888889 0.271568 6.6916667 0.270453 6.6944444 0.268223 6.6972222 0.267108 6.7000000 0.266551 6.7027778 0.267108 6.7055556 0.268223 6.7083333 0.264321 6.7111111 0.263763 6.7138889 0.262648 6.7166667 0.262648 6.7194444 0.263206 6.7222222 0.260976 6.7250000 0.261533 6.7277778 0.259303 6.7305556 0.257631 6.7333333 0.258188 6.7361111 0.258188 6.7388889 0.257073 6.7416667 0.257073 6.7444444 0.255401 6.7472222 0.255401 6.7500000 0.255958 6.7527778 0.256516 6.7555556 0.256516 6.7583333 0.255401 6.7611111 0.254843 6.7638889 0.254286 6.7666667 0.257631 6.7694444 0.260418 6.7722222 0.260976 6.7750000 0.262091 6.7777778 0.261533 6.7805556 0.262648 6.7833333 0.265436 6.7861111 0.268223 6.7888889 0.268780 6.7916667 0.269895 6.7944444 0.271568 6.7972222 0.272683 6.8000000 0.273798 6.8027778 0.276585 6.8055556 0.276028 6.8083333 0.275470 6.8111111 0.275470 6.8138889 0.276028 6.8166667 0.278815 6.8194444 0.279930 6.8222222 0.279930 6.8250000 0.279373 6.8277778 0.278258 6.8305556 0.278258 6.8333333 0.278815 6.8361111 0.281045 6.8388889 0.281045 6.8416667 0.279373 6.8444444 0.279373 6.8472222 0.279373 6.8500000 0.279930 6.8527778 0.281045 6.8555556 0.278815 6.8583333 0.279930 6.8611111 0.278258 6.8638889 0.278815 6.8666667 0.281045 6.8694444 0.281045 6.8722222 0.280488 6.8750000 0.278815 6.8777778 0.278258 6.8805556 0.278815 6.8833333 0.279373 6.8861111 0.279373 6.8888889 0.279930 6.8916667 0.279373 6.8944444 0.278815 6.8972222 0.277143 6.9000000 0.278258 6.9027778 0.279373 6.9055556 0.279373 6.9083333 0.279373 6.9111111 0.277143 6.9138889 0.277143 6.9166667 0.279930 6.9194444 0.278258 6.9222222 0.278258 6.9250000 0.277143 6.9277778 0.276585 6.9305556 0.274913 6.9333333 0.276585 6.9361111 0.277700 6.9388889 0.277700 6.9416667 0.277143 6.9444444 0.276585 6.9472222 0.274913 6.9500000 0.276585 6.9527778 0.277700 6.9555556 0.277700 6.9583333 0.277143 6.9611111 0.276585 6.9638889 0.277700 6.9666667 0.278258 6.9694444 0.279373 6.9722222 0.277143 6.9750000 0.276585 6.9777778 0.275470 6.9805556 0.276028 6.9833333 0.277143 6.9861111 0.277700 6.9888889 0.276028 6.9916667 0.276585 6.9944444 0.274913 6.9972222 0.275470 7.0000000 0.276028 7.0027778 0.277700 7.0055556 0.276585 7.0083333 0.277143 7.0111111 0.276028 7.0138889 0.276028 7.0166667 0.276028 7.0194444 0.277700 7.0222222 0.277700 7.0250000 0.276585 7.0277778 0.275470 7.0305556 0.276585 7.0333333 0.278258 7.0361111 0.277700 7.0388889 0.278815 7.0416667 0.276585 7.0444444 0.275470 7.0472222 0.276028 7.0500000 0.277700 7.0527778 0.279373 7.0555556 0.278258 7.0583333 0.277700 7.0611111 0.277700 7.0638889 0.277143 7.0666667 0.278258 7.0694444 0.279373 7.0722222 0.278815 7.0750000 0.278258 7.0777778 0.277700 7.0805556 0.277700 7.0833333 0.277700 7.0861111 0.278815 7.0888889 0.277700 7.0916667 0.278815 7.0944444 0.277700 7.0972222 0.278258 7.1000000 0.279930 7.1027778 0.282160 7.1055556 0.279930 7.1083333 0.279930 7.1111111 0.279373 7.1138889 0.279930 7.1166667 0.282160 7.1194444 0.283833 7.1222222 0.282718 7.1250000 0.281045 7.1277778 0.281045 7.1305556 0.282718 7.1333333 0.283833 7.1361111 0.285505 7.1388889 0.284948 7.1416667 0.284390 7.1444444 0.284948 7.1472222 0.284390 7.1500000 0.284390 7.1527778 0.286063 7.1555556 0.285505 7.1583333 0.283275 7.1611111 0.281603 7.1638889 0.281603 7.1666667 0.281603 7.1694444 0.282718 7.1722222 0.283275 7.1750000 0.281603 7.1777778 0.279930 7.1805556 0.278258 7.1833333 0.280488 7.1861111 0.281045 7.1888889 0.280488 7.1916667 0.279373 7.1944444 0.278258 7.1972222 0.278815 7.2000000 0.280488 7.2027778 0.279373 7.2055556 0.278815 7.2083333 0.277143 7.2111111 0.276028 7.2138889 0.276028 7.2166667 0.278258 7.2194444 0.279930 7.2222222 0.278815 7.2250000 0.277700 7.2277778 0.277700 7.2305556 0.276028 7.2333333 0.277700 7.2361111 0.279930 7.2388889 0.278258 7.2416667 0.277700 7.2444444 0.277143 7.2472222 0.276585 7.2500000 0.277700 7.2527778 0.277143 7.2555556 0.273798 7.2583333 0.271010 7.2611111 0.268223 7.2638889 0.266551 7.2666667 0.263763 7.2694444 0.264321 7.2722222 0.267666 7.2750000 0.278815 7.2777778 0.293868 7.2805556 0.305575 7.2833333 0.316725 7.2861111 0.327317 7.2888889 0.338467 7.2916667 0.349617 7.2944444 0.359094 7.2972222 0.366341 7.3000000 0.357979 7.3027778 0.330662 7.3055556 0.290523 7.3083333 0.266551 7.3111111 0.262648 7.3138889 0.268223 7.3166667 0.272125 7.3194444 0.272683 7.3222222 0.273798 7.3250000 0.276028 7.3277778 0.274355 7.3305556 0.274355 7.3333333 0.273240 7.3361111 0.273798 7.3388889 0.273798 7.3416667 0.272683 7.3444444 0.271568 7.3472222 0.272125 7.3500000 0.273240 7.3527778 0.274913 7.3555556 0.274355 7.3583333 0.272125 7.3611111 0.273240 7.3638889 0.271568 7.3666667 0.274355 7.3694444 0.274913 7.3722222 0.274913 7.3750000 0.274913 7.3777778 0.274355 7.3805556 0.273240 7.3833333 0.274913 7.3861111 0.276028 7.3888889 0.276028 7.3916667 0.274913 7.3944444 0.273798 7.3972222 0.273240 7.4000000 0.274913 7.4027778 0.277143 7.4055556 0.276585 7.4083333 0.274913 7.4111111 0.274355 7.4138889 0.273798 7.4166667 0.274913 7.4194444 0.276028 7.4222222 0.275470 7.4250000 0.274355 7.4277778 0.273798 7.4305556 0.274355 7.4333333 0.276028 7.4361111 0.276028 7.4388889 0.276028 7.4416667 0.274913 7.4444444 0.273798 7.4472222 0.273798 7.4500000 0.274355 7.4527778 0.276028 7.4555556 0.274913 7.4583333 0.274913 7.4611111 0.273798 7.4638889 0.272683 7.4666667 0.273240 7.4694444 0.274913 7.4722222 0.276585 7.4750000 0.274355 7.4777778 0.274355 7.4805556 0.272683 7.4833333 0.275470 7.4861111 0.274913 7.4888889 0.273798 7.4916667 0.272683 7.4944444 0.272125 7.4972222 0.272125 7.5000000 0.273240 7.5027778 0.273240 7.5055556 0.272683 7.5083333 0.272125 7.5111111 0.269895 7.5138889 0.269895 7.5166667 0.270453 7.5194444 0.271010 7.5222222 0.268780 7.5250000 0.267108 7.5277778 0.267108 7.5305556 0.264878 7.5333333 0.265436 7.5361111 0.265993 7.5388889 0.265436 7.5416667 0.263763 7.5444444 0.263206 7.5472222 0.260976 7.5500000 0.262091 7.5527778 0.262648 7.5555556 0.260976 7.5583333 0.260976 7.5611111 0.258746 7.5638889 0.259303 7.5666667 0.260418 7.5694444 0.262648 7.5722222 0.260418 7.5750000 0.259303 7.5777778 0.258746 7.5805556 0.259861 7.5833333 0.262648 7.5861111 0.264878 7.5888889 0.264878 7.5916667 0.265993 7.5944444 0.268223 7.5972222 0.268223 7.6000000 0.269895 7.6027778 0.273240 7.6055556 0.274355 7.6083333 0.275470 7.6111111 0.275470 7.6138889 0.277700 7.6166667 0.279930 7.6194444 0.280488 7.6222222 0.279930 7.6250000 0.279373 7.6277778 0.278815 7.6305556 0.279373 7.6333333 0.279930 7.6361111 0.280488 7.6388889 0.281045 7.6416667 0.281603 7.6444444 0.280488 7.6472222 0.281045 7.6500000 0.281603 7.6527778 0.282718 7.6555556 0.282160 7.6583333 0.282160 7.6611111 0.281603 7.6638889 0.281603 7.6666667 0.282160 7.6694444 0.283833 7.6722222 0.283275 7.6750000 0.282160 7.6777778 0.281603 7.6805556 0.280488 7.6833333 0.283275 7.6861111 0.284390 7.6888889 0.282718 7.6916667 0.282160 7.6944444 0.280488 7.6972222 0.280488 7.7000000 0.281045 7.7027778 0.282160 7.7055556 0.282718 7.7083333 0.281603 7.7111111 0.280488 7.7138889 0.279930 7.7166667 0.281045 7.7194444 0.281603 7.7222222 0.281045 7.7250000 0.279373 7.7277778 0.279373 7.7305556 0.279930 7.7333333 0.280488 7.7361111 0.281045 7.7388889 0.279930 7.7416667 0.279373 7.7444444 0.277700 7.7472222 0.278258 7.7500000 0.279373 7.7527778 0.280488 7.7555556 0.279930 7.7583333 0.279373 7.7611111 0.277143 7.7638889 0.276585 7.7666667 0.278815 7.7694444 0.279373 7.7722222 0.278815 7.7750000 0.277700 7.7777778 0.277143 7.7805556 0.276028 7.7833333 0.277700 7.7861111 0.279930 7.7888889 0.279373 7.7916667 0.277700 7.7944444 0.277143 7.7972222 0.277700 7.8000000 0.277143 7.8027778 0.278815 7.8055556 0.278815 7.8083333 0.279930 7.8111111 0.277143 7.8138889 0.277700 7.8166667 0.278258 7.8194444 0.279930 7.8222222 0.279373 7.8250000 0.279373 7.8277778 0.277700 7.8305556 0.277700 7.8333333 0.279930 7.8361111 0.279930 7.8388889 0.279373 7.8416667 0.279373 7.8444444 0.277700 7.8472222 0.278258 7.8500000 0.280488 7.8527778 0.280488 7.8555556 0.279373 7.8583333 0.278815 7.8611111 0.278258 7.8638889 0.277143 7.8666667 0.279373 7.8694444 0.282160 7.8722222 0.281045 7.8750000 0.278815 7.8777778 0.278815 7.8805556 0.278815 7.8833333 0.279930 7.8861111 0.281045 7.8888889 0.282160 7.8916667 0.281045 7.8944444 0.279373 7.8972222 0.278258 7.9000000 0.279930 7.9027778 0.280488 7.9055556 0.281045 7.9083333 0.281045 7.9111111 0.278258 7.9138889 0.277700 7.9166667 0.279930 7.9194444 0.281045 7.9222222 0.280488 7.9250000 0.279930 7.9277778 0.279930 7.9305556 0.281045 7.9333333 0.282718 7.9361111 0.284948 7.9388889 0.283833 7.9416667 0.282160 7.9444444 0.282160 7.9472222 0.282160 7.9500000 0.284390 7.9527778 0.286620 7.9555556 0.286620 7.9583333 0.285505 7.9611111 0.285505 7.9638889 0.286063 7.9666667 0.286063 7.9694444 0.287178 7.9722222 0.287735 7.9750000 0.285505 7.9777778 0.283833 7.9805556 0.282718 7.9833333 0.284390 7.9861111 0.284390 7.9888889 0.283833 7.9916667 0.283275 7.9944444 0.282160 7.9972222 0.281603 8.0000000 0.282160 8.0027778 0.283275 8.0055556 0.281603 8.0083333 0.279373 8.0111111 0.279930 8.0138889 0.279373 8.0166667 0.281045 8.0194444 0.282718 8.0222222 0.280488 8.0250000 0.278815 8.0277778 0.278258 8.0305556 0.278258 8.0333333 0.279930 8.0361111 0.280488 8.0388889 0.279930 8.0416667 0.279930 8.0444444 0.278815 8.0472222 0.281045 8.0500000 0.279930 8.0527778 0.280488 8.0555556 0.279930 8.0583333 0.279373 8.0611111 0.277700 8.0638889 0.278258 8.0666667 0.277700 8.0694444 0.274913 8.0722222 0.271568 8.0750000 0.267108 8.0777778 0.263206 8.0805556 0.262091 8.0833333 0.265993 8.0861111 0.278258 8.0888889 0.292753 8.0916667 0.307805 8.0944444 0.320070 8.0972222 0.331777 8.1000000 0.346272 8.1027778 0.361882 8.1055556 0.374704 8.1083333 0.378049 8.1111111 0.361882 8.1138889 0.323415 8.1166667 0.286063 8.1194444 0.270453 8.1222222 0.273240 8.1250000 0.276028 8.1277778 0.276028 8.1305556 0.274355 8.1333333 0.275470 8.1361111 0.276585 8.1388889 0.273798 8.1416667 0.273798 8.1444444 0.273798 8.1472222 0.274355 8.1500000 0.274913 8.1527778 0.276585 8.1555556 0.276028 8.1583333 0.274913 8.1611111 0.273240 8.1638889 0.272125 8.1666667 0.274355 8.1694444 0.274355 8.1722222 0.274913 8.1750000 0.274355 8.1777778 0.273240 8.1805556 0.273798 8.1833333 0.274355 8.1861111 0.274913 8.1888889 0.274355 8.1916667 0.272683 8.1944444 0.273798 8.1972222 0.273798 8.2000000 0.275470 8.2027778 0.275470 8.2055556 0.274913 8.2083333 0.274355 8.2111111 0.272683 8.2138889 0.274913 8.2166667 0.275470 8.2194444 0.276585 8.2222222 0.276585 8.2250000 0.275470 8.2277778 0.273240 8.2305556 0.273798 8.2333333 0.274913 8.2361111 0.276585 8.2388889 0.277700 8.2416667 0.274913 8.2444444 0.274913 8.2472222 0.274913 8.2500000 0.274913 8.2527778 0.276028 8.2555556 0.276028 8.2583333 0.273798 8.2611111 0.273240 8.2638889 0.273240 8.2666667 0.273798 8.2694444 0.275470 8.2722222 0.274913 8.2750000 0.273798 8.2777778 0.272683 8.2805556 0.272683 8.2833333 0.274355 8.2861111 0.274913 8.2888889 0.275470 8.2916667 0.272683 8.2944444 0.272125 8.2972222 0.271568 8.3000000 0.271568 8.3027778 0.273240 8.3055556 0.272125 8.3083333 0.271010 8.3111111 0.269338 8.3138889 0.268223 8.3166667 0.269338 8.3194444 0.268780 8.3222222 0.267666 8.3250000 0.266551 8.3277778 0.265993 8.3305556 0.264878 8.3333333 0.265436 8.3361111 0.264878 8.3388889 0.263763 8.3416667 0.262648 8.3444444 0.260976 8.3472222 0.261533 8.3500000 0.262091 8.3527778 0.262648 8.3555556 0.260976 8.3583333 0.259861 8.3611111 0.258746 8.3638889 0.259303 8.3666667 0.259861 8.3694444 0.261533 8.3722222 0.262091 8.3750000 0.260976 8.3777778 0.260418 8.3805556 0.261533 8.3833333 0.263763 8.3861111 0.265993 8.3888889 0.266551 8.3916667 0.268223 8.3944444 0.268223 8.3972222 0.268780 8.4000000 0.270453 8.4027778 0.274355 8.4055556 0.273798 8.4083333 0.273240 8.4111111 0.272683 8.4138889 0.274913 8.4166667 0.276028 8.4194444 0.278258 8.4222222 0.279930 8.4250000 0.279930 8.4277778 0.278815 8.4305556 0.279930 8.4333333 0.281603 8.4361111 0.284390 8.4388889 0.282718 8.4416667 0.281603 8.4444444 0.282160 8.4472222 0.282718 8.4500000 0.283833 8.4527778 0.284948 8.4555556 0.283275 8.4583333 0.281603 8.4611111 0.281045 8.4638889 0.283275 8.4666667 0.283833 8.4694444 0.283833 8.4722222 0.283833 8.4750000 0.282160 8.4777778 0.281045 8.4805556 0.281045 8.4833333 0.282718 8.4861111 0.284948 8.4888889 0.283833 8.4916667 0.282718 8.4944444 0.281603 8.4972222 0.279930 8.5000000 0.281603 8.5027778 0.283275 8.5055556 0.282160 8.5083333 0.283275 8.5111111 0.281045 8.5138889 0.280488 8.5166667 0.281603 8.5194444 0.282718 8.5222222 0.281603 8.5250000 0.280488 8.5277778 0.279930 8.5305556 0.280488 8.5333333 0.281603 8.5361111 0.282160 8.5388889 0.281603 8.5416667 0.279373 8.5444444 0.278258 8.5472222 0.279373 8.5500000 0.279373 8.5527778 0.281045 8.5555556 0.280488 8.5583333 0.281045 8.5611111 0.279373 8.5638889 0.279930 8.5666667 0.279373 8.5694444 0.279930 8.5722222 0.280488 8.5750000 0.279373 8.5777778 0.278815 8.5805556 0.279373 8.5833333 0.281045 8.5861111 0.282160 8.5888889 0.279373 8.5916667 0.279373 8.5944444 0.278815 8.5972222 0.277700 8.6000000 0.278258 8.6027778 0.281603 8.6055556 0.280488 8.6083333 0.279930 8.6111111 0.278815 8.6138889 0.278258 8.6166667 0.278815 8.6194444 0.282160 8.6222222 0.280488 8.6250000 0.281603 8.6277778 0.279373 8.6305556 0.279930 8.6333333 0.279930 8.6361111 0.282718 8.6388889 0.281045 8.6416667 0.279930 8.6444444 0.279930 8.6472222 0.279373 8.6500000 0.281603 8.6527778 0.283275 8.6555556 0.282160 8.6583333 0.281603 8.6611111 0.279930 8.6638889 0.279930 8.6666667 0.281603 8.6694444 0.283275 8.6722222 0.282718 8.6750000 0.282718 8.6777778 0.281045 8.6805556 0.280488 8.6833333 0.281603 8.6861111 0.282718 8.6888889 0.283275 8.6916667 0.282718 8.6944444 0.281603 8.6972222 0.281603 8.7000000 0.282160 8.7027778 0.282160 8.7055556 0.281603 8.7083333 0.281045 8.7111111 0.280488 8.7138889 0.282160 8.7166667 0.284948 8.7194444 0.284390 8.7222222 0.283833 8.7250000 0.284390 8.7277778 0.283833 8.7305556 0.284948 8.7333333 0.286063 8.7361111 0.287178 8.7388889 0.287178 8.7416667 0.286063 8.7444444 0.285505 8.7472222 0.288293 8.7500000 0.289408 8.7527778 0.289408 8.7555556 0.289408 8.7583333 0.289408 8.7611111 0.289408 8.7638889 0.287178 8.7666667 0.286620 8.7694444 0.286620 8.7722222 0.285505 8.7750000 0.284948 8.7777778 0.286063 8.7805556 0.284390 8.7833333 0.284948 8.7861111 0.286620 8.7888889 0.283275 8.7916667 0.283275 8.7944444 0.282718 8.7972222 0.282160 8.8000000 0.283833 8.8027778 0.284390 8.8055556 0.283833 8.8083333 0.283833 8.8111111 0.282160 8.8138889 0.281603 8.8166667 0.282718 8.8194444 0.283833 8.8222222 0.282718 8.8250000 0.282718 8.8277778 0.281045 8.8305556 0.281603 8.8333333 0.282160 8.8361111 0.282718 8.8388889 0.282160 8.8416667 0.281045 8.8444444 0.281045 8.8472222 0.281603 8.8500000 0.281603 8.8527778 0.283833 8.8555556 0.281045 8.8583333 0.278815 8.8611111 0.274913 8.8638889 0.272125 8.8666667 0.269895 8.8694444 0.268780 8.8722222 0.265993 8.8750000 0.267666 8.8777778 0.277700 8.8805556 0.291638 8.8833333 0.304460 8.8861111 0.315052 8.8888889 0.323972 8.8916667 0.335679 8.8944444 0.348502 8.8972222 0.360209 8.9000000 0.364669 8.9027778 0.351847 8.9055556 0.316167 8.9083333 0.282718 8.9111111 0.268223 8.9138889 0.272125 8.9166667 0.277700 8.9194444 0.279930 8.9222222 0.278815 8.9250000 0.278815 8.9277778 0.279373 8.9305556 0.278258 8.9333333 0.279373 8.9361111 0.280488 8.9388889 0.278815 8.9416667 0.278258 8.9444444 0.277143 8.9472222 0.277143 8.9500000 0.279373 8.9527778 0.281603 8.9555556 0.279373 8.9583333 0.278815 8.9611111 0.276585 8.9638889 0.276585 8.9666667 0.277700 8.9694444 0.278815 8.9722222 0.279373 8.9750000 0.278258 8.9777778 0.276585 8.9805556 0.276585 8.9833333 0.278815 8.9861111 0.279930 8.9888889 0.278815 8.9916667 0.278258 8.9944444 0.276028 8.9972222 0.276028 9.0000000 0.278258 9.0027778 0.279373 9.0055556 0.279930 9.0083333 0.279373 9.0111111 0.277700 9.0138889 0.277143 9.0166667 0.278815 9.0194444 0.279930 9.0222222 0.279373 9.0250000 0.278258 9.0277778 0.278258 9.0305556 0.278258 9.0333333 0.278815 9.0361111 0.279373 9.0388889 0.278258 9.0416667 0.278258 9.0444444 0.277143 9.0472222 0.277700 9.0500000 0.278815 9.0527778 0.279373 9.0555556 0.278258 9.0583333 0.276585 9.0611111 0.276028 9.0638889 0.276028 9.0666667 0.277143 9.0694444 0.278815 9.0722222 0.278815 9.0750000 0.277143 9.0777778 0.275470 9.0805556 0.276028 9.0833333 0.277143 9.0861111 0.276585 9.0888889 0.275470 9.0916667 0.274355 9.0944444 0.273240 9.0972222 0.271568 9.1000000 0.273240 9.1027778 0.274913 9.1055556 0.274355 9.1083333 0.272125 9.1111111 0.272125 9.1138889 0.271010 9.1166667 0.271010 9.1194444 0.271568 9.1222222 0.271010 9.1250000 0.268223 9.1277778 0.267108 9.1305556 0.266551 9.1333333 0.268223 9.1361111 0.268780 9.1388889 0.267666 9.1416667 0.265993 9.1444444 0.264878 9.1472222 0.264321 9.1500000 0.265436 9.1527778 0.265993 9.1555556 0.265436 9.1583333 0.264321 9.1611111 0.263763 9.1638889 0.262648 9.1666667 0.264321 9.1694444 0.266551 9.1722222 0.266551 9.1750000 0.266551 9.1777778 0.268223 9.1805556 0.268780 9.1833333 0.271010 9.1861111 0.273240 9.1888889 0.273798 9.1916667 0.274913 9.1944444 0.274355 9.1972222 0.274913 9.2000000 0.278815 9.2027778 0.279930 9.2055556 0.279373 9.2083333 0.279930 9.2111111 0.278258 9.2138889 0.279930 9.2166667 0.281045 9.2194444 0.282160 9.2222222 0.281045 9.2250000 0.281045 9.2277778 0.279930 9.2305556 0.279930 9.2333333 0.281045 9.2361111 0.282718 9.2388889 0.282718 9.2416667 0.282160 9.2444444 0.279930 9.2472222 0.280488 9.2500000 0.281603 9.2527778 0.282160 9.2555556 0.281045 9.2583333 0.280488 9.2611111 0.278815 9.2638889 0.278815 9.2666667 0.280488 9.2694444 0.281603 9.2722222 0.280488 9.2750000 0.279930 9.2777778 0.279373 9.2805556 0.279373 9.2833333 0.279373 9.2861111 0.281603 9.2888889 0.279373 9.2916667 0.279373 9.2944444 0.277143 9.2972222 0.276585 9.3000000 0.278258 9.3027778 0.281045 9.3055556 0.279930 9.3083333 0.279373 9.3111111 0.278815 9.3138889 0.277700 9.3166667 0.277700 9.3194444 0.278258 9.3222222 0.277700 9.3250000 0.277143 9.3277778 0.276585 9.3305556 0.276028 9.3333333 0.277143 9.3361111 0.277143 9.3388889 0.275470 9.3416667 0.276028 9.3444444 0.274913 9.3472222 0.276028 9.3500000 0.276585 9.3527778 0.278815 9.3555556 0.277143 9.3583333 0.276028 9.3611111 0.275470 9.3638889 0.274913 9.3666667 0.276585 9.3694444 0.277700 9.3722222 0.277143 9.3750000 0.276028 9.3777778 0.275470 9.3805556 0.274913 9.3833333 0.276028 9.3861111 0.277143 9.3888889 0.278258 9.3916667 0.276028 9.3944444 0.274355 9.3972222 0.273798 9.4000000 0.275470 9.4027778 0.277143 9.4055556 0.275470 9.4083333 0.274355 9.4111111 0.273240 9.4138889 0.273798 9.4166667 0.276028 9.4194444 0.276585 9.4222222 0.277143 9.4250000 0.277143 9.4277778 0.276585 9.4305556 0.276028 9.4333333 0.275470 9.4361111 0.277143 9.4388889 0.275470 9.4416667 0.274355 9.4444444 0.274913 9.4472222 0.274913 9.4500000 0.278258 9.4527778 0.278258 9.4555556 0.275470 9.4583333 0.274355 9.4611111 0.272125 9.4638889 0.273240 9.4666667 0.274913 9.4694444 0.276585 9.4722222 0.276585 9.4750000 0.274355 9.4777778 0.273798 9.4805556 0.273240 9.4833333 0.276585 9.4861111 0.278258 9.4888889 0.278258 9.4916667 0.278815 9.4944444 0.277700 9.4972222 0.278258 9.5000000 0.279930 9.5027778 0.279930 9.5055556 0.278815 9.5083333 0.278815 9.5111111 0.279930 9.5138889 0.279373 9.5166667 0.281603 9.5194444 0.281603 9.5222222 0.280488 9.5250000 0.279373 9.5277778 0.277700 9.5305556 0.278258 9.5333333 0.279373 9.5361111 0.279930 9.5388889 0.278258 9.5416667 0.278258 9.5444444 0.276028 9.5472222 0.277700 9.5500000 0.276585 9.5527778 0.278258 9.5555556 0.274913 9.5583333 0.273798 9.5611111 0.272683 9.5638889 0.272683 9.5666667 0.275470 9.5694444 0.274355 9.5722222 0.275470 9.5750000 0.274913 9.5777778 0.273240 9.5805556 0.274913 9.5833333 0.276585 9.5861111 0.275470 9.5888889 0.274355 9.5916667 0.274355 9.5944444 0.273240 9.5972222 0.272683 9.6000000 0.272683 9.6027778 0.273240 9.6055556 0.273798 9.6083333 0.273240 9.6111111 0.271568 9.6138889 0.271568 9.6166667 0.272125 9.6194444 0.274355 9.6222222 0.273240 9.6250000 0.272125 9.6277778 0.270453 9.6305556 0.267666 9.6333333 0.265436 9.6361111 0.265993 9.6388889 0.262648 9.6416667 0.260418 9.6444444 0.262648 9.6472222 0.269895 9.6500000 0.282160 9.6527778 0.294425 9.6555556 0.301115 9.6583333 0.307247 9.6611111 0.315052 9.6638889 0.326760 9.6666667 0.339582 9.6694444 0.344042 9.6722222 0.328432 9.6750000 0.298328 9.6777778 0.267108 9.6805556 0.254843 9.6833333 0.256516 9.6861111 0.262091 9.6888889 0.265993 9.6916667 0.265436 9.6944444 0.267108 9.6972222 0.267108 9.7000000 0.268780 9.7027778 0.269895 9.7055556 0.270453 9.7083333 0.268223 9.7111111 0.267666 9.7138889 0.267666 9.7166667 0.267666 9.7194444 0.268223 9.7222222 0.267666 9.7250000 0.267666 9.7277778 0.268223 9.7305556 0.268223 9.7333333 0.268223 9.7361111 0.270453 9.7388889 0.270453 9.7416667 0.269338 9.7444444 0.268223 9.7472222 0.268780 9.7500000 0.269895 9.7527778 0.269895 9.7555556 0.269338 9.7583333 0.269895 9.7611111 0.268223 9.7638889 0.266551 9.7666667 0.268780 9.7694444 0.269338 9.7722222 0.268223 9.7750000 0.268223 9.7777778 0.267108 9.7805556 0.267666 9.7833333 0.268223 9.7861111 0.269338 9.7888889 0.270453 9.7916667 0.268223 9.7944444 0.266551 9.7972222 0.265993 9.8000000 0.268223 9.8027778 0.269895 9.8055556 0.268780 9.8083333 0.269338 9.8111111 0.267666 9.8138889 0.268780 9.8166667 0.267666 9.8194444 0.268780 9.8222222 0.268780 9.8250000 0.268223 9.8277778 0.268223 9.8305556 0.268223 9.8333333 0.267108 9.8361111 0.269338 9.8388889 0.268780 9.8416667 0.267666 9.8444444 0.267108 9.8472222 0.267108 9.8500000 0.268223 9.8527778 0.269338 9.8555556 0.267108 9.8583333 0.265993 9.8611111 0.265993 9.8638889 0.264321 9.8666667 0.265993 9.8694444 0.267108 9.8722222 0.266551 9.8750000 0.266551 9.8777778 0.264321 9.8805556 0.264321 9.8833333 0.265436 9.8861111 0.265993 9.8888889 0.264878 9.8916667 0.263206 9.8944444 0.261533 9.8972222 0.260418 9.9000000 0.262091 9.9027778 0.262648 9.9055556 0.260976 9.9083333 0.258746 9.9111111 0.257631 9.9138889 0.257631 9.9166667 0.258188 9.9194444 0.257073 9.9222222 0.254843 9.9250000 0.254843 9.9277778 0.253171 9.9305556 0.252056 9.9333333 0.253728 9.9361111 0.254286 9.9388889 0.253728 9.9416667 0.252613 9.9444444 0.252613 9.9472222 0.252613 9.9500000 0.254843 9.9527778 0.257073 9.9555556 0.256516 9.9583333 0.257073 9.9611111 0.257073 9.9638889 0.257631 9.9666667 0.260976 9.9694444 0.264321 9.9722222 0.264878 9.9750000 0.264878 9.9777778 0.265993 9.9805556 0.265993 9.9833333 0.269895 9.9861111 0.272125 9.9888889 0.273798 9.9916667 0.273798 9.9944444 0.272683 9.9972222 0.273240 10.0000000 0.273798 10.0027778 0.276028 10.0055556 0.275470 10.0083333 0.275470 10.0111111 0.274913 10.0138889 0.275470 10.0166667 0.276028 10.0194444 0.277143 10.0222222 0.276028 10.0250000 0.276028 10.0277778 0.274913 10.0305556 0.274913 10.0333333 0.276028 10.0361111 0.278815 10.0388889 0.278258 10.0416667 0.276585 10.0444444 0.277143 10.0472222 0.277143 10.0500000 0.277700 10.0527778 0.277143 10.0555556 0.277143 10.0583333 0.277143 10.0611111 0.276028 10.0638889 0.276585 10.0666667 0.276585 10.0694444 0.277700 10.0722222 0.277700 10.0750000 0.277143 10.0777778 0.275470 10.0805556 0.276585 10.0833333 0.277700 10.0861111 0.277700 10.0888889 0.278258 10.0916667 0.276028 10.0944444 0.276028 10.0972222 0.275470 10.1000000 0.276585 10.1027778 0.276585 10.1055556 0.276585 10.1083333 0.276028 10.1111111 0.274913 10.1138889 0.274355 10.1166667 0.276028 10.1194444 0.276028 10.1222222 0.276028 10.1250000 0.275470 10.1277778 0.274355 10.1305556 0.275470 10.1333333 0.277143 10.1361111 0.277700 10.1388889 0.275470 10.1416667 0.274913 10.1444444 0.273240 10.1472222 0.274355 10.1500000 0.274355 10.1527778 0.276028 10.1555556 0.274913 10.1583333 0.275470 10.1611111 0.273798 10.1638889 0.274913 10.1666667 0.274913 10.1694444 0.276585 10.1722222 0.274913 10.1750000 0.274913 10.1777778 0.274913 10.1805556 0.274355 10.1833333 0.275470 10.1861111 0.276585 10.1888889 0.275470 10.1916667 0.276028 10.1944444 0.274355 10.1972222 0.273798 10.2000000 0.276028 10.2027778 0.276585 10.2055556 0.276028 10.2083333 0.274913 10.2111111 0.274913 10.2138889 0.273798 10.2166667 0.274355 10.2194444 0.276028 10.2222222 0.274913 10.2250000 0.275470 10.2277778 0.274355 10.2305556 0.274913 10.2333333 0.275470 10.2361111 0.276585 10.2388889 0.276028 10.2416667 0.275470 10.2444444 0.275470 10.2472222 0.274913 10.2500000 0.276585 10.2527778 0.277143 10.2555556 0.276028 10.2583333 0.274913 10.2611111 0.274355 10.2638889 0.273240 10.2666667 0.274913 10.2694444 0.277143 10.2722222 0.276028 10.2750000 0.276028 10.2777778 0.275470 10.2805556 0.274355 10.2833333 0.274913 10.2861111 0.276028 10.2888889 0.274913 10.2916667 0.275470 10.2944444 0.275470 10.2972222 0.274913 10.3000000 0.278258 10.3027778 0.278258 10.3055556 0.277143 10.3083333 0.277700 10.3111111 0.277700 10.3138889 0.278258 10.3166667 0.278815 10.3194444 0.281045 10.3222222 0.281045 10.3250000 0.279930 10.3277778 0.279930 10.3305556 0.279373 10.3333333 0.281045 10.3361111 0.281603 10.3388889 0.279930 10.3416667 0.280488 10.3444444 0.279373 10.3472222 0.280488 10.3500000 0.281045 10.3527778 0.283275 10.3555556 0.283275 10.3583333 0.282718 10.3611111 0.279930 10.3638889 0.279930 10.3666667 0.281045 10.3694444 0.280488 10.3722222 0.279930 10.3750000 0.278815 10.3777778 0.278258 10.3805556 0.277700 10.3833333 0.278815 10.3861111 0.279373 10.3888889 0.277700 10.3916667 0.278258 10.3944444 0.276028 10.3972222 0.276585 10.4000000 0.277700 10.4027778 0.278258 10.4055556 0.277143 10.4083333 0.275470 10.4111111 0.276028 10.4138889 0.274913 10.4166667 0.274913 10.4194444 0.276585 10.4222222 0.277143 10.4250000 0.276585 10.4277778 0.274913 10.4305556 0.274355 10.4333333 0.276028 10.4361111 0.277700 10.4388889 0.276028 10.4416667 0.275470 10.4444444 0.274913 10.4472222 0.276585 10.4500000 0.276585 10.4527778 0.277700 10.4555556 0.276585 10.4583333 0.276028 10.4611111 0.274913 10.4638889 0.273798 10.4666667 0.273240 10.4694444 0.271568 10.4722222 0.267666 10.4750000 0.265436 10.4777778 0.262648 10.4805556 0.259861 10.4833333 0.260976 10.4861111 0.268223 10.4888889 0.280488 10.4916667 0.294425 10.4944444 0.308362 10.4972222 0.321185 10.5000000 0.335122 10.5027778 0.347944 10.5055556 0.360767 10.5083333 0.373031 10.5111111 0.373031 10.5138889 0.356307 10.5166667 0.323415 10.5194444 0.289965 10.5222222 0.269338 10.5250000 0.267666 10.5277778 0.270453 10.5305556 0.272125 10.5333333 0.271568 10.5361111 0.274355 10.5388889 0.274355 10.5416667 0.272125 10.5444444 0.271568 10.5472222 0.271568 10.5500000 0.272125 10.5527778 0.273798 10.5555556 0.272125 10.5583333 0.272125 10.5611111 0.270453 10.5638889 0.271568 10.5666667 0.272125 10.5694444 0.273240 10.5722222 0.272683 10.5750000 0.271568 10.5777778 0.271568 10.5805556 0.270453 10.5833333 0.273240 10.5861111 0.273240 10.5888889 0.271568 10.5916667 0.271568 10.5944444 0.270453 10.5972222 0.271010 10.6000000 0.272125 10.6027778 0.271568 10.6055556 0.271568 10.6083333 0.271568 10.6111111 0.271568 10.6138889 0.272125 10.6166667 0.272683 10.6194444 0.274913 10.6222222 0.274355 10.6250000 0.272683 10.6277778 0.271568 10.6305556 0.271010 10.6333333 0.272683 10.6361111 0.272683 10.6388889 0.272683 10.6416667 0.273240 10.6444444 0.272125 10.6472222 0.272683 10.6500000 0.272683 10.6527778 0.273240 10.6555556 0.273240 10.6583333 0.272125 10.6611111 0.270453 10.6638889 0.271568 10.6666667 0.273240 10.6694444 0.273240 10.6722222 0.273240 10.6750000 0.271568)

Vth_rpeak rpeak_threshold 0 0.3472
Vth14  vth_14_fast 0 0.276549
Vth69  vth_69      0 0.446868
Vth28  vth_28      0 0.468409
Vth300 vth_300     0 0.327676
Vth10  vth_10      0 0.325957
Vth_pwb vth_pw_base 0 PWL(0.0000000 0.300000 0.8148889 0.413756 1.6260000 0.413756 2.4148889 0.413760 3.2065556 0.413791 3.9954444 0.413819 4.8121111 0.413850 5.4648889 0.413845 6.4593333 0.414047 7.3037778 0.413814 8.1148889 0.413775 8.9037778 0.413778 9.6760000 0.413809 10.6750000 0.413809)
Vth_pwp vth_pw_peak 0 PWL(0.0000000 0.300000 0.8148889 0.409176 1.6260000 0.409176 2.4148889 0.409179 3.2065556 0.409213 3.9954444 0.409243 4.8121111 0.409275 5.4648889 0.409270 6.4593333 0.409486 7.3037778 0.409238 8.1148889 0.409196 8.9037778 0.409199 9.6760000 0.409232 10.6750000 0.409232)
Vth_rrc vth_rr_cap  0 PWL(0.0000000 0.300000 0.8148889 0.396511 1.6260000 0.396511 2.4148889 0.396516 3.2065556 0.396558 3.9954444 0.396595 4.8121111 0.396635 5.4648889 0.396629 6.4593333 0.396898 7.3037778 0.396589 8.1148889 0.396536 8.9037778 0.396540 9.6760000 0.396582 10.6750000 0.396582)

.include "C:/Users/kadhi/OneDrive/Desktop/amux/verilogLearning/Leaky-Integrate-Fire---SNN-model-on-FPGA/experiments/frontend_optimization/complete_frontend_v9b/inverter.spice"
.include "C:/Users/kadhi/OneDrive/Desktop/amux/verilogLearning/Leaky-Integrate-Fire---SNN-model-on-FPGA/experiments/frontend_optimization/complete_frontend_v9b/bias_gen.spice"
.include "C:/Users/kadhi/OneDrive/Desktop/amux/verilogLearning/Leaky-Integrate-Fire---SNN-model-on-FPGA/experiments/frontend_optimization/complete_frontend_v9b/rpeak_detector.spice"
.include "C:/Users/kadhi/OneDrive/Desktop/amux/verilogLearning/Leaky-Integrate-Fire---SNN-model-on-FPGA/experiments/frontend_optimization/complete_frontend_v9b/rpeak_hold.spice"
.include "C:/Users/kadhi/OneDrive/Desktop/amux/verilogLearning/Leaky-Integrate-Fire---SNN-model-on-FPGA/experiments/frontend_optimization/complete_frontend_v9b/true_peak_detector.spice"
.include "C:/Users/kadhi/OneDrive/Desktop/amux/verilogLearning/Leaky-Integrate-Fire---SNN-model-on-FPGA/experiments/frontend_optimization/complete_frontend_v9b/delay_timer.spice"
.include "C:/Users/kadhi/OneDrive/Desktop/amux/verilogLearning/Leaky-Integrate-Fire---SNN-model-on-FPGA/experiments/frontend_optimization/complete_frontend_v9b/pulse_gen.spice"
.include "C:/Users/kadhi/OneDrive/Desktop/amux/verilogLearning/Leaky-Integrate-Fire---SNN-model-on-FPGA/experiments/frontend_optimization/complete_frontend_v9b/long_pulse_gen.spice"
.include "C:/Users/kadhi/OneDrive/Desktop/amux/verilogLearning/Leaky-Integrate-Fire---SNN-model-on-FPGA/experiments/frontend_optimization/complete_frontend_v9b/edge_buffer.spice"
.include "C:/Users/kadhi/OneDrive/Desktop/amux/verilogLearning/Leaky-Integrate-Fire---SNN-model-on-FPGA/experiments/frontend_optimization/complete_frontend_v9b/rr_timing.spice"
.include "C:/Users/kadhi/OneDrive/Desktop/amux/verilogLearning/Leaky-Integrate-Fire---SNN-model-on-FPGA/experiments/frontend_optimization/complete_frontend_v9b/beat_instability.spice"
.include "C:/Users/kadhi/OneDrive/Desktop/amux/verilogLearning/Leaky-Integrate-Fire---SNN-model-on-FPGA/experiments/frontend_optimization/complete_frontend_v9b/pwave_diff.spice"
.include "C:/Users/kadhi/OneDrive/Desktop/amux/verilogLearning/Leaky-Integrate-Fire---SNN-model-on-FPGA/experiments/frontend_optimization/complete_frontend_v9b/qrs_width.spice"
.include "C:/Users/kadhi/OneDrive/Desktop/amux/verilogLearning/Leaky-Integrate-Fire---SNN-model-on-FPGA/experiments/frontend_optimization/complete_frontend_v9b/qrs_slope.spice"
.include "C:/Users/kadhi/OneDrive/Desktop/amux/verilogLearning/Leaky-Integrate-Fire---SNN-model-on-FPGA/experiments/frontend_optimization/complete_frontend_v9b/qrs_symmetry.spice"

Xbias vbias vref vdd vss bias_gen

Xrpeak ecg_l0 rpeak_threshold rpeak_level vdd vss vbias rpeak_detector
Xrpk_hold rpeak_level rpeak_level_held vdd vss vbias rpeak_hold
Xtpd ecg_l0 rpeak_level_held peak_detected vdd vss vbias true_peak_detector
Xpg_rpk peak_detected true_rpeak_pulse vdd vss vbias pulse_gen

Vth_rpkdel vth_rpk_del 0 0.48
Xdt true_rpeak_pulse dt_s14_lev dt_s69_lev dt_wid_lev dt_bi_lev dt_rr_lev dt_rpk_del_unused dt_sf_out vdd vss vbias vth_14_fast vth_69 vth_28 vth_300 vth_10 vth_rpk_del delay_timer

Xpg_s14 dt_s14_lev trig_s14 vdd vss vbias pulse_gen
Xpg_rr  dt_rr_lev  trig_rr_copy vdd vss vbias long_pulse_gen
Xeb_wid dt_wid_lev wid_sharp vdd vss edge_buffer
Xpg_wid wid_sharp  trig_wid  vdd vss vbias pulse_gen
Xeb_s69 dt_s69_lev s69_sharp vdd vss edge_buffer
Xpg_s69 s69_sharp  trig_s69  vdd vss vbias pulse_gen
Xeb_bi  dt_bi_lev  bi_sharp  vdd vss edge_buffer
Xpg_bi  bi_sharp   trig_bi_copy vdd vss vbias long_pulse_gen

XMcpwb1 cnpwb vth_pw_base ctpwb vss sky130_fd_pr__nfet_01v8 L=4 W=2 nf=1
XMcpwb2 pw_base_lev rr_timer ctpwb vss sky130_fd_pr__nfet_01v8 L=4 W=2 nf=1
XMcpwb3 cnpwb cnpwb vdd vdd sky130_fd_pr__pfet_01v8 L=4 W=2 nf=1
XMcpwb4 pw_base_lev cnpwb vdd vdd sky130_fd_pr__pfet_01v8 L=4 W=2 nf=1
XMcpwb5 ctpwb vbias vss vss sky130_fd_pr__nfet_01v8 L=8 W=0.42 nf=1

XMcpwp1 cnpwp vth_pw_peak ctpwp vss sky130_fd_pr__nfet_01v8 L=4 W=2 nf=1
XMcpwp2 pw_peak_lev rr_timer ctpwp vss sky130_fd_pr__nfet_01v8 L=4 W=2 nf=1
XMcpwp3 cnpwp cnpwp vdd vdd sky130_fd_pr__pfet_01v8 L=4 W=2 nf=1
XMcpwp4 pw_peak_lev cnpwp vdd vdd sky130_fd_pr__pfet_01v8 L=4 W=2 nf=1
XMcpwp5 ctpwp vbias vss vss sky130_fd_pr__nfet_01v8 L=8 W=0.42 nf=1

XMcrrc1 cnrrc vth_rr_cap ctrrc vss sky130_fd_pr__nfet_01v8 L=4 W=2 nf=1
XMcrrc2 rr_cap_lev rr_timer ctrrc vss sky130_fd_pr__nfet_01v8 L=4 W=2 nf=1
XMcrrc3 cnrrc cnrrc vdd vdd sky130_fd_pr__pfet_01v8 L=4 W=2 nf=1
XMcrrc4 rr_cap_lev cnrrc vdd vdd sky130_fd_pr__pfet_01v8 L=4 W=2 nf=1
XMcrrc5 ctrrc vbias vss vss sky130_fd_pr__nfet_01v8 L=8 W=0.42 nf=1

Xeb_pwb pw_base_lev pwb_sharp vdd vss edge_buffer
Xpg_pwb pwb_sharp   trig_pw_base vdd vss vbias pulse_gen
Xeb_pwp pw_peak_lev pwp_sharp vdd vss edge_buffer
Xpg_pwp pwp_sharp   trig_pw_peak vdd vss vbias pulse_gen
Xeb_rrc rr_cap_lev  trig_rr_cap vdd vss edge_buffer

Xrr ecg_l0 trig_rr_cap true_rpeak_pulse trig_rr_copy f1_rr_ratio f2_rr_asym rr_timer rr_ewma vdd vss vbias rr_timing
Xbi0 ecg_l0 true_rpeak_pulse trig_bi_copy f3_bi_l0 vdd vss vbias beat_instability
Xbi1 ecg_l1 true_rpeak_pulse trig_bi_copy f4_bi_l1 vdd vss vbias beat_instability
Xpw ecg_l0 trig_pw_base trig_pw_peak f5_pwave vdd vss vbias pwave_diff
Xwid ecg_l0 trig_wid f6_width vdd vss qrs_width
Xslp ecg_l0 trig_s14 trig_s69 f7_slope vdd vss vbias qrs_slope
Xsym ecg_l0 true_rpeak_pulse f8_symmetry vdd vss qrs_symmetry

.ic V(xbias.iref)=0.3
.ic V(xrr.ewma_node)=0.390857
.ic V(xrr.esamp_node)=0.390857
.ic V(xrr.prev_node)=0.390857
.ic V(xbi0.prev_node)=0.30
.ic V(xbi0.esamp_node)=0.30
.ic V(xbi1.prev_node)=0.30
.ic V(xbi1.esamp_node)=0.30
.ic V(xtpd.peak_hold)=0.30

.tran 0.5m 10.6750 0 0.2m

.meas tran rpk_det_2 WHEN V(rpeak_level)=0.45 RISE=1 TD=2.363889
.meas tran rpk_hold_2 WHEN V(rpeak_level_held)=0.45 RISE=1 TD=2.363889
.meas tran tpd_2 WHEN V(peak_detected)=0.45 RISE=1 TD=2.363889
.meas tran trpk_pls_2 WHEN V(true_rpeak_pulse)=0.45 RISE=1 TD=2.363889
.meas tran dt_s14_2 WHEN V(dt_s14_lev)=0.45 RISE=1 TD=2.363889
.meas tran dt_s69_2 WHEN V(dt_s69_lev)=0.45 RISE=1 TD=2.363889
.meas tran dt_wid_2 WHEN V(dt_wid_lev)=0.45 RISE=1 TD=2.363889
.meas tran dt_bi_2 WHEN V(dt_bi_lev)=0.45 RISE=1 TD=2.363889
.meas tran dt_rr_2 WHEN V(dt_rr_lev)=0.45 RISE=1 TD=2.363889
.meas tran trig_s14_2 WHEN V(trig_s14)=0.45 RISE=1 TD=2.363889
.meas tran trig_wid_2 WHEN V(trig_wid)=0.45 RISE=1 TD=2.363889
.meas tran trig_s69_2 WHEN V(trig_s69)=0.45 RISE=1 TD=2.363889
.meas tran trig_bi_2 WHEN V(trig_bi_copy)=0.45 RISE=1 TD=2.363889
.meas tran trig_rrc_2 WHEN V(trig_rr_copy)=0.45 RISE=1 TD=2.363889
.meas tran ecg_at_ann_2 FIND V(ecg_l0) AT=2.4138889
.meas tran dt_sf_at_ann_2 FIND V(dt_sf_out) AT=2.4138889
.meas tran phold_at_ann_2 FIND V(xtpd.peak_hold) AT=2.4138889
.meas tran f1_2 FIND V(f1_rr_ratio) AT=2.5138889
.meas tran f3_2 FIND V(f3_bi_l0) AT=2.5138889
.meas tran f6_2 FIND V(f6_width) AT=2.5138889
.meas tran f7_2 FIND V(f7_slope) AT=2.5138889
.meas tran f8_2 FIND V(f8_symmetry) AT=2.5138889
.meas tran rpk_det_3 WHEN V(rpeak_level)=0.45 RISE=1 TD=3.155556
.meas tran rpk_hold_3 WHEN V(rpeak_level_held)=0.45 RISE=1 TD=3.155556
.meas tran tpd_3 WHEN V(peak_detected)=0.45 RISE=1 TD=3.155556
.meas tran trpk_pls_3 WHEN V(true_rpeak_pulse)=0.45 RISE=1 TD=3.155556
.meas tran dt_s14_3 WHEN V(dt_s14_lev)=0.45 RISE=1 TD=3.155556
.meas tran dt_s69_3 WHEN V(dt_s69_lev)=0.45 RISE=1 TD=3.155556
.meas tran dt_wid_3 WHEN V(dt_wid_lev)=0.45 RISE=1 TD=3.155556
.meas tran dt_bi_3 WHEN V(dt_bi_lev)=0.45 RISE=1 TD=3.155556
.meas tran dt_rr_3 WHEN V(dt_rr_lev)=0.45 RISE=1 TD=3.155556
.meas tran trig_s14_3 WHEN V(trig_s14)=0.45 RISE=1 TD=3.155556
.meas tran trig_wid_3 WHEN V(trig_wid)=0.45 RISE=1 TD=3.155556
.meas tran trig_s69_3 WHEN V(trig_s69)=0.45 RISE=1 TD=3.155556
.meas tran trig_bi_3 WHEN V(trig_bi_copy)=0.45 RISE=1 TD=3.155556
.meas tran trig_rrc_3 WHEN V(trig_rr_copy)=0.45 RISE=1 TD=3.155556
.meas tran ecg_at_ann_3 FIND V(ecg_l0) AT=3.2055556
.meas tran dt_sf_at_ann_3 FIND V(dt_sf_out) AT=3.2055556
.meas tran phold_at_ann_3 FIND V(xtpd.peak_hold) AT=3.2055556
.meas tran f1_3 FIND V(f1_rr_ratio) AT=3.3055556
.meas tran f3_3 FIND V(f3_bi_l0) AT=3.3055556
.meas tran f6_3 FIND V(f6_width) AT=3.3055556
.meas tran f7_3 FIND V(f7_slope) AT=3.3055556
.meas tran f8_3 FIND V(f8_symmetry) AT=3.3055556
.meas tran rpk_det_4 WHEN V(rpeak_level)=0.45 RISE=1 TD=3.944444
.meas tran rpk_hold_4 WHEN V(rpeak_level_held)=0.45 RISE=1 TD=3.944444
.meas tran tpd_4 WHEN V(peak_detected)=0.45 RISE=1 TD=3.944444
.meas tran trpk_pls_4 WHEN V(true_rpeak_pulse)=0.45 RISE=1 TD=3.944444
.meas tran dt_s14_4 WHEN V(dt_s14_lev)=0.45 RISE=1 TD=3.944444
.meas tran dt_s69_4 WHEN V(dt_s69_lev)=0.45 RISE=1 TD=3.944444
.meas tran dt_wid_4 WHEN V(dt_wid_lev)=0.45 RISE=1 TD=3.944444
.meas tran dt_bi_4 WHEN V(dt_bi_lev)=0.45 RISE=1 TD=3.944444
.meas tran dt_rr_4 WHEN V(dt_rr_lev)=0.45 RISE=1 TD=3.944444
.meas tran trig_s14_4 WHEN V(trig_s14)=0.45 RISE=1 TD=3.944444
.meas tran trig_wid_4 WHEN V(trig_wid)=0.45 RISE=1 TD=3.944444
.meas tran trig_s69_4 WHEN V(trig_s69)=0.45 RISE=1 TD=3.944444
.meas tran trig_bi_4 WHEN V(trig_bi_copy)=0.45 RISE=1 TD=3.944444
.meas tran trig_rrc_4 WHEN V(trig_rr_copy)=0.45 RISE=1 TD=3.944444
.meas tran ecg_at_ann_4 FIND V(ecg_l0) AT=3.9944444
.meas tran dt_sf_at_ann_4 FIND V(dt_sf_out) AT=3.9944444
.meas tran phold_at_ann_4 FIND V(xtpd.peak_hold) AT=3.9944444
.meas tran f1_4 FIND V(f1_rr_ratio) AT=4.0944444
.meas tran f3_4 FIND V(f3_bi_l0) AT=4.0944444
.meas tran f6_4 FIND V(f6_width) AT=4.0944444
.meas tran f7_4 FIND V(f7_slope) AT=4.0944444
.meas tran f8_4 FIND V(f8_symmetry) AT=4.0944444
.meas tran rpk_det_5 WHEN V(rpeak_level)=0.45 RISE=1 TD=4.761111
.meas tran rpk_hold_5 WHEN V(rpeak_level_held)=0.45 RISE=1 TD=4.761111
.meas tran tpd_5 WHEN V(peak_detected)=0.45 RISE=1 TD=4.761111
.meas tran trpk_pls_5 WHEN V(true_rpeak_pulse)=0.45 RISE=1 TD=4.761111
.meas tran dt_s14_5 WHEN V(dt_s14_lev)=0.45 RISE=1 TD=4.761111
.meas tran dt_s69_5 WHEN V(dt_s69_lev)=0.45 RISE=1 TD=4.761111
.meas tran dt_wid_5 WHEN V(dt_wid_lev)=0.45 RISE=1 TD=4.761111
.meas tran dt_bi_5 WHEN V(dt_bi_lev)=0.45 RISE=1 TD=4.761111
.meas tran dt_rr_5 WHEN V(dt_rr_lev)=0.45 RISE=1 TD=4.761111
.meas tran trig_s14_5 WHEN V(trig_s14)=0.45 RISE=1 TD=4.761111
.meas tran trig_wid_5 WHEN V(trig_wid)=0.45 RISE=1 TD=4.761111
.meas tran trig_s69_5 WHEN V(trig_s69)=0.45 RISE=1 TD=4.761111
.meas tran trig_bi_5 WHEN V(trig_bi_copy)=0.45 RISE=1 TD=4.761111
.meas tran trig_rrc_5 WHEN V(trig_rr_copy)=0.45 RISE=1 TD=4.761111
.meas tran ecg_at_ann_5 FIND V(ecg_l0) AT=4.8111111
.meas tran dt_sf_at_ann_5 FIND V(dt_sf_out) AT=4.8111111
.meas tran phold_at_ann_5 FIND V(xtpd.peak_hold) AT=4.8111111
.meas tran f1_5 FIND V(f1_rr_ratio) AT=4.9111111
.meas tran f3_5 FIND V(f3_bi_l0) AT=4.9111111
.meas tran f6_5 FIND V(f6_width) AT=4.9111111
.meas tran f7_5 FIND V(f7_slope) AT=4.9111111
.meas tran f8_5 FIND V(f8_symmetry) AT=4.9111111
.meas tran rpk_det_6 WHEN V(rpeak_level)=0.45 RISE=1 TD=5.413889
.meas tran rpk_hold_6 WHEN V(rpeak_level_held)=0.45 RISE=1 TD=5.413889
.meas tran tpd_6 WHEN V(peak_detected)=0.45 RISE=1 TD=5.413889
.meas tran trpk_pls_6 WHEN V(true_rpeak_pulse)=0.45 RISE=1 TD=5.413889
.meas tran dt_s14_6 WHEN V(dt_s14_lev)=0.45 RISE=1 TD=5.413889
.meas tran dt_s69_6 WHEN V(dt_s69_lev)=0.45 RISE=1 TD=5.413889
.meas tran dt_wid_6 WHEN V(dt_wid_lev)=0.45 RISE=1 TD=5.413889
.meas tran dt_bi_6 WHEN V(dt_bi_lev)=0.45 RISE=1 TD=5.413889
.meas tran dt_rr_6 WHEN V(dt_rr_lev)=0.45 RISE=1 TD=5.413889
.meas tran trig_s14_6 WHEN V(trig_s14)=0.45 RISE=1 TD=5.413889
.meas tran trig_wid_6 WHEN V(trig_wid)=0.45 RISE=1 TD=5.413889
.meas tran trig_s69_6 WHEN V(trig_s69)=0.45 RISE=1 TD=5.413889
.meas tran trig_bi_6 WHEN V(trig_bi_copy)=0.45 RISE=1 TD=5.413889
.meas tran trig_rrc_6 WHEN V(trig_rr_copy)=0.45 RISE=1 TD=5.413889
.meas tran ecg_at_ann_6 FIND V(ecg_l0) AT=5.4638889
.meas tran dt_sf_at_ann_6 FIND V(dt_sf_out) AT=5.4638889
.meas tran phold_at_ann_6 FIND V(xtpd.peak_hold) AT=5.4638889
.meas tran f1_6 FIND V(f1_rr_ratio) AT=5.5638889
.meas tran f3_6 FIND V(f3_bi_l0) AT=5.5638889
.meas tran f6_6 FIND V(f6_width) AT=5.5638889
.meas tran f7_6 FIND V(f7_slope) AT=5.5638889
.meas tran f8_6 FIND V(f8_symmetry) AT=5.5638889
.meas tran rpk_det_7 WHEN V(rpeak_level)=0.45 RISE=1 TD=6.408333
.meas tran rpk_hold_7 WHEN V(rpeak_level_held)=0.45 RISE=1 TD=6.408333
.meas tran tpd_7 WHEN V(peak_detected)=0.45 RISE=1 TD=6.408333
.meas tran trpk_pls_7 WHEN V(true_rpeak_pulse)=0.45 RISE=1 TD=6.408333
.meas tran dt_s14_7 WHEN V(dt_s14_lev)=0.45 RISE=1 TD=6.408333
.meas tran dt_s69_7 WHEN V(dt_s69_lev)=0.45 RISE=1 TD=6.408333
.meas tran dt_wid_7 WHEN V(dt_wid_lev)=0.45 RISE=1 TD=6.408333
.meas tran dt_bi_7 WHEN V(dt_bi_lev)=0.45 RISE=1 TD=6.408333
.meas tran dt_rr_7 WHEN V(dt_rr_lev)=0.45 RISE=1 TD=6.408333
.meas tran trig_s14_7 WHEN V(trig_s14)=0.45 RISE=1 TD=6.408333
.meas tran trig_wid_7 WHEN V(trig_wid)=0.45 RISE=1 TD=6.408333
.meas tran trig_s69_7 WHEN V(trig_s69)=0.45 RISE=1 TD=6.408333
.meas tran trig_bi_7 WHEN V(trig_bi_copy)=0.45 RISE=1 TD=6.408333
.meas tran trig_rrc_7 WHEN V(trig_rr_copy)=0.45 RISE=1 TD=6.408333
.meas tran ecg_at_ann_7 FIND V(ecg_l0) AT=6.4583333
.meas tran dt_sf_at_ann_7 FIND V(dt_sf_out) AT=6.4583333
.meas tran phold_at_ann_7 FIND V(xtpd.peak_hold) AT=6.4583333
.meas tran f1_7 FIND V(f1_rr_ratio) AT=6.5583333
.meas tran f3_7 FIND V(f3_bi_l0) AT=6.5583333
.meas tran f6_7 FIND V(f6_width) AT=6.5583333
.meas tran f7_7 FIND V(f7_slope) AT=6.5583333
.meas tran f8_7 FIND V(f8_symmetry) AT=6.5583333
.meas tran rpk_det_8 WHEN V(rpeak_level)=0.45 RISE=1 TD=7.252778
.meas tran rpk_hold_8 WHEN V(rpeak_level_held)=0.45 RISE=1 TD=7.252778
.meas tran tpd_8 WHEN V(peak_detected)=0.45 RISE=1 TD=7.252778
.meas tran trpk_pls_8 WHEN V(true_rpeak_pulse)=0.45 RISE=1 TD=7.252778
.meas tran dt_s14_8 WHEN V(dt_s14_lev)=0.45 RISE=1 TD=7.252778
.meas tran dt_s69_8 WHEN V(dt_s69_lev)=0.45 RISE=1 TD=7.252778
.meas tran dt_wid_8 WHEN V(dt_wid_lev)=0.45 RISE=1 TD=7.252778
.meas tran dt_bi_8 WHEN V(dt_bi_lev)=0.45 RISE=1 TD=7.252778
.meas tran dt_rr_8 WHEN V(dt_rr_lev)=0.45 RISE=1 TD=7.252778
.meas tran trig_s14_8 WHEN V(trig_s14)=0.45 RISE=1 TD=7.252778
.meas tran trig_wid_8 WHEN V(trig_wid)=0.45 RISE=1 TD=7.252778
.meas tran trig_s69_8 WHEN V(trig_s69)=0.45 RISE=1 TD=7.252778
.meas tran trig_bi_8 WHEN V(trig_bi_copy)=0.45 RISE=1 TD=7.252778
.meas tran trig_rrc_8 WHEN V(trig_rr_copy)=0.45 RISE=1 TD=7.252778
.meas tran ecg_at_ann_8 FIND V(ecg_l0) AT=7.3027778
.meas tran dt_sf_at_ann_8 FIND V(dt_sf_out) AT=7.3027778
.meas tran phold_at_ann_8 FIND V(xtpd.peak_hold) AT=7.3027778
.meas tran f1_8 FIND V(f1_rr_ratio) AT=7.4027778
.meas tran f3_8 FIND V(f3_bi_l0) AT=7.4027778
.meas tran f6_8 FIND V(f6_width) AT=7.4027778
.meas tran f7_8 FIND V(f7_slope) AT=7.4027778
.meas tran f8_8 FIND V(f8_symmetry) AT=7.4027778
.meas tran rpk_det_9 WHEN V(rpeak_level)=0.45 RISE=1 TD=8.063889
.meas tran rpk_hold_9 WHEN V(rpeak_level_held)=0.45 RISE=1 TD=8.063889
.meas tran tpd_9 WHEN V(peak_detected)=0.45 RISE=1 TD=8.063889
.meas tran trpk_pls_9 WHEN V(true_rpeak_pulse)=0.45 RISE=1 TD=8.063889
.meas tran dt_s14_9 WHEN V(dt_s14_lev)=0.45 RISE=1 TD=8.063889
.meas tran dt_s69_9 WHEN V(dt_s69_lev)=0.45 RISE=1 TD=8.063889
.meas tran dt_wid_9 WHEN V(dt_wid_lev)=0.45 RISE=1 TD=8.063889
.meas tran dt_bi_9 WHEN V(dt_bi_lev)=0.45 RISE=1 TD=8.063889
.meas tran dt_rr_9 WHEN V(dt_rr_lev)=0.45 RISE=1 TD=8.063889
.meas tran trig_s14_9 WHEN V(trig_s14)=0.45 RISE=1 TD=8.063889
.meas tran trig_wid_9 WHEN V(trig_wid)=0.45 RISE=1 TD=8.063889
.meas tran trig_s69_9 WHEN V(trig_s69)=0.45 RISE=1 TD=8.063889
.meas tran trig_bi_9 WHEN V(trig_bi_copy)=0.45 RISE=1 TD=8.063889
.meas tran trig_rrc_9 WHEN V(trig_rr_copy)=0.45 RISE=1 TD=8.063889
.meas tran ecg_at_ann_9 FIND V(ecg_l0) AT=8.1138889
.meas tran dt_sf_at_ann_9 FIND V(dt_sf_out) AT=8.1138889
.meas tran phold_at_ann_9 FIND V(xtpd.peak_hold) AT=8.1138889
.meas tran f1_9 FIND V(f1_rr_ratio) AT=8.2138889
.meas tran f3_9 FIND V(f3_bi_l0) AT=8.2138889
.meas tran f6_9 FIND V(f6_width) AT=8.2138889
.meas tran f7_9 FIND V(f7_slope) AT=8.2138889
.meas tran f8_9 FIND V(f8_symmetry) AT=8.2138889
.meas tran rpk_det_10 WHEN V(rpeak_level)=0.45 RISE=1 TD=8.852778
.meas tran rpk_hold_10 WHEN V(rpeak_level_held)=0.45 RISE=1 TD=8.852778
.meas tran tpd_10 WHEN V(peak_detected)=0.45 RISE=1 TD=8.852778
.meas tran trpk_pls_10 WHEN V(true_rpeak_pulse)=0.45 RISE=1 TD=8.852778
.meas tran dt_s14_10 WHEN V(dt_s14_lev)=0.45 RISE=1 TD=8.852778
.meas tran dt_s69_10 WHEN V(dt_s69_lev)=0.45 RISE=1 TD=8.852778
.meas tran dt_wid_10 WHEN V(dt_wid_lev)=0.45 RISE=1 TD=8.852778
.meas tran dt_bi_10 WHEN V(dt_bi_lev)=0.45 RISE=1 TD=8.852778
.meas tran dt_rr_10 WHEN V(dt_rr_lev)=0.45 RISE=1 TD=8.852778
.meas tran trig_s14_10 WHEN V(trig_s14)=0.45 RISE=1 TD=8.852778
.meas tran trig_wid_10 WHEN V(trig_wid)=0.45 RISE=1 TD=8.852778
.meas tran trig_s69_10 WHEN V(trig_s69)=0.45 RISE=1 TD=8.852778
.meas tran trig_bi_10 WHEN V(trig_bi_copy)=0.45 RISE=1 TD=8.852778
.meas tran trig_rrc_10 WHEN V(trig_rr_copy)=0.45 RISE=1 TD=8.852778
.meas tran ecg_at_ann_10 FIND V(ecg_l0) AT=8.9027778
.meas tran dt_sf_at_ann_10 FIND V(dt_sf_out) AT=8.9027778
.meas tran phold_at_ann_10 FIND V(xtpd.peak_hold) AT=8.9027778
.meas tran f1_10 FIND V(f1_rr_ratio) AT=9.0027778
.meas tran f3_10 FIND V(f3_bi_l0) AT=9.0027778
.meas tran f6_10 FIND V(f6_width) AT=9.0027778
.meas tran f7_10 FIND V(f7_slope) AT=9.0027778
.meas tran f8_10 FIND V(f8_symmetry) AT=9.0027778
.meas tran rpk_det_11 WHEN V(rpeak_level)=0.45 RISE=1 TD=9.625000
.meas tran rpk_hold_11 WHEN V(rpeak_level_held)=0.45 RISE=1 TD=9.625000
.meas tran tpd_11 WHEN V(peak_detected)=0.45 RISE=1 TD=9.625000
.meas tran trpk_pls_11 WHEN V(true_rpeak_pulse)=0.45 RISE=1 TD=9.625000
.meas tran dt_s14_11 WHEN V(dt_s14_lev)=0.45 RISE=1 TD=9.625000
.meas tran dt_s69_11 WHEN V(dt_s69_lev)=0.45 RISE=1 TD=9.625000
.meas tran dt_wid_11 WHEN V(dt_wid_lev)=0.45 RISE=1 TD=9.625000
.meas tran dt_bi_11 WHEN V(dt_bi_lev)=0.45 RISE=1 TD=9.625000
.meas tran dt_rr_11 WHEN V(dt_rr_lev)=0.45 RISE=1 TD=9.625000
.meas tran trig_s14_11 WHEN V(trig_s14)=0.45 RISE=1 TD=9.625000
.meas tran trig_wid_11 WHEN V(trig_wid)=0.45 RISE=1 TD=9.625000
.meas tran trig_s69_11 WHEN V(trig_s69)=0.45 RISE=1 TD=9.625000
.meas tran trig_bi_11 WHEN V(trig_bi_copy)=0.45 RISE=1 TD=9.625000
.meas tran trig_rrc_11 WHEN V(trig_rr_copy)=0.45 RISE=1 TD=9.625000
.meas tran ecg_at_ann_11 FIND V(ecg_l0) AT=9.6750000
.meas tran dt_sf_at_ann_11 FIND V(dt_sf_out) AT=9.6750000
.meas tran phold_at_ann_11 FIND V(xtpd.peak_hold) AT=9.6750000
.meas tran f1_11 FIND V(f1_rr_ratio) AT=9.7750000
.meas tran f3_11 FIND V(f3_bi_l0) AT=9.7750000
.meas tran f6_11 FIND V(f6_width) AT=9.7750000
.meas tran f7_11 FIND V(f7_slope) AT=9.7750000
.meas tran f8_11 FIND V(f8_symmetry) AT=9.7750000

.end
