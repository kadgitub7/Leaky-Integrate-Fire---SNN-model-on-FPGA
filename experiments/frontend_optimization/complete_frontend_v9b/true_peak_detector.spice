* ============================================================
* TRUE PEAK DETECTOR v7g — Slow pump (25mV/ms) + large detect threshold
* ============================================================
*
* v6: source followers in cutoff, pump 80x slow. 2.8-7.6ms late.
* v7a-e: Removed source followers. Tried pump tuning, blanking
*   timers, and RC filters — all fail because tracking oscillation
*   overshoots exceed the detect threshold (SR latch captures any
*   glitch), and RC filters cause SPICE convergence issues.
*
* v7g: Slow pump + large threshold. 4pF hold cap → 25mV/ms pump
*   (1.25x upslope). Overshoot ~5mV (vs 15mV at 50mV/ms), well
*   below 19mV detect threshold. No false triggers during tracking.
*   After peak: ECG drops 14mV in ~0.7ms → detect fires.
*   Expected latency: ~1ms after true peak, jitter <0.3ms.
*
* Pin: ecg_in arm_signal peak_detected vdd vss vbias
* ============================================================

.subckt true_peak_detector ecg_in arm_signal peak_detected vdd vss vbias

* === PEAK HOLD CAP (4pF, 45x45 MIM) ===
* Doubled from 2pF to slow pump rate from 50 to 25mV/ms
XChold peak_hold vss sky130_fd_pr__cap_mim_m3_1 W=45 L=45

* === TRACKING COMPARATOR (direct input, no source followers) ===
* Fires HIGH when ecg_in > peak_hold + ~2mV (W offset: 4.3 vs 4)
XMt1 tn1 peak_hold tt1 vss sky130_fd_pr__nfet_01v8 L=2 W=4.3 nf=1
XMt2 stg1_track ecg_in tt1 vss sky130_fd_pr__nfet_01v8 L=2 W=4 nf=1
XMt3 tn1 tn1 vdd vdd sky130_fd_pr__pfet_01v8 L=2 W=4 nf=1
XMt4 stg1_track tn1 vdd vdd sky130_fd_pr__pfet_01v8 L=2 W=4 nf=1
XMt5 tt1 vbias vss vss sky130_fd_pr__nfet_01v8 L=2 W=4 nf=1
XMt6 track_level stg1_track vdd vdd sky130_fd_pr__pfet_01v8 L=0.5 W=4 nf=1
XMt7 track_level stg1_track vss vss sky130_fd_pr__nfet_01v8 L=0.5 W=2 nf=1

* === AND GATE: track_level AND arm_signal -> charge_en ===
XMg_p1 nand_trk track_level vdd vdd sky130_fd_pr__pfet_01v8 L=0.15 W=2 nf=1
XMg_p2 nand_trk arm_signal vdd vdd sky130_fd_pr__pfet_01v8 L=0.15 W=2 nf=1
XMg_n1 nand_trk track_level nand_mid1 vss sky130_fd_pr__nfet_01v8 L=0.15 W=1 nf=1
XMg_n2 nand_mid1 arm_signal vss vss sky130_fd_pr__nfet_01v8 L=0.15 W=1 nf=1
XMg_i1 charge_en nand_trk vdd vdd sky130_fd_pr__pfet_01v8 L=0.15 W=2 nf=1
XMg_i2 charge_en nand_trk vss vss sky130_fd_pr__nfet_01v8 L=0.15 W=1 nf=1

* === CHARGE PUMP: unidirectional ~100pA into peak_hold ===
* Mirror ratio 0.15 (W=0.6 / W=4), 100pA / 4pF = 25mV/ms.
XMcp_nb cp_bias vbias vss vss sky130_fd_pr__nfet_01v8 L=2 W=4 nf=1
XMcp_pd cp_bias cp_bias vdd vdd sky130_fd_pr__pfet_01v8 L=2 W=4 nf=1
XMcp_po cp_node cp_bias vdd vdd sky130_fd_pr__pfet_01v8 L=2 W=0.6 nf=1
Xinv_ce charge_en charge_en_bar vdd vss inverter_sub
XMcp_sw cp_node charge_en_bar peak_hold vdd sky130_fd_pr__pfet_01v8 L=0.5 W=2 nf=1

* === ECG PRECHARGE (when arm LOW: peak_hold tracks ecg_in) ===
Xinv_arm arm_signal arm_bar vdd vss inverter_sub
XMdis peak_hold arm_bar ecg_in vss sky130_fd_pr__nfet_01v8 L=0.5 W=2 nf=1

* === PEAK-DETECT COMPARATOR (~19mV threshold) ===
* Fires HIGH when peak_hold > ecg_in + ~19mV
* W=7 vs W=4: Vos = nVt*ln(7/4) = 34*0.559 = 19mV
* Exceeds worst-case tracking overshoot (~12mV from BSIM4 sim).
XMd1 dn1 ecg_in dt1 vss sky130_fd_pr__nfet_01v8 L=2 W=7 nf=1
XMd2 stg1_det peak_hold dt1 vss sky130_fd_pr__nfet_01v8 L=2 W=4 nf=1
XMd3 dn1 dn1 vdd vdd sky130_fd_pr__pfet_01v8 L=2 W=4 nf=1
XMd4 stg1_det dn1 vdd vdd sky130_fd_pr__pfet_01v8 L=2 W=4 nf=1
XMd5 dt1 vbias vss vss sky130_fd_pr__nfet_01v8 L=2 W=4 nf=1
XMd6 detect_raw stg1_det vdd vdd sky130_fd_pr__pfet_01v8 L=0.5 W=4 nf=1
XMd7 detect_raw stg1_det vss vss sky130_fd_pr__nfet_01v8 L=0.5 W=2 nf=1

* === TRACK-LEVEL INVERSION (for detect blanking) ===
Xinv_tl track_level track_level_bar vdd vss inverter_sub

* === 3-INPUT AND: detect_raw AND arm_signal AND track_level_bar ===
XMa_p1 nand_det detect_raw vdd vdd sky130_fd_pr__pfet_01v8 L=0.15 W=2 nf=1
XMa_p2 nand_det arm_signal vdd vdd sky130_fd_pr__pfet_01v8 L=0.15 W=2 nf=1
XMa_p3 nand_det track_level_bar vdd vdd sky130_fd_pr__pfet_01v8 L=0.15 W=2 nf=1
XMa_n1 nand_det detect_raw nand_mid2 vss sky130_fd_pr__nfet_01v8 L=0.15 W=1 nf=1
XMa_n2 nand_mid2 arm_signal nand_mid3 vss sky130_fd_pr__nfet_01v8 L=0.15 W=1 nf=1
XMa_n3 nand_mid3 track_level_bar vss vss sky130_fd_pr__nfet_01v8 L=0.15 W=1 nf=1
XMa_i1 det_pulse nand_det vdd vdd sky130_fd_pr__pfet_01v8 L=0.15 W=2 nf=1
XMa_i2 det_pulse nand_det vss vss sky130_fd_pr__nfet_01v8 L=0.15 W=1 nf=1

* === SR LATCH: set by det_pulse, reset by arm_bar ===
XMl1_pa l1_mid det_pulse vdd vdd sky130_fd_pr__pfet_01v8 L=0.15 W=4 nf=1
XMl1_pb latch_qb peak_detected l1_mid vdd sky130_fd_pr__pfet_01v8 L=0.15 W=4 nf=1
XMl1_na latch_qb det_pulse vss vss sky130_fd_pr__nfet_01v8 L=0.15 W=1 nf=1
XMl1_nb latch_qb peak_detected vss vss sky130_fd_pr__nfet_01v8 L=0.15 W=1 nf=1
XMl2_pa l2_mid arm_bar vdd vdd sky130_fd_pr__pfet_01v8 L=0.15 W=4 nf=1
XMl2_pb peak_detected latch_qb l2_mid vdd sky130_fd_pr__pfet_01v8 L=0.15 W=4 nf=1
XMl2_na peak_detected arm_bar vss vss sky130_fd_pr__nfet_01v8 L=0.15 W=1 nf=1
XMl2_nb peak_detected latch_qb vss vss sky130_fd_pr__nfet_01v8 L=0.15 W=1 nf=1

.ends true_peak_detector
