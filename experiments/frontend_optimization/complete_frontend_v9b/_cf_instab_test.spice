.title beat_instability_cf_test
.lib "C:\Users\kadhi\OneDrive\Desktop\amux\verilogLearning\Leaky-Integrate-Fire---SNN-model-on-FPGA\experiments\frontend_optimization\ngspice_frontend\sky130_minimal.lib.spice" tt
.option scale=1.0u method=gear reltol=0.01 gmin=1e-15
.temp 27
.include "beat_instability.spice"

Vdd vdd 0 0.9
Vss vss 0 0
Vbias vbias 0 0.35
Vecg ecg_in 0 PWL(0.0000000 0.300000 0.9890000 0.300000 0.9900000 0.389393 1.0050000 0.389393 1.0060000 0.300000 1.6445556 0.300000 1.6455556 0.404939 1.6605556 0.404939 1.6615556 0.300000 2.3167778 0.300000 2.3177778 0.460000 2.3327778 0.460000 2.3337778 0.300000 2.9528889 0.300000 2.9538889 0.443158 2.9688889 0.443158 2.9698889 0.300000 3.5778889 0.300000 3.5788889 0.456761 3.5938889 0.456761 3.5948889 0.300000 4.1778889 0.300000 4.1788889 0.457409 4.1938889 0.457409 4.1948889 0.300000 4.8056667 0.300000 4.8066667 0.423077 4.8216667 0.423077 4.8226667 0.300000 5.4223333 0.300000 5.4233333 0.414008 5.4383333 0.414008 5.4393333 0.300000 6.0695556 0.300000 6.0705556 0.408178 6.0855556 0.408178 6.0865556 0.300000 6.7251111 0.300000 6.7261111 0.373198 6.7411111 0.373198 6.7421111 0.300000 7.3751111 0.300000 7.3761111 0.370607 7.3911111 0.370607 7.3921111 0.300000 8.0056667 0.300000 8.0066667 0.372551 8.0216667 0.372551 8.0226667 0.300000 8.6390000 0.300000 8.6400000 0.379676 8.6550000 0.379676 8.6560000 0.300000 9.2584444 0.300000 9.2594444 0.377733 9.2744444 0.377733 9.2754444 0.300000 9.8584444 0.300000 9.8594444 0.359595 9.8744444 0.359595 9.8754444 0.300000 10.4417778 0.300000 10.4427778 0.356356 10.4577778 0.356356 10.4587778 0.300000 11.0473333 0.300000 11.0483333 0.369960 11.0633333 0.369960 11.0643333 0.300000 11.6584444 0.300000 11.6594444 0.379676 11.6744444 0.379676 11.6754444 0.300000 12.2973333 0.300000 12.2983333 0.377085 12.3133333 0.377085 12.3143333 0.300000 12.9473333 0.300000 12.9483333 0.364130 12.9633333 0.364130 12.9643333 0.300000 13.5806667 0.300000 13.5816667 0.368016 13.5966667 0.368016 13.5976667 0.300000 14.2112222 0.300000 14.2122222 0.379028 14.2272222 0.379028 14.2282222 0.300000 14.8001111 0.300000 14.8011111 0.300000 14.8161111 0.300000 14.8171111 0.300000 15.4195556 0.300000 15.4205556 0.387449 15.4355556 0.387449 15.4365556 0.300000 16.0140000 0.300000 16.0150000 0.371903 16.0300000 0.371903 16.0310000 0.300000 16.6306667 0.300000 16.6316667 0.379676 16.6466667 0.379676 16.6476667 0.300000 17.2306667 0.300000 17.2316667 0.382915 17.2466667 0.382915 17.2476667 0.300000 17.8501111 0.300000 17.8511111 0.390688 17.8661111 0.390688 17.8671111 0.300000 18.4806667 0.300000 18.4816667 0.387449 18.4966667 0.387449 18.4976667 0.300000 19.1473333 0.300000 19.1483333 0.379028 19.1633333 0.379028 19.1643333 0.300000 20.1583333 0.300000)
Vcapt capture_trig 0 PWL(0.0000000 0.000000 0.9915000 0.000000 0.9920000 0.900000 0.9970000 0.900000 0.9975000 0.000000 1.6470556 0.000000 1.6475556 0.900000 1.6525556 0.900000 1.6530556 0.000000 2.3192778 0.000000 2.3197778 0.900000 2.3247778 0.900000 2.3252778 0.000000 2.9553889 0.000000 2.9558889 0.900000 2.9608889 0.900000 2.9613889 0.000000 3.5803889 0.000000 3.5808889 0.900000 3.5858889 0.900000 3.5863889 0.000000 4.1803889 0.000000 4.1808889 0.900000 4.1858889 0.900000 4.1863889 0.000000 4.8081667 0.000000 4.8086667 0.900000 4.8136667 0.900000 4.8141667 0.000000 5.4248333 0.000000 5.4253333 0.900000 5.4303333 0.900000 5.4308333 0.000000 6.0720556 0.000000 6.0725556 0.900000 6.0775556 0.900000 6.0780556 0.000000 6.7276111 0.000000 6.7281111 0.900000 6.7331111 0.900000 6.7336111 0.000000 7.3776111 0.000000 7.3781111 0.900000 7.3831111 0.900000 7.3836111 0.000000 8.0081667 0.000000 8.0086667 0.900000 8.0136667 0.900000 8.0141667 0.000000 8.6415000 0.000000 8.6420000 0.900000 8.6470000 0.900000 8.6475000 0.000000 9.2609444 0.000000 9.2614444 0.900000 9.2664444 0.900000 9.2669444 0.000000 9.8609444 0.000000 9.8614444 0.900000 9.8664444 0.900000 9.8669444 0.000000 10.4442778 0.000000 10.4447778 0.900000 10.4497778 0.900000 10.4502778 0.000000 11.0498333 0.000000 11.0503333 0.900000 11.0553333 0.900000 11.0558333 0.000000 11.6609444 0.000000 11.6614444 0.900000 11.6664444 0.900000 11.6669444 0.000000 12.2998333 0.000000 12.3003333 0.900000 12.3053333 0.900000 12.3058333 0.000000 12.9498333 0.000000 12.9503333 0.900000 12.9553333 0.900000 12.9558333 0.000000 13.5831667 0.000000 13.5836667 0.900000 13.5886667 0.900000 13.5891667 0.000000 14.2137222 0.000000 14.2142222 0.900000 14.2192222 0.900000 14.2197222 0.000000 14.8026111 0.000000 14.8031111 0.900000 14.8081111 0.900000 14.8086111 0.000000 15.4220556 0.000000 15.4225556 0.900000 15.4275556 0.900000 15.4280556 0.000000 16.0165000 0.000000 16.0170000 0.900000 16.0220000 0.900000 16.0225000 0.000000 16.6331667 0.000000 16.6336667 0.900000 16.6386667 0.900000 16.6391667 0.000000 17.2331667 0.000000 17.2336667 0.900000 17.2386667 0.900000 17.2391667 0.000000 17.8526111 0.000000 17.8531111 0.900000 17.8581111 0.900000 17.8586111 0.000000 18.4831667 0.000000 18.4836667 0.900000 18.4886667 0.900000 18.4891667 0.000000 19.1498333 0.000000 19.1503333 0.900000 19.1553333 0.900000 19.1558333 0.000000 20.1583333 0.000000)
Vcopy copy_trig 0 PWL(0.0000000 0.000000 1.0095000 0.000000 1.0100000 0.900000 1.0120000 0.900000 1.0125000 0.000000 1.6650556 0.000000 1.6655556 0.900000 1.6675556 0.900000 1.6680556 0.000000 2.3372778 0.000000 2.3377778 0.900000 2.3397778 0.900000 2.3402778 0.000000 2.9733889 0.000000 2.9738889 0.900000 2.9758889 0.900000 2.9763889 0.000000 3.5983889 0.000000 3.5988889 0.900000 3.6008889 0.900000 3.6013889 0.000000 4.1983889 0.000000 4.1988889 0.900000 4.2008889 0.900000 4.2013889 0.000000 4.8261667 0.000000 4.8266667 0.900000 4.8286667 0.900000 4.8291667 0.000000 5.4428333 0.000000 5.4433333 0.900000 5.4453333 0.900000 5.4458333 0.000000 6.0900556 0.000000 6.0905556 0.900000 6.0925556 0.900000 6.0930556 0.000000 6.7456111 0.000000 6.7461111 0.900000 6.7481111 0.900000 6.7486111 0.000000 7.3956111 0.000000 7.3961111 0.900000 7.3981111 0.900000 7.3986111 0.000000 8.0261667 0.000000 8.0266667 0.900000 8.0286667 0.900000 8.0291667 0.000000 8.6595000 0.000000 8.6600000 0.900000 8.6620000 0.900000 8.6625000 0.000000 9.2789444 0.000000 9.2794444 0.900000 9.2814444 0.900000 9.2819444 0.000000 9.8789444 0.000000 9.8794444 0.900000 9.8814444 0.900000 9.8819444 0.000000 10.4622778 0.000000 10.4627778 0.900000 10.4647778 0.900000 10.4652778 0.000000 11.0678333 0.000000 11.0683333 0.900000 11.0703333 0.900000 11.0708333 0.000000 11.6789444 0.000000 11.6794444 0.900000 11.6814444 0.900000 11.6819444 0.000000 12.3178333 0.000000 12.3183333 0.900000 12.3203333 0.900000 12.3208333 0.000000 12.9678333 0.000000 12.9683333 0.900000 12.9703333 0.900000 12.9708333 0.000000 13.6011667 0.000000 13.6016667 0.900000 13.6036667 0.900000 13.6041667 0.000000 14.2317222 0.000000 14.2322222 0.900000 14.2342222 0.900000 14.2347222 0.000000 14.8206111 0.000000 14.8211111 0.900000 14.8231111 0.900000 14.8236111 0.000000 15.4400556 0.000000 15.4405556 0.900000 15.4425556 0.900000 15.4430556 0.000000 16.0345000 0.000000 16.0350000 0.900000 16.0370000 0.900000 16.0375000 0.000000 16.6511667 0.000000 16.6516667 0.900000 16.6536667 0.900000 16.6541667 0.000000 17.2511667 0.000000 17.2516667 0.900000 17.2536667 0.900000 17.2541667 0.000000 17.8706111 0.000000 17.8711111 0.900000 17.8731111 0.900000 17.8736111 0.000000 18.5011667 0.000000 18.5016667 0.900000 18.5036667 0.900000 18.5041667 0.000000 19.1678333 0.000000 19.1683333 0.900000 19.1703333 0.900000 19.1708333 0.000000 20.1583333 0.000000)

Xinstab ecg_in capture_trig copy_trig instab_out vdd vss vbias beat_instability

.tran 0.5m 20.1583

.meas tran instab_b0 FIND V(instab_out) AT=1.0050000
.meas tran curr_b0 FIND V(Xinstab.curr_node) AT=1.0050000
.meas tran prev_b0 FIND V(Xinstab.prev_node) AT=1.0050000
.meas tran instab_b1 FIND V(instab_out) AT=1.6605556
.meas tran curr_b1 FIND V(Xinstab.curr_node) AT=1.6605556
.meas tran prev_b1 FIND V(Xinstab.prev_node) AT=1.6605556
.meas tran instab_b2 FIND V(instab_out) AT=2.3327778
.meas tran curr_b2 FIND V(Xinstab.curr_node) AT=2.3327778
.meas tran prev_b2 FIND V(Xinstab.prev_node) AT=2.3327778
.meas tran instab_b3 FIND V(instab_out) AT=2.9688889
.meas tran curr_b3 FIND V(Xinstab.curr_node) AT=2.9688889
.meas tran prev_b3 FIND V(Xinstab.prev_node) AT=2.9688889
.meas tran instab_b4 FIND V(instab_out) AT=3.5938889
.meas tran curr_b4 FIND V(Xinstab.curr_node) AT=3.5938889
.meas tran prev_b4 FIND V(Xinstab.prev_node) AT=3.5938889
.meas tran instab_b5 FIND V(instab_out) AT=4.1938889
.meas tran curr_b5 FIND V(Xinstab.curr_node) AT=4.1938889
.meas tran prev_b5 FIND V(Xinstab.prev_node) AT=4.1938889
.meas tran instab_b6 FIND V(instab_out) AT=4.8216667
.meas tran curr_b6 FIND V(Xinstab.curr_node) AT=4.8216667
.meas tran prev_b6 FIND V(Xinstab.prev_node) AT=4.8216667
.meas tran instab_b7 FIND V(instab_out) AT=5.4383333
.meas tran curr_b7 FIND V(Xinstab.curr_node) AT=5.4383333
.meas tran prev_b7 FIND V(Xinstab.prev_node) AT=5.4383333
.meas tran instab_b8 FIND V(instab_out) AT=6.0855556
.meas tran curr_b8 FIND V(Xinstab.curr_node) AT=6.0855556
.meas tran prev_b8 FIND V(Xinstab.prev_node) AT=6.0855556
.meas tran instab_b9 FIND V(instab_out) AT=6.7411111
.meas tran curr_b9 FIND V(Xinstab.curr_node) AT=6.7411111
.meas tran prev_b9 FIND V(Xinstab.prev_node) AT=6.7411111
.meas tran instab_b10 FIND V(instab_out) AT=7.3911111
.meas tran curr_b10 FIND V(Xinstab.curr_node) AT=7.3911111
.meas tran prev_b10 FIND V(Xinstab.prev_node) AT=7.3911111
.meas tran instab_b11 FIND V(instab_out) AT=8.0216667
.meas tran curr_b11 FIND V(Xinstab.curr_node) AT=8.0216667
.meas tran prev_b11 FIND V(Xinstab.prev_node) AT=8.0216667
.meas tran instab_b12 FIND V(instab_out) AT=8.6550000
.meas tran curr_b12 FIND V(Xinstab.curr_node) AT=8.6550000
.meas tran prev_b12 FIND V(Xinstab.prev_node) AT=8.6550000
.meas tran instab_b13 FIND V(instab_out) AT=9.2744444
.meas tran curr_b13 FIND V(Xinstab.curr_node) AT=9.2744444
.meas tran prev_b13 FIND V(Xinstab.prev_node) AT=9.2744444
.meas tran instab_b14 FIND V(instab_out) AT=9.8744444
.meas tran curr_b14 FIND V(Xinstab.curr_node) AT=9.8744444
.meas tran prev_b14 FIND V(Xinstab.prev_node) AT=9.8744444
.meas tran instab_b15 FIND V(instab_out) AT=10.4577778
.meas tran curr_b15 FIND V(Xinstab.curr_node) AT=10.4577778
.meas tran prev_b15 FIND V(Xinstab.prev_node) AT=10.4577778
.meas tran instab_b16 FIND V(instab_out) AT=11.0633333
.meas tran curr_b16 FIND V(Xinstab.curr_node) AT=11.0633333
.meas tran prev_b16 FIND V(Xinstab.prev_node) AT=11.0633333
.meas tran instab_b17 FIND V(instab_out) AT=11.6744444
.meas tran curr_b17 FIND V(Xinstab.curr_node) AT=11.6744444
.meas tran prev_b17 FIND V(Xinstab.prev_node) AT=11.6744444
.meas tran instab_b18 FIND V(instab_out) AT=12.3133333
.meas tran curr_b18 FIND V(Xinstab.curr_node) AT=12.3133333
.meas tran prev_b18 FIND V(Xinstab.prev_node) AT=12.3133333
.meas tran instab_b19 FIND V(instab_out) AT=12.9633333
.meas tran curr_b19 FIND V(Xinstab.curr_node) AT=12.9633333
.meas tran prev_b19 FIND V(Xinstab.prev_node) AT=12.9633333
.meas tran instab_b20 FIND V(instab_out) AT=13.5966667
.meas tran curr_b20 FIND V(Xinstab.curr_node) AT=13.5966667
.meas tran prev_b20 FIND V(Xinstab.prev_node) AT=13.5966667
.meas tran instab_b21 FIND V(instab_out) AT=14.2272222
.meas tran curr_b21 FIND V(Xinstab.curr_node) AT=14.2272222
.meas tran prev_b21 FIND V(Xinstab.prev_node) AT=14.2272222
.meas tran instab_b22 FIND V(instab_out) AT=14.8161111
.meas tran curr_b22 FIND V(Xinstab.curr_node) AT=14.8161111
.meas tran prev_b22 FIND V(Xinstab.prev_node) AT=14.8161111
.meas tran instab_b23 FIND V(instab_out) AT=15.4355556
.meas tran curr_b23 FIND V(Xinstab.curr_node) AT=15.4355556
.meas tran prev_b23 FIND V(Xinstab.prev_node) AT=15.4355556
.meas tran instab_b24 FIND V(instab_out) AT=16.0300000
.meas tran curr_b24 FIND V(Xinstab.curr_node) AT=16.0300000
.meas tran prev_b24 FIND V(Xinstab.prev_node) AT=16.0300000
.meas tran instab_b25 FIND V(instab_out) AT=16.6466667
.meas tran curr_b25 FIND V(Xinstab.curr_node) AT=16.6466667
.meas tran prev_b25 FIND V(Xinstab.prev_node) AT=16.6466667
.meas tran instab_b26 FIND V(instab_out) AT=17.2466667
.meas tran curr_b26 FIND V(Xinstab.curr_node) AT=17.2466667
.meas tran prev_b26 FIND V(Xinstab.prev_node) AT=17.2466667
.meas tran instab_b27 FIND V(instab_out) AT=17.8661111
.meas tran curr_b27 FIND V(Xinstab.curr_node) AT=17.8661111
.meas tran prev_b27 FIND V(Xinstab.prev_node) AT=17.8661111
.meas tran instab_b28 FIND V(instab_out) AT=18.4966667
.meas tran curr_b28 FIND V(Xinstab.curr_node) AT=18.4966667
.meas tran prev_b28 FIND V(Xinstab.prev_node) AT=18.4966667
.meas tran instab_b29 FIND V(instab_out) AT=19.1633333
.meas tran curr_b29 FIND V(Xinstab.curr_node) AT=19.1633333
.meas tran prev_b29 FIND V(Xinstab.prev_node) AT=19.1633333

.end
