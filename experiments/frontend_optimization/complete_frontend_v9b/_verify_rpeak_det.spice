.title rpeak_det
.lib "C:/Users/kadhi/OneDrive/Desktop/amux/verilogLearning/Leaky-Integrate-Fire---SNN-model-on-FPGA/experiments/frontend_optimization/ngspice_frontend/sky130_minimal.lib.spice" tt
.option scale=1.0u method=gear reltol=0.01 gmin=1e-15
.temp 27
Vdd vdd 0 0.9
Vss vss 0 0
Vbias vbias 0 0.300
Vecg ecg_l0 0 PWL(0.0000000 0.300000 0.5608889 0.300000 0.5638889 0.249691 0.5666667 0.248866 0.5694444 0.250515 0.5722222 0.249691 0.5750000 0.252165 0.5777778 0.250515 0.5805556 0.250515 0.5833333 0.249691 0.5861111 0.249691 0.5888889 0.252165 0.5916667 0.253814 0.5944444 0.251340 0.5972222 0.249691 0.6000000 0.248041 0.6027778 0.249691 0.6055556 0.251340 0.6083333 0.252165 0.6111111 0.253814 0.6138889 0.255464 0.6166667 0.254639 0.6194444 0.254639 0.6222222 0.255464 0.6250000 0.258763 0.6277778 0.258763 0.6305556 0.257938 0.6333333 0.262887 0.6361111 0.263711 0.6388889 0.266186 0.6416667 0.267010 0.6444444 0.266186 0.6472222 0.264536 0.6500000 0.262062 0.6527778 0.263711 0.6555556 0.262887 0.6583333 0.262887 0.6611111 0.262887 0.6638889 0.262062 0.6666667 0.261237 0.6694444 0.260412 0.6722222 0.261237 0.6750000 0.263711 0.6777778 0.265361 0.6805556 0.266186 0.6833333 0.259588 0.6861111 0.252990 0.6888889 0.252990 0.6916667 0.250515 0.6944444 0.248866 0.6972222 0.245567 0.7000000 0.245567 0.7027778 0.246392 0.7055556 0.248041 0.7083333 0.247216 0.7111111 0.248041 0.7138889 0.246392 0.7166667 0.243918 0.7194444 0.243093 0.7222222 0.243918 0.7250000 0.243918 0.7277778 0.242268 0.7305556 0.243093 0.7333333 0.241443 0.7361111 0.245567 0.7388889 0.244742 0.7416667 0.245567 0.7444444 0.247216 0.7472222 0.243093 0.7500000 0.241443 0.7527778 0.243918 0.7555556 0.245567 0.7583333 0.246392 0.7611111 0.245567 0.7638889 0.242268 0.7666667 0.239794 0.7694444 0.240619 0.7722222 0.237320 0.7750000 0.229897 0.7777778 0.226598 0.7805556 0.221649 0.7833333 0.215876 0.7861111 0.211753 0.7888889 0.216701 0.7916667 0.231546 0.7944444 0.250515 0.7972222 0.273608 0.8000000 0.297526 0.8027778 0.338763 0.8055556 0.380825 0.8083333 0.418763 0.8111111 0.444330 0.8138889 0.455052 0.8166667 0.449278 0.8194444 0.424536 0.8222222 0.380825 0.8250000 0.327216 0.8277778 0.281856 0.8305556 0.255464 0.8333333 0.235670 0.8361111 0.225773 0.8388889 0.221649 0.8416667 0.224948 0.8444444 0.229897 0.8472222 0.235670 0.8500000 0.235670 0.8527778 0.236495 0.8555556 0.235670 0.8583333 0.237320 0.8611111 0.237320 0.8638889 0.237320 0.8666667 0.234845 0.8694444 0.236495 0.8722222 0.236495 0.8750000 0.236495 0.8777778 0.238144 0.8805556 0.234845 0.8833333 0.232371 0.8861111 0.232371 0.8888889 0.234021 0.8916667 0.234845 0.8944444 0.235670 0.8972222 0.233196 0.9000000 0.234845 0.9027778 0.236495 0.9055556 0.238144 0.9083333 0.235670 0.9111111 0.235670 0.9138889 0.233196 0.9166667 0.232371 0.9194444 0.232371 0.9222222 0.235670 0.9250000 0.235670 0.9277778 0.234845 0.9305556 0.233196 0.9333333 0.231546 0.9361111 0.234021 0.9388889 0.232371 0.9416667 0.233196 0.9444444 0.232371 0.9472222 0.231546 0.9500000 0.232371 0.9527778 0.234021 0.9555556 0.234021 0.9583333 0.234845 0.9611111 0.235670 0.9638889 0.233196 0.9666667 0.232371 0.9694444 0.235670 0.9722222 0.235670 0.9750000 0.236495 0.9777778 0.236495 0.9805556 0.232371 0.9833333 0.233196 0.9861111 0.234845 0.9888889 0.235670 0.9916667 0.238144 0.9944444 0.235670 0.9972222 0.234845 1.0000000 0.232371 1.0027778 0.234021 1.0055556 0.235670 1.0083333 0.235670 1.0111111 0.236495 1.0138889 0.233196 1.0166667 0.231546 1.0194444 0.231546 1.0222222 0.234021 1.0250000 0.234845 1.0277778 0.233196 1.0305556 0.231546 1.0333333 0.230722 1.0361111 0.230722 1.0388889 0.232371 1.0416667 0.231546 1.0444444 0.229897 1.0472222 0.230722 1.0500000 0.228247 1.0527778 0.229072 1.0555556 0.229072 1.0583333 0.230722 1.0611111 0.229072 1.0638889 0.225773 1.0666667 0.224948 1.0694444 0.225773 1.0722222 0.228247 1.0750000 0.226598 1.0777778 0.225773 1.0805556 0.224948 1.0833333 0.222474 1.0861111 0.224124 1.0888889 0.224948 1.0916667 0.225773 1.0944444 0.224948 1.0972222 0.222474 1.1000000 0.221649 1.1027778 0.224124 1.1055556 0.225773 1.1083333 0.226598 1.1111111 0.227423 1.1168889 0.300000 1.3720000 0.300000 1.3750000 0.245567 1.3777778 0.243093 1.3805556 0.243093 1.3833333 0.241443 1.3861111 0.242268 1.3888889 0.243918 1.3916667 0.245567 1.3944444 0.243918 1.3972222 0.243918 1.4000000 0.243918 1.4027778 0.245567 1.4055556 0.244742 1.4083333 0.245567 1.4111111 0.244742 1.4138889 0.243093 1.4166667 0.243093 1.4194444 0.243918 1.4222222 0.245567 1.4250000 0.248041 1.4277778 0.251340 1.4305556 0.250515 1.4333333 0.251340 1.4361111 0.252990 1.4388889 0.254639 1.4416667 0.256289 1.4444444 0.256289 1.4472222 0.256289 1.4500000 0.257938 1.4527778 0.258763 1.4555556 0.260412 1.4583333 0.262887 1.4611111 0.264536 1.4638889 0.260412 1.4666667 0.259588 1.4694444 0.260412 1.4722222 0.259588 1.4750000 0.261237 1.4777778 0.259588 1.4805556 0.258763 1.4833333 0.254639 1.4861111 0.254639 1.4888889 0.256289 1.4916667 0.258763 1.4944444 0.262887 1.4972222 0.263711 1.5000000 0.262062 1.5027778 0.256289 1.5055556 0.255464 1.5083333 0.253814 1.5111111 0.252990 1.5138889 0.249691 1.5166667 0.247216 1.5194444 0.243918 1.5222222 0.245567 1.5250000 0.244742 1.5277778 0.244742 1.5305556 0.241443 1.5333333 0.238969 1.5361111 0.240619 1.5388889 0.243093 1.5416667 0.242268 1.5444444 0.241443 1.5472222 0.239794 1.5500000 0.238144 1.5527778 0.237320 1.5555556 0.238969 1.5583333 0.239794 1.5611111 0.239794 1.5638889 0.237320 1.5666667 0.236495 1.5694444 0.237320 1.5722222 0.238144 1.5750000 0.241443 1.5777778 0.238969 1.5805556 0.235670 1.5833333 0.233196 1.5861111 0.232371 1.5888889 0.228247 1.5916667 0.223299 1.5944444 0.219175 1.5972222 0.214227 1.6000000 0.208454 1.6027778 0.205979 1.6055556 0.213402 1.6083333 0.233196 1.6111111 0.258763 1.6138889 0.285155 1.6166667 0.319794 1.6194444 0.367629 1.6222222 0.413814 1.6250000 0.445979 1.6277778 0.458351 1.6305556 0.440206 1.6333333 0.385773 1.6361111 0.308247 1.6388889 0.247216 1.6416667 0.217526 1.6444444 0.216701 1.6472222 0.226598 1.6500000 0.231546 1.6527778 0.234845 1.6555556 0.235670 1.6583333 0.234845 1.6611111 0.235670 1.6638889 0.234845 1.6666667 0.233196 1.6694444 0.234845 1.6722222 0.233196 1.6750000 0.235670 1.6777778 0.234845 1.6805556 0.234845 1.6833333 0.232371 1.6861111 0.233196 1.6888889 0.234021 1.6916667 0.234021 1.6944444 0.231546 1.6972222 0.233196 1.7000000 0.230722 1.7027778 0.231546 1.7055556 0.233196 1.7083333 0.233196 1.7111111 0.230722 1.7138889 0.230722 1.7166667 0.228247 1.7194444 0.230722 1.7222222 0.232371 1.7250000 0.232371 1.7277778 0.233196 1.7305556 0.229897 1.7333333 0.229072 1.7361111 0.230722 1.7388889 0.231546 1.7416667 0.232371 1.7444444 0.232371 1.7472222 0.229897 1.7500000 0.230722 1.7527778 0.234021 1.7555556 0.234845 1.7583333 0.234021 1.7611111 0.234021 1.7638889 0.234845 1.7666667 0.231546 1.7694444 0.233196 1.7722222 0.235670 1.7750000 0.234021 1.7777778 0.234021 1.7805556 0.231546 1.7833333 0.229897 1.7861111 0.229897 1.7888889 0.231546 1.7916667 0.231546 1.7944444 0.232371 1.7972222 0.229897 1.8000000 0.229897 1.8027778 0.230722 1.8055556 0.231546 1.8083333 0.234021 1.8111111 0.234021 1.8138889 0.232371 1.8166667 0.229897 1.8194444 0.232371 1.8222222 0.233196 1.8250000 0.234845 1.8277778 0.234021 1.8305556 0.234021 1.8333333 0.233196 1.8361111 0.236495 1.8388889 0.234021 1.8416667 0.235670 1.8444444 0.235670 1.8472222 0.234021 1.8500000 0.231546 1.8527778 0.233196 1.8555556 0.233196 1.8583333 0.232371 1.8611111 0.231546 1.8638889 0.230722 1.8666667 0.230722 1.8694444 0.229897 1.8722222 0.231546 1.8750000 0.231546 1.8777778 0.232371 1.8805556 0.228247 1.8833333 0.229072 1.8861111 0.228247 1.8888889 0.230722 1.8916667 0.230722 1.8944444 0.230722 1.8972222 0.230722 1.9000000 0.229897 1.9027778 0.229897 1.9055556 0.231546 1.9083333 0.234845 1.9111111 0.234845 1.9138889 0.235670 1.9166667 0.238144 1.9194444 0.240619 1.9222222 0.243918 1.9280000 0.300000 2.1608889 0.300000 2.1638889 0.238144 2.1666667 0.236495 2.1694444 0.241443 2.1722222 0.240619 2.1750000 0.241443 2.1777778 0.240619 2.1805556 0.240619 2.1833333 0.238969 2.1861111 0.240619 2.1888889 0.243093 2.1916667 0.241443 2.1944444 0.243093 2.1972222 0.243093 2.2000000 0.243093 2.2027778 0.243918 2.2055556 0.248866 2.2083333 0.249691 2.2111111 0.249691 2.2138889 0.248866 2.2166667 0.249691 2.2194444 0.252165 2.2222222 0.252990 2.2250000 0.254639 2.2277778 0.253814 2.2305556 0.253814 2.2333333 0.254639 2.2361111 0.256289 2.2388889 0.257938 2.2416667 0.259588 2.2444444 0.257113 2.2472222 0.256289 2.2500000 0.254639 2.2527778 0.253814 2.2555556 0.256289 2.2583333 0.255464 2.2611111 0.254639 2.2638889 0.253814 2.2666667 0.254639 2.2694444 0.253814 2.2722222 0.254639 2.2750000 0.256289 2.2777778 0.257938 2.2805556 0.260412 2.2833333 0.257113 2.2861111 0.253814 2.2888889 0.248866 2.2916667 0.248866 2.2944444 0.243093 2.2972222 0.240619 2.3000000 0.237320 2.3027778 0.236495 2.3055556 0.237320 2.3083333 0.238969 2.3111111 0.238144 2.3138889 0.236495 2.3166667 0.235670 2.3194444 0.234845 2.3222222 0.236495 2.3250000 0.236495 2.3277778 0.236495 2.3305556 0.234845 2.3333333 0.233196 2.3361111 0.234021 2.3388889 0.238144 2.3416667 0.238144 2.3444444 0.235670 2.3472222 0.234845 2.3500000 0.231546 2.3527778 0.233196 2.3555556 0.234021 2.3583333 0.235670 2.3611111 0.233196 2.3638889 0.229897 2.3666667 0.224124 2.3694444 0.221649 2.3722222 0.216701 2.3750000 0.215876 2.3777778 0.213402 2.3805556 0.210928 2.3833333 0.201031 2.3861111 0.193608 2.3888889 0.196082 2.3916667 0.205155 2.3944444 0.218351 2.3972222 0.236495 2.4000000 0.255464 2.4027778 0.281031 2.4055556 0.314845 2.4083333 0.361031 2.4111111 0.404742 2.4138889 0.433608 2.4166667 0.441856 2.4194444 0.427010 2.4222222 0.378351 2.4250000 0.310722 2.4277778 0.249691 2.4305556 0.217526 2.4333333 0.214227 2.4361111 0.221649 2.4388889 0.232371 2.4416667 0.235670 2.4444444 0.235670 2.4472222 0.234021 2.4500000 0.232371 2.4527778 0.233196 2.4555556 0.236495 2.4583333 0.235670 2.4611111 0.234845 2.4638889 0.233196 2.4666667 0.232371 2.4694444 0.233196 2.4722222 0.234021 2.4750000 0.235670 2.4777778 0.234845 2.4805556 0.232371 2.4833333 0.231546 2.4861111 0.232371 2.4888889 0.234845 2.4916667 0.233196 2.4944444 0.232371 2.4972222 0.233196 2.5000000 0.233196 2.5027778 0.232371 2.5055556 0.235670 2.5083333 0.236495 2.5111111 0.235670 2.5138889 0.234845 2.5166667 0.234021 2.5194444 0.234021 2.5222222 0.234021 2.5250000 0.234845 2.5277778 0.234845 2.5305556 0.233196 2.5333333 0.233196 2.5361111 0.234021 2.5388889 0.234845 2.5416667 0.236495 2.5444444 0.238144 2.5472222 0.236495 2.5500000 0.234845 2.5527778 0.235670 2.5555556 0.236495 2.5583333 0.238144 2.5611111 0.236495 2.5638889 0.234845 2.5666667 0.234845 2.5694444 0.236495 2.5722222 0.238144 2.5750000 0.238144 2.5777778 0.236495 2.5805556 0.234845 2.5833333 0.235670 2.5861111 0.235670 2.5888889 0.239794 2.5916667 0.238144 2.5944444 0.236495 2.5972222 0.234845 2.6000000 0.237320 2.6027778 0.236495 2.6055556 0.238144 2.6083333 0.237320 2.6111111 0.235670 2.6138889 0.237320 2.6166667 0.238144 2.6194444 0.238144 2.6222222 0.238144 2.6250000 0.238144 2.6277778 0.237320 2.6305556 0.235670 2.6333333 0.235670 2.6361111 0.239794 2.6388889 0.238969 2.6416667 0.238144 2.6444444 0.236495 2.6472222 0.235670 2.6500000 0.235670 2.6527778 0.238144 2.6555556 0.239794 2.6583333 0.236495 2.6611111 0.237320 2.6638889 0.235670 2.6666667 0.238144 2.6694444 0.238144 2.6722222 0.239794 2.6750000 0.238969 2.6777778 0.236495 2.6805556 0.234845 2.6833333 0.236495 2.6861111 0.236495 2.6888889 0.238969 2.6916667 0.239794 2.6944444 0.238969 2.6972222 0.238144 2.7000000 0.242268 2.7027778 0.244742 2.7055556 0.247216 2.7083333 0.248041 2.7111111 0.247216 2.7168889 0.300000 2.9525556 0.300000 2.9555556 0.243093 2.9583333 0.243093 2.9611111 0.242268 2.9638889 0.241443 2.9666667 0.243093 2.9694444 0.245567 2.9722222 0.245567 2.9750000 0.244742 2.9777778 0.244742 2.9805556 0.243918 2.9833333 0.245567 2.9861111 0.247216 2.9888889 0.252165 2.9916667 0.252165 2.9944444 0.250515 2.9972222 0.249691 3.0000000 0.252990 3.0027778 0.253814 3.0055556 0.254639 3.0083333 0.253814 3.0111111 0.254639 3.0138889 0.255464 3.0166667 0.256289 3.0194444 0.258763 3.0222222 0.262062 3.0250000 0.259588 3.0277778 0.260412 3.0305556 0.257938 3.0333333 0.257938 3.0361111 0.259588 3.0388889 0.261237 3.0416667 0.257938 3.0444444 0.256289 3.0472222 0.257113 3.0500000 0.257938 3.0527778 0.255464 3.0555556 0.256289 3.0583333 0.253814 3.0611111 0.257938 3.0638889 0.258763 3.0666667 0.259588 3.0694444 0.256289 3.0722222 0.253814 3.0750000 0.250515 3.0777778 0.248041 3.0805556 0.246392 3.0833333 0.244742 3.0861111 0.243093 3.0888889 0.245567 3.0916667 0.244742 3.0944444 0.243093 3.0972222 0.240619 3.1000000 0.242268 3.1027778 0.243918 3.1055556 0.244742 3.1083333 0.243093 3.1111111 0.240619 3.1138889 0.239794 3.1166667 0.238144 3.1194444 0.238969 3.1222222 0.239794 3.1250000 0.239794 3.1277778 0.237320 3.1305556 0.238144 3.1333333 0.238144 3.1361111 0.239794 3.1388889 0.238969 3.1416667 0.240619 3.1444444 0.238969 3.1472222 0.237320 3.1500000 0.239794 3.1527778 0.240619 3.1555556 0.242268 3.1583333 0.241443 3.1611111 0.238969 3.1638889 0.236495 3.1666667 0.234845 3.1694444 0.229072 3.1722222 0.226598 3.1750000 0.220000 3.1777778 0.215052 3.1805556 0.206804 3.1833333 0.208454 3.1861111 0.221649 3.1888889 0.241443 3.1916667 0.263711 3.1944444 0.290928 3.1972222 0.330515 3.2000000 0.378351 3.2027778 0.416289 3.2055556 0.435258 3.2083333 0.428660 3.2111111 0.388247 3.2138889 0.323918 3.2166667 0.267010 3.2194444 0.230722 3.2222222 0.217526 3.2250000 0.220825 3.2277778 0.225773 3.2305556 0.232371 3.2333333 0.234021 3.2361111 0.235670 3.2388889 0.235670 3.2416667 0.234021 3.2444444 0.233196 3.2472222 0.229897 3.2500000 0.229897 3.2527778 0.233196 3.2555556 0.234845 3.2583333 0.233196 3.2611111 0.233196 3.2638889 0.231546 3.2666667 0.233196 3.2694444 0.236495 3.2722222 0.235670 3.2750000 0.234845 3.2777778 0.234845 3.2805556 0.234845 3.2833333 0.234845 3.2861111 0.236495 3.2888889 0.235670 3.2916667 0.235670 3.2944444 0.234021 3.2972222 0.229897 3.3000000 0.232371 3.3027778 0.234021 3.3055556 0.234845 3.3083333 0.234021 3.3111111 0.233196 3.3138889 0.229897 3.3166667 0.231546 3.3194444 0.233196 3.3222222 0.233196 3.3250000 0.233196 3.3277778 0.232371 3.3305556 0.231546 3.3333333 0.233196 3.3361111 0.230722 3.3388889 0.233196 3.3416667 0.232371 3.3444444 0.232371 3.3472222 0.230722 3.3500000 0.231546 3.3527778 0.233196 3.3555556 0.234845 3.3583333 0.234845 3.3611111 0.234845 3.3638889 0.234021 3.3666667 0.234845 3.3694444 0.234845 3.3722222 0.233196 3.3750000 0.233196 3.3777778 0.230722 3.3805556 0.228247 3.3833333 0.231546 3.3861111 0.233196 3.3888889 0.234845 3.3916667 0.235670 3.3944444 0.231546 3.3972222 0.233196 3.4000000 0.233196 3.4027778 0.234021 3.4055556 0.234845 3.4083333 0.234845 3.4111111 0.233196 3.4138889 0.230722 3.4166667 0.231546 3.4194444 0.234021 3.4222222 0.234845 3.4250000 0.234021 3.4277778 0.233196 3.4305556 0.229897 3.4333333 0.229897 3.4361111 0.229897 3.4388889 0.230722 3.4416667 0.229897 3.4444444 0.225773 3.4472222 0.226598 3.4500000 0.225773 3.4527778 0.228247 3.4555556 0.226598 3.4583333 0.222474 3.4611111 0.224948 3.4638889 0.224124 3.4666667 0.227423 3.4694444 0.228247 3.4722222 0.229897 3.4750000 0.229072 3.4777778 0.226598 3.4805556 0.225773 3.4833333 0.226598 3.4861111 0.229072 3.4888889 0.230722 3.4916667 0.232371 3.4944444 0.229897 3.4972222 0.230722 3.5000000 0.233196 3.5027778 0.237320 3.5085556 0.300000 3.7414444 0.300000 3.7444444 0.243918 3.7472222 0.243918 3.7500000 0.243918 3.7527778 0.246392 3.7555556 0.246392 3.7583333 0.246392 3.7611111 0.243093 3.7638889 0.242268 3.7666667 0.243918 3.7694444 0.245567 3.7722222 0.247216 3.7750000 0.248866 3.7777778 0.249691 3.7805556 0.249691 3.7833333 0.254639 3.7861111 0.255464 3.7888889 0.257938 3.7916667 0.257113 3.7944444 0.256289 3.7972222 0.257113 3.8000000 0.258763 3.8027778 0.261237 3.8055556 0.261237 3.8083333 0.263711 3.8111111 0.261237 3.8138889 0.261237 3.8166667 0.263711 3.8194444 0.262062 3.8222222 0.262887 3.8250000 0.261237 3.8277778 0.259588 3.8305556 0.257938 3.8333333 0.260412 3.8361111 0.262062 3.8388889 0.262062 3.8416667 0.258763 3.8444444 0.257938 3.8472222 0.258763 3.8500000 0.262062 3.8527778 0.266186 3.8555556 0.267835 3.8583333 0.265361 3.8611111 0.262062 3.8638889 0.255464 3.8666667 0.255464 3.8694444 0.252990 3.8722222 0.252990 3.8750000 0.248866 3.8777778 0.245567 3.8805556 0.243918 3.8833333 0.243918 3.8861111 0.243093 3.8888889 0.242268 3.8916667 0.242268 3.8944444 0.243918 3.8972222 0.241443 3.9000000 0.243093 3.9027778 0.243918 3.9055556 0.243918 3.9083333 0.243093 3.9111111 0.241443 3.9138889 0.238969 3.9166667 0.241443 3.9194444 0.238969 3.9222222 0.243093 3.9250000 0.243918 3.9277778 0.240619 3.9305556 0.237320 3.9333333 0.240619 3.9361111 0.243093 3.9388889 0.242268 3.9416667 0.242268 3.9444444 0.241443 3.9472222 0.237320 3.9500000 0.235670 3.9527778 0.234845 3.9555556 0.229897 3.9583333 0.224948 3.9611111 0.221649 3.9638889 0.215876 3.9666667 0.210103 3.9694444 0.210928 3.9722222 0.218351 3.9750000 0.233196 3.9777778 0.251340 3.9805556 0.273608 3.9833333 0.306598 3.9861111 0.351959 3.9888889 0.398144 3.9916667 0.431959 3.9944444 0.445979 3.9972222 0.431134 4.0000000 0.385773 4.0027778 0.321443 4.0055556 0.264536 4.0083333 0.229897 4.0111111 0.217526 4.0138889 0.219175 4.0166667 0.225773 4.0194444 0.234021 4.0222222 0.235670 4.0250000 0.234845 4.0277778 0.234845 4.0305556 0.234021 4.0333333 0.235670 4.0361111 0.237320 4.0388889 0.236495 4.0416667 0.236495 4.0444444 0.234021 4.0472222 0.232371 4.0500000 0.232371 4.0527778 0.235670 4.0555556 0.235670 4.0583333 0.233196 4.0611111 0.233196 4.0638889 0.231546 4.0666667 0.232371 4.0694444 0.234845 4.0722222 0.234845 4.0750000 0.234021 4.0777778 0.231546 4.0805556 0.231546 4.0833333 0.231546 4.0861111 0.234021 4.0888889 0.235670 4.0916667 0.235670 4.0944444 0.232371 4.0972222 0.231546 4.1000000 0.233196 4.1027778 0.234845 4.1055556 0.234845 4.1083333 0.234845 4.1111111 0.233196 4.1138889 0.232371 4.1166667 0.232371 4.1194444 0.234021 4.1222222 0.235670 4.1250000 0.234845 4.1277778 0.232371 4.1305556 0.229897 4.1333333 0.231546 4.1361111 0.233196 4.1388889 0.232371 4.1416667 0.233196 4.1444444 0.231546 4.1472222 0.229897 4.1500000 0.229897 4.1527778 0.232371 4.1555556 0.234845 4.1583333 0.235670 4.1611111 0.234021 4.1638889 0.232371 4.1666667 0.232371 4.1694444 0.234021 4.1722222 0.235670 4.1750000 0.232371 4.1777778 0.230722 4.1805556 0.230722 4.1833333 0.231546 4.1861111 0.231546 4.1888889 0.233196 4.1916667 0.230722 4.1944444 0.231546 4.1972222 0.229897 4.2000000 0.232371 4.2027778 0.234021 4.2055556 0.233196 4.2083333 0.234021 4.2111111 0.234021 4.2138889 0.232371 4.2166667 0.234021 4.2194444 0.234845 4.2222222 0.234845 4.2250000 0.233196 4.2277778 0.232371 4.2305556 0.229897 4.2333333 0.229897 4.2361111 0.232371 4.2388889 0.232371 4.2416667 0.230722 4.2444444 0.229072 4.2472222 0.226598 4.2500000 0.227423 4.2527778 0.228247 4.2555556 0.229072 4.2583333 0.229072 4.2611111 0.225773 4.2638889 0.226598 4.2666667 0.226598 4.2694444 0.228247 4.2722222 0.228247 4.2750000 0.226598 4.2777778 0.227423 4.2805556 0.225773 4.2833333 0.229072 4.2861111 0.229072 4.2888889 0.231546 4.2916667 0.234021 4.2974444 0.300000 4.5581111 0.300000 4.5611111 0.245567 4.5638889 0.245567 4.5666667 0.246392 4.5694444 0.248041 4.5722222 0.248041 4.5750000 0.248041 4.5777778 0.245567 4.5805556 0.245567 4.5833333 0.247216 4.5861111 0.248041 4.5888889 0.249691 4.5916667 0.249691 4.5944444 0.251340 4.5972222 0.248041 4.6000000 0.250515 4.6027778 0.254639 4.6055556 0.257938 4.6083333 0.257938 4.6111111 0.257113 4.6138889 0.256289 4.6166667 0.257938 4.6194444 0.261237 4.6222222 0.262062 4.6250000 0.262887 4.6277778 0.263711 4.6305556 0.263711 4.6333333 0.264536 4.6361111 0.267010 4.6388889 0.266186 4.6416667 0.266186 4.6444444 0.262887 4.6472222 0.261237 4.6500000 0.260412 4.6527778 0.262062 4.6555556 0.264536 4.6583333 0.260412 4.6611111 0.260412 4.6638889 0.258763 4.6666667 0.261237 4.6694444 0.265361 4.6722222 0.267010 4.6750000 0.263711 4.6777778 0.257938 4.6805556 0.254639 4.6833333 0.252990 4.6861111 0.250515 4.6888889 0.249691 4.6916667 0.247216 4.6944444 0.245567 4.6972222 0.246392 4.7000000 0.247216 4.7027778 0.245567 4.7055556 0.245567 4.7083333 0.244742 4.7111111 0.243918 4.7138889 0.243093 4.7166667 0.243918 4.7194444 0.244742 4.7222222 0.247216 4.7250000 0.246392 4.7277778 0.244742 4.7305556 0.243093 4.7333333 0.243093 4.7361111 0.243093 4.7388889 0.244742 4.7416667 0.243918 4.7444444 0.243093 4.7472222 0.241443 4.7500000 0.243918 4.7527778 0.243918 4.7555556 0.243918 4.7583333 0.243918 4.7611111 0.243093 4.7638889 0.241443 4.7666667 0.239794 4.7694444 0.238969 4.7722222 0.233196 4.7750000 0.226598 4.7777778 0.220825 4.7805556 0.218351 4.7833333 0.214227 4.7861111 0.211753 4.7888889 0.216701 4.7916667 0.231546 4.7944444 0.253814 4.7972222 0.277732 4.8000000 0.310722 4.8027778 0.349485 4.8055556 0.395670 4.8083333 0.433608 4.8111111 0.455876 4.8138889 0.451753 4.8166667 0.427835 4.8194444 0.373402 4.8222222 0.303299 4.8250000 0.251340 4.8277778 0.226598 4.8305556 0.222474 4.8333333 0.229897 4.8361111 0.237320 4.8388889 0.240619 4.8416667 0.240619 4.8444444 0.238969 4.8472222 0.237320 4.8500000 0.237320 4.8527778 0.238144 4.8555556 0.238969 4.8583333 0.239794 4.8611111 0.238969 4.8638889 0.236495 4.8666667 0.236495 4.8694444 0.238144 4.8722222 0.238969 4.8750000 0.238969 4.8777778 0.236495 4.8805556 0.234845 4.8833333 0.236495 4.8861111 0.236495 4.8888889 0.235670 4.8916667 0.236495 4.8944444 0.234845 4.8972222 0.232371 4.9000000 0.234021 4.9027778 0.234845 4.9055556 0.237320 4.9083333 0.234845 4.9111111 0.234845 4.9138889 0.234021 4.9166667 0.234021 4.9194444 0.234845 4.9222222 0.235670 4.9250000 0.235670 4.9277778 0.234845 4.9305556 0.233196 4.9333333 0.235670 4.9361111 0.236495 4.9388889 0.238144 4.9416667 0.238144 4.9444444 0.237320 4.9472222 0.235670 4.9500000 0.236495 4.9527778 0.238969 4.9555556 0.238969 4.9583333 0.238969 4.9611111 0.238144 4.9638889 0.236495 4.9666667 0.238969 4.9694444 0.235670 4.9722222 0.238144 4.9750000 0.238969 4.9777778 0.237320 4.9805556 0.235670 4.9833333 0.235670 4.9861111 0.236495 4.9888889 0.238144 4.9916667 0.238144 4.9944444 0.236495 4.9972222 0.234845 5.0000000 0.235670 5.0027778 0.236495 5.0055556 0.238144 5.0083333 0.237320 5.0111111 0.236495 5.0138889 0.235670 5.0166667 0.237320 5.0194444 0.237320 5.0222222 0.238969 5.0250000 0.238969 5.0277778 0.239794 5.0305556 0.235670 5.0333333 0.239794 5.0361111 0.239794 5.0388889 0.240619 5.0416667 0.238144 5.0444444 0.237320 5.0472222 0.234021 5.0500000 0.235670 5.0527778 0.238144 5.0555556 0.238144 5.0583333 0.238969 5.0611111 0.236495 5.0638889 0.235670 5.0666667 0.235670 5.0694444 0.235670 5.0722222 0.235670 5.0750000 0.238144 5.0777778 0.236495 5.0805556 0.234845 5.0833333 0.237320 5.0861111 0.238969 5.0888889 0.238144 5.0916667 0.238144 5.0944444 0.235670 5.0972222 0.233196 5.1000000 0.238144 5.1027778 0.238969 5.1055556 0.240619 5.1083333 0.238144 5.1141111 0.300000 5.2108889 0.300000 5.2138889 0.251340 5.2166667 0.252990 5.2194444 0.253814 5.2222222 0.254639 5.2250000 0.253814 5.2277778 0.252165 5.2305556 0.248866 5.2333333 0.249691 5.2361111 0.252990 5.2388889 0.255464 5.2416667 0.255464 5.2444444 0.254639 5.2472222 0.252990 5.2500000 0.252990 5.2527778 0.255464 5.2555556 0.256289 5.2583333 0.256289 5.2611111 0.256289 5.2638889 0.253814 5.2666667 0.256289 5.2694444 0.259588 5.2722222 0.261237 5.2750000 0.261237 5.2777778 0.258763 5.2805556 0.258763 5.2833333 0.259588 5.2861111 0.264536 5.2888889 0.263711 5.2916667 0.259588 5.2944444 0.257938 5.2972222 0.262062 5.3000000 0.266186 5.3027778 0.265361 5.3055556 0.263711 5.3083333 0.262062 5.3111111 0.260412 5.3138889 0.260412 5.3166667 0.259588 5.3194444 0.258763 5.3222222 0.255464 5.3250000 0.252990 5.3277778 0.248041 5.3305556 0.247216 5.3333333 0.247216 5.3361111 0.248866 5.3388889 0.245567 5.3416667 0.243918 5.3444444 0.243093 5.3472222 0.240619 5.3500000 0.239794 5.3527778 0.240619 5.3555556 0.242268 5.3583333 0.241443 5.3611111 0.238144 5.3638889 0.236495 5.3666667 0.238144 5.3694444 0.238969 5.3722222 0.239794 5.3750000 0.239794 5.3777778 0.238969 5.3805556 0.237320 5.3833333 0.240619 5.3861111 0.242268 5.3888889 0.241443 5.3916667 0.241443 5.3944444 0.242268 5.3972222 0.239794 5.4000000 0.242268 5.4027778 0.242268 5.4055556 0.243918 5.4083333 0.241443 5.4111111 0.242268 5.4138889 0.238144 5.4166667 0.239794 5.4194444 0.238144 5.4222222 0.234021 5.4250000 0.229072 5.4277778 0.221649 5.4305556 0.214227 5.4333333 0.214227 5.4361111 0.209278 5.4388889 0.205979 5.4416667 0.210928 5.4444444 0.226598 5.4472222 0.249691 5.4500000 0.276907 5.4527778 0.304124 5.4555556 0.342887 5.4583333 0.384124 5.4611111 0.421237 5.4638889 0.439381 5.4666667 0.444330 5.4694444 0.421237 5.4722222 0.365979 5.4750000 0.295876 5.4777778 0.244742 5.4805556 0.220825 5.4833333 0.222474 5.4861111 0.231546 5.4888889 0.238144 5.4916667 0.239794 5.4944444 0.236495 5.4972222 0.234021 5.5000000 0.237320 5.5027778 0.235670 5.5055556 0.238144 5.5083333 0.236495 5.5111111 0.234845 5.5138889 0.233196 5.5166667 0.235670 5.5194444 0.237320 5.5222222 0.236495 5.5250000 0.236495 5.5277778 0.234845 5.5305556 0.234021 5.5333333 0.233196 5.5361111 0.234021 5.5388889 0.235670 5.5416667 0.235670 5.5444444 0.234845 5.5472222 0.234021 5.5500000 0.235670 5.5527778 0.236495 5.5555556 0.235670 5.5583333 0.236495 5.5611111 0.232371 5.5638889 0.230722 5.5666667 0.233196 5.5694444 0.232371 5.5722222 0.235670 5.5750000 0.235670 5.5777778 0.235670 5.5805556 0.234021 5.5833333 0.234021 5.5861111 0.235670 5.5888889 0.238144 5.5916667 0.237320 5.5944444 0.234845 5.5972222 0.234021 5.6000000 0.235670 5.6027778 0.234021 5.6055556 0.235670 5.6083333 0.234845 5.6111111 0.232371 5.6138889 0.231546 5.6166667 0.233196 5.6194444 0.236495 5.6222222 0.236495 5.6250000 0.237320 5.6277778 0.234021 5.6305556 0.234021 5.6333333 0.234845 5.6361111 0.235670 5.6388889 0.237320 5.6416667 0.238144 5.6444444 0.234845 5.6472222 0.234845 5.6500000 0.236495 5.6527778 0.237320 5.6555556 0.238144 5.6583333 0.236495 5.6611111 0.235670 5.6638889 0.234021 5.6666667 0.234021 5.6694444 0.236495 5.6722222 0.237320 5.6750000 0.234845 5.6777778 0.235670 5.6805556 0.234021 5.6833333 0.234845 5.6861111 0.236495 5.6888889 0.237320 5.6916667 0.236495 5.6944444 0.234845 5.6972222 0.233196 5.7000000 0.234021 5.7027778 0.235670 5.7055556 0.237320 5.7083333 0.237320 5.7111111 0.236495 5.7138889 0.233196 5.7166667 0.234845 5.7194444 0.234021 5.7222222 0.235670 5.7250000 0.234021 5.7277778 0.233196 5.7305556 0.229897 5.7333333 0.230722 5.7361111 0.233196 5.7388889 0.234021 5.7416667 0.233196 5.7444444 0.233196 5.7472222 0.231546 5.7500000 0.234021 5.7527778 0.235670 5.7555556 0.237320 5.7583333 0.236495 5.7611111 0.234845 5.7668889 0.300000 6.2053333 0.300000 6.2083333 0.243093 6.2111111 0.241443 6.2138889 0.240619 6.2166667 0.240619 6.2194444 0.239794 6.2222222 0.243093 6.2250000 0.241443 6.2277778 0.242268 6.2305556 0.240619 6.2333333 0.241443 6.2361111 0.240619 6.2388889 0.243093 6.2416667 0.244742 6.2444444 0.245567 6.2472222 0.245567 6.2500000 0.248866 6.2527778 0.249691 6.2555556 0.250515 6.2583333 0.249691 6.2611111 0.251340 6.2638889 0.249691 6.2666667 0.252990 6.2694444 0.254639 6.2722222 0.256289 6.2750000 0.257938 6.2777778 0.257938 6.2805556 0.257113 6.2833333 0.256289 6.2861111 0.257938 6.2888889 0.257938 6.2916667 0.257113 6.2944444 0.253814 6.2972222 0.252165 6.3000000 0.253814 6.3027778 0.255464 6.3055556 0.257938 6.3083333 0.254639 6.3111111 0.252165 6.3138889 0.247216 6.3166667 0.250515 6.3194444 0.251340 6.3222222 0.255464 6.3250000 0.256289 6.3277778 0.255464 6.3305556 0.252990 6.3333333 0.250515 6.3361111 0.248866 6.3388889 0.248041 6.3416667 0.247216 6.3444444 0.242268 6.3472222 0.238969 6.3500000 0.239794 6.3527778 0.239794 6.3555556 0.239794 6.3583333 0.238969 6.3611111 0.238969 6.3638889 0.238969 6.3666667 0.237320 6.3694444 0.240619 6.3722222 0.238144 6.3750000 0.238144 6.3777778 0.234021 6.3805556 0.230722 6.3833333 0.233196 6.3861111 0.234021 6.3888889 0.236495 6.3916667 0.237320 6.3944444 0.234021 6.3972222 0.231546 6.4000000 0.233196 6.4027778 0.234845 6.4055556 0.234845 6.4083333 0.234845 6.4111111 0.232371 6.4138889 0.229072 6.4166667 0.227423 6.4194444 0.224948 6.4222222 0.219175 6.4250000 0.220000 6.4277778 0.214227 6.4305556 0.205979 6.4333333 0.205155 6.4361111 0.213402 6.4388889 0.230722 6.4416667 0.249691 6.4444444 0.268660 6.4472222 0.296701 6.4500000 0.336289 6.4527778 0.380000 6.4555556 0.417938 6.4583333 0.439381 6.4611111 0.445979 6.4638889 0.430309 6.4666667 0.392371 6.4694444 0.337113 6.4722222 0.288454 6.4750000 0.252990 6.4777778 0.229897 6.4805556 0.217526 6.4833333 0.209278 6.4861111 0.211753 6.4888889 0.217526 6.4916667 0.223299 6.4944444 0.225773 6.4972222 0.225773 6.5000000 0.228247 6.5027778 0.230722 6.5055556 0.232371 6.5083333 0.232371 6.5111111 0.231546 6.5138889 0.230722 6.5166667 0.229897 6.5194444 0.230722 6.5222222 0.229072 6.5250000 0.229072 6.5277778 0.227423 6.5305556 0.225773 6.5333333 0.225773 6.5361111 0.229072 6.5388889 0.229072 6.5416667 0.229072 6.5444444 0.226598 6.5472222 0.226598 6.5500000 0.227423 6.5527778 0.229897 6.5555556 0.229072 6.5583333 0.229072 6.5611111 0.229897 6.5638889 0.226598 6.5666667 0.226598 6.5694444 0.229072 6.5722222 0.228247 6.5750000 0.228247 6.5777778 0.226598 6.5805556 0.226598 6.5833333 0.228247 6.5861111 0.229072 6.5888889 0.229897 6.5916667 0.229072 6.5944444 0.229072 6.5972222 0.227423 6.6000000 0.230722 6.6027778 0.229072 6.6055556 0.229897 6.6083333 0.229072 6.6111111 0.227423 6.6138889 0.227423 6.6166667 0.229072 6.6194444 0.229072 6.6222222 0.231546 6.6250000 0.229897 6.6277778 0.229072 6.6305556 0.224948 6.6333333 0.226598 6.6361111 0.226598 6.6388889 0.229072 6.6416667 0.229072 6.6444444 0.227423 6.6472222 0.227423 6.6500000 0.228247 6.6527778 0.229072 6.6555556 0.231546 6.6583333 0.231546 6.6611111 0.229897 6.6638889 0.229897 6.6666667 0.230722 6.6694444 0.233196 6.6722222 0.233196 6.6750000 0.231546 6.6777778 0.231546 6.6805556 0.229897 6.6833333 0.229072 6.6861111 0.233196 6.6888889 0.233196 6.6916667 0.233196 6.6944444 0.233196 6.6972222 0.229072 6.7000000 0.231546 6.7027778 0.232371 6.7055556 0.231546 6.7083333 0.229072 6.7111111 0.226598 6.7138889 0.223299 6.7166667 0.224124 6.7194444 0.225773 6.7222222 0.224948 6.7250000 0.224124 6.7277778 0.223299 6.7305556 0.220000 6.7333333 0.218351 6.7361111 0.221649 6.7388889 0.219175 6.7416667 0.217526 6.7444444 0.218351 6.7472222 0.215052 6.7500000 0.217526 6.7527778 0.220000 6.7555556 0.219175 6.7613333 0.300000 7.0497778 0.300000 7.0527778 0.241443 7.0555556 0.243918 7.0583333 0.243093 7.0611111 0.241443 7.0638889 0.241443 7.0666667 0.241443 7.0694444 0.243918 7.0722222 0.243918 7.0750000 0.243093 7.0777778 0.239794 7.0805556 0.238969 7.0833333 0.242268 7.0861111 0.245567 7.0888889 0.247216 7.0916667 0.248041 7.0944444 0.251340 7.0972222 0.249691 7.1000000 0.251340 7.1027778 0.250515 7.1055556 0.252990 7.1083333 0.254639 7.1111111 0.257113 7.1138889 0.254639 7.1166667 0.256289 7.1194444 0.257113 7.1222222 0.258763 7.1250000 0.259588 7.1277778 0.257938 7.1305556 0.256289 7.1333333 0.257113 7.1361111 0.257113 7.1388889 0.258763 7.1416667 0.257113 7.1444444 0.253814 7.1472222 0.253814 7.1500000 0.254639 7.1527778 0.252990 7.1555556 0.253814 7.1583333 0.257938 7.1611111 0.259588 7.1638889 0.259588 7.1666667 0.257113 7.1694444 0.252990 7.1722222 0.252165 7.1750000 0.250515 7.1777778 0.247216 7.1805556 0.244742 7.1833333 0.241443 7.1861111 0.242268 7.1888889 0.241443 7.1916667 0.241443 7.1944444 0.238144 7.1972222 0.236495 7.2000000 0.237320 7.2027778 0.240619 7.2055556 0.242268 7.2083333 0.240619 7.2111111 0.239794 7.2138889 0.238969 7.2166667 0.238969 7.2194444 0.239794 7.2222222 0.240619 7.2250000 0.239794 7.2277778 0.238969 7.2305556 0.236495 7.2333333 0.236495 7.2361111 0.239794 7.2388889 0.240619 7.2416667 0.237320 7.2444444 0.236495 7.2472222 0.234845 7.2500000 0.234845 7.2527778 0.236495 7.2555556 0.237320 7.2583333 0.234845 7.2611111 0.229897 7.2638889 0.223299 7.2666667 0.217526 7.2694444 0.215052 7.2722222 0.212577 7.2750000 0.207629 7.2777778 0.203505 7.2805556 0.212577 7.2833333 0.232371 7.2861111 0.257938 7.2888889 0.282680 7.2916667 0.317320 7.2944444 0.358557 7.2972222 0.398969 7.3000000 0.433608 7.3027778 0.446804 7.3055556 0.436907 7.3083333 0.395670 7.3111111 0.330515 7.3138889 0.266186 7.3166667 0.225773 7.3194444 0.213402 7.3222222 0.218351 7.3250000 0.223299 7.3277778 0.228247 7.3305556 0.231546 7.3333333 0.231546 7.3361111 0.231546 7.3388889 0.234021 7.3416667 0.234845 7.3444444 0.233196 7.3472222 0.229897 7.3500000 0.228247 7.3527778 0.231546 7.3555556 0.231546 7.3583333 0.231546 7.3611111 0.231546 7.3638889 0.229072 7.3666667 0.230722 7.3694444 0.232371 7.3722222 0.233196 7.3750000 0.230722 7.3777778 0.232371 7.3805556 0.230722 7.3833333 0.234021 7.3861111 0.234845 7.3888889 0.236495 7.3916667 0.234021 7.3944444 0.234021 7.3972222 0.234021 7.4000000 0.234021 7.4027778 0.234845 7.4055556 0.234021 7.4083333 0.234021 7.4111111 0.234021 7.4138889 0.232371 7.4166667 0.234845 7.4194444 0.232371 7.4222222 0.234021 7.4250000 0.234845 7.4277778 0.233196 7.4305556 0.232371 7.4333333 0.231546 7.4361111 0.233196 7.4388889 0.234021 7.4416667 0.234845 7.4444444 0.233196 7.4472222 0.231546 7.4500000 0.233196 7.4527778 0.231546 7.4555556 0.232371 7.4583333 0.233196 7.4611111 0.233196 7.4638889 0.232371 7.4666667 0.233196 7.4694444 0.234021 7.4722222 0.234845 7.4750000 0.233196 7.4777778 0.233196 7.4805556 0.234021 7.4833333 0.234845 7.4861111 0.235670 7.4888889 0.234845 7.4916667 0.235670 7.4944444 0.234845 7.4972222 0.230722 7.5000000 0.231546 7.5027778 0.233196 7.5055556 0.234021 7.5083333 0.234021 7.5111111 0.231546 7.5138889 0.230722 7.5166667 0.232371 7.5194444 0.234845 7.5222222 0.234021 7.5250000 0.233196 7.5277778 0.231546 7.5305556 0.228247 7.5333333 0.231546 7.5361111 0.231546 7.5388889 0.234021 7.5416667 0.233196 7.5444444 0.230722 7.5472222 0.229072 7.5500000 0.229897 7.5527778 0.232371 7.5555556 0.232371 7.5583333 0.233196 7.5611111 0.231546 7.5638889 0.229897 7.5666667 0.229897 7.5694444 0.230722 7.5722222 0.232371 7.5750000 0.232371 7.5777778 0.230722 7.5805556 0.229072 7.5833333 0.229897 7.5861111 0.230722 7.5888889 0.233196 7.5916667 0.231546 7.5944444 0.232371 7.5972222 0.232371 7.6000000 0.236495 7.6057778 0.300000 7.8608889 0.300000 7.8638889 0.244742 7.8666667 0.247216 7.8694444 0.246392 7.8722222 0.248041 7.8750000 0.247216 7.8777778 0.247216 7.8805556 0.243093 7.8833333 0.244742 7.8861111 0.247216 7.8888889 0.248866 7.8916667 0.247216 7.8944444 0.247216 7.8972222 0.243918 7.9000000 0.245567 7.9027778 0.247216 7.9055556 0.248866 7.9083333 0.248866 7.9111111 0.248866 7.9138889 0.251340 7.9166667 0.253814 7.9194444 0.257938 7.9222222 0.258763 7.9250000 0.258763 7.9277778 0.257938 7.9305556 0.257113 7.9333333 0.260412 7.9361111 0.263711 7.9388889 0.262062 7.9416667 0.262062 7.9444444 0.264536 7.9472222 0.263711 7.9500000 0.262887 7.9527778 0.262062 7.9555556 0.262062 7.9583333 0.261237 7.9611111 0.259588 7.9638889 0.257938 7.9666667 0.260412 7.9694444 0.261237 7.9722222 0.259588 7.9750000 0.261237 7.9777778 0.262062 7.9805556 0.263711 7.9833333 0.267835 7.9861111 0.263711 7.9888889 0.259588 7.9916667 0.257113 7.9944444 0.255464 7.9972222 0.252165 8.0000000 0.250515 8.0027778 0.249691 8.0055556 0.249691 8.0083333 0.247216 8.0111111 0.245567 8.0138889 0.242268 8.0166667 0.242268 8.0194444 0.244742 8.0222222 0.244742 8.0250000 0.244742 8.0277778 0.243918 8.0305556 0.242268 8.0333333 0.242268 8.0361111 0.243093 8.0388889 0.244742 8.0416667 0.243093 8.0444444 0.241443 8.0472222 0.238969 8.0500000 0.242268 8.0527778 0.243093 8.0555556 0.244742 8.0583333 0.244742 8.0611111 0.244742 8.0638889 0.241443 8.0666667 0.241443 8.0694444 0.243093 8.0722222 0.241443 8.0750000 0.234845 8.0777778 0.225773 8.0805556 0.220825 8.0833333 0.216701 8.0861111 0.213402 8.0888889 0.210103 8.0916667 0.217526 8.0944444 0.234845 8.0972222 0.257938 8.1000000 0.288454 8.1027778 0.323918 8.1055556 0.370103 8.1083333 0.412990 8.1111111 0.444330 8.1138889 0.452577 8.1166667 0.431134 8.1194444 0.377526 8.1222222 0.303299 8.1250000 0.246392 8.1277778 0.222474 8.1305556 0.220000 8.1333333 0.232371 8.1361111 0.239794 8.1388889 0.241443 8.1416667 0.239794 8.1444444 0.237320 8.1472222 0.236495 8.1500000 0.237320 8.1527778 0.238969 8.1555556 0.238969 8.1583333 0.238144 8.1611111 0.236495 8.1638889 0.234845 8.1666667 0.236495 8.1694444 0.237320 8.1722222 0.236495 8.1750000 0.238144 8.1777778 0.235670 8.1805556 0.233196 8.1833333 0.233196 8.1861111 0.235670 8.1888889 0.236495 8.1916667 0.236495 8.1944444 0.235670 8.1972222 0.232371 8.2000000 0.234021 8.2027778 0.235670 8.2055556 0.236495 8.2083333 0.236495 8.2111111 0.234845 8.2138889 0.235670 8.2166667 0.234845 8.2194444 0.237320 8.2222222 0.238144 8.2250000 0.237320 8.2277778 0.236495 8.2305556 0.234021 8.2333333 0.236495 8.2361111 0.237320 8.2388889 0.238144 8.2416667 0.237320 8.2444444 0.234845 8.2472222 0.234845 8.2500000 0.236495 8.2527778 0.238144 8.2555556 0.238969 8.2583333 0.239794 8.2611111 0.236495 8.2638889 0.234845 8.2666667 0.236495 8.2694444 0.236495 8.2722222 0.238969 8.2750000 0.238144 8.2777778 0.238969 8.2805556 0.238144 8.2833333 0.238144 8.2861111 0.238969 8.2888889 0.241443 8.2916667 0.239794 8.2944444 0.237320 8.2972222 0.238144 8.3000000 0.238969 8.3027778 0.237320 8.3055556 0.239794 8.3083333 0.238969 8.3111111 0.238144 8.3138889 0.235670 8.3166667 0.237320 8.3194444 0.238144 8.3222222 0.237320 8.3250000 0.238969 8.3277778 0.238144 8.3305556 0.237320 8.3333333 0.236495 8.3361111 0.236495 8.3388889 0.238969 8.3416667 0.238144 8.3444444 0.238144 8.3472222 0.237320 8.3500000 0.237320 8.3527778 0.237320 8.3555556 0.237320 8.3583333 0.238144 8.3611111 0.235670 8.3638889 0.234845 8.3666667 0.236495 8.3694444 0.236495 8.3722222 0.238144 8.3750000 0.238144 8.3777778 0.236495 8.3805556 0.236495 8.3833333 0.235670 8.3861111 0.238969 8.3888889 0.239794 8.3916667 0.239794 8.3944444 0.238144 8.3972222 0.236495 8.4000000 0.242268 8.4027778 0.243093 8.4055556 0.246392 8.4083333 0.246392 8.4111111 0.245567 8.4168889 0.300000 8.6497778 0.300000 8.6527778 0.249691 8.6555556 0.252165 8.6583333 0.252990 8.6611111 0.252165 8.6638889 0.249691 8.6666667 0.248866 8.6694444 0.250515 8.6722222 0.250515 8.6750000 0.248866 8.6777778 0.248041 8.6805556 0.248041 8.6833333 0.248866 8.6861111 0.251340 8.6888889 0.250515 8.6916667 0.251340 8.6944444 0.248041 8.6972222 0.248866 8.7000000 0.252165 8.7027778 0.256289 8.7055556 0.260412 8.7083333 0.257938 8.7111111 0.260412 8.7138889 0.258763 8.7166667 0.262887 8.7194444 0.262887 8.7222222 0.264536 8.7250000 0.265361 8.7277778 0.267010 8.7305556 0.267835 8.7333333 0.267835 8.7361111 0.270309 8.7388889 0.271134 8.7416667 0.270309 8.7444444 0.266186 8.7472222 0.264536 8.7500000 0.265361 8.7527778 0.265361 8.7555556 0.265361 8.7583333 0.265361 8.7611111 0.264536 8.7638889 0.262887 8.7666667 0.265361 8.7694444 0.270309 8.7722222 0.271959 8.7750000 0.269485 8.7777778 0.260412 8.7805556 0.257938 8.7833333 0.257938 8.7861111 0.255464 8.7888889 0.254639 8.7916667 0.252990 8.7944444 0.250515 8.7972222 0.250515 8.8000000 0.248041 8.8027778 0.249691 8.8055556 0.250515 8.8083333 0.251340 8.8111111 0.250515 8.8138889 0.248041 8.8166667 0.248866 8.8194444 0.248866 8.8222222 0.250515 8.8250000 0.250515 8.8277778 0.249691 8.8305556 0.248041 8.8333333 0.246392 8.8361111 0.247216 8.8388889 0.247216 8.8416667 0.247216 8.8444444 0.246392 8.8472222 0.243918 8.8500000 0.244742 8.8527778 0.246392 8.8555556 0.248041 8.8583333 0.247216 8.8611111 0.243093 8.8638889 0.238969 8.8666667 0.234845 8.8694444 0.229897 8.8722222 0.226598 8.8750000 0.223299 8.8777778 0.215876 8.8805556 0.212577 8.8833333 0.220000 8.8861111 0.238969 8.8888889 0.261237 8.8916667 0.285155 8.8944444 0.317320 8.8972222 0.361856 8.9000000 0.408041 8.9027778 0.435258 8.9055556 0.442680 8.9083333 0.421237 8.9111111 0.374227 8.9138889 0.309897 8.9166667 0.255464 8.9194444 0.229072 8.9222222 0.224124 8.9250000 0.231546 8.9277778 0.236495 8.9305556 0.239794 8.9333333 0.241443 8.9361111 0.241443 8.9388889 0.243093 8.9416667 0.242268 8.9444444 0.242268 8.9472222 0.240619 8.9500000 0.243093 8.9527778 0.243918 8.9555556 0.243918 8.9583333 0.244742 8.9611111 0.244742 8.9638889 0.241443 8.9666667 0.243093 8.9694444 0.243918 8.9722222 0.244742 8.9750000 0.243918 8.9777778 0.242268 8.9805556 0.239794 8.9833333 0.240619 8.9861111 0.239794 8.9888889 0.242268 8.9916667 0.243093 8.9944444 0.239794 8.9972222 0.240619 9.0000000 0.242268 9.0027778 0.241443 9.0055556 0.242268 9.0083333 0.241443 9.0111111 0.242268 9.0138889 0.240619 9.0166667 0.244742 9.0194444 0.244742 9.0222222 0.245567 9.0250000 0.243918 9.0277778 0.242268 9.0305556 0.242268 9.0333333 0.243093 9.0361111 0.244742 9.0388889 0.243093 9.0416667 0.241443 9.0444444 0.241443 9.0472222 0.238969 9.0500000 0.241443 9.0527778 0.242268 9.0555556 0.243093 9.0583333 0.239794 9.0611111 0.239794 9.0638889 0.238969 9.0666667 0.239794 9.0694444 0.241443 9.0722222 0.243093 9.0750000 0.243093 9.0777778 0.243093 9.0805556 0.243918 9.0833333 0.244742 9.0861111 0.246392 9.0888889 0.244742 9.0916667 0.243093 9.0944444 0.242268 9.0972222 0.242268 9.1000000 0.241443 9.1027778 0.241443 9.1055556 0.240619 9.1083333 0.242268 9.1111111 0.240619 9.1138889 0.239794 9.1166667 0.243093 9.1194444 0.243093 9.1222222 0.245567 9.1250000 0.242268 9.1277778 0.243093 9.1305556 0.241443 9.1333333 0.242268 9.1361111 0.243918 9.1388889 0.244742 9.1416667 0.242268 9.1444444 0.239794 9.1472222 0.237320 9.1500000 0.236495 9.1527778 0.241443 9.1555556 0.240619 9.1583333 0.241443 9.1611111 0.238969 9.1638889 0.236495 9.1666667 0.238969 9.1694444 0.238969 9.1722222 0.242268 9.1750000 0.243093 9.1777778 0.239794 9.1805556 0.239794 9.1833333 0.240619 9.1861111 0.243093 9.1888889 0.245567 9.1916667 0.245567 9.1944444 0.245567 9.1972222 0.244742 9.2000000 0.248041 9.2057778 0.300000 9.4220000 0.300000 9.4250000 0.249691 9.4277778 0.248866 9.4305556 0.247216 9.4333333 0.248866 9.4361111 0.250515 9.4388889 0.251340 9.4416667 0.250515 9.4444444 0.248041 9.4472222 0.246392 9.4500000 0.246392 9.4527778 0.249691 9.4555556 0.248866 9.4583333 0.252165 9.4611111 0.248041 9.4638889 0.246392 9.4666667 0.247216 9.4694444 0.252165 9.4722222 0.253814 9.4750000 0.257113 9.4777778 0.257113 9.4805556 0.256289 9.4833333 0.257113 9.4861111 0.258763 9.4888889 0.262062 9.4916667 0.263711 9.4944444 0.263711 9.4972222 0.261237 9.5000000 0.263711 9.5027778 0.266186 9.5055556 0.266186 9.5083333 0.265361 9.5111111 0.265361 9.5138889 0.262062 9.5166667 0.260412 9.5194444 0.262062 9.5222222 0.262887 9.5250000 0.261237 9.5277778 0.258763 9.5305556 0.256289 9.5333333 0.257113 9.5361111 0.259588 9.5388889 0.264536 9.5416667 0.264536 9.5444444 0.259588 9.5472222 0.253814 9.5500000 0.254639 9.5527778 0.254639 9.5555556 0.251340 9.5583333 0.248866 9.5611111 0.246392 9.5638889 0.243918 9.5666667 0.243918 9.5694444 0.246392 9.5722222 0.248041 9.5750000 0.248866 9.5777778 0.248041 9.5805556 0.245567 9.5833333 0.245567 9.5861111 0.246392 9.5888889 0.246392 9.5916667 0.244742 9.5944444 0.243093 9.5972222 0.242268 9.6000000 0.242268 9.6027778 0.242268 9.6055556 0.243093 9.6083333 0.242268 9.6111111 0.239794 9.6138889 0.240619 9.6166667 0.242268 9.6194444 0.241443 9.6222222 0.243093 9.6250000 0.243093 9.6277778 0.242268 9.6305556 0.239794 9.6333333 0.237320 9.6361111 0.233196 9.6388889 0.229897 9.6416667 0.227423 9.6444444 0.222474 9.6472222 0.214227 9.6500000 0.210928 9.6527778 0.219175 9.6555556 0.235670 9.6583333 0.257113 9.6611111 0.281031 9.6638889 0.314021 9.6666667 0.359381 9.6694444 0.401443 9.6722222 0.428660 9.6750000 0.437732 9.6777778 0.418763 9.6805556 0.367629 9.6833333 0.304948 9.6861111 0.257938 9.6888889 0.231546 9.6916667 0.222474 9.6944444 0.223299 9.6972222 0.228247 9.7000000 0.234845 9.7027778 0.238144 9.7055556 0.238969 9.7083333 0.238144 9.7111111 0.238144 9.7138889 0.235670 9.7166667 0.234021 9.7194444 0.237320 9.7222222 0.236495 9.7250000 0.236495 9.7277778 0.236495 9.7305556 0.236495 9.7333333 0.238969 9.7361111 0.238969 9.7388889 0.240619 9.7416667 0.237320 9.7444444 0.237320 9.7472222 0.236495 9.7500000 0.238969 9.7527778 0.238969 9.7555556 0.239794 9.7583333 0.238144 9.7611111 0.236495 9.7638889 0.235670 9.7666667 0.235670 9.7694444 0.236495 9.7722222 0.236495 9.7750000 0.234845 9.7777778 0.235670 9.7805556 0.234021 9.7833333 0.233196 9.7861111 0.235670 9.7888889 0.234845 9.7916667 0.235670 9.7944444 0.233196 9.7972222 0.233196 9.8000000 0.234021 9.8027778 0.238144 9.8055556 0.237320 9.8083333 0.235670 9.8111111 0.234845 9.8138889 0.234845 9.8166667 0.235670 9.8194444 0.235670 9.8222222 0.236495 9.8250000 0.233196 9.8277778 0.234021 9.8305556 0.233196 9.8333333 0.234845 9.8361111 0.235670 9.8388889 0.234845 9.8416667 0.235670 9.8444444 0.234021 9.8472222 0.233196 9.8500000 0.233196 9.8527778 0.235670 9.8555556 0.235670 9.8583333 0.234845 9.8611111 0.234021 9.8638889 0.234021 9.8666667 0.234845 9.8694444 0.237320 9.8722222 0.238969 9.8750000 0.237320 9.8777778 0.236495 9.8805556 0.234845 9.8833333 0.235670 9.8861111 0.237320 9.8888889 0.237320 9.8916667 0.236495 9.8944444 0.235670 9.8972222 0.235670 9.9000000 0.234021 9.9027778 0.234021 9.9055556 0.233196 9.9083333 0.231546 9.9111111 0.230722 9.9138889 0.229072 9.9166667 0.229072 9.9194444 0.229897 9.9222222 0.230722 9.9250000 0.229072 9.9277778 0.226598 9.9305556 0.223299 9.9333333 0.224948 9.9361111 0.227423 9.9388889 0.229897 9.9416667 0.228247 9.9444444 0.225773 9.9472222 0.227423 9.9500000 0.226598 9.9527778 0.229897 9.9555556 0.229897 9.9583333 0.229897 9.9611111 0.229072 9.9638889 0.229072 9.9666667 0.231546 9.9694444 0.231546 9.9722222 0.236495 9.9780000 0.300000 10.2608889 0.300000 10.2638889 0.247216 10.2666667 0.248041 10.2694444 0.248866 10.2722222 0.251340 10.2750000 0.251340 10.2777778 0.249691 10.2805556 0.248866 10.2833333 0.250515 10.2861111 0.253814 10.2888889 0.254639 10.2916667 0.256289 10.2944444 0.254639 10.2972222 0.254639 10.3000000 0.257113 10.3027778 0.260412 10.3055556 0.260412 10.3083333 0.261237 10.3111111 0.260412 10.3138889 0.261237 10.3166667 0.262887 10.3194444 0.264536 10.3222222 0.266186 10.3250000 0.266186 10.3277778 0.265361 10.3305556 0.264536 10.3333333 0.263711 10.3361111 0.263711 10.3388889 0.264536 10.3416667 0.263711 10.3444444 0.263711 10.3472222 0.262062 10.3500000 0.262062 10.3527778 0.260412 10.3555556 0.265361 10.3583333 0.263711 10.3611111 0.262062 10.3638889 0.257938 10.3666667 0.261237 10.3694444 0.265361 10.3722222 0.268660 10.3750000 0.266186 10.3777778 0.262887 10.3805556 0.257113 10.3833333 0.254639 10.3861111 0.253814 10.3888889 0.252990 10.3916667 0.249691 10.3944444 0.247216 10.3972222 0.248041 10.4000000 0.244742 10.4027778 0.246392 10.4055556 0.244742 10.4083333 0.247216 10.4111111 0.246392 10.4138889 0.247216 10.4166667 0.246392 10.4194444 0.246392 10.4222222 0.248866 10.4250000 0.249691 10.4277778 0.247216 10.4305556 0.247216 10.4333333 0.245567 10.4361111 0.247216 10.4388889 0.247216 10.4416667 0.245567 10.4444444 0.245567 10.4472222 0.240619 10.4500000 0.241443 10.4527778 0.245567 10.4555556 0.246392 10.4583333 0.246392 10.4611111 0.244742 10.4638889 0.242268 10.4666667 0.243918 10.4694444 0.243093 10.4722222 0.241443 10.4750000 0.236495 10.4777778 0.229897 10.4805556 0.225773 10.4833333 0.222474 10.4861111 0.220000 10.4888889 0.215876 10.4916667 0.215052 10.4944444 0.224948 10.4972222 0.246392 10.5000000 0.272784 10.5027778 0.301649 10.5055556 0.341237 10.5083333 0.384948 10.5111111 0.422062 10.5138889 0.445979 10.5166667 0.454227 10.5194444 0.437732 10.5222222 0.386598 10.5250000 0.319794 10.5277778 0.262062 10.5305556 0.229897 10.5333333 0.224948 10.5361111 0.230722 10.5388889 0.237320 10.5416667 0.240619 10.5444444 0.239794 10.5472222 0.238144 10.5500000 0.237320 10.5527778 0.241443 10.5555556 0.241443 10.5583333 0.238969 10.5611111 0.238144 10.5638889 0.236495 10.5666667 0.237320 10.5694444 0.239794 10.5722222 0.238969 10.5750000 0.238969 10.5777778 0.239794 10.5805556 0.237320 10.5833333 0.238969 10.5861111 0.238144 10.5888889 0.239794 10.5916667 0.238969 10.5944444 0.237320 10.5972222 0.238144 10.6000000 0.239794 10.6027778 0.240619 10.6055556 0.240619 10.6083333 0.241443 10.6111111 0.241443 10.6138889 0.238969 10.6166667 0.239794 10.6194444 0.241443 10.6222222 0.242268 10.6250000 0.242268 10.6277778 0.242268 10.6305556 0.240619 10.6333333 0.240619 10.6361111 0.240619 10.6388889 0.242268 10.6416667 0.241443 10.6444444 0.239794 10.6472222 0.238969 10.6500000 0.240619 10.6527778 0.242268 10.6555556 0.241443 10.6583333 0.242268 10.6611111 0.241443 10.6638889 0.238969 10.6666667 0.238144 10.6694444 0.240619 10.6722222 0.242268 10.6750000 0.243093 10.6777778 0.242268 10.6805556 0.238969 10.6833333 0.238969 10.6861111 0.241443 10.6888889 0.242268 10.6916667 0.243093 10.6944444 0.240619 10.6972222 0.238969 10.7000000 0.239794 10.7027778 0.240619 10.7055556 0.242268 10.7083333 0.241443 10.7111111 0.239794 10.7138889 0.239794 10.7166667 0.238969 10.7194444 0.239794 10.7222222 0.242268 10.7250000 0.242268 10.7277778 0.240619 10.7305556 0.240619 10.7333333 0.241443 10.7361111 0.243093 10.7388889 0.242268 10.7416667 0.243093 10.7444444 0.241443 10.7472222 0.238969 10.7500000 0.239794 10.7527778 0.241443 10.7555556 0.240619 10.7583333 0.239794 10.7611111 0.239794 10.7638889 0.237320 10.7666667 0.236495 10.7694444 0.238144 10.7722222 0.238969 10.7750000 0.238144 10.7777778 0.236495 10.7805556 0.234845 10.7833333 0.238144 10.7861111 0.236495 10.7888889 0.237320 10.7916667 0.238969 10.7944444 0.236495 10.7972222 0.236495 10.8000000 0.237320 10.8027778 0.238969 10.8055556 0.240619 10.8083333 0.242268 10.8111111 0.244742 10.8168889 0.300000 11.1164444 0.300000 11.1194444 0.251340 11.1222222 0.252990 11.1250000 0.251340 11.1277778 0.251340 11.1305556 0.248866 11.1333333 0.250515 11.1361111 0.252990 11.1388889 0.253814 11.1416667 0.254639 11.1444444 0.253814 11.1472222 0.256289 11.1500000 0.259588 11.1527778 0.262062 11.1555556 0.260412 11.1583333 0.260412 11.1611111 0.260412 11.1638889 0.259588 11.1666667 0.263711 11.1694444 0.263711 11.1722222 0.264536 11.1750000 0.267010 11.1777778 0.267010 11.1805556 0.265361 11.1833333 0.266186 11.1861111 0.267835 11.1888889 0.266186 11.1916667 0.265361 11.1944444 0.264536 11.1972222 0.262887 11.2000000 0.262887 11.2027778 0.267010 11.2055556 0.267010 11.2083333 0.265361 11.2111111 0.262887 11.2138889 0.263711 11.2166667 0.267835 11.2194444 0.270309 11.2222222 0.271134 11.2250000 0.266186 11.2277778 0.259588 11.2305556 0.256289 11.2333333 0.254639 11.2361111 0.253814 11.2388889 0.252990 11.2416667 0.250515 11.2444444 0.248866 11.2472222 0.246392 11.2500000 0.247216 11.2527778 0.246392 11.2555556 0.248866 11.2583333 0.246392 11.2611111 0.245567 11.2638889 0.243918 11.2666667 0.244742 11.2694444 0.245567 11.2722222 0.246392 11.2750000 0.247216 11.2777778 0.243918 11.2805556 0.243093 11.2833333 0.243918 11.2861111 0.245567 11.2888889 0.244742 11.2916667 0.245567 11.2944444 0.243918 11.2972222 0.243918 11.3000000 0.244742 11.3027778 0.244742 11.3055556 0.245567 11.3083333 0.244742 11.3111111 0.243093 11.3138889 0.238144 11.3166667 0.234845 11.3194444 0.229072 11.3222222 0.227423 11.3250000 0.225773 11.3277778 0.225773 11.3305556 0.221649 11.3333333 0.220825 11.3361111 0.215876 11.3388889 0.209278 11.3416667 0.205155 11.3444444 0.210103 11.3472222 0.219175 11.3500000 0.238144 11.3527778 0.258763 11.3555556 0.280206 11.3583333 0.309897 11.3611111 0.347010 11.3638889 0.386598 11.3666667 0.422062 11.3694444 0.441856 11.3722222 0.446804 11.3750000 0.420412 11.3777778 0.370103 11.3805556 0.302474 11.3833333 0.252990 11.3861111 0.228247 11.3888889 0.225773 11.3916667 0.228247 11.3944444 0.236495 11.3972222 0.237320 11.4000000 0.238969 11.4027778 0.238969 11.4055556 0.238969 11.4083333 0.240619 11.4111111 0.240619 11.4138889 0.238969 11.4166667 0.236495 11.4194444 0.239794 11.4222222 0.240619 11.4250000 0.239794 11.4277778 0.239794 11.4305556 0.238144 11.4333333 0.236495 11.4361111 0.240619 11.4388889 0.239794 11.4416667 0.241443 11.4444444 0.238144 11.4472222 0.237320 11.4500000 0.238144 11.4527778 0.241443 11.4555556 0.241443 11.4583333 0.240619 11.4611111 0.239794 11.4638889 0.237320 11.4666667 0.238969 11.4694444 0.241443 11.4722222 0.242268 11.4750000 0.241443 11.4777778 0.239794 11.4805556 0.237320 11.4833333 0.239794 11.4861111 0.241443 11.4888889 0.241443 11.4916667 0.239794 11.4944444 0.236495 11.4972222 0.235670 11.5000000 0.238144 11.5027778 0.241443 11.5055556 0.239794 11.5083333 0.240619 11.5111111 0.241443 11.5138889 0.239794 11.5166667 0.239794 11.5194444 0.241443 11.5222222 0.243093 11.5250000 0.243093 11.5277778 0.239794 11.5305556 0.240619 11.5333333 0.238144 11.5361111 0.241443 11.5388889 0.240619 11.5416667 0.239794 11.5444444 0.239794 11.5472222 0.238969 11.5500000 0.240619 11.5527778 0.241443 11.5555556 0.240619 11.5583333 0.239794 11.5611111 0.236495 11.5638889 0.237320 11.5666667 0.239794 11.5694444 0.241443 11.5722222 0.244742 11.5750000 0.240619 11.5777778 0.240619 11.5805556 0.236495 11.5833333 0.237320 11.5861111 0.238144 11.5888889 0.240619 11.5916667 0.240619 11.5944444 0.239794 11.5972222 0.238144 11.6000000 0.239794 11.6027778 0.241443 11.6055556 0.240619 11.6083333 0.242268 11.6111111 0.240619 11.6138889 0.238969 11.6166667 0.238969 11.6194444 0.239794 11.6222222 0.238969 11.6250000 0.237320 11.6277778 0.235670 11.6305556 0.236495 11.6333333 0.237320 11.6361111 0.238969 11.6388889 0.238969 11.6416667 0.239794 11.6444444 0.239794 11.6472222 0.235670 11.6500000 0.238144 11.6527778 0.238969 11.6555556 0.241443 11.6583333 0.239794 11.6611111 0.240619 11.6638889 0.238969 11.6666667 0.242268 11.6724444 0.300000 11.9386667 0.300000 11.9416667 0.248041 11.9444444 0.244742 11.9472222 0.244742 11.9500000 0.245567 11.9527778 0.248866 11.9555556 0.248866 11.9583333 0.248041 11.9611111 0.245567 11.9638889 0.247216 11.9666667 0.248041 11.9694444 0.250515 11.9722222 0.252990 11.9750000 0.253814 11.9777778 0.256289 11.9805556 0.257113 11.9833333 0.256289 11.9861111 0.257113 11.9888889 0.257938 11.9916667 0.257113 11.9944444 0.258763 11.9972222 0.257938 12.0000000 0.260412 12.0027778 0.262062 12.0055556 0.266186 12.0083333 0.265361 12.0111111 0.262887 12.0138889 0.261237 12.0166667 0.262887 12.0194444 0.262887 12.0222222 0.262062 12.0250000 0.262887 12.0277778 0.260412 12.0305556 0.260412 12.0333333 0.262062 12.0361111 0.261237 12.0388889 0.258763 12.0416667 0.258763 12.0444444 0.257938 12.0472222 0.261237 12.0500000 0.263711 12.0527778 0.266186 12.0555556 0.264536 12.0583333 0.260412 12.0611111 0.256289 12.0638889 0.253814 12.0666667 0.253814 12.0694444 0.255464 12.0722222 0.255464 12.0750000 0.252165 12.0777778 0.247216 12.0805556 0.244742 12.0833333 0.243918 12.0861111 0.245567 12.0888889 0.245567 12.0916667 0.244742 12.0944444 0.242268 12.0972222 0.240619 12.1000000 0.242268 12.1027778 0.242268 12.1055556 0.243093 12.1083333 0.242268 12.1111111 0.241443 12.1138889 0.239794 12.1166667 0.240619 12.1194444 0.241443 12.1222222 0.242268 12.1250000 0.243918 12.1277778 0.240619 12.1305556 0.238969 12.1333333 0.238969 12.1361111 0.241443 12.1388889 0.243093 12.1416667 0.242268 12.1444444 0.238969 12.1472222 0.236495 12.1500000 0.232371 12.1527778 0.227423 12.1555556 0.224124 12.1583333 0.219175 12.1611111 0.210928 12.1638889 0.206804 12.1666667 0.209278 12.1694444 0.220000 12.1722222 0.239794 12.1750000 0.257938 12.1777778 0.279381 12.1805556 0.314845 12.1833333 0.359381 12.1861111 0.398969 12.1888889 0.423711 12.1916667 0.431134 12.1944444 0.415464 12.1972222 0.372577 12.2000000 0.315670 12.2027778 0.269485 12.2055556 0.238969 12.2083333 0.222474 12.2111111 0.219175 12.2138889 0.222474 12.2166667 0.227423 12.2194444 0.229897 12.2222222 0.232371 12.2250000 0.232371 12.2277778 0.232371 12.2305556 0.230722 12.2333333 0.234021 12.2361111 0.234845 12.2388889 0.233196 12.2416667 0.232371 12.2444444 0.233196 12.2472222 0.230722 12.2500000 0.234845 12.2527778 0.234845 12.2555556 0.235670 12.2583333 0.234845 12.2611111 0.234845 12.2638889 0.232371 12.2666667 0.234021 12.2694444 0.234021 12.2722222 0.232371 12.2750000 0.234021 12.2777778 0.233196 12.2805556 0.232371 12.2833333 0.232371 12.2861111 0.234021 12.2888889 0.235670 12.2916667 0.235670 12.2944444 0.234021 12.2972222 0.234021 12.3000000 0.234845 12.3027778 0.235670 12.3055556 0.236495 12.3083333 0.235670 12.3111111 0.232371 12.3138889 0.232371 12.3166667 0.232371 12.3194444 0.231546 12.3222222 0.232371 12.3250000 0.233196 12.3277778 0.230722 12.3305556 0.230722 12.3333333 0.230722 12.3361111 0.231546 12.3388889 0.232371 12.3416667 0.231546 12.3444444 0.229897 12.3472222 0.229897 12.3500000 0.230722 12.3527778 0.229897 12.3555556 0.230722 12.3583333 0.232371 12.3611111 0.232371 12.3638889 0.231546 12.3666667 0.232371 12.3694444 0.232371 12.3722222 0.234021 12.3750000 0.233196 12.3777778 0.233196 12.3805556 0.229897 12.3833333 0.230722 12.3861111 0.232371 12.3888889 0.234021 12.3916667 0.233196 12.3944444 0.231546 12.3972222 0.230722 12.4000000 0.232371 12.4027778 0.232371 12.4055556 0.234021 12.4083333 0.232371 12.4111111 0.231546 12.4138889 0.230722 12.4166667 0.232371 12.4194444 0.234021 12.4222222 0.235670 12.4250000 0.234021 12.4277778 0.231546 12.4305556 0.230722 12.4333333 0.231546 12.4361111 0.231546 12.4388889 0.234021 12.4416667 0.231546 12.4444444 0.229072 12.4472222 0.225773 12.4500000 0.227423 12.4527778 0.227423 12.4555556 0.228247 12.4583333 0.228247 12.4611111 0.227423 12.4638889 0.225773 12.4666667 0.228247 12.4694444 0.227423 12.4722222 0.229072 12.4750000 0.227423 12.4777778 0.226598 12.4805556 0.226598 12.4833333 0.227423 12.4861111 0.228247 12.4888889 0.230722 12.4946667 0.300000 12.7664444 0.300000 12.7694444 0.242268 12.7722222 0.244742 12.7750000 0.243093 12.7777778 0.242268 12.7805556 0.242268 12.7833333 0.241443 12.7861111 0.243918 12.7888889 0.244742 12.7916667 0.245567 12.7944444 0.243918 12.7972222 0.241443 12.8000000 0.241443 12.8027778 0.245567 12.8055556 0.248041 12.8083333 0.248041 12.8111111 0.248041 12.8138889 0.247216 12.8166667 0.250515 12.8194444 0.250515 12.8222222 0.253814 12.8250000 0.256289 12.8277778 0.253814 12.8305556 0.252990 12.8333333 0.256289 12.8361111 0.261237 12.8388889 0.262062 12.8416667 0.262062 12.8444444 0.259588 12.8472222 0.257938 12.8500000 0.258763 12.8527778 0.259588 12.8555556 0.258763 12.8583333 0.257938 12.8611111 0.256289 12.8638889 0.255464 12.8666667 0.252165 12.8694444 0.253814 12.8722222 0.254639 12.8750000 0.257113 12.8777778 0.257938 12.8805556 0.257113 12.8833333 0.254639 12.8861111 0.251340 12.8888889 0.250515 12.8916667 0.249691 12.8944444 0.244742 12.8972222 0.241443 12.9000000 0.242268 12.9027778 0.242268 12.9055556 0.242268 12.9083333 0.241443 12.9111111 0.238969 12.9138889 0.238969 12.9166667 0.240619 12.9194444 0.239794 12.9222222 0.241443 12.9250000 0.239794 12.9277778 0.238144 12.9305556 0.236495 12.9333333 0.237320 12.9361111 0.238144 12.9388889 0.241443 12.9416667 0.238969 12.9444444 0.236495 12.9472222 0.235670 12.9500000 0.235670 12.9527778 0.238969 12.9555556 0.240619 12.9583333 0.238969 12.9611111 0.237320 12.9638889 0.236495 12.9666667 0.237320 12.9694444 0.238144 12.9722222 0.238969 12.9750000 0.237320 12.9777778 0.233196 12.9805556 0.226598 12.9833333 0.223299 12.9861111 0.220825 12.9888889 0.220000 12.9916667 0.213402 12.9944444 0.208454 12.9972222 0.211753 13.0000000 0.225773 13.0027778 0.246392 13.0055556 0.269485 13.0083333 0.295876 13.0111111 0.330515 13.0138889 0.370928 13.0166667 0.408866 13.0194444 0.434433 13.0222222 0.440206 13.0250000 0.423711 13.0277778 0.380000 13.0305556 0.318144 13.0333333 0.265361 13.0361111 0.235670 13.0388889 0.224124 13.0416667 0.220000 13.0444444 0.222474 13.0472222 0.225773 13.0500000 0.229897 13.0527778 0.231546 13.0555556 0.233196 13.0583333 0.231546 13.0611111 0.231546 13.0638889 0.230722 13.0666667 0.234021 13.0694444 0.234845 13.0722222 0.236495 13.0750000 0.234845 13.0777778 0.234021 13.0805556 0.230722 13.0833333 0.232371 13.0861111 0.234021 13.0888889 0.234021 13.0916667 0.233196 13.0944444 0.233196 13.0972222 0.228247 13.1000000 0.230722 13.1027778 0.232371 13.1055556 0.233196 13.1083333 0.231546 13.1111111 0.229072 13.1138889 0.227423 13.1166667 0.228247 13.1194444 0.231546 13.1222222 0.230722 13.1250000 0.229072 13.1277778 0.231546 13.1305556 0.229072 13.1333333 0.229897 13.1361111 0.230722 13.1388889 0.230722 13.1416667 0.231546 13.1444444 0.229897 13.1472222 0.229897 13.1500000 0.230722 13.1527778 0.232371 13.1555556 0.232371 13.1583333 0.232371 13.1611111 0.230722 13.1638889 0.229072 13.1666667 0.230722 13.1694444 0.231546 13.1722222 0.234845 13.1750000 0.233196 13.1777778 0.231546 13.1805556 0.229072 13.1833333 0.230722 13.1861111 0.230722 13.1888889 0.231546 13.1916667 0.230722 13.1944444 0.229897 13.1972222 0.227423 13.2000000 0.229072 13.2027778 0.229897 13.2055556 0.231546 13.2083333 0.230722 13.2111111 0.229897 13.2138889 0.227423 13.2166667 0.229072 13.2194444 0.229072 13.2222222 0.229897 13.2250000 0.230722 13.2277778 0.231546 13.2305556 0.229897 13.2333333 0.229072 13.2361111 0.229897 13.2388889 0.231546 13.2416667 0.233196 13.2444444 0.233196 13.2472222 0.229897 13.2500000 0.231546 13.2527778 0.230722 13.2555556 0.230722 13.2583333 0.230722 13.2611111 0.228247 13.2638889 0.228247 13.2666667 0.227423 13.2694444 0.230722 13.2722222 0.229072 13.2750000 0.225773 13.2777778 0.224948 13.2805556 0.223299 13.2833333 0.223299 13.2861111 0.223299 13.2888889 0.223299 13.2916667 0.223299 13.2944444 0.222474 13.2972222 0.219175 13.3000000 0.220000 13.3027778 0.224124 13.3055556 0.224948 13.3083333 0.224124 13.3111111 0.224948 13.3138889 0.224948 13.3166667 0.227423 13.3224444 0.300000 13.5886667 0.300000 13.5916667 0.244742 13.5944444 0.241443 13.5972222 0.243093 13.6000000 0.243918 13.6027778 0.245567 13.6055556 0.243918 13.6083333 0.243093 13.6111111 0.242268 13.6138889 0.241443 13.6166667 0.242268 13.6194444 0.244742 13.6222222 0.245567 13.6250000 0.245567 13.6277778 0.245567 13.6305556 0.245567 13.6333333 0.249691 13.6361111 0.252990 13.6388889 0.254639 13.6416667 0.253814 13.6444444 0.252990 13.6472222 0.252165 13.6500000 0.254639 13.6527778 0.257113 13.6555556 0.259588 13.6583333 0.260412 13.6611111 0.260412 13.6638889 0.260412 13.6666667 0.261237 13.6694444 0.262887 13.6722222 0.263711 13.6750000 0.262062 13.6777778 0.260412 13.6805556 0.257938 13.6833333 0.257938 13.6861111 0.260412 13.6888889 0.260412 13.6916667 0.258763 13.6944444 0.255464 13.6972222 0.255464 13.7000000 0.260412 13.7027778 0.262062 13.7055556 0.262887 13.7083333 0.256289 13.7111111 0.251340 13.7138889 0.249691 13.7166667 0.246392 13.7194444 0.248041 13.7222222 0.246392 13.7250000 0.245567 13.7277778 0.243093 13.7305556 0.240619 13.7333333 0.239794 13.7361111 0.241443 13.7388889 0.243093 13.7416667 0.243918 13.7444444 0.244742 13.7472222 0.240619 13.7500000 0.241443 13.7527778 0.243093 13.7555556 0.244742 13.7583333 0.241443 13.7611111 0.242268 13.7638889 0.238144 13.7666667 0.238144 13.7694444 0.239794 13.7722222 0.239794 13.7750000 0.242268 13.7777778 0.238969 13.7805556 0.237320 13.7833333 0.239794 13.7861111 0.238969 13.7888889 0.241443 13.7916667 0.238969 13.7944444 0.237320 13.7972222 0.236495 13.8000000 0.236495 13.8027778 0.234021 13.8055556 0.229072 13.8083333 0.223299 13.8111111 0.220000 13.8138889 0.214227 13.8166667 0.208454 13.8194444 0.213402 13.8222222 0.228247 13.8250000 0.249691 13.8277778 0.274433 13.8305556 0.301649 13.8333333 0.342887 13.8361111 0.388247 13.8388889 0.425361 13.8416667 0.446804 13.8444444 0.449278 13.8472222 0.416289 13.8500000 0.359381 13.8527778 0.295052 13.8555556 0.247216 13.8583333 0.224948 13.8611111 0.221649 13.8638889 0.227423 13.8666667 0.234845 13.8694444 0.237320 13.8722222 0.237320 13.8750000 0.236495 13.8777778 0.234845 13.8805556 0.234021 13.8833333 0.233196 13.8861111 0.234845 13.8888889 0.232371 13.8916667 0.235670 13.8944444 0.234845 13.8972222 0.233196 13.9000000 0.233196 13.9027778 0.234845 13.9055556 0.236495 13.9083333 0.236495 13.9111111 0.233196 13.9138889 0.233196 13.9166667 0.234021 13.9194444 0.236495 13.9222222 0.237320 13.9250000 0.236495 13.9277778 0.233196 13.9305556 0.232371 13.9333333 0.234021 13.9361111 0.234845 13.9388889 0.236495 13.9416667 0.234845 13.9444444 0.232371 13.9472222 0.233196 13.9500000 0.233196 13.9527778 0.234845 13.9555556 0.235670 13.9583333 0.234845 13.9611111 0.234845 13.9638889 0.233196 13.9666667 0.232371 13.9694444 0.234021 13.9722222 0.236495 13.9750000 0.234845 13.9777778 0.234021 13.9805556 0.234845 13.9833333 0.236495 13.9861111 0.236495 13.9888889 0.238144 13.9916667 0.238144 13.9944444 0.237320 13.9972222 0.234845 14.0000000 0.236495 14.0027778 0.235670 14.0055556 0.236495 14.0083333 0.237320 14.0111111 0.235670 14.0138889 0.234021 14.0166667 0.234021 14.0194444 0.235670 14.0222222 0.239794 14.0250000 0.238144 14.0277778 0.236495 14.0305556 0.234021 14.0333333 0.234021 14.0361111 0.235670 14.0388889 0.237320 14.0416667 0.238144 14.0444444 0.236495 14.0472222 0.234845 14.0500000 0.237320 14.0527778 0.238969 14.0555556 0.239794 14.0583333 0.239794 14.0611111 0.238144 14.0638889 0.236495 14.0666667 0.238144 14.0694444 0.238144 14.0722222 0.239794 14.0750000 0.238969 14.0777778 0.238144 14.0805556 0.234021 14.0833333 0.234845 14.0861111 0.233196 14.0888889 0.238969 14.0916667 0.236495 14.0944444 0.234021 14.0972222 0.232371 14.1000000 0.234021 14.1027778 0.234845 14.1055556 0.238144 14.1083333 0.237320 14.1111111 0.236495 14.1138889 0.233196 14.1166667 0.236495 14.1194444 0.238144 14.1222222 0.238969 14.1250000 0.239794 14.1277778 0.239794 14.1305556 0.242268 14.1333333 0.241443 14.1361111 0.247216 14.1388889 0.248866 14.1446667 0.300000 14.3831111 0.300000 14.3861111 0.247216 14.3888889 0.248866 14.3916667 0.249691 14.3944444 0.248041 14.3972222 0.245567 14.4000000 0.247216 14.4027778 0.248866 14.4055556 0.249691 14.4083333 0.250515 14.4111111 0.251340 14.4138889 0.247216 14.4166667 0.248866 14.4194444 0.250515 14.4222222 0.254639 14.4250000 0.255464 14.4277778 0.257113 14.4305556 0.258763 14.4333333 0.261237 14.4361111 0.262062 14.4388889 0.262887 14.4416667 0.262062 14.4444444 0.262062 14.4472222 0.260412 14.4500000 0.262062 14.4527778 0.262887 14.4555556 0.266186 14.4583333 0.266186 14.4611111 0.267010 14.4638889 0.265361 14.4666667 0.267835 14.4694444 0.267010 14.4722222 0.268660 14.4750000 0.267010 14.4777778 0.265361 14.4805556 0.262887 14.4833333 0.262887 14.4861111 0.263711 14.4888889 0.263711 14.4916667 0.263711 14.4944444 0.262062 14.4972222 0.258763 14.5000000 0.259588 14.5027778 0.262062 14.5055556 0.266186 14.5083333 0.269485 14.5111111 0.267835 14.5138889 0.262887 14.5166667 0.258763 14.5194444 0.257938 14.5222222 0.256289 14.5250000 0.254639 14.5277778 0.249691 14.5305556 0.247216 14.5333333 0.246392 14.5361111 0.246392 14.5388889 0.245567 14.5416667 0.245567 14.5444444 0.246392 14.5472222 0.244742 14.5500000 0.243918 14.5527778 0.244742 14.5555556 0.247216 14.5583333 0.244742 14.5611111 0.243093 14.5638889 0.241443 14.5666667 0.242268 14.5694444 0.241443 14.5722222 0.242268 14.5750000 0.243093 14.5777778 0.243918 14.5805556 0.241443 14.5833333 0.242268 14.5861111 0.243918 14.5888889 0.243918 14.5916667 0.243918 14.5944444 0.241443 14.5972222 0.234021 14.6000000 0.228247 14.6027778 0.224948 14.6055556 0.222474 14.6083333 0.217526 14.6111111 0.210928 14.6138889 0.210103 14.6166667 0.223299 14.6194444 0.241443 14.6222222 0.265361 14.6250000 0.294227 14.6277778 0.330515 14.6305556 0.371753 14.6333333 0.411340 14.6361111 0.435258 14.6388889 0.436082 14.6416667 0.405567 14.6444444 0.352784 14.6472222 0.288454 14.6500000 0.243918 14.6527778 0.226598 14.6555556 0.226598 14.6583333 0.232371 14.6611111 0.237320 14.6638889 0.238144 14.6666667 0.238144 14.6694444 0.238969 14.6722222 0.239794 14.6750000 0.240619 14.6777778 0.238969 14.6805556 0.238144 14.6833333 0.238969 14.6861111 0.240619 14.6888889 0.242268 14.6916667 0.241443 14.6944444 0.239794 14.6972222 0.237320 14.7000000 0.237320 14.7027778 0.238969 14.7055556 0.239794 14.7083333 0.239794 14.7111111 0.237320 14.7138889 0.236495 14.7166667 0.235670 14.7194444 0.237320 14.7222222 0.238144 14.7250000 0.238144 14.7277778 0.237320 14.7305556 0.235670 14.7333333 0.237320 14.7361111 0.238144 14.7388889 0.238969 14.7416667 0.239794 14.7444444 0.238144 14.7472222 0.236495 14.7500000 0.239794 14.7527778 0.240619 14.7555556 0.242268 14.7583333 0.241443 14.7611111 0.241443 14.7638889 0.238969 14.7666667 0.239794 14.7694444 0.242268 14.7722222 0.240619 14.7750000 0.239794 14.7777778 0.239794 14.7805556 0.238144 14.7833333 0.238144 14.7861111 0.241443 14.7888889 0.241443 14.7916667 0.238969 14.7944444 0.238144 14.7972222 0.237320 14.8000000 0.236495 14.8027778 0.238969 14.8055556 0.238969 14.8083333 0.240619 14.8111111 0.238969 14.8138889 0.238144 14.8166667 0.239794 14.8194444 0.241443 14.8222222 0.243093 14.8250000 0.240619 14.8277778 0.241443 14.8305556 0.239794 14.8333333 0.240619 14.8361111 0.243093 14.8388889 0.244742 14.8416667 0.244742 14.8444444 0.241443 14.8472222 0.241443 14.8500000 0.242268 14.8527778 0.243918 14.8555556 0.242268 14.8583333 0.242268 14.8611111 0.241443 14.8638889 0.239794 14.8666667 0.240619 14.8694444 0.239794 14.8722222 0.239794 14.8750000 0.239794 14.8777778 0.238969 14.8805556 0.238144 14.8833333 0.237320 14.8861111 0.239794 14.8888889 0.242268 14.8916667 0.240619 14.8944444 0.239794 14.8972222 0.237320 14.9000000 0.238144 14.9027778 0.238969 14.9055556 0.240619 14.9083333 0.239794 14.9111111 0.238144 14.9138889 0.237320 14.9166667 0.238144 14.9194444 0.240619 14.9222222 0.241443 14.9250000 0.241443 14.9277778 0.241443 14.9305556 0.242268 14.9333333 0.242268 14.9391111 0.300000 15.1803333 0.300000 15.1833333 0.244742 15.1861111 0.246392 15.1888889 0.246392 15.1916667 0.247216 15.1944444 0.246392 15.1972222 0.244742 15.2000000 0.247216 15.2027778 0.247216 15.2055556 0.248866 15.2083333 0.248866 15.2111111 0.247216 15.2138889 0.245567 15.2166667 0.243918 15.2194444 0.246392 15.2222222 0.249691 15.2250000 0.249691 15.2277778 0.252165 15.2305556 0.252165 15.2333333 0.255464 15.2361111 0.256289 15.2388889 0.256289 15.2416667 0.257113 15.2444444 0.257113 15.2472222 0.255464 15.2500000 0.254639 15.2527778 0.257113 15.2555556 0.259588 15.2583333 0.261237 15.2611111 0.262062 15.2638889 0.259588 15.2666667 0.260412 15.2694444 0.262062 15.2722222 0.260412 15.2750000 0.262887 15.2777778 0.260412 15.2805556 0.259588 15.2833333 0.260412 15.2861111 0.263711 15.2888889 0.263711 15.2916667 0.262062 15.2944444 0.259588 15.2972222 0.257938 15.3000000 0.260412 15.3027778 0.264536 15.3055556 0.262887 15.3083333 0.257938 15.3111111 0.252990 15.3138889 0.248866 15.3166667 0.248866 15.3194444 0.245567 15.3222222 0.244742 15.3250000 0.242268 15.3277778 0.242268 15.3305556 0.240619 15.3333333 0.241443 15.3361111 0.243918 15.3388889 0.243918 15.3416667 0.244742 15.3444444 0.242268 15.3472222 0.240619 15.3500000 0.240619 15.3527778 0.243093 15.3555556 0.243093 15.3583333 0.242268 15.3611111 0.242268 15.3638889 0.240619 15.3666667 0.242268 15.3694444 0.242268 15.3722222 0.243093 15.3750000 0.241443 15.3777778 0.241443 15.3805556 0.238969 15.3833333 0.238144 15.3861111 0.235670 15.3888889 0.229897 15.3916667 0.224948 15.3944444 0.221649 15.3972222 0.217526 15.4000000 0.210928 15.4027778 0.205979 15.4055556 0.215876 15.4083333 0.231546 15.4111111 0.244742 15.4138889 0.257113 15.4166667 0.275258 15.4194444 0.299175 15.4222222 0.333814 15.4250000 0.377526 15.4277778 0.412165 15.4305556 0.436082 15.4333333 0.452577 15.4361111 0.460000 15.4388889 0.445979 15.4416667 0.413814 15.4444444 0.368454 15.4472222 0.317320 15.4500000 0.275258 15.4527778 0.243093 15.4555556 0.228247 15.4583333 0.223299 15.4611111 0.224948 15.4638889 0.229897 15.4666667 0.231546 15.4694444 0.234845 15.4722222 0.238144 15.4750000 0.238969 15.4777778 0.234845 15.4805556 0.234021 15.4833333 0.234021 15.4861111 0.232371 15.4888889 0.234021 15.4916667 0.233196 15.4944444 0.234021 15.4972222 0.233196 15.5000000 0.234845 15.5027778 0.235670 15.5055556 0.237320 15.5083333 0.236495 15.5111111 0.233196 15.5138889 0.230722 15.5166667 0.233196 15.5194444 0.234021 15.5222222 0.235670 15.5250000 0.237320 15.5277778 0.234845 15.5305556 0.234845 15.5333333 0.234021 15.5361111 0.235670 15.5388889 0.232371 15.5416667 0.233196 15.5444444 0.232371 15.5472222 0.232371 15.5500000 0.234845 15.5527778 0.236495 15.5555556 0.234845 15.5583333 0.233196 15.5611111 0.230722 15.5638889 0.228247 15.5666667 0.231546 15.5694444 0.233196 15.5722222 0.232371 15.5750000 0.234021 15.5777778 0.232371 15.5805556 0.231546 15.5833333 0.232371 15.5861111 0.234021 15.5888889 0.233196 15.5916667 0.235670 15.5944444 0.235670 15.5972222 0.234021 15.6000000 0.235670 15.6027778 0.235670 15.6055556 0.235670 15.6083333 0.234845 15.6111111 0.230722 15.6138889 0.230722 15.6166667 0.231546 15.6194444 0.232371 15.6222222 0.234845 15.6250000 0.234845 15.6277778 0.234021 15.6305556 0.231546 15.6333333 0.231546 15.6361111 0.234021 15.6388889 0.234021 15.6416667 0.236495 15.6444444 0.235670 15.6472222 0.232371 15.6500000 0.234845 15.6527778 0.235670 15.6555556 0.237320 15.6583333 0.238144 15.6611111 0.235670 15.6638889 0.233196 15.6666667 0.230722 15.6694444 0.231546 15.6722222 0.231546 15.6750000 0.231546 15.6777778 0.228247 15.6805556 0.223299 15.6833333 0.224948 15.6861111 0.223299 15.6888889 0.224124 15.6916667 0.226598 15.6944444 0.224948 15.6972222 0.223299 15.7000000 0.221649 15.7027778 0.224948 15.7055556 0.224124 15.7083333 0.225773 15.7111111 0.224948 15.7138889 0.222474 15.7166667 0.224948 15.7194444 0.227423 15.7222222 0.230722 15.7250000 0.231546 15.7277778 0.230722 15.7305556 0.232371 15.7363333 0.300000 15.9720000 0.300000 15.9750000 0.242268 15.9777778 0.239794 15.9805556 0.241443 15.9833333 0.242268 15.9861111 0.243918 15.9888889 0.243918 15.9916667 0.241443 15.9944444 0.241443 15.9972222 0.242268 16.0000000 0.242268 16.0027778 0.244742 16.0055556 0.243918 16.0083333 0.243918 16.0111111 0.245567 16.0138889 0.242268 16.0166667 0.248041 16.0194444 0.250515 16.0222222 0.252165 16.0250000 0.254639 16.0277778 0.253814 16.0305556 0.252990 16.0333333 0.254639 16.0361111 0.255464 16.0388889 0.257938 16.0416667 0.260412 16.0444444 0.258763 16.0472222 0.257938 16.0500000 0.260412 16.0527778 0.262887 16.0555556 0.262887 16.0583333 0.260412 16.0611111 0.257938 16.0638889 0.257113 16.0666667 0.254639 16.0694444 0.257113 16.0722222 0.259588 16.0750000 0.257938 16.0777778 0.256289 16.0805556 0.253814 16.0833333 0.255464 16.0861111 0.258763 16.0888889 0.261237 16.0916667 0.262062 16.0944444 0.259588 16.0972222 0.255464 16.1000000 0.253814 16.1027778 0.253814 16.1055556 0.252165 16.1083333 0.248041 16.1111111 0.244742 16.1138889 0.241443 16.1166667 0.241443 16.1194444 0.241443 16.1222222 0.240619 16.1250000 0.240619 16.1277778 0.238144 16.1305556 0.237320 16.1333333 0.240619 16.1361111 0.241443 16.1388889 0.242268 16.1416667 0.243093 16.1444444 0.238969 16.1472222 0.238969 16.1500000 0.241443 16.1527778 0.241443 16.1555556 0.242268 16.1583333 0.243093 16.1611111 0.241443 16.1638889 0.241443 16.1666667 0.240619 16.1694444 0.241443 16.1722222 0.241443 16.1750000 0.241443 16.1777778 0.240619 16.1805556 0.238144 16.1833333 0.238969 16.1861111 0.235670 16.1888889 0.229897 16.1916667 0.223299 16.1944444 0.219175 16.1972222 0.213402 16.2000000 0.207629 16.2027778 0.207629 16.2055556 0.218351 16.2083333 0.240619 16.2111111 0.263711 16.2138889 0.292577 16.2166667 0.331340 16.2194444 0.378351 16.2222222 0.419588 16.2250000 0.447629 16.2277778 0.447629 16.2305556 0.417113 16.2333333 0.357732 16.2361111 0.290928 16.2388889 0.242268 16.2416667 0.220825 16.2444444 0.219175 16.2472222 0.223299 16.2500000 0.231546 16.2527778 0.233196 16.2555556 0.234845 16.2583333 0.233196 16.2611111 0.230722 16.2638889 0.234845 16.2666667 0.231546 16.2694444 0.234021 16.2722222 0.235670 16.2750000 0.236495 16.2777778 0.234845 16.2805556 0.233196 16.2833333 0.234845 16.2861111 0.234021 16.2888889 0.235670 16.2916667 0.235670 16.2944444 0.234021 16.2972222 0.231546 16.3000000 0.233196 16.3027778 0.235670 16.3055556 0.237320 16.3083333 0.237320 16.3111111 0.233196 16.3138889 0.235670 16.3166667 0.234021 16.3194444 0.235670 16.3222222 0.237320 16.3250000 0.237320 16.3277778 0.233196 16.3305556 0.234021 16.3333333 0.232371 16.3361111 0.234021 16.3388889 0.234845 16.3416667 0.234021 16.3444444 0.234021 16.3472222 0.233196 16.3500000 0.235670 16.3527778 0.237320 16.3555556 0.236495 16.3583333 0.236495 16.3611111 0.235670 16.3638889 0.233196 16.3666667 0.234021 16.3694444 0.234021 16.3722222 0.235670 16.3750000 0.235670 16.3777778 0.232371 16.3805556 0.232371 16.3833333 0.233196 16.3861111 0.234021 16.3888889 0.232371 16.3916667 0.233196 16.3944444 0.232371 16.3972222 0.231546 16.4000000 0.232371 16.4027778 0.233196 16.4055556 0.234845 16.4083333 0.233196 16.4111111 0.234021 16.4138889 0.234021 16.4166667 0.234845 16.4194444 0.233196 16.4222222 0.237320 16.4250000 0.236495 16.4277778 0.235670 16.4305556 0.232371 16.4333333 0.234845 16.4361111 0.235670 16.4388889 0.237320 16.4416667 0.236495 16.4444444 0.233196 16.4472222 0.233196 16.4500000 0.233196 16.4527778 0.234021 16.4555556 0.232371 16.4583333 0.232371 16.4611111 0.231546 16.4638889 0.228247 16.4666667 0.229072 16.4694444 0.231546 16.4722222 0.230722 16.4750000 0.230722 16.4777778 0.227423 16.4805556 0.227423 16.4833333 0.228247 16.4861111 0.228247 16.4888889 0.228247 16.4916667 0.229072 16.4944444 0.226598 16.4972222 0.226598 16.5000000 0.230722 16.5027778 0.229897 16.5055556 0.232371 16.5083333 0.233196 16.5111111 0.234021 16.5138889 0.232371 16.5166667 0.237320 16.5194444 0.238969 16.5222222 0.242268 16.5280000 0.300000 16.7250000 0.300000)
Vthresh rpeak_threshold 0 0.346763

.include "C:/Users/kadhi/OneDrive/Desktop/amux/verilogLearning/Leaky-Integrate-Fire---SNN-model-on-FPGA/experiments/frontend_optimization/complete_frontend/inverter.spice"
.include "C:/Users/kadhi/OneDrive/Desktop/amux/verilogLearning/Leaky-Integrate-Fire---SNN-model-on-FPGA/experiments/frontend_optimization/complete_frontend/rpeak_detector.spice"

Xrpk ecg_l0 rpeak_threshold rpeak_out vdd vss vbias rpeak_detector

.tran 0.5m 16.7250
.meas tran rpk_rise_3 WHEN V(rpeak_out)=0.45 RISE=1 TD=3.1855556
.meas tran rpk_rise_4 WHEN V(rpeak_out)=0.45 RISE=1 TD=3.9744444
.meas tran rpk_rise_5 WHEN V(rpeak_out)=0.45 RISE=1 TD=4.7911111
.meas tran rpk_rise_6 WHEN V(rpeak_out)=0.45 RISE=1 TD=5.4438889
.meas tran rpk_rise_7 WHEN V(rpeak_out)=0.45 RISE=1 TD=6.4383333
.meas tran rpk_rise_8 WHEN V(rpeak_out)=0.45 RISE=1 TD=7.2827778
.meas tran rpk_rise_9 WHEN V(rpeak_out)=0.45 RISE=1 TD=8.0938889
.meas tran rpk_rise_10 WHEN V(rpeak_out)=0.45 RISE=1 TD=8.8827778
.meas tran rpk_rise_11 WHEN V(rpeak_out)=0.45 RISE=1 TD=9.6550000
.meas tran rpk_rise_12 WHEN V(rpeak_out)=0.45 RISE=1 TD=10.4938889
.meas tran rpk_rise_13 WHEN V(rpeak_out)=0.45 RISE=1 TD=11.3494444
.meas tran rpk_rise_14 WHEN V(rpeak_out)=0.45 RISE=1 TD=12.1716667
.meas tran rpk_rise_15 WHEN V(rpeak_out)=0.45 RISE=1 TD=12.9994444
.meas tran rpk_rise_16 WHEN V(rpeak_out)=0.45 RISE=1 TD=13.8216667
.meas tran rpk_rise_17 WHEN V(rpeak_out)=0.45 RISE=1 TD=14.6161111
.meas tran rpk_rise_18 WHEN V(rpeak_out)=0.45 RISE=1 TD=15.4133333
.meas tran rpk_rise_19 WHEN V(rpeak_out)=0.45 RISE=1 TD=16.2050000

.end
