Integration test v7 - fixed F1/F2
.lib "C:\Users\kadhi\OneDrive\Desktop\amux\verilogLearning\Leaky-Integrate-Fire---SNN-model-on-FPGA\experiments\frontend_optimization\ngspice_frontend\sky130_minimal.lib.spice" tt
.option scale=1.0u method=gear gmin=1e-15
.temp 27

.include "inverter.spice"
.include "delay_timer.spice"
.include "rr_timing.spice"
.include "pwave_predictor.spice"
.include "beat_instability.spice"
.include "pwave_diff.spice"
.include "qrs_width.spice"
.include "qrs_slope.spice"
.include "qrs_symmetry.spice"

Vdd vdd 0 0.9
Vss vss 0 0
Vbias vbias 0 0.3

Vecg_l0 ecg_amp_l0 0 PWL(
+ 0.000000 0.242247
+ 0.002778 0.193881
+ 0.005556 0.369248
+ 0.008333 0.242247
+ 0.011111 0.183713
+ 0.013889 0.369242
+ 0.016667 0.242247
+ 0.019444 0.188043
+ 0.022222 0.369208
+ 0.025000 0.249503
+ 0.027778 0.193910
+ 0.030556 0.369265
+ 0.033333 0.240796
+ 0.036111 0.190968
+ 0.038889 0.369253
+ 0.041667 0.248052
+ 0.044444 0.190979
+ 0.047222 0.369236
+ 0.050000 0.242247
+ 0.052778 0.190985
+ 0.055556 0.369236
+ 0.058333 0.237894
+ 0.061111 0.183707
+ 0.063889 0.369236
+ 0.066667 0.240796
+ 0.069444 0.188054
+ 0.072222 0.369225
+ 0.075000 0.239345
+ 0.077778 0.192419
+ 0.080556 0.369242
+ 0.083333 0.237894
+ 0.086111 0.190951
+ 0.088889 0.369253
+ 0.091667 0.237894
+ 0.094444 0.196772
+ 0.097222 0.369253
+ 0.100000 0.239345
+ 0.102778 0.190974
+ 0.105556 0.369253
+ 0.108333 0.233541
+ 0.111111 0.190939
+ 0.113889 0.369242
+ 0.116667 0.242247
+ 0.119444 0.186603
+ 0.122222 0.369225
+ 0.125000 0.234992
+ 0.127778 0.192402
+ 0.130556 0.369242
+ 0.133333 0.232090
+ 0.136111 0.188003
+ 0.138889 0.369236
+ 0.141667 0.233541
+ 0.144444 0.190939
+ 0.147222 0.369242
+ 0.150000 0.234992
+ 0.152778 0.195298
+ 0.155556 0.369259
+ 0.158333 0.229188
+ 0.161111 0.190917
+ 0.163889 0.369236
+ 0.166667 0.234992
+ 0.169444 0.193842
+ 0.172222 0.369242
+ 0.175000 0.237894
+ 0.177778 0.195304
+ 0.180556 0.369270
+ 0.183333 0.229188
+ 0.186111 0.205427
+ 0.188889 0.369304
+ 0.191667 0.237894
+ 0.194444 0.209820
+ 0.197222 0.369304
+ 0.200000 0.242247
+ 0.202778 0.218555
+ 0.205556 0.369361
+ 0.208333 0.243698
+ 0.211111 0.218549
+ 0.213889 0.369361
+ 0.216667 0.249503
+ 0.219444 0.214202
+ 0.222222 0.369321
+ 0.225000 0.246601
+ 0.227778 0.221468
+ 0.230556 0.369338
+ 0.233333 0.245149
+ 0.236111 0.208397
+ 0.238889 0.369316
+ 0.241667 0.242247
+ 0.244444 0.217075
+ 0.247222 0.369327
+ 0.250000 0.239345
+ 0.252778 0.204039
+ 0.255556 0.369287
+ 0.258333 0.237894
+ 0.261111 0.189466
+ 0.263889 0.369236
+ 0.266667 0.234992
+ 0.269444 0.188037
+ 0.272222 0.369231
+ 0.275000 0.233541
+ 0.277778 0.186581
+ 0.280556 0.369225
+ 0.283333 0.229188
+ 0.286111 0.177846
+ 0.288889 0.369197
+ 0.291667 0.232090
+ 0.294444 0.179308
+ 0.297222 0.369180
+ 0.300000 0.230639
+ 0.302778 0.180771
+ 0.305556 0.369202
+ 0.308333 0.220482
+ 0.311111 0.167643
+ 0.313889 0.369134
+ 0.316667 0.203069
+ 0.319444 0.144364
+ 0.322222 0.369004
+ 0.325000 0.261111
+ 0.327778 0.173731
+ 0.330556 0.392521
+ 0.333333 0.339558
+ 0.336111 0.358342
+ 0.338889 0.393416
+ 0.341667 0.452745
+ 0.344444 0.180074
+ 0.347222 0.370546
+ 0.350000 0.200173
+ 0.352778 0.274890
+ 0.355556 0.369327
+ 0.358333 0.197265
+ 0.361111 0.135698
+ 0.363889 0.369044
+ 0.366667 0.217580
+ 0.369444 0.164747
+ 0.372222 0.369140
+ 0.375000 0.217580
+ 0.377778 0.176378
+ 0.380556 0.369185
+ 0.383333 0.217580
+ 0.386111 0.172002
+ 0.388889 0.369174
+ 0.391667 0.219031
+ 0.394444 0.167666
+ 0.397222 0.369140
+ 0.400000 0.221933
+ 0.402778 0.170574
+ 0.405556 0.369163
+ 0.408333 0.219031
+ 0.411111 0.167660
+ 0.413889 0.369168
+ 0.416667 0.224835
+ 0.419444 0.172031
+ 0.422222 0.369146
+ 0.425000 0.221933
+ 0.427778 0.169129
+ 0.430556 0.369157
+ 0.433333 0.220482
+ 0.436111 0.169123
+ 0.438889 0.369163
+ 0.441667 0.226286
+ 0.444444 0.170585
+ 0.447222 0.369151
+ 0.450000 0.223384
+ 0.452778 0.172059
+ 0.455556 0.369163
+ 0.458333 0.224835
+ 0.461111 0.170568
+ 0.463889 0.369163
+ 0.466667 0.224835
+ 0.469444 0.170574
+ 0.472222 0.369134
+ 0.475000 0.220482
+ 0.477778 0.170585
+ 0.480556 0.369163
+ 0.483333 0.217580
+ 0.486111 0.169112
+ 0.488889 0.369163
+ 0.491667 0.214678
+ 0.494444 0.172002
+ 0.497222 0.369168
+ 0.500000 0.216129
+ 0.502778 0.177835
+ 0.505556 0.369180
+ 0.508333 0.216129
+ 0.511111 0.170534
+ 0.513889 0.369191
+ 0.516667 0.220482
+ 0.519444 0.177812
+ 0.522222 0.369163
+ 0.525000 0.207422
+ 0.527778 0.174876
+ 0.530556 0.369163
+ 0.533333 0.200167
+ 0.536111 0.161771
+ 0.538889 0.369140
+ 0.541667 0.192912
+ 0.544444 0.160309
+ 0.547222 0.369100
+ 0.550000 0.185657
+ 0.552778 0.153020
+ 0.555556 0.369083
+ 0.558333 0.178402
+ 0.561111 0.150089
+ 0.563889 0.369100
+ 0.566667 0.181304
+ 0.569444 0.150089
+ 0.572222 0.369083
+ 0.575000 0.184206
+ 0.577778 0.161749
+ 0.580556 0.369129
+ 0.583333 0.194363
+ 0.586111 0.167575
+ 0.588889 0.369163
+ 0.591667 0.213227
+ 0.594444 0.176355
+ 0.597222 0.369197
+ 0.600000 0.226286
+ 0.602778 0.192385
+ 0.605556 0.369253
+ 0.608333 0.230639
+ 0.611111 0.196732
+ 0.613889 0.369276
+ 0.616667 0.242247
+ 0.619444 0.202570
+ 0.622222 0.369293
+ 0.625000 0.239345
+ 0.627778 0.206941
+ 0.630556 0.369304
+ 0.633333 0.240796
+ 0.636111 0.205473
+ 0.638889 0.369293
+ 0.641667 0.239345
+ 0.644444 0.201125
+ 0.647222 0.369282
+ 0.650000 0.245149
+ 0.652778 0.205490
+ 0.655556 0.369293
+ 0.658333 0.237894
+ 0.661111 0.201114
+ 0.663889 0.369282
+ 0.666667 0.242247
+ 0.669444 0.199668
+ 0.672222 0.369270
+ 0.675000 0.237894
+ 0.677778 0.202570
+ 0.680556 0.369287
+ 0.683333 0.234992
+ 0.686111 0.201097
+ 0.688889 0.369282
+ 0.691667 0.237894
+ 0.694444 0.201097
+ 0.697222 0.369253
+ 0.700000 0.233541
+ 0.702778 0.198200
+ 0.705556 0.369259
+ 0.708333 0.233541
+ 0.711111 0.192368
+ 0.713889 0.369259
+ 0.716667 0.236443
+ 0.719444 0.195293
+ 0.722222 0.369248
+ 0.725000 0.237894
+ 0.727778 0.199668
+ 0.730556 0.369270
+ 0.733333 0.230639
+ 0.736111 0.193830
+ 0.738889 0.369265
+ 0.741667 0.232090
+ 0.744444 0.190934
+ 0.747222 0.369248
+ 0.750000 0.232090
+ 0.752778 0.195298
+ 0.755556 0.369253
+ 0.758333 0.232090
+ 0.761111 0.188026
+ 0.763889 0.369259
+ 0.766667 0.236443
+ 0.769444 0.192385
+ 0.772222 0.369236
+ 0.775000 0.237894
+ 0.777778 0.195298
+ 0.780556 0.369253
+ 0.783333 0.230639
+ 0.786111 0.193830
+ 0.788889 0.369248
+ 0.791667 0.237894
+ 0.794444 0.192396
+ 0.797222 0.369248
+ 0.800000 0.237894
+ 0.802778 0.196766
+ 0.805556 0.369259
+ 0.808333 0.236443
+ 0.811111 0.193847
+ 0.813889 0.369276
+ 0.816667 0.236443
+ 0.819444 0.209820
+ 0.822222 0.369304
+ 0.825000 0.242247
+ 0.827778 0.212756
+ 0.830556 0.369338
+ 0.833333 0.240796
+ 0.836111 0.218538
+ 0.838889 0.369355
+ 0.841667 0.249503
+ 0.844444 0.221451
+ 0.847222 0.369350
+ 0.850000 0.252405
+ 0.852778 0.222947
+ 0.855556 0.369355
+ 0.858333 0.255307
+ 0.861111 0.215681
+ 0.863889 0.369327
+ 0.866667 0.256758
+ 0.869444 0.224376
+ 0.872222 0.369372
+ 0.875000 0.246601
+ 0.877778 0.211311
+ 0.880556 0.369310
+ 0.883333 0.242247
+ 0.886111 0.192402
+ 0.888889 0.369253
+ 0.891667 0.243698
+ 0.894444 0.186609
+ 0.897222 0.369214
+ 0.900000 0.243698
+ 0.902778 0.193864
+ 0.905556 0.369242
+ 0.908333 0.232090
+ 0.911111 0.188026
+ 0.913889 0.369236
+ 0.916667 0.239345
+ 0.919444 0.188043
+ 0.922222 0.369214
+ 0.925000 0.236443
+ 0.927778 0.190968
+ 0.930556 0.369219
+ 0.933333 0.234992
+ 0.936111 0.180777
+ 0.938889 0.369214
+ 0.941667 0.226286
+ 0.944444 0.172014
+ 0.947222 0.369123
+ 0.950000 0.200167
+ 0.952778 0.141474
+ 0.955556 0.369015
+ 0.958333 0.278523
+ 0.961111 0.175267
+ 0.963889 0.392578
+ 0.966667 0.394697
+ 0.969444 0.397724
+ 0.972222 0.393547
+ 0.975000 0.445490
+ 0.977778 0.163914
+ 0.980556 0.370307
+ 0.983333 0.197271
+ 0.986111 0.164730
+ 0.988889 0.369055
+ 0.991667 0.226286
+ 0.994444 0.169163
+ 0.997222 0.369180
+ 1.000000 0.224835
+ 1.002778 0.179297
+ 1.005556 0.369202
+ 1.008333 0.220482
+ 1.011111 0.169123
+ 1.013889 0.369180
+ 1.016667 0.227737
+ 1.019444 0.174927
+ 1.022222 0.369163
+ 1.025000 0.227737
+ 1.027778 0.177857
+ 1.030556 0.369174
+ 1.033333 0.227737
+ 1.036111 0.179291
+ 1.038889 0.369202
+ 1.041667 0.232090
+ 1.044444 0.179308
+ 1.047222 0.369197
+ 1.050000 0.229188
+ 1.052778 0.179331
+ 1.055556 0.369197
+ 1.058333 0.227737
+ 1.061111 0.180748
+ 1.063889 0.369185
+ 1.066667 0.230639
+ 1.069444 0.177852
+ 1.072222 0.369185
+ 1.075000 0.232090
+ 1.077778 0.179320
+ 1.080556 0.369202
+ 1.083333 0.226286
+ 1.086111 0.177846
+ 1.088889 0.369180
+ 1.091667 0.229188
+ 1.094444 0.177857
+ 1.097222 0.369185
+ 1.100000 0.224835
+ 1.102778 0.180760
+ 1.105556 0.369191
+ 1.108333 0.227737
+ 1.111111 0.180737
+ 1.113889 0.369208
+ 1.116667 0.226286
+ 1.119444 0.180737
+ 1.122222 0.369174
+ 1.125000 0.224835
+ 1.127778 0.179291
+ 1.130556 0.369197
+ 1.133333 0.216129
+ 1.136111 0.176355
+ 1.138889 0.369202
+ 1.141667 0.213227
+ 1.144444 0.174876
+ 1.147222 0.369157
+ 1.150000 0.204520
+ 1.152778 0.179218
+ 1.155556 0.369191
+ 1.158333 0.198716
+ 1.161111 0.171912
+ 1.163889 0.369185
+ 1.166667 0.192912
+ 1.169444 0.174814
+ 1.172222 0.369168
+ 1.175000 0.191461
+ 1.177778 0.176282
+ 1.180556 0.369185
+ 1.183333 0.187108
+ 1.186111 0.171900
+ 1.188889 0.369174
+ 1.191667 0.203069
+ 1.194444 0.176316
+ 1.197222 0.369185
+ 1.200000 0.216129
+ 1.202778 0.190900
+ 1.205556 0.369253
+ 1.208333 0.230639
+ 1.211111 0.198200
+ 1.213889 0.369287
+ 1.216667 0.242247
+ 1.219444 0.204022
+ 1.222222 0.369287
+ 1.225000 0.242247
+ 1.227778 0.209837
+ 1.230556 0.369321
+ 1.233333 0.243698
+ 1.236111 0.212745
+ 1.238889 0.369327
+ 1.241667 0.248052
+ 1.244444 0.214207
+ 1.247222 0.369316
+ 1.250000 0.248052
+ 1.252778 0.215675
+ 1.255556 0.369327
+ 1.258333 0.246601
+ 1.261111 0.209837
+ 1.263889 0.369327
+ 1.266667 0.249503
+ 1.269444 0.208403
+ 1.272222 0.369299
+ 1.275000 0.245149
+ 1.277778 0.211305
+ 1.280556 0.369327
+ 1.283333 0.243698
+ 1.286111 0.208380
+ 1.288889 0.369316
+ 1.291667 0.245149
+ 1.294444 0.206924
+ 1.297222 0.369287
+ 1.300000 0.243698
+ 1.302778 0.208392
+ 1.305556 0.369299
+ 1.308333 0.236443
+ 1.311111 0.199657
+ 1.313889 0.369299
+ 1.316667 0.242247
+ 1.319444 0.201119
+ 1.322222 0.369259
+ 1.325000 0.239345
+ 1.327778 0.202570
+ 1.330556 0.369270
+ 1.333333 0.234992
+ 1.336111 0.196732
+ 1.338889 0.369287
+ 1.341667 0.240796
+ 1.344444 0.196749
+ 1.347222 0.369265
+ 1.350000 0.234992
+ 1.352778 0.199663
+ 1.355556 0.369265
+ 1.358333 0.234992
+ 1.361111 0.195298
+ 1.363889 0.369270
+ 1.366667 0.240796
+ 1.369444 0.196766
+ 1.372222 0.369259
+ 1.375000 0.242247
+ 1.377778 0.201125
+ 1.380556 0.369282
+ 1.383333 0.236443
+ 1.386111 0.196755
+ 1.388889 0.369287
+ 1.391667 0.240796
+ 1.394444 0.198212
+ 1.397222 0.369270
+ 1.400000 0.240796
+ 1.402778 0.204050
+ 1.405556 0.369287
+ 1.408333 0.239345
+ 1.411111 0.198212
+ 1.413889 0.369287
+ 1.416667 0.248052
+ 1.419444 0.202588
+ 1.422222 0.369265
+ 1.425000 0.242247
+ 1.427778 0.205484
+ 1.430556 0.369299
+ 1.433333 0.237894
+ 1.436111 0.214162
+ 1.438889 0.369361
+ 1.441667 0.243698
+ 1.444444 0.221440
+ 1.447222 0.369355
+ 1.450000 0.249503
+ 1.452778 0.228746
+ 1.455556 0.369389
+ 1.458333 0.248052
+ 1.461111 0.230169
+ 1.463889 0.369389
+ 1.466667 0.259660
+ 1.469444 0.224398
+ 1.472222 0.369361
+ 1.475000 0.258209
+ 1.477778 0.224415
+ 1.480556 0.369384
+ 1.483333 0.252405
+ 1.486111 0.238881
+ 1.488889 0.369401
+ 1.491667 0.252405
+ 1.494444 0.217121
+ 1.497222 0.369321
+ 1.500000 0.248052
+ 1.502778 0.206963
+ 1.505556 0.369287
+ 1.508333 0.242247
+ 1.511111 0.193864
+ 1.513889 0.369270
+ 1.516667 0.243698
+ 1.519444 0.196761
+ 1.522222 0.369253
+ 1.525000 0.242247
+ 1.527778 0.198229
+ 1.530556 0.369259
+ 1.533333 0.239345
+ 1.536111 0.193881
+ 1.538889 0.369259
+ 1.541667 0.242247
+ 1.544444 0.198217
+ 1.547222 0.369248
+ 1.550000 0.236443
+ 1.552778 0.192368
+ 1.555556 0.369202
+ 1.558333 0.198716
+ 1.561111 0.148706
+ 1.563889 0.369055
+ 1.566667 0.275621
+ 1.569444 0.179643
+ 1.572222 0.392578
+ 1.575000 0.415012
+ 1.577778 0.418164
+ 1.580556 0.393643
+ 1.583333 0.455647
+ 1.586111 0.153683
+ 1.588889 0.370183
+ 1.591667 0.224841
+ 1.594444 0.159005
+ 1.597222 0.369100
+ 1.600000 0.230639
+ 1.602778 0.192385
+ 1.605556 0.369236
+ 1.608333 0.226286
+ 1.611111 0.185107
+ 1.613889 0.369231
+ 1.616667 0.232090
+ 1.619444 0.183662
+ 1.622222 0.369202
+ 1.625000 0.227737
+ 1.627778 0.183656
+ 1.630556 0.369225
+ 1.633333 0.224835
+ 1.636111 0.177846
+ 1.638889 0.369208
+ 1.641667 0.227737
+ 1.644444 0.182188
+ 1.647222 0.369185
+ 1.650000 0.230639
+ 1.652778 0.183667
+ 1.655556 0.369214
+ 1.658333 0.223384
+ 1.661111 0.180760
+ 1.663889 0.369219
+ 1.666667 0.233541
+ 1.669444 0.183667
+ 1.672222 0.369197
+ 1.675000 0.229188
+ 1.677778 0.186581
+ 1.680556 0.369219
+ 1.683333 0.229188
+ 1.686111 0.183662
+ 1.688889 0.369225
+ 1.691667 0.232090
+ 1.694444 0.183650
+ 1.697222 0.369202
+ 1.700000 0.226286
+ 1.702778 0.188020
+ 1.705556 0.369225
+ 1.708333 0.223384
+ 1.711111 0.186541
+ 1.713889 0.369231
+ 1.716667 0.230639
+ 1.719444 0.185090
+ 1.722222 0.369225
+ 1.725000 0.220482
+ 1.727778 0.189449
+ 1.730556 0.369231
+ 1.733333 0.214678
+ 1.736111 0.185045
+ 1.738889 0.369225
+ 1.741667 0.210325
+ 1.744444 0.186479
+ 1.747222 0.369219
+ 1.750000 0.204520
+ 1.752778 0.187913
+ 1.755556 0.369225
+ 1.758333 0.192912
+ 1.761111 0.184977
+ 1.763889 0.369219
+ 1.766667 0.192912
+ 1.769444 0.182058
+ 1.772222 0.369202
+ 1.775000 0.190010
+ 1.777778 0.186428
+ 1.780556 0.369225
+ 1.783333 0.191461
+ 1.786111 0.182075
+ 1.788889 0.369231
+ 1.791667 0.207422
+ 1.794444 0.186496
+ 1.797222 0.369214
+ 1.800000 0.217580
+ 1.802778 0.201068
+ 1.805556 0.369282
+ 1.808333 0.223384
+ 1.811111 0.201074
+ 1.813889 0.369293
+ 1.816667 0.242247
+ 1.819444 0.208380
+ 1.822222 0.369310
+ 1.825000 0.246601
+ 1.827778 0.218583
+ 1.830556 0.369355
+ 1.833333 0.248052
+ 1.836111 0.218566
+ 1.838889 0.369361
+ 1.841667 0.250954
+ 1.844444 0.214202
+ 1.847222 0.369327
+ 1.850000 0.252405
+ 1.852778 0.217126
+ 1.855556 0.369344
+ 1.858333 0.245149
+ 1.861111 0.214196
+ 1.863889 0.369338
+ 1.866667 0.252405
+ 1.869444 0.215664
+ 1.872222 0.369321
+ 1.875000 0.246601
+ 1.877778 0.215670
+ 1.880556 0.369344
+ 1.883333 0.245149
+ 1.886111 0.214190
+ 1.888889 0.369344
+ 1.891667 0.246601
+ 1.894444 0.212739
+ 1.897222 0.369310
+ 1.900000 0.246601
+ 1.902778 0.209854
+ 1.905556 0.369310
+ 1.908333 0.237894
+ 1.911111 0.209826
+ 1.913889 0.369321
+ 1.916667 0.243698
+ 1.919444 0.205490
+ 1.922222 0.369287
+ 1.925000 0.240796
+ 1.927778 0.208380
+ 1.930556 0.369304
+ 1.933333 0.239345
+ 1.936111 0.202570
+ 1.938889 0.369304
+ 1.941667 0.240796
+ 1.944444 0.204022
+ 1.947222 0.369282
+ 1.950000 0.237894
+ 1.952778 0.208397
+ 1.955556 0.369304
+ 1.958333 0.239345
+ 1.961111 0.204010
+ 1.963889 0.369293
+ 1.966667 0.243698
+ 1.969444 0.201142
+ 1.972222 0.369287
+ 1.975000 0.242247
+ 1.977778 0.206958
+ 1.980556 0.369287
+ 1.983333 0.242247
+ 1.986111 0.205473
+ 1.988889 0.369304
+ 1.991667 0.248052
+ 1.994444 0.211299
+ 1.997222 0.369304
+ 2.000000 0.246601
+ 2.002778 0.208414
+ 2.005556 0.369299
+ 2.008333 0.245149
+ 2.011111 0.205484
+ 2.013889 0.369316
+ 2.016667 0.250954
+ 2.019444 0.204056
+ 2.022222 0.369299
+ 2.025000 0.248052
+ 2.027778 0.225816
+ 2.030556 0.369361
+ 2.033333 0.243698
+ 2.036111 0.230169
+ 2.038889 0.369395
+ 2.041667 0.252405
+ 2.044444 0.237447
+ 2.047222 0.369429
+ 2.050000 0.258209
+ 2.052778 0.244730
+ 2.055556 0.369446
+ 2.058333 0.256758
+ 2.061111 0.234584
+ 2.063889 0.369412
+ 2.066667 0.266915
+ 2.069444 0.233144
+ 2.072222 0.369395
+ 2.075000 0.259660
+ 2.077778 0.246175
+ 2.080556 0.369440
+ 2.083333 0.258209
+ 2.086111 0.221485
+ 2.088889 0.369344
+ 2.091667 0.250954
+ 2.094444 0.208414
+ 2.097222 0.369310
+ 2.100000 0.252405
+ 2.102778 0.208426
+ 2.105556 0.369316
+ 2.108333 0.248052
+ 2.111111 0.205495
+ 2.113889 0.369299
+ 2.116667 0.249503
+ 2.119444 0.206958
+ 2.122222 0.369293
+ 2.125000 0.248052
+ 2.127778 0.202605
+ 2.130556 0.369287
+ 2.133333 0.245149
+ 2.136111 0.198240
+ 2.138889 0.369282
+ 2.141667 0.245149
+ 2.144444 0.195310
+ 2.147222 0.369231
+ 2.150000 0.216129
+ 2.152778 0.166187
+ 2.155556 0.369123
+ 2.158333 0.236443
+ 2.161111 0.154811
+ 2.163889 0.392447
+ 2.166667 0.356970
+ 2.169444 0.325030
+ 2.172222 0.393292
+ 2.175000 0.462902
+ 2.177778 0.174287
+ 2.180556 0.370483
+ 2.183333 0.211781
+ 2.186111 0.217007
+ 2.188889 0.369163
+ 2.191667 0.239345
+ 2.194444 0.183701
+ 2.197222 0.369236
+ 2.200000 0.240796
+ 2.202778 0.195327
+ 2.205556 0.369253
+ 2.208333 0.234992
+ 2.211111 0.195293
+ 2.213889 0.369265
+ 2.216667 0.240796
+ 2.219444 0.198212
+ 2.222222 0.369248
+ 2.225000 0.236443
+ 2.227778 0.198212
+ 2.230556 0.369265
+ 2.233333 0.233541
+ 2.236111 0.190934
+ 2.238889 0.369236
+ 2.241667 0.239345
+ 2.244444 0.189500
+ 2.247222 0.369242
+ 2.250000 0.237894
+ 2.252778 0.193864
+ 2.255556 0.369248
+ 2.258333 0.236443
+ 2.261111 0.198195
+ 2.263889 0.369270
+ 2.266667 0.240796
+ 2.269444 0.193853
+ 2.272222 0.369253
+ 2.275000 0.239345
+ 2.277778 0.195315
+ 2.280556 0.369248
+ 2.283333 0.234992
+ 2.286111 0.192396
+ 2.288889 0.369253
+ 2.291667 0.237894
+ 2.294444 0.189483
+ 2.297222 0.369231
+ 2.300000 0.234992
+ 2.302778 0.195310
+ 2.305556 0.369259
+ 2.308333 0.230639
+ 2.311111 0.198183
+ 2.313889 0.369282
+ 2.316667 0.230639
+ 2.319444 0.193813
+ 2.322222 0.369253
+ 2.325000 0.224835
+ 2.327778 0.190917
+ 2.330556 0.369253
+ 2.333333 0.221933
+ 2.336111 0.195230
+ 2.338889 0.369259
+ 2.341667 0.219031
+ 2.344444 0.195202
+ 2.347222 0.369248
+ 2.350000 0.211776
+ 2.352778 0.198110
+ 2.355556 0.369253
+ 2.358333 0.203069
+ 2.361111 0.183554
+ 2.363889 0.369248
+ 2.366667 0.204520
+ 2.369444 0.187907
+ 2.372222 0.369214
+ 2.375000 0.201618
+ 2.377778 0.193734
+ 2.380556 0.369259
+ 2.383333 0.211776
+ 2.386111 0.190854
+ 2.388889 0.369259
+ 2.391667 0.226286
+ 2.394444 0.199623
+ 2.397222 0.369270
+ 2.400000 0.239345
+ 2.402778 0.212733
+ 2.405556 0.369321
+ 2.408333 0.237894
+ 2.411111 0.214184
+ 2.413889 0.369338
+ 2.416667 0.245149
+ 2.419444 0.217098
+ 2.422222 0.369350
+ 2.425000 0.245149
+ 2.427778 0.224370
+ 2.430556 0.369372
+ 2.433333 0.242247
+ 2.436111 0.219994
+ 2.438889 0.369361
+ 2.441667 0.245149
+ 2.444444 0.221445
+ 2.447222 0.369338
+ 2.450000 0.243698
+ 2.452778 0.217104
+ 2.455556 0.369338
+ 2.458333 0.240796
+ 2.461111 0.214179
+ 2.463889 0.369338
+ 2.466667 0.240796
+ 2.469444 0.214179
+ 2.472222 0.369321
+ 2.475000 0.237894
+ 2.477778 0.215647
+ 2.480556 0.369321
+ 2.483333 0.239345
+ 2.486111 0.214162
+ 2.488889 0.369327
+ 2.491667 0.236443
+ 2.494444 0.209803
+ 2.497222 0.369304
+ 2.500000 0.234992
+ 2.502778 0.206901
+ 2.505556 0.369293
+ 2.508333 0.229188
+ 2.511111 0.205439
+ 2.513889 0.369310
+ 2.516667 0.234992
+ 2.519444 0.202536
+ 2.522222 0.369282
+ 2.525000 0.233541
+ 2.527778 0.205456
+ 2.530556 0.369299
+ 2.533333 0.230639
+ 2.536111 0.203976
+ 2.538889 0.369304
+ 2.541667 0.237894
+ 2.544444 0.202536
+ 2.547222 0.369282
+ 2.550000 0.230639
+ 2.552778 0.206901
+ 2.555556 0.369304
+ 2.558333 0.224835
+ 2.561111 0.208318
+ 2.563889 0.369299
+ 2.566667 0.234992
+ 2.569444 0.205450
+ 2.572222 0.369287
+ 2.575000 0.230639
+ 2.577778 0.209803
+ 2.580556 0.369310
+ 2.583333 0.229188
+ 2.586111 0.201074
+ 2.588889 0.369304
+ 2.591667 0.230639
+ 2.594444 0.203971
+ 2.597222 0.369282
+ 2.600000 0.229188
+ 2.602778 0.214150
+ 2.605556 0.369355
+ 2.608333 0.226286
+ 2.611111 0.219921
+ 2.613889 0.369367
+ 2.616667 0.237894
+ 2.619444 0.231586
+ 2.622222 0.369384
+ 2.625000 0.242247
+ 2.627778 0.235950
+ 2.630556 0.369412
+ 2.633333 0.242247
+ 2.636111 0.225787
+ 2.638889 0.369389
+ 2.641667 0.243698
+ 2.644444 0.222885
+ 2.647222 0.369350
+ 2.650000 0.240796
+ 2.652778 0.233048
+ 2.655556 0.369406
+ 2.658333 0.232090
+ 2.661111 0.215613
+ 2.663889 0.369338
+ 2.666667 0.229188
+ 2.669444 0.201063
+ 2.672222 0.369265
+ 2.675000 0.230639
+ 2.677778 0.203971
+ 2.680556 0.369299
+ 2.683333 0.224835
+ 2.686111 0.199623
+ 2.688889 0.369282
+ 2.691667 0.227737
+ 2.694444 0.195264
+ 2.697222 0.369253
+ 2.700000 0.223384
+ 2.702778 0.195253
+ 2.705556 0.369253
+ 2.708333 0.220482
+ 2.711111 0.193785
+ 2.713889 0.369248
+ 2.716667 0.224835
+ 2.719444 0.193791
+ 2.722222 0.369236
+ 2.725000 0.204520
+ 2.727778 0.171963
+ 2.730556 0.369151
+ 2.733333 0.197265
+ 2.736111 0.138628
+ 2.738889 0.369095
+ 2.741667 0.297478
+ 2.744444 0.260896
+ 2.747222 0.392963
+ 2.750000 0.397605
+ 2.752778 0.149539
+ 2.755556 0.370597
+ 2.758333 0.208879
+ 2.761111 0.303894
+ 2.763889 0.369361
+ 2.766667 0.205971
+ 2.769444 0.160349
+ 2.772222 0.369157
+ 2.775000 0.213227
+ 2.777778 0.187964
+ 2.780556 0.369225
+ 2.783333 0.210325
+ 2.786111 0.179235
+ 2.788889 0.369219
+ 2.791667 0.210325
+ 2.794444 0.183588
+ 2.797222 0.369214
+ 2.800000 0.211776
+ 2.802778 0.190871
+ 2.805556 0.369219
+ 2.808333 0.211776
+ 2.811111 0.187952
+ 2.813889 0.369231
+ 2.816667 0.214678
+ 2.819444 0.183611
+ 2.822222 0.369208
+ 2.825000 0.213227
+ 2.827778 0.183605
+ 2.830556 0.369202
+ 2.833333 0.208873
+ 2.836111 0.177784
+ 2.838889 0.369208
+ 2.841667 0.217580
+ 2.844444 0.177789
+ 2.847222 0.369191
+ 2.850000 0.211776
+ 2.852778 0.185062
+ 2.855556 0.369208
+ 2.858333 0.210325
+ 2.861111 0.182148
+ 2.863889 0.369208
+ 2.866667 0.213227
+ 2.869444 0.179240
+ 2.872222 0.369191
+ 2.875000 0.208873
+ 2.877778 0.180703
+ 2.880556 0.369208
+ 2.883333 0.208873
+ 2.886111 0.177778
+ 2.888889 0.369208
+ 2.891667 0.208873
+ 2.894444 0.179218
+ 2.897222 0.369197
+ 2.900000 0.205971
+ 2.902778 0.187935
+ 2.905556 0.369219
+ 2.908333 0.201618
+ 2.911111 0.182103
+ 2.913889 0.369219
+ 2.916667 0.203069
+ 2.919444 0.182092
+ 2.922222 0.369208
+ 2.925000 0.195814
+ 2.927778 0.177733
+ 2.930556 0.369180
+ 2.933333 0.184206
+ 2.936111 0.170427
+ 2.938889 0.369168
+ 2.941667 0.176951
+ 2.944444 0.166045
+ 2.947222 0.369123
+ 2.950000 0.174048
+ 2.952778 0.171844
+ 2.955556 0.369157
+ 2.958333 0.171146
+ 2.961111 0.166022
+ 2.963889 0.369168
+ 2.966667 0.181304
+ 2.969444 0.170421
+ 2.972222 0.369163
+ 2.975000 0.192912
+ 2.977778 0.183554
+ 2.980556 0.369225
+ 2.983333 0.205971
+ 2.986111 0.190826
+ 2.988889 0.369253
+ 2.991667 0.226286
+ 2.994444 0.201063
+ 2.997222 0.369287
+ 3.000000 0.226286
+ 3.002778 0.209792
+ 3.005556 0.369310
+ 3.008333 0.229188
+ 3.011111 0.211237
+ 3.013889 0.369321
+ 3.016667 0.232090
+ 3.019444 0.212694
+ 3.022222 0.369321
+ 3.025000 0.232090
+ 3.027778 0.217075
+ 3.030556 0.369344
+ 3.033333 0.234992
+ 3.036111 0.212705
+ 3.038889 0.369338
+ 3.041667 0.234992
+ 3.044444 0.211254
+ 3.047222 0.369304
+ 3.050000 0.233541
+ 3.052778 0.214162
+ 3.055556 0.369321
+ 3.058333 0.230639
+ 3.061111 0.205444
+ 3.063889 0.369316
+ 3.066667 0.237894
+ 3.069444 0.206890
+ 3.072222 0.369304
+ 3.075000 0.233541
+ 3.077778 0.209797
+ 3.080556 0.369304
+ 3.083333 0.229188
+ 3.086111 0.205422
+ 3.088889 0.369299
+ 3.091667 0.232090
+ 3.094444 0.206884
+ 3.097222 0.369299
+ 3.100000 0.234992
+ 3.102778 0.209809
+ 3.105556 0.369310
+ 3.108333 0.224835
+ 3.111111 0.202519
+ 3.113889 0.369287
+ 3.116667 0.229188
+ 3.119444 0.201080
+ 3.122222 0.369270
+ 3.125000 0.229188
+ 3.127778 0.202542
+ 3.130556 0.369299
+ 3.133333 0.229188
+ 3.136111 0.201068
+ 3.138889 0.369299
+ 3.141667 0.230639
+ 3.144444 0.202536
+ 3.147222 0.369276
+ 3.150000 0.232090
+ 3.152778 0.205444
+ 3.155556 0.369304
+ 3.158333 0.229188
+ 3.161111 0.199612
+ 3.163889 0.369276
+ 3.166667 0.229188
+ 3.169444 0.201080
+ 3.172222 0.369270
+ 3.175000 0.230639
+ 3.177778 0.205444
+ 3.180556 0.369293
+ 3.183333 0.230639
+ 3.186111 0.203976
+ 3.188889 0.369299
+ 3.191667 0.232090
+ 3.194444 0.203976
+ 3.197222 0.369287
+ 3.200000 0.229188
+ 3.202778 0.209803
+ 3.205556 0.369316
+ 3.208333 0.230639
+ 3.211111 0.208324
+ 3.213889 0.369333
+ 3.216667 0.229188
+ 3.219444 0.215590
+ 3.222222 0.369338
+ 3.225000 0.237894
+ 3.227778 0.225776
+ 3.230556 0.369384
+ 3.233333 0.236443
+ 3.236111 0.230129
+ 3.238889 0.369406
+ 3.241667 0.245149
+ 3.244444 0.234499
+ 3.247222 0.369406
+ 3.250000 0.245149
+ 3.252778 0.233065
+ 3.255556 0.369401
+ 3.258333 0.240796
+ 3.261111 0.228701
+ 3.263889 0.369378
+ 3.266667 0.250954
+ 3.269444 0.228723
+ 3.272222 0.369361
+ 3.275000 0.245149
+ 3.277778 0.240309
+ 3.280556 0.369418
+ 3.283333 0.237894
+ 3.286111 0.215613
+ 3.288889 0.369333
+ 3.291667 0.236443
+ 3.294444 0.202559
+ 3.297222 0.369293
+ 3.300000 0.236443
+ 3.302778 0.198206
+ 3.305556 0.369287
+ 3.308333 0.232090
+ 3.311111 0.201074
+ 3.313889 0.369282
+ 3.316667 0.234992
+ 3.319444 0.202542
+ 3.322222 0.369287
+ 3.325000 0.232090
+ 3.327778 0.202553
+ 3.330556 0.369276
+ 3.333333 0.229188
+ 3.336111 0.192385
+ 3.338889 0.369276
+ 3.341667 0.233541
+ 3.344444 0.198183
+ 3.347222 0.369253
+ 3.350000 0.224835
+ 3.352778 0.192334
+ 3.355556 0.369214
+ 3.358333 0.197265
+ 3.361111 0.158841
+ 3.363889 0.369100
+ 3.366667 0.243698
+ 3.369444 0.163545
+ 3.372222 0.392498
+ 3.375000 0.385991
+ 3.377778 0.367235
+ 3.380556 0.393450
+ 3.383333 0.484668
+ 3.386111 0.194646
+ 3.388889 0.370597
+ 3.391667 0.214683
+ 3.394444 0.228570
+ 3.397222 0.369168
+ 3.400000 0.220482
+ 3.402778 0.185107
+ 3.405556 0.369242
+ 3.408333 0.220482
+ 3.411111 0.185079
+ 3.413889 0.369248
+ 3.416667 0.221933
+ 3.419444 0.186535
+ 3.422222 0.369214
+ 3.425000 0.221933
+ 3.427778 0.187998
+ 3.430556 0.369231
+ 3.433333 0.220482
+ 3.436111 0.187969
+ 3.438889 0.369225
+ 3.441667 0.220482
+ 3.444444 0.185079
+ 3.447222 0.369225
+ 3.450000 0.221933
+ 3.452778 0.190883
+ 3.455556 0.369248
+ 3.458333 0.220482
+ 3.461111 0.189437
+ 3.463889 0.369248
+ 3.466667 0.227737
+ 3.469444 0.193796
+ 3.472222 0.369242
+ 3.475000 0.223384
+ 3.477778 0.193796
+ 3.480556 0.369248
+ 3.483333 0.221933
+ 3.486111 0.190894
+ 3.488889 0.369253
+ 3.491667 0.224835
+ 3.494444 0.192340
+ 3.497222 0.369231
+ 3.500000 0.224835
+ 3.502778 0.193802
+ 3.505556 0.369259
+ 3.508333 0.219031
+ 3.511111 0.187975
+ 3.513889 0.369248
+ 3.516667 0.221933
+ 3.519444 0.190877
+ 3.522222 0.369231
+ 3.525000 0.213227
+ 3.527778 0.193768
+ 3.530556 0.369248
+ 3.533333 0.210325
+ 3.536111 0.187952
+ 3.538889 0.369236
+ 3.541667 0.208873
+ 3.544444 0.190826
+ 3.547222 0.369242
+ 3.550000 0.201618
+ 3.552778 0.193728
+ 3.555556 0.369259
+ 3.558333 0.192912
+ 3.561111 0.189318
+ 3.563889 0.369248
+ 3.566667 0.192912
+ 3.569444 0.189313
+ 3.572222 0.369219
+ 3.575000 0.184206
+ 3.577778 0.187839
+ 3.580556 0.369225
+ 3.583333 0.179853
+ 3.586111 0.186388
+ 3.588889 0.369214
+ 3.591667 0.182755
+ 3.594444 0.183486
+ 3.597222 0.369214
+ 3.600000 0.197265
+ 3.602778 0.190815
+ 3.605556 0.369253
+ 3.608333 0.204520
+ 3.611111 0.203908
+ 3.613889 0.369316
+ 3.616667 0.229188
+ 3.619444 0.212688
+ 3.622222 0.369321
+ 3.625000 0.234992
+ 3.627778 0.219972
+ 3.630556 0.369361
+ 3.633333 0.239345
+ 3.636111 0.219989
+ 3.638889 0.369367
+ 3.641667 0.248052
+ 3.644444 0.219994
+ 3.647222 0.369350
+ 3.650000 0.245149
+ 3.652778 0.224364
+ 3.655556 0.369378
+ 3.658333 0.242247
+ 3.661111 0.222896
+ 3.663889 0.369367
+ 3.666667 0.245149
+ 3.669444 0.221440
+ 3.672222 0.369350
+ 3.675000 0.245149
+ 3.677778 0.222919
+ 3.680556 0.369372
+ 3.683333 0.243698
+ 3.686111 0.218538
+ 3.688889 0.369344
+ 3.691667 0.246601
+ 3.694444 0.215641
+ 3.697222 0.369327
+ 3.700000 0.239345
+ 3.702778 0.217092
+ 3.705556 0.369344
+ 3.708333 0.237894
+ 3.711111 0.212716
+ 3.713889 0.369333
+ 3.716667 0.239345
+ 3.719444 0.212705
+ 3.722222 0.369310
+ 3.725000 0.233541
+ 3.727778 0.217075
+ 3.730556 0.369333
+ 3.733333 0.234992
+ 3.736111 0.211231
+ 3.738889 0.369316
+ 3.741667 0.234992
+ 3.744444 0.206901
+ 3.747222 0.369293
+ 3.750000 0.236443
+ 3.752778 0.211260
+ 3.755556 0.369316
+ 3.758333 0.227737
+ 3.761111 0.203988
+ 3.763889 0.369299
+ 3.766667 0.234992
+ 3.769444 0.203982
+ 3.772222 0.369287
+ 3.775000 0.230639
+ 3.777778 0.211248
+ 3.780556 0.369310
+ 3.783333 0.227737
+ 3.786111 0.205433
+ 3.788889 0.369310
+ 3.791667 0.233541
+ 3.794444 0.205416
+ 3.797222 0.369282
+ 3.800000 0.230639
+ 3.802778 0.206907
+ 3.805556 0.369304
+ 3.808333 0.226286
+ 3.811111 0.202519
+ 3.813889 0.369299
+ 3.816667 0.232090
+ 3.819444 0.203982
+ 3.822222 0.369287
+ 3.825000 0.233541
+ 3.827778 0.211260
+ 3.830556 0.369316
+ 3.833333 0.229188
+ 3.836111 0.209780
+ 3.838889 0.369316
+ 3.841667 0.234992
+ 3.844444 0.209797
+ 3.847222 0.369299
+ 3.850000 0.232090
+ 3.852778 0.214150
+ 3.855556 0.369338
+ 3.858333 0.229188
+ 3.861111 0.224291
+ 3.863889 0.369389
+ 3.866667 0.233541
+ 3.869444 0.225747
+ 3.872222 0.369372
+ 3.875000 0.239345
+ 3.877778 0.233037
+ 3.880556 0.369423
+ 3.883333 0.240796
+ 3.886111 0.235927
+ 3.888889 0.369429
+ 3.891667 0.245149
+ 3.894444 0.233076
+ 3.897222 0.369395
+ 3.900000 0.243698
+ 3.902778 0.237418
+ 3.905556 0.369412
+ 3.908333 0.246601
+ 3.911111 0.238864
+ 3.913889 0.369446
+ 3.916667 0.243698
+ 3.919444 0.224325
+ 3.922222 0.369350
+ 3.925000 0.237894
+ 3.927778 0.212716
+ 3.930556 0.369310
+ 3.933333 0.230639
+ 3.936111 0.202525
+ 3.938889 0.369282
+ 3.941667 0.232090
+ 3.944444 0.199629
+ 3.947222 0.369265
+ 3.950000 0.232090
+ 3.952778 0.201085
+ 3.955556 0.369287
+ 3.958333 0.224835
+ 3.961111 0.196693
+ 3.963889 0.369276
+ 3.966667 0.229188
+ 3.969444 0.196715
+ 3.972222 0.369265
+ 3.975000 0.227737
+ 3.977778 0.199634
+ 3.980556 0.369270
+ 3.983333 0.213227
+ 3.986111 0.180669
+ 3.988889 0.369163
+ 3.991667 0.198716
+ 3.994444 0.164656
+ 3.997222 0.369112
+ 4.000000 0.174048
+ 4.002778 0.135607
+ 4.005556 0.368998
+ 4.008333 0.258209
+ 4.011111 0.185368
+ 4.013889 0.392583
+ 4.016667 0.385991
+ 4.019444 0.377381
+ 4.022222 0.393462
+ 4.025000 0.473059
+ 4.027778 0.181547
+ 4.030556 0.370478
+ 4.033333 0.200173
+ 4.036111 0.212592
+ 4.038889 0.369157
+ 4.041667 0.219031
+ 4.044444 0.183633
+ 4.047222 0.369219
+ 4.050000 0.219031
+ 4.052778 0.187975
+ 4.055556 0.369242
+ 4.058333 0.216129
+ 4.061111 0.183611
+ 4.063889 0.369236
+ 4.066667 0.216129
+ 4.069444 0.189415
+ 4.072222 0.369225
+ 4.075000 0.217580
+ 4.077778 0.189432
+ 4.080556 0.369248
+ 4.083333 0.214678
+ 4.086111 0.186496
+ 4.088889 0.369248
+ 4.091667 0.217580
+ 4.094444 0.189426
+ 4.097222 0.369219
+ 4.100000 0.217580
+ 4.102778 0.193785
+ 4.105556 0.369248
+ 4.108333 0.214678
+ 4.111111 0.189420
+ 4.113889 0.369248
+ 4.116667 0.220482
+ 4.119444 0.183622
+ 4.122222 0.369208
+ 4.125000 0.219031
+ 4.127778 0.189449
+ 4.130556 0.369242
+ 4.133333 0.216129
+ 4.136111 0.189403
+ 4.138889 0.369248
+ 4.141667 0.220482
+ 4.144444 0.189426
+ 4.147222 0.369242
+ 4.150000 0.214678
+ 4.152778 0.190877
+ 4.155556 0.369236
+ 4.158333 0.213227
+ 4.161111 0.190854
+ 4.163889 0.369248
+ 4.166667 0.214678
+ 4.169444 0.183611
+ 4.172222 0.369219
+ 4.175000 0.208873
+ 4.177778 0.198110
+ 4.180556 0.369242
+ 4.183333 0.204520
+ 4.186111 0.185011
+ 4.188889 0.369225
+ 4.191667 0.203069
+ 4.194444 0.189347
+ 4.197222 0.369225
+ 4.200000 0.191461
+ 4.202778 0.190792
+ 4.205556 0.369253
+ 4.208333 0.187108
+ 4.211111 0.187845
+ 4.213889 0.369236
+ 4.216667 0.181304
+ 4.219444 0.182024
+ 4.222222 0.369214
+ 4.225000 0.179853
+ 4.227778 0.187822
+ 4.230556 0.369236
+ 4.233333 0.175500
+ 4.236111 0.186360
+ 4.238889 0.369231
+ 4.241667 0.188559
+ 4.244444 0.190758
+ 4.247222 0.369231
+ 4.250000 0.200167
+ 4.252778 0.200995
+ 4.255556 0.369287
+ 4.258333 0.213227
+ 4.261111 0.205371
+ 4.263889 0.369316
+ 4.266667 0.232090
+ 4.269444 0.211248
+ 4.272222 0.369338
+ 4.275000 0.233541
+ 4.277778 0.219972
+ 4.280556 0.369355
+ 4.283333 0.237894
+ 4.286111 0.212699
+ 4.288889 0.369355
+ 4.291667 0.239345
+ 4.294444 0.217070
+ 4.297222 0.369333
+ 4.300000 0.239345
+ 4.302778 0.221451
+ 4.305556 0.369372
+ 4.308333 0.237894
+ 4.311111 0.221406
+ 4.313889 0.369361
+ 4.316667 0.240796
+ 4.319444 0.214173
+ 4.322222 0.369316
+ 4.325000 0.233541
+ 4.327778 0.214162
+ 4.330556 0.369333
+ 4.333333 0.232090
+ 4.336111 0.212682
+ 4.338889 0.369333
+ 4.341667 0.234992
+ 4.344444 0.208335
+ 4.347222 0.369299
+ 4.350000 0.230639
+ 4.352778 0.214150
+ 4.355556 0.369310
+ 4.358333 0.230639
+ 4.361111 0.208318
+ 4.363889 0.369316
+ 4.366667 0.229188
+ 4.369444 0.209775
+ 4.372222 0.369282
+ 4.375000 0.229188
+ 4.377778 0.206884
+ 4.380556 0.369310
+ 4.383333 0.219031
+ 4.386111 0.202485
+ 4.388889 0.369287
+ 4.391667 0.224835
+ 4.394444 0.201051
+ 4.397222 0.369270
+ 4.400000 0.224835
+ 4.402778 0.205416
+ 4.405556 0.369293
+ 4.408333 0.220482
+ 4.411111 0.202491
+ 4.413889 0.369299
+ 4.416667 0.221933
+ 4.419444 0.202485
+ 4.422222 0.369270
+ 4.425000 0.223384
+ 4.427778 0.203971
+ 4.430556 0.369299
+ 4.433333 0.224835
+ 4.436111 0.202497
+ 4.438889 0.369287
+ 4.441667 0.219031
+ 4.444444 0.199589
+ 4.447222 0.369259
+ 4.450000 0.220482
+ 4.452778 0.202491
+ 4.455556 0.369293
+ 4.458333 0.224835
+ 4.461111 0.199606
+ 4.463889 0.369299
+ 4.466667 0.226286
+ 4.469444 0.199600
+ 4.472222 0.369287
+ 4.475000 0.221933
+ 4.477778 0.212654
+ 4.480556 0.369333
+ 4.483333 0.216129
+ 4.486111 0.218436
+ 4.488889 0.369355
+ 4.491667 0.226286
+ 4.494444 0.222823
+ 4.497222 0.369361
+ 4.500000 0.227737
+ 4.502778 0.235899
+ 4.505556 0.369412
+ 4.508333 0.229188
+ 4.511111 0.230101
+ 4.513889 0.369395
+ 4.516667 0.234992
+ 4.519444 0.225764
+ 4.522222 0.369378
+ 4.525000 0.233541
+ 4.527778 0.222874
+ 4.530556 0.369367
+ 4.533333 0.226286
+ 4.536111 0.231540
+ 4.538889 0.369418
+ 4.541667 0.223384
+ 4.544444 0.218458
+ 4.547222 0.369333
+ 4.550000 0.227737
+ 4.552778 0.217024
+ 4.555556 0.369321
+ 4.558333 0.213227
+ 4.561111 0.196670
+ 4.563889 0.369276
+ 4.566667 0.217580
+ 4.569444 0.193762
+ 4.572222 0.369242
+ 4.575000 0.214678
+ 4.577778 0.195225
+ 4.580556 0.369253
+ 4.583333 0.213227
+ 4.586111 0.190854
+ 4.588889 0.369248
+ 4.591667 0.213227
+ 4.594444 0.190849
+ 4.597222 0.369231
+ 4.600000 0.213227
+ 4.602778 0.195225
+ 4.605556 0.369253
+ 4.608333 0.200167
+ 4.611111 0.176259
+ 4.613889 0.369151
+ 4.616667 0.182755
+ 4.619444 0.138481
+ 4.622222 0.369009
+ 4.625000 0.245149
+ 4.627778 0.189636
+ 4.630556 0.392578
+ 4.633333 0.333754
+ 4.636111 0.398960
+ 4.638889 0.393547
+ 4.641667 0.374389
+ 4.644444 0.125920
+ 4.647222 0.370149
+ 4.650000 0.175505
+ 4.652778 0.187862
+ 4.655556 0.369117
+ 4.658333 0.194363
+ 4.661111 0.167564
+ 4.663889 0.369168
+ 4.666667 0.203069
+ 4.669444 0.176304
+ 4.672222 0.369174
+ 4.675000 0.198716
+ 4.677778 0.177761
+ 4.680556 0.369185
+ 4.683333 0.201618
+ 4.686111 0.180652
+ 4.688889 0.369202
+ 4.691667 0.200167
+ 4.694444 0.180640
+ 4.697222 0.369185
+ 4.700000 0.201618
+ 4.702778 0.176310
+ 4.705556 0.369197
+ 4.708333 0.200167
+ 4.711111 0.176293
+ 4.713889 0.369197
+ 4.716667 0.204520
+ 4.719444 0.179206
+ 4.722222 0.369197
+ 4.725000 0.203069
+ 4.727778 0.183588
+ 4.730556 0.369208
+ 4.733333 0.201618
+ 4.736111 0.176299
+ 4.738889 0.369180
+ 4.741667 0.203069
+ 4.744444 0.173397
+ 4.747222 0.369174
+ 4.750000 0.203069
+ 4.752778 0.176310
+ 4.755556 0.369180
+ 4.758333 0.195814
+ 4.761111 0.173380
+ 4.763889 0.369168
+ 4.766667 0.201618
+ 4.769444 0.176293
+ 4.772222 0.369180
+ 4.775000 0.198716
+ 4.777778 0.179201
+ 4.780556 0.369191
+ 4.783333 0.200167
+ 4.786111 0.173385
+ 4.788889 0.369185
+ 4.791667 0.198716
+ 4.794444 0.174831
+ 4.797222 0.369174
+ 4.800000 0.197265
+ 4.802778 0.179178
+ 4.805556 0.369185
+ 4.808333 0.190010
+ 4.811111 0.176231
+ 4.813889 0.369197
+ 4.816667 0.187108
+ 4.819444 0.174780
+ 4.822222 0.369174
+ 4.825000 0.172597
+ 4.827778 0.179104
+ 4.830556 0.369180
+ 4.833333 0.166793
+ 4.836111 0.167451
+ 4.838889 0.369151
+ 4.841667 0.169695
+ 4.844444 0.167456
+ 4.847222 0.369140
+ 4.850000 0.166793
+ 4.852778 0.170364
+ 4.855556 0.369151
+ 4.858333 0.163891
+ 4.861111 0.167451
+ 4.863889 0.369157
+ 4.866667 0.182755
+ 4.869444 0.176231
+ 4.872222 0.369191
+ 4.875000 0.188559
+ 4.877778 0.187879
+ 4.880556 0.369231
+ 4.883333 0.200167
+ 4.886111 0.192277
+ 4.888889 0.369282
+ 4.891667 0.210325
+ 4.894444 0.202434
+ 4.897222 0.369282
+ 4.900000 0.210325
+ 4.902778 0.208267
+ 4.905556 0.369304
+ 4.908333 0.210325
+ 4.911111 0.199555
+ 4.913889 0.369299
+ 4.916667 0.210325
+ 4.919444 0.206799
+ 4.922222 0.369299
+ 4.925000 0.213227
+ 4.927778 0.208278
+ 4.930556 0.369310
+ 4.933333 0.207422
+ 4.936111 0.202451
+ 4.938889 0.369293
+ 4.941667 0.211776
+ 4.944444 0.199538
+ 4.947222 0.369270
+ 4.950000 0.208873
+ 4.952778 0.203897
+ 4.955556 0.369293
+ 4.958333 0.205971
+ 4.961111 0.198076
+ 4.963889 0.369287
+ 4.966667 0.208873
+ 4.969444 0.202440
+ 4.972222 0.369287
+ 4.975000 0.201618
+ 4.977778 0.202440
+ 4.980556 0.369282
+ 4.983333 0.200167
+ 4.986111 0.195145
+ 4.988889 0.369253
+ 4.991667 0.201618
+ 4.994444 0.190803
+ 4.997222 0.369242
+ 5.000000 0.200167
+ 5.002778 0.196619
+ 5.005556 0.369248
+ 5.008333 0.197265
+ 5.011111 0.192237
+ 5.013889 0.369265
+ 5.016667 0.198716
+ 5.019444 0.193683
+ 5.022222 0.369248
+ 5.025000 0.198716
+ 5.027778 0.195157
+ 5.030556 0.369259
+ 5.033333 0.192912
+ 5.036111 0.189318
+ 5.038889 0.369236
+ 5.041667 0.200167
+ 5.044444 0.190798
+ 5.047222 0.369231
+ 5.050000 0.195814
+ 5.052778 0.198064
+ 5.055556 0.369253
+ 5.058333 0.198716
+ 5.061111 0.196579
+ 5.063889 0.369265
+ 5.066667 0.195814
+ 5.069444 0.195140
+ 5.072222 0.369253
+ 5.075000 0.200167
+ 5.077778 0.198064
+ 5.080556 0.369259
+ 5.083333 0.192912
+ 5.086111 0.192226
+ 5.088889 0.369265
+ 5.091667 0.203069
+ 5.094444 0.196602
+ 5.097222 0.369248
+ 5.100000 0.195814
+ 5.102778 0.203868
+ 5.105556 0.369293
+ 5.108333 0.192912
+ 5.111111 0.208205
+ 5.113889 0.369310
+ 5.116667 0.205971
+ 5.119444 0.214026
+ 5.122222 0.369327
+ 5.125000 0.204520
+ 5.127778 0.228570
+ 5.130556 0.369389
+ 5.133333 0.205971
+ 5.136111 0.222743
+ 5.138889 0.369372
+ 5.141667 0.213227
+ 5.144444 0.218419
+ 5.147222 0.369344
+ 5.150000 0.210325
+ 5.152778 0.215517
+ 5.155556 0.369355
+ 5.158333 0.203069
+ 5.161111 0.215482
+ 5.163889 0.369316
+ 5.166667 0.205971
+ 5.169444 0.198076
+ 5.172222 0.369248
+ 5.175000 0.195814
+ 5.177778 0.193694
+ 5.180556 0.369248
+ 5.183333 0.194363
+ 5.186111 0.190781
+ 5.188889 0.369236
+ 5.191667 0.198716
+ 5.194444 0.186439
+ 5.197222 0.369214
+ 5.200000 0.200167
+ 5.202778 0.192272
+ 5.205556 0.369231
+ 5.208333 0.198716
+ 5.211111 0.182086
+ 5.213889 0.369231
+ 5.216667 0.201618
+ 5.219444 0.184994
+ 5.222222 0.369214
+ 5.225000 0.200167
+ 5.227778 0.187896
+ 5.230556 0.369219
+ 5.233333 0.179853
+ 5.236111 0.160218
+ 5.238889 0.369106
+ 5.241667 0.171146
+ 5.244444 0.134167
+ 5.247222 0.369044
+ 5.250000 0.275621
+ 5.252778 0.240524
+ 5.255556 0.392838
+ 5.258333 0.380193
+ 5.261111 0.114709
+ 5.263889 0.393791
+ 5.266667 0.301836
+ 5.269444 0.436103
+ 5.272222 0.369775
+ 5.275000 0.174048
+ 5.277778 0.161726
+ 5.280556 0.369100
+ 5.283333 0.192912
+ 5.286111 0.171912
+ 5.288889 0.369180
+ 5.291667 0.200167
+ 5.294444 0.174825
+ 5.297222 0.369174
+ 5.300000 0.200167
+ 5.302778 0.183548
+ 5.305556 0.369202
+ 5.308333 0.192912
+ 5.311111 0.176276
+ 5.313889 0.369197
+ 5.316667 0.201618
+ 5.319444 0.177744
+ 5.322222 0.369157
+ 5.325000 0.198716
+ 5.327778 0.177755
+ 5.330556 0.369180
+ 5.333333 0.197265
+ 5.336111 0.169026
+ 5.338889 0.369180
+ 5.341667 0.200167
+ 5.344444 0.174836
+ 5.347222 0.369163
+ 5.350000 0.203069
+ 5.352778 0.173397
+ 5.355556 0.369180
+ 5.358333 0.197265
+ 5.361111 0.173385
+ 5.363889 0.369185
+ 5.366667 0.203069
+ 5.369444 0.173397
+ 5.372222 0.369163
+ 5.375000 0.203069
+ 5.377778 0.180663
+ 5.380556 0.369191
+ 5.383333 0.197265
+ 5.386111 0.173380
+ 5.388889 0.369174
+ 5.391667 0.198716
+ 5.394444 0.171934
+ 5.397222 0.369151
+ 5.400000 0.198716
+ 5.402778 0.174842
+ 5.405556 0.369174
+ 5.408333 0.191461
+ 5.411111 0.170455
+ 5.413889 0.369163
+ 5.416667 0.195814
+ 5.419444 0.174802
+ 5.422222 0.369168
+ 5.425000 0.187108
+ 5.427778 0.174814
+ 5.430556 0.369191
+ 5.433333 0.184206
+ 5.436111 0.174768
+ 5.438889 0.369174
+ 5.441667 0.181304
+ 5.444444 0.168958
+ 5.447222 0.369157
+ 5.450000 0.172597
+ 5.452778 0.170393
+ 5.455556 0.369140
+ 5.458333 0.163891
+ 5.461111 0.160179
+ 5.463889 0.369123
+ 5.466667 0.163891
+ 5.469444 0.158739
+ 5.472222 0.369095
+ 5.475000 0.160989
+ 5.477778 0.163103
+ 5.480556 0.369129
+ 5.483333 0.172597
+ 5.486111 0.167502
+ 5.488889 0.369168
+ 5.491667 0.188559
+ 5.494444 0.177710
+ 5.497222 0.369197
+ 5.500000 0.201618
+ 5.502778 0.189381
+ 5.505556 0.369242
+ 5.508333 0.208873
+ 5.511111 0.192300
+ 5.513889 0.369265
+ 5.516667 0.220482
+ 5.519444 0.199595
+ 5.522222 0.369265
+ 5.525000 0.223384
+ 5.527778 0.206856
+ 5.530556 0.369293
+ 5.533333 0.224835
+ 5.536111 0.202497
+ 5.538889 0.369293
+ 5.541667 0.226286
+ 5.544444 0.203959
+ 5.547222 0.369276
+ 5.550000 0.224835
+ 5.552778 0.205422
+ 5.555556 0.369287
+ 5.558333 0.217580
+ 5.561111 0.199578
+ 5.563889 0.369282
+ 5.566667 0.223384
+ 5.569444 0.196693
+ 5.572222 0.369253
+ 5.575000 0.220482
+ 5.577778 0.203948
+ 5.580556 0.369282
+ 5.583333 0.219031
+ 5.586111 0.195236
+ 5.588889 0.369265
+ 5.591667 0.220482
+ 5.594444 0.195219
+ 5.597222 0.369242
+ 5.600000 0.221933
+ 5.602778 0.199595
+ 5.605556 0.369270
+ 5.608333 0.214678
+ 5.611111 0.187958
+ 5.613889 0.369253
+ 5.616667 0.219031
+ 5.619444 0.190871
+ 5.622222 0.369248
+ 5.625000 0.217580
+ 5.627778 0.198138
+ 5.630556 0.369287
+ 5.633333 0.214678
+ 5.636111 0.193757
+ 5.638889 0.369259
+ 5.641667 0.216129
+ 5.644444 0.193774
+ 5.647222 0.369231
+ 5.650000 0.216129
+ 5.652778 0.193779
+ 5.655556 0.369259
+ 5.658333 0.213227
+ 5.661111 0.190866
+ 5.663889 0.369253
+ 5.666667 0.220482
+ 5.669444 0.192311
+ 5.672222 0.369236
+ 5.675000 0.216129
+ 5.677778 0.195230
+ 5.680556 0.369253
+ 5.683333 0.216129
+ 5.686111 0.192306
+ 5.688889 0.369253
+ 5.691667 0.219031
+ 5.694444 0.192317
+ 5.697222 0.369259
+ 5.700000 0.217580
+ 5.702778 0.196693
+ 5.705556 0.369259
+ 5.708333 0.217580
+ 5.711111 0.193762
+ 5.713889 0.369270
+ 5.716667 0.221933
+ 5.719444 0.199578
+ 5.722222 0.369276
+ 5.725000 0.221933
+ 5.727778 0.215573
+ 5.730556 0.369333
+ 5.733333 0.221933
+ 5.736111 0.215556
+ 5.738889 0.369355
+ 5.741667 0.232090
+ 5.744444 0.225736
+ 5.747222 0.369378
+ 5.750000 0.230639
+ 5.752778 0.231580
+ 5.755556 0.369389
+ 5.758333 0.236443
+ 5.761111 0.221400
+ 5.763889 0.369378
+ 5.766667 0.237894
+ 5.769444 0.217075
+ 5.772222 0.369344
+ 5.775000 0.236443
+ 5.777778 0.230112
+ 5.780556 0.369350
+ 5.783333 0.227737
+ 5.786111 0.201063
+ 5.788889 0.369293
+ 5.791667 0.226286
+ 5.794444 0.195253
+ 5.797222 0.369242
+ 5.800000 0.220482
+ 5.802778 0.195247
+ 5.805556 0.369265
+ 5.808333 0.221933
+ 5.811111 0.192334
+ 5.813889 0.369259
+ 5.816667 0.224835
+ 5.819444 0.193796
+ 5.822222 0.369225
+ 5.825000 0.220482
+ 5.827778 0.189460
+ 5.830556 0.369253
+ 5.833333 0.220482
+ 5.836111 0.189420
+ 5.838889 0.369231
+ 5.841667 0.223384
+ 5.844444 0.185084
+ 5.847222 0.369214
+ 5.850000 0.201618
+ 5.852778 0.170483
+ 5.855556 0.369123
+ 5.858333 0.187108
+ 5.861111 0.134219
+ 5.863889 0.369055
+ 5.866667 0.316341
+ 5.869444 0.249429
+ 5.872222 0.392878
+ 5.875000 0.460000
+ 5.877778 0.144036
+ 5.880556 0.393876
+ 5.883333 0.329406
+ 5.886111 0.399923
+ 5.888889 0.369616
+ 5.891667 0.220482
+ 5.894444 0.157486
+ 5.897222 0.369151
+ 5.900000 0.214678
+ 5.902778 0.185050
+ 5.905556 0.369214
+ 5.908333 0.208873
+ 5.911111 0.177772
+ 5.913889 0.369202
+ 5.916667 0.208873
+ 5.919444 0.180675
+ 5.922222 0.369191
+ 5.925000 0.205971
+ 5.927778 0.183588
+ 5.930556 0.369214
+ 5.933333 0.205971
+ 5.936111 0.179223
+ 5.938889 0.369214
+ 5.941667 0.210325
+ 5.944444 0.177784
+ 5.947222 0.369185
+ 5.950000 0.210325
+ 5.952778 0.183594
+ 5.955556 0.369202
+ 5.958333 0.204520
+ 5.961111 0.177767
+ 5.963889 0.369202
+ 5.966667 0.213227
+ 5.969444 0.180692
+ 5.972222 0.369191
+ 5.975000 0.210325
+ 5.977778 0.183611
+ 5.980556 0.369202
+ 5.983333 0.208873
+ 5.986111 0.183571
+ 5.988889 0.369214
+ 5.991667 0.213227
+ 5.994444 0.185045
+ 5.997222 0.369202
+ 6.000000 0.208873
+ 6.002778 0.183588
+ 6.005556 0.369219
+ 6.008333 0.204520
+ 6.011111 0.179223
+ 6.013889 0.369208
+ 6.016667 0.205971
+ 6.019444 0.183560
+ 6.022222 0.369197
+ 6.025000 0.200167
+ 6.027778 0.185011
+ 6.030556 0.369225
+ 6.033333 0.194363
+ 6.036111 0.184971
+ 6.038889 0.369231
+ 6.041667 0.191461
+ 6.044444 0.186388
+ 6.047222 0.369214
+ 6.050000 0.185657
+ 6.052778 0.189301
+ 6.055556 0.369231
+ 6.058333 0.175500
+ 6.061111 0.180550
+ 6.063889 0.369191
+ 6.066667 0.176951
+ 6.069444 0.179087
+ 6.072222 0.369185
+ 6.075000 0.172597
+ 6.077778 0.186354
+ 6.080556 0.369219
+ 6.083333 0.175500
+ 6.086111 0.183458
+ 6.088889 0.369225
+ 6.091667 0.191461
+ 6.094444 0.189330
+ 6.097222 0.369253
+ 6.100000 0.207422
+ 6.102778 0.205365
+ 6.105556 0.369299
+ 6.108333 0.217580
+ 6.111111 0.211203
+ 6.113889 0.369333
+ 6.116667 0.232090
+ 6.119444 0.214128
+ 6.122222 0.369327
+ 6.125000 0.229188
+ 6.127778 0.218504
+ 6.130556 0.369344
+ 6.133333 0.233541
+ 6.136111 0.211248
+ 6.138889 0.369338
+ 6.141667 0.236443
+ 6.144444 0.215596
+ 6.147222 0.369321
+ 6.150000 0.234992
+ 6.152778 0.219972
+ 6.155556 0.369355
+ 6.158333 0.229188
+ 6.161111 0.215590
+ 6.163889 0.369350
+ 6.166667 0.233541
+ 6.169444 0.211243
+ 6.172222 0.369316
+ 6.175000 0.230639
+ 6.177778 0.214150
+ 6.180556 0.369338
+ 6.183333 0.226286
+ 6.186111 0.206867
+ 6.188889 0.369327
+ 6.191667 0.230639
+ 6.194444 0.209780
+ 6.197222 0.369310
+ 6.200000 0.227737
+ 6.202778 0.214145
+ 6.205556 0.369316
+ 6.208333 0.224835
+ 6.211111 0.206850
+ 6.213889 0.369310
+ 6.216667 0.226286
+ 6.219444 0.205416
+ 6.222222 0.369293
+ 6.225000 0.226286
+ 6.227778 0.209769
+ 6.230556 0.369310
+ 6.233333 0.221933
+ 6.236111 0.202502
+ 6.238889 0.369287
+ 6.241667 0.224835
+ 6.244444 0.205405
+ 6.247222 0.369276
+ 6.250000 0.223384
+ 6.252778 0.206861
+ 6.255556 0.369304
+ 6.258333 0.220482
+ 6.261111 0.203937
+ 6.263889 0.369304
+ 6.266667 0.221933
+ 6.269444 0.205405
+ 6.272222 0.369299
+ 6.275000 0.224835
+ 6.277778 0.209775
+ 6.280556 0.369310
+ 6.283333 0.221933
+ 6.286111 0.199595
+ 6.288889 0.369287
+ 6.291667 0.226286
+ 6.294444 0.203954
+ 6.297222 0.369276
+ 6.300000 0.229188
+ 6.302778 0.206867
+ 6.305556 0.369310
+ 6.308333 0.224835
+ 6.311111 0.205405
+ 6.313889 0.369310
+ 6.316667 0.229188
+ 6.319444 0.219932
+ 6.322222 0.369367
+ 6.325000 0.227737
+ 6.327778 0.230106
+ 6.330556 0.369389
+ 6.333333 0.229188
+ 6.336111 0.228638
+ 6.338889 0.369395
+ 6.341667 0.234992
+ 6.344444 0.237367
+ 6.347222 0.369412
+ 6.350000 0.239345
+ 6.352778 0.240303
+ 6.355556 0.369423
+ 6.358333 0.236443
+ 6.361111 0.230129
+ 6.363889 0.369401
+ 6.366667 0.246601
+ 6.369444 0.228706
+ 6.372222 0.369367
+ 6.375000 0.242247
+ 6.377778 0.235973
+ 6.380556 0.369440
+ 6.383333 0.234992
+ 6.386111 0.222862
+ 6.388889 0.369361
+ 6.391667 0.236443
+ 6.394444 0.206901
+ 6.397222 0.369287
+ 6.400000 0.229188
+ 6.402778 0.199651
+ 6.405556 0.369276
+ 6.408333 0.227737
+ 6.411111 0.196698
+ 6.413889 0.369270
+ 6.416667 0.229188
+ 6.419444 0.195259
+ 6.422222 0.369248
+ 6.425000 0.230639
+ 6.427778 0.193825
+ 6.430556 0.369259
+ 6.433333 0.229188
+ 6.436111 0.193813
+ 6.438889 0.369265
+ 6.441667 0.223384
+ 6.444444 0.192306
+ 6.447222 0.369197
+ 6.450000 0.192912
+ 6.452778 0.158841
+ 6.455556 0.369083
+ 6.458333 0.230639
+ 6.461111 0.160592
+ 6.463889 0.392464
+ 6.466667 0.365677
+ 6.469444 0.348298
+ 6.472222 0.393360
+ 6.475000 0.462902
+ 6.477778 0.162622
+ 6.480556 0.370376
+ 6.483333 0.198722
+ 6.486111 0.196636
+ 6.488889 0.369146
+ 6.491667 0.219031
+ 6.494444 0.185079
+ 6.497222 0.369225
+ 6.500000 0.220482
+ 6.502778 0.189437
+ 6.505556 0.369242
+ 6.508333 0.219031
+ 6.511111 0.187958
+ 6.513889 0.369242
+ 6.516667 0.219031
+ 6.519444 0.189409
+ 6.522222 0.369219
+ 6.525000 0.219031
+ 6.527778 0.189426
+ 6.530556 0.369236
+ 6.533333 0.211776
+ 6.536111 0.182148
+ 6.538889 0.369219
+ 6.541667 0.221933
+ 6.544444 0.185073
+ 6.547222 0.369208
+ 6.550000 0.214678
+ 6.552778 0.187986
+ 6.555556 0.369236
+ 6.558333 0.216129
+ 6.561111 0.189415
+ 6.563889 0.369242
+ 6.566667 0.221933
+ 6.569444 0.192334
+ 6.572222 0.369231
+ 6.575000 0.220482
+ 6.577778 0.190905
+ 6.580556 0.369236
+ 6.583333 0.220482
+ 6.586111 0.186518
+ 6.588889 0.369248
+ 6.591667 0.221933
+ 6.594444 0.186524
+ 6.597222 0.369219
+ 6.600000 0.214678
+ 6.602778 0.187981
+ 6.605556 0.369242
+ 6.608333 0.213227
+ 6.611111 0.189386
+ 6.613889 0.369248
+ 6.616667 0.211776
+ 6.619444 0.192289
+ 6.622222 0.369236
+ 6.625000 0.205971
+ 6.627778 0.198081
+ 6.630556 0.369270
+ 6.633333 0.198716
+ 6.636111 0.193700
+ 6.638889 0.369265
+ 6.641667 0.201618
+ 6.644444 0.192237
+ 6.647222 0.369236
+ 6.650000 0.190010
+ 6.652778 0.189330
+ 6.655556 0.369236
+ 6.658333 0.182755
+ 6.661111 0.184931
+ 6.663889 0.369236
+ 6.666667 0.188559
+ 6.669444 0.189284
+ 6.672222 0.369219
+ 6.675000 0.181304
+ 6.677778 0.190741
+ 6.680556 0.369236
+ 6.683333 0.176951
+ 6.686111 0.186365
+ 6.688889 0.369242
+ 6.691667 0.187108
+ 6.694444 0.192209
+ 6.697222 0.369253
+ 6.700000 0.197265
+ 6.702778 0.199515
+ 6.705556 0.369282
+ 6.708333 0.205971
+ 6.711111 0.199544
+ 6.713889 0.369299
+ 6.716667 0.220482
+ 6.719444 0.206833
+ 6.722222 0.369299
+ 6.725000 0.224835
+ 6.727778 0.218487
+ 6.730556 0.369344
+ 6.733333 0.226286
+ 6.736111 0.215562
+ 6.738889 0.369344
+ 6.741667 0.226286
+ 6.744444 0.218470
+ 6.747222 0.369338
+ 6.750000 0.226286
+ 6.752778 0.222828
+ 6.755556 0.369355
+ 6.758333 0.220482
+ 6.761111 0.211197
+ 6.763889 0.369321
+ 6.766667 0.223384
+ 6.769444 0.211197
+ 6.772222 0.369304
+ 6.775000 0.219031
+ 6.777778 0.209763
+ 6.780556 0.369310
+ 6.783333 0.213227
+ 6.786111 0.205382
+ 6.788889 0.369299
+ 6.791667 0.219031
+ 6.794444 0.208295
+ 6.797222 0.369287
+ 6.800000 0.220482
+ 6.802778 0.208301
+ 6.805556 0.369299
+ 6.808333 0.213227
+ 6.811111 0.206805
+ 6.813889 0.369304
+ 6.816667 0.219031
+ 6.819444 0.206822
+ 6.822222 0.369299
+ 6.825000 0.211776
+ 6.827778 0.203914
+ 6.830556 0.369287
+ 6.833333 0.211776
+ 6.836111 0.198098
+ 6.838889 0.369299
+ 6.841667 0.211776
+ 6.844444 0.199555
+ 6.847222 0.369282
+ 6.850000 0.211776
+ 6.852778 0.202463
+ 6.855556 0.369293
+ 6.858333 0.207422
+ 6.861111 0.198093
+ 6.863889 0.369282
+ 6.866667 0.213227
+ 6.869444 0.198093
+ 6.872222 0.369265
+ 6.875000 0.210325
+ 6.877778 0.202474
+ 6.880556 0.369293
+ 6.883333 0.210325
+ 6.886111 0.198093
+ 6.888889 0.369282
+ 6.891667 0.211776
+ 6.894444 0.201000
+ 6.897222 0.369270
+ 6.900000 0.208873
+ 6.902778 0.205371
+ 6.905556 0.369299
+ 6.908333 0.207422
+ 6.911111 0.196636
+ 6.913889 0.369282
+ 6.916667 0.216129
+ 6.919444 0.211152
+ 6.922222 0.369321
+ 6.925000 0.210325
+ 6.927778 0.218436
+ 6.930556 0.369355
+ 6.933333 0.210325
+ 6.936111 0.215528
+ 6.938889 0.369355
+ 6.941667 0.219031
+ 6.944444 0.228593
+ 6.947222 0.369372
+ 6.950000 0.217580
+ 6.952778 0.225719
+ 6.955556 0.369395
+ 6.958333 0.221933
+ 6.961111 0.225725
+ 6.963889 0.369401
+ 6.966667 0.227737
+ 6.969444 0.224262
+ 6.972222 0.369361
+ 6.975000 0.214678
+ 6.977778 0.230055
+ 6.980556 0.369361
+ 6.983333 0.210325
+ 6.986111 0.205348
+ 6.988889 0.369276
+ 6.991667 0.216129
+ 6.994444 0.193745
+ 6.997222 0.369242
+ 7.000000 0.207422
+ 7.002778 0.196636
+ 7.005556 0.369270
+ 7.008333 0.208873
+ 7.011111 0.190837
+ 7.013889 0.369259
+ 7.016667 0.207422
+ 7.019444 0.193734
+ 7.022222 0.369242
+ 7.025000 0.205971
+ 7.027778 0.195208
+ 7.030556 0.369248
+ 7.033333 0.200167
+ 7.036111 0.186433
+ 7.038889 0.369208
+ 7.041667 0.184206
+ 7.044444 0.157327
+ 7.047222 0.369083
+ 7.050000 0.194363
+ 7.052778 0.147363
+ 7.055556 0.369180
+ 7.058333 0.277072
+ 7.061111 0.252110
+ 7.063889 0.392861
+ 7.066667 0.371486
+ 7.069444 0.120502
+ 7.072222 0.393802
+ 7.075000 0.435332
+ 7.077778 0.179943
+ 7.080556 0.370432
+ 7.083333 0.169701
+ 7.086111 0.251571
+ 7.088889 0.369259
+ 7.091667 0.184206
+ 7.094444 0.163188
+ 7.097222 0.369168
+ 7.100000 0.194363
+ 7.102778 0.186428
+ 7.105556 0.369231
+ 7.108333 0.188559
+ 7.111111 0.179155
+ 7.113889 0.369185
+ 7.116667 0.192912
+ 7.119444 0.179172
+ 7.122222 0.369191
+ 7.125000 0.190010
+ 7.127778 0.184977
+ 7.130556 0.369214
+ 7.133333 0.190010
+ 7.136111 0.177693
+ 7.138889 0.369197
+ 7.141667 0.194363
+ 7.144444 0.180612
+ 7.147222 0.369202
+ 7.150000 0.191461
+ 7.152778 0.176265
+ 7.155556 0.369191
+ 7.158333 0.190010
+ 7.161111 0.180623
+ 7.163889 0.369214
+ 7.166667 0.192912
+ 7.169444 0.173346
+ 7.172222 0.369157
+ 7.175000 0.190010
+ 7.177778 0.176270
+ 7.180556 0.369197
+ 7.183333 0.185657
+ 7.186111 0.176231
+ 7.188889 0.369197
+ 7.191667 0.191461
+ 7.194444 0.182063
+ 7.197222 0.369197
+ 7.200000 0.191461
+ 7.202778 0.182058
+ 7.205556 0.369202
+ 7.208333 0.181304
+ 7.211111 0.174780
+ 7.213889 0.369185
+ 7.216667 0.182755
+ 7.219444 0.179127
+ 7.222222 0.369180
+ 7.225000 0.181304
+ 7.227778 0.179121
+ 7.230556 0.369214
+ 7.233333 0.176951
+ 7.236111 0.180561
+ 7.238889 0.369208
+ 7.241667 0.176951
+ 7.244444 0.181984
+ 7.247222 0.369191
+ 7.250000 0.162440
+ 7.252778 0.174706
+ 7.255556 0.369180
+ 7.258333 0.155185
+ 7.261111 0.163052
+ 7.263889 0.369123
+ 7.266667 0.152283
+ 7.269444 0.163035
+ 7.272222 0.369123
+ 7.275000 0.146479
+ 7.277778 0.161590
+ 7.280556 0.369140
+ 7.283333 0.146479
+ 7.286111 0.163047
+ 7.288889 0.369151
+ 7.291667 0.163891
+ 7.294444 0.173249
+ 7.297222 0.369185
+ 7.300000 0.176951
+ 7.302778 0.190730
+ 7.305556 0.369253
+ 7.308333 0.184206
+ 7.311111 0.198008
+ 7.313889 0.369287
+ 7.316667 0.195814
+ 7.319444 0.203857
+ 7.322222 0.369265
+ 7.325000 0.200167
+ 7.327778 0.208222
+ 7.330556 0.369310
+ 7.333333 0.200167
+ 7.336111 0.205303
+ 7.338889 0.369304
+ 7.341667 0.205971
+ 7.344444 0.203863
+ 7.347222 0.369276
+ 7.350000 0.200167
+ 7.352778 0.205320
+ 7.355556 0.369304
+ 7.358333 0.195814
+ 7.361111 0.205291
+ 7.363889 0.369310
+ 7.366667 0.203069
+ 7.369444 0.205320
+ 7.372222 0.369287
+ 7.375000 0.200167
+ 7.377778 0.203846
+ 7.380556 0.369287
+ 7.383333 0.195814
+ 7.386111 0.198030
+ 7.388889 0.369276
+ 7.391667 0.194363
+ 7.394444 0.200938
+ 7.397222 0.369253
+ 7.400000 0.194363
+ 7.402778 0.198047
+ 7.405556 0.369259
+ 7.408333 0.191461
+ 7.411111 0.190775
+ 7.413889 0.369259
+ 7.416667 0.191461
+ 7.419444 0.198019
+ 7.422222 0.369259
+ 7.425000 0.194363
+ 7.427778 0.199487
+ 7.430556 0.369270
+ 7.433333 0.195814
+ 7.436111 0.195106
+ 7.438889 0.369248
+ 7.441667 0.192912
+ 7.444444 0.192226
+ 7.447222 0.369236
+ 7.450000 0.187108
+ 7.452778 0.195117
+ 7.455556 0.369259
+ 7.458333 0.190010
+ 7.461111 0.195117
+ 7.463889 0.369265
+ 7.466667 0.192912
+ 7.469444 0.195123
+ 7.472222 0.369231
+ 7.475000 0.192912
+ 7.477778 0.196602
+ 7.480556 0.369253
+ 7.483333 0.192912
+ 7.486111 0.193666
+ 7.488889 0.369265
+ 7.491667 0.197265
+ 7.494444 0.192237
+ 7.497222 0.369253
+ 7.500000 0.195814
+ 7.502778 0.196602
+ 7.505556 0.369265
+ 7.508333 0.194363
+ 7.511111 0.203840
+ 7.513889 0.369310
+ 7.516667 0.201618
+ 7.519444 0.214009
+ 7.522222 0.369327
+ 7.525000 0.200167
+ 7.527778 0.221304
+ 7.530556 0.369378
+ 7.533333 0.205971
+ 7.536111 0.225657
+ 7.538889 0.369395
+ 7.541667 0.210325
+ 7.544444 0.221315
+ 7.547222 0.369355
+ 7.550000 0.214678
+ 7.552778 0.224257
+ 7.555556 0.369361
+ 7.558333 0.213227
+ 7.561111 0.216968
+ 7.563889 0.369367
+ 7.566667 0.211776
+ 7.569444 0.224200
+ 7.572222 0.369344
+ 7.575000 0.208873
+ 7.577778 0.211152
+ 7.580556 0.369293
+ 7.583333 0.200167
+ 7.586111 0.192254
+ 7.588889 0.369248
+ 7.591667 0.207422
+ 7.594444 0.186467
+ 7.597222 0.369219
+ 7.600000 0.200167
+ 7.602778 0.193728
+ 7.605556 0.369259
+ 7.608333 0.201618
+ 7.611111 0.192254
+ 7.613889 0.369248
+ 7.616667 0.203069
+ 7.619444 0.192260
+ 7.622222 0.369248
+ 7.625000 0.203069
+ 7.627778 0.192277
+ 7.630556 0.369248
+ 7.633333 0.197265
+ 7.636111 0.187873
+ 7.638889 0.369208
+ 7.641667 0.174048
+ 7.644444 0.152957
+ 7.647222 0.369055
+ 7.650000 0.205971
+ 7.652778 0.151812
+ 7.655556 0.392459
+ 7.658333 0.329401
+ 7.661111 0.349613
+ 7.663889 0.393405
+ 7.666667 0.432430
+ 7.669444 0.182800
+ 7.672222 0.370455
+ 7.675000 0.166799
+ 7.677778 0.193604
+ 7.680556 0.369106
+ 7.683333 0.188559
+ 7.686111 0.174808
+ 7.688889 0.369191
+ 7.691667 0.197265
+ 7.694444 0.173363
+ 7.697222 0.369202
+ 7.700000 0.191461
+ 7.702778 0.182063
+ 7.705556 0.369214
+ 7.708333 0.191461
+ 7.711111 0.180618
+ 7.713889 0.369197
+ 7.716667 0.194363
+ 7.719444 0.179172
+ 7.722222 0.369180
+ 7.725000 0.197265
+ 7.727778 0.184988
+ 7.730556 0.369219
+ 7.733333 0.194363
+ 7.736111 0.179178
+ 7.738889 0.369208
+ 7.741667 0.197265
+ 7.744444 0.177738
+ 7.747222 0.369197
+ 7.750000 0.197265
+ 7.752778 0.180646
+ 7.755556 0.369197
+ 7.758333 0.194363
+ 7.761111 0.182075
+ 7.763889 0.369219
+ 7.766667 0.198716
+ 7.769444 0.182075
+ 7.772222 0.369191
+ 7.775000 0.198716
+ 7.777778 0.182097
+ 7.780556 0.369208
+ 7.783333 0.194363
+ 7.786111 0.177716
+ 7.788889 0.369197
+ 7.791667 0.195814
+ 7.794444 0.176282
+ 7.797222 0.369180
+ 7.800000 0.191461
+ 7.802778 0.180618
+ 7.805556 0.369191
+ 7.808333 0.185657
+ 7.811111 0.180601
+ 7.813889 0.369191
+ 7.816667 0.188559
+ 7.819444 0.182041
+ 7.822222 0.369185
+ 7.825000 0.184206
+ 7.827778 0.184948
+ 7.830556 0.369214
+ 7.833333 0.176951
+ 7.836111 0.177631
+ 7.838889 0.369197
+ 7.841667 0.171146
+ 7.844444 0.174717
+ 7.847222 0.369157
+ 7.850000 0.160989
+ 7.852778 0.173244
+ 7.855556 0.369174
+ 7.858333 0.152283
+ 7.861111 0.168851
+ 7.863889 0.369157
+ 7.866667 0.158087
+ 7.869444 0.165960
+ 7.872222 0.369146
+ 7.875000 0.159538
+ 7.877778 0.176174
+ 7.880556 0.369191
+ 7.883333 0.172597
+ 7.886111 0.184926
+ 7.888889 0.369231
+ 7.891667 0.192912
+ 7.894444 0.192237
+ 7.897222 0.369259
+ 7.900000 0.204520
+ 7.902778 0.202451
+ 7.905556 0.369310
+ 7.908333 0.210325
+ 7.911111 0.206810
+ 7.913889 0.369310
+ 7.916667 0.217580
+ 7.919444 0.211186
+ 7.922222 0.369310
+ 7.925000 0.216129
+ 7.927778 0.214099
+ 7.930556 0.369327
+ 7.933333 0.214678
+ 7.936111 0.212620
+ 7.938889 0.369333
+ 7.941667 0.216129
+ 7.944444 0.214071
+ 7.947222 0.369316
+ 7.950000 0.214678
+ 7.952778 0.215539
+ 7.955556 0.369321
+ 7.958333 0.211776
+ 7.961111 0.211158
+ 7.963889 0.369321
+ 7.966667 0.217580
+ 7.969444 0.209718
+ 7.972222 0.369293
+ 7.975000 0.213227
+ 7.977778 0.209729
+ 7.980556 0.369321
+ 7.983333 0.211776
+ 7.986111 0.206805
+ 7.988889 0.369310
+ 7.991667 0.210325
+ 7.994444 0.203897
+ 7.997222 0.369276
+ 8.000000 0.211776
+ 8.002778 0.209718
+ 8.005556 0.369316
+ 8.008333 0.204520
+ 8.011111 0.203880
+ 8.013889 0.369293
+ 8.016667 0.210325
+ 8.019444 0.203897
+ 8.022222 0.369270
+ 8.025000 0.207422
+ 8.027778 0.203897
+ 8.030556 0.369299
+ 8.033333 0.205971
+ 8.036111 0.200989
+ 8.038889 0.369299
+ 8.041667 0.214678
+ 8.044444 0.202451
+ 8.047222 0.369282
+ 8.050000 0.208873
+ 8.052778 0.208261
+ 8.055556 0.369293
+ 8.058333 0.210325
+ 8.061111 0.202457
+ 8.063889 0.369287
+ 8.066667 0.210325
+ 8.069444 0.205354
+ 8.072222 0.369293
+ 8.075000 0.211776
+ 8.077778 0.209729
+ 8.080556 0.369304
+ 8.083333 0.210325
+ 8.086111 0.208261
+ 8.088889 0.369293
+ 8.091667 0.217580
+ 8.094444 0.201029
+ 8.097222 0.369282
+ 8.100000 0.213227
+ 8.102778 0.209729
+ 8.105556 0.369299
+ 8.108333 0.217580
+ 8.111111 0.203914
+ 8.113889 0.369299
+ 8.116667 0.216129
+ 8.119444 0.216973
+ 8.122222 0.369367
+ 8.125000 0.220482
+ 8.127778 0.231506
+ 8.130556 0.369395
+ 8.133333 0.219031
+ 8.136111 0.231512
+ 8.138889 0.369418
+ 8.141667 0.229188
+ 8.144444 0.240241
+ 8.147222 0.369418
+ 8.150000 0.227737
+ 8.152778 0.234465
+ 8.155556 0.369406
+ 8.158333 0.236443
+ 8.161111 0.230123
+ 8.163889 0.369401
+ 8.166667 0.239345
+ 8.169444 0.225764
+ 8.172222 0.369389
+ 8.175000 0.234992
+ 8.177778 0.238830
+ 8.180556 0.369401
+ 8.183333 0.226286
+ 8.186111 0.219926
+ 8.188889 0.369338
+ 8.191667 0.229188
+ 8.194444 0.208318
+ 8.197222 0.369299
+ 8.200000 0.224835
+ 8.202778 0.202519
+ 8.205556 0.369282
+ 8.208333 0.220482
+ 8.211111 0.198132
+ 8.213889 0.369270
+ 8.216667 0.223384
+ 8.219444 0.195236
+ 8.222222 0.369242
+ 8.225000 0.223384
+ 8.227778 0.195259
+ 8.230556 0.369259
+ 8.233333 0.219031
+ 8.236111 0.192328
+ 8.238889 0.369265
+ 8.241667 0.221933
+ 8.244444 0.193774
+ 8.247222 0.369248
+ 8.250000 0.208873
+ 8.252778 0.187918
+ 8.255556 0.369168
+ 8.258333 0.175500
+ 8.261111 0.150067
+ 8.263889 0.369049
+ 8.266667 0.261111
+ 8.269444 0.179581
+ 8.272222 0.392578
+ 8.275000 0.401953
+ 8.277778 0.396336
+ 8.280556 0.393581
+ 8.283333 0.129163
+ 8.286111 0.206260
+ 8.288889 0.370585
+ 8.291667 0.211781
+ 8.294444 0.216956
+ 8.297222 0.369134
+ 8.300000 0.210325
+ 8.302778 0.177795
+ 8.305556 0.369225
+ 8.308333 0.210325
+ 8.311111 0.185039
+ 8.313889 0.369242
+ 8.316667 0.211776
+ 8.319444 0.189386
+ 8.322222 0.369225
+ 8.325000 0.207422
+ 8.327778 0.192283
+ 8.330556 0.369231
+ 8.333333 0.205971
+ 8.336111 0.183565
+ 8.338889 0.369219
+ 8.341667 0.210325
+ 8.344444 0.183582
+ 8.347222 0.369202
+ 8.350000 0.208873
+ 8.352778 0.183599
+ 8.355556 0.369219
+ 8.358333 0.205971
+ 8.361111 0.182114
+ 8.363889 0.369219
+ 8.366667 0.210325
+ 8.369444 0.183588
+ 8.372222 0.369219
+ 8.375000 0.210325
+ 8.377778 0.190854
+ 8.380556 0.369236
+ 8.383333 0.207422
+ 8.386111 0.187924
+ 8.388889 0.369236
+ 8.391667 0.207422
+ 8.394444 0.180680
+ 8.397222 0.369202
+ 8.400000 0.210325
+ 8.402778 0.185056
+ 8.405556 0.369231
+ 8.408333 0.205971
+ 8.411111 0.183565
+ 8.413889 0.369219
+ 8.416667 0.207422
+ 8.419444 0.183571
+ 8.422222 0.369214
+ 8.425000 0.201618
+ 8.427778 0.187913
+ 8.430556 0.369225
+ 8.433333 0.197265
+ 8.436111 0.184982
+ 8.438889 0.369248
+ 8.441667 0.200167
+ 8.444444 0.187896
+ 8.447222 0.369219
+ 8.450000 0.191461
+ 8.452778 0.190781
+ 8.455556 0.369231
+ 8.458333 0.185657
+ 8.461111 0.186377
+ 8.463889 0.369225
+ 8.466667 0.181304
+ 8.469444 0.183463
+ 8.472222 0.369197
+ 8.475000 0.176951
+ 8.477778 0.180555
+ 8.480556 0.369219
+ 8.483333 0.165342
+ 8.486111 0.179036
+ 8.488889 0.369208
+ 8.491667 0.162440
+ 8.494444 0.179048
+ 8.497222 0.369197
+ 8.500000 0.160989
+ 8.502778 0.184858
+ 8.505556 0.369214
+ 8.508333 0.166793
+ 8.511111 0.180527
+ 8.513889 0.369219
+ 8.516667 0.182755
+ 8.519444 0.184948
+ 8.522222 0.369236
+ 8.525000 0.197265
+ 8.527778 0.200983
+ 8.530556 0.369287
+ 8.533333 0.205971
+ 8.536111 0.203903
+ 8.538889 0.369310
+ 8.541667 0.217580
+ 8.544444 0.209735
+ 8.547222 0.369321
+ 8.550000 0.221933
+ 8.552778 0.219915
+ 8.555556 0.369350
+ 8.558333 0.216129
+ 8.561111 0.215545
+ 8.563889 0.369344
+ 8.566667 0.224835
+ 8.569444 0.217007
+ 8.572222 0.369333
+ 8.575000 0.221933
+ 8.577778 0.218470
+ 8.580556 0.369344
+ 8.583333 0.220482
+ 8.586111 0.212643
+ 8.588889 0.369338
+ 8.591667 0.221933
+ 8.594444 0.212637
+ 8.597222 0.369316
+ 8.600000 0.216129
+ 8.602778 0.214111
+ 8.605556 0.369344
+ 8.608333 0.219031
+ 8.611111 0.211186
+ 8.613889 0.369327
+ 8.616667 0.219031
+ 8.619444 0.208284
+ 8.622222 0.369299
+ 8.625000 0.216129
+ 8.627778 0.208295
+ 8.630556 0.369310
+ 8.633333 0.216129
+ 8.636111 0.203920
+ 8.638889 0.369304
+ 8.641667 0.217580
+ 8.644444 0.203925
+ 8.647222 0.369276
+ 8.650000 0.217580
+ 8.652778 0.202480
+ 8.655556 0.369293
+ 8.658333 0.216129
+ 8.661111 0.198127
+ 8.663889 0.369282
+ 8.666667 0.216129
+ 8.669444 0.203920
+ 8.672222 0.369287
+ 8.675000 0.210325
+ 8.677778 0.208273
+ 8.680556 0.369304
+ 8.683333 0.211776
+ 8.686111 0.198115
+ 8.688889 0.369276
+ 8.691667 0.216129
+ 8.694444 0.199561
+ 8.697222 0.369270
+ 8.700000 0.217580
+ 8.702778 0.201040
+ 8.705556 0.369265
+ 8.708333 0.214678
+ 8.711111 0.196659
+ 8.713889 0.369282
+ 8.716667 0.219031
+ 8.719444 0.196687
+ 8.722222 0.369253
+ 8.725000 0.219031
+ 8.727778 0.199589
+ 8.730556 0.369282
+ 8.733333 0.216129
+ 8.736111 0.198127
+ 8.738889 0.369293
+ 8.741667 0.219031
+ 8.744444 0.202491
+ 8.747222 0.369276
+ 8.750000 0.220482
+ 8.752778 0.205410
+ 8.755556 0.369304
+ 8.758333 0.223384
+ 8.761111 0.206833
+ 8.763889 0.369321
+ 8.766667 0.223384
+ 8.769444 0.212654
+ 8.772222 0.369327
+ 8.775000 0.224835
+ 8.777778 0.222840
+ 8.780556 0.369367
+ 8.783333 0.223384
+ 8.786111 0.222811
+ 8.788889 0.369389
+ 8.791667 0.232090
+ 8.794444 0.230112
+ 8.797222 0.369389
+ 8.800000 0.234992
+ 8.802778 0.233025
+ 8.805556 0.369406
+ 8.808333 0.236443
+ 8.811111 0.225776
+ 8.813889 0.369389
+ 8.816667 0.240796
+ 8.819444 0.222885
+ 8.822222 0.369361
+ 8.825000 0.239345
+ 8.827778 0.237384
+ 8.830556 0.369395
+ 8.833333 0.230639
+ 8.836111 0.211231
+ 8.838889 0.369310
+ 8.841667 0.229188
+ 8.844444 0.198178
+ 8.847222 0.369265
+ 8.850000 0.227737
+ 8.852778 0.196727
+ 8.855556 0.369259
+ 8.858333 0.224835
+ 8.861111 0.195247
+ 8.863889 0.369259
+ 8.866667 0.227737
+ 8.869444 0.192345
+ 8.872222 0.369248
+ 8.875000 0.221933
+ 8.877778 0.196704
+ 8.880556 0.369265
+ 8.883333 0.223384
+ 8.886111 0.190888
+ 8.888889 0.369248
+ 8.891667 0.227737
+ 8.894444 0.190894
+ 8.897222 0.369231
+ 8.900000 0.213227
+ 8.902778 0.185045
+ 8.905556 0.369174
+ )
Vecg_l1 ecg_amp_l1 0 PWL(
+ 0.000000 0.360955
+ 0.002778 0.251718
+ 0.005556 0.204034
+ 0.008333 0.360921
+ 0.011111 0.251718
+ 0.013889 0.204024
+ 0.016667 0.360941
+ 0.019444 0.245331
+ 0.022222 0.200177
+ 0.025000 0.360941
+ 0.027778 0.252995
+ 0.030556 0.207856
+ 0.033333 0.360950
+ 0.036111 0.251718
+ 0.038889 0.206598
+ 0.041667 0.360975
+ 0.044444 0.249163
+ 0.047222 0.202737
+ 0.050000 0.360950
+ 0.052778 0.251718
+ 0.055556 0.200187
+ 0.058333 0.360926
+ 0.061111 0.247886
+ 0.063889 0.201464
+ 0.066667 0.360936
+ 0.069444 0.249163
+ 0.072222 0.202737
+ 0.075000 0.360955
+ 0.077778 0.246608
+ 0.080556 0.202737
+ 0.083333 0.360941
+ 0.086111 0.247886
+ 0.088889 0.209138
+ 0.091667 0.360965
+ 0.094444 0.249163
+ 0.097222 0.207851
+ 0.100000 0.360960
+ 0.102778 0.246608
+ 0.105556 0.204014
+ 0.108333 0.360941
+ 0.111111 0.247886
+ 0.113889 0.205301
+ 0.116667 0.360950
+ 0.119444 0.240222
+ 0.122222 0.201429
+ 0.125000 0.360960
+ 0.127778 0.246608
+ 0.130556 0.202732
+ 0.133333 0.360936
+ 0.136111 0.241499
+ 0.138889 0.204004
+ 0.141667 0.360955
+ 0.144444 0.240222
+ 0.147222 0.206544
+ 0.150000 0.360970
+ 0.152778 0.246608
+ 0.155556 0.205261
+ 0.158333 0.360950
+ 0.161111 0.242777
+ 0.163889 0.207836
+ 0.166667 0.360955
+ 0.169444 0.241499
+ 0.172222 0.205271
+ 0.175000 0.360950
+ 0.177778 0.245331
+ 0.180556 0.211668
+ 0.183333 0.360980
+ 0.186111 0.242777
+ 0.188889 0.219341
+ 0.191667 0.361005
+ 0.194444 0.244054
+ 0.197222 0.223178
+ 0.200000 0.361035
+ 0.202778 0.251718
+ 0.205556 0.230847
+ 0.208333 0.361050
+ 0.211111 0.252995
+ 0.213889 0.230877
+ 0.216667 0.361050
+ 0.219444 0.251718
+ 0.222222 0.224475
+ 0.225000 0.361040
+ 0.227778 0.251718
+ 0.230556 0.221906
+ 0.233333 0.360990
+ 0.236111 0.254272
+ 0.238889 0.227035
+ 0.241667 0.361045
+ 0.244444 0.242777
+ 0.247222 0.219341
+ 0.250000 0.361000
+ 0.252778 0.247886
+ 0.255556 0.206569
+ 0.258333 0.360941
+ 0.261111 0.240222
+ 0.263889 0.202727
+ 0.266667 0.360941
+ 0.269444 0.242777
+ 0.272222 0.198875
+ 0.275000 0.360950
+ 0.277778 0.241499
+ 0.280556 0.193771
+ 0.283333 0.360891
+ 0.286111 0.236390
+ 0.288889 0.197613
+ 0.291667 0.360931
+ 0.294444 0.237667
+ 0.297222 0.192488
+ 0.300000 0.360916
+ 0.302778 0.237667
+ 0.305556 0.191206
+ 0.308333 0.360881
+ 0.311111 0.221063
+ 0.313889 0.170705
+ 0.316667 0.360826
+ 0.319444 0.217231
+ 0.322222 0.149036
+ 0.325000 0.360786
+ 0.327778 0.302889
+ 0.330556 0.246434
+ 0.333333 0.381726
+ 0.336111 0.393581
+ 0.338889 0.151057
+ 0.341667 0.382589
+ 0.344444 0.350153
+ 0.347222 0.439134
+ 0.350000 0.361534
+ 0.352778 0.196794
+ 0.355556 0.187235
+ 0.358333 0.360811
+ 0.361111 0.222340
+ 0.363889 0.168170
+ 0.366667 0.360846
+ 0.369444 0.224895
+ 0.372222 0.184760
+ 0.375000 0.360891
+ 0.377778 0.228726
+ 0.380556 0.189894
+ 0.383333 0.360891
+ 0.386111 0.227449
+ 0.388889 0.186077
+ 0.391667 0.360881
+ 0.394444 0.223617
+ 0.397222 0.180953
+ 0.400000 0.360881
+ 0.402778 0.230004
+ 0.405556 0.182235
+ 0.408333 0.360866
+ 0.411111 0.230004
+ 0.413889 0.186097
+ 0.416667 0.360881
+ 0.419444 0.227449
+ 0.422222 0.182215
+ 0.425000 0.360881
+ 0.427778 0.236390
+ 0.430556 0.182250
+ 0.433333 0.360866
+ 0.436111 0.231281
+ 0.438889 0.187354
+ 0.441667 0.360881
+ 0.444444 0.231281
+ 0.447222 0.188627
+ 0.450000 0.360881
+ 0.452778 0.232558
+ 0.455556 0.183523
+ 0.458333 0.360871
+ 0.461111 0.232558
+ 0.463889 0.189929
+ 0.466667 0.360886
+ 0.469444 0.228726
+ 0.472222 0.182225
+ 0.475000 0.360866
+ 0.477778 0.231281
+ 0.480556 0.183518
+ 0.483333 0.360871
+ 0.486111 0.228726
+ 0.488889 0.189889
+ 0.491667 0.360896
+ 0.494444 0.226172
+ 0.497222 0.188607
+ 0.500000 0.360906
+ 0.502778 0.227449
+ 0.505556 0.189889
+ 0.508333 0.360886
+ 0.511111 0.228726
+ 0.513889 0.192464
+ 0.516667 0.360906
+ 0.519444 0.222340
+ 0.522222 0.189859
+ 0.525000 0.360901
+ 0.527778 0.222340
+ 0.530556 0.182170
+ 0.533333 0.360846
+ 0.536111 0.209567
+ 0.538889 0.179606
+ 0.541667 0.360851
+ 0.544444 0.201903
+ 0.547222 0.169338
+ 0.550000 0.360836
+ 0.552778 0.196794
+ 0.555556 0.169333
+ 0.558333 0.360796
+ 0.561111 0.194240
+ 0.563889 0.170605
+ 0.566667 0.360826
+ 0.569444 0.191685
+ 0.572222 0.170585
+ 0.575000 0.360831
+ 0.577778 0.205735
+ 0.580556 0.175764
+ 0.583333 0.360846
+ 0.586111 0.215954
+ 0.588889 0.187314
+ 0.591667 0.360901
+ 0.594444 0.230004
+ 0.597222 0.196295
+ 0.600000 0.360931
+ 0.602778 0.240222
+ 0.605556 0.205261
+ 0.608333 0.360960
+ 0.611111 0.246608
+ 0.613889 0.212965
+ 0.616667 0.361005
+ 0.619444 0.245331
+ 0.622222 0.218059
+ 0.625000 0.361010
+ 0.627778 0.251718
+ 0.630556 0.216792
+ 0.633333 0.360980
+ 0.636111 0.249163
+ 0.638889 0.215529
+ 0.641667 0.360990
+ 0.644444 0.245331
+ 0.647222 0.212955
+ 0.650000 0.361000
+ 0.652778 0.250440
+ 0.655556 0.212955
+ 0.658333 0.360980
+ 0.661111 0.247886
+ 0.663889 0.215515
+ 0.666667 0.360990
+ 0.669444 0.246608
+ 0.672222 0.211663
+ 0.675000 0.360995
+ 0.677778 0.247886
+ 0.680556 0.210405
+ 0.683333 0.360975
+ 0.686111 0.249163
+ 0.688889 0.214227
+ 0.691667 0.360990
+ 0.694444 0.241499
+ 0.697222 0.207811
+ 0.700000 0.360965
+ 0.702778 0.244054
+ 0.705556 0.205276
+ 0.708333 0.360955
+ 0.711111 0.241499
+ 0.713889 0.210390
+ 0.716667 0.360975
+ 0.719444 0.241499
+ 0.722222 0.209113
+ 0.725000 0.360975
+ 0.727778 0.242777
+ 0.730556 0.207826
+ 0.733333 0.360960
+ 0.736111 0.242777
+ 0.738889 0.210390
+ 0.741667 0.360980
+ 0.744444 0.237667
+ 0.747222 0.207816
+ 0.750000 0.360975
+ 0.752778 0.241499
+ 0.755556 0.203999
+ 0.758333 0.360931
+ 0.761111 0.240222
+ 0.763889 0.207836
+ 0.766667 0.360960
+ 0.769444 0.238945
+ 0.772222 0.203994
+ 0.775000 0.360965
+ 0.777778 0.246608
+ 0.780556 0.203994
+ 0.783333 0.360950
+ 0.786111 0.244054
+ 0.788889 0.209128
+ 0.791667 0.360965
+ 0.794444 0.244054
+ 0.797222 0.205276
+ 0.800000 0.360970
+ 0.802778 0.246608
+ 0.805556 0.202732
+ 0.808333 0.360941
+ 0.811111 0.244054
+ 0.813889 0.214232
+ 0.816667 0.360995
+ 0.819444 0.244054
+ 0.822222 0.220614
+ 0.825000 0.361010
+ 0.827778 0.249163
+ 0.830556 0.229570
+ 0.833333 0.361035
+ 0.836111 0.254272
+ 0.838889 0.232159
+ 0.841667 0.361065
+ 0.844444 0.251718
+ 0.847222 0.229595
+ 0.850000 0.361050
+ 0.852778 0.260659
+ 0.855556 0.224500
+ 0.858333 0.361030
+ 0.861111 0.259381
+ 0.863889 0.224515
+ 0.866667 0.361055
+ 0.869444 0.252995
+ 0.872222 0.229585
+ 0.875000 0.361025
+ 0.877778 0.256827
+ 0.880556 0.214257
+ 0.883333 0.360975
+ 0.886111 0.250440
+ 0.888889 0.205311
+ 0.891667 0.360955
+ 0.894444 0.245331
+ 0.897222 0.198905
+ 0.900000 0.360950
+ 0.902778 0.246608
+ 0.905556 0.202722
+ 0.908333 0.360941
+ 0.911111 0.245331
+ 0.913889 0.204024
+ 0.916667 0.360945
+ 0.919444 0.244054
+ 0.922222 0.197603
+ 0.925000 0.360945
+ 0.927778 0.245331
+ 0.930556 0.197618
+ 0.933333 0.360916
+ 0.936111 0.244054
+ 0.938889 0.198890
+ 0.941667 0.360916
+ 0.944444 0.222340
+ 0.947222 0.168140
+ 0.950000 0.360796
+ 0.952778 0.221063
+ 0.955556 0.146536
+ 0.958333 0.381217
+ 0.961111 0.333544
+ 0.963889 0.268312
+ 0.966667 0.381851
+ 0.969444 0.430622
+ 0.972222 0.175420
+ 0.975000 0.382634
+ 0.977778 0.273436
+ 0.980556 0.343128
+ 0.983333 0.361105
+ 0.986111 0.231281
+ 0.988889 0.169472
+ 0.991667 0.360846
+ 0.994444 0.236390
+ 0.997222 0.189924
+ 1.000000 0.360896
+ 1.002778 0.235113
+ 1.005556 0.192464
+ 1.008333 0.360886
+ 1.011111 0.233836
+ 1.013889 0.189929
+ 1.016667 0.360896
+ 1.019444 0.233836
+ 1.022222 0.188622
+ 1.025000 0.360901
+ 1.027778 0.237667
+ 1.030556 0.191206
+ 1.033333 0.360891
+ 1.036111 0.237667
+ 1.038889 0.197603
+ 1.041667 0.360911
+ 1.044444 0.235113
+ 1.047222 0.193746
+ 1.050000 0.360916
+ 1.052778 0.241499
+ 1.055556 0.193761
+ 1.058333 0.360901
+ 1.061111 0.237667
+ 1.063889 0.193771
+ 1.066667 0.360916
+ 1.069444 0.235113
+ 1.072222 0.189924
+ 1.075000 0.360906
+ 1.077778 0.240222
+ 1.080556 0.192483
+ 1.083333 0.360896
+ 1.086111 0.236390
+ 1.088889 0.191216
+ 1.091667 0.360906
+ 1.094444 0.235113
+ 1.097222 0.192464
+ 1.100000 0.360911
+ 1.102778 0.241499
+ 1.105556 0.192478
+ 1.108333 0.360911
+ 1.111111 0.238945
+ 1.113889 0.195038
+ 1.116667 0.360921
+ 1.119444 0.231281
+ 1.122222 0.189904
+ 1.125000 0.360906
+ 1.127778 0.232558
+ 1.130556 0.189904
+ 1.133333 0.360891
+ 1.136111 0.227449
+ 1.138889 0.193726
+ 1.141667 0.360906
+ 1.144444 0.219785
+ 1.147222 0.189839
+ 1.150000 0.360896
+ 1.152778 0.215954
+ 1.155556 0.188552
+ 1.158333 0.360881
+ 1.161111 0.208290
+ 1.163889 0.191096
+ 1.166667 0.360906
+ 1.169444 0.200626
+ 1.172222 0.187235
+ 1.175000 0.360891
+ 1.177778 0.204458
+ 1.180556 0.188512
+ 1.183333 0.360881
+ 1.186111 0.209567
+ 1.188889 0.192394
+ 1.191667 0.360896
+ 1.194444 0.222340
+ 1.197222 0.197533
+ 1.200000 0.360941
+ 1.202778 0.236390
+ 1.205556 0.206539
+ 1.208333 0.360960
+ 1.211111 0.249163
+ 1.213889 0.218079
+ 1.216667 0.360995
+ 1.219444 0.246608
+ 1.222222 0.218069
+ 1.225000 0.361005
+ 1.227778 0.251718
+ 1.230556 0.220644
+ 1.233333 0.361015
+ 1.236111 0.252995
+ 1.238889 0.227040
+ 1.241667 0.361030
+ 1.244444 0.252995
+ 1.247222 0.224475
+ 1.250000 0.361025
+ 1.252778 0.256827
+ 1.255556 0.220649
+ 1.258333 0.361005
+ 1.261111 0.256827
+ 1.263889 0.223223
+ 1.266667 0.361020
+ 1.269444 0.250440
+ 1.272222 0.220634
+ 1.275000 0.361010
+ 1.277778 0.255549
+ 1.280556 0.218089
+ 1.283333 0.361000
+ 1.286111 0.251718
+ 1.288889 0.218089
+ 1.291667 0.361010
+ 1.294444 0.247886
+ 1.297222 0.214242
+ 1.300000 0.361000
+ 1.302778 0.249163
+ 1.305556 0.214237
+ 1.308333 0.360970
+ 1.311111 0.247886
+ 1.313889 0.215525
+ 1.316667 0.360985
+ 1.319444 0.242777
+ 1.322222 0.211658
+ 1.325000 0.360990
+ 1.327778 0.246608
+ 1.330556 0.210390
+ 1.333333 0.360955
+ 1.336111 0.244054
+ 1.338889 0.215520
+ 1.341667 0.360980
+ 1.344444 0.242777
+ 1.347222 0.206559
+ 1.350000 0.360980
+ 1.352778 0.246608
+ 1.355556 0.206579
+ 1.358333 0.360955
+ 1.361111 0.245331
+ 1.363889 0.210410
+ 1.366667 0.360970
+ 1.369444 0.244054
+ 1.372222 0.210390
+ 1.375000 0.360975
+ 1.377778 0.247886
+ 1.380556 0.210405
+ 1.383333 0.360970
+ 1.386111 0.250440
+ 1.388889 0.215525
+ 1.391667 0.360990
+ 1.394444 0.245331
+ 1.397222 0.214217
+ 1.400000 0.360985
+ 1.402778 0.251718
+ 1.405556 0.214232
+ 1.408333 0.360965
+ 1.411111 0.249163
+ 1.413889 0.216807
+ 1.416667 0.360990
+ 1.419444 0.247886
+ 1.422222 0.211673
+ 1.425000 0.360990
+ 1.427778 0.251718
+ 1.430556 0.216807
+ 1.433333 0.361015
+ 1.436111 0.249163
+ 1.438889 0.232134
+ 1.441667 0.361060
+ 1.444444 0.249163
+ 1.447222 0.234689
+ 1.450000 0.361090
+ 1.452778 0.258104
+ 1.455556 0.241085
+ 1.458333 0.361090
+ 1.461111 0.259381
+ 1.463889 0.237293
+ 1.466667 0.361075
+ 1.469444 0.261936
+ 1.472222 0.234734
+ 1.475000 0.361075
+ 1.477778 0.267045
+ 1.480556 0.237283
+ 1.483333 0.361090
+ 1.486111 0.259381
+ 1.488889 0.233441
+ 1.491667 0.361050
+ 1.494444 0.254272
+ 1.497222 0.219366
+ 1.500000 0.361005
+ 1.502778 0.252995
+ 1.505556 0.211683
+ 1.508333 0.360960
+ 1.511111 0.251718
+ 1.513889 0.210435
+ 1.516667 0.360975
+ 1.519444 0.245331
+ 1.522222 0.206564
+ 1.525000 0.360965
+ 1.527778 0.249163
+ 1.530556 0.205301
+ 1.533333 0.360941
+ 1.536111 0.249163
+ 1.538889 0.210415
+ 1.541667 0.360975
+ 1.544444 0.244054
+ 1.547222 0.205286
+ 1.550000 0.360965
+ 1.552778 0.230004
+ 1.555556 0.180918
+ 1.558333 0.360831
+ 1.561111 0.217231
+ 1.563889 0.156749
+ 1.566667 0.381247
+ 1.569444 0.341207
+ 1.572222 0.277293
+ 1.575000 0.381891
+ 1.577778 0.139401
+ 1.580556 0.192129
+ 1.583333 0.382669
+ 1.586111 0.263218
+ 1.588889 0.301013
+ 1.591667 0.360985
+ 1.594444 0.240222
+ 1.597222 0.191201
+ 1.600000 0.360945
+ 1.602778 0.235113
+ 1.605556 0.198860
+ 1.608333 0.360926
+ 1.611111 0.237667
+ 1.613889 0.201439
+ 1.616667 0.360936
+ 1.619444 0.233836
+ 1.622222 0.197568
+ 1.625000 0.360931
+ 1.627778 0.237667
+ 1.630556 0.196310
+ 1.633333 0.360906
+ 1.636111 0.236390
+ 1.638889 0.197593
+ 1.641667 0.360926
+ 1.644444 0.235113
+ 1.647222 0.193751
+ 1.650000 0.360921
+ 1.652778 0.237667
+ 1.655556 0.195033
+ 1.658333 0.360921
+ 1.661111 0.238945
+ 1.663889 0.200162
+ 1.666667 0.360931
+ 1.669444 0.233836
+ 1.672222 0.197583
+ 1.675000 0.360931
+ 1.677778 0.244054
+ 1.680556 0.195038
+ 1.683333 0.360916
+ 1.686111 0.237667
+ 1.688889 0.201434
+ 1.691667 0.360945
+ 1.694444 0.233836
+ 1.697222 0.197578
+ 1.700000 0.360926
+ 1.702778 0.237667
+ 1.705556 0.201414
+ 1.708333 0.360936
+ 1.711111 0.236390
+ 1.713889 0.205256
+ 1.716667 0.360945
+ 1.719444 0.231281
+ 1.722222 0.201395
+ 1.725000 0.360931
+ 1.727778 0.231281
+ 1.730556 0.200112
+ 1.733333 0.360921
+ 1.736111 0.224895
+ 1.738889 0.198815
+ 1.741667 0.360941
+ 1.744444 0.217231
+ 1.747222 0.197503
+ 1.750000 0.360926
+ 1.752778 0.212122
+ 1.755556 0.200037
+ 1.758333 0.360931
+ 1.761111 0.208290
+ 1.763889 0.198760
+ 1.766667 0.360936
+ 1.769444 0.200626
+ 1.772222 0.197453
+ 1.775000 0.360926
+ 1.777778 0.208290
+ 1.780556 0.197468
+ 1.783333 0.360926
+ 1.786111 0.212122
+ 1.788889 0.202622
+ 1.791667 0.360945
+ 1.794444 0.222340
+ 1.797222 0.206479
+ 1.800000 0.360965
+ 1.802778 0.235113
+ 1.805556 0.211628
+ 1.808333 0.360985
+ 1.811111 0.240222
+ 1.813889 0.215505
+ 1.816667 0.360995
+ 1.819444 0.246608
+ 1.822222 0.223183
+ 1.825000 0.361040
+ 1.827778 0.255549
+ 1.830556 0.225753
+ 1.833333 0.361025
+ 1.836111 0.258104
+ 1.838889 0.232169
+ 1.841667 0.361040
+ 1.844444 0.251718
+ 1.847222 0.223213
+ 1.850000 0.361030
+ 1.852778 0.258104
+ 1.855556 0.227035
+ 1.858333 0.361025
+ 1.861111 0.255549
+ 1.863889 0.227060
+ 1.866667 0.361045
+ 1.869444 0.252995
+ 1.872222 0.223183
+ 1.875000 0.361025
+ 1.877778 0.254272
+ 1.880556 0.224490
+ 1.883333 0.361015
+ 1.886111 0.252995
+ 1.888889 0.227040
+ 1.891667 0.361035
+ 1.894444 0.249163
+ 1.897222 0.220634
+ 1.900000 0.361020
+ 1.902778 0.252995
+ 1.905556 0.221901
+ 1.908333 0.361005
+ 1.911111 0.247886
+ 1.913889 0.220639
+ 1.916667 0.361020
+ 1.919444 0.247886
+ 1.922222 0.215520
+ 1.925000 0.360995
+ 1.927778 0.250440
+ 1.930556 0.215515
+ 1.933333 0.360980
+ 1.936111 0.251718
+ 1.938889 0.215539
+ 1.941667 0.361005
+ 1.944444 0.246608
+ 1.947222 0.216777
+ 1.950000 0.361015
+ 1.952778 0.250440
+ 1.955556 0.216797
+ 1.958333 0.360985
+ 1.961111 0.246608
+ 1.963889 0.218094
+ 1.966667 0.361005
+ 1.969444 0.247886
+ 1.972222 0.214242
+ 1.975000 0.361000
+ 1.977778 0.251718
+ 1.980556 0.214242
+ 1.983333 0.360990
+ 1.986111 0.252995
+ 1.988889 0.221936
+ 1.991667 0.361025
+ 1.994444 0.249163
+ 1.997222 0.216797
+ 2.000000 0.361010
+ 2.002778 0.255549
+ 2.005556 0.215544
+ 2.008333 0.360995
+ 2.011111 0.252995
+ 2.013889 0.219376
+ 2.016667 0.361015
+ 2.019444 0.252995
+ 2.022222 0.221921
+ 2.025000 0.361045
+ 2.027778 0.252995
+ 2.030556 0.234689
+ 2.033333 0.361060
+ 2.036111 0.260659
+ 2.038889 0.241105
+ 2.041667 0.361100
+ 2.044444 0.258104
+ 2.047222 0.246219
+ 2.050000 0.361130
+ 2.052778 0.265768
+ 2.055556 0.243675
+ 2.058333 0.361095
+ 2.061111 0.270877
+ 2.063889 0.242427
+ 2.066667 0.361100
+ 2.069444 0.270877
+ 2.072222 0.242407
+ 2.075000 0.361130
+ 2.077778 0.261936
+ 2.080556 0.234724
+ 2.083333 0.361055
+ 2.086111 0.260659
+ 2.088889 0.225798
+ 2.091667 0.361025
+ 2.094444 0.255549
+ 2.097222 0.215539
+ 2.100000 0.361005
+ 2.102778 0.258104
+ 2.105556 0.219386
+ 2.108333 0.360995
+ 2.111111 0.255549
+ 2.113889 0.219386
+ 2.116667 0.361010
+ 2.119444 0.251718
+ 2.122222 0.212980
+ 2.125000 0.360990
+ 2.127778 0.254272
+ 2.130556 0.212975
+ 2.133333 0.360970
+ 2.136111 0.252995
+ 2.138889 0.215554
+ 2.141667 0.360990
+ 2.144444 0.237667
+ 2.147222 0.195013
+ 2.150000 0.360886
+ 2.152778 0.217231
+ 2.155556 0.165596
+ 2.158333 0.360781
+ 2.161111 0.305443
+ 2.163889 0.234993
+ 2.166667 0.381656
+ 2.169444 0.406354
+ 2.172222 0.462754
+ 2.175000 0.382565
+ 2.177778 0.332271
+ 2.180556 0.410969
+ 2.183333 0.361370
+ 2.186111 0.244054
+ 2.188889 0.178478
+ 2.191667 0.360896
+ 2.194444 0.247886
+ 2.197222 0.205286
+ 2.200000 0.360955
+ 2.202778 0.246608
+ 2.205556 0.206564
+ 2.208333 0.360950
+ 2.211111 0.247886
+ 2.213889 0.209148
+ 2.216667 0.360975
+ 2.219444 0.241499
+ 2.222222 0.207826
+ 2.225000 0.360970
+ 2.227778 0.247886
+ 2.230556 0.206564
+ 2.233333 0.360945
+ 2.236111 0.246608
+ 2.238889 0.206579
+ 2.241667 0.360965
+ 2.244444 0.240222
+ 2.247222 0.206544
+ 2.250000 0.360955
+ 2.252778 0.249163
+ 2.255556 0.206574
+ 2.258333 0.360950
+ 2.261111 0.246608
+ 2.263889 0.211688
+ 2.266667 0.360970
+ 2.269444 0.245331
+ 2.272222 0.207841
+ 2.275000 0.360975
+ 2.277778 0.245331
+ 2.280556 0.205286
+ 2.283333 0.360941
+ 2.286111 0.246608
+ 2.288889 0.207851
+ 2.291667 0.360945
+ 2.294444 0.240222
+ 2.297222 0.202712
+ 2.300000 0.360955
+ 2.302778 0.246608
+ 2.305556 0.207831
+ 2.308333 0.360970
+ 2.311111 0.242777
+ 2.313889 0.210380
+ 2.316667 0.360965
+ 2.319444 0.233836
+ 2.322222 0.205226
+ 2.325000 0.360955
+ 2.327778 0.236390
+ 2.330556 0.203954
+ 2.333333 0.360945
+ 2.336111 0.228726
+ 2.338889 0.211613
+ 2.341667 0.360960
+ 2.344444 0.219785
+ 2.347222 0.206459
+ 2.350000 0.360970
+ 2.352778 0.221063
+ 2.355556 0.202622
+ 2.358333 0.360931
+ 2.361111 0.215954
+ 2.363889 0.203899
+ 2.366667 0.360955
+ 2.369444 0.212122
+ 2.372222 0.201315
+ 2.375000 0.360941
+ 2.377778 0.218508
+ 2.380556 0.202627
+ 2.383333 0.360945
+ 2.386111 0.228726
+ 2.388889 0.211628
+ 2.391667 0.360980
+ 2.394444 0.236390
+ 2.397222 0.215475
+ 2.400000 0.361000
+ 2.402778 0.247886
+ 2.405556 0.221906
+ 2.408333 0.361010
+ 2.411111 0.251718
+ 2.413889 0.229590
+ 2.416667 0.361050
+ 2.419444 0.249163
+ 2.422222 0.230847
+ 2.425000 0.361060
+ 2.427778 0.255549
+ 2.430556 0.230867
+ 2.433333 0.361045
+ 2.436111 0.252995
+ 2.438889 0.234699
+ 2.441667 0.361060
+ 2.444444 0.246608
+ 2.447222 0.225728
+ 2.450000 0.361045
+ 2.452778 0.250440
+ 2.455556 0.224461
+ 2.458333 0.361020
+ 2.461111 0.247886
+ 2.463889 0.227030
+ 2.466667 0.361040
+ 2.469444 0.242777
+ 2.472222 0.224431
+ 2.475000 0.361025
+ 2.477778 0.249163
+ 2.480556 0.224456
+ 2.483333 0.361020
+ 2.486111 0.244054
+ 2.488889 0.225723
+ 2.491667 0.361030
+ 2.494444 0.241499
+ 2.497222 0.219316
+ 2.500000 0.361010
+ 2.502778 0.238945
+ 2.505556 0.214207
+ 2.508333 0.361000
+ 2.511111 0.241499
+ 2.513889 0.216787
+ 2.516667 0.361000
+ 2.519444 0.238945
+ 2.522222 0.216752
+ 2.525000 0.360990
+ 2.527778 0.242777
+ 2.530556 0.215485
+ 2.533333 0.360985
+ 2.536111 0.240222
+ 2.538889 0.215495
+ 2.541667 0.361000
+ 2.544444 0.236390
+ 2.547222 0.212910
+ 2.550000 0.360990
+ 2.552778 0.238945
+ 2.555556 0.219301
+ 2.558333 0.360995
+ 2.561111 0.240222
+ 2.563889 0.215490
+ 2.566667 0.361005
+ 2.569444 0.241499
+ 2.572222 0.216762
+ 2.575000 0.361010
+ 2.577778 0.238945
+ 2.580556 0.215470
+ 2.583333 0.360985
+ 2.586111 0.245331
+ 2.588889 0.216782
+ 2.591667 0.361020
+ 2.594444 0.231281
+ 2.597222 0.214182
+ 2.600000 0.361020
+ 2.602778 0.241499
+ 2.605556 0.229520
+ 2.608333 0.361045
+ 2.611111 0.241499
+ 2.613889 0.237218
+ 2.616667 0.361090
+ 2.619444 0.244054
+ 2.622222 0.239773
+ 2.625000 0.361105
+ 2.627778 0.246608
+ 2.630556 0.242333
+ 2.633333 0.361080
+ 2.636111 0.252995
+ 2.638889 0.238526
+ 2.641667 0.361075
+ 2.644444 0.244054
+ 2.647222 0.229555
+ 2.650000 0.361065
+ 2.652778 0.245331
+ 2.655556 0.233387
+ 2.658333 0.361030
+ 2.661111 0.241499
+ 2.663889 0.220614
+ 2.666667 0.361000
+ 2.669444 0.232558
+ 2.672222 0.209068
+ 2.675000 0.360985
+ 2.677778 0.238945
+ 2.680556 0.215475
+ 2.683333 0.360980
+ 2.686111 0.241499
+ 2.688889 0.212925
+ 2.691667 0.360975
+ 2.694444 0.233836
+ 2.697222 0.206514
+ 2.700000 0.360960
+ 2.702778 0.235113
+ 2.705556 0.202687
+ 2.708333 0.360950
+ 2.711111 0.231281
+ 2.713889 0.207806
+ 2.716667 0.360965
+ 2.719444 0.227449
+ 2.722222 0.198805
+ 2.725000 0.360906
+ 2.727778 0.209567
+ 2.730556 0.175749
+ 2.733333 0.360791
+ 2.736111 0.254272
+ 2.738889 0.196490
+ 2.741667 0.381487
+ 2.744444 0.329712
+ 2.747222 0.387095
+ 2.750000 0.382360
+ 2.752778 0.360372
+ 2.755556 0.153097
+ 2.758333 0.361719
+ 2.761111 0.195522
+ 2.763889 0.189814
+ 2.766667 0.360841
+ 2.769444 0.219785
+ 2.772222 0.194968
+ 2.775000 0.360936
+ 2.777778 0.227449
+ 2.780556 0.200087
+ 2.783333 0.360921
+ 2.786111 0.221063
+ 2.788889 0.197533
+ 2.791667 0.360926
+ 2.794444 0.222340
+ 2.797222 0.201365
+ 2.800000 0.360941
+ 2.802778 0.227449
+ 2.805556 0.198820
+ 2.808333 0.360926
+ 2.811111 0.226172
+ 2.813889 0.202657
+ 2.816667 0.360936
+ 2.819444 0.222340
+ 2.822222 0.196240
+ 2.825000 0.360926
+ 2.827778 0.222340
+ 2.830556 0.196255
+ 2.833333 0.360911
+ 2.836111 0.222340
+ 2.838889 0.194988
+ 2.841667 0.360921
+ 2.844444 0.218508
+ 2.847222 0.193681
+ 2.850000 0.360936
+ 2.852778 0.223617
+ 2.855556 0.194988
+ 2.858333 0.360916
+ 2.861111 0.221063
+ 2.863889 0.197538
+ 2.866667 0.360906
+ 2.869444 0.222340
+ 2.872222 0.194978
+ 2.875000 0.360921
+ 2.877778 0.223617
+ 2.880556 0.193696
+ 2.883333 0.360906
+ 2.886111 0.222340
+ 2.888889 0.196265
+ 2.891667 0.360916
+ 2.894444 0.217231
+ 2.897222 0.194943
+ 2.900000 0.360931
+ 2.902778 0.218508
+ 2.905556 0.197518
+ 2.908333 0.360916
+ 2.911111 0.215954
+ 2.913889 0.198790
+ 2.916667 0.360926
+ 2.919444 0.207013
+ 2.922222 0.193631
+ 2.925000 0.360911
+ 2.927778 0.205735
+ 2.930556 0.188507
+ 2.933333 0.360881
+ 2.936111 0.199349
+ 2.938889 0.188492
+ 2.941667 0.360881
+ 2.944444 0.187853
+ 2.947222 0.179506
+ 2.950000 0.360871
+ 2.952778 0.189131
+ 2.955556 0.180788
+ 2.958333 0.360871
+ 2.961111 0.191685
+ 2.963889 0.187215
+ 2.966667 0.360886
+ 2.969444 0.196794
+ 2.972222 0.189774
+ 2.975000 0.360896
+ 2.977778 0.214676
+ 2.980556 0.197503
+ 2.983333 0.360941
+ 2.986111 0.226172
+ 2.988889 0.210341
+ 2.991667 0.360975
+ 2.994444 0.232558
+ 2.997222 0.212905
+ 3.000000 0.361005
+ 3.002778 0.238945
+ 3.005556 0.221866
+ 3.008333 0.361015
+ 3.011111 0.240222
+ 3.013889 0.223158
+ 3.016667 0.361025
+ 3.019444 0.237667
+ 3.022222 0.221861
+ 3.025000 0.361025
+ 3.027778 0.245331
+ 3.030556 0.224431
+ 3.033333 0.361020
+ 3.036111 0.244054
+ 3.038889 0.225713
+ 3.041667 0.361035
+ 3.044444 0.240222
+ 3.047222 0.218044
+ 3.050000 0.361010
+ 3.052778 0.244054
+ 3.055556 0.218049
+ 3.058333 0.360995
+ 3.061111 0.244054
+ 3.063889 0.221886
+ 3.066667 0.361010
+ 3.069444 0.240222
+ 3.072222 0.216757
+ 3.075000 0.361010
+ 3.077778 0.241499
+ 3.080556 0.218039
+ 3.083333 0.360995
+ 3.086111 0.240222
+ 3.088889 0.220594
+ 3.091667 0.361010
+ 3.094444 0.236390
+ 3.097222 0.218034
+ 3.100000 0.361005
+ 3.102778 0.238945
+ 3.105556 0.215475
+ 3.108333 0.360985
+ 3.111111 0.236390
+ 3.113889 0.215485
+ 3.116667 0.361000
+ 3.119444 0.235113
+ 3.122222 0.211643
+ 3.125000 0.360990
+ 3.127778 0.237667
+ 3.130556 0.211643
+ 3.133333 0.360980
+ 3.136111 0.238945
+ 3.138889 0.218044
+ 3.141667 0.361005
+ 3.144444 0.236390
+ 3.147222 0.212910
+ 3.150000 0.361010
+ 3.152778 0.240222
+ 3.155556 0.215475
+ 3.158333 0.360980
+ 3.161111 0.236390
+ 3.163889 0.214207
+ 3.166667 0.360985
+ 3.169444 0.236390
+ 3.172222 0.212920
+ 3.175000 0.360995
+ 3.177778 0.240222
+ 3.180556 0.214202
+ 3.183333 0.360985
+ 3.186111 0.241499
+ 3.188889 0.218049
+ 3.191667 0.361000
+ 3.194444 0.236390
+ 3.197222 0.215460
+ 3.200000 0.361000
+ 3.202778 0.240222
+ 3.205556 0.218039
+ 3.208333 0.361000
+ 3.211111 0.237667
+ 3.213889 0.225703
+ 3.216667 0.361045
+ 3.219444 0.238945
+ 3.222222 0.229525
+ 3.225000 0.361070
+ 3.227778 0.242777
+ 3.230556 0.234659
+ 3.233333 0.361075
+ 3.236111 0.246608
+ 3.238889 0.243630
+ 3.241667 0.361105
+ 3.244444 0.249163
+ 3.247222 0.239783
+ 3.250000 0.361090
+ 3.252778 0.249163
+ 3.255556 0.239793
+ 3.258333 0.361080
+ 3.261111 0.251718
+ 3.263889 0.242372
+ 3.266667 0.361090
+ 3.269444 0.249163
+ 3.272222 0.235956
+ 3.275000 0.361100
+ 3.277778 0.249163
+ 3.280556 0.238501
+ 3.283333 0.361050
+ 3.286111 0.246608
+ 3.288889 0.223178
+ 3.291667 0.361005
+ 3.294444 0.240222
+ 3.297222 0.210380
+ 3.300000 0.360985
+ 3.302778 0.242777
+ 3.305556 0.212925
+ 3.308333 0.360990
+ 3.311111 0.237667
+ 3.313889 0.216767
+ 3.316667 0.361005
+ 3.319444 0.237667
+ 3.322222 0.211638
+ 3.325000 0.360990
+ 3.327778 0.240222
+ 3.330556 0.211648
+ 3.333333 0.360950
+ 3.336111 0.241499
+ 3.338889 0.212945
+ 3.341667 0.360985
+ 3.344444 0.237667
+ 3.347222 0.209078
+ 3.350000 0.360965
+ 3.352778 0.221063
+ 3.355556 0.187290
+ 3.358333 0.360861
+ 3.361111 0.205735
+ 3.363889 0.165601
+ 3.366667 0.360796
+ 3.369444 0.314384
+ 3.372222 0.252930
+ 3.375000 0.381756
+ 3.377778 0.434454
+ 3.380556 0.157598
+ 3.383333 0.382629
+ 3.386111 0.348876
+ 3.388889 0.430193
+ 3.391667 0.361429
+ 3.394444 0.227449
+ 3.397222 0.179686
+ 3.400000 0.360891
+ 3.402778 0.236390
+ 3.405556 0.202677
+ 3.408333 0.360936
+ 3.411111 0.231281
+ 3.413889 0.205246
+ 3.416667 0.360941
+ 3.419444 0.227449
+ 3.422222 0.198840
+ 3.425000 0.360945
+ 3.427778 0.232558
+ 3.430556 0.202672
+ 3.433333 0.360931
+ 3.436111 0.233836
+ 3.438889 0.202687
+ 3.441667 0.360941
+ 3.444444 0.227449
+ 3.447222 0.202667
+ 3.450000 0.360950
+ 3.452778 0.230004
+ 3.455556 0.205226
+ 3.458333 0.360941
+ 3.461111 0.232558
+ 3.463889 0.206534
+ 3.466667 0.360960
+ 3.469444 0.230004
+ 3.472222 0.203944
+ 3.475000 0.360950
+ 3.477778 0.232558
+ 3.480556 0.202687
+ 3.483333 0.360941
+ 3.486111 0.232558
+ 3.488889 0.205241
+ 3.491667 0.360960
+ 3.494444 0.227449
+ 3.497222 0.200117
+ 3.500000 0.360950
+ 3.502778 0.233836
+ 3.505556 0.206504
+ 3.508333 0.360941
+ 3.511111 0.230004
+ 3.513889 0.206504
+ 3.516667 0.360965
+ 3.519444 0.224895
+ 3.522222 0.202647
+ 3.525000 0.360950
+ 3.527778 0.227449
+ 3.530556 0.202642
+ 3.533333 0.360945
+ 3.536111 0.223617
+ 3.538889 0.206484
+ 3.541667 0.360960
+ 3.544444 0.215954
+ 3.547222 0.205172
+ 3.550000 0.360965
+ 3.552778 0.213399
+ 3.555556 0.205137
+ 3.558333 0.360941
+ 3.561111 0.204458
+ 3.563889 0.203854
+ 3.566667 0.360945
+ 3.569444 0.198072
+ 3.572222 0.197433
+ 3.575000 0.360936
+ 3.577778 0.199349
+ 3.580556 0.197433
+ 3.583333 0.360916
+ 3.586111 0.195517
+ 3.588889 0.198715
+ 3.591667 0.360941
+ 3.594444 0.199349
+ 3.597222 0.198725
+ 3.600000 0.360941
+ 3.602778 0.215954
+ 3.605556 0.210291
+ 3.608333 0.360980
+ 3.611111 0.228726
+ 3.613889 0.221861
+ 3.616667 0.361020
+ 3.619444 0.236390
+ 3.622222 0.224426
+ 3.625000 0.361030
+ 3.627778 0.247886
+ 3.630556 0.227000
+ 3.633333 0.361035
+ 3.636111 0.251718
+ 3.638889 0.233431
+ 3.641667 0.361060
+ 3.644444 0.247886
+ 3.647222 0.233407
+ 3.650000 0.361075
+ 3.652778 0.252995
+ 3.655556 0.232139
+ 3.658333 0.361045
+ 3.661111 0.251718
+ 3.663889 0.232139
+ 3.666667 0.361060
+ 3.669444 0.247886
+ 3.672222 0.229560
+ 3.675000 0.361070
+ 3.677778 0.254272
+ 3.680556 0.232139
+ 3.683333 0.361040
+ 3.686111 0.251718
+ 3.688889 0.228307
+ 3.691667 0.361045
+ 3.694444 0.247886
+ 3.697222 0.225728
+ 3.700000 0.361045
+ 3.702778 0.246608
+ 3.705556 0.224461
+ 3.708333 0.361025
+ 3.711111 0.249163
+ 3.713889 0.223183
+ 3.716667 0.361030
+ 3.719444 0.240222
+ 3.722222 0.221871
+ 3.725000 0.361025
+ 3.727778 0.247886
+ 3.730556 0.220609
+ 3.733333 0.361020
+ 3.736111 0.242777
+ 3.738889 0.221886
+ 3.741667 0.361025
+ 3.744444 0.240222
+ 3.747222 0.216762
+ 3.750000 0.361000
+ 3.752778 0.241499
+ 3.755556 0.216767
+ 3.758333 0.360990
+ 3.761111 0.238945
+ 3.763889 0.219326
+ 3.766667 0.361010
+ 3.769444 0.235113
+ 3.772222 0.215475
+ 3.775000 0.360990
+ 3.777778 0.240222
+ 3.780556 0.219311
+ 3.783333 0.360995
+ 3.786111 0.238945
+ 3.788889 0.219316
+ 3.791667 0.361020
+ 3.794444 0.237667
+ 3.797222 0.215480
+ 3.800000 0.361005
+ 3.802778 0.238945
+ 3.805556 0.215485
+ 3.808333 0.360985
+ 3.811111 0.237667
+ 3.813889 0.219321
+ 3.816667 0.361015
+ 3.819444 0.237667
+ 3.822222 0.218039
+ 3.825000 0.361010
+ 3.827778 0.241499
+ 3.830556 0.220589
+ 3.833333 0.361000
+ 3.836111 0.237667
+ 3.838889 0.223153
+ 3.841667 0.361015
+ 3.844444 0.236390
+ 3.847222 0.219306
+ 3.850000 0.361025
+ 3.852778 0.241499
+ 3.855556 0.224416
+ 3.858333 0.361045
+ 3.861111 0.242777
+ 3.863889 0.234659
+ 3.866667 0.361070
+ 3.869444 0.241499
+ 3.872222 0.239753
+ 3.875000 0.361090
+ 3.877778 0.247886
+ 3.880556 0.244892
+ 3.883333 0.361100
+ 3.886111 0.247886
+ 3.888889 0.243630
+ 3.891667 0.361100
+ 3.894444 0.254272
+ 3.897222 0.238531
+ 3.900000 0.361110
+ 3.902778 0.254272
+ 3.905556 0.238531
+ 3.908333 0.361090
+ 3.911111 0.252995
+ 3.913889 0.251303
+ 3.916667 0.361105
+ 3.919444 0.244054
+ 3.922222 0.225713
+ 3.925000 0.361030
+ 3.927778 0.242777
+ 3.930556 0.216777
+ 3.933333 0.360985
+ 3.936111 0.238945
+ 3.938889 0.216767
+ 3.941667 0.360985
+ 3.944444 0.236390
+ 3.947222 0.210351
+ 3.950000 0.360980
+ 3.952778 0.237667
+ 3.955556 0.209078
+ 3.958333 0.360965
+ 3.961111 0.236390
+ 3.963889 0.210385
+ 3.966667 0.360980
+ 3.969444 0.233836
+ 3.972222 0.210341
+ 3.975000 0.360975
+ 3.977778 0.236390
+ 3.980556 0.207781
+ 3.983333 0.360936
+ 3.986111 0.214676
+ 3.988889 0.183443
+ 3.991667 0.360861
+ 3.994444 0.199349
+ 3.997222 0.173135
+ 4.000000 0.360801
+ 4.002778 0.213399
+ 4.005556 0.156709
+ 4.008333 0.381257
+ 4.011111 0.324603
+ 4.013889 0.264441
+ 4.016667 0.381806
+ 4.019444 0.429345
+ 4.022222 0.157553
+ 4.025000 0.382604
+ 4.027778 0.329717
+ 4.030556 0.404573
+ 4.033333 0.361325
+ 4.036111 0.226172
+ 4.038889 0.180953
+ 4.041667 0.360876
+ 4.044444 0.226172
+ 4.047222 0.201375
+ 4.050000 0.360941
+ 4.052778 0.224895
+ 4.055556 0.203934
+ 4.058333 0.360941
+ 4.061111 0.227449
+ 4.063889 0.203944
+ 4.066667 0.360945
+ 4.069444 0.223617
+ 4.072222 0.197533
+ 4.075000 0.360950
+ 4.077778 0.228726
+ 4.080556 0.200102
+ 4.083333 0.360931
+ 4.086111 0.226172
+ 4.088889 0.205216
+ 4.091667 0.360950
+ 4.094444 0.224895
+ 4.097222 0.201380
+ 4.100000 0.360955
+ 4.102778 0.228726
+ 4.105556 0.202672
+ 4.108333 0.360931
+ 4.111111 0.228726
+ 4.113889 0.205226
+ 4.116667 0.360945
+ 4.119444 0.227449
+ 4.122222 0.200092
+ 4.125000 0.360955
+ 4.127778 0.231281
+ 4.130556 0.205216
+ 4.133333 0.360945
+ 4.136111 0.227449
+ 4.138889 0.207786
+ 4.141667 0.360965
+ 4.144444 0.226172
+ 4.147222 0.200092
+ 4.150000 0.360955
+ 4.152778 0.226172
+ 4.155556 0.202642
+ 4.158333 0.360941
+ 4.161111 0.224895
+ 4.163889 0.203924
+ 4.166667 0.360945
+ 4.169444 0.219785
+ 4.172222 0.202622
+ 4.175000 0.360955
+ 4.177778 0.218508
+ 4.180556 0.203894
+ 4.183333 0.360926
+ 4.186111 0.214676
+ 4.188889 0.203894
+ 4.191667 0.360950
+ 4.194444 0.205735
+ 4.197222 0.202577
+ 4.200000 0.360955
+ 4.202778 0.207013
+ 4.205556 0.203849
+ 4.208333 0.360941
+ 4.211111 0.196794
+ 4.213889 0.201270
+ 4.216667 0.360931
+ 4.219444 0.191685
+ 4.222222 0.198685
+ 4.225000 0.360941
+ 4.227778 0.194240
+ 4.230556 0.202527
+ 4.233333 0.360921
+ 4.236111 0.196794
+ 4.238889 0.205107
+ 4.241667 0.360945
+ 4.244444 0.201903
+ 4.247222 0.206404
+ 4.250000 0.360970
+ 4.252778 0.219785
+ 4.255556 0.215435
+ 4.258333 0.360985
+ 4.261111 0.232558
+ 4.263889 0.223133
+ 4.266667 0.361020
+ 4.269444 0.237667
+ 4.272222 0.226980
+ 4.275000 0.361045
+ 4.277778 0.246608
+ 4.280556 0.225703
+ 4.283333 0.361035
+ 4.286111 0.249163
+ 4.288889 0.229570
+ 4.291667 0.361045
+ 4.294444 0.244054
+ 4.297222 0.225718
+ 4.300000 0.361055
+ 4.302778 0.249163
+ 4.305556 0.230832
+ 4.308333 0.361050
+ 4.311111 0.244054
+ 4.313889 0.229555
+ 4.316667 0.361045
+ 4.319444 0.240222
+ 4.322222 0.221876
+ 4.325000 0.361035
+ 4.327778 0.242777
+ 4.330556 0.224426
+ 4.333333 0.361025
+ 4.336111 0.240222
+ 4.338889 0.227000
+ 4.341667 0.361025
+ 4.344444 0.233836
+ 4.347222 0.219292
+ 4.350000 0.361020
+ 4.352778 0.240222
+ 4.355556 0.221871
+ 4.358333 0.361000
+ 4.361111 0.237667
+ 4.363889 0.221866
+ 4.366667 0.361025
+ 4.369444 0.235113
+ 4.372222 0.215455
+ 4.375000 0.361000
+ 4.377778 0.236390
+ 4.380556 0.215455
+ 4.383333 0.360980
+ 4.386111 0.231281
+ 4.388889 0.215470
+ 4.391667 0.360990
+ 4.394444 0.231281
+ 4.397222 0.211618
+ 4.400000 0.360985
+ 4.402778 0.232558
+ 4.405556 0.215460
+ 4.408333 0.360975
+ 4.411111 0.231281
+ 4.413889 0.215450
+ 4.416667 0.361000
+ 4.419444 0.228726
+ 4.422222 0.212895
+ 4.425000 0.360985
+ 4.427778 0.235113
+ 4.430556 0.214182
+ 4.433333 0.360980
+ 4.436111 0.233836
+ 4.438889 0.216737
+ 4.441667 0.360980
+ 4.444444 0.226172
+ 4.447222 0.209043
+ 4.450000 0.360980
+ 4.452778 0.233836
+ 4.455556 0.210346
+ 4.458333 0.360975
+ 4.461111 0.232558
+ 4.463889 0.216742
+ 4.466667 0.360995
+ 4.469444 0.226172
+ 4.472222 0.215440
+ 4.475000 0.361010
+ 4.477778 0.230004
+ 4.480556 0.228223
+ 4.483333 0.361050
+ 4.486111 0.231281
+ 4.488889 0.230797
+ 4.491667 0.361050
+ 4.494444 0.235113
+ 4.497222 0.234624
+ 4.500000 0.361080
+ 4.502778 0.240222
+ 4.505556 0.238456
+ 4.508333 0.361075
+ 4.511111 0.242777
+ 4.513889 0.237208
+ 4.516667 0.361085
+ 4.519444 0.241499
+ 4.522222 0.237188
+ 4.525000 0.361075
+ 4.527778 0.244054
+ 4.530556 0.230812
+ 4.533333 0.361075
+ 4.536111 0.237667
+ 4.538889 0.241020
+ 4.541667 0.361070
+ 4.544444 0.228726
+ 4.547222 0.224376
+ 4.550000 0.361040
+ 4.552778 0.233836
+ 4.555556 0.214172
+ 4.558333 0.360975
+ 4.561111 0.227449
+ 4.563889 0.211613
+ 4.566667 0.360975
+ 4.569444 0.223617
+ 4.572222 0.206469
+ 4.575000 0.360960
+ 4.577778 0.226172
+ 4.580556 0.205211
+ 4.583333 0.360945
+ 4.586111 0.226172
+ 4.588889 0.206494
+ 4.591667 0.360970
+ 4.594444 0.219785
+ 4.597222 0.201355
+ 4.600000 0.360955
+ 4.602778 0.223617
+ 4.605556 0.201350
+ 4.608333 0.360926
+ 4.611111 0.203181
+ 4.613889 0.178304
+ 4.616667 0.360821
+ 4.619444 0.204458
+ 4.622222 0.155397
+ 4.625000 0.360826
+ 4.627778 0.292591
+ 4.630556 0.263009
+ 4.633333 0.381836
+ 4.636111 0.387195
+ 4.638889 0.159888
+ 4.641667 0.382540
+ 4.644444 0.237672
+ 4.647222 0.320037
+ 4.650000 0.361125
+ 4.652778 0.207013
+ 4.655556 0.170655
+ 4.658333 0.360841
+ 4.661111 0.210844
+ 4.663889 0.191126
+ 4.666667 0.360901
+ 4.669444 0.212122
+ 4.672222 0.193651
+ 4.675000 0.360916
+ 4.677778 0.214676
+ 4.680556 0.192389
+ 4.683333 0.360891
+ 4.686111 0.213399
+ 4.688889 0.196231
+ 4.691667 0.360916
+ 4.694444 0.207013
+ 4.697222 0.193646
+ 4.700000 0.360911
+ 4.702778 0.215954
+ 4.705556 0.192389
+ 4.708333 0.360901
+ 4.711111 0.214676
+ 4.713889 0.196231
+ 4.716667 0.360921
+ 4.719444 0.210844
+ 4.722222 0.194943
+ 4.725000 0.360921
+ 4.727778 0.217231
+ 4.730556 0.191126
+ 4.733333 0.360901
+ 4.736111 0.212122
+ 4.738889 0.191111
+ 4.741667 0.360906
+ 4.744444 0.212122
+ 4.747222 0.188547
+ 4.750000 0.360896
+ 4.752778 0.214676
+ 4.755556 0.187270
+ 4.758333 0.360886
+ 4.761111 0.214676
+ 4.763889 0.188572
+ 4.766667 0.360901
+ 4.769444 0.213399
+ 4.772222 0.191106
+ 4.775000 0.360901
+ 4.777778 0.215954
+ 4.780556 0.192384
+ 4.783333 0.360886
+ 4.786111 0.212122
+ 4.788889 0.193656
+ 4.791667 0.360906
+ 4.794444 0.209567
+ 4.797222 0.191086
+ 4.800000 0.360901
+ 4.802778 0.207013
+ 4.805556 0.189804
+ 4.808333 0.360891
+ 4.811111 0.201903
+ 4.813889 0.196181
+ 4.816667 0.360911
+ 4.819444 0.191685
+ 4.822222 0.189729
+ 4.825000 0.360896
+ 4.827778 0.190408
+ 4.830556 0.185897
+ 4.833333 0.360861
+ 4.836111 0.182744
+ 4.838889 0.184615
+ 4.841667 0.360876
+ 4.844444 0.180190
+ 4.847222 0.184580
+ 4.850000 0.360871
+ 4.852778 0.181467
+ 4.855556 0.182026
+ 4.858333 0.360866
+ 4.861111 0.187853
+ 4.863889 0.188477
+ 4.866667 0.360896
+ 4.869444 0.198072
+ 4.872222 0.198720
+ 4.875000 0.360936
+ 4.877778 0.208290
+ 4.880556 0.201310
+ 4.883333 0.360950
+ 4.886111 0.223617
+ 4.888889 0.217979
+ 4.891667 0.361000
+ 4.894444 0.215954
+ 4.897222 0.212840
+ 4.900000 0.360995
+ 4.902778 0.223617
+ 4.905556 0.214152
+ 4.908333 0.360980
+ 4.911111 0.221063
+ 4.913889 0.216702
+ 4.916667 0.361000
+ 4.919444 0.221063
+ 4.922222 0.214122
+ 4.925000 0.361005
+ 4.927778 0.223617
+ 4.930556 0.217969
+ 4.933333 0.360990
+ 4.936111 0.222340
+ 4.938889 0.215425
+ 4.941667 0.361000
+ 4.944444 0.217231
+ 4.947222 0.210281
+ 4.950000 0.360990
+ 4.952778 0.221063
+ 4.955556 0.212850
+ 4.958333 0.360980
+ 4.961111 0.217231
+ 4.963889 0.219237
+ 4.966667 0.361010
+ 4.969444 0.218508
+ 4.972222 0.211558
+ 4.975000 0.360990
+ 4.977778 0.212122
+ 4.980556 0.208988
+ 4.983333 0.360955
+ 4.986111 0.210844
+ 4.988889 0.207726
+ 4.991667 0.360965
+ 4.994444 0.209567
+ 4.997222 0.207696
+ 5.000000 0.360970
+ 5.002778 0.210844
+ 5.005556 0.206429
+ 5.008333 0.360960
+ 5.011111 0.209567
+ 5.013889 0.210276
+ 5.016667 0.360970
+ 5.019444 0.208290
+ 5.022222 0.205142
+ 5.025000 0.360955
+ 5.027778 0.210844
+ 5.030556 0.206419
+ 5.033333 0.360950
+ 5.036111 0.209567
+ 5.038889 0.206439
+ 5.041667 0.360960
+ 5.044444 0.210844
+ 5.047222 0.203849
+ 5.050000 0.360960
+ 5.052778 0.209567
+ 5.055556 0.206424
+ 5.058333 0.360965
+ 5.061111 0.209567
+ 5.063889 0.208978
+ 5.066667 0.360970
+ 5.069444 0.205735
+ 5.072222 0.203859
+ 5.075000 0.360960
+ 5.077778 0.212122
+ 5.080556 0.206414
+ 5.083333 0.360960
+ 5.086111 0.207013
+ 5.088889 0.210261
+ 5.091667 0.360980
+ 5.094444 0.208290
+ 5.097222 0.205137
+ 5.100000 0.360980
+ 5.102778 0.210844
+ 5.105556 0.215360
+ 5.108333 0.360990
+ 5.111111 0.212122
+ 5.113889 0.224331
+ 5.116667 0.361045
+ 5.119444 0.214676
+ 5.122222 0.228153
+ 5.125000 0.361075
+ 5.127778 0.219785
+ 5.130556 0.233277
+ 5.133333 0.361055
+ 5.136111 0.219785
+ 5.138889 0.232024
+ 5.141667 0.361055
+ 5.144444 0.221063
+ 5.147222 0.221791
+ 5.150000 0.361030
+ 5.152778 0.219785
+ 5.155556 0.230727
+ 5.158333 0.361050
+ 5.161111 0.217231
+ 5.163889 0.219237
+ 5.166667 0.361005
+ 5.169444 0.207013
+ 5.172222 0.206424
+ 5.175000 0.360960
+ 5.177778 0.210844
+ 5.180556 0.201320
+ 5.183333 0.360941
+ 5.186111 0.208290
+ 5.188889 0.205147
+ 5.191667 0.360945
+ 5.194444 0.209567
+ 5.197222 0.198765
+ 5.200000 0.360936
+ 5.202778 0.212122
+ 5.205556 0.197493
+ 5.208333 0.360921
+ 5.211111 0.209567
+ 5.213889 0.203889
+ 5.216667 0.360941
+ 5.219444 0.212122
+ 5.222222 0.198760
+ 5.225000 0.360936
+ 5.227778 0.205735
+ 5.230556 0.192334
+ 5.233333 0.360866
+ 5.236111 0.186576
+ 5.238889 0.171842
+ 5.241667 0.360786
+ 5.244444 0.226172
+ 5.247222 0.181048
+ 5.250000 0.381422
+ 5.252778 0.315662
+ 5.255556 0.342330
+ 5.258333 0.382175
+ 5.261111 0.398690
+ 5.263889 0.185359
+ 5.266667 0.362058
+ 5.269444 0.182749
+ 5.272222 0.242058
+ 5.275000 0.360921
+ 5.277778 0.203181
+ 5.280556 0.175754
+ 5.283333 0.360861
+ 5.286111 0.209567
+ 5.288889 0.192384
+ 5.291667 0.360896
+ 5.294444 0.210844
+ 5.297222 0.193651
+ 5.300000 0.360916
+ 5.302778 0.209567
+ 5.305556 0.193661
+ 5.308333 0.360891
+ 5.311111 0.208290
+ 5.313889 0.193676
+ 5.316667 0.360906
+ 5.319444 0.207013
+ 5.322222 0.188537
+ 5.325000 0.360901
+ 5.327778 0.215954
+ 5.330556 0.186002
+ 5.333333 0.360871
+ 5.336111 0.212122
+ 5.338889 0.188562
+ 5.341667 0.360881
+ 5.344444 0.212122
+ 5.347222 0.187270
+ 5.350000 0.360891
+ 5.352778 0.215954
+ 5.355556 0.187280
+ 5.358333 0.360886
+ 5.361111 0.214676
+ 5.363889 0.191116
+ 5.366667 0.360901
+ 5.369444 0.210844
+ 5.372222 0.188547
+ 5.375000 0.360896
+ 5.377778 0.217231
+ 5.380556 0.189834
+ 5.383333 0.360881
+ 5.386111 0.207013
+ 5.388889 0.189829
+ 5.391667 0.360891
+ 5.394444 0.209567
+ 5.397222 0.185987
+ 5.400000 0.360886
+ 5.402778 0.210844
+ 5.405556 0.187265
+ 5.408333 0.360871
+ 5.411111 0.205735
+ 5.413889 0.187270
+ 5.416667 0.360891
+ 5.419444 0.201903
+ 5.422222 0.185957
+ 5.425000 0.360886
+ 5.427778 0.204458
+ 5.430556 0.192339
+ 5.433333 0.360886
+ 5.436111 0.196794
+ 5.438889 0.188497
+ 5.441667 0.360891
+ 5.444444 0.187853
+ 5.447222 0.183338
+ 5.450000 0.360891
+ 5.452778 0.186576
+ 5.455556 0.179506
+ 5.458333 0.360846
+ 5.461111 0.181467
+ 5.463889 0.176927
+ 5.466667 0.360846
+ 5.469444 0.175080
+ 5.472222 0.171807
+ 5.475000 0.360851
+ 5.477778 0.181467
+ 5.480556 0.179501
+ 5.483333 0.360856
+ 5.486111 0.198072
+ 5.488889 0.189789
+ 5.491667 0.360911
+ 5.494444 0.208290
+ 5.497222 0.197473
+ 5.500000 0.360945
+ 5.502778 0.221063
+ 5.505556 0.201370
+ 5.508333 0.360936
+ 5.511111 0.226172
+ 5.513889 0.211608
+ 5.516667 0.360980
+ 5.519444 0.231281
+ 5.522222 0.210336
+ 5.525000 0.360990
+ 5.527778 0.235113
+ 5.530556 0.214177
+ 5.533333 0.360990
+ 5.536111 0.233836
+ 5.538889 0.216747
+ 5.541667 0.361000
+ 5.544444 0.228726
+ 5.547222 0.214172
+ 5.550000 0.360990
+ 5.552778 0.235113
+ 5.555556 0.211633
+ 5.558333 0.360970
+ 5.561111 0.230004
+ 5.563889 0.212900
+ 5.566667 0.360990
+ 5.569444 0.226172
+ 5.572222 0.209043
+ 5.575000 0.360990
+ 5.577778 0.230004
+ 5.580556 0.209058
+ 5.583333 0.360965
+ 5.586111 0.230004
+ 5.588889 0.211618
+ 5.591667 0.360975
+ 5.594444 0.224895
+ 5.597222 0.205201
+ 5.600000 0.360970
+ 5.602778 0.230004
+ 5.605556 0.207766
+ 5.608333 0.360945
+ 5.611111 0.226172
+ 5.613889 0.209053
+ 5.616667 0.360975
+ 5.619444 0.223617
+ 5.622222 0.209033
+ 5.625000 0.360975
+ 5.627778 0.228726
+ 5.630556 0.210311
+ 5.633333 0.360955
+ 5.636111 0.227449
+ 5.638889 0.209058
+ 5.641667 0.360975
+ 5.644444 0.222340
+ 5.647222 0.203919
+ 5.650000 0.360955
+ 5.652778 0.227449
+ 5.655556 0.202667
+ 5.658333 0.360950
+ 5.661111 0.224895
+ 5.663889 0.207771
+ 5.666667 0.360955
+ 5.669444 0.223617
+ 5.672222 0.203929
+ 5.675000 0.360965
+ 5.677778 0.227449
+ 5.680556 0.205221
+ 5.683333 0.360950
+ 5.686111 0.228726
+ 5.688889 0.210336
+ 5.691667 0.360975
+ 5.694444 0.226172
+ 5.697222 0.209038
+ 5.700000 0.360980
+ 5.702778 0.231281
+ 5.705556 0.206499
+ 5.708333 0.360955
+ 5.711111 0.227449
+ 5.713889 0.211613
+ 5.716667 0.360980
+ 5.719444 0.228726
+ 5.722222 0.217989
+ 5.725000 0.361025
+ 5.727778 0.228726
+ 5.730556 0.223103
+ 5.733333 0.361020
+ 5.736111 0.233836
+ 5.738889 0.233362
+ 5.741667 0.361070
+ 5.744444 0.233836
+ 5.747222 0.235911
+ 5.750000 0.361085
+ 5.752778 0.244054
+ 5.755556 0.234649
+ 5.758333 0.361055
+ 5.761111 0.246608
+ 5.763889 0.234664
+ 5.766667 0.361060
+ 5.769444 0.241499
+ 5.772222 0.234649
+ 5.775000 0.361080
+ 5.777778 0.237667
+ 5.780556 0.220589
+ 5.783333 0.361005
+ 5.786111 0.237667
+ 5.788889 0.212925
+ 5.791667 0.360980
+ 5.794444 0.236390
+ 5.797222 0.202677
+ 5.800000 0.360955
+ 5.802778 0.233836
+ 5.805556 0.210346
+ 5.808333 0.360950
+ 5.811111 0.233836
+ 5.813889 0.210355
+ 5.816667 0.360955
+ 5.819444 0.230004
+ 5.822222 0.200112
+ 5.825000 0.360945
+ 5.827778 0.233836
+ 5.830556 0.201405
+ 5.833333 0.360931
+ 5.836111 0.227449
+ 5.838889 0.205231
+ 5.841667 0.360941
+ 5.844444 0.226172
+ 5.847222 0.197518
+ 5.850000 0.360911
+ 5.852778 0.204458
+ 5.855556 0.171887
+ 5.858333 0.360791
+ 5.861111 0.246608
+ 5.863889 0.184994
+ 5.866667 0.381442
+ 5.869444 0.373140
+ 5.872222 0.361744
+ 5.875000 0.382280
+ 5.877778 0.460000
+ 5.880556 0.199548
+ 5.883333 0.362013
+ 5.886111 0.219790
+ 5.888889 0.214162
+ 5.891667 0.360856
+ 5.894444 0.223617
+ 5.897222 0.194983
+ 5.900000 0.360931
+ 5.902778 0.223617
+ 5.905556 0.194978
+ 5.908333 0.360911
+ 5.911111 0.221063
+ 5.913889 0.191146
+ 5.916667 0.360921
+ 5.919444 0.215954
+ 5.922222 0.192414
+ 5.925000 0.360916
+ 5.927778 0.222340
+ 5.930556 0.192409
+ 5.933333 0.360906
+ 5.936111 0.221063
+ 5.938889 0.198810
+ 5.941667 0.360926
+ 5.944444 0.219785
+ 5.947222 0.193696
+ 5.950000 0.360916
+ 5.952778 0.222340
+ 5.955556 0.191141
+ 5.958333 0.360906
+ 5.961111 0.222340
+ 5.963889 0.196260
+ 5.966667 0.360916
+ 5.969444 0.219785
+ 5.972222 0.191126
+ 5.975000 0.360911
+ 5.977778 0.223617
+ 5.980556 0.193706
+ 5.983333 0.360916
+ 5.986111 0.219785
+ 5.988889 0.200092
+ 5.991667 0.360936
+ 5.994444 0.219785
+ 5.997222 0.197523
+ 6.000000 0.360921
+ 6.002778 0.219785
+ 6.005556 0.196240
+ 6.008333 0.360911
+ 6.011111 0.218508
+ 6.013889 0.202632
+ 6.016667 0.360936
+ 6.019444 0.210844
+ 6.022222 0.193661
+ 6.025000 0.360921
+ 6.027778 0.212122
+ 6.030556 0.197488
+ 6.033333 0.360916
+ 6.036111 0.207013
+ 6.038889 0.202592
+ 6.041667 0.360945
+ 6.044444 0.199349
+ 6.047222 0.199988
+ 6.050000 0.360936
+ 6.052778 0.198072
+ 6.055556 0.199978
+ 6.058333 0.360911
+ 6.061111 0.191685
+ 6.063889 0.201250
+ 6.066667 0.360926
+ 6.069444 0.185299
+ 6.072222 0.193556
+ 6.075000 0.360916
+ 6.077778 0.191685
+ 6.080556 0.197413
+ 6.083333 0.360906
+ 6.086111 0.196794
+ 6.088889 0.201280
+ 6.091667 0.360945
+ 6.094444 0.209567
+ 6.097222 0.205162
+ 6.100000 0.360990
+ 6.102778 0.226172
+ 6.105556 0.217989
+ 6.108333 0.361000
+ 6.111111 0.237667
+ 6.113889 0.224426
+ 6.116667 0.361040
+ 6.119444 0.237667
+ 6.122222 0.224416
+ 6.125000 0.361025
+ 6.127778 0.241499
+ 6.130556 0.225703
+ 6.133333 0.361020
+ 6.136111 0.241499
+ 6.138889 0.225723
+ 6.141667 0.361040
+ 6.144444 0.238945
+ 6.147222 0.223148
+ 6.150000 0.361025
+ 6.152778 0.242777
+ 6.155556 0.225698
+ 6.158333 0.361025
+ 6.161111 0.241499
+ 6.163889 0.226990
+ 6.166667 0.361030
+ 6.169444 0.237667
+ 6.172222 0.219301
+ 6.175000 0.361030
+ 6.177778 0.238945
+ 6.180556 0.221866
+ 6.183333 0.361010
+ 6.186111 0.237667
+ 6.188889 0.223148
+ 6.191667 0.361025
+ 6.194444 0.235113
+ 6.197222 0.219296
+ 6.200000 0.361015
+ 6.202778 0.240222
+ 6.205556 0.221861
+ 6.208333 0.361005
+ 6.211111 0.235113
+ 6.213889 0.223128
+ 6.216667 0.361025
+ 6.219444 0.228726
+ 6.222222 0.218004
+ 6.225000 0.361005
+ 6.227778 0.236390
+ 6.230556 0.214182
+ 6.233333 0.360975
+ 6.236111 0.233836
+ 6.238889 0.216737
+ 6.241667 0.360995
+ 6.244444 0.231281
+ 6.247222 0.214167
+ 6.250000 0.361000
+ 6.252778 0.232558
+ 6.255556 0.215445
+ 6.258333 0.360995
+ 6.261111 0.232558
+ 6.263889 0.218024
+ 6.266667 0.361010
+ 6.269444 0.228726
+ 6.272222 0.216717
+ 6.275000 0.361000
+ 6.277778 0.237667
+ 6.280556 0.212915
+ 6.283333 0.360985
+ 6.286111 0.233836
+ 6.288889 0.216747
+ 6.291667 0.361005
+ 6.294444 0.233836
+ 6.297222 0.214192
+ 6.300000 0.361000
+ 6.302778 0.236390
+ 6.305556 0.220579
+ 6.308333 0.360990
+ 6.311111 0.236390
+ 6.313889 0.225693
+ 6.316667 0.361040
+ 6.319444 0.232558
+ 6.322222 0.235896
+ 6.325000 0.361080
+ 6.327778 0.241499
+ 6.330556 0.237188
+ 6.333333 0.361070
+ 6.336111 0.240222
+ 6.338889 0.243600
+ 6.341667 0.361105
+ 6.344444 0.241499
+ 6.347222 0.246154
+ 6.350000 0.361110
+ 6.352778 0.247886
+ 6.355556 0.242328
+ 6.358333 0.361085
+ 6.361111 0.247886
+ 6.363889 0.239813
+ 6.366667 0.361090
+ 6.369444 0.249163
+ 6.372222 0.233407
+ 6.375000 0.361080
+ 6.377778 0.247886
+ 6.380556 0.246164
+ 6.383333 0.361085
+ 6.386111 0.245331
+ 6.388889 0.228282
+ 6.391667 0.361035
+ 6.394444 0.237667
+ 6.397222 0.212915
+ 6.400000 0.360985
+ 6.402778 0.240222
+ 6.405556 0.212920
+ 6.408333 0.360975
+ 6.411111 0.235113
+ 6.413889 0.214207
+ 6.416667 0.360975
+ 6.419444 0.236390
+ 6.422222 0.206524
+ 6.425000 0.360955
+ 6.427778 0.237667
+ 6.430556 0.209088
+ 6.433333 0.360955
+ 6.436111 0.237667
+ 6.438889 0.209088
+ 6.441667 0.360970
+ 6.444444 0.217231
+ 6.447222 0.184710
+ 6.450000 0.360856
+ 6.452778 0.203181
+ 6.455556 0.157907
+ 6.458333 0.360766
+ 6.461111 0.301612
+ 6.463889 0.241385
+ 6.466667 0.381711
+ 6.469444 0.414018
+ 6.472222 0.140903
+ 6.475000 0.382565
+ 6.477778 0.314389
+ 6.480556 0.377705
+ 6.483333 0.361240
+ 6.486111 0.226172
+ 6.488889 0.182230
+ 6.491667 0.360901
+ 6.494444 0.227449
+ 6.497222 0.200107
+ 6.500000 0.360941
+ 6.502778 0.228726
+ 6.505556 0.201385
+ 6.508333 0.360936
+ 6.511111 0.230004
+ 6.513889 0.206504
+ 6.516667 0.360955
+ 6.519444 0.224895
+ 6.522222 0.198820
+ 6.525000 0.360941
+ 6.527778 0.230004
+ 6.530556 0.198820
+ 6.533333 0.360926
+ 6.536111 0.227449
+ 6.538889 0.200122
+ 6.541667 0.360936
+ 6.544444 0.224895
+ 6.547222 0.198810
+ 6.550000 0.360936
+ 6.552778 0.230004
+ 6.555556 0.200117
+ 6.558333 0.360926
+ 6.561111 0.230004
+ 6.563889 0.206509
+ 6.566667 0.360955
+ 6.569444 0.230004
+ 6.572222 0.202677
+ 6.575000 0.360960
+ 6.577778 0.233836
+ 6.580556 0.202672
+ 6.583333 0.360936
+ 6.586111 0.228726
+ 6.588889 0.205231
+ 6.591667 0.360941
+ 6.594444 0.224895
+ 6.597222 0.197538
+ 6.600000 0.360941
+ 6.602778 0.227449
+ 6.605556 0.201365
+ 6.608333 0.360936
+ 6.611111 0.219785
+ 6.613889 0.207761
+ 6.616667 0.360950
+ 6.619444 0.217231
+ 6.622222 0.203899
+ 6.625000 0.360965
+ 6.627778 0.215954
+ 6.630556 0.205167
+ 6.633333 0.360955
+ 6.636111 0.214676
+ 6.638889 0.206444
+ 6.641667 0.360960
+ 6.644444 0.201903
+ 6.647222 0.203844
+ 6.650000 0.360945
+ 6.652778 0.201903
+ 6.655556 0.201285
+ 6.658333 0.360936
+ 6.661111 0.195517
+ 6.663889 0.206384
+ 6.666667 0.360950
+ 6.669444 0.192962
+ 6.672222 0.199978
+ 6.675000 0.360941
+ 6.677778 0.196794
+ 6.680556 0.199973
+ 6.683333 0.360931
+ 6.686111 0.194240
+ 6.688889 0.205112
+ 6.691667 0.360955
+ 6.694444 0.200626
+ 6.697222 0.206409
+ 6.700000 0.360970
+ 6.702778 0.213399
+ 6.705556 0.210281
+ 6.708333 0.360975
+ 6.711111 0.222340
+ 6.713889 0.219262
+ 6.716667 0.361015
+ 6.719444 0.226172
+ 6.722222 0.223113
+ 6.725000 0.361025
+ 6.727778 0.236390
+ 6.730556 0.223138
+ 6.733333 0.361020
+ 6.736111 0.231281
+ 6.738889 0.230792
+ 6.741667 0.361045
+ 6.744444 0.230004
+ 6.747222 0.226945
+ 6.750000 0.361050
+ 6.752778 0.233836
+ 6.755556 0.226950
+ 6.758333 0.361030
+ 6.761111 0.228726
+ 6.763889 0.224396
+ 6.766667 0.361030
+ 6.769444 0.227449
+ 6.772222 0.219262
+ 6.775000 0.361010
+ 6.777778 0.233836
+ 6.780556 0.221831
+ 6.783333 0.361010
+ 6.786111 0.227449
+ 6.788889 0.220549
+ 6.791667 0.361015
+ 6.794444 0.228726
+ 6.797222 0.215440
+ 6.800000 0.360995
+ 6.802778 0.228726
+ 6.805556 0.217989
+ 6.808333 0.360995
+ 6.811111 0.224895
+ 6.813889 0.217999
+ 6.816667 0.361010
+ 6.819444 0.221063
+ 6.822222 0.215410
+ 6.825000 0.360995
+ 6.827778 0.224895
+ 6.830556 0.210311
+ 6.833333 0.360965
+ 6.836111 0.222340
+ 6.838889 0.212870
+ 6.841667 0.360990
+ 6.844444 0.222340
+ 6.847222 0.212850
+ 6.850000 0.360990
+ 6.852778 0.224895
+ 6.855556 0.212855
+ 6.858333 0.360965
+ 6.861111 0.222340
+ 6.863889 0.212865
+ 6.866667 0.360980
+ 6.869444 0.219785
+ 6.872222 0.210291
+ 6.875000 0.360985
+ 6.877778 0.224895
+ 6.880556 0.210311
+ 6.883333 0.360965
+ 6.886111 0.222340
+ 6.888889 0.212860
+ 6.891667 0.360990
+ 6.894444 0.218508
+ 6.897222 0.214127
+ 6.900000 0.360990
+ 6.902778 0.223617
+ 6.905556 0.214142
+ 6.908333 0.360980
+ 6.911111 0.222340
+ 6.913889 0.217979
+ 6.916667 0.361005
+ 6.919444 0.219785
+ 6.922222 0.226890
+ 6.925000 0.361045
+ 6.927778 0.223617
+ 6.930556 0.229460
+ 6.933333 0.361040
+ 6.936111 0.230004
+ 6.938889 0.233332
+ 6.941667 0.361075
+ 6.944444 0.223617
+ 6.947222 0.234589
+ 6.950000 0.361080
+ 6.952778 0.232558
+ 6.955556 0.234604
+ 6.958333 0.361065
+ 6.961111 0.235113
+ 6.963889 0.239738
+ 6.966667 0.361080
+ 6.969444 0.227449
+ 6.972222 0.234584
+ 6.975000 0.361095
+ 6.977778 0.230004
+ 6.980556 0.223098
+ 6.983333 0.361000
+ 6.986111 0.219785
+ 6.988889 0.210311
+ 6.991667 0.360960
+ 6.994444 0.218508
+ 6.997222 0.205186
+ 7.000000 0.360970
+ 7.002778 0.218508
+ 7.005556 0.206454
+ 7.008333 0.360950
+ 7.011111 0.219785
+ 7.013889 0.207736
+ 7.016667 0.360960
+ 7.019444 0.218508
+ 7.022222 0.206444
+ 7.025000 0.360960
+ 7.027778 0.221063
+ 7.030556 0.205186
+ 7.033333 0.360941
+ 7.036111 0.203181
+ 7.038889 0.187235
+ 7.041667 0.360856
+ 7.044444 0.180190
+ 7.047222 0.157802
+ 7.050000 0.360741
+ 7.052778 0.254272
+ 7.055556 0.210500
+ 7.058333 0.361050
+ 7.061111 0.307998
+ 7.063889 0.347424
+ 7.066667 0.382215
+ 7.069444 0.412740
+ 7.072222 0.204698
+ 7.075000 0.382714
+ 7.077778 0.306726
+ 7.080556 0.401938
+ 7.083333 0.361414
+ 7.086111 0.185299
+ 7.088889 0.184645
+ 7.091667 0.360846
+ 7.094444 0.204458
+ 7.097222 0.189789
+ 7.100000 0.360916
+ 7.102778 0.208290
+ 7.105556 0.194918
+ 7.108333 0.360911
+ 7.111111 0.203181
+ 7.113889 0.193646
+ 7.116667 0.360906
+ 7.119444 0.201903
+ 7.122222 0.194903
+ 7.125000 0.360921
+ 7.127778 0.207013
+ 7.130556 0.192349
+ 7.133333 0.360891
+ 7.136111 0.204458
+ 7.138889 0.196196
+ 7.141667 0.360931
+ 7.144444 0.203181
+ 7.147222 0.193626
+ 7.150000 0.360921
+ 7.152778 0.208290
+ 7.155556 0.191086
+ 7.158333 0.360901
+ 7.161111 0.204458
+ 7.163889 0.194928
+ 7.166667 0.360906
+ 7.169444 0.203181
+ 7.172222 0.189784
+ 7.175000 0.360906
+ 7.177778 0.208290
+ 7.180556 0.191076
+ 7.183333 0.360896
+ 7.186111 0.201903
+ 7.188889 0.192349
+ 7.191667 0.360921
+ 7.194444 0.205735
+ 7.197222 0.196176
+ 7.200000 0.360921
+ 7.202778 0.201903
+ 7.205556 0.188492
+ 7.208333 0.360891
+ 7.211111 0.200626
+ 7.213889 0.194898
+ 7.216667 0.360916
+ 7.219444 0.187853
+ 7.222222 0.189749
+ 7.225000 0.360911
+ 7.227778 0.196794
+ 7.230556 0.196146
+ 7.233333 0.360901
+ 7.236111 0.194240
+ 7.238889 0.198700
+ 7.241667 0.360936
+ 7.244444 0.182744
+ 7.247222 0.188422
+ 7.250000 0.360896
+ 7.252778 0.176358
+ 7.255556 0.184580
+ 7.258333 0.360846
+ 7.261111 0.171249
+ 7.263889 0.178174
+ 7.266667 0.360866
+ 7.269444 0.164862
+ 7.272222 0.174302
+ 7.275000 0.360856
+ 7.277778 0.167417
+ 7.280556 0.179421
+ 7.283333 0.360841
+ 7.286111 0.173803
+ 7.288889 0.188427
+ 7.291667 0.360896
+ 7.294444 0.182744
+ 7.297222 0.191002
+ 7.300000 0.360941
+ 7.302778 0.195517
+ 7.305556 0.206379
+ 7.308333 0.360965
+ 7.311111 0.204458
+ 7.313889 0.219192
+ 7.316667 0.360990
+ 7.319444 0.208290
+ 7.322222 0.212815
+ 7.325000 0.361010
+ 7.327778 0.213399
+ 7.330556 0.216657
+ 7.333333 0.360980
+ 7.336111 0.214676
+ 7.338889 0.219217
+ 7.341667 0.361005
+ 7.344444 0.208290
+ 7.347222 0.216632
+ 7.350000 0.361005
+ 7.352778 0.213399
+ 7.355556 0.216652
+ 7.358333 0.361000
+ 7.361111 0.210844
+ 7.363889 0.217944
+ 7.366667 0.361000
+ 7.369444 0.207013
+ 7.372222 0.215355
+ 7.375000 0.360980
+ 7.377778 0.209567
+ 7.380556 0.208968
+ 7.383333 0.360970
+ 7.386111 0.207013
+ 7.388889 0.214088
+ 7.391667 0.360990
+ 7.394444 0.204458
+ 7.397222 0.208958
+ 7.400000 0.360975
+ 7.402778 0.207013
+ 7.405556 0.206414
+ 7.408333 0.360950
+ 7.411111 0.204458
+ 7.413889 0.210251
+ 7.416667 0.360975
+ 7.419444 0.204458
+ 7.422222 0.210251
+ 7.425000 0.360975
+ 7.427778 0.207013
+ 7.430556 0.210236
+ 7.433333 0.360960
+ 7.436111 0.200626
+ 7.438889 0.207686
+ 7.441667 0.360965
+ 7.444444 0.203181
+ 7.447222 0.203834
+ 7.450000 0.360955
+ 7.452778 0.203181
+ 7.455556 0.207681
+ 7.458333 0.360950
+ 7.461111 0.205735
+ 7.463889 0.210246
+ 7.466667 0.360970
+ 7.469444 0.201903
+ 7.472222 0.201290
+ 7.475000 0.360950
+ 7.477778 0.209567
+ 7.480556 0.202587
+ 7.483333 0.360955
+ 7.486111 0.208290
+ 7.488889 0.208973
+ 7.491667 0.360955
+ 7.494444 0.205735
+ 7.497222 0.206409
+ 7.500000 0.360975
+ 7.502778 0.210844
+ 7.505556 0.211528
+ 7.508333 0.360960
+ 7.511111 0.207013
+ 7.513889 0.221751
+ 7.516667 0.361035
+ 7.519444 0.208290
+ 7.522222 0.225573
+ 7.525000 0.361040
+ 7.527778 0.214676
+ 7.530556 0.231990
+ 7.533333 0.361055
+ 7.536111 0.223617
+ 7.538889 0.238421
+ 7.541667 0.361070
+ 7.544444 0.219785
+ 7.547222 0.225628
+ 7.550000 0.361050
+ 7.552778 0.227449
+ 7.555556 0.228198
+ 7.558333 0.361030
+ 7.561111 0.223617
+ 7.563889 0.235866
+ 7.566667 0.361080
+ 7.569444 0.217231
+ 7.572222 0.224336
+ 7.575000 0.361030
+ 7.577778 0.219785
+ 7.580556 0.210276
+ 7.583333 0.360955
+ 7.586111 0.215954
+ 7.588889 0.203899
+ 7.591667 0.360950
+ 7.594444 0.212122
+ 7.597222 0.203879
+ 7.600000 0.360955
+ 7.602778 0.217231
+ 7.605556 0.201325
+ 7.608333 0.360941
+ 7.611111 0.215954
+ 7.613889 0.206449
+ 7.616667 0.360965
+ 7.619444 0.212122
+ 7.622222 0.203884
+ 7.625000 0.360955
+ 7.627778 0.218508
+ 7.630556 0.203879
+ 7.633333 0.360936
+ 7.636111 0.204458
+ 7.638889 0.187220
+ 7.641667 0.360846
+ 7.644444 0.178912
+ 7.647222 0.152703
+ 7.650000 0.360751
+ 7.652778 0.283650
+ 7.655556 0.238725
+ 7.658333 0.381701
+ 7.661111 0.393581
+ 7.663889 0.153606
+ 7.666667 0.382639
+ 7.669444 0.284932
+ 7.672222 0.385229
+ 7.675000 0.361255
+ 7.677778 0.198072
+ 7.680556 0.170635
+ 7.683333 0.360846
+ 7.686111 0.208290
+ 7.688889 0.194923
+ 7.691667 0.360906
+ 7.694444 0.200626
+ 7.697222 0.189794
+ 7.700000 0.360911
+ 7.702778 0.205735
+ 7.705556 0.194913
+ 7.708333 0.360906
+ 7.711111 0.205735
+ 7.713889 0.196201
+ 7.716667 0.360921
+ 7.719444 0.205735
+ 7.722222 0.192364
+ 7.725000 0.360921
+ 7.727778 0.210844
+ 7.730556 0.192364
+ 7.733333 0.360921
+ 7.736111 0.209567
+ 7.738889 0.198775
+ 7.741667 0.360931
+ 7.744444 0.208290
+ 7.747222 0.191091
+ 7.750000 0.360911
+ 7.752778 0.212122
+ 7.755556 0.193646
+ 7.758333 0.360906
+ 7.761111 0.213399
+ 7.763889 0.197498
+ 7.766667 0.360926
+ 7.769444 0.209567
+ 7.772222 0.193646
+ 7.775000 0.360911
+ 7.777778 0.210844
+ 7.780556 0.191091
+ 7.783333 0.360901
+ 7.786111 0.209567
+ 7.788889 0.191106
+ 7.791667 0.360906
+ 7.794444 0.204458
+ 7.797222 0.191071
+ 7.800000 0.360906
+ 7.802778 0.207013
+ 7.805556 0.193631
+ 7.808333 0.360911
+ 7.811111 0.199349
+ 7.813889 0.198720
+ 7.816667 0.360926
+ 7.819444 0.196794
+ 7.822222 0.194873
+ 7.825000 0.360921
+ 7.827778 0.198072
+ 7.830556 0.192319
+ 7.833333 0.360906
+ 7.836111 0.187853
+ 7.838889 0.191007
+ 7.841667 0.360901
+ 7.844444 0.181467
+ 7.847222 0.185873
+ 7.850000 0.360896
+ 7.852778 0.175080
+ 7.855556 0.183293
+ 7.858333 0.360871
+ 7.861111 0.173803
+ 7.863889 0.184580
+ 7.866667 0.360881
+ 7.869444 0.171249
+ 7.872222 0.188407
+ 7.875000 0.360886
+ 7.877778 0.185299
+ 7.880556 0.193566
+ 7.883333 0.360901
+ 7.886111 0.199349
+ 7.888889 0.206394
+ 7.891667 0.360970
+ 7.894444 0.212122
+ 7.897222 0.208988
+ 7.900000 0.360995
+ 7.902778 0.222340
+ 7.905556 0.219242
+ 7.908333 0.360995
+ 7.911111 0.226172
+ 7.913889 0.224396
+ 7.916667 0.361020
+ 7.919444 0.223617
+ 7.922222 0.220519
+ 7.925000 0.361015
+ 7.927778 0.226172
+ 7.930556 0.221821
+ 7.933333 0.361015
+ 7.936111 0.224895
+ 7.938889 0.225653
+ 7.941667 0.361045
+ 7.944444 0.223617
+ 7.947222 0.224356
+ 7.950000 0.361030
+ 7.952778 0.226172
+ 7.955556 0.220539
+ 7.958333 0.361000
+ 7.961111 0.226172
+ 7.963889 0.225658
+ 7.966667 0.361040
+ 7.969444 0.222340
+ 7.972222 0.216697
+ 7.975000 0.361010
+ 7.977778 0.223617
+ 7.980556 0.219252
+ 7.983333 0.360995
+ 7.986111 0.223617
+ 7.988889 0.221811
+ 7.991667 0.361000
+ 7.994444 0.217231
+ 7.997222 0.216682
+ 8.000000 0.361005
+ 8.002778 0.221063
+ 8.005556 0.217954
+ 8.008333 0.360985
+ 8.011111 0.217231
+ 8.013889 0.216692
+ 8.016667 0.361010
+ 8.019444 0.217231
+ 8.022222 0.212840
+ 8.025000 0.360985
+ 8.027778 0.218508
+ 8.030556 0.214132
+ 8.033333 0.360975
+ 8.036111 0.222340
+ 8.038889 0.217984
+ 8.041667 0.361005
+ 8.044444 0.219785
+ 8.047222 0.215400
+ 8.050000 0.361000
+ 8.052778 0.222340
+ 8.055556 0.212860
+ 8.058333 0.360990
+ 8.061111 0.223617
+ 8.063889 0.216707
+ 8.066667 0.361000
+ 8.069444 0.219785
+ 8.072222 0.217974
+ 8.075000 0.361025
+ 8.077778 0.224895
+ 8.080556 0.216692
+ 8.083333 0.360995
+ 8.086111 0.223617
+ 8.088889 0.217999
+ 8.091667 0.361005
+ 8.094444 0.223617
+ 8.097222 0.215415
+ 8.100000 0.361010
+ 8.102778 0.231281
+ 8.105556 0.215430
+ 8.108333 0.360990
+ 8.111111 0.224895
+ 8.113889 0.220544
+ 8.116667 0.361025
+ 8.119444 0.223617
+ 8.122222 0.233302
+ 8.125000 0.361080
+ 8.127778 0.231281
+ 8.130556 0.235881
+ 8.133333 0.361080
+ 8.136111 0.235113
+ 8.138889 0.247417
+ 8.141667 0.361120
+ 8.144444 0.235113
+ 8.147222 0.243560
+ 8.150000 0.361105
+ 8.152778 0.242777
+ 8.155556 0.238486
+ 8.158333 0.361080
+ 8.161111 0.244054
+ 8.163889 0.239778
+ 8.166667 0.361070
+ 8.169444 0.241499
+ 8.172222 0.243595
+ 8.175000 0.361115
+ 8.177778 0.241499
+ 8.180556 0.233357
+ 8.183333 0.361035
+ 8.186111 0.236390
+ 8.188889 0.223148
+ 8.191667 0.361010
+ 8.194444 0.235113
+ 8.197222 0.216732
+ 8.200000 0.360990
+ 8.202778 0.233836
+ 8.205556 0.210346
+ 8.208333 0.360965
+ 8.211111 0.230004
+ 8.213889 0.211638
+ 8.216667 0.360975
+ 8.219444 0.230004
+ 8.222222 0.207781
+ 8.225000 0.360975
+ 8.227778 0.232558
+ 8.230556 0.205231
+ 8.233333 0.360950
+ 8.236111 0.231281
+ 8.238889 0.209073
+ 8.241667 0.360960
+ 8.244444 0.224895
+ 8.247222 0.205206
+ 8.250000 0.360955
+ 8.252778 0.208290
+ 8.255556 0.177006
+ 8.258333 0.360831
+ 8.261111 0.201903
+ 8.263889 0.159264
+ 8.266667 0.381262
+ 8.269444 0.324603
+ 8.272222 0.270857
+ 8.275000 0.381841
+ 8.277778 0.452336
+ 8.280556 0.184471
+ 8.283333 0.382699
+ 8.286111 0.336103
+ 8.288889 0.418663
+ 8.291667 0.361365
+ 8.294444 0.219785
+ 8.297222 0.171967
+ 8.300000 0.360871
+ 8.302778 0.224895
+ 8.305556 0.200102
+ 8.308333 0.360921
+ 8.311111 0.221063
+ 8.313889 0.205201
+ 8.316667 0.360965
+ 8.319444 0.219785
+ 8.322222 0.201345
+ 8.325000 0.360941
+ 8.327778 0.221063
+ 8.330556 0.200077
+ 8.333333 0.360931
+ 8.336111 0.218508
+ 8.338889 0.198805
+ 8.341667 0.360931
+ 8.344444 0.215954
+ 8.347222 0.194963
+ 8.350000 0.360921
+ 8.352778 0.222340
+ 8.355556 0.198800
+ 8.358333 0.360916
+ 8.361111 0.221063
+ 8.363889 0.201365
+ 8.366667 0.360936
+ 8.369444 0.219785
+ 8.372222 0.200072
+ 8.375000 0.360945
+ 8.377778 0.222340
+ 8.380556 0.202637
+ 8.383333 0.360926
+ 8.386111 0.219785
+ 8.388889 0.205201
+ 8.391667 0.360926
+ 8.394444 0.217231
+ 8.397222 0.197513
+ 8.400000 0.360941
+ 8.402778 0.221063
+ 8.405556 0.200072
+ 8.408333 0.360921
+ 8.411111 0.219785
+ 8.413889 0.201355
+ 8.416667 0.360941
+ 8.419444 0.214676
+ 8.422222 0.198780
+ 8.425000 0.360926
+ 8.427778 0.210844
+ 8.430556 0.200052
+ 8.433333 0.360931
+ 8.436111 0.210844
+ 8.438889 0.203894
+ 8.441667 0.360945
+ 8.444444 0.207013
+ 8.447222 0.201300
+ 8.450000 0.360936
+ 8.452778 0.204458
+ 8.455556 0.198735
+ 8.458333 0.360926
+ 8.461111 0.200626
+ 8.463889 0.201270
+ 8.466667 0.360941
+ 8.469444 0.190408
+ 8.472222 0.194853
+ 8.475000 0.360926
+ 8.477778 0.185299
+ 8.480556 0.193546
+ 8.483333 0.360911
+ 8.486111 0.178912
+ 8.488889 0.196096
+ 8.491667 0.360926
+ 8.494444 0.176358
+ 8.497222 0.197348
+ 8.500000 0.360931
+ 8.502778 0.182744
+ 8.505556 0.197373
+ 8.508333 0.360906
+ 8.511111 0.191685
+ 8.513889 0.201255
+ 8.516667 0.360941
+ 8.519444 0.199349
+ 8.522222 0.205127
+ 8.525000 0.360975
+ 8.527778 0.218508
+ 8.530556 0.214118
+ 8.533333 0.360980
+ 8.536111 0.223617
+ 8.538889 0.220539
+ 8.541667 0.361025
+ 8.544444 0.228726
+ 8.547222 0.223098
+ 8.550000 0.361040
+ 8.552778 0.235113
+ 8.555556 0.225678
+ 8.558333 0.361030
+ 8.561111 0.232558
+ 8.563889 0.226950
+ 8.566667 0.361050
+ 8.569444 0.230004
+ 8.572222 0.223103
+ 8.575000 0.361035
+ 8.577778 0.231281
+ 8.580556 0.223108
+ 8.583333 0.361025
+ 8.586111 0.232558
+ 8.588889 0.224396
+ 8.591667 0.361035
+ 8.594444 0.227449
+ 8.597222 0.220544
+ 8.600000 0.361025
+ 8.602778 0.232558
+ 8.605556 0.223113
+ 8.608333 0.361035
+ 8.611111 0.230004
+ 8.613889 0.224381
+ 8.616667 0.361020
+ 8.619444 0.227449
+ 8.622222 0.216717
+ 8.625000 0.361000
+ 8.627778 0.228726
+ 8.630556 0.215425
+ 8.633333 0.360985
+ 8.636111 0.230004
+ 8.638889 0.216722
+ 8.641667 0.361000
+ 8.644444 0.222340
+ 8.647222 0.212870
+ 8.650000 0.360990
+ 8.652778 0.226172
+ 8.655556 0.212875
+ 8.658333 0.360980
+ 8.661111 0.226172
+ 8.663889 0.214157
+ 8.666667 0.360990
+ 8.669444 0.223617
+ 8.672222 0.216682
+ 8.675000 0.361000
+ 8.677778 0.227449
+ 8.680556 0.214152
+ 8.683333 0.360970
+ 8.686111 0.224895
+ 8.688889 0.214157
+ 8.691667 0.360980
+ 8.694444 0.223617
+ 8.697222 0.209033
+ 8.700000 0.360975
+ 8.702778 0.226172
+ 8.705556 0.207761
+ 8.708333 0.360970
+ 8.711111 0.228726
+ 8.713889 0.209058
+ 8.716667 0.360975
+ 8.719444 0.224895
+ 8.722222 0.209038
+ 8.725000 0.360980
+ 8.727778 0.227449
+ 8.730556 0.210331
+ 8.733333 0.360970
+ 8.736111 0.230004
+ 8.738889 0.215450
+ 8.741667 0.361000
+ 8.744444 0.224895
+ 8.747222 0.214157
+ 8.750000 0.361005
+ 8.752778 0.232558
+ 8.755556 0.220554
+ 8.758333 0.360990
+ 8.761111 0.232558
+ 8.763889 0.223123
+ 8.766667 0.361025
+ 8.769444 0.227449
+ 8.772222 0.228208
+ 8.775000 0.361060
+ 8.777778 0.235113
+ 8.780556 0.232054
+ 8.783333 0.361060
+ 8.786111 0.235113
+ 8.788889 0.241025
+ 8.791667 0.361085
+ 8.794444 0.241499
+ 8.797222 0.237188
+ 8.800000 0.361085
+ 8.802778 0.245331
+ 8.805556 0.237208
+ 8.808333 0.361060
+ 8.811111 0.250440
+ 8.813889 0.237238
+ 8.816667 0.361070
+ 8.819444 0.246608
+ 8.822222 0.239763
+ 8.825000 0.361110
+ 8.827778 0.241499
+ 8.830556 0.228262
+ 8.833333 0.361020
+ 8.836111 0.240222
+ 8.838889 0.216762
+ 8.841667 0.360985
+ 8.844444 0.235113
+ 8.847222 0.206524
+ 8.850000 0.360970
+ 8.852778 0.238945
+ 8.855556 0.211628
+ 8.858333 0.360960
+ 8.861111 0.236390
+ 8.863889 0.209083
+ 8.866667 0.360960
+ 8.869444 0.230004
+ 8.872222 0.205231
+ 8.875000 0.360965
+ 8.877778 0.232558
+ 8.880556 0.205231
+ 8.883333 0.360950
+ 8.886111 0.235113
+ 8.888889 0.207816
+ 8.891667 0.360965
+ 8.894444 0.226172
+ 8.897222 0.200097
+ 8.900000 0.360941
+ 8.902778 0.213399
+ 8.905556 0.177036
+ )
Vrpeak rpeak_pulse 0 PWL(
+ 0 0
+ 0.1999000 0
+ 0.1999500 0.9
+ 0.2005000 0.9
+ 0.2005500 0
+ 0.8526778 0
+ 0.8527278 0.9
+ 0.8532778 0.9
+ 0.8533278 0
+ 1.8471222 0
+ 1.8471722 0.9
+ 1.8477222 0.9
+ 1.8477722 0
+ 2.6915667 0
+ 2.6916167 0.9
+ 2.6921667 0.9
+ 2.6922167 0
+ 3.5026778 0
+ 3.5027278 0.9
+ 3.5032778 0.9
+ 3.5033278 0
+ 4.2915667 0
+ 4.2916167 0.9
+ 4.2921667 0.9
+ 4.2922167 0
+ 5.0637889 0
+ 5.0638389 0.9
+ 5.0643889 0.9
+ 5.0644389 0
+ 5.9026778 0
+ 5.9027278 0.9
+ 5.9032778 0.9
+ 5.9033278 0
+ 6.7582333 0
+ 6.7582833 0.9
+ 6.7588333 0.9
+ 6.7588833 0
+ 7.5804556 0
+ 7.5805056 0.9
+ 7.5810556 0.9
+ 7.5811056 0
+ )

Xdelay rpeak_pulse trig_s14 trig_s69 trig_wid trig_bi_copy trig_rr_copy vdd vss vbias vth_14 vth_69 vth_83 vth_300 vth_10 delay_timer
Vth14 vth_14 0 0.4757
Vth69 vth_69 0 0.4471
Vth83 vth_83 0 0.4684
Vth300 vth_300 0 0.3269
Vth10 vth_10 0 0.2282

Xrr ecg_amp_l0 trig_rr_cap rpeak_pulse trig_rr_copy f1_rr_ratio f2_rr_asym rr_timer_node rr_ewma_node vdd vss vbias rr_timing

Vthpb vth_pw_base 0 0.39
Vthpp vth_pw_peak 0 0.375
Xpw rr_timer_node rr_ewma_node trig_pw_base trig_pw_peak trig_rr_cap vth_pw_base vth_pw_peak vdd vss vbias pwave_predictor

Xbi_l0 ecg_amp_l0 rpeak_pulse trig_bi_copy f3_bi_l0 vdd vss vbias beat_instability
Xbi_l1 ecg_amp_l1 rpeak_pulse trig_bi_copy f4_bi_l1 vdd vss vbias beat_instability
Xpwave ecg_amp_l0 trig_pw_base trig_pw_peak f5_pwave vdd vss vbias pwave_diff
Xwidth ecg_amp_l0 trig_wid f6_width vdd vss qrs_width
Xslope ecg_amp_l0 trig_s14 trig_s69 f7_slope vdd vss vbias qrs_slope
Xsym ecg_amp_l0 rpeak_pulse f8_symmetry vdd vss qrs_symmetry

* Timer ICs
.ic v(xdelay.timer_node) = 0.9
.ic v(xdelay.timer2) = 0.9
.ic v(xrr.net_timer) = 0.9
* FIXED: Set ewma and prev within the RR timer's operating range
.ic v(xrr.ewma_node) = 0.40
.ic v(xrr.prev_node) = 0.40
.ic v(xrr.esamp_node) = 0.40

.tran 0.5m 8.908 uic

.meas tran f1_rr_ratio_b1 FIND V(f1_rr_ratio) AT=0.842778
.meas tran f2_rr_asym_b1 FIND V(f2_rr_asym) AT=0.842778
.meas tran f3_bi_l0_b1 FIND V(f3_bi_l0) AT=0.842778
.meas tran f4_bi_l1_b1 FIND V(f4_bi_l1) AT=0.842778
.meas tran f5_pwave_b1 FIND V(f5_pwave) AT=0.842778
.meas tran f6_width_b1 FIND V(f6_width) AT=0.842778
.meas tran f7_slope_b1 FIND V(f7_slope) AT=0.842778
.meas tran f8_symmetry_b1 FIND V(f8_symmetry) AT=0.842778
.meas tran f1_rr_ratio_b2 FIND V(f1_rr_ratio) AT=1.837222
.meas tran f2_rr_asym_b2 FIND V(f2_rr_asym) AT=1.837222
.meas tran f3_bi_l0_b2 FIND V(f3_bi_l0) AT=1.837222
.meas tran f4_bi_l1_b2 FIND V(f4_bi_l1) AT=1.837222
.meas tran f5_pwave_b2 FIND V(f5_pwave) AT=1.837222
.meas tran f6_width_b2 FIND V(f6_width) AT=1.837222
.meas tran f7_slope_b2 FIND V(f7_slope) AT=1.837222
.meas tran f8_symmetry_b2 FIND V(f8_symmetry) AT=1.837222
.meas tran f1_rr_ratio_b3 FIND V(f1_rr_ratio) AT=2.681667
.meas tran f2_rr_asym_b3 FIND V(f2_rr_asym) AT=2.681667
.meas tran f3_bi_l0_b3 FIND V(f3_bi_l0) AT=2.681667
.meas tran f4_bi_l1_b3 FIND V(f4_bi_l1) AT=2.681667
.meas tran f5_pwave_b3 FIND V(f5_pwave) AT=2.681667
.meas tran f6_width_b3 FIND V(f6_width) AT=2.681667
.meas tran f7_slope_b3 FIND V(f7_slope) AT=2.681667
.meas tran f8_symmetry_b3 FIND V(f8_symmetry) AT=2.681667
.meas tran f1_rr_ratio_b4 FIND V(f1_rr_ratio) AT=3.492778
.meas tran f2_rr_asym_b4 FIND V(f2_rr_asym) AT=3.492778
.meas tran f3_bi_l0_b4 FIND V(f3_bi_l0) AT=3.492778
.meas tran f4_bi_l1_b4 FIND V(f4_bi_l1) AT=3.492778
.meas tran f5_pwave_b4 FIND V(f5_pwave) AT=3.492778
.meas tran f6_width_b4 FIND V(f6_width) AT=3.492778
.meas tran f7_slope_b4 FIND V(f7_slope) AT=3.492778
.meas tran f8_symmetry_b4 FIND V(f8_symmetry) AT=3.492778
.meas tran f1_rr_ratio_b5 FIND V(f1_rr_ratio) AT=4.281667
.meas tran f2_rr_asym_b5 FIND V(f2_rr_asym) AT=4.281667
.meas tran f3_bi_l0_b5 FIND V(f3_bi_l0) AT=4.281667
.meas tran f4_bi_l1_b5 FIND V(f4_bi_l1) AT=4.281667
.meas tran f5_pwave_b5 FIND V(f5_pwave) AT=4.281667
.meas tran f6_width_b5 FIND V(f6_width) AT=4.281667
.meas tran f7_slope_b5 FIND V(f7_slope) AT=4.281667
.meas tran f8_symmetry_b5 FIND V(f8_symmetry) AT=4.281667
.meas tran f1_rr_ratio_b6 FIND V(f1_rr_ratio) AT=5.053889
.meas tran f2_rr_asym_b6 FIND V(f2_rr_asym) AT=5.053889
.meas tran f3_bi_l0_b6 FIND V(f3_bi_l0) AT=5.053889
.meas tran f4_bi_l1_b6 FIND V(f4_bi_l1) AT=5.053889
.meas tran f5_pwave_b6 FIND V(f5_pwave) AT=5.053889
.meas tran f6_width_b6 FIND V(f6_width) AT=5.053889
.meas tran f7_slope_b6 FIND V(f7_slope) AT=5.053889
.meas tran f8_symmetry_b6 FIND V(f8_symmetry) AT=5.053889
.meas tran f1_rr_ratio_b7 FIND V(f1_rr_ratio) AT=5.892778
.meas tran f2_rr_asym_b7 FIND V(f2_rr_asym) AT=5.892778
.meas tran f3_bi_l0_b7 FIND V(f3_bi_l0) AT=5.892778
.meas tran f4_bi_l1_b7 FIND V(f4_bi_l1) AT=5.892778
.meas tran f5_pwave_b7 FIND V(f5_pwave) AT=5.892778
.meas tran f6_width_b7 FIND V(f6_width) AT=5.892778
.meas tran f7_slope_b7 FIND V(f7_slope) AT=5.892778
.meas tran f8_symmetry_b7 FIND V(f8_symmetry) AT=5.892778
.meas tran f1_rr_ratio_b8 FIND V(f1_rr_ratio) AT=6.748333
.meas tran f2_rr_asym_b8 FIND V(f2_rr_asym) AT=6.748333
.meas tran f3_bi_l0_b8 FIND V(f3_bi_l0) AT=6.748333
.meas tran f4_bi_l1_b8 FIND V(f4_bi_l1) AT=6.748333
.meas tran f5_pwave_b8 FIND V(f5_pwave) AT=6.748333
.meas tran f6_width_b8 FIND V(f6_width) AT=6.748333
.meas tran f7_slope_b8 FIND V(f7_slope) AT=6.748333
.meas tran f8_symmetry_b8 FIND V(f8_symmetry) AT=6.748333
.meas tran f1_rr_ratio_b9 FIND V(f1_rr_ratio) AT=7.570556
.meas tran f2_rr_asym_b9 FIND V(f2_rr_asym) AT=7.570556
.meas tran f3_bi_l0_b9 FIND V(f3_bi_l0) AT=7.570556
.meas tran f4_bi_l1_b9 FIND V(f4_bi_l1) AT=7.570556
.meas tran f5_pwave_b9 FIND V(f5_pwave) AT=7.570556
.meas tran f6_width_b9 FIND V(f6_width) AT=7.570556
.meas tran f7_slope_b9 FIND V(f7_slope) AT=7.570556
.meas tran f8_symmetry_b9 FIND V(f8_symmetry) AT=7.570556
.meas tran rrsf_50ms_b1 FIND V(rr_timer_node) AT=0.902778
.meas tran ewma_b1_50 FIND V(rr_ewma_node) AT=0.902778
.meas tran rrsf_300ms_b1 FIND V(rr_timer_node) AT=1.152778
.meas tran ewma_b1_300 FIND V(rr_ewma_node) AT=1.152778
.meas tran rrsf_600ms_b1 FIND V(rr_timer_node) AT=1.452778
.meas tran ewma_b1_600 FIND V(rr_ewma_node) AT=1.452778
.meas tran rrsf_50ms_b2 FIND V(rr_timer_node) AT=1.897222
.meas tran ewma_b2_50 FIND V(rr_ewma_node) AT=1.897222
.meas tran rrsf_300ms_b2 FIND V(rr_timer_node) AT=2.147222
.meas tran ewma_b2_300 FIND V(rr_ewma_node) AT=2.147222
.meas tran rrsf_600ms_b2 FIND V(rr_timer_node) AT=2.447222
.meas tran ewma_b2_600 FIND V(rr_ewma_node) AT=2.447222
.meas tran rrsf_50ms_b3 FIND V(rr_timer_node) AT=2.741667
.meas tran ewma_b3_50 FIND V(rr_ewma_node) AT=2.741667
.meas tran rrsf_300ms_b3 FIND V(rr_timer_node) AT=2.991667
.meas tran ewma_b3_300 FIND V(rr_ewma_node) AT=2.991667
.meas tran rrsf_600ms_b3 FIND V(rr_timer_node) AT=3.291667
.meas tran ewma_b3_600 FIND V(rr_ewma_node) AT=3.291667
.meas tran rrsf_50ms_b4 FIND V(rr_timer_node) AT=3.552778
.meas tran ewma_b4_50 FIND V(rr_ewma_node) AT=3.552778
.meas tran rrsf_300ms_b4 FIND V(rr_timer_node) AT=3.802778
.meas tran ewma_b4_300 FIND V(rr_ewma_node) AT=3.802778
.meas tran rrsf_600ms_b4 FIND V(rr_timer_node) AT=4.102778
.meas tran ewma_b4_600 FIND V(rr_ewma_node) AT=4.102778
.meas tran pwbase_b2 FIND V(trig_pw_base) AT=1.657222
.meas tran pwpeak_b2 FIND V(trig_pw_peak) AT=1.727222
.meas tran rrcap_b2 FIND V(trig_rr_cap) AT=1.848222
.meas tran pwbase_b3 FIND V(trig_pw_base) AT=2.501667
.meas tran pwpeak_b3 FIND V(trig_pw_peak) AT=2.571667
.meas tran rrcap_b3 FIND V(trig_rr_cap) AT=2.692667
.meas tran pwbase_b4 FIND V(trig_pw_base) AT=3.312778
.meas tran pwpeak_b4 FIND V(trig_pw_peak) AT=3.382778
.meas tran rrcap_b4 FIND V(trig_rr_cap) AT=3.503778
.meas tran trg_s14_b1 FIND V(trig_s14) AT=0.904778
.meas tran trg_s14_b2 FIND V(trig_s14) AT=1.899222
.meas tran trg_s14_b3 FIND V(trig_s14) AT=2.743667
.meas tran avg_idd AVG I(Vdd) FROM=0.5 TO=8.908

.control
run
.endc
.end
