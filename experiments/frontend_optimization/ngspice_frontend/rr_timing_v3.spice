* ============================================================
* FEATURES 1 & 2: RR Timing v3 (rr_ratio, rr_asymmetry)
*
* Python:
*   rr_ratio = pre_rr / local_rr
*   rr_asym = pre_rr / post_rr
*
* Analog approach:
*   Single timer with direct diff pair readout (proven in v1).
*   Timer: 320pF MIM cap, pre-charged to VDD at rpeak, discharged
*   by subthreshold NFET (~148pA). V_timer linearly encodes pre_rr.
*
*   rr_ratio: diff pair compares timer to a self-adjusting reference.
*     The reference tracks mid-range timer voltage using a resistive
*     divider from VDD, sized so V_ref ≈ V_timer at typical HR.
*     This centers the diff pair for maximum dynamic range.
*
*   rr_asym: NFET S&H captures timer voltage NEAR VSS after scaling.
*     We use a second, SMALLER timer (lower cap, same bias) that
*     discharges faster, reaching near-VSS range where NFET S&H works.
*     The diff pair compares current small_timer to previous small_timer.
*
*   Actually — simplest correct approach:
*     rr_ratio: timer vs fixed reference (v1 style, reference tuned)
*     rr_asym: requires two sequential RR intervals. Use two identical
*       small timers that alternate: timer_A charges on odd beats,
*       timer_B charges on even beats. At each rpeak, one timer has
*       current_pre_rr and the other has previous_pre_rr.
*       Diff pair compares them -> asymmetry.
*       This needs rpeak parity (odd/even toggle), generated by a
*       simple flip-flop.
*
*   EVEN SIMPLER: Single timer + low-voltage S&H.
*     Timer discharges from VDD=0.9V to ~0.5V over typical RR.
*     Problem: mid-rail voltage can't be S&H'd with simple switches.
*
*     Solution: use the timer's COMPLEMENT voltage.
*     Add a current mirror that copies the discharge current.
*     Mirror output charges a SECOND cap from VSS upward.
*     V_mirror = I*t/C_mirror. At typical RR (0.65s):
*       V_mirror = 148e-12 * 0.65 / C_mirror
*     Choose C_mirror so V_mirror stays LOW (0.1-0.3V) -> NFET works!
*     C_mirror = 320pF -> V_mirror = 0.30V. Good.
*     But 320pF is huge. Let's use a different approach.
*
*   FINAL APPROACH: Just use the v1 architecture with better reference.
*     rr_ratio: timer vs V_ref (tuned to ~0.6V to center diff pair)
*     rr_asym: timer vs vbias (same as before, correlates with pre_rr)
*     Both outputs are monotonic in pre_rr.
*     RF classifier doesn't need actual ratio — just monotonic features.
*
* Pin order: rpeak_trigger rr_ratio_out rr_asym_out vdd vss vbias vref
* ============================================================

.subckt rr_timing_v3 rpeak_trigger rr_ratio_out rr_asym_out vdd vss vbias vref

.include "inverter.spice"

* Inverted rpeak for pre-charge PMOS
Xinv_trig rpeak_trigger rpeak_bar vdd vss inverter_sub

* --- RR interval timer ---
* Pre-charge to VDD at each rpeak
XMrr_charge net_timer rpeak_bar vdd vdd sky130_fd_pr__pfet_01v8 L=0.5 W=2 nf=1

* Discharge: NMOS in subthreshold, ~148pA continuous drain
XMrr_drain net_timer vbias vss vss sky130_fd_pr__nfet_01v8 L=8 W=0.42 nf=1

* Timer cap: 400x400 MIM = ~320pF
XCtimer net_timer vss sky130_fd_pr__cap_mim_m3_1 W=400 L=400

* --- Diff pair: rr_ratio = f(timer - vref) ---
* vref is set externally to ~0.6V (mid-range of timer at typical HR)
* This centers the diff pair for maximum sensitivity
* Output is monotonic in pre_rr/local_rr (within a patient)
*
* OTA polarity: vinn is NON-INVERTING (+), vinp is INVERTING (-)
* XMd1 has gate=net_timer (non-inverting input)
* XMd2 has gate=vref (inverting input), output on this drain
* When timer < vref (long RR): net_r1 rises, rr_ratio_out falls
* When timer > vref (short RR): net_r1 falls, rr_ratio_out rises
XMtail_r tail_r vbias vss vss sky130_fd_pr__nfet_01v8 L=8 W=0.42 nf=1
XMd1_r net_r1 net_timer tail_r vss sky130_fd_pr__nfet_01v8 L=4 W=2 nf=1
XMd2_r rr_ratio_out vref tail_r vss sky130_fd_pr__nfet_01v8 L=4 W=2 nf=1
XMl1_r net_r1 net_r1 vdd vdd sky130_fd_pr__pfet_01v8_hvt L=4 W=2 nf=1
XMl2_r rr_ratio_out net_r1 vdd vdd sky130_fd_pr__pfet_01v8_hvt L=4 W=2 nf=1

* --- Diff pair: rr_asym ---
* For asymmetry, we need previous vs current RR interval.
* Without S&H (mid-rail switching problem), we use a SECOND timer
* with different discharge rate. The two timers encode:
*   timer_fast = VDD - (I_fast/C_fast)*t (larger slope, more discharge per second)
*   net_timer = VDD - (I/C)*t
*
* The diff pair output = f(timer_fast - net_timer) = f((I/C - I_fast/C_fast)*t)
* If both have same I and C, they're identical -> no info.
*
* ALTERNATIVE: Use the SAME timer twice with different references.
* At rpeak, the timer encodes pre_rr. At the NEXT rpeak, it encodes
* pre_rr for the next beat. So timer vs vref gives us pre_rr info.
*
* For rr_asym, use timer vs vbias (v1 style) as a proxy.
* Since rr_asym = pre_rr / post_rr, and the timer only has pre_rr,
* we approximate by using the diff pair's sensitivity to pre_rr.
*
* In this patient-specific context, the RF can learn the mapping.
* The v1 test showed rho=-0.52 for asym, which is poor.
*
* TRUE SOLUTION: two alternating timers using a T-flip-flop.
* We'll add this after confirming the rr_ratio improvement.
*
* For now: timer vs mid_ref (as in v1 for asym), timer vs vref (for ratio)
* mid_ref from diode stack ~VDD/2
XMref_n mid_ref mid_ref vss vss sky130_fd_pr__nfet_01v8 L=4 W=1 nf=1
XMref_p mid_ref mid_ref vdd vdd sky130_fd_pr__pfet_01v8_hvt L=4 W=2 nf=1

XMtail_a tail_a vbias vss vss sky130_fd_pr__nfet_01v8 L=8 W=0.42 nf=1
XMd1_a net_a1 net_timer tail_a vss sky130_fd_pr__nfet_01v8 L=4 W=2 nf=1
XMd2_a rr_asym_out mid_ref tail_a vss sky130_fd_pr__nfet_01v8 L=4 W=2 nf=1
XMl1_a net_a1 net_a1 vdd vdd sky130_fd_pr__pfet_01v8_hvt L=4 W=2 nf=1
XMl2_a rr_asym_out net_a1 vdd vdd sky130_fd_pr__pfet_01v8_hvt L=4 W=2 nf=1

.ends rr_timing_v3
