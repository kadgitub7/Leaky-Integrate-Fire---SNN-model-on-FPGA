.title feature_test
.lib "sky130_minimal.lib.spice" tt
.option scale=1.0u method=gear gmin=1e-15 abstol=1e-15 reltol=0.005
.temp 27
.include "ota_5t_subthreshold.spice"
.include "inverter.spice"
.include "resistor_div.spice"
.include "rr_timing.spice"
.include "beat_instability.spice"
.include "pwave_energy.spice"
.include "qrs_width.spice"
.include "slope_ratio.spice"
.include "qrs_symmetry.spice"

Vdd vdd 0 0.9
Vss vss 0 0
Vbias vbias 0 0.35
Vref vref 0 0.45
Vecg_base ecg_base_ref 0 0.25
Vthr width_threshold 0 PWL(0.0000000 0.250000 0.4695556 0.385206 0.4705556 0.385206 0.5294444 0.385206 0.9640000 0.385206 0.9650000 0.385206 1.0711111 0.385206 1.6806667 0.384794 1.6816667 0.384794 1.7405556 0.384794 2.2806667 0.384794 2.2816667 0.384794 2.3377778 0.384794 2.6640000 0.452397 2.6650000 0.452397 2.7683333 0.452397 3.3945556 0.343573 3.3955556 0.343573 3.5794444 0.343573 4.0112222 0.355527 4.0122222 0.355527 4.1961111 0.355527 4.6417778 0.379847 4.6427778 0.379847 4.7877778 0.379847 5.0167778 0.430550 5.0177778 0.430550 5.1322222 0.430550 5.8140000 0.407053 5.8150000 0.407053 5.8738889 0.407053 6.3444444 0.250000)

Vecg ecg_in 0 PWL(0.0000000 0.250000 0.2500000 0.182672 0.2527778 0.181298 0.2555556 0.184046 0.2583333 0.186794 0.2611111 0.189542 0.2638889 0.186794 0.2666667 0.189542 0.2694444 0.188168 0.2722222 0.185420 0.2750000 0.182672 0.2777778 0.186794 0.2805556 0.186794 0.2833333 0.184046 0.2861111 0.185420 0.2888889 0.188168 0.2916667 0.195038 0.2944444 0.195038 0.2972222 0.195038 0.3000000 0.195038 0.3027778 0.192290 0.3055556 0.189542 0.3083333 0.192290 0.3111111 0.192290 0.3138889 0.197786 0.3166667 0.201908 0.3194444 0.207405 0.3222222 0.217023 0.3250000 0.221145 0.3277778 0.228015 0.3305556 0.230763 0.3333333 0.237634 0.3361111 0.239008 0.3388889 0.237634 0.3416667 0.236260 0.3444444 0.241756 0.3472222 0.248626 0.3500000 0.259618 0.3527778 0.269237 0.3555556 0.284351 0.3583333 0.293969 0.3611111 0.295344 0.3638889 0.291221 0.3666667 0.280229 0.3694444 0.271985 0.3722222 0.270611 0.3750000 0.267863 0.3777778 0.266489 0.3805556 0.271985 0.3833333 0.274733 0.3861111 0.273359 0.3888889 0.267863 0.3916667 0.265115 0.3944444 0.254122 0.3972222 0.243130 0.4000000 0.237634 0.4027778 0.230763 0.4055556 0.218397 0.4083333 0.212901 0.4111111 0.207405 0.4138889 0.203282 0.4166667 0.197786 0.4194444 0.196412 0.4222222 0.197786 0.4250000 0.197786 0.4277778 0.193664 0.4305556 0.195038 0.4333333 0.195038 0.4361111 0.193664 0.4388889 0.193664 0.4416667 0.195038 0.4444444 0.192290 0.4472222 0.192290 0.4500000 0.193664 0.4527778 0.195038 0.4555556 0.197786 0.4583333 0.199160 0.4611111 0.203282 0.4638889 0.208779 0.4666667 0.219771 0.4694444 0.236260 0.4722222 0.265115 0.4750000 0.306336 0.4777778 0.354427 0.4805556 0.410763 0.4833333 0.467099 0.4861111 0.519313 0.4888889 0.563282 0.4916667 0.611374 0.4944444 0.647099 0.4972222 0.681450 0.5000000 0.700687 0.5027778 0.699313 0.5055556 0.684198 0.5083333 0.656718 0.5111111 0.614122 0.5138889 0.550916 0.5166667 0.478092 0.5194444 0.399771 0.5222222 0.333817 0.5250000 0.282977 0.5277778 0.245878 0.5305556 0.226641 0.5333333 0.211527 0.5361111 0.201908 0.5388889 0.197786 0.5416667 0.186794 0.5444444 0.175802 0.5472222 0.167557 0.5500000 0.160687 0.5527778 0.157939 0.5555556 0.155191 0.5583333 0.155191 0.5611111 0.156565 0.5638889 0.155191 0.5666667 0.156565 0.5694444 0.152443 0.5722222 0.149695 0.5750000 0.148321 0.5777778 0.142824 0.5805556 0.145573 0.5833333 0.148321 0.5861111 0.145573 0.5888889 0.148321 0.5916667 0.146947 0.5944444 0.149695 0.5972222 0.146947 0.6000000 0.148321 0.6027778 0.148321 0.6055556 0.142824 0.6083333 0.142824 0.6111111 0.138702 0.6138889 0.140076 0.6166667 0.138702 0.6194444 0.141450 0.6222222 0.142824 0.6250000 0.142824 0.6277778 0.141450 0.6305556 0.138702 0.6333333 0.140076 0.6361111 0.138702 0.6388889 0.131832 0.6416667 0.131832 0.6444444 0.129084 0.6472222 0.130458 0.6500000 0.126336 0.6527778 0.127710 0.6555556 0.127710 0.6583333 0.127710 0.6611111 0.123588 0.6638889 0.119466 0.6666667 0.113969 0.6694444 0.109847 0.6722222 0.105725 0.6750000 0.100229 0.6777778 0.096107 0.6805556 0.093359 0.6833333 0.087863 0.6861111 0.085115 0.6888889 0.083740 0.6916667 0.082366 0.6944444 0.076870 0.6972222 0.074122 0.7000000 0.068626 0.7027778 0.063130 0.7055556 0.056260 0.7083333 0.053511 0.7111111 0.048015 0.7138889 0.045267 0.7166667 0.046641 0.7194444 0.045267 0.7222222 0.046641 0.7250000 0.046641 0.7277778 0.050763 0.7305556 0.049389 0.7333333 0.050763 0.7361111 0.050763 0.7388889 0.050763 0.7416667 0.056260 0.7444444 0.057634 0.7472222 0.063130 0.7500000 0.070000 0.7527778 0.078244 0.7555556 0.085115 0.7583333 0.094733 0.7611111 0.100229 0.7638889 0.108473 0.7666667 0.116718 0.7694444 0.122214 0.7722222 0.129084 0.7750000 0.135954 0.7777778 0.142824 0.7805556 0.148321 0.7833333 0.156565 0.7861111 0.167557 0.7888889 0.174427 0.7916667 0.179924 0.7944444 0.184046 0.7972222 0.188168 0.8000000 0.196412 0.8027778 0.195038 0.8055556 0.196412 0.8083333 0.197786 0.8111111 0.196412 0.8138889 0.199160 0.8166667 0.201908 0.8194444 0.201908 0.8222222 0.207405 0.8250000 0.207405 0.8277778 0.210153 0.8305556 0.208779 0.8333333 0.208779 0.8361111 0.207405 0.8388889 0.208779 0.8416667 0.206031 0.8444444 0.208779 0.8472222 0.207405 0.8500000 0.210153 0.8527778 0.211527 0.8555556 0.212901 0.8583333 0.217023 0.8611111 0.217023 0.8638889 0.214275 0.8666667 0.214275 0.8694444 0.212901 0.8722222 0.212901 0.8750000 0.210153 0.8777778 0.207405 0.8805556 0.208779 0.8833333 0.210153 0.8861111 0.210153 0.8888889 0.212901 0.8916667 0.218397 0.8944444 0.217023 0.8972222 0.217023 0.9000000 0.218397 0.9027778 0.219771 0.9055556 0.219771 0.9083333 0.221145 0.9111111 0.222519 0.9138889 0.228015 0.9166667 0.233511 0.9194444 0.241756 0.9222222 0.250000 0.9250000 0.259618 0.9277778 0.266489 0.9305556 0.269237 0.9333333 0.276107 0.9361111 0.284351 0.9388889 0.289847 0.9416667 0.299466 0.9444444 0.311832 0.9472222 0.328321 0.9500000 0.346183 0.9527778 0.370916 0.9555556 0.402519 0.9583333 0.434122 0.9611111 0.467099 0.9638889 0.490458 0.9666667 0.515191 0.9694444 0.528931 0.9722222 0.541298 0.9750000 0.553664 0.9777778 0.572901 0.9805556 0.597634 0.9833333 0.620992 0.9861111 0.648473 0.9888889 0.669084 0.9916667 0.682824 0.9944444 0.688321 0.9972222 0.680076 1.0000000 0.655344 1.0027778 0.611374 1.0055556 0.545420 1.0083333 0.449237 1.0111111 0.332443 1.0138889 0.200534 1.0166667 0.072748 1.0194444 0.010000 1.0222222 0.010000 1.0250000 0.010000 1.0277778 0.010000 1.0305556 0.010000 1.0333333 0.010000 1.0361111 0.010000 1.0388889 0.010000 1.0416667 0.010000 1.0444444 0.010000 1.0472222 0.010000 1.0500000 0.010000 1.0527778 0.010000 1.0555556 0.038397 1.0583333 0.067252 1.0611111 0.098855 1.0638889 0.127710 1.0666667 0.153817 1.0694444 0.162061 1.0722222 0.173053 1.0750000 0.168931 1.0777778 0.166183 1.0805556 0.166183 1.0833333 0.168931 1.0861111 0.171679 1.0888889 0.171679 1.0916667 0.174427 1.0944444 0.177176 1.0972222 0.179924 1.1000000 0.182672 1.1027778 0.178550 1.1055556 0.178550 1.1083333 0.175802 1.1111111 0.178550 1.1138889 0.175802 1.1166667 0.179924 1.1194444 0.182672 1.1222222 0.179924 1.1250000 0.182672 1.1277778 0.184046 1.1305556 0.186794 1.1333333 0.184046 1.1361111 0.182672 1.1388889 0.181298 1.1416667 0.181298 1.1444444 0.178550 1.1472222 0.179924 1.1500000 0.179924 1.1527778 0.184046 1.1555556 0.185420 1.1583333 0.186794 1.1611111 0.186794 1.1638889 0.186794 1.1666667 0.185420 1.1694444 0.182672 1.1722222 0.184046 1.1750000 0.182672 1.1777778 0.184046 1.1805556 0.186794 1.1833333 0.188168 1.1861111 0.188168 1.1888889 0.196412 1.1916667 0.200534 1.1944444 0.203282 1.1972222 0.204656 1.2000000 0.210153 1.2027778 0.212901 1.2055556 0.211527 1.2083333 0.215649 1.2111111 0.215649 1.2138889 0.219771 1.2166667 0.226641 1.2194444 0.232137 1.2222222 0.236260 1.2250000 0.243130 1.2277778 0.248626 1.2305556 0.252748 1.2333333 0.256870 1.2361111 0.259618 1.2388889 0.255496 1.2416667 0.255496 1.2444444 0.256870 1.2472222 0.260992 1.2500000 0.262366 1.2527778 0.262366 1.2555556 0.269237 1.2583333 0.267863 1.2611111 0.269237 1.2638889 0.266489 1.2666667 0.262366 1.2694444 0.258244 1.2722222 0.254122 1.2750000 0.248626 1.2777778 0.244504 1.2805556 0.244504 1.2833333 0.240382 1.2861111 0.239008 1.2888889 0.236260 1.2916667 0.234885 1.2944444 0.233511 1.2972222 0.230763 1.3000000 0.228015 1.3027778 0.219771 1.3055556 0.218397 1.3083333 0.217023 1.3111111 0.212901 1.3138889 0.214275 1.3166667 0.212901 1.3194444 0.215649 1.3222222 0.211527 1.3250000 0.217023 1.3277778 0.214275 1.4611111 0.221145 1.4638889 0.217023 1.4666667 0.219771 1.4694444 0.217023 1.4722222 0.215649 1.4750000 0.217023 1.4777778 0.218397 1.4805556 0.218397 1.4833333 0.218397 1.4861111 0.219771 1.4888889 0.219771 1.4916667 0.221145 1.4944444 0.223893 1.4972222 0.218397 1.5000000 0.219771 1.5027778 0.218397 1.5055556 0.221145 1.5083333 0.215649 1.5111111 0.218397 1.5138889 0.219771 1.5166667 0.225267 1.5194444 0.228015 1.5222222 0.232137 1.5250000 0.236260 1.5277778 0.241756 1.5305556 0.245878 1.5333333 0.248626 1.5361111 0.251374 1.5388889 0.252748 1.5416667 0.252748 1.5444444 0.259618 1.5472222 0.262366 1.5500000 0.260992 1.5527778 0.267863 1.5555556 0.274733 1.5583333 0.287099 1.5611111 0.293969 1.5638889 0.302214 1.5666667 0.313206 1.5694444 0.314580 1.5722222 0.310458 1.5750000 0.307710 1.5777778 0.300840 1.5805556 0.295344 1.5833333 0.292595 1.5861111 0.293969 1.5888889 0.295344 1.5916667 0.299466 1.5944444 0.302214 1.5972222 0.296718 1.6000000 0.293969 1.6027778 0.285725 1.6055556 0.274733 1.6083333 0.266489 1.6111111 0.256870 1.6138889 0.248626 1.6166667 0.239008 1.6194444 0.234885 1.6222222 0.233511 1.6250000 0.232137 1.6277778 0.223893 1.6305556 0.223893 1.6333333 0.221145 1.6361111 0.214275 1.6388889 0.210153 1.6416667 0.207405 1.6444444 0.208779 1.6472222 0.207405 1.6500000 0.210153 1.6527778 0.217023 1.6555556 0.215649 1.6583333 0.217023 1.6611111 0.219771 1.6638889 0.221145 1.6666667 0.222519 1.6694444 0.222519 1.6722222 0.219771 1.6750000 0.225267 1.6777778 0.232137 1.6805556 0.244504 1.6833333 0.273359 1.6861111 0.315954 1.6888889 0.368168 1.6916667 0.421756 1.6944444 0.479466 1.6972222 0.527557 1.7000000 0.572901 1.7027778 0.615496 1.7055556 0.652595 1.7083333 0.681450 1.7111111 0.696565 1.7138889 0.699313 1.7166667 0.682824 1.7194444 0.653969 1.7222222 0.612748 1.7250000 0.550916 1.7277778 0.479466 1.7305556 0.402519 1.7333333 0.342061 1.7361111 0.288473 1.7388889 0.260992 1.7416667 0.236260 1.7444444 0.226641 1.7472222 0.221145 1.7500000 0.214275 1.7527778 0.207405 1.7555556 0.197786 1.7583333 0.189542 1.7611111 0.182672 1.7638889 0.179924 1.7666667 0.175802 1.7694444 0.173053 1.7722222 0.171679 1.7750000 0.168931 1.7777778 0.168931 1.7805556 0.168931 1.7833333 0.168931 1.7861111 0.168931 1.7888889 0.171679 1.7916667 0.170305 1.7944444 0.171679 1.7972222 0.170305 1.8000000 0.170305 1.8027778 0.167557 1.8055556 0.166183 1.8083333 0.162061 1.8111111 0.163435 1.8138889 0.162061 1.8166667 0.166183 1.8194444 0.163435 1.8222222 0.166183 1.8250000 0.164809 1.8277778 0.163435 1.8305556 0.163435 1.8333333 0.164809 1.8361111 0.159313 1.8388889 0.157939 1.8416667 0.156565 1.8444444 0.153817 1.8472222 0.152443 1.8500000 0.151069 1.8527778 0.149695 1.8555556 0.148321 1.8583333 0.149695 1.8611111 0.152443 1.8638889 0.151069 1.8666667 0.145573 1.8694444 0.140076 1.8722222 0.137328 1.8750000 0.130458 1.8777778 0.122214 1.8805556 0.120840 1.8833333 0.119466 1.8861111 0.115344 1.8888889 0.113969 1.8916667 0.112595 1.8944444 0.109847 1.8972222 0.107099 1.9000000 0.102977 1.9027778 0.098855 1.9055556 0.096107 1.9083333 0.091985 1.9111111 0.087863 1.9138889 0.083740 1.9166667 0.083740 1.9194444 0.079618 1.9222222 0.078244 1.9250000 0.082366 1.9277778 0.089237 1.9305556 0.090611 1.9333333 0.090611 1.9361111 0.093359 1.9388889 0.094733 1.9416667 0.096107 1.9444444 0.098855 1.9472222 0.104351 1.9500000 0.109847 1.9527778 0.115344 1.9555556 0.120840 1.9583333 0.131832 1.9611111 0.141450 1.9638889 0.144198 1.9666667 0.153817 1.9694444 0.157939 1.9722222 0.163435 1.9750000 0.166183 1.9777778 0.171679 1.9805556 0.179924 1.9833333 0.186794 1.9861111 0.195038 1.9888889 0.201908 1.9916667 0.208779 1.9944444 0.214275 1.9972222 0.215649 2.0000000 0.222519 2.0027778 0.219771 2.0055556 0.219771 2.0083333 0.218397 2.0611111 0.225267 2.0638889 0.226641 2.0666667 0.223893 2.0694444 0.222519 2.0722222 0.223893 2.0750000 0.223893 2.0777778 0.222519 2.0805556 0.222519 2.0833333 0.223893 2.0861111 0.223893 2.0888889 0.223893 2.0916667 0.222519 2.0944444 0.228015 2.0972222 0.226641 2.1000000 0.228015 2.1027778 0.226641 2.1055556 0.225267 2.1083333 0.223893 2.1111111 0.222519 2.1138889 0.225267 2.1166667 0.229389 2.1194444 0.233511 2.1222222 0.236260 2.1250000 0.237634 2.1277778 0.245878 2.1305556 0.248626 2.1333333 0.255496 2.1361111 0.260992 2.1388889 0.263740 2.1416667 0.269237 2.1444444 0.270611 2.1472222 0.274733 2.1500000 0.280229 2.1527778 0.282977 2.1555556 0.292595 2.1583333 0.300840 2.1611111 0.314580 2.1638889 0.315954 2.1666667 0.320076 2.1694444 0.317328 2.1722222 0.311832 2.1750000 0.303588 2.1777778 0.300840 2.1805556 0.295344 2.1833333 0.292595 2.1861111 0.302214 2.1888889 0.302214 2.1916667 0.303588 2.1944444 0.299466 2.1972222 0.292595 2.2000000 0.284351 2.2027778 0.273359 2.2055556 0.263740 2.2083333 0.254122 2.2111111 0.251374 2.2138889 0.243130 2.2166667 0.244504 2.2194444 0.240382 2.2222222 0.237634 2.2250000 0.233511 2.2277778 0.230763 2.2305556 0.228015 2.2333333 0.225267 2.2361111 0.222519 2.2388889 0.221145 2.2416667 0.221145 2.2444444 0.219771 2.2472222 0.222519 2.2500000 0.222519 2.2527778 0.226641 2.2555556 0.229389 2.2583333 0.232137 2.2611111 0.232137 2.2638889 0.229389 2.2666667 0.229389 2.2694444 0.223893 2.2722222 0.226641 2.2750000 0.230763 2.2777778 0.239008 2.2805556 0.256870 2.2833333 0.292595 2.2861111 0.331069 2.2888889 0.384656 2.2916667 0.440992 2.2944444 0.497328 2.2972222 0.546794 2.3000000 0.594885 2.3027778 0.637481 2.3055556 0.666336 2.3083333 0.689695 2.3111111 0.699313 2.3138889 0.692443 2.3166667 0.673206 2.3194444 0.638855 2.3222222 0.586641 2.3250000 0.528931 2.3277778 0.453359 2.3305556 0.383282 2.3333333 0.326947 2.3361111 0.281603 2.3388889 0.256870 2.3416667 0.241756 2.3444444 0.228015 2.3472222 0.226641 2.3500000 0.223893 2.3527778 0.215649 2.3555556 0.208779 2.3583333 0.199160 2.3611111 0.193664 2.3638889 0.186794 2.3666667 0.188168 2.3694444 0.186794 2.3722222 0.186794 2.3750000 0.184046 2.3777778 0.179924 2.3805556 0.179924 2.3833333 0.178550 2.3861111 0.178550 2.3888889 0.178550 2.3916667 0.179924 2.3944444 0.179924 2.3972222 0.181298 2.4000000 0.178550 2.4027778 0.177176 2.4055556 0.177176 2.4083333 0.178550 2.4111111 0.173053 2.4138889 0.173053 2.4166667 0.171679 2.4194444 0.175802 2.4222222 0.178550 2.4250000 0.177176 2.4277778 0.178550 2.4305556 0.175802 2.4333333 0.173053 2.4361111 0.170305 2.4388889 0.167557 2.4416667 0.166183 2.4444444 0.164809 2.4472222 0.160687 2.4500000 0.156565 2.4527778 0.156565 2.4555556 0.162061 2.4583333 0.160687 2.4611111 0.160687 2.4638889 0.155191 2.4666667 0.155191 2.4694444 0.149695 2.4722222 0.146947 2.4750000 0.140076 2.4777778 0.137328 2.4805556 0.134580 2.4833333 0.130458 2.4861111 0.127710 2.4888889 0.124962 2.4916667 0.123588 2.4944444 0.120840 2.4972222 0.119466 2.5000000 0.113969 2.5027778 0.112595 2.5055556 0.107099 2.5083333 0.105725 2.5111111 0.101603 2.5138889 0.101603 2.5166667 0.096107 2.5194444 0.101603 2.5222222 0.105725 2.5250000 0.105725 2.5277778 0.108473 2.5305556 0.112595 2.5333333 0.115344 2.5361111 0.115344 2.5388889 0.119466 2.5416667 0.122214 2.5444444 0.126336 2.5472222 0.129084 2.5500000 0.140076 2.5527778 0.146947 2.5555556 0.153817 2.5583333 0.162061 2.5611111 0.167557 2.5638889 0.171679 2.5666667 0.175802 2.5694444 0.178550 2.5722222 0.178550 2.5750000 0.182672 2.5777778 0.182672 2.5805556 0.185420 2.5833333 0.190916 2.5861111 0.193664 2.5888889 0.195038 2.5916667 0.197786 2.5944444 0.197786 2.5972222 0.200534 2.6000000 0.197786 2.6027778 0.199160 2.6055556 0.197786 2.6083333 0.193664 2.6111111 0.195038 2.6138889 0.196412 2.6166667 0.193664 2.6194444 0.206031 2.6222222 0.208779 2.6250000 0.215649 2.6277778 0.226641 2.6305556 0.232137 2.6333333 0.244504 2.6361111 0.258244 2.6388889 0.271985 2.6416667 0.288473 2.6444444 0.303588 2.6472222 0.326947 2.6500000 0.348931 2.6527778 0.381908 2.6555556 0.412137 2.6583333 0.436870 2.6611111 0.442366 2.6638889 0.420382 2.6666667 0.357176 2.6694444 0.250000 2.6722222 0.115344 2.6750000 0.010000 2.6777778 0.010000 2.6805556 0.010000 2.6833333 0.010000 2.6861111 0.010000 2.6888889 0.010000 2.6916667 0.010000 2.6944444 0.010000 2.6972222 0.010000 2.7000000 0.010000 2.7027778 0.010000 2.7055556 0.010000 2.7083333 0.010000 2.7111111 0.010000 2.7138889 0.010000 2.7166667 0.010000 2.7194444 0.010000 2.7222222 0.010000 2.7250000 0.010000 2.7277778 0.010000 2.7305556 0.010000 2.7333333 0.010000 2.7361111 0.010000 2.7388889 0.010000 2.7416667 0.010000 2.7444444 0.010000 2.7472222 0.010000 2.7500000 0.010000 2.7527778 0.016412 2.7555556 0.024656 2.7583333 0.037023 2.7611111 0.053511 2.7638889 0.080992 2.7666667 0.120840 2.7694444 0.166183 2.7722222 0.207405 2.7750000 0.245878 2.7777778 0.267863 2.7805556 0.278855 2.7833333 0.284351 2.7861111 0.281603 2.7888889 0.276107 2.7916667 0.276107 2.7944444 0.280229 2.7972222 0.282977 2.8000000 0.289847 2.8027778 0.289847 2.8055556 0.293969 2.8083333 0.296718 2.8111111 0.296718 2.8138889 0.300840 2.8166667 0.307710 2.8194444 0.309084 2.8222222 0.314580 2.8250000 0.320076 2.8277778 0.328321 2.8305556 0.331069 2.8333333 0.333817 2.8361111 0.335191 2.8388889 0.336565 2.8416667 0.340687 2.8444444 0.344809 2.8472222 0.348931 2.8500000 0.355802 2.8527778 0.362672 2.8555556 0.368168 2.8583333 0.379160 2.8611111 0.388779 2.8638889 0.387405 2.8666667 0.392901 2.8694444 0.401145 2.8722222 0.405267 2.8750000 0.406641 2.8777778 0.408015 2.8805556 0.414885 2.8833333 0.417634 2.8861111 0.419008 2.8888889 0.424504 2.8916667 0.428626 2.8944444 0.428626 2.8972222 0.430000 2.9000000 0.427252 2.9027778 0.421756 2.9055556 0.414885 2.9083333 0.408015 2.9111111 0.402519 2.9138889 0.397023 2.9166667 0.392901 2.9194444 0.388779 2.9222222 0.377786 2.9250000 0.369542 2.9277778 0.361298 2.9305556 0.348931 2.9333333 0.332443 2.9361111 0.315954 2.9388889 0.304962 2.9416667 0.292595 2.9444444 0.282977 2.9472222 0.269237 2.9500000 0.260992 2.9527778 0.254122 2.9555556 0.244504 2.9583333 0.236260 2.9611111 0.226641 2.9638889 0.217023 2.9666667 0.206031 2.9694444 0.197786 2.9722222 0.189542 2.9750000 0.178550 2.9777778 0.166183 2.9805556 0.157939 2.9833333 0.151069 2.9861111 0.148321 2.9888889 0.145573 2.9916667 0.142824 3.2111111 0.039771 3.2138889 0.039771 3.2166667 0.038397 3.2194444 0.039771 3.2222222 0.038397 3.2250000 0.038397 3.2277778 0.035649 3.2305556 0.034275 3.2333333 0.030153 3.2361111 0.030153 3.2388889 0.031527 3.2416667 0.028779 3.2444444 0.030153 3.2472222 0.034275 3.2500000 0.031527 3.2527778 0.032901 3.2555556 0.034275 3.2583333 0.032901 3.2611111 0.031527 3.2638889 0.031527 3.2666667 0.035649 3.2694444 0.035649 3.2722222 0.034275 3.2750000 0.032901 3.2777778 0.027405 3.2805556 0.023282 3.2833333 0.021908 3.2861111 0.023282 3.2888889 0.030153 3.2916667 0.035649 3.2944444 0.048015 3.2972222 0.053511 3.3000000 0.053511 3.3027778 0.050763 3.3055556 0.049389 3.3083333 0.049389 3.3111111 0.050763 3.3138889 0.056260 3.3166667 0.067252 3.3194444 0.072748 3.3222222 0.082366 3.3250000 0.090611 3.3277778 0.091985 3.3305556 0.097481 3.3333333 0.094733 3.3361111 0.089237 3.3388889 0.089237 3.3416667 0.089237 3.3444444 0.087863 3.3472222 0.090611 3.3500000 0.087863 3.3527778 0.083740 3.3555556 0.070000 3.3583333 0.064504 3.3611111 0.052137 3.3638889 0.041145 3.3666667 0.030153 3.3694444 0.019160 3.3722222 0.015038 3.3750000 0.012290 3.3777778 0.010000 3.3805556 0.010000 3.3833333 0.010000 3.3861111 0.010000 3.3888889 0.010000 3.3916667 0.010000 3.3944444 0.010000 3.3972222 0.010000 3.4000000 0.010000 3.4027778 0.010000 3.4055556 0.010000 3.4083333 0.010000 3.4111111 0.010000 3.4138889 0.010000 3.4166667 0.010000 3.4194444 0.010000 3.4222222 0.010000 3.4250000 0.010000 3.4277778 0.010916 3.4305556 0.019160 3.4333333 0.052137 3.4361111 0.094733 3.4388889 0.151069 3.4416667 0.215649 3.4444444 0.276107 3.4472222 0.337939 3.4500000 0.392901 3.4527778 0.443740 3.4555556 0.489084 3.4583333 0.526183 3.4611111 0.546794 3.4638889 0.549542 3.4666667 0.531679 3.4694444 0.483588 3.4722222 0.413511 3.4750000 0.321450 3.4777778 0.218397 3.4805556 0.122214 3.4833333 0.052137 3.4861111 0.010916 3.4888889 0.010000 3.4916667 0.010000 3.4944444 0.010000 3.4972222 0.010000 3.5000000 0.010000 3.5027778 0.010000 3.5055556 0.010000 3.5083333 0.010000 3.5111111 0.010000 3.5138889 0.010000 3.5166667 0.010000 3.5194444 0.010000 3.5222222 0.010000 3.5250000 0.010000 3.5277778 0.010000 3.5305556 0.010000 3.5333333 0.010000 3.5361111 0.010000 3.5388889 0.010000 3.5416667 0.010000 3.5444444 0.010000 3.5472222 0.010000 3.5500000 0.010000 3.5527778 0.010000 3.5555556 0.010000 3.5583333 0.010000 3.5611111 0.010000 3.5638889 0.010000 3.5666667 0.010000 3.5694444 0.010000 3.5722222 0.010000 3.5750000 0.010000 3.5777778 0.010000 3.5805556 0.010000 3.5833333 0.010000 3.5861111 0.010000 3.5888889 0.010000 3.5916667 0.010000 3.5944444 0.010000 3.5972222 0.010000 3.6000000 0.010000 3.6027778 0.010000 3.6055556 0.010000 3.6083333 0.010000 3.6111111 0.010000 3.6138889 0.010000 3.6166667 0.010000 3.6194444 0.010000 3.6222222 0.010000 3.6250000 0.010000 3.6277778 0.010000 3.6305556 0.010000 3.6333333 0.010000 3.6361111 0.010000 3.6388889 0.010000 3.6416667 0.010000 3.6444444 0.010000 3.6472222 0.010000 3.6500000 0.010000 3.6527778 0.010000 3.6555556 0.010000 3.6583333 0.010000 3.6611111 0.010000 3.6638889 0.010000 3.6666667 0.010000 3.6694444 0.010000 3.6722222 0.010000 3.6750000 0.010000 3.6777778 0.010000 3.6805556 0.010000 3.6833333 0.010000 3.6861111 0.010000 3.6888889 0.010000 3.6916667 0.010000 3.6944444 0.010000 3.6972222 0.010000 3.7000000 0.010000 3.7027778 0.010000 3.7055556 0.010000 3.7083333 0.010000 3.7111111 0.010000 3.7138889 0.010000 3.7166667 0.010000 3.7194444 0.010000 3.7222222 0.010000 3.7250000 0.010000 3.7277778 0.010000 3.7305556 0.010000 3.7333333 0.010000 3.7361111 0.010000 3.7388889 0.010000 3.7416667 0.010000 3.7444444 0.010000 3.7472222 0.010000 3.7500000 0.010000 3.7527778 0.010000 3.7555556 0.010000 3.7583333 0.010000 3.8277778 0.026031 3.8305556 0.028779 3.8333333 0.030153 3.8361111 0.030153 3.8388889 0.024656 3.8416667 0.021908 3.8444444 0.017786 3.8472222 0.019160 3.8500000 0.020534 3.8527778 0.021908 3.8555556 0.023282 3.8583333 0.026031 3.8611111 0.023282 3.8638889 0.028779 3.8666667 0.031527 3.8694444 0.028779 3.8722222 0.030153 3.8750000 0.028779 3.8777778 0.030153 3.8805556 0.031527 3.8833333 0.032901 3.8861111 0.035649 3.8888889 0.041145 3.8916667 0.043893 3.8944444 0.045267 3.8972222 0.049389 3.9000000 0.053511 3.9027778 0.059008 3.9055556 0.061756 3.9083333 0.064504 3.9111111 0.067252 3.9138889 0.072748 3.9166667 0.071374 3.9194444 0.075496 3.9222222 0.082366 3.9250000 0.089237 3.9277778 0.100229 3.9305556 0.109847 3.9333333 0.116718 3.9361111 0.120840 3.9388889 0.119466 3.9416667 0.118092 3.9444444 0.111221 3.9472222 0.107099 3.9500000 0.105725 3.9527778 0.108473 3.9555556 0.109847 3.9583333 0.112595 3.9611111 0.115344 3.9638889 0.113969 3.9666667 0.111221 3.9694444 0.100229 3.9722222 0.090611 3.9750000 0.083740 3.9777778 0.074122 3.9805556 0.070000 3.9833333 0.067252 3.9861111 0.061756 3.9888889 0.059008 3.9916667 0.057634 3.9944444 0.052137 3.9972222 0.049389 4.0000000 0.045267 4.0027778 0.043893 4.0055556 0.039771 4.0083333 0.038397 4.0111111 0.038397 4.0138889 0.039771 4.0166667 0.039771 4.0194444 0.041145 4.0222222 0.042519 4.0250000 0.043893 4.0277778 0.046641 4.0305556 0.048015 4.0333333 0.052137 4.0361111 0.052137 4.0388889 0.052137 4.0416667 0.049389 4.0444444 0.056260 4.0472222 0.072748 4.0500000 0.096107 4.0527778 0.137328 4.0555556 0.190916 4.0583333 0.252748 4.0611111 0.322824 4.0638889 0.381908 4.0666667 0.440992 4.0694444 0.493206 4.0722222 0.538550 4.0750000 0.574275 4.0777778 0.597634 4.0805556 0.601756 4.0833333 0.582519 4.0861111 0.544046 4.0888889 0.483588 4.0916667 0.397023 4.0944444 0.298092 4.0972222 0.197786 4.1000000 0.129084 4.1027778 0.079618 4.1055556 0.054885 4.1083333 0.045267 4.1111111 0.050763 4.1138889 0.052137 4.1166667 0.050763 4.1194444 0.046641 4.1222222 0.038397 4.1250000 0.034275 4.1277778 0.026031 4.1305556 0.024656 4.1333333 0.026031 4.1361111 0.024656 4.1388889 0.021908 4.1416667 0.020534 4.1444444 0.016412 4.1472222 0.017786 4.1500000 0.016412 4.1527778 0.019160 4.1555556 0.020534 4.1583333 0.024656 4.1611111 0.026031 4.1638889 0.023282 4.1666667 0.020534 4.1694444 0.020534 4.1722222 0.019160 4.1750000 0.017786 4.1777778 0.015038 4.1805556 0.017786 4.1833333 0.019160 4.1861111 0.015038 4.1888889 0.016412 4.1916667 0.017786 4.1944444 0.017786 4.1972222 0.020534 4.2000000 0.016412 4.2027778 0.012290 4.2055556 0.016412 4.2083333 0.013664 4.2111111 0.012290 4.2138889 0.010000 4.2166667 0.012290 4.2194444 0.015038 4.2222222 0.015038 4.2250000 0.015038 4.2277778 0.010000 4.2305556 0.010000 4.2333333 0.010000 4.2361111 0.010000 4.2388889 0.010000 4.2416667 0.010000 4.2444444 0.010000 4.2472222 0.010000 4.2500000 0.010000 4.2527778 0.010000 4.2555556 0.010000 4.2583333 0.010000 4.2611111 0.010000 4.2638889 0.010000 4.2666667 0.010000 4.2694444 0.010000 4.2722222 0.010000 4.2750000 0.010000 4.2777778 0.010000 4.2805556 0.010000 4.2833333 0.010000 4.2861111 0.010000 4.2888889 0.010000 4.2916667 0.010000 4.2944444 0.010000 4.2972222 0.010000 4.3000000 0.010000 4.3027778 0.010000 4.3055556 0.010000 4.3083333 0.010000 4.3111111 0.010000 4.3138889 0.010916 4.3166667 0.017786 4.3194444 0.027405 4.3222222 0.034275 4.3250000 0.043893 4.3277778 0.052137 4.3305556 0.057634 4.3333333 0.060382 4.3361111 0.063130 4.3388889 0.067252 4.3416667 0.067252 4.3444444 0.071374 4.3472222 0.074122 4.3500000 0.076870 4.3527778 0.079618 4.3555556 0.083740 4.3583333 0.085115 4.3611111 0.089237 4.3638889 0.087863 4.3666667 0.086489 4.3694444 0.089237 4.3722222 0.085115 4.3750000 0.083740 4.4194444 0.090611 4.4222222 0.091985 4.4250000 0.097481 4.4277778 0.098855 4.4305556 0.100229 4.4333333 0.102977 4.4361111 0.100229 4.4388889 0.100229 4.4416667 0.098855 4.4444444 0.097481 4.4472222 0.097481 4.4500000 0.100229 4.4527778 0.097481 4.4555556 0.100229 4.4583333 0.102977 4.4611111 0.104351 4.4638889 0.109847 4.4666667 0.108473 4.4694444 0.107099 4.4722222 0.108473 4.4750000 0.109847 4.4777778 0.109847 4.4805556 0.112595 4.4833333 0.113969 4.4861111 0.122214 4.4888889 0.129084 4.4916667 0.135954 4.4944444 0.142824 4.4972222 0.145573 4.5000000 0.148321 4.5027778 0.149695 4.5055556 0.152443 4.5083333 0.156565 4.5111111 0.164809 4.5138889 0.171679 4.5166667 0.184046 4.5194444 0.190916 4.5222222 0.195038 4.5250000 0.197786 4.5277778 0.195038 4.5305556 0.190916 4.5333333 0.188168 4.5361111 0.185420 4.5388889 0.181298 4.5416667 0.184046 4.5444444 0.186794 4.5472222 0.189542 4.5500000 0.189542 4.5527778 0.186794 4.5555556 0.181298 4.5583333 0.171679 4.5611111 0.163435 4.5638889 0.153817 4.5666667 0.145573 4.5694444 0.141450 4.5722222 0.137328 4.5750000 0.133206 4.5777778 0.131832 4.5805556 0.129084 4.5833333 0.130458 4.5861111 0.127710 4.5888889 0.126336 4.5916667 0.126336 4.5944444 0.124962 4.5972222 0.124962 4.6000000 0.127710 4.6027778 0.124962 4.6055556 0.124962 4.6083333 0.122214 4.6111111 0.122214 4.6138889 0.124962 4.6166667 0.127710 4.6194444 0.127710 4.6222222 0.130458 4.6250000 0.130458 4.6277778 0.134580 4.6305556 0.137328 4.6333333 0.142824 4.6361111 0.153817 4.6388889 0.170305 4.6416667 0.203282 4.6444444 0.244504 4.6472222 0.302214 4.6500000 0.359924 4.6527778 0.423130 4.6555556 0.475344 4.6583333 0.530305 4.6611111 0.579771 4.6638889 0.622366 4.6666667 0.658092 4.6694444 0.678702 4.6722222 0.682824 4.6750000 0.666336 4.6777778 0.634733 4.6805556 0.586641 4.6833333 0.517939 4.6861111 0.431374 4.6888889 0.339313 4.6916667 0.265115 4.6944444 0.204656 4.6972222 0.167557 4.7000000 0.153817 4.7027778 0.148321 4.7055556 0.145573 4.7083333 0.144198 4.7111111 0.142824 4.7138889 0.133206 4.7166667 0.123588 4.7194444 0.107099 4.7222222 0.105725 4.7250000 0.108473 4.7277778 0.108473 4.7305556 0.107099 4.7333333 0.107099 4.7361111 0.108473 4.7388889 0.104351 4.7416667 0.100229 4.7444444 0.097481 4.7472222 0.097481 4.7500000 0.097481 4.7527778 0.102977 4.7555556 0.105725 4.7583333 0.109847 4.7611111 0.108473 4.7638889 0.102977 4.7666667 0.105725 4.7694444 0.104351 4.7722222 0.102977 4.7750000 0.102977 4.7777778 0.101603 4.7805556 0.102977 4.7833333 0.105725 4.7861111 0.107099 4.7888889 0.104351 4.7916667 0.102977 4.7944444 0.104351 4.7972222 0.102977 4.8000000 0.098855 4.8027778 0.100229 4.8055556 0.097481 4.8083333 0.094733 4.8111111 0.094733 4.8138889 0.094733 4.8166667 0.094733 4.8194444 0.096107 4.8222222 0.094733 4.8250000 0.096107 4.8277778 0.093359 4.8305556 0.093359 4.8333333 0.091985 4.8361111 0.087863 4.8388889 0.085115 4.8416667 0.078244 4.8444444 0.074122 4.8472222 0.072748 4.8500000 0.070000 4.8527778 0.067252 4.8555556 0.065878 4.8583333 0.065878 4.8611111 0.067252 4.8638889 0.063130 4.8666667 0.060382 4.8694444 0.057634 4.8722222 0.053511 4.8750000 0.049389 4.8777778 0.045267 4.8805556 0.042519 4.8833333 0.041145 4.8861111 0.041145 4.8888889 0.045267 4.8916667 0.048015 4.8944444 0.049389 4.8972222 0.052137 4.9000000 0.056260 4.9027778 0.060382 4.9055556 0.063130 4.9083333 0.063130 4.9111111 0.068626 4.9138889 0.075496 4.9166667 0.083740 4.9194444 0.091985 4.9222222 0.100229 4.9250000 0.107099 4.9277778 0.113969 4.9305556 0.120840 4.9333333 0.126336 4.9361111 0.133206 4.9388889 0.137328 4.9416667 0.140076 4.9444444 0.142824 4.9472222 0.149695 4.9500000 0.155191 4.9527778 0.162061 4.9555556 0.164809 4.9583333 0.171679 4.9611111 0.177176 4.9638889 0.173053 4.9666667 0.175802 4.9694444 0.177176 4.9722222 0.173053 4.9750000 0.170305 4.9777778 0.174427 4.9805556 0.177176 4.9833333 0.181298 4.9861111 0.186794 4.9888889 0.193664 4.9916667 0.200534 4.9944444 0.212901 4.9972222 0.222519 5.0000000 0.233511 5.0027778 0.244504 5.0055556 0.256870 5.0083333 0.270611 5.0111111 0.288473 5.0138889 0.309084 5.0166667 0.332443 5.0194444 0.361298 5.0222222 0.392901 5.0250000 0.419008 5.0277778 0.440992 5.0305556 0.443740 5.0333333 0.421756 5.0361111 0.372290 5.0388889 0.289847 5.0416667 0.186794 5.0444444 0.076870 5.0472222 0.010000 5.0500000 0.010000 5.0527778 0.010000 5.0555556 0.010000 5.0583333 0.010000 5.0611111 0.010000 5.0638889 0.010000 5.0666667 0.010000 5.0694444 0.010000 5.0722222 0.010000 5.0750000 0.010000 5.0777778 0.010000 5.0805556 0.010000 5.0833333 0.010000 5.0861111 0.010000 5.0888889 0.010000 5.0916667 0.010000 5.0944444 0.010000 5.0972222 0.010000 5.1000000 0.010000 5.1027778 0.010000 5.1055556 0.010000 5.1083333 0.010000 5.1111111 0.010000 5.1138889 0.010000 5.1166667 0.010000 5.1194444 0.028779 5.1222222 0.059008 5.1250000 0.083740 5.1277778 0.097481 5.1305556 0.105725 5.1333333 0.112595 5.1361111 0.127710 5.1388889 0.151069 5.1416667 0.181298 5.1444444 0.225267 5.1472222 0.273359 5.1500000 0.307710 5.1527778 0.331069 5.1555556 0.339313 5.1583333 0.337939 5.1611111 0.332443 5.1638889 0.324198 5.1666667 0.317328 5.1694444 0.318702 5.1722222 0.320076 5.1750000 0.321450 5.1777778 0.326947 5.1805556 0.329695 5.1833333 0.335191 5.1861111 0.339313 5.1888889 0.343435 5.1916667 0.348931 5.1944444 0.351679 5.1972222 0.355802 5.2000000 0.358550 5.2027778 0.364046 5.2055556 0.361298 5.2083333 0.365420 5.2111111 0.366794 5.2138889 0.372290 5.2166667 0.375038 5.2194444 0.386031 5.2222222 0.391527 5.2250000 0.399771 5.2277778 0.403893 5.2305556 0.409389 5.2333333 0.414885 5.2361111 0.416260 5.2388889 0.424504 5.2416667 0.427252 5.2444444 0.432748 5.2472222 0.438244 5.2500000 0.443740 5.2527778 0.450611 5.2555556 0.458855 5.2583333 0.471221 5.2611111 0.475344 5.2638889 0.480840 5.2666667 0.484962 5.2694444 0.484962 5.2722222 0.486336 5.2750000 0.486336 5.2777778 0.487710 5.2805556 0.487710 5.2833333 0.490458 5.2861111 0.490458 5.2888889 0.489084 5.2916667 0.480840 5.2944444 0.478092 5.2972222 0.475344 5.3000000 0.468473 5.3027778 0.460229 5.3055556 0.450611 5.3083333 0.445115 5.3111111 0.435496 5.3138889 0.424504 5.3166667 0.419008 5.3194444 0.410763 5.3222222 0.399771 5.3250000 0.387405 5.5944444 0.236260 5.5972222 0.234885 5.6000000 0.234885 5.6027778 0.232137 5.6055556 0.232137 5.6083333 0.228015 5.6111111 0.230763 5.6138889 0.228015 5.6166667 0.230763 5.6194444 0.233511 5.6222222 0.232137 5.6250000 0.233511 5.6277778 0.236260 5.6305556 0.233511 5.6333333 0.236260 5.6361111 0.234885 5.6388889 0.233511 5.6416667 0.234885 5.6444444 0.233511 5.6472222 0.230763 5.6500000 0.234885 5.6527778 0.237634 5.6555556 0.236260 5.6583333 0.240382 5.6611111 0.243130 5.6638889 0.247252 5.6666667 0.247252 5.6694444 0.250000 5.6722222 0.251374 5.6750000 0.256870 5.6777778 0.260992 5.6805556 0.267863 5.6833333 0.274733 5.6861111 0.276107 5.6888889 0.280229 5.6916667 0.285725 5.6944444 0.289847 5.6972222 0.295344 5.7000000 0.303588 5.7027778 0.310458 5.7055556 0.318702 5.7083333 0.322824 5.7111111 0.324198 5.7138889 0.321450 5.7166667 0.315954 5.7194444 0.310458 5.7222222 0.309084 5.7250000 0.310458 5.7277778 0.314580 5.7305556 0.310458 5.7333333 0.314580 5.7361111 0.313206 5.7388889 0.304962 5.7416667 0.296718 5.7444444 0.284351 5.7472222 0.277481 5.7500000 0.270611 5.7527778 0.265115 5.7555556 0.263740 5.7583333 0.262366 5.7611111 0.255496 5.7638889 0.254122 5.7666667 0.248626 5.7694444 0.244504 5.7722222 0.241756 5.7750000 0.239008 5.7777778 0.236260 5.7805556 0.236260 5.7833333 0.239008 5.7861111 0.241756 5.7888889 0.243130 5.7916667 0.250000 5.7944444 0.250000 5.7972222 0.248626 5.8000000 0.250000 5.8027778 0.247252 5.8055556 0.247252 5.8083333 0.248626 5.8111111 0.250000 5.8138889 0.266489 5.8166667 0.289847 5.8194444 0.331069 5.8222222 0.383282 5.8250000 0.440992 5.8277778 0.501450 5.8305556 0.555038 5.8333333 0.604504 5.8361111 0.653969 5.8388889 0.700687 5.8416667 0.740534 5.8444444 0.765267 5.8472222 0.773511 5.8500000 0.763893 5.8527778 0.733664 5.8555556 0.685573 5.8583333 0.615496 5.8611111 0.527557 5.8638889 0.439618 5.8666667 0.366794 5.8694444 0.311832 5.8722222 0.273359 5.8750000 0.256870 5.8777778 0.250000 5.8805556 0.250000 5.8833333 0.245878 5.8861111 0.241756 5.8888889 0.234885 5.8916667 0.223893 5.8944444 0.217023 5.8972222 0.212901 5.9000000 0.210153 5.9027778 0.210153 5.9055556 0.207405 5.9083333 0.204656 5.9111111 0.206031 5.9138889 0.201908 5.9166667 0.206031 5.9194444 0.206031 5.9222222 0.206031 5.9250000 0.207405 5.9277778 0.206031 5.9305556 0.204656 5.9333333 0.203282 5.9361111 0.197786 5.9388889 0.201908 5.9416667 0.200534 5.9444444 0.200534 5.9472222 0.197786 5.9500000 0.199160 5.9527778 0.197786 5.9555556 0.199160 5.9583333 0.200534 5.9611111 0.203282 5.9638889 0.197786 5.9666667 0.199160 5.9694444 0.197786 5.9722222 0.197786 5.9750000 0.195038 5.9777778 0.195038 5.9805556 0.190916 5.9833333 0.190916 5.9861111 0.189542 5.9888889 0.190916 5.9916667 0.188168 5.9944444 0.186794 5.9972222 0.186794 6.0000000 0.184046 6.0027778 0.179924 6.0055556 0.175802 6.0083333 0.174427 6.0111111 0.168931 6.0138889 0.167557 6.0166667 0.162061 6.0194444 0.160687 6.0222222 0.159313 6.0250000 0.156565 6.0277778 0.153817 6.0305556 0.152443 6.0333333 0.148321 6.0361111 0.141450 6.0388889 0.131832 6.0416667 0.129084 6.0444444 0.120840 6.0472222 0.118092 6.0500000 0.115344 6.0527778 0.113969 6.0555556 0.109847 6.0583333 0.112595 6.0611111 0.112595 6.0638889 0.111221 6.0666667 0.112595 6.0694444 0.112595 6.0722222 0.113969 6.0750000 0.112595 6.0777778 0.113969 6.0805556 0.115344 6.0833333 0.120840 6.0861111 0.123588 6.0888889 0.131832 6.0916667 0.140076 6.0944444 0.151069 6.0972222 0.157939 6.1000000 0.164809 6.1027778 0.171679 6.1055556 0.179924 6.1083333 0.189542 6.1111111 0.195038 6.1138889 0.206031 6.1166667 0.215649 6.1194444 0.225267 6.1222222 0.232137 6.1250000 0.241756 6.1277778 0.248626 6.1305556 0.254122 6.1333333 0.254122 6.1361111 0.262366 6.1388889 0.267863 6.1416667 0.267863 6.3444444 0.250000)
Vecg2 ecg_in_l1 0 PWL(0.0000000 0.250000 0.2500000 0.266489 0.2527778 0.266489 0.2555556 0.266489 0.2583333 0.270611 0.2611111 0.269237 0.2638889 0.271985 0.2666667 0.270611 0.2694444 0.265115 0.2722222 0.260992 0.2750000 0.258244 0.2777778 0.260992 0.2805556 0.259618 0.2833333 0.265115 0.2861111 0.267863 0.2888889 0.267863 0.2916667 0.267863 0.2944444 0.266489 0.2972222 0.267863 0.3000000 0.263740 0.3027778 0.259618 0.3055556 0.260992 0.3083333 0.259618 0.3111111 0.262366 0.3138889 0.265115 0.3166667 0.270611 0.3194444 0.274733 0.3222222 0.284351 0.3250000 0.295344 0.3277778 0.302214 0.3305556 0.310458 0.3333333 0.314580 0.3361111 0.315954 0.3388889 0.314580 0.3416667 0.313206 0.3444444 0.310458 0.3472222 0.309084 0.3500000 0.306336 0.3527778 0.299466 0.3555556 0.292595 0.3583333 0.285725 0.3611111 0.280229 0.3638889 0.277481 0.3666667 0.269237 0.3694444 0.262366 0.3722222 0.255496 0.3750000 0.258244 0.3777778 0.251374 0.3805556 0.254122 0.3833333 0.248626 0.3861111 0.241756 0.3888889 0.234885 0.3916667 0.234885 0.3944444 0.230763 0.3972222 0.232137 0.4000000 0.232137 0.4027778 0.234885 0.4055556 0.241756 0.4083333 0.240382 0.4111111 0.240382 0.4138889 0.243130 0.4166667 0.251374 0.4194444 0.248626 0.4222222 0.254122 0.4250000 0.256870 0.4277778 0.252748 0.4305556 0.250000 0.4333333 0.248626 0.4361111 0.244504 0.4388889 0.241756 0.4416667 0.239008 0.4444444 0.241756 0.4472222 0.241756 0.4500000 0.243130 0.4527778 0.245878 0.4555556 0.247252 0.4583333 0.254122 0.4611111 0.259618 0.4638889 0.269237 0.4666667 0.278855 0.4694444 0.289847 0.4722222 0.291221 0.4750000 0.287099 0.4777778 0.260992 0.4805556 0.223893 0.4833333 0.177176 0.4861111 0.119466 0.4888889 0.048015 0.4916667 0.010000 0.4944444 0.010000 0.4972222 0.010000 0.5000000 0.010000 0.5027778 0.010000 0.5055556 0.010000 0.5083333 0.010000 0.5111111 0.010000 0.5138889 0.010000 0.5166667 0.010000 0.5194444 0.010000 0.5222222 0.010000 0.5250000 0.010000 0.5277778 0.010000 0.5305556 0.056260 0.5333333 0.094733 0.5361111 0.116718 0.5388889 0.138702 0.5416667 0.155191 0.5444444 0.173053 0.5472222 0.193664 0.5500000 0.215649 0.5527778 0.233511 0.5555556 0.248626 0.5583333 0.258244 0.5611111 0.260992 0.5638889 0.259618 0.5666667 0.258244 0.5694444 0.262366 0.5722222 0.260992 0.5750000 0.262366 0.5777778 0.263740 0.5805556 0.271985 0.5833333 0.273359 0.5861111 0.277481 0.5888889 0.280229 0.5916667 0.285725 0.5944444 0.284351 0.5972222 0.285725 0.6000000 0.285725 0.6027778 0.288473 0.6055556 0.288473 0.6083333 0.285725 0.6111111 0.289847 0.6138889 0.292595 0.6166667 0.298092 0.6194444 0.300840 0.6222222 0.300840 0.6250000 0.300840 0.6277778 0.307710 0.6305556 0.306336 0.6333333 0.310458 0.6361111 0.307710 0.6388889 0.311832 0.6416667 0.309084 0.6444444 0.310458 0.6472222 0.315954 0.6500000 0.315954 0.6527778 0.318702 0.6555556 0.326947 0.6583333 0.328321 0.6611111 0.331069 0.6638889 0.335191 0.6666667 0.332443 0.6694444 0.332443 0.6722222 0.333817 0.6750000 0.333817 0.6777778 0.337939 0.6805556 0.340687 0.6833333 0.344809 0.6861111 0.353053 0.6888889 0.351679 0.6916667 0.357176 0.6944444 0.359924 0.6972222 0.359924 0.7000000 0.358550 0.7027778 0.355802 0.7055556 0.358550 0.7083333 0.354427 0.7111111 0.355802 0.7138889 0.361298 0.7166667 0.365420 0.7194444 0.368168 0.7222222 0.369542 0.7250000 0.370916 0.7277778 0.369542 0.7305556 0.370916 0.7333333 0.366794 0.7361111 0.361298 0.7388889 0.362672 0.7416667 0.358550 0.7444444 0.357176 0.7472222 0.355802 0.7500000 0.354427 0.7527778 0.350305 0.7555556 0.348931 0.7583333 0.348931 0.7611111 0.343435 0.7638889 0.333817 0.7666667 0.331069 0.7694444 0.325573 0.7722222 0.315954 0.7750000 0.310458 0.7777778 0.303588 0.7805556 0.299466 0.7833333 0.295344 0.7861111 0.289847 0.7888889 0.285725 0.7916667 0.281603 0.7944444 0.278855 0.7972222 0.273359 0.8000000 0.269237 0.8027778 0.266489 0.8055556 0.260992 0.8083333 0.256870 0.8111111 0.254122 0.8138889 0.254122 0.8166667 0.256870 0.8194444 0.256870 0.8222222 0.262366 0.8250000 0.259618 0.8277778 0.256870 0.8305556 0.256870 0.8333333 0.251374 0.8361111 0.250000 0.8388889 0.251374 0.8416667 0.248626 0.8444444 0.251374 0.8472222 0.255496 0.8500000 0.255496 0.8527778 0.251374 0.8555556 0.258244 0.8583333 0.255496 0.8611111 0.255496 0.8638889 0.254122 0.8666667 0.254122 0.8694444 0.252748 0.8722222 0.252748 0.8750000 0.252748 0.8777778 0.252748 0.8805556 0.252748 0.8833333 0.254122 0.8861111 0.258244 0.8888889 0.258244 0.8916667 0.262366 0.8944444 0.260992 0.8972222 0.263740 0.9000000 0.263740 0.9027778 0.262366 0.9055556 0.262366 0.9083333 0.258244 0.9111111 0.259618 0.9138889 0.255496 0.9166667 0.260992 0.9194444 0.265115 0.9222222 0.269237 0.9250000 0.281603 0.9277778 0.284351 0.9305556 0.292595 0.9333333 0.306336 0.9361111 0.313206 0.9388889 0.320076 0.9416667 0.325573 0.9444444 0.329695 0.9472222 0.332443 0.9500000 0.342061 0.9527778 0.348931 0.9555556 0.350305 0.9583333 0.339313 0.9611111 0.328321 0.9638889 0.307710 0.9666667 0.287099 0.9694444 0.266489 0.9722222 0.251374 0.9750000 0.236260 0.9777778 0.228015 0.9805556 0.222519 0.9833333 0.208779 0.9861111 0.190916 0.9888889 0.163435 0.9916667 0.131832 0.9944444 0.093359 0.9972222 0.052137 1.0000000 0.015038 1.0027778 0.010000 1.0055556 0.010000 1.0083333 0.010000 1.0111111 0.010000 1.0138889 0.010000 1.0166667 0.010000 1.0194444 0.010000 1.0222222 0.010000 1.0250000 0.010000 1.0277778 0.010000 1.0305556 0.010000 1.0333333 0.010000 1.0361111 0.010000 1.0388889 0.010000 1.0416667 0.010000 1.0444444 0.010000 1.0472222 0.010000 1.0500000 0.010000 1.0527778 0.019160 1.0555556 0.064504 1.0583333 0.104351 1.0611111 0.137328 1.0638889 0.170305 1.0666667 0.188168 1.0694444 0.203282 1.0722222 0.214275 1.0750000 0.218397 1.0777778 0.225267 1.0805556 0.229389 1.0833333 0.236260 1.0861111 0.244504 1.0888889 0.247252 1.0916667 0.251374 1.0944444 0.252748 1.0972222 0.251374 1.1000000 0.251374 1.1027778 0.254122 1.1055556 0.250000 1.1083333 0.247252 1.1111111 0.251374 1.1138889 0.256870 1.1166667 0.262366 1.1194444 0.266489 1.1222222 0.266489 1.1250000 0.266489 1.1277778 0.269237 1.1305556 0.270611 1.1333333 0.266489 1.1361111 0.267863 1.1388889 0.266489 1.1416667 0.269237 1.1444444 0.271985 1.1472222 0.274733 1.1500000 0.277481 1.1527778 0.280229 1.1555556 0.284351 1.1583333 0.287099 1.1611111 0.289847 1.1638889 0.288473 1.1666667 0.292595 1.1694444 0.291221 1.1722222 0.295344 1.1750000 0.299466 1.1777778 0.300840 1.1805556 0.304962 1.1833333 0.306336 1.1861111 0.311832 1.1888889 0.317328 1.1916667 0.321450 1.1944444 0.326947 1.1972222 0.332443 1.2000000 0.332443 1.2027778 0.335191 1.2055556 0.339313 1.2083333 0.339313 1.2111111 0.343435 1.2138889 0.346183 1.2166667 0.350305 1.2194444 0.357176 1.2222222 0.362672 1.2250000 0.366794 1.2277778 0.368168 1.2305556 0.370916 1.2333333 0.369542 1.2361111 0.369542 1.2388889 0.366794 1.2416667 0.364046 1.2444444 0.365420 1.2472222 0.366794 1.2500000 0.370916 1.2527778 0.370916 1.2555556 0.365420 1.2583333 0.364046 1.2611111 0.359924 1.2638889 0.357176 1.2666667 0.350305 1.2694444 0.346183 1.2722222 0.339313 1.2750000 0.335191 1.2777778 0.331069 1.2805556 0.331069 1.2833333 0.321450 1.2861111 0.321450 1.2888889 0.311832 1.2916667 0.311832 1.2944444 0.303588 1.2972222 0.300840 1.3000000 0.291221 1.3027778 0.288473 1.3055556 0.281603 1.3083333 0.280229 1.3111111 0.278855 1.3138889 0.277481 1.3166667 0.271985 1.3194444 0.274733 1.3222222 0.271985 1.3250000 0.273359 1.3277778 0.270611 1.4611111 0.259618 1.4638889 0.258244 1.4666667 0.260992 1.4694444 0.258244 1.4722222 0.256870 1.4750000 0.254122 1.4777778 0.254122 1.4805556 0.252748 1.4833333 0.252748 1.4861111 0.255496 1.4888889 0.259618 1.4916667 0.259618 1.4944444 0.256870 1.4972222 0.256870 1.5000000 0.255496 1.5027778 0.251374 1.5055556 0.248626 1.5083333 0.244504 1.5111111 0.245878 1.5138889 0.247252 1.5166667 0.251374 1.5194444 0.256870 1.5222222 0.258244 1.5250000 0.265115 1.5277778 0.269237 1.5305556 0.276107 1.5333333 0.280229 1.5361111 0.285725 1.5388889 0.291221 1.5416667 0.296718 1.5444444 0.302214 1.5472222 0.300840 1.5500000 0.307710 1.5527778 0.306336 1.5555556 0.303588 1.5583333 0.303588 1.5611111 0.296718 1.5638889 0.289847 1.5666667 0.281603 1.5694444 0.271985 1.5722222 0.262366 1.5750000 0.258244 1.5777778 0.254122 1.5805556 0.254122 1.5833333 0.252748 1.5861111 0.251374 1.5888889 0.251374 1.5916667 0.248626 1.5944444 0.241756 1.5972222 0.236260 1.6000000 0.228015 1.6027778 0.219771 1.6055556 0.218397 1.6083333 0.217023 1.6111111 0.219771 1.6138889 0.223893 1.6166667 0.230763 1.6194444 0.237634 1.6222222 0.243130 1.6250000 0.244504 1.6277778 0.240382 1.6305556 0.244504 1.6333333 0.240382 1.6361111 0.241756 1.6388889 0.236260 1.6416667 0.237634 1.6444444 0.233511 1.6472222 0.233511 1.6500000 0.234885 1.6527778 0.234885 1.6555556 0.236260 1.6583333 0.237634 1.6611111 0.239008 1.6638889 0.240382 1.6666667 0.236260 1.6694444 0.236260 1.6722222 0.239008 1.6750000 0.248626 1.6777778 0.263740 1.6805556 0.280229 1.6833333 0.288473 1.6861111 0.285725 1.6888889 0.265115 1.6916667 0.230763 1.6944444 0.182672 1.6972222 0.123588 1.7000000 0.048015 1.7027778 0.010000 1.7055556 0.010000 1.7083333 0.010000 1.7111111 0.010000 1.7138889 0.010000 1.7166667 0.010000 1.7194444 0.010000 1.7222222 0.010000 1.7250000 0.010000 1.7277778 0.010000 1.7305556 0.010000 1.7333333 0.010000 1.7361111 0.010000 1.7388889 0.010000 1.7416667 0.056260 1.7444444 0.091985 1.7472222 0.118092 1.7500000 0.142824 1.7527778 0.164809 1.7555556 0.189542 1.7583333 0.211527 1.7611111 0.229389 1.7638889 0.240382 1.7666667 0.247252 1.7694444 0.248626 1.7722222 0.250000 1.7750000 0.252748 1.7777778 0.255496 1.7805556 0.256870 1.7833333 0.263740 1.7861111 0.270611 1.7888889 0.276107 1.7916667 0.277481 1.7944444 0.278855 1.7972222 0.280229 1.8000000 0.281603 1.8027778 0.278855 1.8055556 0.284351 1.8083333 0.282977 1.8111111 0.284351 1.8138889 0.288473 1.8166667 0.292595 1.8194444 0.296718 1.8222222 0.299466 1.8250000 0.300840 1.8277778 0.299466 1.8305556 0.302214 1.8333333 0.303588 1.8361111 0.303588 1.8388889 0.303588 1.8416667 0.306336 1.8444444 0.310458 1.8472222 0.313206 1.8500000 0.315954 1.8527778 0.318702 1.8555556 0.324198 1.8583333 0.324198 1.8611111 0.329695 1.8638889 0.331069 1.8666667 0.331069 1.8694444 0.331069 1.8722222 0.332443 1.8750000 0.329695 1.8777778 0.333817 1.8805556 0.336565 1.8833333 0.340687 1.8861111 0.344809 1.8888889 0.350305 1.8916667 0.357176 1.8944444 0.357176 1.8972222 0.355802 1.9000000 0.357176 1.9027778 0.358550 1.9055556 0.357176 1.9083333 0.357176 1.9111111 0.361298 1.9138889 0.365420 1.9166667 0.366794 1.9194444 0.373664 1.9222222 0.370916 1.9250000 0.373664 1.9277778 0.370916 1.9305556 0.369542 1.9333333 0.366794 1.9361111 0.366794 1.9388889 0.362672 1.9416667 0.361298 1.9444444 0.357176 1.9472222 0.358550 1.9500000 0.353053 1.9527778 0.351679 1.9555556 0.350305 1.9583333 0.347557 1.9611111 0.337939 1.9638889 0.333817 1.9666667 0.329695 1.9694444 0.322824 1.9722222 0.317328 1.9750000 0.306336 1.9777778 0.304962 1.9805556 0.296718 1.9833333 0.291221 1.9861111 0.288473 1.9888889 0.287099 1.9916667 0.284351 1.9944444 0.278855 1.9972222 0.271985 2.0000000 0.267863 2.0027778 0.265115 2.0055556 0.259618 2.0083333 0.255496 2.0611111 0.252748 2.0638889 0.254122 2.0666667 0.248626 2.0694444 0.250000 2.0722222 0.250000 2.0750000 0.250000 2.0777778 0.250000 2.0805556 0.251374 2.0833333 0.252748 2.0861111 0.252748 2.0888889 0.255496 2.0916667 0.254122 2.0944444 0.255496 2.0972222 0.258244 2.1000000 0.255496 2.1027778 0.254122 2.1055556 0.254122 2.1083333 0.255496 2.1111111 0.256870 2.1138889 0.256870 2.1166667 0.259618 2.1194444 0.258244 2.1222222 0.265115 2.1250000 0.270611 2.1277778 0.273359 2.1305556 0.280229 2.1333333 0.287099 2.1361111 0.289847 2.1388889 0.296718 2.1416667 0.296718 2.1444444 0.299466 2.1472222 0.302214 2.1500000 0.302214 2.1527778 0.304962 2.1555556 0.303588 2.1583333 0.300840 2.1611111 0.292595 2.1638889 0.282977 2.1666667 0.266489 2.1694444 0.258244 2.1722222 0.251374 2.1750000 0.243130 2.1777778 0.241756 2.1805556 0.244504 2.1833333 0.244504 2.1861111 0.244504 2.1888889 0.239008 2.1916667 0.233511 2.1944444 0.225267 2.1972222 0.222519 2.2000000 0.218397 2.2027778 0.218397 2.2055556 0.219771 2.2083333 0.226641 2.2111111 0.233511 2.2138889 0.236260 2.2166667 0.239008 2.2194444 0.239008 2.2222222 0.240382 2.2250000 0.237634 2.2277778 0.239008 2.2305556 0.240382 2.2333333 0.240382 2.2361111 0.236260 2.2388889 0.236260 2.2416667 0.234885 2.2444444 0.234885 2.2472222 0.232137 2.2500000 0.232137 2.2527778 0.232137 2.2555556 0.234885 2.2583333 0.237634 2.2611111 0.239008 2.2638889 0.240382 2.2666667 0.237634 2.2694444 0.239008 2.2722222 0.244504 2.2750000 0.252748 2.2777778 0.266489 2.2805556 0.277481 2.2833333 0.284351 2.2861111 0.282977 2.2888889 0.263740 2.2916667 0.226641 2.2944444 0.177176 2.2972222 0.115344 2.3000000 0.031527 2.3027778 0.010000 2.3055556 0.010000 2.3083333 0.010000 2.3111111 0.010000 2.3138889 0.010000 2.3166667 0.010000 2.3194444 0.010000 2.3222222 0.010000 2.3250000 0.010000 2.3277778 0.010000 2.3305556 0.010000 2.3333333 0.010000 2.3361111 0.010000 2.3388889 0.027405 2.3416667 0.071374 2.3444444 0.100229 2.3472222 0.122214 2.3500000 0.140076 2.3527778 0.160687 2.3555556 0.182672 2.3583333 0.200534 2.3611111 0.217023 2.3638889 0.232137 2.3666667 0.240382 2.3694444 0.244504 2.3722222 0.245878 2.3750000 0.244504 2.3777778 0.247252 2.3805556 0.251374 2.3833333 0.252748 2.3861111 0.256870 2.3888889 0.263740 2.3916667 0.267863 2.3944444 0.270611 2.3972222 0.271985 2.4000000 0.271985 2.4027778 0.274733 2.4055556 0.273359 2.4083333 0.270611 2.4111111 0.274733 2.4138889 0.280229 2.4166667 0.282977 2.4194444 0.285725 2.4222222 0.289847 2.4250000 0.293969 2.4277778 0.292595 2.4305556 0.295344 2.4333333 0.295344 2.4361111 0.296718 2.4388889 0.298092 2.4416667 0.296718 2.4444444 0.300840 2.4472222 0.303588 2.4500000 0.309084 2.4527778 0.315954 2.4555556 0.318702 2.4583333 0.320076 2.4611111 0.321450 2.4638889 0.322824 2.4666667 0.324198 2.4694444 0.329695 2.4722222 0.332443 2.4750000 0.332443 2.4777778 0.336565 2.4805556 0.339313 2.4833333 0.344809 2.4861111 0.347557 2.4888889 0.355802 2.4916667 0.361298 2.4944444 0.364046 2.4972222 0.362672 2.5000000 0.366794 2.5027778 0.362672 2.5055556 0.362672 2.5083333 0.362672 2.5111111 0.365420 2.5138889 0.366794 2.5166667 0.369542 2.5194444 0.375038 2.5222222 0.376412 2.5250000 0.377786 2.5277778 0.379160 2.5305556 0.376412 2.5333333 0.370916 2.5361111 0.369542 2.5388889 0.361298 2.5416667 0.355802 2.5444444 0.347557 2.5472222 0.346183 2.5500000 0.342061 2.5527778 0.339313 2.5555556 0.331069 2.5583333 0.326947 2.5611111 0.313206 2.5638889 0.309084 2.5666667 0.300840 2.5694444 0.292595 2.5722222 0.282977 2.5750000 0.276107 2.5777778 0.270611 2.5805556 0.266489 2.5833333 0.266489 2.5861111 0.263740 2.5888889 0.259618 2.5916667 0.256870 2.5944444 0.254122 2.5972222 0.252748 2.6000000 0.250000 2.6027778 0.247252 2.6055556 0.244504 2.6083333 0.243130 2.6111111 0.237634 2.6138889 0.241756 2.6166667 0.241756 2.6194444 0.241756 2.6222222 0.245878 2.6250000 0.247252 2.6277778 0.250000 2.6305556 0.245878 2.6333333 0.244504 2.6361111 0.241756 2.6388889 0.236260 2.6416667 0.233511 2.6444444 0.232137 2.6472222 0.232137 2.6500000 0.234885 2.6527778 0.230763 2.6555556 0.228015 2.6583333 0.218397 2.6611111 0.206031 2.6638889 0.182672 2.6666667 0.160687 2.6694444 0.135954 2.6722222 0.116718 2.6750000 0.108473 2.6777778 0.108473 2.6805556 0.108473 2.6833333 0.107099 2.6861111 0.104351 2.6888889 0.102977 2.6916667 0.107099 2.6944444 0.124962 2.6972222 0.155191 2.7000000 0.193664 2.7027778 0.237634 2.7055556 0.287099 2.7083333 0.337939 2.7111111 0.380534 2.7138889 0.423130 2.7166667 0.461603 2.7194444 0.493206 2.7222222 0.523435 2.7250000 0.539924 2.7277778 0.552290 2.7305556 0.561908 2.7333333 0.566031 2.7361111 0.556412 2.7388889 0.531679 2.7416667 0.483588 2.7444444 0.416260 2.7472222 0.337939 2.7500000 0.258244 2.7527778 0.186794 2.7555556 0.133206 2.7583333 0.098855 2.7611111 0.090611 2.7638889 0.098855 2.7666667 0.113969 2.7694444 0.129084 2.7722222 0.141450 2.7750000 0.155191 2.7777778 0.166183 2.7805556 0.171679 2.7833333 0.184046 2.7861111 0.189542 2.7888889 0.193664 2.7916667 0.196412 2.7944444 0.199160 2.7972222 0.200534 2.8000000 0.201908 2.8027778 0.201908 2.8055556 0.200534 2.8083333 0.201908 2.8111111 0.199160 2.8138889 0.197786 2.8166667 0.199160 2.8194444 0.199160 2.8222222 0.204656 2.8250000 0.201908 2.8277778 0.201908 2.8305556 0.201908 2.8333333 0.196412 2.8361111 0.193664 2.8388889 0.189542 2.8416667 0.190916 2.8444444 0.189542 2.8472222 0.193664 2.8500000 0.195038 2.8527778 0.195038 2.8555556 0.199160 2.8583333 0.196412 2.8611111 0.195038 2.8638889 0.196412 2.8666667 0.192290 2.8694444 0.188168 2.8722222 0.189542 2.8750000 0.188168 2.8777778 0.186794 2.8805556 0.184046 2.8833333 0.181298 2.8861111 0.182672 2.8888889 0.182672 2.8916667 0.179924 2.8944444 0.178550 2.8972222 0.178550 2.9000000 0.177176 2.9027778 0.173053 2.9055556 0.167557 2.9083333 0.166183 2.9111111 0.163435 2.9138889 0.160687 2.9166667 0.159313 2.9194444 0.159313 2.9222222 0.160687 2.9250000 0.163435 2.9277778 0.162061 2.9305556 0.157939 2.9333333 0.159313 2.9361111 0.155191 2.9388889 0.155191 2.9416667 0.157939 2.9444444 0.164809 2.9472222 0.166183 2.9500000 0.174427 2.9527778 0.178550 2.9555556 0.185420 2.9583333 0.186794 2.9611111 0.193664 2.9638889 0.196412 2.9666667 0.201908 2.9694444 0.206031 2.9722222 0.207405 2.9750000 0.214275 2.9777778 0.218397 2.9805556 0.225267 2.9833333 0.228015 2.9861111 0.232137 2.9888889 0.236260 2.9916667 0.240382 3.2111111 0.228015 3.2138889 0.228015 3.2166667 0.232137 3.2194444 0.244504 3.2222222 0.255496 3.2250000 0.262366 3.2277778 0.258244 3.2305556 0.251374 3.2333333 0.244504 3.2361111 0.241756 3.2388889 0.239008 3.2416667 0.234885 3.2444444 0.236260 3.2472222 0.241756 3.2500000 0.245878 3.2527778 0.251374 3.2555556 0.254122 3.2583333 0.258244 3.2611111 0.258244 3.2638889 0.259618 3.2666667 0.251374 3.2694444 0.250000 3.2722222 0.251374 3.2750000 0.254122 3.2777778 0.254122 3.2805556 0.254122 3.2833333 0.250000 3.2861111 0.252748 3.2888889 0.256870 3.2916667 0.267863 3.2944444 0.278855 3.2972222 0.293969 3.3000000 0.306336 3.3027778 0.310458 3.3055556 0.314580 3.3083333 0.309084 3.3111111 0.309084 3.3138889 0.304962 3.3166667 0.306336 3.3194444 0.307710 3.3222222 0.303588 3.3250000 0.296718 3.3277778 0.291221 3.3305556 0.285725 3.3333333 0.282977 3.3361111 0.274733 3.3388889 0.269237 3.3416667 0.266489 3.3444444 0.259618 3.3472222 0.258244 3.3500000 0.254122 3.3527778 0.252748 3.3555556 0.251374 3.3583333 0.248626 3.3611111 0.245878 3.3638889 0.245878 3.3666667 0.245878 3.3694444 0.254122 3.3722222 0.260992 3.3750000 0.267863 3.3777778 0.265115 3.3805556 0.260992 3.3833333 0.256870 3.3861111 0.252748 3.3888889 0.255496 3.3916667 0.252748 3.3944444 0.252748 3.3972222 0.255496 3.4000000 0.251374 3.4027778 0.251374 3.4055556 0.251374 3.4083333 0.251374 3.4111111 0.251374 3.4138889 0.255496 3.4166667 0.255496 3.4194444 0.255496 3.4222222 0.263740 3.4250000 0.274733 3.4277778 0.285725 3.4305556 0.293969 3.4333333 0.299466 3.4361111 0.296718 3.4388889 0.280229 3.4416667 0.260992 3.4444444 0.223893 3.4472222 0.173053 3.4500000 0.113969 3.4527778 0.041145 3.4555556 0.010000 3.4583333 0.010000 3.4611111 0.010000 3.4638889 0.010000 3.4666667 0.010000 3.4694444 0.010000 3.4722222 0.010000 3.4750000 0.010000 3.4777778 0.010000 3.4805556 0.010000 3.4833333 0.010000 3.4861111 0.024656 3.4888889 0.078244 3.4916667 0.116718 3.4944444 0.144198 3.4972222 0.163435 3.5000000 0.181298 3.5027778 0.197786 3.5055556 0.215649 3.5083333 0.230763 3.5111111 0.245878 3.5138889 0.252748 3.5166667 0.263740 3.5194444 0.270611 3.5222222 0.277481 3.5250000 0.278855 3.5277778 0.284351 3.5305556 0.287099 3.5333333 0.289847 3.5361111 0.291221 3.5388889 0.287099 3.5416667 0.285725 3.5444444 0.287099 3.5472222 0.292595 3.5500000 0.295344 3.5527778 0.300840 3.5555556 0.304962 3.5583333 0.309084 3.5611111 0.306336 3.5638889 0.309084 3.5666667 0.307710 3.5694444 0.303588 3.5722222 0.306336 3.5750000 0.306336 3.5777778 0.310458 3.5805556 0.313206 3.5833333 0.317328 3.5861111 0.315954 3.5888889 0.321450 3.5916667 0.320076 3.5944444 0.320076 3.5972222 0.320076 3.6000000 0.321450 3.6027778 0.321450 3.6055556 0.324198 3.6083333 0.328321 3.6111111 0.335191 3.6138889 0.331069 3.6166667 0.335191 3.6194444 0.339313 3.6222222 0.339313 3.6250000 0.344809 3.6277778 0.347557 3.6305556 0.347557 3.6333333 0.348931 3.6361111 0.347557 3.6388889 0.348931 3.6416667 0.350305 3.6444444 0.350305 3.6472222 0.354427 3.6500000 0.358550 3.6527778 0.361298 3.6555556 0.366794 3.6583333 0.369542 3.6611111 0.373664 3.6638889 0.373664 3.6666667 0.373664 3.6694444 0.370916 3.6722222 0.372290 3.6750000 0.368168 3.6777778 0.370916 3.6805556 0.369542 3.6833333 0.376412 3.6861111 0.379160 3.6888889 0.384656 3.6916667 0.387405 3.6944444 0.386031 3.6972222 0.387405 3.7000000 0.383282 3.7027778 0.376412 3.7055556 0.373664 3.7083333 0.370916 3.7111111 0.369542 3.7138889 0.369542 3.7166667 0.370916 3.7194444 0.370916 3.7222222 0.368168 3.7250000 0.365420 3.7277778 0.358550 3.7305556 0.353053 3.7333333 0.347557 3.7361111 0.339313 3.7388889 0.335191 3.7416667 0.329695 3.7444444 0.325573 3.7472222 0.320076 3.7500000 0.318702 3.7527778 0.314580 3.7555556 0.310458 3.7583333 0.306336 3.8277778 0.295344 3.8305556 0.293969 3.8333333 0.288473 3.8361111 0.288473 3.8388889 0.282977 3.8416667 0.287099 3.8444444 0.292595 3.8472222 0.295344 3.8500000 0.298092 3.8527778 0.303588 3.8555556 0.302214 3.8583333 0.299466 3.8611111 0.298092 3.8638889 0.295344 3.8666667 0.296718 3.8694444 0.298092 3.8722222 0.296718 3.8750000 0.298092 3.8777778 0.298092 3.8805556 0.300840 3.8833333 0.302214 3.8861111 0.300840 3.8888889 0.302214 3.8916667 0.304962 3.8944444 0.311832 3.8972222 0.313206 3.9000000 0.324198 3.9027778 0.328321 3.9055556 0.328321 3.9083333 0.332443 3.9111111 0.332443 3.9138889 0.331069 3.9166667 0.332443 3.9194444 0.333817 3.9222222 0.336565 3.9250000 0.340687 3.9277778 0.339313 3.9305556 0.328321 3.9333333 0.321450 3.9361111 0.313206 3.9388889 0.300840 3.9416667 0.292595 3.9444444 0.284351 3.9472222 0.285725 3.9500000 0.291221 3.9527778 0.292595 3.9555556 0.295344 3.9583333 0.292595 3.9611111 0.288473 3.9638889 0.282977 3.9666667 0.276107 3.9694444 0.269237 3.9722222 0.262366 3.9750000 0.260992 3.9777778 0.263740 3.9805556 0.269237 3.9833333 0.273359 3.9861111 0.284351 3.9888889 0.287099 3.9916667 0.288473 3.9944444 0.285725 3.9972222 0.285725 4.0000000 0.282977 4.0027778 0.278855 4.0055556 0.277481 4.0083333 0.277481 4.0111111 0.277481 4.0138889 0.278855 4.0166667 0.280229 4.0194444 0.280229 4.0222222 0.278855 4.0250000 0.278855 4.0277778 0.277481 4.0305556 0.280229 4.0333333 0.280229 4.0361111 0.280229 4.0388889 0.282977 4.0416667 0.288473 4.0444444 0.300840 4.0472222 0.309084 4.0500000 0.321450 4.0527778 0.324198 4.0555556 0.314580 4.0583333 0.292595 4.0611111 0.259618 4.0638889 0.207405 4.0666667 0.140076 4.0694444 0.052137 4.0722222 0.010000 4.0750000 0.010000 4.0777778 0.010000 4.0805556 0.010000 4.0833333 0.010000 4.0861111 0.010000 4.0888889 0.010000 4.0916667 0.010000 4.0944444 0.010000 4.0972222 0.010000 4.1000000 0.010000 4.1027778 0.031527 4.1055556 0.085115 4.1083333 0.120840 4.1111111 0.151069 4.1138889 0.173053 4.1166667 0.195038 4.1194444 0.217023 4.1222222 0.240382 4.1250000 0.259618 4.1277778 0.274733 4.1305556 0.287099 4.1333333 0.287099 4.1361111 0.288473 4.1388889 0.289847 4.1416667 0.295344 4.1444444 0.295344 4.1472222 0.295344 4.1500000 0.300840 4.1527778 0.304962 4.1555556 0.307710 4.1583333 0.309084 4.1611111 0.313206 4.1638889 0.315954 4.1666667 0.313206 4.1694444 0.314580 4.1722222 0.314580 4.1750000 0.313206 4.1777778 0.314580 4.1805556 0.317328 4.1833333 0.318702 4.1861111 0.324198 4.1888889 0.329695 4.1916667 0.331069 4.1944444 0.336565 4.1972222 0.331069 4.2000000 0.331069 4.2027778 0.329695 4.2055556 0.332443 4.2083333 0.336565 4.2111111 0.339313 4.2138889 0.343435 4.2166667 0.344809 4.2194444 0.350305 4.2222222 0.353053 4.2250000 0.355802 4.2277778 0.357176 4.2305556 0.359924 4.2333333 0.364046 4.2361111 0.364046 4.2388889 0.368168 4.2416667 0.369542 4.2444444 0.369542 4.2472222 0.369542 4.2500000 0.373664 4.2527778 0.377786 4.2555556 0.380534 4.2583333 0.386031 4.2611111 0.391527 4.2638889 0.388779 4.2666667 0.391527 4.2694444 0.392901 4.2722222 0.392901 4.2750000 0.397023 4.2777778 0.394275 4.2805556 0.391527 4.2833333 0.398397 4.2861111 0.401145 4.2888889 0.405267 4.2916667 0.405267 4.2944444 0.408015 4.2972222 0.403893 4.3000000 0.398397 4.3027778 0.391527 4.3055556 0.388779 4.3083333 0.384656 4.3111111 0.381908 4.3138889 0.373664 4.3166667 0.375038 4.3194444 0.370916 4.3222222 0.364046 4.3250000 0.358550 4.3277778 0.351679 4.3305556 0.344809 4.3333333 0.336565 4.3361111 0.332443 4.3388889 0.324198 4.3416667 0.320076 4.3444444 0.315954 4.3472222 0.313206 4.3500000 0.310458 4.3527778 0.310458 4.3555556 0.307710 4.3583333 0.304962 4.3611111 0.299466 4.3638889 0.299466 4.3666667 0.293969 4.3694444 0.296718 4.3722222 0.293969 4.3750000 0.292595 4.4194444 0.289847 4.4222222 0.293969 4.4250000 0.296718 4.4277778 0.295344 4.4305556 0.292595 4.4333333 0.291221 4.4361111 0.287099 4.4388889 0.282977 4.4416667 0.282977 4.4444444 0.284351 4.4472222 0.285725 4.4500000 0.285725 4.4527778 0.288473 4.4555556 0.291221 4.4583333 0.293969 4.4611111 0.295344 4.4638889 0.291221 4.4666667 0.291221 4.4694444 0.288473 4.4722222 0.288473 4.4750000 0.289847 4.4777778 0.292595 4.4805556 0.299466 4.4833333 0.300840 4.4861111 0.306336 4.4888889 0.314580 4.4916667 0.322824 4.4944444 0.329695 4.4972222 0.335191 4.5000000 0.333817 4.5027778 0.333817 4.5055556 0.332443 4.5083333 0.329695 4.5111111 0.326947 4.5138889 0.321450 4.5166667 0.313206 4.5194444 0.313206 4.5222222 0.303588 4.5250000 0.302214 4.5277778 0.291221 4.5305556 0.285725 4.5333333 0.287099 4.5361111 0.280229 4.5388889 0.282977 4.5416667 0.278855 4.5444444 0.281603 4.5472222 0.274733 4.5500000 0.270611 4.5527778 0.265115 4.5555556 0.266489 4.5583333 0.265115 4.5611111 0.265115 4.5638889 0.266489 4.5666667 0.271985 4.5694444 0.274733 4.5722222 0.276107 4.5750000 0.273359 4.5777778 0.271985 4.5805556 0.269237 4.5833333 0.273359 4.5861111 0.276107 4.5888889 0.278855 4.5916667 0.280229 4.5944444 0.280229 4.5972222 0.277481 4.6000000 0.273359 4.6027778 0.270611 4.6055556 0.270611 4.6083333 0.267863 4.6111111 0.269237 4.6138889 0.267863 4.6166667 0.269237 4.6194444 0.270611 4.6222222 0.267863 4.6250000 0.274733 4.6277778 0.276107 4.6305556 0.281603 4.6333333 0.291221 4.6361111 0.304962 4.6388889 0.310458 4.6416667 0.318702 4.6444444 0.313206 4.6472222 0.293969 4.6500000 0.259618 4.6527778 0.226641 4.6555556 0.168931 4.6583333 0.100229 4.6611111 0.019160 4.6638889 0.010000 4.6666667 0.010000 4.6694444 0.010000 4.6722222 0.010000 4.6750000 0.010000 4.6777778 0.010000 4.6805556 0.010000 4.6833333 0.010000 4.6861111 0.010000 4.6888889 0.010000 4.6916667 0.010000 4.6944444 0.010000 4.6972222 0.045267 4.7000000 0.083740 4.7027778 0.119466 4.7055556 0.142824 4.7083333 0.164809 4.7111111 0.184046 4.7138889 0.201908 4.7166667 0.222519 4.7194444 0.243130 4.7222222 0.259618 4.7250000 0.270611 4.7277778 0.277481 4.7305556 0.278855 4.7333333 0.282977 4.7361111 0.280229 4.7388889 0.276107 4.7416667 0.284351 4.7444444 0.284351 4.7472222 0.287099 4.7500000 0.291221 4.7527778 0.296718 4.7555556 0.300840 4.7583333 0.303588 4.7611111 0.303588 4.7638889 0.303588 4.7666667 0.303588 4.7694444 0.303588 4.7722222 0.303588 4.7750000 0.303588 4.7777778 0.306336 4.7805556 0.306336 4.7833333 0.309084 4.7861111 0.314580 4.7888889 0.315954 4.7916667 0.318702 4.7944444 0.318702 4.7972222 0.318702 4.8000000 0.321450 4.8027778 0.322824 4.8055556 0.318702 4.8083333 0.320076 4.8111111 0.324198 4.8138889 0.328321 4.8166667 0.329695 4.8194444 0.332443 4.8222222 0.336565 4.8250000 0.342061 4.8277778 0.340687 4.8305556 0.346183 4.8333333 0.350305 4.8361111 0.348931 4.8388889 0.347557 4.8416667 0.347557 4.8444444 0.350305 4.8472222 0.353053 4.8500000 0.358550 4.8527778 0.361298 4.8555556 0.370916 4.8583333 0.375038 4.8611111 0.379160 4.8638889 0.376412 4.8666667 0.377786 4.8694444 0.377786 4.8722222 0.375038 4.8750000 0.379160 4.8777778 0.377786 4.8805556 0.381908 4.8833333 0.388779 4.8861111 0.390153 4.8888889 0.390153 4.8916667 0.392901 4.8944444 0.391527 4.8972222 0.388779 4.9000000 0.386031 4.9027778 0.381908 4.9055556 0.379160 4.9083333 0.373664 4.9111111 0.369542 4.9138889 0.369542 4.9166667 0.364046 4.9194444 0.358550 4.9222222 0.354427 4.9250000 0.350305 4.9277778 0.344809 4.9305556 0.335191 4.9333333 0.329695 4.9361111 0.320076 4.9388889 0.313206 4.9416667 0.311832 4.9444444 0.304962 4.9472222 0.298092 4.9500000 0.295344 4.9527778 0.291221 4.9555556 0.285725 4.9583333 0.287099 4.9611111 0.281603 4.9638889 0.280229 4.9666667 0.277481 4.9694444 0.274733 4.9722222 0.271985 4.9750000 0.265115 4.9777778 0.262366 4.9805556 0.263740 4.9833333 0.263740 4.9861111 0.267863 4.9888889 0.270611 4.9916667 0.273359 4.9944444 0.267863 4.9972222 0.267863 5.0000000 0.269237 5.0027778 0.260992 5.0055556 0.256870 5.0083333 0.258244 5.0111111 0.251374 5.0138889 0.254122 5.0166667 0.251374 5.0194444 0.250000 5.0222222 0.250000 5.0250000 0.250000 5.0277778 0.244504 5.0305556 0.230763 5.0333333 0.218397 5.0361111 0.199160 5.0388889 0.178550 5.0416667 0.164809 5.0444444 0.153817 5.0472222 0.152443 5.0500000 0.151069 5.0527778 0.159313 5.0555556 0.151069 5.0583333 0.148321 5.0611111 0.142824 5.0638889 0.141450 5.0666667 0.145573 5.0694444 0.164809 5.0722222 0.192290 5.0750000 0.229389 5.0777778 0.274733 5.0805556 0.313206 5.0833333 0.355802 5.0861111 0.392901 5.0888889 0.424504 5.0916667 0.454733 5.0944444 0.479466 5.0972222 0.494580 5.1000000 0.513817 5.1027778 0.522061 5.1055556 0.527557 5.1083333 0.531679 5.1111111 0.528931 5.1138889 0.508321 5.1166667 0.469847 5.1194444 0.412137 5.1222222 0.339313 5.1250000 0.265115 5.1277778 0.201908 5.1305556 0.156565 5.1333333 0.137328 5.1361111 0.130458 5.1388889 0.145573 5.1416667 0.159313 5.1444444 0.173053 5.1472222 0.190916 5.1500000 0.201908 5.1527778 0.210153 5.1555556 0.211527 5.1583333 0.215649 5.1611111 0.217023 5.1638889 0.215649 5.1666667 0.218397 5.1694444 0.221145 5.1722222 0.223893 5.1750000 0.222519 5.1777778 0.222519 5.1805556 0.222519 5.1833333 0.226641 5.1861111 0.225267 5.1888889 0.228015 5.1916667 0.225267 5.1944444 0.225267 5.1972222 0.228015 5.2000000 0.222519 5.2027778 0.219771 5.2055556 0.219771 5.2083333 0.219771 5.2111111 0.218397 5.2138889 0.217023 5.2166667 0.219771 5.2194444 0.217023 5.2222222 0.217023 5.2250000 0.219771 5.2277778 0.222519 5.2305556 0.219771 5.2333333 0.218397 5.2361111 0.217023 5.2388889 0.214275 5.2416667 0.212901 5.2444444 0.210153 5.2472222 0.207405 5.2500000 0.208779 5.2527778 0.211527 5.2555556 0.214275 5.2583333 0.212901 5.2611111 0.214275 5.2638889 0.211527 5.2666667 0.208779 5.2694444 0.201908 5.2722222 0.200534 5.2750000 0.196412 5.2777778 0.195038 5.2805556 0.196412 5.2833333 0.197786 5.2861111 0.199160 5.2888889 0.193664 5.2916667 0.196412 5.2944444 0.193664 5.2972222 0.190916 5.3000000 0.188168 5.3027778 0.182672 5.3055556 0.185420 5.3083333 0.178550 5.3111111 0.181298 5.3138889 0.178550 5.3166667 0.181298 5.3194444 0.179924 5.3222222 0.184046 5.3250000 0.188168 5.5944444 0.229389 5.5972222 0.225267 5.6000000 0.223893 5.6027778 0.222519 5.6055556 0.219771 5.6083333 0.221145 5.6111111 0.218397 5.6138889 0.225267 5.6166667 0.222519 5.6194444 0.222519 5.6222222 0.226641 5.6250000 0.223893 5.6277778 0.225267 5.6305556 0.225267 5.6333333 0.223893 5.6361111 0.222519 5.6388889 0.218397 5.6416667 0.215649 5.6444444 0.218397 5.6472222 0.218397 5.6500000 0.218397 5.6527778 0.219771 5.6555556 0.219771 5.6583333 0.222519 5.6611111 0.226641 5.6638889 0.225267 5.6666667 0.229389 5.6694444 0.232137 5.6722222 0.234885 5.6750000 0.239008 5.6777778 0.250000 5.6805556 0.258244 5.6833333 0.262366 5.6861111 0.262366 5.6888889 0.269237 5.6916667 0.266489 5.6944444 0.266489 5.6972222 0.258244 5.7000000 0.252748 5.7027778 0.240382 5.7055556 0.232137 5.7083333 0.223893 5.7111111 0.221145 5.7138889 0.217023 5.7166667 0.219771 5.7194444 0.215649 5.7222222 0.218397 5.7250000 0.219771 5.7277778 0.214275 5.7305556 0.207405 5.7333333 0.197786 5.7361111 0.195038 5.7388889 0.186794 5.7416667 0.185420 5.7444444 0.188168 5.7472222 0.188168 5.7500000 0.195038 5.7527778 0.201908 5.7555556 0.204656 5.7583333 0.204656 5.7611111 0.206031 5.7638889 0.207405 5.7666667 0.204656 5.7694444 0.207405 5.7722222 0.204656 5.7750000 0.200534 5.7777778 0.197786 5.7805556 0.197786 5.7833333 0.195038 5.7861111 0.197786 5.7888889 0.196412 5.7916667 0.200534 5.7944444 0.200534 5.7972222 0.200534 5.8000000 0.201908 5.8027778 0.201908 5.8055556 0.206031 5.8083333 0.210153 5.8111111 0.223893 5.8138889 0.230763 5.8166667 0.243130 5.8194444 0.243130 5.8222222 0.230763 5.8250000 0.203282 5.8277778 0.157939 5.8305556 0.098855 5.8333333 0.024656 5.8361111 0.010000 5.8388889 0.010000 5.8416667 0.010000 5.8444444 0.010000 5.8472222 0.010000 5.8500000 0.010000 5.8527778 0.010000 5.8555556 0.010000 5.8583333 0.010000 5.8611111 0.010000 5.8638889 0.010000 5.8666667 0.010000 5.8694444 0.010000 5.8722222 0.010000 5.8750000 0.034275 5.8777778 0.060382 5.8805556 0.082366 5.8833333 0.101603 5.8861111 0.122214 5.8888889 0.144198 5.8916667 0.162061 5.8944444 0.184046 5.8972222 0.192290 5.9000000 0.204656 5.9027778 0.207405 5.9055556 0.203282 5.9083333 0.201908 5.9111111 0.203282 5.9138889 0.206031 5.9166667 0.207405 5.9194444 0.214275 5.9222222 0.219771 5.9250000 0.223893 5.9277778 0.225267 5.9305556 0.228015 5.9333333 0.228015 5.9361111 0.229389 5.9388889 0.228015 5.9416667 0.226641 5.9444444 0.225267 5.9472222 0.229389 5.9500000 0.233511 5.9527778 0.239008 5.9555556 0.241756 5.9583333 0.244504 5.9611111 0.245878 5.9638889 0.244504 5.9666667 0.243130 5.9694444 0.244504 5.9722222 0.245878 5.9750000 0.250000 5.9777778 0.251374 5.9805556 0.254122 5.9833333 0.255496 5.9861111 0.258244 5.9888889 0.260992 5.9916667 0.262366 5.9944444 0.267863 5.9972222 0.271985 6.0000000 0.270611 6.0027778 0.273359 6.0055556 0.270611 6.0083333 0.274733 6.0111111 0.273359 6.0138889 0.274733 6.0166667 0.277481 6.0194444 0.280229 6.0222222 0.284351 6.0250000 0.291221 6.0277778 0.295344 6.0305556 0.298092 6.0333333 0.296718 6.0361111 0.300840 6.0388889 0.298092 6.0416667 0.299466 6.0444444 0.293969 6.0472222 0.299466 6.0500000 0.303588 6.0527778 0.309084 6.0555556 0.310458 6.0583333 0.315954 6.0611111 0.315954 6.0638889 0.313206 6.0666667 0.311832 6.0694444 0.309084 6.0722222 0.303588 6.0750000 0.304962 6.0777778 0.302214 6.0805556 0.304962 6.0833333 0.303588 6.0861111 0.300840 6.0888889 0.296718 6.0916667 0.298092 6.0944444 0.293969 6.0972222 0.285725 6.1000000 0.282977 6.1027778 0.274733 6.1055556 0.267863 6.1083333 0.262366 6.1111111 0.255496 6.1138889 0.245878 6.1166667 0.243130 6.1194444 0.237634 6.1222222 0.234885 6.1250000 0.228015 6.1277778 0.223893 6.1305556 0.219771 6.1333333 0.215649 6.1361111 0.210153 6.1388889 0.207405 6.1416667 0.201908 6.3444444 0.250000)
Vrpeak rpeak_trigger 0 PWL(0.0000000 0.000000 0.4990000 0.000000 0.5000000 0.900000 0.5010000 0.900000 0.5020000 0.000000 1.0295556 0.000000 1.0305556 0.900000 1.0315556 0.900000 1.0325556 0.000000 1.7101111 0.000000 1.7111111 0.900000 1.7121111 0.900000 1.7131111 0.000000 2.3101111 0.000000 2.3111111 0.900000 2.3121111 0.900000 2.3131111 0.000000 2.6934444 0.000000 2.6944444 0.900000 2.6954444 0.900000 2.6964444 0.000000 3.4601111 0.000000 3.4611111 0.900000 3.4621111 0.900000 3.4631111 0.000000 4.0767778 0.000000 4.0777778 0.900000 4.0787778 0.900000 4.0797778 0.000000 4.6684444 0.000000 4.6694444 0.900000 4.6704444 0.900000 4.6714444 0.000000 5.0267778 0.000000 5.0277778 0.900000 5.0287778 0.900000 5.0297778 0.000000 5.8434444 0.000000 5.8444444 0.900000 5.8454444 0.900000 5.8464444 0.000000 6.3444444 0.000000)
Vqrs qrs_gate 0 PWL(0.0000000 0.000000 0.4745556 0.000000 0.4755556 0.900000 0.5244444 0.900000 0.5254444 0.000000 0.9690000 0.000000 0.9700000 0.900000 1.0661111 0.900000 1.0671111 0.000000 1.6856667 0.000000 1.6866667 0.900000 1.7355556 0.900000 1.7365556 0.000000 2.2856667 0.000000 2.2866667 0.900000 2.3327778 0.900000 2.3337778 0.000000 2.6690000 0.000000 2.6700000 0.900000 2.7633333 0.900000 2.7643333 0.000000 3.3995556 0.000000 3.4005556 0.900000 3.5744444 0.900000 3.5754444 0.000000 4.0162222 0.000000 4.0172222 0.900000 4.1911111 0.900000 4.1921111 0.000000 4.6467778 0.000000 4.6477778 0.900000 4.7827778 0.900000 4.7837778 0.000000 5.0217778 0.000000 5.0227778 0.900000 5.1272222 0.900000 5.1282222 0.000000 5.8190000 0.000000 5.8200000 0.900000 5.8688889 0.900000 5.8698889 0.000000 6.3444444 0.000000)
Vsym qrs_sym_gate 0 PWL(0.0000000 0.000000 0.4886667 0.000000 0.4896667 0.900000 0.5131111 0.900000 0.5141111 0.000000 0.9747778 0.000000 0.9757778 0.900000 1.0464444 0.900000 1.0474444 0.000000 1.6970000 0.000000 1.6980000 0.900000 1.7242222 0.900000 1.7252222 0.000000 2.2970000 0.000000 2.2980000 0.900000 2.3242222 0.900000 2.3252222 0.000000 2.6775556 0.000000 2.6785556 0.900000 2.7242222 0.900000 2.7252222 0.000000 3.4025556 0.000000 3.4035556 0.900000 3.5714444 0.900000 3.5724444 0.000000 4.0692222 0.000000 4.0702222 0.900000 4.0881111 0.900000 4.0891111 0.000000 4.6581111 0.000000 4.6591111 0.900000 4.6825556 0.900000 4.6835556 0.000000 5.0525556 0.000000 5.0535556 0.900000 5.0992222 0.900000 5.1002222 0.000000 5.8331111 0.000000 5.8341111 0.900000 5.8575556 0.900000 5.8585556 0.000000 6.3444444 0.000000)
Vpwave pwave_gate 0 PWL(0.0000000 0.000000 0.2934444 0.000000 0.2944444 0.900000 0.4444444 0.900000 0.4454444 0.000000 0.8240000 0.000000 0.8250000 0.900000 0.9750000 0.900000 0.9760000 0.000000 1.5045556 0.000000 1.5055556 0.900000 1.6555556 0.900000 1.6565556 0.000000 2.1045556 0.000000 2.1055556 0.900000 2.2555556 0.900000 2.2565556 0.000000 2.4878889 0.000000 2.4888889 0.900000 2.6388889 0.900000 2.6398889 0.000000 3.2545556 0.000000 3.2555556 0.900000 3.4055556 0.900000 3.4065556 0.000000 3.8712222 0.000000 3.8722222 0.900000 4.0222222 0.900000 4.0232222 0.000000 4.4628889 0.000000 4.4638889 0.900000 4.6138889 0.900000 4.6148889 0.000000 4.8212222 0.000000 4.8222222 0.900000 4.9722222 0.900000 4.9732222 0.000000 5.6378889 0.000000 5.6388889 0.900000 5.7888889 0.900000 5.7898889 0.000000 6.3444444 0.000000)

Xrr rpeak_trigger f_rr_ratio f_rr_asym vdd vss vbias rr_timing
Xinstab0 ecg_in qrs_gate rpeak_trigger f_instab_l0 peak_out_l0 vdd vss vbias vref beat_instability
Xinstab1 ecg_in_l1 qrs_gate rpeak_trigger f_instab_l1 peak_out_l1 vdd vss vbias vref beat_instability

* Width uses the correct 30% threshold (from PWL for now, will be generated internally)
Xwidth width_threshold ecg_in qrs_gate rpeak_trigger f_width vdd vss vbias qrs_width

Xpwave ecg_in_l1 pwave_gate rpeak_trigger f_pwave vdd vss vbias vref pwave_energy
Xsym qrs_sym_gate rpeak_trigger f_sym rise_timer_out fall_timer_out vdd vss vbias qrs_symmetry
Xslope rise_timer_out fall_timer_out f_slope vdd vss vbias slope_ratio

.tran 0.5m 6.3444

.meas tran f_rr_ratio_b0 FIND V(f_rr_ratio) AT=0.4605556
.meas tran f_instab_l1_b0 FIND V(f_instab_l1) AT=0.4605556
.meas tran f_rr_asym_b0 FIND V(f_rr_asym) AT=0.4605556
.meas tran f_pwave_b0 FIND V(f_pwave) AT=0.4605556
.meas tran f_width_b0 FIND V(f_width) AT=0.5394444
.meas tran f_instab_l0_b0 FIND V(f_instab_l0) AT=0.4605556
.meas tran peak_l0_b0 FIND V(peak_out_l0) AT=0.5394444
.meas tran peak_l1_b0 FIND V(peak_out_l1) AT=0.5394444
.meas tran thr_b0 FIND V(width_threshold) AT=0.4605556
.meas tran f_sym_b0 FIND V(f_sym) AT=0.5311111
.meas tran f_slope_b0 FIND V(f_slope) AT=0.5311111
.meas tran rise_b0 FIND V(rise_timer_out) AT=0.5311111
.meas tran fall_b0 FIND V(fall_timer_out) AT=0.5311111
.meas tran f_rr_ratio_b1 FIND V(f_rr_ratio) AT=0.9550000
.meas tran f_instab_l1_b1 FIND V(f_instab_l1) AT=0.9550000
.meas tran f_rr_asym_b1 FIND V(f_rr_asym) AT=0.9550000
.meas tran f_pwave_b1 FIND V(f_pwave) AT=0.9550000
.meas tran f_width_b1 FIND V(f_width) AT=1.0811111
.meas tran f_instab_l0_b1 FIND V(f_instab_l0) AT=0.9550000
.meas tran peak_l0_b1 FIND V(peak_out_l0) AT=1.0811111
.meas tran peak_l1_b1 FIND V(peak_out_l1) AT=1.0811111
.meas tran thr_b1 FIND V(width_threshold) AT=0.9550000
.meas tran f_sym_b1 FIND V(f_sym) AT=1.0644444
.meas tran f_slope_b1 FIND V(f_slope) AT=1.0644444
.meas tran rise_b1 FIND V(rise_timer_out) AT=1.0644444
.meas tran fall_b1 FIND V(fall_timer_out) AT=1.0644444
.meas tran f_rr_ratio_b2 FIND V(f_rr_ratio) AT=1.6716667
.meas tran f_instab_l1_b2 FIND V(f_instab_l1) AT=1.6716667
.meas tran f_rr_asym_b2 FIND V(f_rr_asym) AT=1.6716667
.meas tran f_pwave_b2 FIND V(f_pwave) AT=1.6716667
.meas tran f_width_b2 FIND V(f_width) AT=1.7505556
.meas tran f_instab_l0_b2 FIND V(f_instab_l0) AT=1.6716667
.meas tran peak_l0_b2 FIND V(peak_out_l0) AT=1.7505556
.meas tran peak_l1_b2 FIND V(peak_out_l1) AT=1.7505556
.meas tran thr_b2 FIND V(width_threshold) AT=1.6716667
.meas tran f_sym_b2 FIND V(f_sym) AT=1.7422222
.meas tran f_slope_b2 FIND V(f_slope) AT=1.7422222
.meas tran rise_b2 FIND V(rise_timer_out) AT=1.7422222
.meas tran fall_b2 FIND V(fall_timer_out) AT=1.7422222
.meas tran f_rr_ratio_b3 FIND V(f_rr_ratio) AT=2.2716667
.meas tran f_instab_l1_b3 FIND V(f_instab_l1) AT=2.2716667
.meas tran f_rr_asym_b3 FIND V(f_rr_asym) AT=2.2716667
.meas tran f_pwave_b3 FIND V(f_pwave) AT=2.2716667
.meas tran f_width_b3 FIND V(f_width) AT=2.3477778
.meas tran f_instab_l0_b3 FIND V(f_instab_l0) AT=2.2716667
.meas tran peak_l0_b3 FIND V(peak_out_l0) AT=2.3477778
.meas tran peak_l1_b3 FIND V(peak_out_l1) AT=2.3477778
.meas tran thr_b3 FIND V(width_threshold) AT=2.2716667
.meas tran f_sym_b3 FIND V(f_sym) AT=2.3422222
.meas tran f_slope_b3 FIND V(f_slope) AT=2.3422222
.meas tran rise_b3 FIND V(rise_timer_out) AT=2.3422222
.meas tran fall_b3 FIND V(fall_timer_out) AT=2.3422222
.meas tran f_rr_ratio_b4 FIND V(f_rr_ratio) AT=2.6550000
.meas tran f_instab_l1_b4 FIND V(f_instab_l1) AT=2.6550000
.meas tran f_rr_asym_b4 FIND V(f_rr_asym) AT=2.6550000
.meas tran f_pwave_b4 FIND V(f_pwave) AT=2.6550000
.meas tran f_width_b4 FIND V(f_width) AT=2.7783333
.meas tran f_instab_l0_b4 FIND V(f_instab_l0) AT=2.6550000
.meas tran peak_l0_b4 FIND V(peak_out_l0) AT=2.7783333
.meas tran peak_l1_b4 FIND V(peak_out_l1) AT=2.7783333
.meas tran thr_b4 FIND V(width_threshold) AT=2.6550000
.meas tran f_sym_b4 FIND V(f_sym) AT=2.7422222
.meas tran f_slope_b4 FIND V(f_slope) AT=2.7422222
.meas tran rise_b4 FIND V(rise_timer_out) AT=2.7422222
.meas tran fall_b4 FIND V(fall_timer_out) AT=2.7422222
.meas tran f_rr_ratio_b5 FIND V(f_rr_ratio) AT=3.3855556
.meas tran f_instab_l1_b5 FIND V(f_instab_l1) AT=3.3855556
.meas tran f_rr_asym_b5 FIND V(f_rr_asym) AT=3.3855556
.meas tran f_pwave_b5 FIND V(f_pwave) AT=3.3855556
.meas tran f_width_b5 FIND V(f_width) AT=3.5894444
.meas tran f_instab_l0_b5 FIND V(f_instab_l0) AT=3.3855556
.meas tran peak_l0_b5 FIND V(peak_out_l0) AT=3.5894444
.meas tran peak_l1_b5 FIND V(peak_out_l1) AT=3.5894444
.meas tran thr_b5 FIND V(width_threshold) AT=3.3855556
.meas tran f_sym_b5 FIND V(f_sym) AT=3.5894444
.meas tran f_slope_b5 FIND V(f_slope) AT=3.5894444
.meas tran rise_b5 FIND V(rise_timer_out) AT=3.5894444
.meas tran fall_b5 FIND V(fall_timer_out) AT=3.5894444
.meas tran f_rr_ratio_b6 FIND V(f_rr_ratio) AT=4.0022222
.meas tran f_instab_l1_b6 FIND V(f_instab_l1) AT=4.0022222
.meas tran f_rr_asym_b6 FIND V(f_rr_asym) AT=4.0022222
.meas tran f_pwave_b6 FIND V(f_pwave) AT=4.0022222
.meas tran f_width_b6 FIND V(f_width) AT=4.2061111
.meas tran f_instab_l0_b6 FIND V(f_instab_l0) AT=4.0022222
.meas tran peak_l0_b6 FIND V(peak_out_l0) AT=4.2061111
.meas tran peak_l1_b6 FIND V(peak_out_l1) AT=4.2061111
.meas tran thr_b6 FIND V(width_threshold) AT=4.0022222
.meas tran f_sym_b6 FIND V(f_sym) AT=4.1061111
.meas tran f_slope_b6 FIND V(f_slope) AT=4.1061111
.meas tran rise_b6 FIND V(rise_timer_out) AT=4.1061111
.meas tran fall_b6 FIND V(fall_timer_out) AT=4.1061111
.meas tran f_rr_ratio_b7 FIND V(f_rr_ratio) AT=4.6327778
.meas tran f_instab_l1_b7 FIND V(f_instab_l1) AT=4.6327778
.meas tran f_rr_asym_b7 FIND V(f_rr_asym) AT=4.6327778
.meas tran f_pwave_b7 FIND V(f_pwave) AT=4.6327778
.meas tran f_width_b7 FIND V(f_width) AT=4.7977778
.meas tran f_instab_l0_b7 FIND V(f_instab_l0) AT=4.6327778
.meas tran peak_l0_b7 FIND V(peak_out_l0) AT=4.7977778
.meas tran peak_l1_b7 FIND V(peak_out_l1) AT=4.7977778
.meas tran thr_b7 FIND V(width_threshold) AT=4.6327778
.meas tran f_sym_b7 FIND V(f_sym) AT=4.7005556
.meas tran f_slope_b7 FIND V(f_slope) AT=4.7005556
.meas tran rise_b7 FIND V(rise_timer_out) AT=4.7005556
.meas tran fall_b7 FIND V(fall_timer_out) AT=4.7005556
.meas tran f_rr_ratio_b8 FIND V(f_rr_ratio) AT=5.0077778
.meas tran f_instab_l1_b8 FIND V(f_instab_l1) AT=5.0077778
.meas tran f_rr_asym_b8 FIND V(f_rr_asym) AT=5.0077778
.meas tran f_pwave_b8 FIND V(f_pwave) AT=5.0077778
.meas tran f_width_b8 FIND V(f_width) AT=5.1422222
.meas tran f_instab_l0_b8 FIND V(f_instab_l0) AT=5.0077778
.meas tran peak_l0_b8 FIND V(peak_out_l0) AT=5.1422222
.meas tran peak_l1_b8 FIND V(peak_out_l1) AT=5.1422222
.meas tran thr_b8 FIND V(width_threshold) AT=5.0077778
.meas tran f_sym_b8 FIND V(f_sym) AT=5.1172222
.meas tran f_slope_b8 FIND V(f_slope) AT=5.1172222
.meas tran rise_b8 FIND V(rise_timer_out) AT=5.1172222
.meas tran fall_b8 FIND V(fall_timer_out) AT=5.1172222
.meas tran f_rr_ratio_b9 FIND V(f_rr_ratio) AT=5.8050000
.meas tran f_instab_l1_b9 FIND V(f_instab_l1) AT=5.8050000
.meas tran f_rr_asym_b9 FIND V(f_rr_asym) AT=5.8050000
.meas tran f_pwave_b9 FIND V(f_pwave) AT=5.8050000
.meas tran f_width_b9 FIND V(f_width) AT=5.8838889
.meas tran f_instab_l0_b9 FIND V(f_instab_l0) AT=5.8050000
.meas tran peak_l0_b9 FIND V(peak_out_l0) AT=5.8838889
.meas tran peak_l1_b9 FIND V(peak_out_l1) AT=5.8838889
.meas tran thr_b9 FIND V(width_threshold) AT=5.8050000
.meas tran f_sym_b9 FIND V(f_sym) AT=5.8755556
.meas tran f_slope_b9 FIND V(f_slope) AT=5.8755556
.meas tran rise_b9 FIND V(rise_timer_out) AT=5.8755556
.meas tran fall_b9 FIND V(fall_timer_out) AT=5.8755556

.end
