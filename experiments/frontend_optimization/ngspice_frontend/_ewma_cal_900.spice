.title ewma_cal_rr900
.lib "C:/Users/kadhi/OneDrive/Desktop/amux/verilogLearning/Leaky-Integrate-Fire---SNN-model-on-FPGA/experiments/frontend_optimization/ngspice_frontend/sky130_minimal.lib.spice" tt
.option scale=1.0u method=gear reltol=0.01 gmin=1e-15
.temp 27
Vdd vdd 0 0.9
Vss vss 0 0
Vbias vbias 0 0.300
Vrpk rpk 0 PWL(0.0000000 0.000000 0.4996000 0.000000 0.5000000 0.900000 0.5050000 0.900000 0.5054000 0.000000 1.3996000 0.000000 1.4000000 0.900000 1.4050000 0.900000 1.4054000 0.000000 2.2996000 0.000000 2.3000000 0.900000 2.3050000 0.900000 2.3054000 0.000000 3.1996000 0.000000 3.2000000 0.900000 3.2050000 0.900000 3.2054000 0.000000 4.0996000 0.000000 4.1000000 0.900000 4.1050000 0.900000 4.1054000 0.000000 4.9996000 0.000000 5.0000000 0.900000 5.0050000 0.900000 5.0054000 0.000000 5.8996000 0.000000 5.9000000 0.900000 5.9050000 0.900000 5.9054000 0.000000 6.7996000 0.000000 6.8000000 0.900000 6.8050000 0.900000 6.8054000 0.000000 7.6996000 0.000000 7.7000000 0.900000 7.7050000 0.900000 7.7054000 0.000000 8.5996000 0.000000 8.6000000 0.900000 8.6050000 0.900000 8.6054000 0.000000 9.4996000 0.000000 9.5000000 0.900000 9.5050000 0.900000 9.5054000 0.000000 10.3996000 0.000000 10.4000000 0.900000 10.4050000 0.900000 10.4054000 0.000000 11.2996000 0.000000 11.3000000 0.900000 11.3050000 0.900000 11.3054000 0.000000 12.1996000 0.000000 12.2000000 0.900000 12.2050000 0.900000 12.2054000 0.000000 13.0996000 0.000000 13.1000000 0.900000 13.1050000 0.900000 13.1054000 0.000000 13.9996000 0.000000 14.0000000 0.900000 14.0050000 0.900000 14.0054000 0.000000 14.8996000 0.000000 14.9000000 0.900000 14.9050000 0.900000 14.9054000 0.000000 15.7996000 0.000000 15.8000000 0.900000 15.8050000 0.900000 15.8054000 0.000000 16.6996000 0.000000 16.7000000 0.900000 16.7050000 0.900000 16.7054000 0.000000 17.5996000 0.000000 17.6000000 0.900000 17.6050000 0.900000 17.6054000 0.000000 18.4996000 0.000000 18.5000000 0.900000 18.5050000 0.900000 18.5054000 0.000000 19.3996000 0.000000 19.4000000 0.900000 19.4050000 0.900000 19.4054000 0.000000 20.2996000 0.000000 20.3000000 0.900000 20.3050000 0.900000 20.3054000 0.000000 21.1996000 0.000000 21.2000000 0.900000 21.2050000 0.900000 21.2054000 0.000000 22.0996000 0.000000 22.1000000 0.900000 22.1050000 0.900000 22.1054000 0.000000 22.9996000 0.000000 23.0000000 0.900000 23.0050000 0.900000 23.0054000 0.000000 23.8996000 0.000000 23.9000000 0.900000 23.9050000 0.900000 23.9054000 0.000000 24.7996000 0.000000 24.8000000 0.900000 24.8050000 0.900000 24.8054000 0.000000 25.6996000 0.000000 25.7000000 0.900000 25.7050000 0.900000 25.7054000 0.000000 26.5996000 0.000000 26.6000000 0.900000 26.6050000 0.900000 26.6054000 0.000000 27.1000000 0.000000)
Vc cap_t 0 PWL(0.0000000 0.000000 0.4946000 0.000000 0.4950000 0.900000 0.4970000 0.900000 0.4974000 0.000000 1.3946000 0.000000 1.3950000 0.900000 1.3970000 0.900000 1.3974000 0.000000 2.2946000 0.000000 2.2950000 0.900000 2.2970000 0.900000 2.2974000 0.000000 3.1946000 0.000000 3.1950000 0.900000 3.1970000 0.900000 3.1974000 0.000000 4.0946000 0.000000 4.0950000 0.900000 4.0970000 0.900000 4.0974000 0.000000 4.9946000 0.000000 4.9950000 0.900000 4.9970000 0.900000 4.9974000 0.000000 5.8946000 0.000000 5.8950000 0.900000 5.8970000 0.900000 5.8974000 0.000000 6.7946000 0.000000 6.7950000 0.900000 6.7970000 0.900000 6.7974000 0.000000 7.6946000 0.000000 7.6950000 0.900000 7.6970000 0.900000 7.6974000 0.000000 8.5946000 0.000000 8.5950000 0.900000 8.5970000 0.900000 8.5974000 0.000000 9.4946000 0.000000 9.4950000 0.900000 9.4970000 0.900000 9.4974000 0.000000 10.3946000 0.000000 10.3950000 0.900000 10.3970000 0.900000 10.3974000 0.000000 11.2946000 0.000000 11.2950000 0.900000 11.2970000 0.900000 11.2974000 0.000000 12.1946000 0.000000 12.1950000 0.900000 12.1970000 0.900000 12.1974000 0.000000 13.0946000 0.000000 13.0950000 0.900000 13.0970000 0.900000 13.0974000 0.000000 13.9946000 0.000000 13.9950000 0.900000 13.9970000 0.900000 13.9974000 0.000000 14.8946000 0.000000 14.8950000 0.900000 14.8970000 0.900000 14.8974000 0.000000 15.7946000 0.000000 15.7950000 0.900000 15.7970000 0.900000 15.7974000 0.000000 16.6946000 0.000000 16.6950000 0.900000 16.6970000 0.900000 16.6974000 0.000000 17.5946000 0.000000 17.5950000 0.900000 17.5970000 0.900000 17.5974000 0.000000 18.4946000 0.000000 18.4950000 0.900000 18.4970000 0.900000 18.4974000 0.000000 19.3946000 0.000000 19.3950000 0.900000 19.3970000 0.900000 19.3974000 0.000000 20.2946000 0.000000 20.2950000 0.900000 20.2970000 0.900000 20.2974000 0.000000 21.1946000 0.000000 21.1950000 0.900000 21.1970000 0.900000 21.1974000 0.000000 22.0946000 0.000000 22.0950000 0.900000 22.0970000 0.900000 22.0974000 0.000000 22.9946000 0.000000 22.9950000 0.900000 22.9970000 0.900000 22.9974000 0.000000 23.8946000 0.000000 23.8950000 0.900000 23.8970000 0.900000 23.8974000 0.000000 24.7946000 0.000000 24.7950000 0.900000 24.7970000 0.900000 24.7974000 0.000000 25.6946000 0.000000 25.6950000 0.900000 25.6970000 0.900000 25.6974000 0.000000 26.5946000 0.000000 26.5950000 0.900000 26.5970000 0.900000 26.5974000 0.000000 27.1000000 0.000000)
Vcp copy_t 0 PWL(0.0000000 0.000000 0.5096000 0.000000 0.5100000 0.900000 0.5120000 0.900000 0.5124000 0.000000 1.4096000 0.000000 1.4100000 0.900000 1.4120000 0.900000 1.4124000 0.000000 2.3096000 0.000000 2.3100000 0.900000 2.3120000 0.900000 2.3124000 0.000000 3.2096000 0.000000 3.2100000 0.900000 3.2120000 0.900000 3.2124000 0.000000 4.1096000 0.000000 4.1100000 0.900000 4.1120000 0.900000 4.1124000 0.000000 5.0096000 0.000000 5.0100000 0.900000 5.0120000 0.900000 5.0124000 0.000000 5.9096000 0.000000 5.9100000 0.900000 5.9120000 0.900000 5.9124000 0.000000 6.8096000 0.000000 6.8100000 0.900000 6.8120000 0.900000 6.8124000 0.000000 7.7096000 0.000000 7.7100000 0.900000 7.7120000 0.900000 7.7124000 0.000000 8.6096000 0.000000 8.6100000 0.900000 8.6120000 0.900000 8.6124000 0.000000 9.5096000 0.000000 9.5100000 0.900000 9.5120000 0.900000 9.5124000 0.000000 10.4096000 0.000000 10.4100000 0.900000 10.4120000 0.900000 10.4124000 0.000000 11.3096000 0.000000 11.3100000 0.900000 11.3120000 0.900000 11.3124000 0.000000 12.2096000 0.000000 12.2100000 0.900000 12.2120000 0.900000 12.2124000 0.000000 13.1096000 0.000000 13.1100000 0.900000 13.1120000 0.900000 13.1124000 0.000000 14.0096000 0.000000 14.0100000 0.900000 14.0120000 0.900000 14.0124000 0.000000 14.9096000 0.000000 14.9100000 0.900000 14.9120000 0.900000 14.9124000 0.000000 15.8096000 0.000000 15.8100000 0.900000 15.8120000 0.900000 15.8124000 0.000000 16.7096000 0.000000 16.7100000 0.900000 16.7120000 0.900000 16.7124000 0.000000 17.6096000 0.000000 17.6100000 0.900000 17.6120000 0.900000 17.6124000 0.000000 18.5096000 0.000000 18.5100000 0.900000 18.5120000 0.900000 18.5124000 0.000000 19.4096000 0.000000 19.4100000 0.900000 19.4120000 0.900000 19.4124000 0.000000 20.3096000 0.000000 20.3100000 0.900000 20.3120000 0.900000 20.3124000 0.000000 21.2096000 0.000000 21.2100000 0.900000 21.2120000 0.900000 21.2124000 0.000000 22.1096000 0.000000 22.1100000 0.900000 22.1120000 0.900000 22.1124000 0.000000 23.0096000 0.000000 23.0100000 0.900000 23.0120000 0.900000 23.0124000 0.000000 23.9096000 0.000000 23.9100000 0.900000 23.9120000 0.900000 23.9124000 0.000000 24.8096000 0.000000 24.8100000 0.900000 24.8120000 0.900000 24.8124000 0.000000 25.7096000 0.000000 25.7100000 0.900000 25.7120000 0.900000 25.7124000 0.000000 26.6096000 0.000000 26.6100000 0.900000 26.6120000 0.900000 26.6124000 0.000000 27.1000000 0.000000)
.include "C:/Users/kadhi/OneDrive/Desktop/amux/verilogLearning/Leaky-Integrate-Fire---SNN-model-on-FPGA/experiments/frontend_optimization/complete_frontend_v9b/inverter.spice"
.include "C:/Users/kadhi/OneDrive/Desktop/amux/verilogLearning/Leaky-Integrate-Fire---SNN-model-on-FPGA/experiments/frontend_optimization/complete_frontend_v9b/rr_timing.spice"
Xrr 0 cap_t rpk copy_t f1 f2 tout eout vdd vss vbias rr_timing
.ic V(xrr.ewma_node)=0.37
.tran 0.1m 27.1000
.meas tran e_2 FIND V(xrr.ewma_node) AT=2.2850000
.meas tran s_2 FIND V(xrr.esamp_node) AT=2.2960000
.meas tran sf_2 FIND V(tout) AT=2.2960000
.meas tran e_3 FIND V(xrr.ewma_node) AT=3.1850000
.meas tran s_3 FIND V(xrr.esamp_node) AT=3.1960000
.meas tran sf_3 FIND V(tout) AT=3.1960000
.meas tran e_4 FIND V(xrr.ewma_node) AT=4.0850000
.meas tran s_4 FIND V(xrr.esamp_node) AT=4.0960000
.meas tran sf_4 FIND V(tout) AT=4.0960000
.meas tran e_5 FIND V(xrr.ewma_node) AT=4.9850000
.meas tran s_5 FIND V(xrr.esamp_node) AT=4.9960000
.meas tran sf_5 FIND V(tout) AT=4.9960000
.meas tran e_6 FIND V(xrr.ewma_node) AT=5.8850000
.meas tran s_6 FIND V(xrr.esamp_node) AT=5.8960000
.meas tran sf_6 FIND V(tout) AT=5.8960000
.meas tran e_7 FIND V(xrr.ewma_node) AT=6.7850000
.meas tran s_7 FIND V(xrr.esamp_node) AT=6.7960000
.meas tran sf_7 FIND V(tout) AT=6.7960000
.meas tran e_8 FIND V(xrr.ewma_node) AT=7.6850000
.meas tran s_8 FIND V(xrr.esamp_node) AT=7.6960000
.meas tran sf_8 FIND V(tout) AT=7.6960000
.meas tran e_9 FIND V(xrr.ewma_node) AT=8.5850000
.meas tran s_9 FIND V(xrr.esamp_node) AT=8.5960000
.meas tran sf_9 FIND V(tout) AT=8.5960000
.meas tran e_10 FIND V(xrr.ewma_node) AT=9.4850000
.meas tran s_10 FIND V(xrr.esamp_node) AT=9.4960000
.meas tran sf_10 FIND V(tout) AT=9.4960000
.meas tran e_11 FIND V(xrr.ewma_node) AT=10.3850000
.meas tran s_11 FIND V(xrr.esamp_node) AT=10.3960000
.meas tran sf_11 FIND V(tout) AT=10.3960000
.meas tran e_12 FIND V(xrr.ewma_node) AT=11.2850000
.meas tran s_12 FIND V(xrr.esamp_node) AT=11.2960000
.meas tran sf_12 FIND V(tout) AT=11.2960000
.meas tran e_13 FIND V(xrr.ewma_node) AT=12.1850000
.meas tran s_13 FIND V(xrr.esamp_node) AT=12.1960000
.meas tran sf_13 FIND V(tout) AT=12.1960000
.meas tran e_14 FIND V(xrr.ewma_node) AT=13.0850000
.meas tran s_14 FIND V(xrr.esamp_node) AT=13.0960000
.meas tran sf_14 FIND V(tout) AT=13.0960000
.meas tran e_15 FIND V(xrr.ewma_node) AT=13.9850000
.meas tran s_15 FIND V(xrr.esamp_node) AT=13.9960000
.meas tran sf_15 FIND V(tout) AT=13.9960000
.meas tran e_16 FIND V(xrr.ewma_node) AT=14.8850000
.meas tran s_16 FIND V(xrr.esamp_node) AT=14.8960000
.meas tran sf_16 FIND V(tout) AT=14.8960000
.meas tran e_17 FIND V(xrr.ewma_node) AT=15.7850000
.meas tran s_17 FIND V(xrr.esamp_node) AT=15.7960000
.meas tran sf_17 FIND V(tout) AT=15.7960000
.meas tran e_18 FIND V(xrr.ewma_node) AT=16.6850000
.meas tran s_18 FIND V(xrr.esamp_node) AT=16.6960000
.meas tran sf_18 FIND V(tout) AT=16.6960000
.meas tran e_19 FIND V(xrr.ewma_node) AT=17.5850000
.meas tran s_19 FIND V(xrr.esamp_node) AT=17.5960000
.meas tran sf_19 FIND V(tout) AT=17.5960000
.meas tran e_20 FIND V(xrr.ewma_node) AT=18.4850000
.meas tran s_20 FIND V(xrr.esamp_node) AT=18.4960000
.meas tran sf_20 FIND V(tout) AT=18.4960000
.meas tran e_21 FIND V(xrr.ewma_node) AT=19.3850000
.meas tran s_21 FIND V(xrr.esamp_node) AT=19.3960000
.meas tran sf_21 FIND V(tout) AT=19.3960000
.meas tran e_22 FIND V(xrr.ewma_node) AT=20.2850000
.meas tran s_22 FIND V(xrr.esamp_node) AT=20.2960000
.meas tran sf_22 FIND V(tout) AT=20.2960000
.meas tran e_23 FIND V(xrr.ewma_node) AT=21.1850000
.meas tran s_23 FIND V(xrr.esamp_node) AT=21.1960000
.meas tran sf_23 FIND V(tout) AT=21.1960000
.meas tran e_24 FIND V(xrr.ewma_node) AT=22.0850000
.meas tran s_24 FIND V(xrr.esamp_node) AT=22.0960000
.meas tran sf_24 FIND V(tout) AT=22.0960000
.meas tran e_25 FIND V(xrr.ewma_node) AT=22.9850000
.meas tran s_25 FIND V(xrr.esamp_node) AT=22.9960000
.meas tran sf_25 FIND V(tout) AT=22.9960000
.meas tran e_26 FIND V(xrr.ewma_node) AT=23.8850000
.meas tran s_26 FIND V(xrr.esamp_node) AT=23.8960000
.meas tran sf_26 FIND V(tout) AT=23.8960000
.meas tran e_27 FIND V(xrr.ewma_node) AT=24.7850000
.meas tran s_27 FIND V(xrr.esamp_node) AT=24.7960000
.meas tran sf_27 FIND V(tout) AT=24.7960000
.meas tran e_28 FIND V(xrr.ewma_node) AT=25.6850000
.meas tran s_28 FIND V(xrr.esamp_node) AT=25.6960000
.meas tran sf_28 FIND V(tout) AT=25.6960000
.meas tran e_29 FIND V(xrr.ewma_node) AT=26.5850000
.meas tran s_29 FIND V(xrr.esamp_node) AT=26.5960000
.meas tran sf_29 FIND V(tout) AT=26.5960000

.end
