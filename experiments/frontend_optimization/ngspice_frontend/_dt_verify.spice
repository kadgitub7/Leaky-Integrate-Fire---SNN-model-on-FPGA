.title delay_timer_sf_verify
.lib "sky130_minimal.lib.spice" tt
.option scale=1.0u method=gear reltol=0.01 gmin=1e-15
.temp 27
Vdd vdd 0 0.9
Vss vss 0 0
Vbias vbias 0 0.300
* Single rpeak pulse at 50ms
Vrpk rpk 0 PWL(0 0 0.0496 0 0.0500 0.9 0.0550 0.9 0.0554 0 0.5 0)

.include "C:/Users/kadhi/OneDrive/Desktop/amux/verilogLearning/Leaky-Integrate-Fire---SNN-model-on-FPGA/experiments/frontend_optimization/complete_frontend_v9b/inverter.spice"
.include "C:/Users/kadhi/OneDrive/Desktop/amux/verilogLearning/Leaky-Integrate-Fire---SNN-model-on-FPGA/experiments/frontend_optimization/complete_frontend_v9b/delay_timer.spice"

* delay_timer: rpeak_pulse trig_s14 trig_s69 trig_wid trig_bi_copy trig_rr_copy
*              trig_rpk_delayed sf_out vdd vss vbias_delay
*              vth_14_fast vth_69 vth_83 vth_300 vth_10 vth_rpk_del
* Connect all threshold pins to low values so comparators don't interfere
Xdt rpk ts14 ts69 twid tbi trr trpk sf_out
+ vdd vss vbias 0.200 0.200 0.200 0.200 0.200 0.200 delay_timer

.tran 0.01m 0.5

.meas tran sf_0ms FIND V(sf_out) AT=0.0560000
.meas tran sf_10ms FIND V(sf_out) AT=0.0660000
.meas tran sf_14ms FIND V(sf_out) AT=0.0700000
.meas tran sf_25ms FIND V(sf_out) AT=0.0810000
.meas tran sf_28ms FIND V(sf_out) AT=0.0840000
.meas tran sf_50ms FIND V(sf_out) AT=0.1060000
.meas tran sf_69ms FIND V(sf_out) AT=0.1250000
.meas tran sf_83ms FIND V(sf_out) AT=0.1390000
.meas tran sf_100ms FIND V(sf_out) AT=0.1560000
.meas tran sf_150ms FIND V(sf_out) AT=0.2060000
.meas tran sf_200ms FIND V(sf_out) AT=0.2560000
.meas tran sf_250ms FIND V(sf_out) AT=0.3060000
.meas tran sf_300ms FIND V(sf_out) AT=0.3560000

.end
