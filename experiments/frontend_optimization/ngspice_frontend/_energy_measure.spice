* Energy Measurement - Final Analog Frontend
.title energy_measurement

.lib "sky130_minimal.lib.spice" tt
.option scale=1.0u
.option method=gear
.option gmin=1e-15
.option abstol=1e-15
.option reltol=0.005
.temp 27

.include "ota_5t_subthreshold.spice"
.include "inverter.spice"
.include "resistor_div.spice"
.include "rr_timing.spice"
.include "beat_instability.spice"
.include "pwave_energy.spice"
.include "qrs_width.spice"
.include "slope_ratio.spice"
.include "qrs_symmetry.spice"

Vdd vdd 0 0.9
Vss vss 0 0
Vbias vbias 0 0.35
Vref vref 0 0.45

Vecg ecg_in 0 PWL(0.0000000 0.250000 0.2500000 0.010000 0.2527778 0.010000 0.2555556 0.010000 0.2583333 0.010000 0.2611111 0.010000 0.2638889 0.010000 0.2666667 0.010000 0.2694444 0.010000 0.2722222 0.010000 0.2750000 0.010000 0.2777778 0.010000 0.2805556 0.010000 0.2833333 0.010000 0.2861111 0.010000 0.2888889 0.010000 0.2916667 0.010000 0.2944444 0.010000 0.2972222 0.010000 0.3000000 0.010000 0.3027778 0.010000 0.3055556 0.010000 0.3083333 0.010000 0.3111111 0.010000 0.3138889 0.010000 0.3166667 0.010000 0.3194444 0.010000 0.3222222 0.010000 0.3250000 0.010000 0.3277778 0.010000 0.3305556 0.010000 0.3333333 0.010000 0.3361111 0.010000 0.3388889 0.010000 0.3416667 0.010000 0.3444444 0.010000 0.3472222 0.010000 0.3500000 0.010000 0.3527778 0.010000 0.3555556 0.010000 0.3583333 0.010000 0.3611111 0.010000 0.3638889 0.010000 0.3666667 0.010000 0.3694444 0.010000 0.3722222 0.010000 0.3750000 0.010000 0.3777778 0.010000 0.3805556 0.010000 0.3833333 0.010000 0.3861111 0.010000 0.3888889 0.010000 0.3916667 0.010000 0.3944444 0.010000 0.3972222 0.010000 0.4000000 0.010000 0.4027778 0.010000 0.4055556 0.010000 0.4083333 0.010000 0.4111111 0.010000 0.4138889 0.010000 0.4166667 0.010000 0.4194444 0.010000 0.4222222 0.010000 0.4250000 0.010000 0.4277778 0.010000 0.4305556 0.010000 0.4333333 0.010000 0.4361111 0.010000 0.4388889 0.010000 0.4416667 0.010000 0.4444444 0.010000 0.4472222 0.010000 0.4500000 0.010000 0.4527778 0.010000 0.4555556 0.010000 0.4583333 0.010000 0.4611111 0.010000 0.4638889 0.010000 0.4666667 0.010000 0.4694444 0.010000 0.4722222 0.010000 0.4750000 0.010000 0.4777778 0.010000 0.4805556 0.010000 0.4833333 0.049419 0.4861111 0.161047 0.4888889 0.300581 0.4916667 0.436628 0.4944444 0.551744 0.4972222 0.621512 0.5000000 0.656395 0.5027778 0.637209 0.5055556 0.563953 0.5083333 0.433140 0.5111111 0.244767 0.5138889 0.049419 0.5166667 0.010000 0.5194444 0.010000 0.5222222 0.010000 0.5250000 0.010000 0.5277778 0.010000 0.5305556 0.010000 0.5333333 0.010000 0.5361111 0.010000 0.5388889 0.010000 0.5416667 0.010000 0.5444444 0.010000 0.5472222 0.010000 0.5500000 0.010000 0.5527778 0.010000 0.5555556 0.010000 0.5583333 0.010000 0.5611111 0.010000 0.5638889 0.010000 0.5666667 0.010000 0.5694444 0.010000 0.5722222 0.010000 0.5750000 0.010000 0.5777778 0.010000 0.5805556 0.010000 0.5833333 0.010000 0.5861111 0.010000 0.5888889 0.010000 0.5916667 0.010000 0.5944444 0.010000 0.5972222 0.010000 0.6000000 0.010000 0.6027778 0.010000 0.6055556 0.010000 0.6083333 0.010000 0.6111111 0.010000 0.6138889 0.010000 0.6166667 0.010000 0.6194444 0.010000 0.6222222 0.010000 0.6250000 0.010000 0.6277778 0.010000 0.6305556 0.010000 0.6333333 0.010000 0.6361111 0.010000 0.6388889 0.010000 0.6416667 0.010000 0.6444444 0.010000 0.6472222 0.010000 0.6500000 0.010000 0.6527778 0.010000 0.6555556 0.010000 0.6583333 0.010000 0.6611111 0.010000 0.6638889 0.010000 0.6666667 0.010000 0.6694444 0.010000 0.6722222 0.010000 0.6750000 0.010000 0.6777778 0.010000 0.6805556 0.010000 0.6833333 0.010000 0.6861111 0.010000 0.6888889 0.010000 0.6916667 0.010000 0.6944444 0.010000 0.6972222 0.010000 0.7000000 0.010000 0.7027778 0.010000 0.7055556 0.010000 0.7083333 0.010000 0.7111111 0.010000 0.7138889 0.010000 0.7166667 0.010000 0.7194444 0.010000 0.7222222 0.010000 0.7250000 0.010000 0.7277778 0.010000 0.7305556 0.010000 0.7333333 0.010000 0.7361111 0.010000 0.7388889 0.014535 0.7416667 0.026744 0.7444444 0.031977 0.7472222 0.038953 0.7500000 0.051163 0.7527778 0.058140 0.7555556 0.065116 0.7583333 0.072093 0.7611111 0.080814 0.7638889 0.086047 0.7666667 0.086047 0.7694444 0.093023 0.7722222 0.094767 0.7750000 0.103488 0.7777778 0.101744 0.7805556 0.105233 0.7833333 0.106977 0.7861111 0.112209 0.7888889 0.112209 0.7916667 0.120930 0.7944444 0.110465 0.7972222 0.106977 1.1472222 0.010000 1.1500000 0.010000 1.1527778 0.010000 1.1555556 0.010000 1.1583333 0.010000 1.1611111 0.010000 1.1638889 0.010000 1.1666667 0.010000 1.1694444 0.010000 1.1722222 0.010000 1.1750000 0.010000 1.1777778 0.010000 1.1805556 0.010000 1.1833333 0.010000 1.1861111 0.010000 1.1888889 0.010000 1.1916667 0.010000 1.1944444 0.010000 1.1972222 0.010000 1.2000000 0.010000 1.2027778 0.010000 1.2055556 0.010000 1.2083333 0.010000 1.2111111 0.010000 1.2138889 0.010000 1.2166667 0.010000 1.2194444 0.010000 1.2222222 0.011047 1.2250000 0.030233 1.2277778 0.038953 1.2305556 0.044186 1.2333333 0.044186 1.2361111 0.040698 1.2388889 0.033721 1.2416667 0.028488 1.2444444 0.018023 1.2472222 0.025000 1.2500000 0.026744 1.2527778 0.025000 1.2555556 0.023256 1.2583333 0.010000 1.2611111 0.010000 1.2638889 0.010000 1.2666667 0.010000 1.2694444 0.010000 1.2722222 0.010000 1.2750000 0.010000 1.2777778 0.010000 1.2805556 0.010000 1.2833333 0.010000 1.2861111 0.010000 1.2888889 0.010000 1.2916667 0.010000 1.2944444 0.010000 1.2972222 0.010000 1.3000000 0.010000 1.3027778 0.010000 1.3055556 0.010000 1.3083333 0.010000 1.3111111 0.010000 1.3138889 0.010000 1.3166667 0.010000 1.3194444 0.010000 1.3222222 0.010000 1.3250000 0.010000 1.3277778 0.010000 1.3305556 0.010000 1.3333333 0.010000 1.3361111 0.010000 1.3388889 0.010000 1.3416667 0.010000 1.3444444 0.010000 1.3472222 0.010000 1.3500000 0.010000 1.3527778 0.010000 1.3555556 0.010000 1.3583333 0.010000 1.3611111 0.010000 1.3638889 0.010000 1.3666667 0.010000 1.3694444 0.010000 1.3722222 0.010000 1.3750000 0.010000 1.3777778 0.010000 1.3805556 0.093023 1.3833333 0.199419 1.3861111 0.328488 1.3888889 0.459302 1.3916667 0.570930 1.3944444 0.644186 1.3972222 0.670349 1.4000000 0.668605 1.4027778 0.628488 1.4055556 0.544767 1.4083333 0.406977 1.4111111 0.234302 1.4138889 0.051163 1.4166667 0.010000 1.4194444 0.010000 1.4222222 0.010000 1.4250000 0.010000 1.4277778 0.010000 1.4305556 0.010000 1.4333333 0.010000 1.4361111 0.010000 1.4388889 0.010000 1.4416667 0.010000 1.4444444 0.010000 1.4472222 0.010000 1.4500000 0.010000 1.4527778 0.010000 1.4555556 0.010000 1.4583333 0.010000 1.4611111 0.010000 1.4638889 0.010000 1.4666667 0.010000 1.4694444 0.010000 1.4722222 0.010000 1.4750000 0.010000 1.4777778 0.010000 1.4805556 0.010000 1.4833333 0.010000 1.4861111 0.010000 1.4888889 0.010000 1.4916667 0.010000 1.4944444 0.010000 1.4972222 0.010000 1.5000000 0.010000 1.5027778 0.010000 1.5055556 0.010000 1.5083333 0.010000 1.5111111 0.010000 1.5138889 0.010000 1.5166667 0.010000 1.5194444 0.010000 1.5222222 0.010000 1.5250000 0.010000 1.5277778 0.010000 1.5305556 0.010000 1.5333333 0.010000 1.5361111 0.010000 1.5388889 0.010000 1.5416667 0.010000 1.5444444 0.010000 1.5472222 0.010000 1.5500000 0.010000 1.5527778 0.010000 1.5555556 0.010000 1.5583333 0.010000 1.5611111 0.010000 1.5638889 0.010000 1.5666667 0.010000 1.5694444 0.010000 1.5722222 0.010000 1.5750000 0.010000 1.5777778 0.010000 1.5805556 0.010000 1.5833333 0.010000 1.5861111 0.010000 1.5888889 0.010000 1.5916667 0.010000 1.5944444 0.010000 1.5972222 0.010000 1.6000000 0.010000 1.6027778 0.010000 1.6055556 0.010000 1.6083333 0.010000 1.6111111 0.010000 1.6138889 0.010000 1.6166667 0.010000 1.6194444 0.010000 1.6222222 0.010000 1.6250000 0.010000 1.6277778 0.010000 1.6305556 0.010000 1.6333333 0.010000 1.6361111 0.010000 1.6388889 0.010000 1.6416667 0.010000 1.6444444 0.010000 1.6472222 0.010000 1.6500000 0.010000 1.6527778 0.016279 1.6555556 0.028488 1.6583333 0.040698 1.6611111 0.044186 1.6638889 0.049419 1.6666667 0.054651 1.6694444 0.061628 1.6722222 0.063372 1.6750000 0.070349 1.6777778 0.073837 1.6805556 0.082558 1.6833333 0.089535 1.6861111 0.098256 1.6888889 0.103488 1.6916667 0.110465 1.6944444 0.117442 1.6972222 0.126163 1.7000000 0.120930 1.7027778 0.122674 1.7055556 0.120930 1.7083333 0.119186 1.7111111 0.115698 1.7138889 0.110465 1.7166667 0.103488 1.7194444 0.096512 1.7222222 0.089535 1.7250000 0.086047 1.7277778 0.073837 1.7305556 0.063372 1.7333333 0.049419 1.7361111 0.030233 1.7388889 0.026744 1.7416667 0.010000 1.7444444 0.010000 1.7472222 0.010000 1.7500000 0.010000 1.7527778 0.010000 1.7555556 0.010000 1.7583333 0.010000 1.7611111 0.010000 1.7638889 0.010000 1.7666667 0.010000 1.7694444 0.010000 1.7722222 0.010000 1.7750000 0.010000 1.7777778 0.010000 1.7805556 0.010000 1.7833333 0.010000 1.7861111 0.010000 1.7888889 0.010000 1.7916667 0.010000 1.7944444 0.010000 1.7972222 0.010000 1.8000000 0.010000 1.8027778 0.010000 1.8055556 0.010000 1.8083333 0.010000 1.8111111 0.010000 1.8138889 0.010000 1.8166667 0.010000 1.8194444 0.010000 1.8222222 0.010000 1.8250000 0.010000 1.8277778 0.010000 1.8305556 0.010000 1.8333333 0.010000 1.8361111 0.010000 1.8388889 0.010000 1.8416667 0.010000 1.8444444 0.010000 1.8472222 0.010000 1.8500000 0.010000 1.8527778 0.010000 1.8555556 0.010000 1.8583333 0.010000 1.8611111 0.010000 1.8638889 0.010000 1.8666667 0.010000 1.8694444 0.010000 1.8722222 0.010000 1.8750000 0.010000 1.8777778 0.010000 1.8805556 0.010000 1.8833333 0.010000 1.8861111 0.010000 1.8888889 0.010000 1.8916667 0.056395 1.8944444 0.108721 1.8972222 0.152326 1.9000000 0.202907 1.9027778 0.251744 1.9055556 0.311047 1.9083333 0.375581 1.9111111 0.443605 1.9138889 0.522093 1.9166667 0.598837 1.9194444 0.673837 1.9222222 0.736628 1.9250000 0.797674 1.9277778 0.848256 1.9305556 0.850000 1.9333333 0.850000 1.9361111 0.850000 1.9388889 0.850000 1.9416667 0.850000 1.9444444 0.850000 1.9472222 0.850000 1.9500000 0.850000 1.9527778 0.850000 1.9555556 0.834302 1.9583333 0.818605 1.9611111 0.808140 1.9638889 0.809884 1.9666667 0.811628 1.9694444 0.797674 1.9722222 0.783721 1.9750000 0.752326 1.9777778 0.703488 1.9805556 0.651163 1.9833333 0.593605 1.9861111 0.522093 1.9888889 0.434884 1.9916667 0.312791 1.9944444 0.176744 1.9972222 0.040698 2.0000000 0.010000 2.0027778 0.010000 2.0055556 0.010000 2.0083333 0.010000 2.0111111 0.010000 2.0138889 0.010000 2.0166667 0.010000 2.0194444 0.010000 2.0222222 0.010000 2.0250000 0.010000 2.0277778 0.010000 2.0305556 0.010000 2.0333333 0.010000 2.0361111 0.010000 2.0388889 0.010000 2.0416667 0.010000 2.0444444 0.010000 2.0472222 0.010000 2.0500000 0.010000 2.0527778 0.010000 2.0555556 0.010000 2.0583333 0.010000 2.0611111 0.010000 2.0638889 0.010000 2.0666667 0.010000 2.0694444 0.010000 2.0722222 0.010000 2.0750000 0.010000 2.0777778 0.010000 2.0805556 0.010000 2.0833333 0.010000 2.0861111 0.010000 2.0888889 0.010000 2.0916667 0.010000 2.0944444 0.010000 2.0972222 0.010000 2.1000000 0.010000 2.1027778 0.010000 2.1055556 0.010000 2.1083333 0.010000 2.1111111 0.010000 2.1138889 0.010000 2.1166667 0.010000 2.1194444 0.010000 2.1222222 0.010000 2.1250000 0.010000 2.1277778 0.010000 2.1305556 0.010000 2.1333333 0.010000 2.1361111 0.010000 2.1388889 0.010000 2.1416667 0.010000 2.1444444 0.010000 2.1472222 0.010000 2.1500000 0.010000 2.1527778 0.010000 2.1555556 0.010000 2.1583333 0.010000 2.1611111 0.010000 2.1638889 0.010000 2.1666667 0.010000 2.1694444 0.010000 2.1722222 0.010000 2.1750000 0.010000 2.1777778 0.010000 2.1805556 0.010000 2.1833333 0.010000 2.1861111 0.010000 2.1888889 0.010000 2.1916667 0.010000 2.1944444 0.010000 2.1972222 0.010000 2.2000000 0.010000 2.2027778 0.010000 2.2055556 0.010000 2.2083333 0.010000 2.2111111 0.010000 2.2138889 0.010000 2.2166667 0.010000 2.2194444 0.010000 2.2222222 0.010000 2.2250000 0.010000 2.2277778 0.010000 2.2305556 0.010000 2.2333333 0.010000 2.9861111 0.010000 2.9888889 0.010000 2.9916667 0.010000 2.9944444 0.010000 2.9972222 0.010000 3.0000000 0.010000 3.0027778 0.010000 3.0055556 0.010000 3.0083333 0.010000 3.0111111 0.010000 3.0138889 0.010000 3.0166667 0.010000 3.0194444 0.010000 3.0222222 0.010000 3.0250000 0.010000 3.0277778 0.010000 3.0305556 0.010000 3.0333333 0.010000 3.0361111 0.010000 3.0388889 0.010000 3.0416667 0.010000 3.0444444 0.010000 3.0472222 0.010000 3.0500000 0.010000 3.0527778 0.010000 3.0555556 0.010000 3.0583333 0.010000 3.0611111 0.010000 3.0638889 0.010000 3.0666667 0.010000 3.0694444 0.010000 3.0722222 0.010000 3.0750000 0.010000 3.0777778 0.010000 3.0805556 0.010000 3.0833333 0.021512 3.0861111 0.038953 3.0888889 0.056395 3.0916667 0.068605 3.0944444 0.068605 3.0972222 0.068605 3.1000000 0.059884 3.1027778 0.059884 3.1055556 0.047674 3.1083333 0.049419 3.1111111 0.049419 3.1138889 0.049419 3.1166667 0.045930 3.1194444 0.038953 3.1222222 0.025000 3.1250000 0.011047 3.1277778 0.010000 3.1305556 0.010000 3.1333333 0.010000 3.1361111 0.010000 3.1388889 0.010000 3.1416667 0.010000 3.1444444 0.010000 3.1472222 0.010000 3.1500000 0.010000 3.1527778 0.010000 3.1555556 0.010000 3.1583333 0.010000 3.1611111 0.010000 3.1638889 0.010000 3.1666667 0.010000 3.1694444 0.010000 3.1722222 0.010000 3.1750000 0.010000 3.1777778 0.010000 3.1805556 0.010000 3.1833333 0.010000 3.1861111 0.010000 3.1888889 0.010000 3.1916667 0.010000 3.1944444 0.010000 3.1972222 0.010000 3.2000000 0.010000 3.2027778 0.010000 3.2055556 0.010000 3.2083333 0.010000 3.2111111 0.010000 3.2138889 0.010000 3.2166667 0.066860 3.2194444 0.159302 3.2222222 0.274419 3.2250000 0.401744 3.2277778 0.527326 3.2305556 0.625000 3.2333333 0.694767 3.2361111 0.719186 3.2388889 0.710465 3.2416667 0.665116 3.2444444 0.576163 3.2472222 0.440116 3.2500000 0.265698 3.2527778 0.089535 3.2555556 0.010000 3.2583333 0.010000 3.2611111 0.010000 3.2638889 0.010000 3.2666667 0.010000 3.2694444 0.016279 3.2722222 0.018023 3.2750000 0.010000 3.2777778 0.010000 3.2805556 0.010000 3.2833333 0.010000 3.2861111 0.010000 3.2888889 0.010000 3.2916667 0.010000 3.2944444 0.010000 3.2972222 0.010000 3.3000000 0.010000 3.3027778 0.010000 3.3055556 0.010000 3.3083333 0.010000 3.3111111 0.010000 3.3138889 0.010000 3.3166667 0.010000 3.3194444 0.010000 3.3222222 0.010000 3.3250000 0.010000 3.3277778 0.010000 3.3305556 0.010000 3.3333333 0.010000 3.3361111 0.010000 3.3388889 0.010000 3.3416667 0.010000 3.3444444 0.010000 3.3472222 0.010000 3.3500000 0.010000 3.3527778 0.010000 3.3555556 0.010000 3.3583333 0.010000 3.3611111 0.010000 3.3638889 0.010000 3.3666667 0.010000 3.3694444 0.010000 3.3722222 0.010000 3.3750000 0.010000 3.3777778 0.010000 3.3805556 0.010000 3.3833333 0.010000 3.3861111 0.010000 3.3888889 0.010000 3.3916667 0.010000 3.3944444 0.010000 3.3972222 0.010000 3.4000000 0.010000 3.4027778 0.010000 3.4055556 0.010000 3.4083333 0.010000 3.4111111 0.010000 3.4138889 0.010000 3.4166667 0.010000 3.4194444 0.010000 3.4222222 0.010000 3.4250000 0.010000 3.4277778 0.010000 3.4305556 0.010000 3.4333333 0.010000 3.4361111 0.010000 3.4388889 0.010000 3.4416667 0.010000 3.4444444 0.010000 3.4472222 0.010000 3.4500000 0.010000 3.4527778 0.010000 3.4555556 0.010000 3.4583333 0.010000 3.4611111 0.010000 3.4638889 0.010000 3.4666667 0.010000 3.4694444 0.010000 3.4722222 0.010000 3.4750000 0.010000 3.4777778 0.010000 3.4805556 0.010000 3.4833333 0.010000 3.4861111 0.016279 3.4888889 0.023256 3.4916667 0.033721 3.4944444 0.038953 3.4972222 0.042442 3.5000000 0.049419 3.5027778 0.051163 3.5055556 0.052907 3.5083333 0.056395 3.5111111 0.059884 3.5138889 0.063372 3.5166667 0.070349 3.5194444 0.082558 3.5222222 0.084302 3.5250000 0.087791 3.5277778 0.098256 3.5305556 0.101744 3.5333333 0.106977 3.9305556 0.010000 3.9333333 0.010000 3.9361111 0.010000 3.9388889 0.010000 3.9416667 0.010000 3.9444444 0.010000 3.9472222 0.010000 3.9500000 0.010000 3.9527778 0.010000 3.9555556 0.010000 3.9583333 0.010000 3.9611111 0.010000 3.9638889 0.010000 3.9666667 0.010000 3.9694444 0.010000 3.9722222 0.010000 3.9750000 0.010000 3.9777778 0.010000 3.9805556 0.010000 3.9833333 0.010000 3.9861111 0.010000 3.9888889 0.010000 3.9916667 0.010000 3.9944444 0.010000 3.9972222 0.010000 4.0000000 0.010000 4.0027778 0.010000 4.0055556 0.010000 4.0083333 0.010000 4.0111111 0.010000 4.0138889 0.010000 4.0166667 0.021512 4.0194444 0.044186 4.0222222 0.054651 4.0250000 0.068605 4.0277778 0.077326 4.0305556 0.070349 4.0333333 0.063372 4.0361111 0.052907 4.0388889 0.051163 4.0416667 0.052907 4.0444444 0.045930 4.0472222 0.049419 4.0500000 0.044186 4.0527778 0.042442 4.0555556 0.038953 4.0583333 0.023256 4.0611111 0.010000 4.0638889 0.010000 4.0666667 0.010000 4.0694444 0.010000 4.0722222 0.010000 4.0750000 0.010000 4.0777778 0.010000 4.0805556 0.010000 4.0833333 0.010000 4.0861111 0.010000 4.0888889 0.010000 4.0916667 0.010000 4.0944444 0.010000 4.0972222 0.010000 4.1000000 0.010000 4.1027778 0.010000 4.1055556 0.010000 4.1083333 0.010000 4.1111111 0.010000 4.1138889 0.010000 4.1166667 0.010000 4.1194444 0.010000 4.1222222 0.010000 4.1250000 0.010000 4.1277778 0.010000 4.1305556 0.010000 4.1333333 0.010000 4.1361111 0.010000 4.1388889 0.010000 4.1416667 0.010000 4.1444444 0.010000 4.1472222 0.010000 4.1500000 0.010000 4.1527778 0.010000 4.1555556 0.010000 4.1583333 0.010000 4.1611111 0.010000 4.1638889 0.075581 4.1666667 0.185465 4.1694444 0.304070 4.1722222 0.436628 4.1750000 0.556977 4.1777778 0.644186 4.1805556 0.696512 4.1833333 0.700000 4.1861111 0.679070 4.1888889 0.611047 4.1916667 0.497674 4.1944444 0.337209 4.1972222 0.150581 4.2000000 0.010000 4.2027778 0.010000 4.2055556 0.010000 4.2083333 0.010000 4.2111111 0.010000 4.2138889 0.010000 4.2166667 0.018023 4.2194444 0.016279 4.2222222 0.010000 4.2250000 0.010000 4.2277778 0.010000 4.2305556 0.010000 4.2333333 0.010000 4.2361111 0.010000 4.2388889 0.010000 4.2416667 0.010000 4.2444444 0.010000 4.2472222 0.010000 4.2500000 0.010000 4.2527778 0.010000 4.2555556 0.010000 4.2583333 0.010000 4.2611111 0.010000 4.2638889 0.010000 4.2666667 0.010000 4.2694444 0.010000 4.2722222 0.010000 4.2750000 0.010000 4.2777778 0.010000 4.2805556 0.010000 4.2833333 0.010000 4.2861111 0.010000 4.2888889 0.010000 4.2916667 0.010000 4.2944444 0.010000 4.2972222 0.010000 4.3000000 0.010000 4.3027778 0.010000 4.3055556 0.010000 4.3083333 0.010000 4.3111111 0.010000 4.3138889 0.010000 4.3166667 0.010000 4.3194444 0.010000 4.3222222 0.010000 4.3250000 0.010000 4.3277778 0.010000 4.3305556 0.010000 4.3333333 0.010000 4.3361111 0.010000 4.3388889 0.010000 4.3416667 0.010000 4.3444444 0.010000 4.3472222 0.010000 4.3500000 0.010000 4.3527778 0.010000 4.3555556 0.010000 4.3583333 0.010000 4.3611111 0.010000 4.3638889 0.010000 4.3666667 0.010000 4.3694444 0.010000 4.3722222 0.010000 4.3750000 0.010000 4.3777778 0.010000 4.3805556 0.010000 4.3833333 0.010000 4.3861111 0.010000 4.3888889 0.010000 4.3916667 0.010000 4.3944444 0.010000 4.3972222 0.010000 4.4000000 0.010000 4.4027778 0.010000 4.4055556 0.010000 4.4083333 0.010000 4.4111111 0.010000 4.4138889 0.010000 4.4166667 0.010000 4.4194444 0.016279 4.4222222 0.018023 4.4250000 0.033721 4.4277778 0.042442 4.4305556 0.052907 4.4333333 0.054651 4.4361111 0.061628 4.4388889 0.063372 4.4416667 0.063372 4.4444444 0.070349 4.4472222 0.075581 4.4500000 0.084302 4.4527778 0.094767 4.4555556 0.106977 4.4583333 0.117442 4.4611111 0.124419 4.4638889 0.127907 4.4666667 0.134884 4.4694444 0.129651 4.4722222 0.133140 4.4750000 0.138372 4.4777778 0.134884 4.6805556 0.250000)
Vecg2 ecg_in_l1 0 PWL(0.0000000 0.250000 0.2500000 0.082558 0.2527778 0.084302 0.2555556 0.091279 0.2583333 0.086047 0.2611111 0.086047 0.2638889 0.077326 0.2666667 0.080814 0.2694444 0.080814 0.2722222 0.075581 0.2750000 0.073837 0.2777778 0.084302 0.2805556 0.077326 0.2833333 0.086047 0.2861111 0.093023 0.2888889 0.094767 0.2916667 0.093023 0.2944444 0.093023 0.2972222 0.093023 0.3000000 0.089535 0.3027778 0.086047 0.3055556 0.089535 0.3083333 0.091279 0.3111111 0.093023 0.3138889 0.100000 0.3166667 0.098256 0.3194444 0.105233 0.3222222 0.108721 0.3250000 0.117442 0.3277778 0.110465 0.3305556 0.113953 0.3333333 0.113953 0.3361111 0.113953 0.3388889 0.108721 0.3416667 0.101744 0.3444444 0.098256 0.3472222 0.087791 0.3500000 0.089535 0.3527778 0.084302 0.3555556 0.086047 0.3583333 0.080814 0.3611111 0.084302 0.3638889 0.073837 0.3666667 0.070349 0.3694444 0.066860 0.3722222 0.059884 0.3750000 0.056395 0.3777778 0.056395 0.3805556 0.063372 0.3833333 0.070349 0.3861111 0.070349 0.3888889 0.075581 0.3916667 0.079070 0.3944444 0.079070 0.3972222 0.070349 0.4000000 0.070349 0.4027778 0.070349 0.4055556 0.059884 0.4083333 0.059884 0.4111111 0.061628 0.4138889 0.065116 0.4166667 0.068605 0.4194444 0.073837 0.4222222 0.072093 0.4250000 0.070349 0.4277778 0.073837 0.4305556 0.066860 0.4333333 0.065116 0.4361111 0.066860 0.4388889 0.056395 0.4416667 0.056395 0.4444444 0.059884 0.4472222 0.066860 0.4500000 0.068605 0.4527778 0.070349 0.4555556 0.077326 0.4583333 0.077326 0.4611111 0.079070 0.4638889 0.075581 0.4666667 0.077326 0.4694444 0.084302 0.4722222 0.089535 0.4750000 0.105233 0.4777778 0.127907 0.4805556 0.141860 0.4833333 0.143605 0.4861111 0.126163 0.4888889 0.087791 0.4916667 0.021512 0.4944444 0.010000 0.4972222 0.010000 0.5000000 0.010000 0.5027778 0.010000 0.5055556 0.010000 0.5083333 0.010000 0.5111111 0.010000 0.5138889 0.010000 0.5166667 0.010000 0.5194444 0.010000 0.5222222 0.010000 0.5250000 0.010000 0.5277778 0.010000 0.5305556 0.010000 0.5333333 0.010000 0.5361111 0.011047 0.5388889 0.025000 0.5416667 0.042442 0.5444444 0.054651 0.5472222 0.061628 0.5500000 0.072093 0.5527778 0.072093 0.5555556 0.077326 0.5583333 0.080814 0.5611111 0.080814 0.5638889 0.086047 0.5666667 0.080814 0.5694444 0.087791 0.5722222 0.080814 0.5750000 0.080814 0.5777778 0.082558 0.5805556 0.091279 0.5833333 0.093023 0.5861111 0.094767 0.5888889 0.094767 0.5916667 0.098256 0.5944444 0.100000 0.5972222 0.101744 0.6000000 0.093023 0.6027778 0.087791 0.6055556 0.086047 0.6083333 0.080814 0.6111111 0.084302 0.6138889 0.091279 0.6166667 0.093023 0.6194444 0.093023 0.6222222 0.094767 0.6250000 0.096512 0.6277778 0.098256 0.6305556 0.100000 0.6333333 0.093023 0.6361111 0.087791 0.6388889 0.080814 0.6416667 0.082558 0.6444444 0.082558 0.6472222 0.089535 0.6500000 0.089535 0.6527778 0.091279 0.6555556 0.096512 0.6583333 0.093023 0.6611111 0.096512 0.6638889 0.091279 0.6666667 0.091279 0.6694444 0.089535 0.6722222 0.086047 0.6750000 0.091279 0.6777778 0.091279 0.6805556 0.096512 0.6833333 0.098256 0.6861111 0.105233 0.6888889 0.105233 0.6916667 0.106977 0.6944444 0.106977 0.6972222 0.105233 0.7000000 0.096512 0.7027778 0.105233 0.7055556 0.093023 0.7083333 0.091279 0.7111111 0.098256 0.7138889 0.098256 0.7166667 0.101744 0.7194444 0.106977 0.7222222 0.106977 0.7250000 0.105233 0.7277778 0.105233 0.7305556 0.106977 0.7333333 0.101744 0.7361111 0.105233 0.7388889 0.098256 0.7416667 0.103488 0.7444444 0.100000 0.7472222 0.101744 0.7500000 0.106977 0.7527778 0.110465 0.7555556 0.106977 0.7583333 0.112209 0.7611111 0.106977 0.7638889 0.103488 0.7666667 0.096512 0.7694444 0.096512 0.7722222 0.091279 0.7750000 0.093023 0.7777778 0.093023 0.7805556 0.091279 0.7833333 0.096512 0.7861111 0.094767 0.7888889 0.096512 0.7916667 0.106977 0.7944444 0.100000 0.7972222 0.093023 1.1472222 0.068605 1.1500000 0.072093 1.1527778 0.073837 1.1555556 0.072093 1.1583333 0.073837 1.1611111 0.072093 1.1638889 0.073837 1.1666667 0.065116 1.1694444 0.063372 1.1722222 0.061628 1.1750000 0.066860 1.1777778 0.065116 1.1805556 0.068605 1.1833333 0.079070 1.1861111 0.079070 1.1888889 0.089535 1.1916667 0.093023 1.1944444 0.091279 1.1972222 0.091279 1.2000000 0.089535 1.2027778 0.093023 1.2055556 0.087791 1.2083333 0.087791 1.2111111 0.089535 1.2138889 0.093023 1.2166667 0.101744 1.2194444 0.106977 1.2222222 0.113953 1.2250000 0.112209 1.2277778 0.112209 1.2305556 0.098256 1.2333333 0.089535 1.2361111 0.079070 1.2388889 0.072093 1.2416667 0.065116 1.2444444 0.061628 1.2472222 0.063372 1.2500000 0.068605 1.2527778 0.073837 1.2555556 0.068605 1.2583333 0.068605 1.2611111 0.063372 1.2638889 0.066860 1.2666667 0.059884 1.2694444 0.065116 1.2722222 0.061628 1.2750000 0.054651 1.2777778 0.056395 1.2805556 0.059884 1.2833333 0.066860 1.2861111 0.068605 1.2888889 0.068605 1.2916667 0.070349 1.2944444 0.070349 1.2972222 0.070349 1.3000000 0.065116 1.3027778 0.065116 1.3055556 0.063372 1.3083333 0.056395 1.3111111 0.063372 1.3138889 0.065116 1.3166667 0.063372 1.3194444 0.066860 1.3222222 0.066860 1.3250000 0.065116 1.3277778 0.066860 1.3305556 0.066860 1.3333333 0.065116 1.3361111 0.065116 1.3388889 0.059884 1.3416667 0.059884 1.3444444 0.052907 1.3472222 0.063372 1.3500000 0.063372 1.3527778 0.063372 1.3555556 0.066860 1.3583333 0.073837 1.3611111 0.079070 1.3638889 0.082558 1.3666667 0.094767 1.3694444 0.110465 1.3722222 0.129651 1.3750000 0.147093 1.3777778 0.157558 1.3805556 0.140116 1.3833333 0.113953 1.3861111 0.073837 1.3888889 0.010000 1.3916667 0.010000 1.3944444 0.010000 1.3972222 0.010000 1.4000000 0.010000 1.4027778 0.010000 1.4055556 0.010000 1.4083333 0.010000 1.4111111 0.010000 1.4138889 0.010000 1.4166667 0.010000 1.4194444 0.010000 1.4222222 0.010000 1.4250000 0.010000 1.4277778 0.010000 1.4305556 0.010000 1.4333333 0.010000 1.4361111 0.010000 1.4388889 0.019767 1.4416667 0.038953 1.4444444 0.049419 1.4472222 0.059884 1.4500000 0.065116 1.4527778 0.073837 1.4555556 0.077326 1.4583333 0.075581 1.4611111 0.079070 1.4638889 0.080814 1.4666667 0.080814 1.4694444 0.080814 1.4722222 0.073837 1.4750000 0.080814 1.4777778 0.077326 1.4805556 0.077326 1.4833333 0.086047 1.4861111 0.089535 1.4888889 0.098256 1.4916667 0.101744 1.4944444 0.100000 1.4972222 0.096512 1.5000000 0.093023 1.5027778 0.094767 1.5055556 0.091279 1.5083333 0.087791 1.5111111 0.091279 1.5138889 0.089535 1.5166667 0.093023 1.5194444 0.096512 1.5222222 0.105233 1.5250000 0.103488 1.5277778 0.105233 1.5305556 0.100000 1.5333333 0.093023 1.5361111 0.093023 1.5388889 0.089535 1.5416667 0.086047 1.5444444 0.091279 1.5472222 0.089535 1.5500000 0.093023 1.5527778 0.098256 1.5555556 0.108721 1.5583333 0.110465 1.5611111 0.112209 1.5638889 0.106977 1.5666667 0.108721 1.5694444 0.103488 1.5722222 0.098256 1.5750000 0.096512 1.5777778 0.096512 1.5805556 0.098256 1.5833333 0.101744 1.5861111 0.110465 1.5888889 0.103488 1.5916667 0.106977 1.5944444 0.108721 1.5972222 0.103488 1.6000000 0.101744 1.6027778 0.098256 1.6055556 0.101744 1.6083333 0.098256 1.6111111 0.100000 1.6138889 0.108721 1.6166667 0.110465 1.6194444 0.117442 1.6222222 0.117442 1.6250000 0.120930 1.6277778 0.120930 1.6305556 0.120930 1.6333333 0.119186 1.6361111 0.113953 1.6388889 0.112209 1.6416667 0.105233 1.6444444 0.112209 1.6472222 0.115698 1.6500000 0.119186 1.6527778 0.122674 1.6555556 0.122674 1.6583333 0.124419 1.6611111 0.122674 1.6638889 0.122674 1.6666667 0.112209 1.6694444 0.113953 1.6722222 0.112209 1.6750000 0.108721 1.6777778 0.108721 1.6805556 0.113953 1.6833333 0.115698 1.6861111 0.115698 1.6888889 0.122674 1.6916667 0.120930 1.6944444 0.120930 1.6972222 0.112209 1.7000000 0.110465 1.7027778 0.101744 1.7055556 0.101744 1.7083333 0.100000 1.7111111 0.101744 1.7138889 0.094767 1.7166667 0.098256 1.7194444 0.103488 1.7222222 0.106977 1.7250000 0.108721 1.7277778 0.106977 1.7305556 0.112209 1.7333333 0.108721 1.7361111 0.105233 1.7388889 0.106977 1.7416667 0.106977 1.7444444 0.105233 1.7472222 0.106977 1.7500000 0.110465 1.7527778 0.106977 1.7555556 0.112209 1.7583333 0.105233 1.7611111 0.105233 1.7638889 0.106977 1.7666667 0.100000 1.7694444 0.100000 1.7722222 0.091279 1.7750000 0.087791 1.7777778 0.087791 1.7805556 0.091279 1.7833333 0.094767 1.7861111 0.093023 1.7888889 0.101744 1.7916667 0.094767 1.7944444 0.098256 1.7972222 0.103488 1.8000000 0.101744 1.8027778 0.093023 1.8055556 0.091279 1.8083333 0.091279 1.8111111 0.093023 1.8138889 0.087791 1.8166667 0.093023 1.8194444 0.100000 1.8222222 0.098256 1.8250000 0.100000 1.8277778 0.096512 1.8305556 0.098256 1.8333333 0.094767 1.8361111 0.091279 1.8388889 0.086047 1.8416667 0.084302 1.8444444 0.084302 1.8472222 0.084302 1.8500000 0.089535 1.8527778 0.091279 1.8555556 0.103488 1.8583333 0.108721 1.8611111 0.105233 1.8638889 0.106977 1.8666667 0.110465 1.8694444 0.106977 1.8722222 0.110465 1.8750000 0.117442 1.8777778 0.126163 1.8805556 0.134884 1.8833333 0.148837 1.8861111 0.178488 1.8888889 0.188953 1.8916667 0.187209 1.8944444 0.159302 1.8972222 0.120930 1.9000000 0.068605 1.9027778 0.010000 1.9055556 0.010000 1.9083333 0.010000 1.9111111 0.010000 1.9138889 0.010000 1.9166667 0.010000 1.9194444 0.010000 1.9222222 0.010000 1.9250000 0.010000 1.9277778 0.010000 1.9305556 0.010000 1.9333333 0.010000 1.9361111 0.010000 1.9388889 0.010000 1.9416667 0.010000 1.9444444 0.010000 1.9472222 0.010000 1.9500000 0.010000 1.9527778 0.010000 1.9555556 0.010000 1.9583333 0.010000 1.9611111 0.010000 1.9638889 0.010000 1.9666667 0.010000 1.9694444 0.010000 1.9722222 0.010000 1.9750000 0.010000 1.9777778 0.010000 1.9805556 0.010000 1.9833333 0.010000 1.9861111 0.010000 1.9888889 0.010000 1.9916667 0.010000 1.9944444 0.010000 1.9972222 0.010000 2.0000000 0.010000 2.0027778 0.023256 2.0055556 0.065116 2.0083333 0.086047 2.0111111 0.103488 2.0138889 0.115698 2.0166667 0.117442 2.0194444 0.126163 2.0222222 0.129651 2.0250000 0.140116 2.0277778 0.143605 2.0305556 0.150581 2.0333333 0.148837 2.0361111 0.148837 2.0388889 0.152326 2.0416667 0.157558 2.0444444 0.161047 2.0472222 0.166279 2.0500000 0.173256 2.0527778 0.180233 2.0555556 0.183721 2.0583333 0.187209 2.0611111 0.190698 2.0638889 0.192442 2.0666667 0.190698 2.0694444 0.192442 2.0722222 0.190698 2.0750000 0.190698 2.0777778 0.192442 2.0805556 0.199419 2.0833333 0.209884 2.0861111 0.216860 2.0888889 0.229070 2.0916667 0.230814 2.0944444 0.239535 2.0972222 0.244767 2.1000000 0.246512 2.1027778 0.248256 2.1055556 0.251744 2.1083333 0.262209 2.1111111 0.267442 2.1138889 0.277907 2.1166667 0.290116 2.1194444 0.302326 2.1222222 0.307558 2.1250000 0.316279 2.1277778 0.323256 2.1305556 0.321512 2.1333333 0.323256 2.1361111 0.312791 2.1388889 0.311047 2.1416667 0.305814 2.1444444 0.304070 2.1472222 0.311047 2.1500000 0.312791 2.1527778 0.325000 2.1555556 0.335465 2.1583333 0.344186 2.1611111 0.349419 2.1638889 0.359884 2.1666667 0.361628 2.1694444 0.366860 2.1722222 0.368605 2.1750000 0.373837 2.1777778 0.386047 2.1805556 0.393023 2.1833333 0.405233 2.1861111 0.415698 2.1888889 0.415698 2.1916667 0.422674 2.1944444 0.427907 2.1972222 0.420930 2.2000000 0.417442 2.2027778 0.417442 2.2055556 0.408721 2.2083333 0.401744 2.2111111 0.400000 2.2138889 0.393023 2.2166667 0.394767 2.2194444 0.389535 2.2222222 0.386047 2.2250000 0.377326 2.2277778 0.368605 2.2305556 0.358140 2.2333333 0.342442 2.9861111 0.070349 2.9888889 0.073837 2.9916667 0.075581 2.9944444 0.073837 2.9972222 0.072093 3.0000000 0.070349 3.0027778 0.065116 3.0055556 0.059884 3.0083333 0.061628 3.0111111 0.052907 3.0138889 0.059884 3.0166667 0.061628 3.0194444 0.063372 3.0222222 0.068605 3.0250000 0.077326 3.0277778 0.072093 3.0305556 0.075581 3.0333333 0.072093 3.0361111 0.068605 3.0388889 0.065116 3.0416667 0.065116 3.0444444 0.059884 3.0472222 0.065116 3.0500000 0.070349 3.0527778 0.075581 3.0555556 0.073837 3.0583333 0.084302 3.0611111 0.084302 3.0638889 0.082558 3.0666667 0.086047 3.0694444 0.089535 3.0722222 0.086047 3.0750000 0.084302 3.0777778 0.087791 3.0805556 0.091279 3.0833333 0.094767 3.0861111 0.101744 3.0888889 0.101744 3.0916667 0.105233 3.0944444 0.098256 3.0972222 0.086047 3.1000000 0.072093 3.1027778 0.066860 3.1055556 0.059884 3.1083333 0.054651 3.1111111 0.054651 3.1138889 0.056395 3.1166667 0.056395 3.1194444 0.054651 3.1222222 0.058140 3.1250000 0.068605 3.1277778 0.063372 3.1305556 0.059884 3.1333333 0.056395 3.1361111 0.058140 3.1388889 0.052907 3.1416667 0.056395 3.1444444 0.051163 3.1472222 0.049419 3.1500000 0.051163 3.1527778 0.052907 3.1555556 0.058140 3.1583333 0.061628 3.1611111 0.061628 3.1638889 0.058140 3.1666667 0.054651 3.1694444 0.054651 3.1722222 0.044186 3.1750000 0.047674 3.1777778 0.047674 3.1805556 0.045930 3.1833333 0.051163 3.1861111 0.058140 3.1888889 0.056395 3.1916667 0.058140 3.1944444 0.056395 3.1972222 0.056395 3.2000000 0.058140 3.2027778 0.058140 3.2055556 0.065116 3.2083333 0.080814 3.2111111 0.103488 3.2138889 0.117442 3.2166667 0.129651 3.2194444 0.120930 3.2222222 0.101744 3.2250000 0.068605 3.2277778 0.012791 3.2305556 0.010000 3.2333333 0.010000 3.2361111 0.010000 3.2388889 0.010000 3.2416667 0.010000 3.2444444 0.010000 3.2472222 0.010000 3.2500000 0.010000 3.2527778 0.010000 3.2555556 0.010000 3.2583333 0.010000 3.2611111 0.010000 3.2638889 0.010000 3.2666667 0.010000 3.2694444 0.010000 3.2722222 0.010000 3.2750000 0.010000 3.2777778 0.012791 3.2805556 0.026744 3.2833333 0.040698 3.2861111 0.052907 3.2888889 0.058140 3.2916667 0.063372 3.2944444 0.065116 3.2972222 0.065116 3.3000000 0.065116 3.3027778 0.065116 3.3055556 0.063372 3.3083333 0.065116 3.3111111 0.065116 3.3138889 0.066860 3.3166667 0.075581 3.3194444 0.075581 3.3222222 0.079070 3.3250000 0.080814 3.3277778 0.087791 3.3305556 0.086047 3.3333333 0.082558 3.3361111 0.075581 3.3388889 0.079070 3.3416667 0.079070 3.3444444 0.075581 3.3472222 0.080814 3.3500000 0.080814 3.3527778 0.087791 3.3555556 0.087791 3.3583333 0.089535 3.3611111 0.091279 3.3638889 0.087791 3.3666667 0.093023 3.3694444 0.086047 3.3722222 0.077326 3.3750000 0.077326 3.3777778 0.079070 3.3805556 0.080814 3.3833333 0.084302 3.3861111 0.086047 3.3888889 0.094767 3.3916667 0.101744 3.3944444 0.096512 3.3972222 0.100000 3.4000000 0.098256 3.4027778 0.096512 3.4055556 0.087791 3.4083333 0.089535 3.4111111 0.082558 3.4138889 0.086047 3.4166667 0.087791 3.4194444 0.096512 3.4222222 0.100000 3.4250000 0.101744 3.4277778 0.098256 3.4305556 0.100000 3.4333333 0.105233 3.4361111 0.096512 3.4388889 0.094767 3.4416667 0.094767 3.4444444 0.093023 3.4472222 0.094767 3.4500000 0.105233 3.4527778 0.105233 3.4555556 0.108721 3.4583333 0.115698 3.4611111 0.113953 3.4638889 0.119186 3.4666667 0.119186 3.4694444 0.112209 3.4722222 0.110465 3.4750000 0.105233 3.4777778 0.101744 3.4805556 0.108721 3.4833333 0.112209 3.4861111 0.115698 3.4888889 0.119186 3.4916667 0.124419 3.4944444 0.120930 3.4972222 0.122674 3.5000000 0.112209 3.5027778 0.110465 3.5055556 0.110465 3.5083333 0.108721 3.5111111 0.108721 3.5138889 0.106977 3.5166667 0.112209 3.5194444 0.113953 3.5222222 0.120930 3.5250000 0.124419 3.5277778 0.117442 3.5305556 0.120930 3.5333333 0.115698 3.9305556 0.079070 3.9333333 0.079070 3.9361111 0.068605 3.9388889 0.070349 3.9416667 0.065116 3.9444444 0.063372 3.9472222 0.068605 3.9500000 0.072093 3.9527778 0.070349 3.9555556 0.072093 3.9583333 0.075581 3.9611111 0.080814 3.9638889 0.077326 3.9666667 0.073837 3.9694444 0.075581 3.9722222 0.070349 3.9750000 0.070349 3.9777778 0.079070 3.9805556 0.073837 3.9833333 0.077326 3.9861111 0.080814 3.9888889 0.084302 3.9916667 0.089535 3.9944444 0.098256 3.9972222 0.101744 4.0000000 0.100000 4.0027778 0.100000 4.0055556 0.094767 4.0083333 0.100000 4.0111111 0.098256 4.0138889 0.094767 4.0166667 0.110465 4.0194444 0.110465 4.0222222 0.108721 4.0250000 0.113953 4.0277778 0.106977 4.0305556 0.098256 4.0333333 0.091279 4.0361111 0.082558 4.0388889 0.072093 4.0416667 0.066860 4.0444444 0.063372 4.0472222 0.061628 4.0500000 0.065116 4.0527778 0.066860 4.0555556 0.068605 4.0583333 0.068605 4.0611111 0.065116 4.0638889 0.063372 4.0666667 0.066860 4.0694444 0.065116 4.0722222 0.054651 4.0750000 0.058140 4.0777778 0.051163 4.0805556 0.056395 4.0833333 0.049419 4.0861111 0.051163 4.0888889 0.052907 4.0916667 0.061628 4.0944444 0.061628 4.0972222 0.063372 4.1000000 0.054651 4.1027778 0.047674 4.1055556 0.044186 4.1083333 0.042442 4.1111111 0.042442 4.1138889 0.042442 4.1166667 0.045930 4.1194444 0.052907 4.1222222 0.052907 4.1250000 0.056395 4.1277778 0.061628 4.1305556 0.063372 4.1333333 0.056395 4.1361111 0.058140 4.1388889 0.044186 4.1416667 0.052907 4.1444444 0.056395 4.1472222 0.051163 4.1500000 0.066860 4.1527778 0.082558 4.1555556 0.106977 4.1583333 0.126163 4.1611111 0.138372 4.1638889 0.140116 4.1666667 0.122674 4.1694444 0.077326 4.1722222 0.016279 4.1750000 0.010000 4.1777778 0.010000 4.1805556 0.010000 4.1833333 0.010000 4.1861111 0.010000 4.1888889 0.010000 4.1916667 0.010000 4.1944444 0.010000 4.1972222 0.010000 4.2000000 0.010000 4.2027778 0.010000 4.2055556 0.010000 4.2083333 0.010000 4.2111111 0.010000 4.2138889 0.010000 4.2166667 0.010000 4.2194444 0.010000 4.2222222 0.010000 4.2250000 0.025000 4.2277778 0.038953 4.2305556 0.047674 4.2333333 0.058140 4.2361111 0.056395 4.2388889 0.051163 4.2416667 0.056395 4.2444444 0.056395 4.2472222 0.063372 4.2500000 0.063372 4.2527778 0.066860 4.2555556 0.073837 4.2583333 0.079070 4.2611111 0.073837 4.2638889 0.072093 4.2666667 0.082558 4.2694444 0.073837 4.2722222 0.072093 4.2750000 0.073837 4.2777778 0.072093 4.2805556 0.073837 4.2833333 0.080814 4.2861111 0.079070 4.2888889 0.082558 4.2916667 0.084302 4.2944444 0.089535 4.2972222 0.084302 4.3000000 0.082558 4.3027778 0.079070 4.3055556 0.075581 4.3083333 0.079070 4.3111111 0.073837 4.3138889 0.072093 4.3166667 0.073837 4.3194444 0.082558 4.3222222 0.084302 4.3250000 0.084302 4.3277778 0.084302 4.3305556 0.084302 4.3333333 0.080814 4.3361111 0.084302 4.3388889 0.079070 4.3416667 0.077326 4.3444444 0.077326 4.3472222 0.080814 4.3500000 0.077326 4.3527778 0.087791 4.3555556 0.087791 4.3583333 0.091279 4.3611111 0.087791 4.3638889 0.093023 4.3666667 0.087791 4.3694444 0.080814 4.3722222 0.082558 4.3750000 0.072093 4.3777778 0.077326 4.3805556 0.075581 4.3833333 0.079070 4.3861111 0.079070 4.3888889 0.089535 4.3916667 0.082558 4.3944444 0.091279 4.3972222 0.086047 4.4000000 0.091279 4.4027778 0.086047 4.4055556 0.084302 4.4083333 0.086047 4.4111111 0.084302 4.4138889 0.084302 4.4166667 0.087791 4.4194444 0.093023 4.4222222 0.094767 4.4250000 0.100000 4.4277778 0.098256 4.4305556 0.096512 4.4333333 0.089535 4.4361111 0.091279 4.4388889 0.087791 4.4416667 0.080814 4.4444444 0.079070 4.4472222 0.087791 4.4500000 0.091279 4.4527778 0.094767 4.4555556 0.100000 4.4583333 0.105233 4.4611111 0.101744 4.4638889 0.106977 4.4666667 0.105233 4.4694444 0.100000 4.4722222 0.093023 4.4750000 0.089535 4.4777778 0.086047 4.6805556 0.250000)
Vrpeak rpeak_trigger 0 PWL(0.0000000 0.000000 0.4990000 0.000000 0.5000000 0.900000 0.5010000 0.900000 0.5020000 0.000000 1.3962222 0.000000 1.3972222 0.900000 1.3982222 0.900000 1.3992222 0.000000 1.9351111 0.000000 1.9361111 0.900000 1.9371111 0.900000 1.9381111 0.000000 3.2351111 0.000000 3.2361111 0.900000 3.2371111 0.900000 3.2381111 0.000000 4.1795556 0.000000 4.1805556 0.900000 4.1815556 0.900000 4.1825556 0.000000 4.6805556 0.000000)
Vqrs qrs_gate 0 PWL(0.0000000 0.000000 0.4384444 0.000000 0.4394444 0.900000 0.6133333 0.900000 0.6143333 0.000000 1.3356667 0.000000 1.3366667 0.900000 1.5105556 0.900000 1.5115556 0.000000 1.8745556 0.000000 1.8755556 0.900000 2.0494444 0.900000 2.0504444 0.000000 3.1745556 0.000000 3.1755556 0.900000 3.3494444 0.900000 3.3504444 0.000000 4.1190000 0.000000 4.1200000 0.900000 4.2938889 0.900000 4.2948889 0.000000 4.6805556 0.000000)
Vsym qrs_sym_gate 0 PWL(0.0000000 0.000000 0.4414444 0.000000 0.4424444 0.900000 0.6103333 0.900000 0.6113333 0.000000 1.3386667 0.000000 1.3396667 0.900000 1.5075556 0.900000 1.5085556 0.000000 1.9192222 0.000000 1.9202222 0.900000 2.0464444 0.900000 2.0474444 0.000000 3.1997778 0.000000 3.2007778 0.900000 3.3464444 0.900000 3.3474444 0.000000 4.1220000 0.000000 4.1230000 0.900000 4.2908889 0.900000 4.2918889 0.000000 4.6805556 0.000000)
Vpwave pwave_gate 0 PWL(0.0000000 0.000000 0.2934444 0.000000 0.2944444 0.900000 0.4444444 0.900000 0.4454444 0.000000 1.1906667 0.000000 1.1916667 0.900000 1.3416667 0.900000 1.3426667 0.000000 1.7295556 0.000000 1.7305556 0.900000 1.8805556 0.900000 1.8815556 0.000000 3.0295556 0.000000 3.0305556 0.900000 3.1805556 0.900000 3.1815556 0.000000 3.9740000 0.000000 3.9750000 0.900000 4.1250000 0.900000 4.1260000 0.000000 4.6805556 0.000000)

Xrr rpeak_trigger f_rr_ratio f_rr_asym vdd vss vbias rr_timing
Xinstab0 ecg_in qrs_gate rpeak_trigger f_instab_l0 peak_out_l0 vdd vss vbias vref beat_instability
Xinstab1 ecg_in_l1 qrs_gate rpeak_trigger f_instab_l1 peak_out_l1 vdd vss vbias vref beat_instability
Xpwave ecg_in_l1 pwave_gate rpeak_trigger f_pwave vdd vss vbias vref pwave_energy
Xwidth vref ecg_in qrs_gate rpeak_trigger f_width vdd vss vbias qrs_width
Xsym qrs_sym_gate rpeak_trigger f_sym rise_timer_out fall_timer_out vdd vss vbias qrs_symmetry
Xslope rise_timer_out fall_timer_out f_slope vdd vss vbias slope_ratio

.tran 0.1m 4.6806

* === ENERGY MEASUREMENTS ===
* Total charge drawn from VDD over entire simulation
.meas tran total_charge INTEG I(Vdd) FROM=0.1 TO=4.6806

* Average current
.meas tran avg_current AVG I(Vdd) FROM=0.1 TO=4.6806

* Per-beat energy (integrate current over each beat interval)
.meas tran charge_b0 INTEG I(Vdd) FROM=0.10000 TO=0.94861
.meas tran avg_i_b0 AVG I(Vdd) FROM=0.10000 TO=0.94861
.meas tran charge_b1 INTEG I(Vdd) FROM=0.94861 TO=1.66667
.meas tran avg_i_b1 AVG I(Vdd) FROM=0.94861 TO=1.66667
.meas tran charge_b2 INTEG I(Vdd) FROM=1.66667 TO=2.58611
.meas tran avg_i_b2 AVG I(Vdd) FROM=1.66667 TO=2.58611
.meas tran charge_b3 INTEG I(Vdd) FROM=2.58611 TO=3.70833
.meas tran avg_i_b3 AVG I(Vdd) FROM=2.58611 TO=3.70833
.meas tran charge_b4 INTEG I(Vdd) FROM=3.70833 TO=4.58056
.meas tran avg_i_b4 AVG I(Vdd) FROM=3.70833 TO=4.58056

.meas tran peak_current MIN I(Vdd) FROM=0.1 TO=4.6806

.end
