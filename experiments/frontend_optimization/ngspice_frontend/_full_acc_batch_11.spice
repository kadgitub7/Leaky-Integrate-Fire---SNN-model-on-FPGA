.title full_acc_batch_11
.lib "sky130_minimal.lib.spice" tt
.option scale=1.0u method=gear gmin=1e-15 abstol=1e-15 reltol=0.005
.temp 27
.include "ota_5t_subthreshold.spice"
.include "inverter.spice"
.include "resistor_div.spice"
.include "rr_timing.spice"
.include "beat_instability.spice"
.include "pwave_energy.spice"
.include "qrs_width.spice"
.include "slope_ratio.spice"
.include "qrs_symmetry.spice"

Vdd vdd 0 0.9
Vss vss 0 0
Vbias vbias 0 0.35
Vref vref 0 0.45

Vecg ecg_in 0 PWL(0.0000000 0.250000 0.2500000 0.044038 0.2527778 0.038846 0.2555556 0.033654 0.2583333 0.033654 0.2611111 0.038846 0.2638889 0.040577 0.2666667 0.040577 0.2694444 0.044038 0.2722222 0.047500 0.2750000 0.050962 0.2777778 0.057885 0.2805556 0.056154 0.2833333 0.057885 0.2861111 0.056154 0.2888889 0.054423 0.2916667 0.049231 0.2944444 0.049231 0.2972222 0.050962 0.3000000 0.054423 0.3027778 0.056154 0.3055556 0.066538 0.3083333 0.075192 0.3111111 0.080385 0.3138889 0.078654 0.3166667 0.082115 0.3194444 0.076923 0.3222222 0.073462 0.3250000 0.070000 0.3277778 0.064808 0.3305556 0.057885 0.3333333 0.061346 0.3361111 0.064808 0.3388889 0.064808 0.3416667 0.068269 0.3444444 0.068269 0.3472222 0.070000 0.3500000 0.064808 0.3527778 0.064808 0.3555556 0.068269 0.3583333 0.073462 0.3611111 0.082115 0.3638889 0.080385 0.3666667 0.083846 0.3694444 0.083846 0.3722222 0.083846 0.3750000 0.082115 0.3777778 0.075192 0.3805556 0.066538 0.3833333 0.063077 0.3861111 0.054423 0.3888889 0.050962 0.3916667 0.044038 0.3944444 0.044038 0.3972222 0.044038 0.4000000 0.047500 0.4027778 0.049231 0.4055556 0.052692 0.4083333 0.056154 0.4111111 0.057885 0.4138889 0.057885 0.4166667 0.054423 0.4194444 0.052692 0.4222222 0.047500 0.4250000 0.038846 0.4277778 0.042308 0.4305556 0.052692 0.4333333 0.071731 0.4361111 0.097692 0.4388889 0.128846 0.4416667 0.160000 0.4444444 0.185962 0.4472222 0.192885 0.4500000 0.192885 0.4527778 0.170385 0.4555556 0.137500 0.4583333 0.090769 0.4611111 0.056154 0.4638889 0.052692 0.4666667 0.087308 0.4694444 0.154808 0.4722222 0.243077 0.4750000 0.340000 0.4777778 0.430000 0.4805556 0.513077 0.4833333 0.589231 0.4861111 0.655000 0.4888889 0.715577 0.4916667 0.760577 0.4944444 0.788269 0.4972222 0.803846 0.5000000 0.809038 0.5027778 0.786538 0.5055556 0.762308 0.5083333 0.725962 0.5111111 0.668846 0.5138889 0.594423 0.5166667 0.525192 0.5194444 0.455962 0.5222222 0.388462 0.5250000 0.322692 0.5277778 0.250000 0.5305556 0.184231 0.5333333 0.118462 0.5361111 0.059615 0.5388889 0.016346 0.5416667 0.010000 0.5444444 0.010000 0.5472222 0.010000 0.5500000 0.010000 0.5527778 0.010000 0.5555556 0.010000 0.5583333 0.010000 0.5611111 0.010000 0.5638889 0.010000 0.5666667 0.010000 0.5694444 0.010000 0.5722222 0.016346 0.5750000 0.018077 0.5777778 0.023269 0.5805556 0.021538 0.5833333 0.019808 0.5861111 0.018077 0.5888889 0.014615 0.5916667 0.010000 0.5944444 0.010000 0.5972222 0.010000 0.6000000 0.010000 0.6027778 0.010000 0.6055556 0.018077 0.6083333 0.019808 0.6111111 0.021538 0.6138889 0.019808 0.6166667 0.014615 0.6194444 0.011154 0.6222222 0.012885 0.6250000 0.010000 0.6277778 0.010000 0.6305556 0.010000 0.6333333 0.010000 0.6361111 0.010000 0.6388889 0.011154 0.6416667 0.011154 0.6444444 0.016346 0.6472222 0.014615 0.6500000 0.011154 0.6527778 0.011154 0.6555556 0.010000 0.6583333 0.010000 0.6611111 0.010000 0.6638889 0.010000 0.6666667 0.010000 0.6694444 0.010000 0.6722222 0.010000 0.6750000 0.010000 0.6777778 0.011154 0.6805556 0.011154 0.6833333 0.010000 0.6861111 0.010000 0.6888889 0.010000 0.6916667 0.010000 0.6944444 0.010000 0.6972222 0.010000 0.7000000 0.010000 0.7027778 0.010000 0.7055556 0.010000 0.7083333 0.010000 0.7111111 0.010000 0.7138889 0.010000 0.7166667 0.010000 0.7194444 0.010000 0.7222222 0.010000 0.7250000 0.010000 0.7277778 0.010000 0.7305556 0.010000 0.7333333 0.010000 0.7361111 0.010000 0.7388889 0.010000 0.7416667 0.010000 0.7444444 0.010000 0.7472222 0.010000 0.7500000 0.010000 0.7527778 0.010000 0.7555556 0.010000 0.7583333 0.010000 0.7611111 0.010000 0.7638889 0.010000 0.7666667 0.010000 0.7694444 0.010000 0.7722222 0.010000 0.7750000 0.010000 0.7777778 0.010000 0.7805556 0.010000 0.7833333 0.010000 0.7861111 0.010000 0.7888889 0.010000 0.7916667 0.010000 0.7944444 0.010000 0.7972222 0.010000 1.4638889 0.052692 1.4666667 0.056154 1.4694444 0.054423 1.4722222 0.059615 1.4750000 0.063077 1.4777778 0.064808 1.4805556 0.063077 1.4833333 0.059615 1.4861111 0.059615 1.4888889 0.052692 1.4916667 0.054423 1.4944444 0.054423 1.4972222 0.056154 1.5000000 0.059615 1.5027778 0.066538 1.5055556 0.063077 1.5083333 0.066538 1.5111111 0.068269 1.5138889 0.064808 1.5166667 0.064808 1.5194444 0.059615 1.5222222 0.063077 1.5250000 0.063077 1.5277778 0.066538 1.5305556 0.070000 1.5333333 0.073462 1.5361111 0.078654 1.5388889 0.082115 1.5416667 0.083846 1.5444444 0.082115 1.5472222 0.080385 1.5500000 0.076923 1.5527778 0.071731 1.5555556 0.066538 1.5583333 0.066538 1.5611111 0.059615 1.5638889 0.061346 1.5666667 0.057885 1.5694444 0.061346 1.5722222 0.066538 1.5750000 0.075192 1.5777778 0.080385 1.5805556 0.083846 1.5833333 0.078654 1.5861111 0.080385 1.5888889 0.075192 1.5916667 0.068269 1.5944444 0.064808 1.5972222 0.061346 1.6000000 0.057885 1.6027778 0.054423 1.6055556 0.056154 1.6083333 0.054423 1.6111111 0.052692 1.6138889 0.047500 1.6166667 0.049231 1.6194444 0.045769 1.6222222 0.042308 1.6250000 0.042308 1.6277778 0.042308 1.6305556 0.044038 1.6333333 0.042308 1.6361111 0.049231 1.6388889 0.044038 1.6416667 0.047500 1.6444444 0.042308 1.6472222 0.045769 1.6500000 0.059615 1.6527778 0.085577 1.6555556 0.118462 1.6583333 0.146154 1.6611111 0.170385 1.6638889 0.185962 1.6666667 0.185962 1.6694444 0.160000 1.6722222 0.104615 1.6750000 0.045769 1.6777778 0.011154 1.6805556 0.012885 1.6833333 0.052692 1.6861111 0.125385 1.6888889 0.211923 1.6916667 0.301923 1.6944444 0.385000 1.6972222 0.462885 1.7000000 0.533846 1.7027778 0.596154 1.7055556 0.644615 1.7083333 0.679231 1.7111111 0.694808 1.7138889 0.691346 1.7166667 0.674038 1.7194444 0.649808 1.7222222 0.608269 1.7250000 0.554615 1.7277778 0.490577 1.7305556 0.419615 1.7333333 0.353846 1.7361111 0.288077 1.7388889 0.218846 1.7416667 0.147885 1.7444444 0.085577 1.7472222 0.030192 1.7500000 0.010000 1.7527778 0.010000 1.7555556 0.010000 1.7583333 0.010000 1.7611111 0.010000 1.7638889 0.010000 1.7666667 0.010000 1.7694444 0.010000 1.7722222 0.010000 1.7750000 0.012885 1.7777778 0.012885 1.7805556 0.016346 1.7833333 0.012885 1.7861111 0.011154 1.7888889 0.010000 1.7916667 0.010000 1.7944444 0.010000 1.7972222 0.010000 1.8000000 0.010000 1.8027778 0.010000 1.8055556 0.010000 1.8083333 0.010000 1.8111111 0.011154 1.8138889 0.010000 1.8166667 0.010000 1.8194444 0.010000 1.8222222 0.010000 1.8250000 0.010000 1.8277778 0.010000 1.8305556 0.010000 1.8333333 0.010000 1.8361111 0.010000 1.8388889 0.010000 1.8416667 0.010000 1.8444444 0.010000 1.8472222 0.010000 1.8500000 0.010000 1.8527778 0.010000 1.8555556 0.010000 1.8583333 0.010000 1.8611111 0.010000 1.8638889 0.010000 1.8666667 0.010000 1.8694444 0.010000 1.8722222 0.010000 1.8750000 0.010000 1.8777778 0.010000 1.8805556 0.010000 1.8833333 0.010000 1.8861111 0.010000 1.8888889 0.010000 1.8916667 0.010000 1.8944444 0.010000 1.8972222 0.010000 1.9000000 0.010000 1.9027778 0.010000 1.9055556 0.010000 1.9083333 0.010000 1.9111111 0.010000 1.9138889 0.010000 1.9166667 0.010000 1.9194444 0.010000 1.9222222 0.010000 1.9250000 0.010000 1.9277778 0.010000 1.9305556 0.010000 1.9333333 0.010000 1.9361111 0.010000 1.9388889 0.010000 1.9416667 0.010000 1.9444444 0.010000 1.9472222 0.010000 1.9500000 0.010000 1.9527778 0.010000 1.9555556 0.010000 1.9583333 0.010000 1.9611111 0.010000 1.9638889 0.010000 1.9666667 0.010000 1.9694444 0.010000 1.9722222 0.010000 1.9750000 0.010000 1.9777778 0.010000 1.9805556 0.010000 1.9833333 0.010000 1.9861111 0.010000 1.9888889 0.010000 1.9916667 0.010000 1.9944444 0.010000 1.9972222 0.010000 2.0000000 0.010000 2.0027778 0.010000 2.0055556 0.010000 2.0083333 0.010000 2.0111111 0.010000 2.7277778 0.010000 2.7305556 0.010000 2.7333333 0.010000 2.7361111 0.010000 2.7388889 0.010000 2.7416667 0.010000 2.7444444 0.010000 2.7472222 0.010000 2.7500000 0.010000 2.7527778 0.010000 2.7555556 0.010000 2.7583333 0.010000 2.7611111 0.010000 2.7638889 0.010000 2.7666667 0.010000 2.7694444 0.010000 2.7722222 0.010000 2.7750000 0.011154 2.7777778 0.011154 2.7805556 0.012885 2.7833333 0.012885 2.7861111 0.019808 2.7888889 0.018077 2.7916667 0.016346 2.7944444 0.023269 2.7972222 0.021538 2.8000000 0.023269 2.8027778 0.023269 2.8055556 0.025000 2.8083333 0.023269 2.8111111 0.025000 2.8138889 0.019808 2.8166667 0.018077 2.8194444 0.011154 2.8222222 0.012885 2.8250000 0.010000 2.8277778 0.010000 2.8305556 0.010000 2.8333333 0.010000 2.8361111 0.016346 2.8388889 0.021538 2.8416667 0.028462 2.8444444 0.033654 2.8472222 0.033654 2.8500000 0.033654 2.8527778 0.028462 2.8555556 0.021538 2.8583333 0.012885 2.8611111 0.010000 2.8638889 0.010000 2.8666667 0.010000 2.8694444 0.010000 2.8722222 0.010000 2.8750000 0.010000 2.8777778 0.010000 2.8805556 0.010000 2.8833333 0.010000 2.8861111 0.010000 2.8888889 0.010000 2.8916667 0.010000 2.8944444 0.010000 2.8972222 0.010000 2.9000000 0.010000 2.9027778 0.010000 2.9055556 0.010000 2.9083333 0.010000 2.9111111 0.010000 2.9138889 0.016346 2.9166667 0.044038 2.9194444 0.078654 2.9222222 0.099423 2.9250000 0.118462 2.9277778 0.125385 2.9305556 0.115000 2.9333333 0.083846 2.9361111 0.037115 2.9388889 0.010000 2.9416667 0.010000 2.9444444 0.010000 2.9472222 0.042308 2.9500000 0.121923 2.9527778 0.213654 2.9555556 0.308846 2.9583333 0.404038 2.9611111 0.488846 2.9638889 0.568462 2.9666667 0.637692 2.9694444 0.700000 2.9722222 0.732885 2.9750000 0.750192 2.9777778 0.745000 2.9805556 0.717308 2.9833333 0.675769 2.9861111 0.606538 2.9888889 0.523462 2.9916667 0.435192 2.9944444 0.352115 2.9972222 0.272500 3.0000000 0.198077 3.0027778 0.115000 3.0055556 0.037115 3.0083333 0.010000 3.0111111 0.010000 3.0138889 0.010000 3.0166667 0.010000 3.0194444 0.010000 3.0222222 0.010000 3.0250000 0.010000 3.0277778 0.010000 3.0305556 0.010000 3.0333333 0.010000 3.0361111 0.010000 3.0388889 0.010000 3.0416667 0.010000 3.0444444 0.010000 3.0472222 0.010000 3.0500000 0.010000 3.0527778 0.010000 3.0555556 0.010000 3.0583333 0.010000 3.0611111 0.010000 3.0638889 0.010000 3.0666667 0.010000 3.0694444 0.010000 3.0722222 0.010000 3.0750000 0.010000 3.0777778 0.010000 3.0805556 0.010000 3.0833333 0.010000 3.0861111 0.010000 3.0888889 0.010000 3.0916667 0.010000 3.0944444 0.010000 3.0972222 0.010000 3.1000000 0.010000 3.1027778 0.010000 3.1055556 0.010000 3.1083333 0.010000 3.1111111 0.010000 3.1138889 0.010000 3.1166667 0.010000 3.1194444 0.010000 3.1222222 0.010000 3.1250000 0.010000 3.1277778 0.010000 3.1305556 0.010000 3.1333333 0.010000 3.1361111 0.010000 3.1388889 0.010000 3.1416667 0.010000 3.1444444 0.010000 3.1472222 0.010000 3.1500000 0.010000 3.1527778 0.010000 3.1555556 0.010000 3.1583333 0.010000 3.1611111 0.010000 3.1638889 0.010000 3.1666667 0.010000 3.1694444 0.010000 3.1722222 0.010000 3.1750000 0.010000 3.1777778 0.010000 3.1805556 0.010000 3.1833333 0.010000 3.1861111 0.010000 3.1888889 0.010000 3.1916667 0.010000 3.1944444 0.010000 3.1972222 0.010000 3.2000000 0.010000 3.2027778 0.010000 3.2055556 0.010000 3.2083333 0.010000 3.2111111 0.010000 3.2138889 0.010000 3.2166667 0.010000 3.2194444 0.010000 3.2222222 0.010000 3.2250000 0.010000 3.2277778 0.010000 3.2305556 0.010000 3.2333333 0.010000 3.2361111 0.010000 3.2388889 0.010000 3.2416667 0.010000 3.2444444 0.010000 3.2472222 0.010000 3.2500000 0.010000 3.2527778 0.010000 3.2555556 0.010000 3.2583333 0.010000 3.2611111 0.010000 3.2638889 0.010000 3.2666667 0.010000 3.2694444 0.010000 3.2722222 0.010000 3.2750000 0.010000 3.9527778 0.010000 3.9555556 0.010000 3.9583333 0.010000 3.9611111 0.010000 3.9638889 0.010000 3.9666667 0.010000 3.9694444 0.010000 3.9722222 0.010000 3.9750000 0.010000 3.9777778 0.010000 3.9805556 0.010000 3.9833333 0.010000 3.9861111 0.010000 3.9888889 0.010000 3.9916667 0.010000 3.9944444 0.010000 3.9972222 0.010000 4.0000000 0.010000 4.0027778 0.010000 4.0055556 0.010000 4.0083333 0.010000 4.0111111 0.010000 4.0138889 0.010000 4.0166667 0.010000 4.0194444 0.010000 4.0222222 0.010000 4.0250000 0.010000 4.0277778 0.010000 4.0305556 0.010000 4.0333333 0.010000 4.0361111 0.010000 4.0388889 0.010000 4.0416667 0.010000 4.0444444 0.010000 4.0472222 0.010000 4.0500000 0.010000 4.0527778 0.010000 4.0555556 0.010000 4.0583333 0.010000 4.0611111 0.010000 4.0638889 0.010000 4.0666667 0.010000 4.0694444 0.010000 4.0722222 0.010000 4.0750000 0.010000 4.0777778 0.010000 4.0805556 0.010000 4.0833333 0.010000 4.0861111 0.010000 4.0888889 0.010000 4.0916667 0.010000 4.0944444 0.010000 4.0972222 0.010000 4.1000000 0.010000 4.1027778 0.010000 4.1055556 0.010000 4.1083333 0.010000 4.1111111 0.010000 4.1138889 0.010000 4.1166667 0.010000 4.1194444 0.010000 4.1222222 0.010000 4.1250000 0.010000 4.1277778 0.010000 4.1305556 0.010000 4.1333333 0.010000 4.1361111 0.014615 4.1388889 0.049231 4.1416667 0.076923 4.1444444 0.095962 4.1472222 0.104615 4.1500000 0.099423 4.1527778 0.075192 4.1555556 0.028462 4.1583333 0.010000 4.1611111 0.010000 4.1638889 0.010000 4.1666667 0.010000 4.1694444 0.010000 4.1722222 0.010000 4.1750000 0.087308 4.1777778 0.175577 4.1805556 0.250000 4.1833333 0.315769 4.1861111 0.385000 4.1888889 0.445577 4.1916667 0.502692 4.1944444 0.545962 4.1972222 0.584038 4.2000000 0.601346 4.2027778 0.599615 4.2055556 0.585769 4.2083333 0.565000 4.2111111 0.530385 4.2138889 0.476731 4.2166667 0.412692 4.2194444 0.348654 4.2222222 0.279423 4.2250000 0.215385 4.2277778 0.147885 4.2305556 0.071731 4.2333333 0.010000 4.2361111 0.010000 4.2388889 0.010000 4.2416667 0.010000 4.2444444 0.010000 4.2472222 0.010000 4.2500000 0.010000 4.2527778 0.010000 4.2555556 0.010000 4.2583333 0.010000 4.2611111 0.010000 4.2638889 0.010000 4.2666667 0.010000 4.2694444 0.010000 4.2722222 0.010000 4.2750000 0.010000 4.2777778 0.010000 4.2805556 0.010000 4.2833333 0.010000 4.2861111 0.010000 4.2888889 0.010000 4.2916667 0.010000 4.2944444 0.010000 4.2972222 0.010000 4.3000000 0.010000 4.3027778 0.010000 4.3055556 0.010000 4.3083333 0.010000 4.3111111 0.010000 4.3138889 0.010000 4.3166667 0.010000 4.3194444 0.010000 4.3222222 0.010000 4.3250000 0.010000 4.3277778 0.010000 4.3305556 0.010000 4.3333333 0.010000 4.3361111 0.010000 4.3388889 0.010000 4.3416667 0.010000 4.3444444 0.010000 4.3472222 0.010000 4.3500000 0.010000 4.3527778 0.010000 4.3555556 0.010000 4.3583333 0.010000 4.3611111 0.010000 4.3638889 0.010000 4.3666667 0.010000 4.3694444 0.010000 4.3722222 0.010000 4.3750000 0.010000 4.3777778 0.010000 4.3805556 0.010000 4.3833333 0.010000 4.3861111 0.010000 4.3888889 0.010000 4.3916667 0.010000 4.3944444 0.010000 4.3972222 0.010000 4.4000000 0.010000 4.4027778 0.010000 4.4055556 0.010000 4.4083333 0.010000 4.4111111 0.010000 4.4138889 0.010000 4.4166667 0.010000 4.4194444 0.010000 4.4222222 0.010000 4.4250000 0.010000 4.4277778 0.010000 4.4305556 0.010000 4.4333333 0.010000 4.4361111 0.010000 4.4388889 0.010000 4.4416667 0.010000 4.4444444 0.010000 4.4472222 0.010000 4.4500000 0.010000 4.4527778 0.010000 4.4555556 0.010000 4.4583333 0.010000 4.4611111 0.010000 4.4638889 0.010000 4.4666667 0.010000 4.4694444 0.010000 4.4722222 0.010000 4.4750000 0.010000 4.4777778 0.010000 4.4805556 0.010000 4.4833333 0.010000 4.4861111 0.010000 4.4888889 0.010000 4.4916667 0.010000 4.4944444 0.010000 4.4972222 0.010000 4.5000000 0.010000 5.1250000 0.010000 5.1277778 0.010000 5.1305556 0.010000 5.1333333 0.010000 5.1361111 0.010000 5.1388889 0.010000 5.1416667 0.010000 5.1444444 0.010000 5.1472222 0.010000 5.1500000 0.010000 5.1527778 0.010000 5.1555556 0.010000 5.1583333 0.010000 5.1611111 0.010000 5.1638889 0.010000 5.1666667 0.010000 5.1694444 0.010000 5.1722222 0.010000 5.1750000 0.010000 5.1777778 0.010000 5.1805556 0.010000 5.1833333 0.010000 5.1861111 0.010000 5.1888889 0.010000 5.1916667 0.010000 5.1944444 0.010000 5.1972222 0.010000 5.2000000 0.010000 5.2027778 0.010000 5.2055556 0.010000 5.2083333 0.010000 5.2111111 0.010000 5.2138889 0.010000 5.2166667 0.010000 5.2194444 0.010000 5.2222222 0.010000 5.2250000 0.010000 5.2277778 0.010000 5.2305556 0.010000 5.2333333 0.010000 5.2361111 0.010000 5.2388889 0.010000 5.2416667 0.010000 5.2444444 0.010000 5.2472222 0.010000 5.2500000 0.010000 5.2527778 0.010000 5.2555556 0.010000 5.2583333 0.010000 5.2611111 0.010000 5.2638889 0.010000 5.2666667 0.010000 5.2694444 0.010000 5.2722222 0.010000 5.2750000 0.010000 5.2777778 0.010000 5.2805556 0.010000 5.2833333 0.010000 5.2861111 0.010000 5.2888889 0.010000 5.2916667 0.010000 5.2944444 0.010000 5.2972222 0.010000 5.3000000 0.010000 5.3027778 0.010000 5.3055556 0.010000 5.3083333 0.010000 5.3111111 0.010000 5.3138889 0.010000 5.3166667 0.010000 5.3194444 0.011154 5.3222222 0.030192 5.3250000 0.045769 5.3277778 0.040577 5.3305556 0.023269 5.3333333 0.010000 5.3361111 0.010000 5.3388889 0.010000 5.3416667 0.010000 5.3444444 0.010000 5.3472222 0.019808 5.3500000 0.115000 5.3527778 0.213654 5.3555556 0.307115 5.3583333 0.400577 5.3611111 0.478462 5.3638889 0.545962 5.3666667 0.608269 5.3694444 0.653269 5.3722222 0.682692 5.3750000 0.686154 5.3777778 0.668846 5.3805556 0.635962 5.3833333 0.580577 5.3861111 0.509615 5.3888889 0.426538 5.3916667 0.340000 5.3944444 0.255192 5.3972222 0.173846 5.4000000 0.097692 5.4027778 0.021538 5.4055556 0.010000 5.4083333 0.010000 5.4111111 0.010000 5.4138889 0.010000 5.4166667 0.010000 5.4194444 0.010000 5.4222222 0.010000 5.4250000 0.010000 5.4277778 0.010000 5.4305556 0.010000 5.4333333 0.010000 5.4361111 0.010000 5.4388889 0.010000 5.4416667 0.010000 5.4444444 0.010000 5.4472222 0.010000 5.4500000 0.010000 5.4527778 0.010000 5.4555556 0.010000 5.4583333 0.010000 5.4611111 0.010000 5.4638889 0.010000 5.4666667 0.010000 5.4694444 0.010000 5.4722222 0.010000 5.4750000 0.010000 5.4777778 0.010000 5.4805556 0.010000 5.4833333 0.010000 5.4861111 0.010000 5.4888889 0.010000 5.4916667 0.010000 5.4944444 0.010000 5.4972222 0.010000 5.5000000 0.010000 5.5027778 0.010000 5.5055556 0.010000 5.5083333 0.010000 5.5111111 0.010000 5.5138889 0.010000 5.5166667 0.010000 5.5194444 0.010000 5.5222222 0.010000 5.5250000 0.010000 5.5277778 0.010000 5.5305556 0.010000 5.5333333 0.010000 5.5361111 0.010000 5.5388889 0.010000 5.5416667 0.010000 5.5444444 0.010000 5.5472222 0.010000 5.5500000 0.010000 5.5527778 0.010000 5.5555556 0.010000 5.5583333 0.010000 5.5611111 0.010000 5.5638889 0.010000 5.5666667 0.010000 5.5694444 0.010000 5.5722222 0.010000 5.5750000 0.010000 5.5777778 0.010000 5.5805556 0.010000 5.5833333 0.010000 5.5861111 0.010000 5.5888889 0.010000 5.5916667 0.010000 5.5944444 0.010000 5.5972222 0.010000 5.6000000 0.010000 5.6027778 0.010000 5.6055556 0.010000 5.6083333 0.010000 5.6111111 0.010000 5.6138889 0.010000 5.6166667 0.010000 5.6194444 0.010000 5.6222222 0.010000 5.6250000 0.010000 5.6277778 0.010000 5.6305556 0.010000 5.6333333 0.010000 5.6361111 0.010000 5.6388889 0.010000 5.6416667 0.010000 5.6444444 0.010000 5.6472222 0.010000 5.6500000 0.010000 5.6527778 0.010000 5.6555556 0.010000 5.6583333 0.010000 5.6611111 0.010000 5.6638889 0.010000 5.6666667 0.010000 5.6694444 0.010000 5.6722222 0.010000 6.3388889 0.010000 6.3416667 0.010000 6.3444444 0.010000 6.3472222 0.010000 6.3500000 0.010000 6.3527778 0.010000 6.3555556 0.010000 6.3583333 0.010000 6.3611111 0.010000 6.3638889 0.010000 6.3666667 0.010000 6.3694444 0.010000 6.3722222 0.010000 6.3750000 0.010000 6.3777778 0.010000 6.3805556 0.010000 6.3833333 0.010000 6.3861111 0.010000 6.3888889 0.010000 6.3916667 0.010000 6.3944444 0.010000 6.3972222 0.010000 6.4000000 0.010000 6.4027778 0.010000 6.4055556 0.010000 6.4083333 0.010000 6.4111111 0.010000 6.4138889 0.010000 6.4166667 0.010000 6.4194444 0.010000 6.4222222 0.010000 6.4250000 0.010000 6.4277778 0.010000 6.4305556 0.010000 6.4333333 0.010000 6.4361111 0.010000 6.4388889 0.010000 6.4416667 0.010000 6.4444444 0.010000 6.4472222 0.010000 6.4500000 0.010000 6.4527778 0.010000 6.4555556 0.010000 6.4583333 0.010000 6.4611111 0.010000 6.4638889 0.010000 6.4666667 0.010000 6.4694444 0.010000 6.4722222 0.010000 6.4750000 0.010000 6.4777778 0.010000 6.4805556 0.010000 6.4833333 0.010000 6.4861111 0.010000 6.4888889 0.010000 6.4916667 0.010000 6.4944444 0.010000 6.4972222 0.010000 6.5000000 0.010000 6.5027778 0.010000 6.5055556 0.010000 6.5083333 0.010000 6.5111111 0.010000 6.5138889 0.010000 6.5166667 0.010000 6.5194444 0.010000 6.5222222 0.010000 6.5250000 0.010000 6.5277778 0.010000 6.5305556 0.012885 6.5333333 0.042308 6.5361111 0.064808 6.5388889 0.076923 6.5416667 0.064808 6.5444444 0.028462 6.5472222 0.010000 6.5500000 0.010000 6.5527778 0.010000 6.5555556 0.010000 6.5583333 0.010000 6.5611111 0.010000 6.5638889 0.101154 6.5666667 0.196346 6.5694444 0.281154 6.5722222 0.364231 6.5750000 0.433462 6.5777778 0.495769 6.5805556 0.544231 6.5833333 0.573654 6.5861111 0.590962 6.5888889 0.589231 6.5916667 0.577115 6.5944444 0.547692 6.5972222 0.509615 6.6000000 0.459423 6.6027778 0.390192 6.6055556 0.320962 6.6083333 0.255192 6.6111111 0.184231 6.6138889 0.111538 6.6166667 0.025000 6.6194444 0.010000 6.6222222 0.010000 6.6250000 0.010000 6.6277778 0.010000 6.6305556 0.010000 6.6333333 0.010000 6.6361111 0.010000 6.6388889 0.010000 6.6416667 0.010000 6.6444444 0.010000 6.6472222 0.010000 6.6500000 0.010000 6.6527778 0.010000 6.6555556 0.010000 6.6583333 0.010000 6.6611111 0.010000 6.6638889 0.010000 6.6666667 0.010000 6.6694444 0.010000 6.6722222 0.010000 6.6750000 0.010000 6.6777778 0.010000 6.6805556 0.010000 6.6833333 0.010000 6.6861111 0.010000 6.6888889 0.010000 6.6916667 0.010000 6.6944444 0.010000 6.6972222 0.010000 6.7000000 0.010000 6.7027778 0.010000 6.7055556 0.010000 6.7083333 0.010000 6.7111111 0.010000 6.7138889 0.010000 6.7166667 0.010000 6.7194444 0.010000 6.7222222 0.010000 6.7250000 0.010000 6.7277778 0.010000 6.7305556 0.010000 6.7333333 0.010000 6.7361111 0.010000 6.7388889 0.010000 6.7416667 0.010000 6.7444444 0.010000 6.7472222 0.010000 6.7500000 0.010000 6.7527778 0.010000 6.7555556 0.010000 6.7583333 0.010000 6.7611111 0.010000 6.7638889 0.010000 6.7666667 0.010000 6.7694444 0.010000 6.7722222 0.010000 6.7750000 0.010000 6.7777778 0.010000 6.7805556 0.010000 6.7833333 0.010000 6.7861111 0.010000 6.7888889 0.010000 6.7916667 0.010000 6.7944444 0.010000 6.7972222 0.010000 6.8000000 0.010000 6.8027778 0.010000 6.8055556 0.010000 6.8083333 0.010000 6.8111111 0.010000 6.8138889 0.010000 6.8166667 0.010000 6.8194444 0.010000 6.8222222 0.010000 6.8250000 0.010000 6.8277778 0.010000 6.8305556 0.010000 6.8333333 0.010000 6.8361111 0.010000 6.8388889 0.010000 6.8416667 0.010000 6.8444444 0.010000 6.8472222 0.010000 6.8500000 0.010000 6.8527778 0.010000 6.8555556 0.010000 6.8583333 0.010000 6.8611111 0.010000 6.8638889 0.010000 6.8666667 0.010000 6.8694444 0.010000 6.8722222 0.010000 6.8750000 0.010000 6.8777778 0.010000 6.8805556 0.010000 6.8833333 0.010000 6.8861111 0.010000 7.4833333 0.010000 7.4861111 0.010000 7.4888889 0.010000 7.4916667 0.010000 7.4944444 0.010000 7.4972222 0.010000 7.5000000 0.010000 7.5027778 0.010000 7.5055556 0.010000 7.5083333 0.010000 7.5111111 0.010000 7.5138889 0.010000 7.5166667 0.010000 7.5194444 0.010000 7.5222222 0.010000 7.5250000 0.010000 7.5277778 0.010000 7.5305556 0.010000 7.5333333 0.010000 7.5361111 0.010000 7.5388889 0.010000 7.5416667 0.010000 7.5444444 0.010000 7.5472222 0.010000 7.5500000 0.010000 7.5527778 0.010000 7.5555556 0.010000 7.5583333 0.010000 7.5611111 0.010000 7.5638889 0.010000 7.5666667 0.010000 7.5694444 0.010000 7.5722222 0.010000 7.5750000 0.010000 7.5777778 0.010000 7.5805556 0.010000 7.5833333 0.010000 7.5861111 0.010000 7.5888889 0.010000 7.5916667 0.010000 7.5944444 0.010000 7.5972222 0.010000 7.6000000 0.010000 7.6027778 0.010000 7.6055556 0.010000 7.6083333 0.010000 7.6111111 0.010000 7.6138889 0.010000 7.6166667 0.010000 7.6194444 0.010000 7.6222222 0.010000 7.6250000 0.010000 7.6277778 0.010000 7.6305556 0.010000 7.6333333 0.010000 7.6361111 0.010000 7.6388889 0.010000 7.6416667 0.010000 7.6444444 0.010000 7.6472222 0.010000 7.6500000 0.010000 7.6527778 0.010000 7.6555556 0.010000 7.6583333 0.010000 7.6611111 0.010000 7.6638889 0.010000 7.6666667 0.010000 7.6694444 0.010000 7.6722222 0.010000 7.6750000 0.010000 7.6777778 0.038846 7.6805556 0.066538 7.6833333 0.085577 7.6861111 0.085577 7.6888889 0.066538 7.6916667 0.031923 7.6944444 0.010000 7.6972222 0.010000 7.7000000 0.010000 7.7027778 0.010000 7.7055556 0.028462 7.7083333 0.127115 7.7111111 0.236154 7.7138889 0.343462 7.7166667 0.450769 7.7194444 0.545962 7.7222222 0.630769 7.7250000 0.689615 7.7277778 0.727692 7.7305556 0.732885 7.7333333 0.719038 7.7361111 0.686154 7.7388889 0.635962 7.7416667 0.570192 7.7444444 0.492308 7.7472222 0.409231 7.7500000 0.322692 7.7527778 0.239615 7.7555556 0.163462 7.7583333 0.078654 7.7611111 0.010000 7.7638889 0.010000 7.7666667 0.010000 7.7694444 0.010000 7.7722222 0.010000 7.7750000 0.010000 7.7777778 0.010000 7.7805556 0.010000 7.7833333 0.010000 7.7861111 0.010000 7.7888889 0.010000 7.7916667 0.010000 7.7944444 0.010000 7.7972222 0.010000 7.8000000 0.010000 7.8027778 0.010000 7.8055556 0.010000 7.8083333 0.010000 7.8111111 0.010000 7.8138889 0.010000 7.8166667 0.010000 7.8194444 0.010000 7.8222222 0.010000 7.8250000 0.010000 7.8277778 0.010000 7.8305556 0.010000 7.8333333 0.010000 7.8361111 0.010000 7.8388889 0.010000 7.8416667 0.010000 7.8444444 0.010000 7.8472222 0.010000 7.8500000 0.010000 7.8527778 0.010000 7.8555556 0.010000 7.8583333 0.010000 7.8611111 0.010000 7.8638889 0.010000 7.8666667 0.010000 7.8694444 0.010000 7.8722222 0.010000 7.8750000 0.010000 7.8777778 0.010000 7.8805556 0.010000 7.8833333 0.010000 7.8861111 0.010000 7.8888889 0.010000 7.8916667 0.010000 7.8944444 0.010000 7.8972222 0.010000 7.9000000 0.010000 7.9027778 0.010000 7.9055556 0.010000 7.9083333 0.010000 7.9111111 0.010000 7.9138889 0.010000 7.9166667 0.010000 7.9194444 0.010000 7.9222222 0.010000 7.9250000 0.010000 7.9277778 0.010000 7.9305556 0.010000 7.9333333 0.010000 7.9361111 0.010000 7.9388889 0.010000 7.9416667 0.010000 7.9444444 0.010000 7.9472222 0.010000 7.9500000 0.010000 7.9527778 0.010000 7.9555556 0.010000 7.9583333 0.010000 7.9611111 0.010000 7.9638889 0.010000 7.9666667 0.010000 7.9694444 0.010000 7.9722222 0.010000 7.9750000 0.010000 7.9777778 0.010000 7.9805556 0.010000 7.9833333 0.010000 7.9861111 0.010000 7.9888889 0.010000 7.9916667 0.010000 7.9944444 0.010000 7.9972222 0.010000 8.0000000 0.010000 8.0027778 0.010000 8.0055556 0.010000 8.0083333 0.010000 8.0111111 0.010000 8.0138889 0.010000 8.0166667 0.010000 8.0194444 0.010000 8.0222222 0.010000 8.0250000 0.010000 8.0277778 0.010000 8.0305556 0.010000 8.7000000 0.010000 8.7027778 0.010000 8.7055556 0.010000 8.7083333 0.010000 8.7111111 0.010000 8.7138889 0.010000 8.7166667 0.010000 8.7194444 0.010000 8.7222222 0.010000 8.7250000 0.010000 8.7277778 0.010000 8.7305556 0.010000 8.7333333 0.010000 8.7361111 0.010000 8.7388889 0.010000 8.7416667 0.010000 8.7444444 0.010000 8.7472222 0.010000 8.7500000 0.010000 8.7527778 0.010000 8.7555556 0.010000 8.7583333 0.010000 8.7611111 0.010000 8.7638889 0.010000 8.7666667 0.010000 8.7694444 0.010000 8.7722222 0.010000 8.7750000 0.010000 8.7777778 0.010000 8.7805556 0.010000 8.7833333 0.010000 8.7861111 0.010000 8.7888889 0.010000 8.7916667 0.010000 8.7944444 0.010000 8.7972222 0.010000 8.8000000 0.010000 8.8027778 0.010000 8.8055556 0.010000 8.8083333 0.010000 8.8111111 0.010000 8.8138889 0.010000 8.8166667 0.010000 8.8194444 0.010000 8.8222222 0.010000 8.8250000 0.010000 8.8277778 0.010000 8.8305556 0.010000 8.8333333 0.010000 8.8361111 0.010000 8.8388889 0.010000 8.8416667 0.010000 8.8444444 0.010000 8.8472222 0.010000 8.8500000 0.010000 8.8527778 0.010000 8.8555556 0.010000 8.8583333 0.010000 8.8611111 0.010000 8.8638889 0.010000 8.8666667 0.010000 8.8694444 0.010000 8.8722222 0.010000 8.8750000 0.010000 8.8777778 0.010000 8.8805556 0.010000 8.8833333 0.010000 8.8861111 0.025000 8.8888889 0.056154 8.8916667 0.082115 8.8944444 0.101154 8.8972222 0.111538 8.9000000 0.108077 8.9027778 0.087308 8.9055556 0.047500 8.9083333 0.010000 8.9111111 0.010000 8.9138889 0.010000 8.9166667 0.010000 8.9194444 0.010000 8.9222222 0.064808 8.9250000 0.147885 8.9277778 0.236154 8.9305556 0.319231 8.9333333 0.398846 8.9361111 0.473269 8.9388889 0.539038 8.9416667 0.592692 8.9444444 0.630769 8.9472222 0.648077 8.9500000 0.644615 8.9527778 0.625577 8.9555556 0.590962 8.9583333 0.542500 8.9611111 0.476731 8.9638889 0.409231 8.9666667 0.340000 8.9694444 0.272500 8.9722222 0.201538 8.9750000 0.123654 8.9777778 0.054423 8.9805556 0.010000 8.9833333 0.010000 8.9861111 0.010000 8.9888889 0.010000 8.9916667 0.010000 8.9944444 0.010000 8.9972222 0.010000 9.0000000 0.010000 9.0027778 0.010000 9.0055556 0.010000 9.0083333 0.010000 9.0111111 0.010000 9.0138889 0.010000 9.0166667 0.010000 9.0194444 0.010000 9.0222222 0.010000 9.0250000 0.010000 9.0277778 0.010000 9.0305556 0.010000 9.0333333 0.010000 9.0361111 0.010000 9.0388889 0.010000 9.0416667 0.010000 9.0444444 0.010000 9.0472222 0.010000 9.0500000 0.010000 9.0527778 0.010000 9.0555556 0.010000 9.0583333 0.010000 9.0611111 0.010000 9.0638889 0.010000 9.0666667 0.010000 9.0694444 0.010000 9.0722222 0.010000 9.0750000 0.010000 9.0777778 0.010000 9.0805556 0.010000 9.0833333 0.010000 9.0861111 0.010000 9.0888889 0.010000 9.0916667 0.010000 9.0944444 0.010000 9.0972222 0.010000 9.1000000 0.010000 9.1027778 0.010000 9.1055556 0.010000 9.1083333 0.010000 9.1111111 0.010000 9.1138889 0.010000 9.1166667 0.010000 9.1194444 0.010000 9.1222222 0.010000 9.1250000 0.010000 9.1277778 0.010000 9.1305556 0.010000 9.1333333 0.010000 9.1361111 0.010000 9.1388889 0.010000 9.1416667 0.010000 9.1444444 0.010000 9.1472222 0.010000 9.1500000 0.010000 9.1527778 0.010000 9.1555556 0.010000 9.1583333 0.010000 9.1611111 0.010000 9.1638889 0.010000 9.1666667 0.010000 9.1694444 0.010000 9.1722222 0.010000 9.1750000 0.010000 9.1777778 0.010000 9.1805556 0.010000 9.1833333 0.010000 9.1861111 0.010000 9.1888889 0.010000 9.1916667 0.010000 9.1944444 0.010000 9.1972222 0.010000 9.2000000 0.010000 9.2027778 0.010000 9.2055556 0.010000 9.2083333 0.010000 9.2111111 0.010000 9.2138889 0.010000 9.2166667 0.010000 9.2194444 0.010000 9.2222222 0.010000 9.2250000 0.010000 9.2277778 0.010000 9.2305556 0.010000 9.2333333 0.010000 9.2361111 0.010000 9.2388889 0.010000 9.2416667 0.010000 9.2444444 0.010000 9.2472222 0.010000 9.8722222 0.010000 9.8750000 0.010000 9.8777778 0.010000 9.8805556 0.010000 9.8833333 0.010000 9.8861111 0.010000 9.8888889 0.010000 9.8916667 0.010000 9.8944444 0.010000 9.8972222 0.010000 9.9000000 0.010000 9.9027778 0.010000 9.9055556 0.010000 9.9083333 0.010000 9.9111111 0.010000 9.9138889 0.010000 9.9166667 0.010000 9.9194444 0.010000 9.9222222 0.010000 9.9250000 0.010000 9.9277778 0.010000 9.9305556 0.010000 9.9333333 0.010000 9.9361111 0.010000 9.9388889 0.010000 9.9416667 0.010000 9.9444444 0.010000 9.9472222 0.010000 9.9500000 0.010000 9.9527778 0.010000 9.9555556 0.010000 9.9583333 0.010000 9.9611111 0.010000 9.9638889 0.010000 9.9666667 0.010000 9.9694444 0.010000 9.9722222 0.010000 9.9750000 0.010000 9.9777778 0.010000 9.9805556 0.012885 9.9833333 0.012885 9.9861111 0.016346 9.9888889 0.010000 9.9916667 0.010000 9.9944444 0.010000 9.9972222 0.010000 10.0000000 0.010000 10.0027778 0.010000 10.0055556 0.010000 10.0083333 0.010000 10.0111111 0.010000 10.0138889 0.010000 10.0166667 0.010000 10.0194444 0.010000 10.0222222 0.010000 10.0250000 0.010000 10.0277778 0.010000 10.0305556 0.010000 10.0333333 0.010000 10.0361111 0.010000 10.0388889 0.010000 10.0416667 0.010000 10.0444444 0.010000 10.0472222 0.010000 10.0500000 0.010000 10.0527778 0.010000 10.0555556 0.010000 10.0583333 0.010000 10.0611111 0.025000 10.0638889 0.050962 10.0666667 0.080385 10.0694444 0.097692 10.0722222 0.111538 10.0750000 0.104615 10.0777778 0.080385 10.0805556 0.042308 10.0833333 0.010000 10.0861111 0.010000 10.0888889 0.010000 10.0916667 0.030192 10.0944444 0.101154 10.0972222 0.185962 10.1000000 0.279423 10.1027778 0.372885 10.1055556 0.457692 10.1083333 0.539038 10.1111111 0.610000 10.1138889 0.670577 10.1166667 0.713846 10.1194444 0.736346 10.1222222 0.741538 10.1250000 0.724231 10.1277778 0.694808 10.1305556 0.653269 10.1333333 0.597885 10.1361111 0.532115 10.1388889 0.461154 10.1416667 0.386731 10.1444444 0.312308 10.1472222 0.243077 10.1500000 0.163462 10.1527778 0.083846 10.1555556 0.010000 10.1583333 0.010000 10.1611111 0.010000 10.1638889 0.010000 10.1666667 0.010000 10.1694444 0.010000 10.1722222 0.010000 10.1750000 0.010000 10.1777778 0.010000 10.1805556 0.010000 10.1833333 0.010000 10.1861111 0.010000 10.1888889 0.010000 10.1916667 0.010000 10.1944444 0.010000 10.1972222 0.010000 10.2000000 0.010000 10.2027778 0.010000 10.2055556 0.010000 10.2083333 0.010000 10.2111111 0.010000 10.2138889 0.010000 10.2166667 0.010000 10.2194444 0.010000 10.2222222 0.010000 10.2250000 0.010000 10.2277778 0.010000 10.2305556 0.010000 10.2333333 0.010000 10.2361111 0.010000 10.2388889 0.010000 10.2416667 0.010000 10.2444444 0.010000 10.2472222 0.010000 10.2500000 0.010000 10.2527778 0.010000 10.2555556 0.010000 10.2583333 0.010000 10.2611111 0.010000 10.2638889 0.010000 10.2666667 0.010000 10.2694444 0.010000 10.2722222 0.010000 10.2750000 0.010000 10.2777778 0.010000 10.2805556 0.010000 10.2833333 0.010000 10.2861111 0.010000 10.2888889 0.010000 10.2916667 0.010000 10.2944444 0.010000 10.2972222 0.010000 10.3000000 0.010000 10.3027778 0.010000 10.3055556 0.010000 10.3083333 0.010000 10.3111111 0.010000 10.3138889 0.010000 10.3166667 0.010000 10.3194444 0.010000 10.3222222 0.010000 10.3250000 0.010000 10.3277778 0.010000 10.3305556 0.010000 10.3333333 0.010000 10.3361111 0.010000 10.3388889 0.010000 10.3416667 0.010000 10.3444444 0.010000 10.3472222 0.010000 10.3500000 0.010000 10.3527778 0.010000 10.3555556 0.010000 10.3583333 0.010000 10.3611111 0.010000 10.3638889 0.010000 10.3666667 0.010000 10.3694444 0.010000 10.3722222 0.010000 10.3750000 0.010000 10.3777778 0.010000 10.3805556 0.010000 10.3833333 0.010000 10.3861111 0.010000 10.3888889 0.010000 10.3916667 0.010000 10.3944444 0.010000 10.3972222 0.010000 10.4000000 0.010000 10.4027778 0.010000 10.4055556 0.010000 10.4083333 0.010000 10.4111111 0.010000 10.4138889 0.010000 10.4166667 0.010000 10.4194444 0.010000 11.0972222 0.010000 11.1000000 0.010000 11.1027778 0.010000 11.1055556 0.010000 11.1083333 0.010000 11.1111111 0.010000 11.1138889 0.010000 11.1166667 0.010000 11.1194444 0.010000 11.1222222 0.010000 11.1250000 0.010000 11.1277778 0.010000 11.1305556 0.010000 11.1333333 0.010000 11.1361111 0.010000 11.1388889 0.010000 11.1416667 0.010000 11.1444444 0.010000 11.1472222 0.010000 11.1500000 0.010000 11.1527778 0.010000 11.1555556 0.010000 11.1583333 0.010000 11.1611111 0.010000 11.1638889 0.010000 11.1666667 0.010000 11.1694444 0.010000 11.1722222 0.010000 11.1750000 0.010000 11.1777778 0.010000 11.1805556 0.010000 11.1833333 0.010000 11.1861111 0.010000 11.1888889 0.010000 11.1916667 0.010000 11.1944444 0.010000 11.1972222 0.010000 11.2000000 0.010000 11.2027778 0.010000 11.2055556 0.012885 11.2083333 0.012885 11.2111111 0.010000 11.2138889 0.010000 11.2166667 0.010000 11.2194444 0.010000 11.2222222 0.010000 11.2250000 0.010000 11.2277778 0.010000 11.2305556 0.010000 11.2333333 0.010000 11.2361111 0.010000 11.2388889 0.010000 11.2416667 0.010000 11.2444444 0.010000 11.2472222 0.010000 11.2500000 0.010000 11.2527778 0.010000 11.2555556 0.010000 11.2583333 0.010000 11.2611111 0.010000 11.2638889 0.010000 11.2666667 0.010000 11.2694444 0.010000 11.2722222 0.010000 11.2750000 0.010000 11.2777778 0.010000 11.2805556 0.010000 11.2833333 0.037115 11.2861111 0.070000 11.2888889 0.092500 11.2916667 0.109808 11.2944444 0.120192 11.2972222 0.116731 11.3000000 0.090769 11.3027778 0.047500 11.3055556 0.010000 11.3083333 0.010000 11.3111111 0.010000 11.3138889 0.010000 11.3166667 0.010000 11.3194444 0.080385 11.3222222 0.168654 11.3250000 0.250000 11.3277778 0.326154 11.3305556 0.395385 11.3333333 0.461154 11.3361111 0.525192 11.3388889 0.580577 11.3416667 0.622115 11.3444444 0.649808 11.3472222 0.660192 11.3500000 0.655000 11.3527778 0.637692 11.3555556 0.599615 11.3583333 0.544231 11.3611111 0.475000 11.3638889 0.400577 11.3666667 0.317500 11.3694444 0.227500 11.3722222 0.140962 11.3750000 0.047500 11.3777778 0.010000 11.3805556 0.010000 11.3833333 0.010000 11.3861111 0.010000 11.3888889 0.010000 11.3916667 0.010000 11.3944444 0.010000 11.3972222 0.010000 11.4000000 0.010000 11.4027778 0.010000 11.4055556 0.010000 11.4083333 0.010000 11.4111111 0.010000 11.4138889 0.010000 11.4166667 0.010000 11.4194444 0.010000 11.4222222 0.010000 11.4250000 0.010000 11.4277778 0.010000 11.4305556 0.010000 11.4333333 0.010000 11.4361111 0.010000 11.4388889 0.010000 11.4416667 0.010000 11.4444444 0.010000 11.4472222 0.010000 11.4500000 0.010000 11.4527778 0.010000 11.4555556 0.010000 11.4583333 0.010000 11.4611111 0.010000 11.4638889 0.010000 11.4666667 0.010000 11.4694444 0.010000 11.4722222 0.010000 11.4750000 0.010000 11.4777778 0.010000 11.4805556 0.010000 11.4833333 0.010000 11.4861111 0.010000 11.4888889 0.010000 11.4916667 0.010000 11.4944444 0.010000 11.4972222 0.010000 11.5000000 0.010000 11.5027778 0.010000 11.5055556 0.010000 11.5083333 0.010000 11.5111111 0.010000 11.5138889 0.010000 11.5166667 0.010000 11.5194444 0.010000 11.5222222 0.010000 11.5250000 0.010000 11.5277778 0.010000 11.5305556 0.010000 11.5333333 0.010000 11.5361111 0.010000 11.5388889 0.010000 11.5416667 0.010000 11.5444444 0.010000 11.5472222 0.010000 11.5500000 0.010000 11.5527778 0.010000 11.5555556 0.010000 11.5583333 0.010000 11.5611111 0.010000 11.5638889 0.010000 11.5666667 0.010000 11.5694444 0.010000 11.5722222 0.010000 11.5750000 0.010000 11.5777778 0.010000 11.5805556 0.010000 11.5833333 0.010000 11.5861111 0.010000 11.5888889 0.010000 11.5916667 0.010000 11.5944444 0.010000 11.5972222 0.010000 11.6000000 0.010000 11.6027778 0.010000 11.6055556 0.010000 11.6083333 0.010000 11.6111111 0.010000 11.6138889 0.010000 11.6166667 0.010000 11.6194444 0.010000 11.6222222 0.010000 11.6250000 0.010000 11.6277778 0.010000 11.6305556 0.010000 11.6333333 0.010000 11.6361111 0.010000 11.6388889 0.010000 11.6416667 0.010000 11.6444444 0.010000 12.2666667 0.010000 12.2694444 0.010000 12.2722222 0.010000 12.2750000 0.010000 12.2777778 0.010000 12.2805556 0.010000 12.2833333 0.010000 12.2861111 0.010000 12.2888889 0.010000 12.2916667 0.010000 12.2944444 0.010000 12.2972222 0.010000 12.3000000 0.010000 12.3027778 0.010000 12.3055556 0.010000 12.3083333 0.010000 12.3111111 0.010000 12.3138889 0.010000 12.3166667 0.010000 12.3194444 0.010000 12.3222222 0.010000 12.3250000 0.010000 12.3277778 0.010000 12.3305556 0.010000 12.3333333 0.010000 12.3361111 0.010000 12.3388889 0.010000 12.3416667 0.010000 12.3444444 0.010000 12.3472222 0.010000 12.3500000 0.010000 12.3527778 0.010000 12.3555556 0.010000 12.3583333 0.010000 12.3611111 0.010000 12.3638889 0.010000 12.3666667 0.010000 12.3694444 0.010000 12.3722222 0.010000 12.3750000 0.010000 12.3777778 0.010000 12.3805556 0.010000 12.3833333 0.010000 12.3861111 0.010000 12.3888889 0.010000 12.3916667 0.010000 12.3944444 0.010000 12.3972222 0.010000 12.4000000 0.010000 12.4027778 0.010000 12.4055556 0.010000 12.4083333 0.010000 12.4111111 0.010000 12.4138889 0.010000 12.4166667 0.010000 12.4194444 0.010000 12.4222222 0.010000 12.4250000 0.010000 12.4277778 0.010000 12.4305556 0.010000 12.4333333 0.010000 12.4361111 0.010000 12.4388889 0.010000 12.4416667 0.010000 12.4444444 0.010000 12.4472222 0.010000 12.4500000 0.010000 12.4527778 0.010000 12.4555556 0.025000 12.4583333 0.052692 12.4611111 0.078654 12.4638889 0.094231 12.4666667 0.095962 12.4694444 0.080385 12.4722222 0.045769 12.4750000 0.010000 12.4777778 0.010000 12.4805556 0.010000 12.4833333 0.010000 12.4861111 0.030192 12.4888889 0.109808 12.4916667 0.198077 12.4944444 0.284615 12.4972222 0.372885 12.5000000 0.452500 12.5027778 0.526923 12.5055556 0.596154 12.5083333 0.653269 12.5111111 0.698269 12.5138889 0.725962 12.5166667 0.732885 12.5194444 0.719038 12.5222222 0.686154 12.5250000 0.639423 12.5277778 0.575385 12.5305556 0.495769 12.5333333 0.414423 12.5361111 0.336538 12.5388889 0.262115 12.5416667 0.189423 12.5444444 0.120192 12.5472222 0.052692 12.5500000 0.010000 12.5527778 0.010000 12.5555556 0.010000 12.5583333 0.010000 12.5611111 0.010000 12.5638889 0.010000 12.5666667 0.010000 12.5694444 0.010000 12.5722222 0.010000 12.5750000 0.010000 12.5777778 0.010000 12.5805556 0.010000 12.5833333 0.010000 12.5861111 0.010000 12.5888889 0.010000 12.5916667 0.010000 12.5944444 0.010000 12.5972222 0.010000 12.6000000 0.010000 12.6027778 0.010000 12.6055556 0.010000 12.6083333 0.010000 12.6111111 0.010000 12.6138889 0.010000 12.6166667 0.010000 12.6194444 0.010000 12.6222222 0.010000 12.6250000 0.010000 12.6277778 0.010000 12.6305556 0.010000 12.6333333 0.010000 12.6361111 0.010000 12.6388889 0.010000 12.6416667 0.010000 12.6444444 0.010000 12.6472222 0.010000 12.6500000 0.010000 12.6527778 0.010000 12.6555556 0.010000 12.6583333 0.010000 12.6611111 0.010000 12.6638889 0.010000 12.6666667 0.010000 12.6694444 0.010000 12.6722222 0.010000 12.6750000 0.010000 12.6777778 0.010000 12.6805556 0.010000 12.6833333 0.010000 12.6861111 0.010000 12.6888889 0.010000 12.6916667 0.010000 12.6944444 0.010000 12.6972222 0.010000 12.7000000 0.010000 12.7027778 0.010000 12.7055556 0.010000 12.7083333 0.010000 12.7111111 0.010000 12.7138889 0.010000 12.7166667 0.010000 12.7194444 0.010000 12.7222222 0.010000 12.7250000 0.010000 12.7277778 0.010000 12.7305556 0.010000 12.7333333 0.010000 12.7361111 0.010000 12.7388889 0.010000 12.7416667 0.010000 12.7444444 0.010000 12.7472222 0.010000 12.7500000 0.010000 12.7527778 0.010000 12.7555556 0.010000 12.7583333 0.010000 12.7611111 0.010000 12.7638889 0.010000 12.7666667 0.010000 12.7694444 0.010000 12.7722222 0.010000 12.7750000 0.010000 12.7777778 0.010000 12.7805556 0.010000 12.7833333 0.010000 12.7861111 0.010000 12.7888889 0.010000 12.7916667 0.010000 12.7944444 0.010000 12.7972222 0.010000 12.8000000 0.010000 12.8027778 0.010000 12.8055556 0.010000 12.8083333 0.010000 12.8111111 0.010000 12.8138889 0.010000 13.5138889 0.010000 13.5166667 0.010000 13.5194444 0.010000 13.5222222 0.010000 13.5250000 0.010000 13.5277778 0.010000 13.5305556 0.010000 13.5333333 0.010000 13.5361111 0.010000 13.5388889 0.010000 13.5416667 0.010000 13.5444444 0.010000 13.5472222 0.010000 13.5500000 0.010000 13.5527778 0.010000 13.5555556 0.010000 13.5583333 0.010000 13.5611111 0.010000 13.5638889 0.010000 13.5666667 0.010000 13.5694444 0.010000 13.5722222 0.010000 13.5750000 0.010000 13.5777778 0.010000 13.5805556 0.010000 13.5833333 0.010000 13.5861111 0.010000 13.5888889 0.010000 13.5916667 0.010000 13.5944444 0.010000 13.5972222 0.010000 13.6000000 0.010000 13.6027778 0.010000 13.6055556 0.010000 13.6083333 0.010000 13.6111111 0.010000 13.6138889 0.010000 13.6166667 0.010000 13.6194444 0.010000 13.6222222 0.010000 13.6250000 0.010000 13.6277778 0.010000 13.6305556 0.010000 13.6333333 0.010000 13.6361111 0.010000 13.6388889 0.010000 13.6416667 0.010000 13.6444444 0.010000 13.6472222 0.010000 13.6500000 0.010000 13.6527778 0.010000 13.6555556 0.010000 13.6583333 0.010000 13.6611111 0.010000 13.6638889 0.010000 13.6666667 0.010000 13.6694444 0.010000 13.6722222 0.010000 13.6750000 0.010000 13.6777778 0.010000 13.6805556 0.010000 13.6833333 0.010000 13.6861111 0.010000 13.6888889 0.010000 13.6916667 0.010000 13.6944444 0.021538 13.6972222 0.047500 13.7000000 0.068269 13.7027778 0.083846 13.7055556 0.092500 13.7083333 0.095962 13.7111111 0.085577 13.7138889 0.052692 13.7166667 0.010000 13.7194444 0.010000 13.7222222 0.010000 13.7250000 0.010000 13.7277778 0.010000 13.7305556 0.010000 13.7333333 0.080385 13.7361111 0.168654 13.7388889 0.253462 13.7416667 0.340000 13.7444444 0.417885 13.7472222 0.494038 13.7500000 0.566731 13.7527778 0.622115 13.7555556 0.663654 13.7583333 0.687885 13.7611111 0.694808 13.7638889 0.684423 13.7666667 0.661923 13.7694444 0.630769 13.7722222 0.582308 13.7750000 0.523462 13.7777778 0.459423 13.7805556 0.395385 13.7833333 0.329615 13.7861111 0.255192 13.7888889 0.179038 13.7916667 0.095962 13.7944444 0.018077 13.7972222 0.010000 13.8000000 0.010000 13.8027778 0.010000 13.8055556 0.010000 13.8083333 0.010000 13.8111111 0.010000 13.8138889 0.010000 13.8166667 0.010000 13.8194444 0.010000 13.8222222 0.010000 13.8250000 0.010000 13.8277778 0.010000 13.8305556 0.010000 13.8333333 0.010000 13.8361111 0.010000 13.8388889 0.010000 13.8416667 0.010000 13.8444444 0.010000 13.8472222 0.010000 13.8500000 0.010000 13.8527778 0.010000 13.8555556 0.010000 13.8583333 0.010000 13.8611111 0.010000 13.8638889 0.010000 13.8666667 0.010000 13.8694444 0.010000 13.8722222 0.010000 13.8750000 0.010000 13.8777778 0.010000 13.8805556 0.010000 13.8833333 0.010000 13.8861111 0.010000 13.8888889 0.010000 13.8916667 0.010000 13.8944444 0.010000 13.8972222 0.010000 13.9000000 0.010000 13.9027778 0.010000 13.9055556 0.010000 13.9083333 0.010000 13.9111111 0.010000 13.9138889 0.010000 13.9166667 0.010000 13.9194444 0.010000 13.9222222 0.010000 13.9250000 0.010000 13.9277778 0.010000 13.9305556 0.010000 13.9333333 0.010000 13.9361111 0.010000 13.9388889 0.010000 13.9416667 0.010000 13.9444444 0.010000 13.9472222 0.010000 13.9500000 0.010000 13.9527778 0.010000 13.9555556 0.010000 13.9583333 0.010000 13.9611111 0.010000 13.9638889 0.010000 13.9666667 0.010000 13.9694444 0.010000 13.9722222 0.010000 13.9750000 0.010000 13.9777778 0.010000 13.9805556 0.010000 13.9833333 0.010000 13.9861111 0.010000 13.9888889 0.010000 13.9916667 0.010000 13.9944444 0.010000 13.9972222 0.010000 14.0000000 0.010000 14.0027778 0.010000 14.0055556 0.010000 14.0083333 0.010000 14.0111111 0.010000 14.0138889 0.010000 14.0166667 0.010000 14.0194444 0.010000 14.0222222 0.010000 14.0250000 0.010000 14.0277778 0.010000 14.0305556 0.010000 14.0333333 0.010000 14.0361111 0.010000 14.0388889 0.010000 14.0416667 0.010000 14.0444444 0.010000 14.0472222 0.010000 14.0500000 0.010000 14.0527778 0.010000 14.0555556 0.010000 14.0583333 0.010000 14.0611111 0.010000 14.7055556 0.010000 14.7083333 0.010000 14.7111111 0.010000 14.7138889 0.010000 14.7166667 0.010000 14.7194444 0.010000 14.7222222 0.010000 14.7250000 0.010000 14.7277778 0.010000 14.7305556 0.010000 14.7333333 0.010000 14.7361111 0.010000 14.7388889 0.010000 14.7416667 0.010000 14.7444444 0.010000 14.7472222 0.010000 14.7500000 0.010000 14.7527778 0.010000 14.7555556 0.010000 14.7583333 0.010000 14.7611111 0.010000 14.7638889 0.010000 14.7666667 0.010000 14.7694444 0.010000 14.7722222 0.010000 14.7750000 0.010000 14.7777778 0.010000 14.7805556 0.010000 14.7833333 0.010000 14.7861111 0.010000 14.7888889 0.010000 14.7916667 0.010000 14.7944444 0.010000 14.7972222 0.010000 14.8000000 0.010000 14.8027778 0.010000 14.8055556 0.010000 14.8083333 0.010000 14.8111111 0.010000 14.8138889 0.010000 14.8166667 0.010000 14.8194444 0.010000 14.8222222 0.010000 14.8250000 0.010000 14.8277778 0.010000 14.8305556 0.010000 14.8333333 0.010000 14.8361111 0.010000 14.8388889 0.010000 14.8416667 0.010000 14.8444444 0.010000 14.8472222 0.010000 14.8500000 0.010000 14.8527778 0.010000 14.8555556 0.010000 14.8583333 0.010000 14.8611111 0.010000 14.8638889 0.010000 14.8666667 0.010000 14.8694444 0.010000 14.8722222 0.010000 14.8750000 0.010000 14.8777778 0.010000 14.8805556 0.010000 14.8833333 0.010000 14.8861111 0.010000 14.8888889 0.010000 14.8916667 0.010000 14.8944444 0.010000 14.8972222 0.010000 14.9000000 0.018077 14.9027778 0.047500 14.9055556 0.075192 14.9083333 0.092500 14.9111111 0.092500 14.9138889 0.057885 14.9166667 0.010000 14.9194444 0.010000 14.9222222 0.010000 14.9250000 0.010000 14.9277778 0.010000 14.9305556 0.038846 14.9333333 0.134038 14.9361111 0.236154 14.9388889 0.338269 14.9416667 0.435192 14.9444444 0.518269 14.9472222 0.589231 14.9500000 0.644615 14.9527778 0.675769 14.9555556 0.682692 14.9583333 0.665385 14.9611111 0.634231 14.9638889 0.580577 14.9666667 0.507885 14.9694444 0.423077 14.9722222 0.327885 14.9750000 0.241346 14.9777778 0.156538 14.9805556 0.073462 14.9833333 0.010000 14.9861111 0.010000 14.9888889 0.010000 14.9916667 0.010000 14.9944444 0.010000 14.9972222 0.010000 15.0000000 0.010000 15.0027778 0.010000 15.0055556 0.010000 15.0083333 0.010000 15.0111111 0.010000 15.0138889 0.010000 15.0166667 0.010000 15.0194444 0.010000 15.0222222 0.010000 15.0250000 0.010000 15.0277778 0.010000 15.0305556 0.010000 15.0333333 0.010000 15.0361111 0.010000 15.0388889 0.010000 15.0416667 0.010000 15.0444444 0.010000 15.0472222 0.010000 15.0500000 0.010000 15.0527778 0.010000 15.0555556 0.010000 15.0583333 0.010000 15.0611111 0.010000 15.0638889 0.010000 15.0666667 0.010000 15.0694444 0.010000 15.0722222 0.010000 15.0750000 0.010000 15.0777778 0.010000 15.0805556 0.010000 15.0833333 0.010000 15.0861111 0.010000 15.0888889 0.010000 15.0916667 0.010000 15.0944444 0.010000 15.0972222 0.010000 15.1000000 0.010000 15.1027778 0.010000 15.1055556 0.010000 15.1083333 0.010000 15.1111111 0.010000 15.1138889 0.010000 15.1166667 0.010000 15.1194444 0.010000 15.1222222 0.010000 15.1250000 0.010000 15.1277778 0.010000 15.1305556 0.010000 15.1333333 0.010000 15.1361111 0.010000 15.1388889 0.010000 15.1416667 0.010000 15.1444444 0.010000 15.1472222 0.010000 15.1500000 0.010000 15.1527778 0.010000 15.1555556 0.010000 15.1583333 0.010000 15.1611111 0.010000 15.1638889 0.010000 15.1666667 0.010000 15.1694444 0.010000 15.1722222 0.010000 15.1750000 0.010000 15.1777778 0.010000 15.1805556 0.010000 15.1833333 0.010000 15.1861111 0.010000 15.1888889 0.010000 15.1916667 0.010000 15.1944444 0.010000 15.1972222 0.010000 15.2000000 0.010000 15.2027778 0.010000 15.2055556 0.010000 15.2083333 0.010000 15.2111111 0.010000 15.2138889 0.010000 15.2166667 0.010000 15.2194444 0.010000 15.2222222 0.010000 15.2250000 0.010000 15.2277778 0.010000 15.2305556 0.010000 15.2333333 0.010000 15.2361111 0.010000 15.2388889 0.010000 15.2416667 0.010000 15.2444444 0.010000 15.2472222 0.010000 15.2500000 0.010000 15.2527778 0.010000 15.9388889 0.010000 15.9416667 0.010000 15.9444444 0.010000 15.9472222 0.010000 15.9500000 0.010000 15.9527778 0.010000 15.9555556 0.010000 15.9583333 0.010000 15.9611111 0.010000 15.9638889 0.010000 15.9666667 0.010000 15.9694444 0.010000 15.9722222 0.010000 15.9750000 0.010000 15.9777778 0.010000 15.9805556 0.010000 15.9833333 0.010000 15.9861111 0.010000 15.9888889 0.010000 15.9916667 0.010000 15.9944444 0.010000 15.9972222 0.010000 16.0000000 0.010000 16.0027778 0.010000 16.0055556 0.010000 16.0083333 0.010000 16.0111111 0.010000 16.0138889 0.010000 16.0166667 0.010000 16.0194444 0.010000 16.0222222 0.010000 16.0250000 0.010000 16.0277778 0.010000 16.0305556 0.010000 16.0333333 0.010000 16.0361111 0.010000 16.0388889 0.010000 16.0416667 0.010000 16.0444444 0.010000 16.0472222 0.010000 16.0500000 0.010000 16.0527778 0.010000 16.0555556 0.010000 16.0583333 0.010000 16.0611111 0.010000 16.0638889 0.010000 16.0666667 0.010000 16.0694444 0.010000 16.0722222 0.010000 16.0750000 0.010000 16.0777778 0.010000 16.0805556 0.010000 16.0833333 0.010000 16.0861111 0.010000 16.0888889 0.010000 16.0916667 0.010000 16.0944444 0.010000 16.0972222 0.010000 16.1000000 0.010000 16.1027778 0.010000 16.1055556 0.010000 16.1083333 0.010000 16.1111111 0.010000 16.1138889 0.010000 16.1166667 0.010000 16.1194444 0.010000 16.1222222 0.012885 16.1250000 0.042308 16.1277778 0.064808 16.1305556 0.080385 16.1333333 0.085577 16.1361111 0.085577 16.1388889 0.073462 16.1416667 0.037115 16.1444444 0.010000 16.1472222 0.010000 16.1500000 0.010000 16.1527778 0.010000 16.1555556 0.010000 16.1583333 0.061346 16.1611111 0.151346 16.1638889 0.241346 16.1666667 0.329615 16.1694444 0.409231 16.1722222 0.488846 16.1750000 0.565000 16.1777778 0.629038 16.1805556 0.684423 16.1833333 0.715577 16.1861111 0.727692 16.1888889 0.719038 16.1916667 0.691346 16.1944444 0.649808 16.1972222 0.592692 16.2000000 0.521731 16.2027778 0.443846 16.2055556 0.364231 16.2083333 0.288077 16.2111111 0.215385 16.2138889 0.139231 16.2166667 0.063077 16.2194444 0.010000 16.2222222 0.010000 16.2250000 0.010000 16.2277778 0.010000 16.2305556 0.010000 16.2333333 0.010000 16.2361111 0.010000 16.2388889 0.010000 16.2416667 0.010000 16.2444444 0.010000 16.2472222 0.010000 16.2500000 0.010000 16.2527778 0.010000 16.2555556 0.010000 16.2583333 0.010000 16.2611111 0.010000 16.2638889 0.010000 16.2666667 0.010000 16.2694444 0.010000 16.2722222 0.010000 16.2750000 0.010000 16.2777778 0.010000 16.2805556 0.010000 16.2833333 0.010000 16.2861111 0.010000 16.2888889 0.010000 16.2916667 0.010000 16.2944444 0.010000 16.2972222 0.010000 16.3000000 0.010000 16.3027778 0.010000 16.3055556 0.010000 16.3083333 0.010000 16.3111111 0.010000 16.3138889 0.010000 16.3166667 0.010000 16.3194444 0.010000 16.3222222 0.010000 16.3250000 0.010000 16.3277778 0.010000 16.3305556 0.010000 16.3333333 0.010000 16.3361111 0.010000 16.3388889 0.010000 16.3416667 0.010000 16.3444444 0.010000 16.3472222 0.010000 16.3500000 0.010000 16.3527778 0.010000 16.3555556 0.010000 16.3583333 0.010000 16.3611111 0.010000 16.3638889 0.010000 16.3666667 0.010000 16.3694444 0.010000 16.3722222 0.010000 16.3750000 0.010000 16.3777778 0.010000 16.3805556 0.010000 16.3833333 0.010000 16.3861111 0.010000 16.3888889 0.010000 16.3916667 0.010000 16.3944444 0.010000 16.3972222 0.010000 16.4000000 0.010000 16.4027778 0.010000 16.4055556 0.010000 16.4083333 0.010000 16.4111111 0.010000 16.4138889 0.010000 16.4166667 0.010000 16.4194444 0.010000 16.4222222 0.010000 16.4250000 0.010000 16.4277778 0.010000 16.4305556 0.010000 16.4333333 0.010000 16.4361111 0.010000 16.4388889 0.010000 16.4416667 0.010000 16.4444444 0.010000 16.4472222 0.010000 16.4500000 0.010000 16.4527778 0.010000 16.4555556 0.010000 16.4583333 0.010000 16.4611111 0.010000 16.4638889 0.010000 16.4666667 0.010000 16.4694444 0.010000 16.4722222 0.010000 16.4750000 0.010000 16.4777778 0.010000 16.4805556 0.010000 16.4833333 0.010000 16.4861111 0.010000 17.1416667 0.010000 17.1444444 0.010000 17.1472222 0.010000 17.1500000 0.010000 17.1527778 0.010000 17.1555556 0.010000 17.1583333 0.010000 17.1611111 0.010000 17.1638889 0.010000 17.1666667 0.010000 17.1694444 0.010000 17.1722222 0.010000 17.1750000 0.010000 17.1777778 0.010000 17.1805556 0.010000 17.1833333 0.010000 17.1861111 0.010000 17.1888889 0.010000 17.1916667 0.010000 17.1944444 0.010000 17.1972222 0.010000 17.2000000 0.010000 17.2027778 0.010000 17.2055556 0.010000 17.2083333 0.010000 17.2111111 0.010000 17.2138889 0.010000 17.2166667 0.010000 17.2194444 0.010000 17.2222222 0.010000 17.2250000 0.010000 17.2277778 0.010000 17.2305556 0.010000 17.2333333 0.010000 17.2361111 0.010000 17.2388889 0.010000 17.2416667 0.010000 17.2444444 0.010000 17.2472222 0.010000 17.2500000 0.010000 17.2527778 0.010000 17.2555556 0.010000 17.2583333 0.010000 17.2611111 0.010000 17.2638889 0.010000 17.2666667 0.010000 17.2694444 0.010000 17.2722222 0.010000 17.2750000 0.010000 17.2777778 0.010000 17.2805556 0.010000 17.2833333 0.010000 17.2861111 0.010000 17.2888889 0.010000 17.2916667 0.010000 17.2944444 0.010000 17.2972222 0.010000 17.3000000 0.010000 17.3027778 0.010000 17.3055556 0.010000 17.3083333 0.010000 17.3111111 0.010000 17.3138889 0.010000 17.3166667 0.010000 17.3194444 0.010000 17.3222222 0.010000 17.3250000 0.011154 17.3277778 0.037115 17.3305556 0.063077 17.3333333 0.083846 17.3361111 0.094231 17.3388889 0.092500 17.3416667 0.070000 17.3444444 0.023269 17.3472222 0.010000 17.3500000 0.010000 17.3527778 0.010000 17.3555556 0.010000 17.3583333 0.010000 17.3611111 0.040577 17.3638889 0.123654 17.3666667 0.206731 17.3694444 0.282885 17.3722222 0.355577 17.3750000 0.426538 17.3777778 0.499231 17.3805556 0.565000 17.3833333 0.623846 17.3861111 0.656731 17.3888889 0.672308 17.3916667 0.672308 17.3944444 0.649808 17.3972222 0.615192 17.4000000 0.565000 17.4027778 0.499231 17.4055556 0.430000 17.4083333 0.355577 17.4111111 0.281154 17.4138889 0.210192 17.4166667 0.135769 17.4194444 0.066538 17.4222222 0.010000 17.4250000 0.010000 17.4277778 0.010000 17.4305556 0.010000 17.4333333 0.010000 17.4361111 0.010000 17.4388889 0.010000 17.4416667 0.010000 17.4444444 0.010000 17.4472222 0.010000 17.4500000 0.010000 17.4527778 0.010000 17.4555556 0.010000 17.4583333 0.010000 17.4611111 0.010000 17.4638889 0.010000 17.4666667 0.010000 17.4694444 0.010000 17.4722222 0.010000 17.4750000 0.010000 17.4777778 0.010000 17.4805556 0.010000 17.4833333 0.010000 17.4861111 0.010000 17.4888889 0.010000 17.4916667 0.010000 17.4944444 0.010000 17.4972222 0.010000 17.5000000 0.010000 17.5027778 0.010000 17.5055556 0.010000 17.5083333 0.010000 17.5111111 0.010000 17.5138889 0.010000 17.5166667 0.010000 17.5194444 0.010000 17.5222222 0.010000 17.5250000 0.010000 17.5277778 0.010000 17.5305556 0.010000 17.5333333 0.010000 17.5361111 0.010000 17.5388889 0.010000 17.5416667 0.010000 17.5444444 0.010000 17.5472222 0.010000 17.5500000 0.010000 17.5527778 0.010000 17.5555556 0.010000 17.5583333 0.010000 17.5611111 0.010000 17.5638889 0.010000 17.5666667 0.010000 17.5694444 0.010000 17.5722222 0.010000 17.5750000 0.010000 17.5777778 0.010000 17.5805556 0.010000 17.5833333 0.010000 17.5861111 0.010000 17.5888889 0.010000 17.5916667 0.010000 17.5944444 0.010000 17.5972222 0.010000 17.6000000 0.010000 17.6027778 0.010000 17.6055556 0.010000 17.6083333 0.010000 17.6111111 0.010000 17.6138889 0.010000 17.6166667 0.010000 17.6194444 0.010000 17.6222222 0.010000 17.6250000 0.010000 17.6277778 0.010000 17.6305556 0.010000 17.6333333 0.010000 17.6361111 0.010000 17.6388889 0.010000 17.6416667 0.010000 17.6444444 0.010000 17.6472222 0.010000 17.6500000 0.010000 17.6527778 0.010000 17.6555556 0.010000 17.6583333 0.010000 17.6611111 0.010000 17.6638889 0.010000 17.6666667 0.010000 17.6694444 0.010000 17.6722222 0.010000 17.6750000 0.010000 17.6777778 0.010000 17.6805556 0.010000 17.6833333 0.010000 17.6861111 0.010000 17.6888889 0.010000 18.3611111 0.010000 18.3638889 0.010000 18.3666667 0.010000 18.3694444 0.010000 18.3722222 0.010000 18.3750000 0.010000 18.3777778 0.010000 18.3805556 0.010000 18.3833333 0.010000 18.3861111 0.010000 18.3888889 0.010000 18.3916667 0.010000 18.3944444 0.010000 18.3972222 0.010000 18.4000000 0.010000 18.4027778 0.010000 18.4055556 0.010000 18.4083333 0.010000 18.4111111 0.010000 18.4138889 0.010000 18.4166667 0.010000 18.4194444 0.010000 18.4222222 0.010000 18.4250000 0.010000 18.4277778 0.010000 18.4305556 0.010000 18.4333333 0.010000 18.4361111 0.010000 18.4388889 0.010000 18.4416667 0.010000 18.4444444 0.010000 18.4472222 0.010000 18.4500000 0.010000 18.4527778 0.010000 18.4555556 0.010000 18.4583333 0.010000 18.4611111 0.010000 18.4638889 0.010000 18.4666667 0.010000 18.4694444 0.010000 18.4722222 0.010000 18.4750000 0.010000 18.4777778 0.010000 18.4805556 0.010000 18.4833333 0.010000 18.4861111 0.010000 18.4888889 0.010000 18.4916667 0.010000 18.4944444 0.010000 18.4972222 0.010000 18.5000000 0.010000 18.5027778 0.010000 18.5055556 0.010000 18.5083333 0.010000 18.5111111 0.010000 18.5138889 0.010000 18.5166667 0.010000 18.5194444 0.010000 18.5222222 0.010000 18.5250000 0.010000 18.5277778 0.010000 18.5305556 0.010000 18.5333333 0.010000 18.5361111 0.010000 18.5388889 0.010000 18.5416667 0.010000 18.5444444 0.010000 18.5472222 0.010000 18.5500000 0.010000 18.5527778 0.033654 18.5555556 0.059615 18.5583333 0.075192 18.5611111 0.083846 18.5638889 0.070000 18.5666667 0.033654 18.5694444 0.010000 18.5722222 0.010000 18.5750000 0.010000 18.5777778 0.010000 18.5805556 0.010000 18.5833333 0.044038 18.5861111 0.137500 18.5888889 0.232692 18.5916667 0.331346 18.5944444 0.421346 18.5972222 0.506154 18.6000000 0.584038 18.6027778 0.644615 18.6055556 0.689615 18.6083333 0.717308 18.6111111 0.719038 18.6138889 0.706923 18.6166667 0.677500 18.6194444 0.627308 18.6222222 0.559808 18.6250000 0.478462 18.6277778 0.397115 18.6305556 0.314038 18.6333333 0.222308 18.6361111 0.139231 18.6388889 0.056154 18.6416667 0.010000 18.6444444 0.010000 18.6472222 0.010000 18.6500000 0.010000 18.6527778 0.010000 18.6555556 0.010000 18.6583333 0.010000 18.6611111 0.010000 18.6638889 0.010000 18.6666667 0.010000 18.6694444 0.010000 18.6722222 0.010000 18.6750000 0.010000 18.6777778 0.010000 18.6805556 0.010000 18.6833333 0.010000 18.6861111 0.010000 18.6888889 0.010000 18.6916667 0.010000 18.6944444 0.010000 18.6972222 0.010000 18.7000000 0.010000 18.7027778 0.010000 18.7055556 0.010000 18.7083333 0.010000 18.7111111 0.010000 18.7138889 0.010000 18.7166667 0.010000 18.7194444 0.010000 18.7222222 0.010000 18.7250000 0.010000 18.7277778 0.010000 18.7305556 0.010000 18.7333333 0.010000 18.7361111 0.010000 18.7388889 0.010000 18.7416667 0.010000 18.7444444 0.010000 18.7472222 0.010000 18.7500000 0.010000 18.7527778 0.010000 18.7555556 0.010000 18.7583333 0.010000 18.7611111 0.010000 18.7638889 0.010000 18.7666667 0.010000 18.7694444 0.010000 18.7722222 0.010000 18.7750000 0.010000 18.7777778 0.010000 18.7805556 0.010000 18.7833333 0.010000 18.7861111 0.010000 18.7888889 0.010000 18.7916667 0.010000 18.7944444 0.010000 18.7972222 0.010000 18.8000000 0.010000 18.8027778 0.010000 18.8055556 0.010000 18.8083333 0.010000 18.8111111 0.010000 18.8138889 0.010000 18.8166667 0.010000 18.8194444 0.010000 18.8222222 0.010000 18.8250000 0.010000 18.8277778 0.010000 18.8305556 0.010000 18.8333333 0.010000 18.8361111 0.010000 18.8388889 0.010000 18.8416667 0.010000 18.8444444 0.010000 18.8472222 0.010000 18.8500000 0.010000 18.8527778 0.010000 18.8555556 0.010000 18.8583333 0.010000 18.8611111 0.010000 18.8638889 0.010000 18.8666667 0.010000 18.8694444 0.010000 18.8722222 0.010000 18.8750000 0.010000 18.8777778 0.010000 18.8805556 0.010000 18.8833333 0.010000 18.8861111 0.010000 18.8888889 0.010000 18.8916667 0.010000 18.8944444 0.010000 18.8972222 0.010000 18.9000000 0.010000 18.9027778 0.010000 18.9055556 0.010000 18.9083333 0.010000 19.5500000 0.010000 19.5527778 0.010000 19.5555556 0.010000 19.5583333 0.010000 19.5611111 0.010000 19.5638889 0.010000 19.5666667 0.010000 19.5694444 0.010000 19.5722222 0.010000 19.5750000 0.010000 19.5777778 0.010000 19.5805556 0.010000 19.5833333 0.010000 19.5861111 0.010000 19.5888889 0.010000 19.5916667 0.010000 19.5944444 0.010000 19.5972222 0.010000 19.6000000 0.010000 19.6027778 0.010000 19.6055556 0.010000 19.6083333 0.010000 19.6111111 0.010000 19.6138889 0.010000 19.6166667 0.010000 19.6194444 0.010000 19.6222222 0.010000 19.6250000 0.010000 19.6277778 0.010000 19.6305556 0.010000 19.6333333 0.010000 19.6361111 0.010000 19.6388889 0.010000 19.6416667 0.010000 19.6444444 0.010000 19.6472222 0.010000 19.6500000 0.010000 19.6527778 0.010000 19.6555556 0.010000 19.6583333 0.010000 19.6611111 0.010000 19.6638889 0.010000 19.6666667 0.010000 19.6694444 0.010000 19.6722222 0.010000 19.6750000 0.010000 19.6777778 0.010000 19.6805556 0.010000 19.6833333 0.010000 19.6861111 0.010000 19.6888889 0.010000 19.6916667 0.010000 19.6944444 0.010000 19.6972222 0.010000 19.7000000 0.010000 19.7027778 0.010000 19.7055556 0.010000 19.7083333 0.010000 19.7111111 0.010000 19.7138889 0.010000 19.7166667 0.010000 19.7194444 0.010000 19.7222222 0.010000 19.7250000 0.010000 19.7277778 0.010000 19.7305556 0.010000 19.7333333 0.010000 19.7361111 0.010000 19.7388889 0.010000 19.7416667 0.021538 19.7444444 0.052692 19.7472222 0.078654 19.7500000 0.087308 19.7527778 0.073462 19.7555556 0.031923 19.7583333 0.010000 19.7611111 0.010000 19.7638889 0.010000 19.7666667 0.010000 19.7694444 0.010000 19.7722222 0.010000 19.7750000 0.104615 19.7777778 0.215385 19.7805556 0.317500 19.7833333 0.410962 19.7861111 0.495769 19.7888889 0.563269 19.7916667 0.618654 19.7944444 0.646346 19.7972222 0.661923 19.8000000 0.651538 19.8027778 0.627308 19.8055556 0.589231 19.8083333 0.539038 19.8111111 0.476731 19.8138889 0.400577 19.8166667 0.331346 19.8194444 0.265577 19.8222222 0.191154 19.8250000 0.116731 19.8277778 0.040577 19.8305556 0.010000 19.8333333 0.010000 19.8361111 0.010000 19.8388889 0.010000 19.8416667 0.010000 19.8444444 0.010000 19.8472222 0.010000 19.8500000 0.010000 19.8527778 0.010000 19.8555556 0.010000 19.8583333 0.010000 19.8611111 0.010000 19.8638889 0.010000 19.8666667 0.010000 19.8694444 0.010000 19.8722222 0.010000 19.8750000 0.010000 19.8777778 0.010000 19.8805556 0.010000 19.8833333 0.010000 19.8861111 0.010000 19.8888889 0.010000 19.8916667 0.010000 19.8944444 0.010000 19.8972222 0.010000 19.9000000 0.010000 19.9027778 0.010000 19.9055556 0.010000 19.9083333 0.010000 19.9111111 0.010000 19.9138889 0.010000 19.9166667 0.010000 19.9194444 0.010000 19.9222222 0.010000 19.9250000 0.010000 19.9277778 0.010000 19.9305556 0.010000 19.9333333 0.010000 19.9361111 0.010000 19.9388889 0.010000 19.9416667 0.010000 19.9444444 0.010000 19.9472222 0.010000 19.9500000 0.010000 19.9527778 0.010000 19.9555556 0.010000 19.9583333 0.010000 19.9611111 0.010000 19.9638889 0.010000 19.9666667 0.010000 19.9694444 0.010000 19.9722222 0.010000 19.9750000 0.010000 19.9777778 0.010000 19.9805556 0.010000 19.9833333 0.010000 19.9861111 0.010000 19.9888889 0.010000 19.9916667 0.010000 19.9944444 0.010000 19.9972222 0.010000 20.0000000 0.010000 20.0027778 0.010000 20.0055556 0.010000 20.0083333 0.010000 20.0111111 0.010000 20.0138889 0.010000 20.0166667 0.010000 20.0194444 0.010000 20.0222222 0.010000 20.0250000 0.010000 20.0277778 0.010000 20.0305556 0.010000 20.0333333 0.010000 20.0361111 0.010000 20.0388889 0.010000 20.0416667 0.010000 20.0444444 0.010000 20.0472222 0.010000 20.0500000 0.010000 20.0527778 0.010000 20.0555556 0.010000 20.0583333 0.010000 20.0611111 0.010000 20.0638889 0.010000 20.0666667 0.010000 20.0694444 0.010000 20.0722222 0.010000 20.0750000 0.010000 20.0777778 0.010000 20.0805556 0.010000 20.0833333 0.010000 20.0861111 0.010000 20.0888889 0.010000 20.0916667 0.010000 20.0944444 0.010000 20.0972222 0.010000 20.7611111 0.010000 20.7638889 0.010000 20.7666667 0.010000 20.7694444 0.010000 20.7722222 0.010000 20.7750000 0.010000 20.7777778 0.010000 20.7805556 0.010000 20.7833333 0.010000 20.7861111 0.010000 20.7888889 0.010000 20.7916667 0.010000 20.7944444 0.010000 20.7972222 0.010000 20.8000000 0.010000 20.8027778 0.010000 20.8055556 0.010000 20.8083333 0.010000 20.8111111 0.010000 20.8138889 0.010000 20.8166667 0.010000 20.8194444 0.010000 20.8222222 0.010000 20.8250000 0.010000 20.8277778 0.010000 20.8305556 0.010000 20.8333333 0.010000 20.8361111 0.010000 20.8388889 0.010000 20.8416667 0.010000 20.8444444 0.010000 20.8472222 0.010000 20.8500000 0.010000 20.8527778 0.010000 20.8555556 0.010000 20.8583333 0.010000 20.8611111 0.010000 20.8638889 0.010000 20.8666667 0.010000 20.8694444 0.010000 20.8722222 0.010000 20.8750000 0.010000 20.8777778 0.010000 20.8805556 0.010000 20.8833333 0.010000 20.8861111 0.010000 20.8888889 0.010000 20.8916667 0.010000 20.8944444 0.010000 20.8972222 0.010000 20.9000000 0.010000 20.9027778 0.010000 20.9055556 0.010000 20.9083333 0.010000 20.9111111 0.010000 20.9138889 0.010000 20.9166667 0.010000 20.9194444 0.010000 20.9222222 0.010000 20.9250000 0.010000 20.9277778 0.010000 20.9305556 0.010000 20.9333333 0.010000 20.9361111 0.010000 20.9388889 0.010000 20.9416667 0.010000 20.9444444 0.010000 20.9472222 0.010000 20.9500000 0.023269 20.9527778 0.059615 20.9555556 0.082115 20.9583333 0.092500 20.9611111 0.094231 20.9638889 0.071731 20.9666667 0.030192 20.9694444 0.010000 20.9722222 0.010000 20.9750000 0.010000 20.9777778 0.010000 20.9805556 0.010000 20.9833333 0.085577 20.9861111 0.180769 20.9888889 0.274231 20.9916667 0.367692 20.9944444 0.452500 20.9972222 0.530385 21.0000000 0.604808 21.0027778 0.668846 21.0055556 0.717308 21.0083333 0.745000 21.0111111 0.750192 21.0138889 0.741538 21.0166667 0.717308 21.0194444 0.670577 21.0222222 0.611731 21.0250000 0.533846 21.0277778 0.452500 21.0305556 0.372885 21.0333333 0.296731 21.0361111 0.220577 21.0388889 0.144423 21.0416667 0.070000 21.0444444 0.010000 21.0472222 0.010000 21.0500000 0.010000 21.0527778 0.010000 21.0555556 0.010000 21.0583333 0.010000 21.0611111 0.010000 21.0638889 0.010000 21.0666667 0.010000 21.0694444 0.010000 21.0722222 0.010000 21.0750000 0.010000 21.0777778 0.010000 21.0805556 0.010000 21.0833333 0.010000 21.0861111 0.010000 21.0888889 0.010000 21.0916667 0.010000 21.0944444 0.010000 21.0972222 0.010000 21.1000000 0.010000 21.1027778 0.010000 21.1055556 0.010000 21.1083333 0.010000 21.1111111 0.010000 21.1138889 0.010000 21.1166667 0.010000 21.1194444 0.010000 21.1222222 0.010000 21.1250000 0.010000 21.1277778 0.010000 21.1305556 0.010000 21.1333333 0.010000 21.1361111 0.010000 21.1388889 0.010000 21.1416667 0.010000 21.1444444 0.010000 21.1472222 0.010000 21.1500000 0.010000 21.1527778 0.010000 21.1555556 0.010000 21.1583333 0.010000 21.1611111 0.010000 21.1638889 0.010000 21.1666667 0.010000 21.1694444 0.010000 21.1722222 0.010000 21.1750000 0.010000 21.1777778 0.010000 21.1805556 0.010000 21.1833333 0.010000 21.1861111 0.010000 21.1888889 0.010000 21.1916667 0.010000 21.1944444 0.010000 21.1972222 0.010000 21.2000000 0.010000 21.2027778 0.010000 21.2055556 0.010000 21.2083333 0.010000 21.2111111 0.010000 21.2138889 0.010000 21.2166667 0.010000 21.2194444 0.010000 21.2222222 0.010000 21.2250000 0.010000 21.2277778 0.010000 21.2305556 0.010000 21.2333333 0.010000 21.2361111 0.010000 21.2388889 0.010000 21.2416667 0.010000 21.2444444 0.010000 21.2472222 0.010000 21.2500000 0.010000 21.2527778 0.010000 21.2555556 0.010000 21.2583333 0.010000 21.2611111 0.010000 21.2638889 0.010000 21.2666667 0.010000 21.2694444 0.010000 21.2722222 0.010000 21.2750000 0.010000 21.2777778 0.010000 21.2805556 0.010000 21.2833333 0.010000 21.2861111 0.010000 21.2888889 0.010000 21.2916667 0.010000 21.2944444 0.010000 21.2972222 0.010000 21.3000000 0.010000 21.3027778 0.010000 21.3055556 0.010000 21.3083333 0.010000 21.9277778 0.010000 21.9305556 0.010000 21.9333333 0.010000 21.9361111 0.010000 21.9388889 0.010000 21.9416667 0.010000 21.9444444 0.010000 21.9472222 0.010000 21.9500000 0.010000 21.9527778 0.010000 21.9555556 0.010000 21.9583333 0.010000 21.9611111 0.010000 21.9638889 0.010000 21.9666667 0.010000 21.9694444 0.010000 21.9722222 0.010000 21.9750000 0.010000 21.9777778 0.010000 21.9805556 0.010000 21.9833333 0.010000 21.9861111 0.010000 21.9888889 0.010000 21.9916667 0.010000 21.9944444 0.010000 21.9972222 0.010000 22.0000000 0.010000 22.0027778 0.010000 22.0055556 0.010000 22.0083333 0.010000 22.0111111 0.010000 22.0138889 0.010000 22.0166667 0.010000 22.0194444 0.010000 22.0222222 0.010000 22.0250000 0.010000 22.0277778 0.010000 22.0305556 0.010000 22.0333333 0.010000 22.0361111 0.010000 22.0388889 0.010000 22.0416667 0.010000 22.0444444 0.010000 22.0472222 0.010000 22.0500000 0.010000 22.0527778 0.010000 22.0555556 0.010000 22.0583333 0.010000 22.0611111 0.010000 22.0638889 0.010000 22.0666667 0.010000 22.0694444 0.010000 22.0722222 0.010000 22.0750000 0.010000 22.0777778 0.010000 22.0805556 0.010000 22.0833333 0.010000 22.0861111 0.010000 22.0888889 0.010000 22.0916667 0.010000 22.0944444 0.010000 22.0972222 0.010000 22.1000000 0.010000 22.1027778 0.010000 22.1055556 0.010000 22.1083333 0.010000 22.1111111 0.010000 22.1138889 0.010000 22.1166667 0.010000 22.1194444 0.023269 22.1222222 0.059615 22.1250000 0.089038 22.1277778 0.108077 22.1305556 0.111538 22.1333333 0.101154 22.1361111 0.056154 22.1388889 0.010000 22.1416667 0.010000 22.1444444 0.010000 22.1472222 0.010000 22.1500000 0.010000 22.1527778 0.099423 22.1555556 0.222308 22.1583333 0.341731 22.1611111 0.447308 22.1638889 0.532115 22.1666667 0.594423 22.1694444 0.639423 22.1722222 0.667115 22.1750000 0.675769 22.1777778 0.665385 22.1805556 0.641154 22.1833333 0.604808 22.1861111 0.551154 22.1888889 0.481923 22.1916667 0.409231 22.1944444 0.319231 22.1972222 0.244808 22.2000000 0.161731 22.2027778 0.087308 22.2055556 0.014615 22.2083333 0.010000 22.2111111 0.010000 22.2138889 0.010000 22.2166667 0.010000 22.2194444 0.010000 22.2222222 0.010000 22.2250000 0.010000 22.2277778 0.010000 22.2305556 0.010000 22.2333333 0.010000 22.2361111 0.010000 22.2388889 0.010000 22.2416667 0.010000 22.2444444 0.010000 22.2472222 0.010000 22.2500000 0.010000 22.2527778 0.010000 22.2555556 0.010000 22.2583333 0.010000 22.2611111 0.010000 22.2638889 0.010000 22.2666667 0.010000 22.2694444 0.010000 22.2722222 0.010000 22.2750000 0.010000 22.2777778 0.010000 22.2805556 0.010000 22.2833333 0.010000 22.2861111 0.010000 22.2888889 0.010000 22.2916667 0.010000 22.2944444 0.010000 22.2972222 0.010000 22.3000000 0.010000 22.3027778 0.010000 22.3055556 0.010000 22.3083333 0.010000 22.3111111 0.010000 22.3138889 0.010000 22.3166667 0.010000 22.3194444 0.010000 22.3222222 0.010000 22.3250000 0.010000 22.3277778 0.010000 22.3305556 0.010000 22.3333333 0.010000 22.3361111 0.010000 22.3388889 0.010000 22.3416667 0.010000 22.3444444 0.010000 22.3472222 0.010000 22.3500000 0.010000 22.3527778 0.010000 22.3555556 0.010000 22.3583333 0.010000 22.3611111 0.010000 22.3638889 0.010000 22.3666667 0.010000 22.3694444 0.010000 22.3722222 0.010000 22.3750000 0.010000 22.3777778 0.010000 22.3805556 0.010000 22.3833333 0.010000 22.3861111 0.010000 22.3888889 0.010000 22.3916667 0.010000 22.3944444 0.010000 22.3972222 0.010000 22.4000000 0.010000 22.4027778 0.010000 22.4055556 0.010000 22.4083333 0.010000 22.4111111 0.010000 22.4138889 0.010000 22.4166667 0.010000 22.4194444 0.010000 22.4222222 0.010000 22.4250000 0.010000 22.4277778 0.010000 22.4305556 0.010000 22.4333333 0.010000 22.4361111 0.010000 22.4388889 0.010000 22.4416667 0.010000 22.4444444 0.010000 22.4472222 0.010000 22.4500000 0.010000 22.4527778 0.010000 22.4555556 0.010000 22.4583333 0.010000 22.4611111 0.010000 22.4638889 0.010000 22.4666667 0.010000 22.4694444 0.010000 22.4722222 0.010000 22.4750000 0.010000 23.1444444 0.010000 23.1472222 0.010000 23.1500000 0.010000 23.1527778 0.010000 23.1555556 0.010000 23.1583333 0.010000 23.1611111 0.010000 23.1638889 0.010000 23.1666667 0.010000 23.1694444 0.010000 23.1722222 0.010000 23.1750000 0.010000 23.1777778 0.010000 23.1805556 0.010000 23.1833333 0.010000 23.1861111 0.010000 23.1888889 0.010000 23.1916667 0.010000 23.1944444 0.010000 23.1972222 0.010000 23.2000000 0.010000 23.2027778 0.010000 23.2055556 0.010000 23.2083333 0.010000 23.2111111 0.010000 23.2138889 0.010000 23.2166667 0.010000 23.2194444 0.010000 23.2222222 0.010000 23.2250000 0.010000 23.2277778 0.010000 23.2305556 0.010000 23.2333333 0.010000 23.2361111 0.010000 23.2388889 0.010000 23.2416667 0.010000 23.2444444 0.010000 23.2472222 0.010000 23.2500000 0.010000 23.2527778 0.010000 23.2555556 0.010000 23.2583333 0.010000 23.2611111 0.011154 23.2638889 0.010000 23.2666667 0.010000 23.2694444 0.010000 23.2722222 0.010000 23.2750000 0.010000 23.2777778 0.010000 23.2805556 0.010000 23.2833333 0.010000 23.2861111 0.010000 23.2888889 0.010000 23.2916667 0.010000 23.2944444 0.010000 23.2972222 0.010000 23.3000000 0.010000 23.3027778 0.010000 23.3055556 0.010000 23.3083333 0.010000 23.3111111 0.010000 23.3138889 0.010000 23.3166667 0.010000 23.3194444 0.010000 23.3222222 0.010000 23.3250000 0.010000 23.3277778 0.010000 23.3305556 0.010000 23.3333333 0.010000 23.3361111 0.021538 23.3388889 0.052692 23.3416667 0.078654 23.3444444 0.101154 23.3472222 0.108077 23.3500000 0.099423 23.3527778 0.070000 23.3555556 0.019808 23.3583333 0.010000 23.3611111 0.010000 23.3638889 0.010000 23.3666667 0.033654 23.3694444 0.135769 23.3722222 0.255192 23.3750000 0.378077 23.3777778 0.497500 23.3805556 0.606538 23.3833333 0.689615 23.3861111 0.748462 23.3888889 0.774423 23.3916667 0.772692 23.3944444 0.748462 23.3972222 0.710385 23.4000000 0.648077 23.4027778 0.571923 23.4055556 0.487115 23.4083333 0.402308 23.4111111 0.319231 23.4138889 0.243077 23.4166667 0.165192 23.4194444 0.083846 23.4222222 0.011154 23.4250000 0.010000 23.4277778 0.010000 23.4305556 0.010000 23.4333333 0.010000 23.4361111 0.010000 23.4388889 0.010000 23.4416667 0.010000 23.4444444 0.010000 23.4472222 0.010000 23.4500000 0.010000 23.4527778 0.010000 23.4555556 0.010000 23.4583333 0.010000 23.4611111 0.010000 23.4638889 0.010000 23.4666667 0.010000 23.4694444 0.010000 23.4722222 0.010000 23.4750000 0.010000 23.4777778 0.010000 23.4805556 0.010000 23.4833333 0.010000 23.4861111 0.010000 23.4888889 0.010000 23.4916667 0.010000 23.4944444 0.010000 23.4972222 0.010000 23.5000000 0.010000 23.5027778 0.010000 23.5055556 0.010000 23.5083333 0.010000 23.5111111 0.010000 23.5138889 0.010000 23.5166667 0.010000 23.5194444 0.010000 23.5222222 0.010000 23.5250000 0.010000 23.5277778 0.010000 23.5305556 0.010000 23.5333333 0.010000 23.5361111 0.010000 23.5388889 0.010000 23.5416667 0.010000 23.5444444 0.010000 23.5472222 0.010000 23.5500000 0.010000 23.5527778 0.010000 23.5555556 0.010000 23.5583333 0.010000 23.5611111 0.010000 23.5638889 0.010000 23.5666667 0.010000 23.5694444 0.010000 23.5722222 0.010000 23.5750000 0.010000 23.5777778 0.010000 23.5805556 0.010000 23.5833333 0.010000 23.5861111 0.010000 23.5888889 0.010000 23.5916667 0.010000 23.5944444 0.010000 23.5972222 0.010000 23.6000000 0.010000 23.6027778 0.010000 23.6055556 0.010000 23.6083333 0.010000 23.6111111 0.010000 23.6138889 0.010000 23.6166667 0.010000 23.6194444 0.010000 23.6222222 0.010000 23.6250000 0.010000 23.6277778 0.010000 23.6305556 0.010000 23.6333333 0.010000 23.6361111 0.010000 23.6388889 0.010000 23.6416667 0.010000 23.6444444 0.010000 23.6472222 0.010000 23.6500000 0.010000 23.6527778 0.010000 23.6555556 0.010000 23.6583333 0.010000 23.6611111 0.010000 23.6638889 0.010000 23.6666667 0.010000 23.6694444 0.010000 23.6722222 0.010000 23.6750000 0.010000 23.6777778 0.010000 23.6805556 0.010000 23.6833333 0.010000 23.6861111 0.010000 23.6888889 0.010000 23.6916667 0.010000 24.3277778 0.010000 24.3305556 0.010000 24.3333333 0.010000 24.3361111 0.010000 24.3388889 0.010000 24.3416667 0.010000 24.3444444 0.010000 24.3472222 0.010000 24.3500000 0.010000 24.3527778 0.010000 24.3555556 0.010000 24.3583333 0.010000 24.3611111 0.010000 24.3638889 0.010000 24.3666667 0.010000 24.3694444 0.010000 24.3722222 0.010000 24.3750000 0.010000 24.3777778 0.010000 24.3805556 0.010000 24.3833333 0.010000 24.3861111 0.010000 24.3888889 0.010000 24.3916667 0.010000 24.3944444 0.010000 24.3972222 0.010000 24.4000000 0.010000 24.4027778 0.010000 24.4055556 0.010000 24.4083333 0.010000 24.4111111 0.010000 24.4138889 0.010000 24.4166667 0.010000 24.4194444 0.010000 24.4222222 0.010000 24.4250000 0.010000 24.4277778 0.010000 24.4305556 0.010000 24.4333333 0.010000 24.4361111 0.010000 24.4388889 0.010000 24.4416667 0.010000 24.4444444 0.010000 24.4472222 0.010000 24.4500000 0.010000 24.4527778 0.010000 24.4555556 0.010000 24.4583333 0.010000 24.4611111 0.010000 24.4638889 0.010000 24.4666667 0.010000 24.4694444 0.010000 24.4722222 0.010000 24.4750000 0.010000 24.4777778 0.010000 24.4805556 0.010000 24.4833333 0.010000 24.4861111 0.010000 24.4888889 0.010000 24.4916667 0.010000 24.4944444 0.010000 24.4972222 0.010000 24.5000000 0.010000 24.5027778 0.010000 24.5055556 0.010000 24.5083333 0.010000 24.5111111 0.010000 24.5138889 0.044038 24.5166667 0.080385 24.5194444 0.106346 24.5222222 0.120192 24.5250000 0.120192 24.5277778 0.106346 24.5305556 0.076923 24.5333333 0.023269 24.5361111 0.010000 24.5388889 0.010000 24.5416667 0.010000 24.5444444 0.010000 24.5472222 0.010000 24.5500000 0.075192 24.5527778 0.166923 24.5555556 0.255192 24.5583333 0.338269 24.5611111 0.417885 24.5638889 0.487115 24.5666667 0.544231 24.5694444 0.599615 24.5722222 0.641154 24.5750000 0.661923 24.5777778 0.663654 24.5805556 0.651538 24.5833333 0.627308 24.5861111 0.578846 24.5888889 0.513077 24.5916667 0.426538 24.5944444 0.345192 24.5972222 0.265577 24.6000000 0.180769 24.6027778 0.097692 24.6055556 0.021538 24.6083333 0.010000 24.6111111 0.010000 24.6138889 0.010000 24.6166667 0.010000 24.6194444 0.010000 24.6222222 0.010000 24.6250000 0.010000 24.6277778 0.010000 24.6305556 0.010000 24.6333333 0.010000 24.6361111 0.010000 24.6388889 0.010000 24.6416667 0.010000 24.6444444 0.010000 24.6472222 0.010000 24.6500000 0.010000 24.6527778 0.010000 24.6555556 0.010000 24.6583333 0.010000 24.6611111 0.010000 24.6638889 0.010000 24.6666667 0.010000 24.6694444 0.010000 24.6722222 0.010000 24.6750000 0.010000 24.6777778 0.010000 24.6805556 0.010000 24.6833333 0.010000 24.6861111 0.010000 24.6888889 0.010000 24.6916667 0.010000 24.6944444 0.010000 24.6972222 0.010000 24.7000000 0.010000 24.7027778 0.010000 24.7055556 0.010000 24.7083333 0.010000 24.7111111 0.010000 24.7138889 0.010000 24.7166667 0.010000 24.7194444 0.010000 24.7222222 0.010000 24.7250000 0.010000 24.7277778 0.010000 24.7305556 0.010000 24.7333333 0.010000 24.7361111 0.010000 24.7388889 0.010000 24.7416667 0.010000 24.7444444 0.010000 24.7472222 0.010000 24.7500000 0.010000 24.7527778 0.010000 24.7555556 0.010000 24.7583333 0.010000 24.7611111 0.010000 24.7638889 0.010000 24.7666667 0.010000 24.7694444 0.010000 24.7722222 0.010000 24.7750000 0.010000 24.7777778 0.010000 24.7805556 0.010000 24.7833333 0.010000 24.7861111 0.010000 24.7888889 0.010000 24.7916667 0.010000 24.7944444 0.010000 24.7972222 0.010000 24.8000000 0.010000 24.8027778 0.010000 24.8055556 0.010000 24.8083333 0.010000 24.8111111 0.010000 24.8138889 0.010000 24.8166667 0.010000 24.8194444 0.010000 24.8222222 0.010000 24.8250000 0.010000 24.8277778 0.010000 24.8305556 0.010000 24.8333333 0.010000 24.8361111 0.010000 24.8388889 0.010000 24.8416667 0.010000 24.8444444 0.010000 24.8472222 0.010000 24.8500000 0.010000 24.8527778 0.010000 24.8555556 0.010000 24.8583333 0.010000 24.8611111 0.010000 24.8638889 0.010000 24.8666667 0.010000 24.8694444 0.010000 24.8722222 0.010000 24.8750000 0.010000 25.5527778 0.010000 25.5555556 0.010000 25.5583333 0.010000 25.5611111 0.010000 25.5638889 0.010000 25.5666667 0.010000 25.5694444 0.010000 25.5722222 0.010000 25.5750000 0.010000 25.5777778 0.010000 25.5805556 0.010000 25.5833333 0.010000 25.5861111 0.010000 25.5888889 0.010000 25.5916667 0.010000 25.5944444 0.010000 25.5972222 0.010000 25.6000000 0.010000 25.6027778 0.010000 25.6055556 0.010000 25.6083333 0.010000 25.6111111 0.010000 25.6138889 0.010000 25.6166667 0.010000 25.6194444 0.010000 25.6222222 0.010000 25.6250000 0.010000 25.6277778 0.010000 25.6305556 0.010000 25.6333333 0.010000 25.6361111 0.010000 25.6388889 0.010000 25.6416667 0.010000 25.6444444 0.010000 25.6472222 0.010000 25.6500000 0.010000 25.6527778 0.010000 25.6555556 0.010000 25.6583333 0.010000 25.6611111 0.010000 25.6638889 0.010000 25.6666667 0.010000 25.6694444 0.010000 25.6722222 0.010000 25.6750000 0.010000 25.6777778 0.010000 25.6805556 0.010000 25.6833333 0.010000 25.6861111 0.010000 25.6888889 0.010000 25.6916667 0.010000 25.6944444 0.010000 25.6972222 0.010000 25.7000000 0.010000 25.7027778 0.010000 25.7055556 0.010000 25.7083333 0.010000 25.7111111 0.010000 25.7138889 0.010000 25.7166667 0.010000 25.7194444 0.010000 25.7222222 0.010000 25.7250000 0.010000 25.7277778 0.010000 25.7305556 0.010000 25.7333333 0.010000 25.7361111 0.010000 25.7388889 0.010000 25.7416667 0.038846 25.7444444 0.066538 25.7472222 0.090769 25.7500000 0.106346 25.7527778 0.108077 25.7555556 0.085577 25.7583333 0.038846 25.7611111 0.010000 25.7638889 0.010000 25.7666667 0.010000 25.7694444 0.010000 25.7722222 0.010000 25.7750000 0.085577 25.7777778 0.189423 25.7805556 0.291538 25.7833333 0.391923 25.7861111 0.487115 25.7888889 0.570192 25.7916667 0.646346 25.7944444 0.705192 25.7972222 0.748462 25.8000000 0.764038 25.8027778 0.758846 25.8055556 0.736346 25.8083333 0.691346 25.8111111 0.627308 25.8138889 0.549423 25.8166667 0.462885 25.8194444 0.376346 25.8222222 0.291538 25.8250000 0.213654 25.8277778 0.130577 25.8305556 0.047500 25.8333333 0.010000 25.8361111 0.010000 25.8388889 0.010000 25.8416667 0.010000 25.8444444 0.010000 25.8472222 0.010000 25.8500000 0.010000 25.8527778 0.010000 25.8555556 0.010000 25.8583333 0.010000 25.8611111 0.010000 25.8638889 0.010000 25.8666667 0.010000 25.8694444 0.010000 25.8722222 0.010000 25.8750000 0.010000 25.8777778 0.010000 25.8805556 0.010000 25.8833333 0.010000 25.8861111 0.010000 25.8888889 0.010000 25.8916667 0.010000 25.8944444 0.010000 25.8972222 0.010000 25.9000000 0.010000 25.9027778 0.010000 25.9055556 0.010000 25.9083333 0.010000 25.9111111 0.010000 25.9138889 0.010000 25.9166667 0.010000 25.9194444 0.010000 25.9222222 0.010000 25.9250000 0.010000 25.9277778 0.010000 25.9305556 0.010000 25.9333333 0.010000 25.9361111 0.010000 25.9388889 0.010000 25.9416667 0.010000 25.9444444 0.010000 25.9472222 0.010000 25.9500000 0.010000 25.9527778 0.010000 25.9555556 0.010000 25.9583333 0.010000 25.9611111 0.010000 25.9638889 0.010000 25.9666667 0.010000 25.9694444 0.010000 25.9722222 0.010000 25.9750000 0.010000 25.9777778 0.010000 25.9805556 0.010000 25.9833333 0.010000 25.9861111 0.010000 25.9888889 0.010000 25.9916667 0.010000 25.9944444 0.010000 25.9972222 0.010000 26.0000000 0.010000 26.0027778 0.010000 26.0055556 0.010000 26.0083333 0.010000 26.0111111 0.010000 26.0138889 0.010000 26.0166667 0.010000 26.0194444 0.010000 26.0222222 0.010000 26.0250000 0.010000 26.0277778 0.010000 26.0305556 0.010000 26.0333333 0.010000 26.0361111 0.010000 26.0388889 0.010000 26.0416667 0.010000 26.0444444 0.010000 26.0472222 0.010000 26.0500000 0.010000 26.0527778 0.010000 26.0555556 0.010000 26.0583333 0.010000 26.0611111 0.010000 26.0638889 0.010000 26.0666667 0.010000 26.0694444 0.010000 26.0722222 0.010000 26.0750000 0.010000 26.0777778 0.010000 26.0805556 0.010000 26.0833333 0.010000 26.0861111 0.010000 26.0888889 0.010000 26.0916667 0.010000 26.0944444 0.010000 26.0972222 0.010000 26.1000000 0.010000 26.7361111 0.010000 26.7388889 0.010000 26.7416667 0.010000 26.7444444 0.010000 26.7472222 0.010000 26.7500000 0.010000 26.7527778 0.010000 26.7555556 0.010000 26.7583333 0.010000 26.7611111 0.010000 26.7638889 0.010000 26.7666667 0.010000 26.7694444 0.010000 26.7722222 0.010000 26.7750000 0.010000 26.7777778 0.010000 26.7805556 0.010000 26.7833333 0.010000 26.7861111 0.010000 26.7888889 0.010000 26.7916667 0.010000 26.7944444 0.010000 26.7972222 0.010000 26.8000000 0.010000 26.8027778 0.010000 26.8055556 0.010000 26.8083333 0.010000 26.8111111 0.010000 26.8138889 0.010000 26.8166667 0.010000 26.8194444 0.010000 26.8222222 0.010000 26.8250000 0.010000 26.8277778 0.010000 26.8305556 0.010000 26.8333333 0.010000 26.8361111 0.010000 26.8388889 0.010000 26.8416667 0.010000 26.8444444 0.010000 26.8472222 0.010000 26.8500000 0.010000 26.8527778 0.010000 26.8555556 0.010000 26.8583333 0.010000 26.8611111 0.010000 26.8638889 0.010000 26.8666667 0.010000 26.8694444 0.010000 26.8722222 0.010000 26.8750000 0.010000 26.8777778 0.010000 26.8805556 0.010000 26.8833333 0.010000 26.8861111 0.010000 26.8888889 0.010000 26.8916667 0.010000 26.8944444 0.010000 26.8972222 0.010000 26.9000000 0.010000 26.9027778 0.010000 26.9055556 0.010000 26.9083333 0.010000 26.9111111 0.010000 26.9138889 0.010000 26.9166667 0.010000 26.9194444 0.010000 26.9222222 0.010000 26.9250000 0.033654 26.9277778 0.063077 26.9305556 0.094231 26.9333333 0.113269 26.9361111 0.115000 26.9388889 0.101154 26.9416667 0.059615 26.9444444 0.010000 26.9472222 0.010000 26.9500000 0.010000 26.9527778 0.010000 26.9555556 0.010000 26.9583333 0.044038 26.9611111 0.135769 26.9638889 0.241346 26.9666667 0.336538 26.9694444 0.426538 26.9722222 0.500962 26.9750000 0.561538 26.9777778 0.610000 26.9805556 0.641154 26.9833333 0.653269 26.9861111 0.644615 26.9888889 0.625577 26.9916667 0.597885 26.9944444 0.551154 26.9972222 0.490577 27.0000000 0.417885 27.0027778 0.346923 27.0055556 0.275962 27.0083333 0.199808 27.0111111 0.125385 27.0138889 0.050962 27.0166667 0.010000 27.0194444 0.010000 27.0222222 0.010000 27.0250000 0.010000 27.0277778 0.010000 27.0305556 0.010000 27.0333333 0.010000 27.0361111 0.010000 27.0388889 0.010000 27.0416667 0.010000 27.0444444 0.010000 27.0472222 0.010000 27.0500000 0.010000 27.0527778 0.010000 27.0555556 0.010000 27.0583333 0.010000 27.0611111 0.010000 27.0638889 0.010000 27.0666667 0.010000 27.0694444 0.010000 27.0722222 0.010000 27.0750000 0.010000 27.0777778 0.010000 27.0805556 0.010000 27.0833333 0.010000 27.0861111 0.010000 27.0888889 0.010000 27.0916667 0.010000 27.0944444 0.010000 27.0972222 0.010000 27.1000000 0.010000 27.1027778 0.010000 27.1055556 0.010000 27.1083333 0.010000 27.1111111 0.010000 27.1138889 0.010000 27.1166667 0.010000 27.1194444 0.010000 27.1222222 0.010000 27.1250000 0.010000 27.1277778 0.010000 27.1305556 0.010000 27.1333333 0.010000 27.1361111 0.010000 27.1388889 0.010000 27.1416667 0.010000 27.1444444 0.010000 27.1472222 0.010000 27.1500000 0.010000 27.1527778 0.010000 27.1555556 0.010000 27.1583333 0.010000 27.1611111 0.010000 27.1638889 0.010000 27.1666667 0.010000 27.1694444 0.010000 27.1722222 0.010000 27.1750000 0.010000 27.1777778 0.010000 27.1805556 0.010000 27.1833333 0.010000 27.1861111 0.010000 27.1888889 0.010000 27.1916667 0.010000 27.1944444 0.010000 27.1972222 0.010000 27.2000000 0.010000 27.2027778 0.010000 27.2055556 0.010000 27.2083333 0.010000 27.2111111 0.010000 27.2138889 0.010000 27.2166667 0.010000 27.2194444 0.010000 27.2222222 0.010000 27.2250000 0.010000 27.2277778 0.010000 27.2305556 0.010000 27.2333333 0.010000 27.2361111 0.010000 27.2388889 0.010000 27.2416667 0.010000 27.2444444 0.010000 27.2472222 0.010000 27.2500000 0.010000 27.2527778 0.010000 27.2555556 0.010000 27.2583333 0.010000 27.2611111 0.010000 27.2638889 0.010000 27.2666667 0.010000 27.2694444 0.010000 27.2722222 0.010000 27.2750000 0.010000 27.2777778 0.010000 27.2805556 0.010000 27.2833333 0.010000 27.9305556 0.010000 27.9333333 0.010000 27.9361111 0.010000 27.9388889 0.010000 27.9416667 0.010000 27.9444444 0.010000 27.9472222 0.010000 27.9500000 0.010000 27.9527778 0.010000 27.9555556 0.010000 27.9583333 0.010000 27.9611111 0.010000 27.9638889 0.010000 27.9666667 0.010000 27.9694444 0.010000 27.9722222 0.010000 27.9750000 0.010000 27.9777778 0.010000 27.9805556 0.010000 27.9833333 0.010000 27.9861111 0.010000 27.9888889 0.010000 27.9916667 0.010000 27.9944444 0.010000 27.9972222 0.010000 28.0000000 0.010000 28.0027778 0.010000 28.0055556 0.010000 28.0083333 0.010000 28.0111111 0.010000 28.0138889 0.010000 28.0166667 0.010000 28.0194444 0.010000 28.0222222 0.010000 28.0250000 0.010000 28.0277778 0.010000 28.0305556 0.010000 28.0333333 0.010000 28.0361111 0.010000 28.0388889 0.010000 28.0416667 0.010000 28.0444444 0.010000 28.0472222 0.010000 28.0500000 0.010000 28.0527778 0.010000 28.0555556 0.010000 28.0583333 0.010000 28.0611111 0.010000 28.0638889 0.010000 28.0666667 0.010000 28.0694444 0.010000 28.0722222 0.010000 28.0750000 0.010000 28.0777778 0.010000 28.0805556 0.010000 28.0833333 0.010000 28.0861111 0.010000 28.0888889 0.010000 28.0916667 0.010000 28.0944444 0.010000 28.0972222 0.010000 28.1000000 0.010000 28.1027778 0.010000 28.1055556 0.010000 28.1083333 0.010000 28.1111111 0.010000 28.1138889 0.010000 28.1166667 0.019808 28.1194444 0.054423 28.1222222 0.082115 28.1250000 0.097692 28.1277778 0.099423 28.1305556 0.085577 28.1333333 0.047500 28.1361111 0.010000 28.1388889 0.010000 28.1416667 0.010000 28.1444444 0.010000 28.1472222 0.010000 28.1500000 0.038846 28.1527778 0.130577 28.1555556 0.229231 28.1583333 0.322692 28.1611111 0.407500 28.1638889 0.488846 28.1666667 0.559808 28.1694444 0.625577 28.1722222 0.682692 28.1750000 0.727692 28.1777778 0.753654 28.1805556 0.760577 28.1833333 0.741538 28.1861111 0.715577 28.1888889 0.670577 28.1916667 0.603077 28.1944444 0.520000 28.1972222 0.435192 28.2000000 0.359038 28.2027778 0.288077 28.2055556 0.218846 28.2083333 0.147885 28.2111111 0.071731 28.2138889 0.010000 28.2166667 0.010000 28.2194444 0.010000 28.2222222 0.010000 28.2250000 0.010000 28.2277778 0.010000 28.2305556 0.010000 28.2333333 0.010000 28.2361111 0.010000 28.2388889 0.010000 28.2416667 0.010000 28.2444444 0.010000 28.2472222 0.010000 28.2500000 0.010000 28.2527778 0.010000 28.2555556 0.010000 28.2583333 0.010000 28.2611111 0.010000 28.2638889 0.010000 28.2666667 0.010000 28.2694444 0.010000 28.2722222 0.010000 28.2750000 0.010000 28.2777778 0.010000 28.2805556 0.010000 28.2833333 0.010000 28.2861111 0.010000 28.2888889 0.010000 28.2916667 0.010000 28.2944444 0.010000 28.2972222 0.010000 28.3000000 0.010000 28.3027778 0.010000 28.3055556 0.010000 28.3083333 0.010000 28.3111111 0.010000 28.3138889 0.010000 28.3166667 0.010000 28.3194444 0.010000 28.3222222 0.010000 28.3250000 0.010000 28.3277778 0.010000 28.3305556 0.010000 28.3333333 0.010000 28.3361111 0.010000 28.3388889 0.010000 28.3416667 0.010000 28.3444444 0.010000 28.3472222 0.010000 28.3500000 0.010000 28.3527778 0.010000 28.3555556 0.010000 28.3583333 0.010000 28.3611111 0.010000 28.3638889 0.010000 28.3666667 0.010000 28.3694444 0.010000 28.3722222 0.010000 28.3750000 0.010000 28.3777778 0.010000 28.3805556 0.010000 28.3833333 0.010000 28.3861111 0.010000 28.3888889 0.010000 28.3916667 0.010000 28.3944444 0.010000 28.3972222 0.010000 28.4000000 0.010000 28.4027778 0.010000 28.4055556 0.010000 28.4083333 0.010000 28.4111111 0.010000 28.4138889 0.010000 28.4166667 0.010000 28.4194444 0.010000 28.4222222 0.010000 28.4250000 0.010000 28.4277778 0.010000 28.4305556 0.010000 28.4333333 0.010000 28.4361111 0.010000 28.4388889 0.010000 28.4416667 0.010000 28.4444444 0.010000 28.4472222 0.010000 28.4500000 0.010000 28.4527778 0.010000 28.4555556 0.010000 28.4583333 0.010000 28.4611111 0.010000 28.4638889 0.010000 28.4666667 0.010000 28.4694444 0.010000 28.4722222 0.010000 28.4750000 0.010000 28.4777778 0.010000 29.1388889 0.010000 29.1416667 0.010000 29.1444444 0.010000 29.1472222 0.010000 29.1500000 0.010000 29.1527778 0.010000 29.1555556 0.010000 29.1583333 0.010000 29.1611111 0.010000 29.1638889 0.010000 29.1666667 0.010000 29.1694444 0.010000 29.1722222 0.010000 29.1750000 0.010000 29.1777778 0.010000 29.1805556 0.010000 29.1833333 0.010000 29.1861111 0.010000 29.1888889 0.010000 29.1916667 0.010000 29.1944444 0.010000 29.1972222 0.010000 29.2000000 0.010000 29.2027778 0.010000 29.2055556 0.010000 29.2083333 0.010000 29.2111111 0.010000 29.2138889 0.010000 29.2166667 0.010000 29.2194444 0.010000 29.2222222 0.010000 29.2250000 0.010000 29.2277778 0.010000 29.2305556 0.010000 29.2333333 0.010000 29.2361111 0.010000 29.2388889 0.010000 29.2416667 0.010000 29.2444444 0.010000 29.2472222 0.010000 29.2500000 0.010000 29.2527778 0.010000 29.2555556 0.010000 29.2583333 0.010000 29.2611111 0.010000 29.2638889 0.010000 29.2666667 0.010000 29.2694444 0.010000 29.2722222 0.010000 29.2750000 0.010000 29.2777778 0.010000 29.2805556 0.010000 29.2833333 0.010000 29.2861111 0.010000 29.2888889 0.010000 29.2916667 0.010000 29.2944444 0.010000 29.2972222 0.010000 29.3000000 0.010000 29.3027778 0.010000 29.3055556 0.010000 29.3083333 0.010000 29.3111111 0.010000 29.3138889 0.010000 29.3166667 0.010000 29.3194444 0.010000 29.3222222 0.010000 29.3250000 0.010000 29.3277778 0.028462 29.3305556 0.059615 29.3333333 0.089038 29.3361111 0.097692 29.3388889 0.099423 29.3416667 0.071731 29.3444444 0.019808 29.3472222 0.010000 29.3500000 0.010000 29.3527778 0.010000 29.3555556 0.010000 29.3583333 0.010000 29.3611111 0.056154 29.3638889 0.151346 29.3666667 0.246538 29.3694444 0.333077 29.3722222 0.414423 29.3750000 0.488846 29.3777778 0.556346 29.3805556 0.604808 29.3833333 0.637692 29.3861111 0.651538 29.3888889 0.642885 29.3916667 0.627308 29.3944444 0.594423 29.3972222 0.547692 29.4000000 0.483654 29.4027778 0.409231 29.4055556 0.333077 29.4083333 0.263846 29.4111111 0.189423 29.4138889 0.109808 29.4166667 0.040577 29.4194444 0.010000 29.4222222 0.010000 29.4250000 0.010000 29.4277778 0.010000 29.4305556 0.010000 29.4333333 0.010000 29.4361111 0.010000 29.4388889 0.010000 29.4416667 0.010000 29.4444444 0.010000 29.4472222 0.010000 29.4500000 0.010000 29.4527778 0.010000 29.4555556 0.010000 29.4583333 0.010000 29.4611111 0.010000 29.4638889 0.010000 29.4666667 0.010000 29.4694444 0.010000 29.4722222 0.010000 29.4750000 0.010000 29.4777778 0.010000 29.4805556 0.010000 29.4833333 0.010000 29.4861111 0.010000 29.4888889 0.010000 29.4916667 0.010000 29.4944444 0.010000 29.4972222 0.010000 29.5000000 0.010000 29.5027778 0.010000 29.5055556 0.010000 29.5083333 0.010000 29.5111111 0.010000 29.5138889 0.010000 29.5166667 0.010000 29.5194444 0.010000 29.5222222 0.010000 29.5250000 0.010000 29.5277778 0.010000 29.5305556 0.010000 29.5333333 0.010000 29.5361111 0.010000 29.5388889 0.010000 29.5416667 0.010000 29.5444444 0.010000 29.5472222 0.010000 29.5500000 0.010000 29.5527778 0.010000 29.5555556 0.010000 29.5583333 0.010000 29.5611111 0.010000 29.5638889 0.010000 29.5666667 0.010000 29.5694444 0.010000 29.5722222 0.010000 29.5750000 0.010000 29.5777778 0.010000 29.5805556 0.010000 29.5833333 0.010000 29.5861111 0.010000 29.5888889 0.010000 29.5916667 0.010000 29.5944444 0.010000 29.5972222 0.010000 29.6000000 0.010000 29.6027778 0.010000 29.6055556 0.010000 29.6083333 0.010000 29.6111111 0.010000 29.6138889 0.010000 29.6166667 0.010000 29.6194444 0.010000 29.6222222 0.010000 29.6250000 0.010000 29.6277778 0.010000 29.6305556 0.010000 29.6333333 0.010000 29.6361111 0.010000 29.6388889 0.010000 29.6416667 0.010000 29.6444444 0.010000 29.6472222 0.010000 29.6500000 0.010000 29.6527778 0.010000 29.6555556 0.010000 29.6583333 0.010000 29.6611111 0.010000 29.6638889 0.010000 29.6666667 0.010000 29.6694444 0.010000 29.6722222 0.010000 29.6750000 0.010000 29.6777778 0.010000 29.6805556 0.010000 29.6833333 0.010000 29.6861111 0.010000 30.3444444 0.010000 30.3472222 0.010000 30.3500000 0.010000 30.3527778 0.010000 30.3555556 0.010000 30.3583333 0.010000 30.3611111 0.010000 30.3638889 0.010000 30.3666667 0.010000 30.3694444 0.010000 30.3722222 0.010000 30.3750000 0.010000 30.3777778 0.010000 30.3805556 0.010000 30.3833333 0.010000 30.3861111 0.010000 30.3888889 0.010000 30.3916667 0.010000 30.3944444 0.010000 30.3972222 0.010000 30.4000000 0.010000 30.4027778 0.010000 30.4055556 0.010000 30.4083333 0.010000 30.4111111 0.010000 30.4138889 0.010000 30.4166667 0.010000 30.4194444 0.010000 30.4222222 0.010000 30.4250000 0.010000 30.4277778 0.010000 30.4305556 0.010000 30.4333333 0.010000 30.4361111 0.010000 30.4388889 0.010000 30.4416667 0.010000 30.4444444 0.010000 30.4472222 0.010000 30.4500000 0.010000 30.4527778 0.010000 30.4555556 0.010000 30.4583333 0.010000 30.4611111 0.010000 30.4638889 0.010000 30.4666667 0.010000 30.4694444 0.010000 30.4722222 0.010000 30.4750000 0.010000 30.4777778 0.010000 30.4805556 0.010000 30.4833333 0.010000 30.4861111 0.010000 30.4888889 0.010000 30.4916667 0.010000 30.4944444 0.010000 30.4972222 0.010000 30.5000000 0.010000 30.5027778 0.010000 30.5055556 0.010000 30.5083333 0.010000 30.5111111 0.010000 30.5138889 0.010000 30.5166667 0.010000 30.5194444 0.010000 30.5222222 0.010000 30.5250000 0.010000 30.5277778 0.010000 30.5305556 0.010000 30.5333333 0.010000 30.5361111 0.019808 30.5388889 0.044038 30.5416667 0.064808 30.5444444 0.080385 30.5472222 0.082115 30.5500000 0.057885 30.5527778 0.018077 30.5555556 0.010000 30.5583333 0.010000 30.5611111 0.010000 30.5638889 0.010000 30.5666667 0.030192 30.5694444 0.125385 30.5722222 0.230962 30.5750000 0.329615 30.5777778 0.426538 30.5805556 0.520000 30.5833333 0.603077 30.5861111 0.667115 30.5888889 0.720769 30.5916667 0.746731 30.5944444 0.745000 30.5972222 0.719038 30.6000000 0.677500 30.6027778 0.611731 30.6055556 0.530385 30.6083333 0.438654 30.6111111 0.350385 30.6138889 0.269038 30.6166667 0.179038 30.6194444 0.090769 30.6222222 0.011154 30.6250000 0.010000 30.6277778 0.010000 30.6305556 0.010000 30.6333333 0.010000 30.6361111 0.010000 30.6388889 0.010000 30.6416667 0.010000 30.6444444 0.010000 30.6472222 0.010000 30.6500000 0.010000 30.6527778 0.010000 30.6555556 0.010000 30.6583333 0.010000 30.6611111 0.010000 30.6638889 0.010000 30.6666667 0.010000 30.6694444 0.010000 30.6722222 0.010000 30.6750000 0.010000 30.6777778 0.010000 30.6805556 0.010000 30.6833333 0.010000 30.6861111 0.010000 30.6888889 0.010000 30.6916667 0.010000 30.6944444 0.010000 30.6972222 0.010000 30.7000000 0.010000 30.7027778 0.010000 30.7055556 0.010000 30.7083333 0.010000 30.7111111 0.010000 30.7138889 0.010000 30.7166667 0.010000 30.7194444 0.010000 30.7222222 0.010000 30.7250000 0.010000 30.7277778 0.010000 30.7305556 0.010000 30.7333333 0.010000 30.7361111 0.010000 30.7388889 0.010000 30.7416667 0.010000 30.7444444 0.010000 30.7472222 0.010000 30.7500000 0.010000 30.7527778 0.010000 30.7555556 0.010000 30.7583333 0.010000 30.7611111 0.010000 30.7638889 0.010000 30.7666667 0.010000 30.7694444 0.010000 30.7722222 0.010000 30.7750000 0.010000 30.7777778 0.010000 30.7805556 0.010000 30.7833333 0.010000 30.7861111 0.010000 30.7888889 0.010000 30.7916667 0.010000 30.7944444 0.010000 30.7972222 0.010000 30.8000000 0.010000 30.8027778 0.010000 30.8055556 0.010000 30.8083333 0.010000 30.8111111 0.010000 30.8138889 0.010000 30.8166667 0.010000 30.8194444 0.010000 30.8222222 0.010000 30.8250000 0.010000 30.8277778 0.010000 30.8305556 0.010000 30.8333333 0.010000 30.8361111 0.010000 30.8388889 0.010000 30.8416667 0.010000 30.8444444 0.010000 30.8472222 0.010000 30.8500000 0.010000 30.8527778 0.010000 30.8555556 0.010000 30.8583333 0.010000 30.8611111 0.010000 30.8638889 0.010000 30.8666667 0.010000 30.8694444 0.010000 30.8722222 0.010000 30.8750000 0.010000 30.8777778 0.010000 30.8805556 0.010000 30.8833333 0.010000 30.8861111 0.010000 30.8888889 0.010000 30.8916667 0.010000 31.5277778 0.010000 31.5305556 0.010000 31.5333333 0.010000 31.5361111 0.010000 31.5388889 0.010000 31.5416667 0.010000 31.5444444 0.010000 31.5472222 0.010000 31.5500000 0.010000 31.5527778 0.010000 31.5555556 0.010000 31.5583333 0.010000 31.5611111 0.010000 31.5638889 0.010000 31.5666667 0.010000 31.5694444 0.010000 31.5722222 0.010000 31.5750000 0.010000 31.5777778 0.010000 31.5805556 0.010000 31.5833333 0.010000 31.5861111 0.010000 31.5888889 0.010000 31.5916667 0.010000 31.5944444 0.010000 31.5972222 0.010000 31.6000000 0.010000 31.6027778 0.010000 31.6055556 0.010000 31.6083333 0.010000 31.6111111 0.010000 31.6138889 0.010000 31.6166667 0.010000 31.6194444 0.010000 31.6222222 0.010000 31.6250000 0.010000 31.6277778 0.010000 31.6305556 0.010000 31.6333333 0.010000 31.6361111 0.010000 31.6388889 0.010000 31.6416667 0.010000 31.6444444 0.010000 31.6472222 0.010000 31.6500000 0.010000 31.6527778 0.010000 31.6555556 0.010000 31.6583333 0.010000 31.6611111 0.010000 31.6638889 0.010000 31.6666667 0.010000 31.6694444 0.010000 31.6722222 0.010000 31.6750000 0.010000 31.6777778 0.010000 31.6805556 0.010000 31.6833333 0.010000 31.6861111 0.010000 31.6888889 0.010000 31.6916667 0.010000 31.6944444 0.010000 31.6972222 0.010000 31.7000000 0.010000 31.7027778 0.010000 31.7055556 0.010000 31.7083333 0.010000 31.7111111 0.010000 31.7138889 0.010000 31.7166667 0.010000 31.7194444 0.010000 31.7222222 0.030192 31.7250000 0.061346 31.7277778 0.075192 31.7305556 0.073462 31.7333333 0.042308 31.7361111 0.010000 31.7388889 0.010000 31.7416667 0.010000 31.7444444 0.010000 31.7472222 0.010000 31.7500000 0.010000 31.7527778 0.113269 31.7555556 0.220577 31.7583333 0.322692 31.7611111 0.421346 31.7638889 0.500962 31.7666667 0.568462 31.7694444 0.610000 31.7722222 0.634231 31.7750000 0.637692 31.7777778 0.623846 31.7805556 0.606538 31.7833333 0.563269 31.7861111 0.514808 31.7888889 0.450769 31.7916667 0.379808 31.7944444 0.308846 31.7972222 0.241346 31.8000000 0.163462 31.8027778 0.083846 31.8055556 0.010000 31.8083333 0.010000 31.8111111 0.010000 31.8138889 0.010000 31.8166667 0.010000 31.8194444 0.010000 31.8222222 0.010000 31.8250000 0.010000 31.8277778 0.010000 31.8305556 0.010000 31.8333333 0.010000 31.8361111 0.010000 31.8388889 0.010000 31.8416667 0.010000 31.8444444 0.010000 31.8472222 0.010000 31.8500000 0.010000 31.8527778 0.010000 31.8555556 0.010000 31.8583333 0.010000 31.8611111 0.010000 31.8638889 0.010000 31.8666667 0.010000 31.8694444 0.010000 31.8722222 0.010000 31.8750000 0.010000 31.8777778 0.010000 31.8805556 0.010000 31.8833333 0.010000 31.8861111 0.010000 31.8888889 0.010000 31.8916667 0.010000 31.8944444 0.010000 31.8972222 0.010000 31.9000000 0.010000 31.9027778 0.010000 31.9055556 0.010000 31.9083333 0.010000 31.9111111 0.010000 31.9138889 0.010000 31.9166667 0.010000 31.9194444 0.010000 31.9222222 0.010000 31.9250000 0.010000 31.9277778 0.010000 31.9305556 0.010000 31.9333333 0.010000 31.9361111 0.010000 31.9388889 0.010000 31.9416667 0.010000 31.9444444 0.010000 31.9472222 0.010000 31.9500000 0.010000 31.9527778 0.010000 31.9555556 0.010000 31.9583333 0.010000 31.9611111 0.010000 31.9638889 0.010000 31.9666667 0.010000 31.9694444 0.010000 31.9722222 0.010000 31.9750000 0.010000 31.9777778 0.010000 31.9805556 0.010000 31.9833333 0.010000 31.9861111 0.010000 31.9888889 0.010000 31.9916667 0.010000 31.9944444 0.010000 31.9972222 0.010000 32.0000000 0.010000 32.0027778 0.010000 32.0055556 0.010000 32.0083333 0.010000 32.0111111 0.010000 32.0138889 0.010000 32.0166667 0.010000 32.0194444 0.010000 32.0222222 0.010000 32.0250000 0.010000 32.0277778 0.010000 32.0305556 0.010000 32.0333333 0.010000 32.0361111 0.010000 32.0388889 0.010000 32.0416667 0.010000 32.0444444 0.010000 32.0472222 0.010000 32.0500000 0.010000 32.0527778 0.010000 32.0555556 0.010000 32.0583333 0.010000 32.0611111 0.010000 32.0638889 0.010000 32.0666667 0.010000 32.0694444 0.010000 32.0722222 0.010000 32.0750000 0.010000 32.7055556 0.010000 32.7083333 0.010000 32.7111111 0.010000 32.7138889 0.010000 32.7166667 0.010000 32.7194444 0.010000 32.7222222 0.010000 32.7250000 0.010000 32.7277778 0.010000 32.7305556 0.010000 32.7333333 0.010000 32.7361111 0.010000 32.7388889 0.010000 32.7416667 0.010000 32.7444444 0.010000 32.7472222 0.010000 32.7500000 0.010000 32.7527778 0.010000 32.7555556 0.010000 32.7583333 0.010000 32.7611111 0.010000 32.7638889 0.010000 32.7666667 0.010000 32.7694444 0.010000 32.7722222 0.010000 32.7750000 0.010000 32.7777778 0.010000 32.7805556 0.010000 32.7833333 0.010000 32.7861111 0.010000 32.7888889 0.010000 32.7916667 0.010000 32.7944444 0.010000 32.7972222 0.010000 32.8000000 0.010000 32.8027778 0.010000 32.8055556 0.010000 32.8083333 0.010000 32.8111111 0.010000 32.8138889 0.010000 32.8166667 0.010000 32.8194444 0.010000 32.8222222 0.010000 32.8250000 0.010000 32.8277778 0.010000 32.8305556 0.010000 32.8333333 0.010000 32.8361111 0.010000 32.8388889 0.010000 32.8416667 0.010000 32.8444444 0.010000 32.8472222 0.010000 32.8500000 0.010000 32.8527778 0.010000 32.8555556 0.010000 32.8583333 0.010000 32.8611111 0.010000 32.8638889 0.010000 32.8666667 0.010000 32.8694444 0.010000 32.8722222 0.010000 32.8750000 0.010000 32.8777778 0.010000 32.8805556 0.010000 32.8833333 0.010000 32.8861111 0.010000 32.8888889 0.010000 32.8916667 0.010000 32.8944444 0.010000 32.8972222 0.010000 32.9000000 0.010000 32.9027778 0.019808 32.9055556 0.040577 32.9083333 0.059615 32.9111111 0.063077 32.9138889 0.050962 32.9166667 0.010000 32.9194444 0.010000 32.9222222 0.010000 32.9250000 0.010000 32.9277778 0.010000 32.9305556 0.023269 32.9333333 0.128846 32.9361111 0.241346 32.9388889 0.352115 32.9416667 0.452500 32.9444444 0.535577 32.9472222 0.604808 32.9500000 0.649808 32.9527778 0.672308 32.9555556 0.670577 32.9583333 0.646346 32.9611111 0.599615 32.9638889 0.533846 32.9666667 0.449038 32.9694444 0.369423 32.9722222 0.281154 32.9750000 0.198077 32.9777778 0.120192 32.9805556 0.044038 32.9833333 0.010000 32.9861111 0.010000 32.9888889 0.010000 32.9916667 0.010000 32.9944444 0.010000 32.9972222 0.010000 33.0000000 0.010000 33.0027778 0.010000 33.0055556 0.010000 33.0083333 0.010000 33.0111111 0.010000 33.0138889 0.010000 33.0166667 0.010000 33.0194444 0.010000 33.0222222 0.010000 33.0250000 0.010000 33.0277778 0.010000 33.0305556 0.010000 33.0333333 0.010000 33.0361111 0.010000 33.0388889 0.010000 33.0416667 0.010000 33.0444444 0.010000 33.0472222 0.010000 33.0500000 0.010000 33.0527778 0.010000 33.0555556 0.010000 33.0583333 0.010000 33.0611111 0.010000 33.0638889 0.010000 33.0666667 0.010000 33.0694444 0.010000 33.0722222 0.010000 33.0750000 0.010000 33.0777778 0.010000 33.0805556 0.010000 33.0833333 0.010000 33.0861111 0.010000 33.0888889 0.010000 33.0916667 0.010000 33.0944444 0.010000 33.0972222 0.010000 33.1000000 0.010000 33.1027778 0.010000 33.1055556 0.010000 33.1083333 0.010000 33.1111111 0.010000 33.1138889 0.010000 33.1166667 0.010000 33.1194444 0.010000 33.1222222 0.010000 33.1250000 0.010000 33.1277778 0.010000 33.1305556 0.010000 33.1333333 0.010000 33.1361111 0.010000 33.1388889 0.010000 33.1416667 0.010000 33.1444444 0.010000 33.1472222 0.010000 33.1500000 0.010000 33.1527778 0.010000 33.1555556 0.010000 33.1583333 0.010000 33.1611111 0.010000 33.1638889 0.010000 33.1666667 0.010000 33.1694444 0.010000 33.1722222 0.010000 33.1750000 0.010000 33.1777778 0.010000 33.1805556 0.010000 33.1833333 0.010000 33.1861111 0.010000 33.1888889 0.010000 33.1916667 0.010000 33.1944444 0.010000 33.1972222 0.010000 33.2000000 0.010000 33.2027778 0.010000 33.2055556 0.010000 33.2083333 0.010000 33.2111111 0.010000 33.2138889 0.010000 33.2166667 0.010000 33.2194444 0.010000 33.2222222 0.010000 33.2250000 0.010000 33.2277778 0.010000 33.2305556 0.010000 33.2333333 0.010000 33.2361111 0.010000 33.2388889 0.010000 33.2416667 0.010000 33.2444444 0.010000 33.2472222 0.010000 33.2500000 0.010000 33.2527778 0.010000 33.9138889 0.010000 33.9166667 0.010000 33.9194444 0.010000 33.9222222 0.010000 33.9250000 0.010000 33.9277778 0.010000 33.9305556 0.010000 33.9333333 0.010000 33.9361111 0.010000 33.9388889 0.010000 33.9416667 0.010000 33.9444444 0.010000 33.9472222 0.010000 33.9500000 0.010000 33.9527778 0.010000 33.9555556 0.010000 33.9583333 0.010000 33.9611111 0.010000 33.9638889 0.010000 33.9666667 0.010000 33.9694444 0.010000 33.9722222 0.010000 33.9750000 0.010000 33.9777778 0.010000 33.9805556 0.010000 33.9833333 0.010000 33.9861111 0.010000 33.9888889 0.010000 33.9916667 0.010000 33.9944444 0.010000 33.9972222 0.010000 34.0000000 0.010000 34.0027778 0.010000 34.0055556 0.010000 34.0083333 0.010000 34.0111111 0.010000 34.0138889 0.010000 34.0166667 0.010000 34.0194444 0.010000 34.0222222 0.010000 34.0250000 0.010000 34.0277778 0.010000 34.0305556 0.010000 34.0333333 0.010000 34.0361111 0.010000 34.0388889 0.010000 34.0416667 0.010000 34.0444444 0.010000 34.0472222 0.010000 34.0500000 0.010000 34.0527778 0.010000 34.0555556 0.010000 34.0583333 0.010000 34.0611111 0.010000 34.0638889 0.010000 34.0666667 0.010000 34.0694444 0.010000 34.0722222 0.010000 34.0750000 0.010000 34.0777778 0.010000 34.0805556 0.010000 34.0833333 0.010000 34.0861111 0.010000 34.0888889 0.010000 34.0916667 0.010000 34.0944444 0.010000 34.0972222 0.010000 34.1000000 0.010000 34.1027778 0.010000 34.1055556 0.025000 34.1083333 0.054423 34.1111111 0.073462 34.1138889 0.090769 34.1166667 0.092500 34.1194444 0.076923 34.1222222 0.044038 34.1250000 0.010000 34.1277778 0.010000 34.1305556 0.010000 34.1333333 0.010000 34.1361111 0.010000 34.1388889 0.076923 34.1416667 0.177308 34.1444444 0.284615 34.1472222 0.395385 34.1500000 0.492308 34.1527778 0.582308 34.1555556 0.656731 34.1583333 0.705192 34.1611111 0.729423 34.1638889 0.722500 34.1666667 0.696538 34.1694444 0.649808 34.1722222 0.585769 34.1750000 0.507885 34.1777778 0.424808 34.1805556 0.343462 34.1833333 0.260385 34.1861111 0.177308 34.1888889 0.095962 34.1916667 0.023269 34.1944444 0.010000 34.1972222 0.010000 34.2000000 0.010000 34.2027778 0.010000 34.2055556 0.010000 34.2083333 0.010000 34.2111111 0.010000 34.2138889 0.010000 34.2166667 0.010000 34.2194444 0.010000 34.2222222 0.010000 34.2250000 0.010000 34.2277778 0.010000 34.2305556 0.010000 34.2333333 0.010000 34.2361111 0.010000 34.2388889 0.010000 34.2416667 0.010000 34.2444444 0.010000 34.2472222 0.010000 34.2500000 0.010000 34.2527778 0.010000 34.2555556 0.010000 34.2583333 0.010000 34.2611111 0.010000 34.2638889 0.010000 34.2666667 0.010000 34.2694444 0.010000 34.2722222 0.010000 34.2750000 0.010000 34.2777778 0.010000 34.2805556 0.010000 34.2833333 0.010000 34.2861111 0.010000 34.2888889 0.010000 34.2916667 0.010000 34.2944444 0.010000 34.2972222 0.010000 34.3000000 0.010000 34.3027778 0.010000 34.3055556 0.010000 34.3083333 0.010000 34.3111111 0.010000 34.3138889 0.010000 34.3166667 0.010000 34.3194444 0.010000 34.3222222 0.010000 34.3250000 0.010000 34.3277778 0.010000 34.3305556 0.010000 34.3333333 0.010000 34.3361111 0.010000 34.3388889 0.010000 34.3416667 0.010000 34.3444444 0.010000 34.3472222 0.010000 34.3500000 0.010000 34.3527778 0.010000 34.3555556 0.010000 34.3583333 0.010000 34.3611111 0.010000 34.3638889 0.010000 34.3666667 0.010000 34.3694444 0.010000 34.3722222 0.010000 34.3750000 0.010000 34.3777778 0.010000 34.3805556 0.010000 34.3833333 0.010000 34.3861111 0.010000 34.3888889 0.010000 34.3916667 0.010000 34.3944444 0.010000 34.3972222 0.010000 34.4000000 0.010000 34.4027778 0.010000 34.4055556 0.010000 34.4083333 0.010000 34.4111111 0.010000 34.4138889 0.010000 34.4166667 0.010000 34.4194444 0.010000 34.4222222 0.010000 34.4250000 0.010000 34.4277778 0.010000 34.4305556 0.010000 34.4333333 0.010000 34.4361111 0.010000 34.4388889 0.010000 34.4416667 0.010000 34.4444444 0.010000 34.4472222 0.010000 34.4500000 0.010000 34.4527778 0.010000 34.4555556 0.010000 34.4583333 0.010000 34.4611111 0.010000 35.1055556 0.030192 35.1083333 0.030192 35.1111111 0.037115 35.1138889 0.033654 35.1166667 0.037115 35.1194444 0.037115 35.1222222 0.042308 35.1250000 0.042308 35.1277778 0.044038 35.1305556 0.044038 35.1333333 0.044038 35.1361111 0.042308 35.1388889 0.040577 35.1416667 0.042308 35.1444444 0.044038 35.1472222 0.045769 35.1500000 0.052692 35.1527778 0.047500 35.1555556 0.054423 35.1583333 0.056154 35.1611111 0.050962 35.1638889 0.054423 35.1666667 0.054423 35.1694444 0.057885 35.1722222 0.057885 35.1750000 0.061346 35.1777778 0.064808 35.1805556 0.066538 35.1833333 0.068269 35.1861111 0.064808 35.1888889 0.064808 35.1916667 0.064808 35.1944444 0.059615 35.1972222 0.059615 35.2000000 0.052692 35.2027778 0.049231 35.2055556 0.044038 35.2083333 0.045769 35.2111111 0.049231 35.2138889 0.057885 35.2166667 0.066538 35.2194444 0.068269 35.2222222 0.071731 35.2250000 0.070000 35.2277778 0.070000 35.2305556 0.059615 35.2333333 0.054423 35.2361111 0.047500 35.2388889 0.038846 35.2416667 0.033654 35.2444444 0.033654 35.2472222 0.033654 35.2500000 0.035385 35.2527778 0.037115 35.2555556 0.038846 35.2583333 0.038846 35.2611111 0.037115 35.2638889 0.038846 35.2666667 0.035385 35.2694444 0.033654 35.2722222 0.030192 35.2750000 0.026731 35.2777778 0.025000 35.2805556 0.025000 35.2833333 0.023269 35.2861111 0.028462 35.2888889 0.038846 35.2916667 0.059615 35.2944444 0.087308 35.2972222 0.118462 35.3000000 0.146154 35.3027778 0.172115 35.3055556 0.185962 35.3083333 0.179038 35.3111111 0.156538 35.3138889 0.115000 35.3166667 0.063077 35.3194444 0.010000 35.3222222 0.010000 35.3250000 0.010000 35.3277778 0.047500 35.3305556 0.125385 35.3333333 0.215385 35.3361111 0.307115 35.3388889 0.395385 35.3416667 0.478462 35.3444444 0.552885 35.3472222 0.618654 35.3500000 0.668846 35.3527778 0.693077 35.3555556 0.698269 35.3583333 0.684423 35.3611111 0.644615 35.3638889 0.584038 35.3666667 0.509615 35.3694444 0.423077 35.3722222 0.343462 35.3750000 0.258654 35.3777778 0.175577 35.3805556 0.106346 35.3833333 0.044038 35.3861111 0.010000 35.3888889 0.010000 35.3916667 0.010000 35.3944444 0.010000 35.3972222 0.010000 35.4000000 0.010000 35.4027778 0.010000 35.4055556 0.010000 35.4083333 0.010000 35.4111111 0.010000 35.4138889 0.010000 35.4166667 0.010000 35.4194444 0.010000 35.4222222 0.011154 35.4250000 0.011154 35.4277778 0.011154 35.4305556 0.010000 35.4333333 0.010000 35.4361111 0.010000 35.4388889 0.010000 35.4416667 0.010000 35.4444444 0.010000 35.4472222 0.010000 35.4500000 0.010000 35.4527778 0.010000 35.4555556 0.010000 35.4583333 0.010000 35.4611111 0.010000 35.4638889 0.010000 35.4666667 0.010000 35.4694444 0.010000 35.4722222 0.010000 35.4750000 0.010000 35.4777778 0.010000 35.4805556 0.010000 35.4833333 0.010000 35.4861111 0.010000 35.4888889 0.010000 35.4916667 0.010000 35.4944444 0.010000 35.4972222 0.010000 35.5000000 0.010000 35.5027778 0.010000 35.5055556 0.010000 35.5083333 0.010000 35.5111111 0.010000 35.5138889 0.010000 35.5166667 0.010000 35.5194444 0.010000 35.5222222 0.010000 35.5250000 0.010000 35.5277778 0.010000 35.5305556 0.010000 35.5333333 0.010000 35.5361111 0.010000 35.5388889 0.010000 35.5416667 0.010000 35.5444444 0.010000 35.5472222 0.010000 35.5500000 0.010000 35.5527778 0.010000 35.5555556 0.010000 35.5583333 0.010000 35.5611111 0.010000 35.5638889 0.010000 35.5666667 0.010000 35.5694444 0.010000 35.5722222 0.010000 35.5750000 0.010000 35.5777778 0.010000 35.5805556 0.010000 35.5833333 0.010000 35.5861111 0.010000 35.5888889 0.010000 35.5916667 0.010000 35.5944444 0.010000 35.5972222 0.010000 35.6000000 0.010000 35.6027778 0.010000 35.6055556 0.010000 35.6083333 0.010000 35.6111111 0.010000 35.6138889 0.010000 35.6166667 0.010000 35.6194444 0.010000 35.6222222 0.010000 35.6250000 0.010000 35.6277778 0.010000 35.6305556 0.010000 35.6333333 0.010000 35.6361111 0.010000 35.6388889 0.010000 35.6416667 0.010000 35.6444444 0.010000 35.6472222 0.010000 35.6500000 0.010000 35.6527778 0.010000 36.2944444 0.030192 36.2972222 0.026731 36.3000000 0.025000 36.3027778 0.019808 36.3055556 0.019808 36.3083333 0.019808 36.3111111 0.023269 36.3138889 0.026731 36.3166667 0.025000 36.3194444 0.030192 36.3222222 0.031923 36.3250000 0.038846 36.3277778 0.038846 36.3305556 0.031923 36.3333333 0.028462 36.3361111 0.026731 36.3388889 0.025000 36.3416667 0.026731 36.3444444 0.033654 36.3472222 0.035385 36.3500000 0.040577 36.3527778 0.045769 36.3555556 0.049231 36.3583333 0.052692 36.3611111 0.052692 36.3638889 0.047500 36.3666667 0.044038 36.3694444 0.040577 36.3722222 0.028462 36.3750000 0.026731 36.3777778 0.025000 36.3805556 0.023269 36.3833333 0.025000 36.3861111 0.028462 36.3888889 0.028462 36.3916667 0.035385 36.3944444 0.035385 36.3972222 0.037115 36.4000000 0.042308 36.4027778 0.038846 36.4055556 0.037115 36.4083333 0.037115 36.4111111 0.035385 36.4138889 0.033654 36.4166667 0.031923 36.4194444 0.025000 36.4222222 0.023269 36.4250000 0.019808 36.4277778 0.011154 36.4305556 0.010000 36.4333333 0.010000 36.4361111 0.010000 36.4388889 0.010000 36.4416667 0.010000 36.4444444 0.010000 36.4472222 0.010000 36.4500000 0.010000 36.4527778 0.010000 36.4555556 0.010000 36.4583333 0.010000 36.4611111 0.010000 36.4638889 0.010000 36.4666667 0.010000 36.4694444 0.010000 36.4722222 0.010000 36.4750000 0.023269 36.4777778 0.049231 36.4805556 0.080385 36.4833333 0.113269 36.4861111 0.135769 36.4888889 0.149615 36.4916667 0.153077 36.4944444 0.137500 36.4972222 0.104615 36.5000000 0.052692 36.5027778 0.010000 36.5055556 0.010000 36.5083333 0.010000 36.5111111 0.016346 36.5138889 0.085577 36.5166667 0.175577 36.5194444 0.270769 36.5222222 0.365962 36.5250000 0.450769 36.5277778 0.526923 36.5305556 0.596154 36.5333333 0.649808 36.5361111 0.693077 36.5388889 0.719038 36.5416667 0.725962 36.5444444 0.717308 36.5472222 0.705192 36.5500000 0.670577 36.5527778 0.620385 36.5555556 0.561538 36.5583333 0.485385 36.5611111 0.410962 36.5638889 0.333077 36.5666667 0.260385 36.5694444 0.185962 36.5722222 0.108077 36.5750000 0.045769 36.5777778 0.010000 36.5805556 0.010000 36.5833333 0.010000 36.5861111 0.010000 36.5888889 0.010000 36.5916667 0.010000 36.5944444 0.010000 36.5972222 0.010000 36.6000000 0.010000 36.6027778 0.010000 36.6055556 0.010000 36.6083333 0.010000 36.6111111 0.010000 36.6138889 0.010000 36.6166667 0.010000 36.6194444 0.010000 36.6222222 0.010000 36.6250000 0.010000 36.6277778 0.010000 36.6305556 0.010000 36.6333333 0.010000 36.6361111 0.010000 36.6388889 0.010000 36.6416667 0.010000 36.6444444 0.010000 36.6472222 0.010000 36.6500000 0.010000 36.6527778 0.010000 36.6555556 0.010000 36.6583333 0.010000 36.6611111 0.010000 36.6638889 0.010000 36.6666667 0.010000 36.6694444 0.010000 36.6722222 0.010000 36.6750000 0.010000 36.6777778 0.010000 36.6805556 0.010000 36.6833333 0.010000 36.6861111 0.010000 36.6888889 0.010000 36.6916667 0.010000 36.6944444 0.010000 36.6972222 0.010000 36.7000000 0.010000 36.7027778 0.010000 36.7055556 0.010000 36.7083333 0.010000 36.7111111 0.010000 36.7138889 0.010000 36.7166667 0.010000 36.7194444 0.010000 36.7222222 0.010000 36.7250000 0.010000 36.7277778 0.010000 36.7305556 0.010000 36.7333333 0.010000 36.7361111 0.010000 36.7388889 0.010000 36.7416667 0.010000 36.7444444 0.010000 36.7472222 0.010000 36.7500000 0.010000 36.7527778 0.010000 36.7555556 0.010000 36.7583333 0.010000 36.7611111 0.010000 36.7638889 0.010000 36.7666667 0.010000 36.7694444 0.010000 36.7722222 0.010000 36.7750000 0.010000 36.7777778 0.010000 36.7805556 0.010000 36.7833333 0.010000 36.7861111 0.010000 36.7888889 0.010000 36.7916667 0.010000 36.7944444 0.010000 36.7972222 0.010000 36.8000000 0.010000 36.8027778 0.010000 36.8055556 0.010000 36.8083333 0.010000 36.8111111 0.010000 36.8138889 0.010000 36.8166667 0.010000 36.8194444 0.010000 36.8222222 0.010000 36.8250000 0.010000 36.8277778 0.010000 36.8305556 0.010000 36.8333333 0.010000 36.8361111 0.010000 36.8388889 0.010000 36.8416667 0.010000 37.5527778 0.010000 37.5555556 0.010000 37.5583333 0.010000 37.5611111 0.010000 37.5638889 0.010000 37.5666667 0.010000 37.5694444 0.010000 37.5722222 0.010000 37.5750000 0.010000 37.5777778 0.010000 37.5805556 0.010000 37.5833333 0.010000 37.5861111 0.010000 37.5888889 0.010000 37.5916667 0.010000 37.5944444 0.010000 37.5972222 0.010000 37.6000000 0.010000 37.6027778 0.010000 37.6055556 0.010000 37.6083333 0.010000 37.6111111 0.010000 37.6138889 0.010000 37.6166667 0.010000 37.6194444 0.010000 37.6222222 0.010000 37.6250000 0.010000 37.6277778 0.010000 37.6305556 0.010000 37.6333333 0.010000 37.6361111 0.010000 37.6388889 0.010000 37.6416667 0.010000 37.6444444 0.010000 37.6472222 0.010000 37.6500000 0.010000 37.6527778 0.010000 37.6555556 0.010000 37.6583333 0.010000 37.6611111 0.010000 37.6638889 0.010000 37.6666667 0.010000 37.6694444 0.010000 37.6722222 0.010000 37.6750000 0.010000 37.6777778 0.010000 37.6805556 0.010000 37.6833333 0.010000 37.6861111 0.010000 37.6888889 0.010000 37.6916667 0.010000 37.6944444 0.010000 37.6972222 0.010000 37.7000000 0.010000 37.7027778 0.010000 37.7055556 0.010000 37.7083333 0.010000 37.7111111 0.010000 37.7138889 0.010000 37.7166667 0.010000 37.7194444 0.010000 37.7222222 0.010000 37.7250000 0.010000 37.7277778 0.010000 37.7305556 0.010000 37.7333333 0.010000 37.7361111 0.010000 37.7388889 0.010000 37.7416667 0.010000 37.7444444 0.038846 37.7472222 0.063077 37.7500000 0.083846 37.7527778 0.095962 37.7555556 0.085577 37.7583333 0.059615 37.7611111 0.012885 37.7638889 0.010000 37.7666667 0.010000 37.7694444 0.010000 37.7722222 0.010000 37.7750000 0.021538 37.7777778 0.101154 37.7805556 0.182500 37.7833333 0.269038 37.7861111 0.348654 37.7888889 0.430000 37.7916667 0.513077 37.7944444 0.587500 37.7972222 0.644615 37.8000000 0.689615 37.8027778 0.710385 37.8055556 0.698269 37.8083333 0.665385 37.8111111 0.610000 37.8138889 0.535577 37.8166667 0.449038 37.8194444 0.367692 37.8222222 0.282885 37.8250000 0.198077 37.8277778 0.113269 37.8305556 0.038846 37.8333333 0.010000 37.8361111 0.010000 37.8388889 0.010000 37.8416667 0.010000 37.8444444 0.010000 37.8472222 0.010000 37.8500000 0.010000 37.8527778 0.010000 37.8555556 0.010000 37.8583333 0.010000 37.8611111 0.010000 37.8638889 0.010000 37.8666667 0.010000 37.8694444 0.010000 37.8722222 0.010000 37.8750000 0.010000 37.8777778 0.010000 37.8805556 0.010000 37.8833333 0.010000 37.8861111 0.010000 37.8888889 0.010000 37.8916667 0.010000 37.8944444 0.010000 37.8972222 0.010000 37.9000000 0.010000 37.9027778 0.010000 37.9055556 0.010000 37.9083333 0.010000 37.9111111 0.010000 37.9138889 0.010000 37.9166667 0.010000 37.9194444 0.010000 37.9222222 0.010000 37.9250000 0.010000 37.9277778 0.010000 37.9305556 0.010000 37.9333333 0.010000 37.9361111 0.010000 37.9388889 0.010000 37.9416667 0.010000 37.9444444 0.010000 37.9472222 0.010000 37.9500000 0.010000 37.9527778 0.010000 37.9555556 0.010000 37.9583333 0.010000 37.9611111 0.010000 37.9638889 0.010000 37.9666667 0.010000 37.9694444 0.010000 37.9722222 0.010000 37.9750000 0.010000 37.9777778 0.010000 37.9805556 0.010000 37.9833333 0.010000 37.9861111 0.010000 37.9888889 0.010000 37.9916667 0.010000 37.9944444 0.010000 37.9972222 0.010000 38.0000000 0.010000 38.0027778 0.010000 38.0055556 0.010000 38.0083333 0.010000 38.0111111 0.010000 38.0138889 0.010000 38.0166667 0.010000 38.0194444 0.010000 38.0222222 0.010000 38.0250000 0.010000 38.0277778 0.010000 38.0305556 0.010000 38.0333333 0.010000 38.0361111 0.010000 38.0388889 0.010000 38.0416667 0.010000 38.0444444 0.010000 38.0472222 0.010000 38.0500000 0.010000 38.0527778 0.010000 38.0555556 0.010000 38.0583333 0.010000 38.0611111 0.010000 38.0638889 0.010000 38.0666667 0.010000 38.0694444 0.010000 38.0722222 0.010000 38.0750000 0.010000 38.0777778 0.010000 38.0805556 0.010000 38.0833333 0.010000 38.0861111 0.010000 38.0888889 0.010000 38.0916667 0.010000 38.0944444 0.010000 38.0972222 0.010000 38.1000000 0.010000 38.7694444 0.010000 38.7722222 0.010000 38.7750000 0.010000 38.7777778 0.010000 38.7805556 0.010000 38.7833333 0.010000 38.7861111 0.010000 38.7888889 0.010000 38.7916667 0.010000 38.7944444 0.010000 38.7972222 0.010000 38.8000000 0.010000 38.8027778 0.010000 38.8055556 0.010000 38.8083333 0.010000 38.8111111 0.010000 38.8138889 0.010000 38.8166667 0.010000 38.8194444 0.010000 38.8222222 0.010000 38.8250000 0.010000 38.8277778 0.010000 38.8305556 0.010000 38.8333333 0.010000 38.8361111 0.010000 38.8388889 0.010000 38.8416667 0.010000 38.8444444 0.010000 38.8472222 0.010000 38.8500000 0.010000 38.8527778 0.010000 38.8555556 0.010000 38.8583333 0.010000 38.8611111 0.010000 38.8638889 0.010000 38.8666667 0.010000 38.8694444 0.010000 38.8722222 0.010000 38.8750000 0.010000 38.8777778 0.010000 38.8805556 0.010000 38.8833333 0.010000 38.8861111 0.010000 38.8888889 0.010000 38.8916667 0.010000 38.8944444 0.010000 38.8972222 0.010000 38.9000000 0.010000 38.9027778 0.010000 38.9055556 0.010000 38.9083333 0.010000 38.9111111 0.010000 38.9138889 0.010000 38.9166667 0.010000 38.9194444 0.010000 38.9222222 0.010000 38.9250000 0.010000 38.9277778 0.010000 38.9305556 0.010000 38.9333333 0.010000 38.9361111 0.010000 38.9388889 0.010000 38.9416667 0.010000 38.9444444 0.010000 38.9472222 0.010000 38.9500000 0.010000 38.9527778 0.010000 38.9555556 0.010000 38.9583333 0.010000 38.9611111 0.035385 38.9638889 0.057885 38.9666667 0.082115 38.9694444 0.083846 38.9722222 0.073462 38.9750000 0.042308 38.9777778 0.010000 38.9805556 0.010000 38.9833333 0.010000 38.9861111 0.010000 38.9888889 0.010000 38.9916667 0.010000 38.9944444 0.047500 38.9972222 0.142692 39.0000000 0.229231 39.0027778 0.314038 39.0055556 0.397115 39.0083333 0.471538 39.0111111 0.535577 39.0138889 0.582308 39.0166667 0.610000 39.0194444 0.613462 39.0222222 0.594423 39.0250000 0.559808 39.0277778 0.494038 39.0305556 0.416154 39.0333333 0.334808 39.0361111 0.253462 39.0388889 0.177308 39.0416667 0.097692 39.0444444 0.026731 39.0472222 0.010000 39.0500000 0.010000 39.0527778 0.010000 39.0555556 0.010000 39.0583333 0.010000 39.0611111 0.010000 39.0638889 0.010000 39.0666667 0.010000 39.0694444 0.010000 39.0722222 0.010000 39.0750000 0.010000 39.0777778 0.010000 39.0805556 0.010000 39.0833333 0.010000 39.0861111 0.010000 39.0888889 0.010000 39.0916667 0.010000 39.0944444 0.010000 39.0972222 0.010000 39.1000000 0.010000 39.1027778 0.010000 39.1055556 0.010000 39.1083333 0.010000 39.1111111 0.010000 39.1138889 0.010000 39.1166667 0.010000 39.1194444 0.010000 39.1222222 0.010000 39.1250000 0.010000 39.1277778 0.010000 39.1305556 0.010000 39.1333333 0.010000 39.1361111 0.010000 39.1388889 0.010000 39.1416667 0.010000 39.1444444 0.010000 39.1472222 0.010000 39.1500000 0.010000 39.1527778 0.010000 39.1555556 0.010000 39.1583333 0.010000 39.1611111 0.010000 39.1638889 0.010000 39.1666667 0.010000 39.1694444 0.010000 39.1722222 0.010000 39.1750000 0.010000 39.1777778 0.010000 39.1805556 0.010000 39.1833333 0.010000 39.1861111 0.010000 39.1888889 0.010000 39.1916667 0.010000 39.1944444 0.010000 39.1972222 0.010000 39.2000000 0.010000 39.2027778 0.010000 39.2055556 0.010000 39.2083333 0.010000 39.2111111 0.010000 39.2138889 0.010000 39.2166667 0.010000 39.2194444 0.010000 39.2222222 0.010000 39.2250000 0.010000 39.2277778 0.010000 39.2305556 0.010000 39.2333333 0.010000 39.2361111 0.010000 39.2388889 0.010000 39.2416667 0.010000 39.2444444 0.010000 39.2472222 0.010000 39.2500000 0.010000 39.2527778 0.010000 39.2555556 0.010000 39.2583333 0.010000 39.2611111 0.010000 39.2638889 0.010000 39.2666667 0.010000 39.2694444 0.010000 39.2722222 0.010000 39.2750000 0.010000 39.2777778 0.010000 39.2805556 0.010000 39.2833333 0.010000 39.2861111 0.010000 39.2888889 0.010000 39.2916667 0.010000 39.2944444 0.010000 39.2972222 0.010000 39.3000000 0.010000 39.3027778 0.010000 39.3055556 0.010000 39.3083333 0.010000 39.3111111 0.010000 39.3138889 0.010000 39.3166667 0.010000 40.0083333 0.010000 40.0111111 0.010000 40.0138889 0.010000 40.0166667 0.010000 40.0194444 0.010000 40.0222222 0.010000 40.0250000 0.010000 40.0277778 0.010000 40.0305556 0.010000 40.0333333 0.010000 40.0361111 0.010000 40.0388889 0.010000 40.0416667 0.010000 40.0444444 0.010000 40.0472222 0.010000 40.0500000 0.010000 40.0527778 0.010000 40.0555556 0.010000 40.0583333 0.010000 40.0611111 0.010000 40.0638889 0.010000 40.0666667 0.010000 40.0694444 0.010000 40.0722222 0.010000 40.0750000 0.010000 40.0777778 0.010000 40.0805556 0.010000 40.0833333 0.010000 40.0861111 0.010000 40.0888889 0.010000 40.0916667 0.010000 40.0944444 0.010000 40.0972222 0.010000 40.1000000 0.010000 40.1027778 0.010000 40.1055556 0.010000 40.1083333 0.010000 40.1111111 0.010000 40.1138889 0.010000 40.1166667 0.010000 40.1194444 0.010000 40.1222222 0.010000 40.1250000 0.010000 40.1277778 0.010000 40.1305556 0.010000 40.1333333 0.010000 40.1361111 0.010000 40.1388889 0.010000 40.1416667 0.010000 40.1444444 0.010000 40.1472222 0.010000 40.1500000 0.010000 40.1527778 0.010000 40.1555556 0.010000 40.1583333 0.010000 40.1611111 0.010000 40.1638889 0.010000 40.1666667 0.010000 40.1694444 0.010000 40.1722222 0.010000 40.1750000 0.010000 40.1777778 0.010000 40.1805556 0.010000 40.1833333 0.010000 40.1861111 0.010000 40.1888889 0.010000 40.1916667 0.010000 40.1944444 0.010000 40.1972222 0.010000 40.2000000 0.010000 40.2027778 0.035385 40.2055556 0.057885 40.2083333 0.070000 40.2111111 0.071731 40.2138889 0.045769 40.2166667 0.010000 40.2194444 0.010000 40.2222222 0.010000 40.2250000 0.010000 40.2277778 0.010000 40.2305556 0.010000 40.2333333 0.030192 40.2361111 0.118462 40.2388889 0.217115 40.2416667 0.312308 40.2444444 0.404038 40.2472222 0.488846 40.2500000 0.559808 40.2527778 0.613462 40.2555556 0.646346 40.2583333 0.651538 40.2611111 0.634231 40.2638889 0.592692 40.2666667 0.539038 40.2694444 0.462885 40.2722222 0.386731 40.2750000 0.305385 40.2777778 0.225769 40.2805556 0.142692 40.2833333 0.061346 40.2861111 0.010000 40.2888889 0.010000 40.2916667 0.010000 40.2944444 0.010000 40.2972222 0.010000 40.3000000 0.010000 40.3027778 0.010000 40.3055556 0.010000 40.3083333 0.010000 40.3111111 0.010000 40.3138889 0.010000 40.3166667 0.010000 40.3194444 0.010000 40.3222222 0.010000 40.3250000 0.010000 40.3277778 0.010000 40.3305556 0.010000 40.3333333 0.010000 40.3361111 0.010000 40.3388889 0.010000 40.3416667 0.010000 40.3444444 0.010000 40.3472222 0.010000 40.3500000 0.010000 40.3527778 0.010000 40.3555556 0.010000 40.3583333 0.010000 40.3611111 0.010000 40.3638889 0.010000 40.3666667 0.010000 40.3694444 0.010000 40.3722222 0.010000 40.3750000 0.010000 40.3777778 0.010000 40.3805556 0.010000 40.3833333 0.010000 40.3861111 0.010000 40.3888889 0.010000 40.3916667 0.010000 40.3944444 0.010000 40.3972222 0.010000 40.4000000 0.010000 40.4027778 0.010000 40.4055556 0.010000 40.4083333 0.010000 40.4111111 0.010000 40.4138889 0.010000 40.4166667 0.010000 40.4194444 0.010000 40.4222222 0.010000 40.4250000 0.010000 40.4277778 0.010000 40.4305556 0.010000 40.4333333 0.010000 40.4361111 0.010000 40.4388889 0.010000 40.4416667 0.010000 40.4444444 0.010000 40.4472222 0.010000 40.4500000 0.010000 40.4527778 0.010000 40.4555556 0.010000 40.4583333 0.010000 40.4611111 0.010000 40.4638889 0.010000 40.4666667 0.010000 40.4694444 0.010000 40.4722222 0.010000 40.4750000 0.010000 40.4777778 0.010000 40.4805556 0.010000 40.4833333 0.010000 40.4861111 0.010000 40.4888889 0.010000 40.4916667 0.010000 40.4944444 0.010000 40.4972222 0.010000 40.5000000 0.010000 40.5027778 0.010000 40.5055556 0.010000 40.5083333 0.010000 40.5111111 0.010000 40.5138889 0.010000 40.5166667 0.010000 40.5194444 0.010000 40.5222222 0.010000 40.5250000 0.010000 40.5277778 0.010000 40.5305556 0.010000 40.5333333 0.010000 40.5361111 0.010000 40.5388889 0.010000 40.5416667 0.010000 40.5444444 0.010000 40.5472222 0.010000 40.5500000 0.010000 40.5527778 0.010000 40.5555556 0.010000 41.2611111 0.010000 41.2638889 0.010000 41.2666667 0.010000 41.2694444 0.010000 41.2722222 0.010000 41.2750000 0.010000 41.2777778 0.010000 41.2805556 0.010000 41.2833333 0.010000 41.2861111 0.010000 41.2888889 0.010000 41.2916667 0.010000 41.2944444 0.010000 41.2972222 0.010000 41.3000000 0.010000 41.3027778 0.010000 41.3055556 0.010000 41.3083333 0.010000 41.3111111 0.010000 41.3138889 0.010000 41.3166667 0.010000 41.3194444 0.010000 41.3222222 0.010000 41.3250000 0.010000 41.3277778 0.010000 41.3305556 0.010000 41.3333333 0.010000 41.3361111 0.010000 41.3388889 0.010000 41.3416667 0.010000 41.3444444 0.010000 41.3472222 0.010000 41.3500000 0.010000 41.3527778 0.010000 41.3555556 0.010000 41.3583333 0.010000 41.3611111 0.010000 41.3638889 0.010000 41.3666667 0.010000 41.3694444 0.010000 41.3722222 0.010000 41.3750000 0.010000 41.3777778 0.010000 41.3805556 0.010000 41.3833333 0.010000 41.3861111 0.010000 41.3888889 0.010000 41.3916667 0.010000 41.3944444 0.010000 41.3972222 0.010000 41.4000000 0.010000 41.4027778 0.010000 41.4055556 0.010000 41.4083333 0.010000 41.4111111 0.010000 41.4138889 0.010000 41.4166667 0.010000 41.4194444 0.010000 41.4222222 0.010000 41.4250000 0.010000 41.4277778 0.010000 41.4305556 0.010000 41.4333333 0.010000 41.4361111 0.010000 41.4388889 0.010000 41.4416667 0.010000 41.4444444 0.010000 41.4472222 0.010000 41.4500000 0.030192 41.4527778 0.052692 41.4555556 0.073462 41.4583333 0.085577 41.4611111 0.078654 41.4638889 0.052692 41.4666667 0.010000 41.4694444 0.010000 41.4722222 0.010000 41.4750000 0.010000 41.4777778 0.010000 41.4805556 0.010000 41.4833333 0.087308 41.4861111 0.182500 41.4888889 0.277692 41.4916667 0.367692 41.4944444 0.455962 41.4972222 0.530385 41.5000000 0.599615 41.5027778 0.653269 41.5055556 0.694808 41.5083333 0.715577 41.5111111 0.708654 41.5138889 0.696538 41.5166667 0.663654 41.5194444 0.620385 41.5222222 0.558077 41.5250000 0.487115 41.5277778 0.407500 41.5305556 0.331346 41.5333333 0.251731 41.5361111 0.175577 41.5388889 0.097692 41.5416667 0.025000 41.5444444 0.010000 41.5472222 0.010000 41.5500000 0.010000 41.5527778 0.010000 41.5555556 0.010000 41.5583333 0.010000 41.5611111 0.010000 41.5638889 0.010000 41.5666667 0.010000 41.5694444 0.010000 41.5722222 0.010000 41.5750000 0.010000 41.5777778 0.010000 41.5805556 0.010000 41.5833333 0.010000 41.5861111 0.010000 41.5888889 0.010000 41.5916667 0.010000 41.5944444 0.010000 41.5972222 0.010000 41.6000000 0.010000 41.6027778 0.010000 41.6055556 0.010000 41.6083333 0.010000 41.6111111 0.010000 41.6138889 0.010000 41.6166667 0.010000 41.6194444 0.010000 41.6222222 0.010000 41.6250000 0.010000 41.6277778 0.010000 41.6305556 0.010000 41.6333333 0.010000 41.6361111 0.010000 41.6388889 0.010000 41.6416667 0.010000 41.6444444 0.010000 41.6472222 0.010000 41.6500000 0.010000 41.6527778 0.010000 41.6555556 0.010000 41.6583333 0.010000 41.6611111 0.010000 41.6638889 0.010000 41.6666667 0.010000 41.6694444 0.010000 41.6722222 0.010000 41.6750000 0.010000 41.6777778 0.010000 41.6805556 0.010000 41.6833333 0.010000 41.6861111 0.010000 41.6888889 0.010000 41.6916667 0.010000 41.6944444 0.010000 41.6972222 0.010000 41.7000000 0.010000 41.7027778 0.010000 41.7055556 0.010000 41.7083333 0.010000 41.7111111 0.010000 41.7138889 0.010000 41.7166667 0.010000 41.7194444 0.010000 41.7222222 0.010000 41.7250000 0.010000 41.7277778 0.010000 41.7305556 0.010000 41.7333333 0.010000 41.7361111 0.010000 41.7388889 0.010000 41.7416667 0.010000 41.7444444 0.010000 41.7472222 0.010000 41.7500000 0.010000 41.7527778 0.010000 41.7555556 0.010000 41.7583333 0.010000 41.7611111 0.010000 41.7638889 0.010000 41.7666667 0.010000 41.7694444 0.010000 41.7722222 0.010000 41.7750000 0.010000 41.7777778 0.010000 41.7805556 0.010000 41.7833333 0.010000 41.7861111 0.010000 41.7888889 0.010000 41.7916667 0.010000 41.7944444 0.010000 41.7972222 0.010000 41.8000000 0.010000 41.8027778 0.010000 41.8055556 0.010000 41.8083333 0.010000 42.5166667 0.010000 42.5194444 0.010000 42.5222222 0.010000 42.5250000 0.010000 42.5277778 0.010000 42.5305556 0.010000 42.5333333 0.010000 42.5361111 0.010000 42.5388889 0.010000 42.5416667 0.010000 42.5444444 0.010000 42.5472222 0.010000 42.5500000 0.010000 42.5527778 0.010000 42.5555556 0.010000 42.5583333 0.010000 42.5611111 0.010000 42.5638889 0.010000 42.5666667 0.010000 42.5694444 0.010000 42.5722222 0.010000 42.5750000 0.010000 42.5777778 0.010000 42.5805556 0.010000 42.5833333 0.010000 42.5861111 0.010000 42.5888889 0.010000 42.5916667 0.010000 42.5944444 0.010000 42.5972222 0.010000 42.6000000 0.010000 42.6027778 0.010000 42.6055556 0.010000 42.6083333 0.010000 42.6111111 0.010000 42.6138889 0.010000 42.6166667 0.010000 42.6194444 0.010000 42.6222222 0.010000 42.6250000 0.010000 42.6277778 0.010000 42.6305556 0.010000 42.6333333 0.010000 42.6361111 0.010000 42.6388889 0.010000 42.6416667 0.010000 42.6444444 0.010000 42.6472222 0.010000 42.6500000 0.010000 42.6527778 0.010000 42.6555556 0.010000 42.6583333 0.010000 42.6611111 0.010000 42.6638889 0.010000 42.6666667 0.010000 42.6694444 0.010000 42.6722222 0.010000 42.6750000 0.010000 42.6777778 0.010000 42.6805556 0.010000 42.6833333 0.010000 42.6861111 0.010000 42.6888889 0.010000 42.6916667 0.010000 42.6944444 0.010000 42.6972222 0.010000 42.7000000 0.010000 42.7027778 0.010000 42.7055556 0.010000 42.7083333 0.010000 42.7111111 0.018077 42.7138889 0.050962 42.7166667 0.078654 42.7194444 0.095962 42.7222222 0.083846 42.7250000 0.047500 42.7277778 0.010000 42.7305556 0.010000 42.7333333 0.010000 42.7361111 0.010000 42.7388889 0.010000 42.7416667 0.101154 42.7444444 0.206731 42.7472222 0.314038 42.7500000 0.417885 42.7527778 0.506154 42.7555556 0.582308 42.7583333 0.632500 42.7611111 0.661923 42.7638889 0.670577 42.7666667 0.658462 42.7694444 0.627308 42.7722222 0.585769 42.7750000 0.525192 42.7777778 0.459423 42.7805556 0.383269 42.7833333 0.312308 42.7861111 0.234423 42.7888889 0.154808 42.7916667 0.073462 42.7944444 0.010000 42.7972222 0.010000 42.8000000 0.010000 42.8027778 0.010000 42.8055556 0.010000 42.8083333 0.010000 42.8111111 0.010000 42.8138889 0.010000 42.8166667 0.010000 42.8194444 0.010000 42.8222222 0.010000 42.8250000 0.010000 42.8277778 0.010000 42.8305556 0.010000 42.8333333 0.010000 42.8361111 0.010000 42.8388889 0.010000 42.8416667 0.010000 42.8444444 0.010000 42.8472222 0.010000 42.8500000 0.010000 42.8527778 0.010000 42.8555556 0.010000 42.8583333 0.010000 42.8611111 0.010000 42.8638889 0.010000 42.8666667 0.010000 42.8694444 0.010000 42.8722222 0.010000 42.8750000 0.010000 42.8777778 0.010000 42.8805556 0.010000 42.8833333 0.010000 42.8861111 0.010000 42.8888889 0.010000 42.8916667 0.010000 42.8944444 0.010000 42.8972222 0.010000 42.9000000 0.010000 42.9027778 0.010000 42.9055556 0.010000 42.9083333 0.010000 42.9111111 0.010000 42.9138889 0.010000 42.9166667 0.010000 42.9194444 0.010000 42.9222222 0.010000 42.9250000 0.010000 42.9277778 0.010000 42.9305556 0.010000 42.9333333 0.010000 42.9361111 0.010000 42.9388889 0.010000 42.9416667 0.010000 42.9444444 0.010000 42.9472222 0.010000 42.9500000 0.010000 42.9527778 0.010000 42.9555556 0.010000 42.9583333 0.010000 42.9611111 0.010000 42.9638889 0.010000 42.9666667 0.010000 42.9694444 0.010000 42.9722222 0.010000 42.9750000 0.010000 42.9777778 0.010000 42.9805556 0.010000 42.9833333 0.010000 42.9861111 0.010000 42.9888889 0.010000 42.9916667 0.010000 42.9944444 0.010000 42.9972222 0.010000 43.0000000 0.010000 43.0027778 0.010000 43.0055556 0.010000 43.0083333 0.010000 43.0111111 0.010000 43.0138889 0.010000 43.0166667 0.010000 43.0194444 0.010000 43.0222222 0.010000 43.0250000 0.010000 43.0277778 0.010000 43.0305556 0.010000 43.0333333 0.010000 43.0361111 0.010000 43.0388889 0.010000 43.0416667 0.010000 43.0444444 0.010000 43.0472222 0.010000 43.0500000 0.010000 43.0527778 0.010000 43.0555556 0.010000 43.0583333 0.010000 43.0611111 0.010000 43.0638889 0.010000 43.7166667 0.010000 43.7194444 0.010000 43.7222222 0.010000 43.7250000 0.010000 43.7277778 0.010000 43.7305556 0.010000 43.7333333 0.010000 43.7361111 0.010000 43.7388889 0.010000 43.7416667 0.010000 43.7444444 0.010000 43.7472222 0.010000 43.7500000 0.010000 43.7527778 0.010000 43.7555556 0.010000 43.7583333 0.010000 43.7611111 0.010000 43.7638889 0.010000 43.7666667 0.010000 43.7694444 0.010000 43.7722222 0.010000 43.7750000 0.010000 43.7777778 0.010000 43.7805556 0.010000 43.7833333 0.010000 43.7861111 0.010000 43.7888889 0.010000 43.7916667 0.010000 43.7944444 0.010000 43.7972222 0.010000 43.8000000 0.010000 43.8027778 0.010000 43.8055556 0.010000 43.8083333 0.010000 43.8111111 0.010000 43.8138889 0.010000 43.8166667 0.010000 43.8194444 0.010000 43.8222222 0.010000 43.8250000 0.010000 43.8277778 0.010000 43.8305556 0.010000 43.8333333 0.010000 43.8361111 0.010000 43.8388889 0.010000 43.8416667 0.010000 43.8444444 0.010000 43.8472222 0.010000 43.8500000 0.010000 43.8527778 0.010000 43.8555556 0.010000 43.8583333 0.010000 43.8611111 0.010000 43.8638889 0.010000 43.8666667 0.010000 43.8694444 0.010000 43.8722222 0.010000 43.8750000 0.010000 43.8777778 0.010000 43.8805556 0.010000 43.8833333 0.010000 43.8861111 0.010000 43.8888889 0.010000 43.8916667 0.010000 43.8944444 0.010000 43.8972222 0.010000 43.9000000 0.010000 43.9027778 0.010000 43.9055556 0.010000 43.9083333 0.010000 43.9111111 0.028462 43.9138889 0.061346 43.9166667 0.087308 43.9194444 0.097692 43.9222222 0.083846 43.9250000 0.047500 43.9277778 0.010000 43.9305556 0.010000 43.9333333 0.010000 43.9361111 0.010000 43.9388889 0.010000 43.9416667 0.068269 43.9444444 0.165192 43.9472222 0.267308 43.9500000 0.365962 43.9527778 0.464615 43.9555556 0.542500 43.9583333 0.608269 43.9611111 0.655000 43.9638889 0.675769 43.9666667 0.674038 43.9694444 0.651538 43.9722222 0.620385 43.9750000 0.559808 43.9777778 0.497500 43.9805556 0.421346 43.9833333 0.353846 43.9861111 0.291538 43.9888889 0.222308 43.9916667 0.158269 43.9944444 0.090769 43.9972222 0.014615 44.0000000 0.010000 44.0027778 0.010000 44.0055556 0.010000 44.0083333 0.010000 44.0111111 0.010000 44.0138889 0.010000 44.0166667 0.010000 44.0194444 0.010000 44.0222222 0.010000 44.0250000 0.010000 44.0277778 0.010000 44.0305556 0.010000 44.0333333 0.010000 44.0361111 0.010000 44.0388889 0.010000 44.0416667 0.010000 44.0444444 0.010000 44.0472222 0.010000 44.0500000 0.010000 44.0527778 0.010000 44.0555556 0.010000 44.0583333 0.010000 44.0611111 0.010000 44.0638889 0.010000 44.0666667 0.010000 44.0694444 0.010000 44.0722222 0.010000 44.0750000 0.010000 44.0777778 0.010000 44.0805556 0.010000 44.0833333 0.010000 44.0861111 0.010000 44.0888889 0.010000 44.0916667 0.010000 44.0944444 0.010000 44.0972222 0.010000 44.1000000 0.010000 44.1027778 0.010000 44.1055556 0.010000 44.1083333 0.010000 44.1111111 0.010000 44.1138889 0.010000 44.1166667 0.010000 44.1194444 0.010000 44.1222222 0.010000 44.1250000 0.010000 44.1277778 0.010000 44.1305556 0.010000 44.1333333 0.010000 44.1361111 0.010000 44.1388889 0.010000 44.1416667 0.010000 44.1444444 0.010000 44.1472222 0.010000 44.1500000 0.010000 44.1527778 0.010000 44.1555556 0.010000 44.1583333 0.010000 44.1611111 0.010000 44.1638889 0.010000 44.1666667 0.010000 44.1694444 0.010000 44.1722222 0.010000 44.1750000 0.010000 44.1777778 0.010000 44.1805556 0.010000 44.1833333 0.010000 44.1861111 0.010000 44.1888889 0.010000 44.1916667 0.010000 44.1944444 0.010000 44.1972222 0.010000 44.2000000 0.010000 44.2027778 0.010000 44.2055556 0.010000 44.2083333 0.010000 44.2111111 0.010000 44.2138889 0.010000 44.2166667 0.010000 44.2194444 0.010000 44.2222222 0.010000 44.2250000 0.010000 44.2277778 0.010000 44.2305556 0.010000 44.2333333 0.010000 44.2361111 0.010000 44.2388889 0.010000 44.2416667 0.010000 44.2444444 0.010000 44.2472222 0.010000 44.2500000 0.010000 44.2527778 0.010000 44.2555556 0.010000 44.2583333 0.010000 44.2611111 0.010000 44.2638889 0.010000 44.9666667 0.010000 44.9694444 0.010000 44.9722222 0.010000 44.9750000 0.010000 44.9777778 0.010000 44.9805556 0.010000 44.9833333 0.010000 44.9861111 0.010000 44.9888889 0.010000 44.9916667 0.010000 44.9944444 0.010000 44.9972222 0.010000 45.0000000 0.010000 45.0027778 0.010000 45.0055556 0.010000 45.0083333 0.010000 45.0111111 0.010000 45.0138889 0.010000 45.0166667 0.010000 45.0194444 0.010000 45.0222222 0.010000 45.0250000 0.010000 45.0277778 0.010000 45.0305556 0.010000 45.0333333 0.010000 45.0361111 0.010000 45.0388889 0.010000 45.0416667 0.010000 45.0444444 0.010000 45.0472222 0.010000 45.0500000 0.010000 45.0527778 0.010000 45.0555556 0.010000 45.0583333 0.010000 45.0611111 0.010000 45.0638889 0.010000 45.0666667 0.010000 45.0694444 0.010000 45.0722222 0.010000 45.0750000 0.010000 45.0777778 0.010000 45.0805556 0.010000 45.0833333 0.010000 45.0861111 0.010000 45.0888889 0.010000 45.0916667 0.010000 45.0944444 0.010000 45.0972222 0.010000 45.1000000 0.010000 45.1027778 0.010000 45.1055556 0.010000 45.1083333 0.010000 45.1111111 0.010000 45.1138889 0.010000 45.1166667 0.010000 45.1194444 0.010000 45.1222222 0.010000 45.1250000 0.010000 45.1277778 0.010000 45.1305556 0.010000 45.1333333 0.010000 45.1361111 0.010000 45.1388889 0.010000 45.1416667 0.010000 45.1444444 0.010000 45.1472222 0.010000 45.1500000 0.010000 45.1527778 0.011154 45.1555556 0.040577 45.1583333 0.064808 45.1611111 0.075192 45.1638889 0.075192 45.1666667 0.056154 45.1694444 0.012885 45.1722222 0.010000 45.1750000 0.010000 45.1777778 0.010000 45.1805556 0.010000 45.1833333 0.010000 45.1861111 0.075192 45.1888889 0.165192 45.1916667 0.255192 45.1944444 0.341731 45.1972222 0.423077 45.2000000 0.494038 45.2027778 0.558077 45.2055556 0.622115 45.2083333 0.668846 45.2111111 0.694808 45.2138889 0.705192 45.2166667 0.705192 45.2194444 0.687885 45.2222222 0.660192 45.2250000 0.623846 45.2277778 0.568462 45.2305556 0.492308 45.2333333 0.412692 45.2361111 0.336538 45.2388889 0.263846 45.2416667 0.189423 45.2444444 0.118462 45.2472222 0.040577 45.2500000 0.010000 45.2527778 0.010000 45.2555556 0.010000 45.2583333 0.010000 45.2611111 0.010000 45.2638889 0.010000 45.2666667 0.010000 45.2694444 0.010000 45.2722222 0.010000 45.2750000 0.010000 45.2777778 0.010000 45.2805556 0.010000 45.2833333 0.010000 45.2861111 0.010000 45.2888889 0.010000 45.2916667 0.010000 45.2944444 0.010000 45.2972222 0.010000 45.3000000 0.010000 45.3027778 0.010000 45.3055556 0.010000 45.3083333 0.010000 45.3111111 0.010000 45.3138889 0.010000 45.3166667 0.010000 45.3194444 0.010000 45.3222222 0.010000 45.3250000 0.010000 45.3277778 0.010000 45.3305556 0.010000 45.3333333 0.010000 45.3361111 0.010000 45.3388889 0.010000 45.3416667 0.010000 45.3444444 0.010000 45.3472222 0.010000 45.3500000 0.010000 45.3527778 0.010000 45.3555556 0.010000 45.3583333 0.010000 45.3611111 0.010000 45.3638889 0.010000 45.3666667 0.010000 45.3694444 0.010000 45.3722222 0.010000 45.3750000 0.010000 45.3777778 0.010000 45.3805556 0.010000 45.3833333 0.010000 45.3861111 0.010000 45.3888889 0.010000 45.3916667 0.010000 45.3944444 0.010000 45.3972222 0.010000 45.4000000 0.010000 45.4027778 0.010000 45.4055556 0.010000 45.4083333 0.010000 45.4111111 0.010000 45.4138889 0.010000 45.4166667 0.010000 45.4194444 0.010000 45.4222222 0.010000 45.4250000 0.010000 45.4277778 0.010000 45.4305556 0.010000 45.4333333 0.010000 45.4361111 0.010000 45.4388889 0.010000 45.4416667 0.010000 45.4444444 0.010000 45.4472222 0.010000 45.4500000 0.010000 45.4527778 0.010000 45.4555556 0.010000 45.4583333 0.010000 45.4611111 0.010000 45.4638889 0.010000 45.4666667 0.010000 45.4694444 0.010000 45.4722222 0.010000 45.4750000 0.010000 45.4777778 0.010000 45.4805556 0.010000 45.4833333 0.010000 45.4861111 0.010000 45.4888889 0.010000 45.4916667 0.010000 45.4944444 0.010000 45.4972222 0.010000 45.5000000 0.010000 45.5027778 0.010000 45.5055556 0.010000 45.5083333 0.010000 45.5111111 0.010000 45.5138889 0.010000 46.1861111 0.010000 46.1888889 0.010000 46.1916667 0.010000 46.1944444 0.010000 46.1972222 0.010000 46.2000000 0.010000 46.2027778 0.010000 46.2055556 0.010000 46.2083333 0.010000 46.2111111 0.010000 46.2138889 0.010000 46.2166667 0.010000 46.2194444 0.010000 46.2222222 0.010000 46.2250000 0.010000 46.2277778 0.010000 46.2305556 0.010000 46.2333333 0.010000 46.2361111 0.010000 46.2388889 0.010000 46.2416667 0.010000 46.2444444 0.010000 46.2472222 0.010000 46.2500000 0.010000 46.2527778 0.010000 46.2555556 0.010000 46.2583333 0.010000 46.2611111 0.010000 46.2638889 0.010000 46.2666667 0.010000 46.2694444 0.010000 46.2722222 0.010000 46.2750000 0.010000 46.2777778 0.010000 46.2805556 0.010000 46.2833333 0.010000 46.2861111 0.010000 46.2888889 0.010000 46.2916667 0.010000 46.2944444 0.010000 46.2972222 0.010000 46.3000000 0.010000 46.3027778 0.010000 46.3055556 0.010000 46.3083333 0.010000 46.3111111 0.010000 46.3138889 0.010000 46.3166667 0.010000 46.3194444 0.010000 46.3222222 0.010000 46.3250000 0.010000 46.3277778 0.010000 46.3305556 0.010000 46.3333333 0.010000 46.3361111 0.010000 46.3388889 0.010000 46.3416667 0.010000 46.3444444 0.010000 46.3472222 0.010000 46.3500000 0.010000 46.3527778 0.010000 46.3555556 0.010000 46.3583333 0.010000 46.3611111 0.010000 46.3638889 0.010000 46.3666667 0.010000 46.3694444 0.010000 46.3722222 0.010000 46.3750000 0.012885 46.3777778 0.042308 46.3805556 0.075192 46.3833333 0.101154 46.3861111 0.115000 46.3888889 0.109808 46.3916667 0.082115 46.3944444 0.028462 46.3972222 0.010000 46.4000000 0.010000 46.4027778 0.010000 46.4055556 0.010000 46.4083333 0.033654 46.4111111 0.121923 46.4138889 0.215385 46.4166667 0.305385 46.4194444 0.388462 46.4222222 0.461154 46.4250000 0.525192 46.4277778 0.578846 46.4305556 0.613462 46.4333333 0.632500 46.4361111 0.634231 46.4388889 0.622115 46.4416667 0.592692 46.4444444 0.554615 46.4472222 0.497500 46.4500000 0.430000 46.4527778 0.360769 46.4555556 0.291538 46.4583333 0.220577 46.4611111 0.146154 46.4638889 0.070000 46.4666667 0.010000 46.4694444 0.010000 46.4722222 0.010000 46.4750000 0.010000 46.4777778 0.010000 46.4805556 0.010000 46.4833333 0.010000 46.4861111 0.010000 46.4888889 0.010000 46.4916667 0.010000 46.4944444 0.010000 46.4972222 0.010000 46.5000000 0.010000 46.5027778 0.010000 46.5055556 0.010000 46.5083333 0.010000 46.5111111 0.010000 46.5138889 0.010000 46.5166667 0.010000 46.5194444 0.010000 46.5222222 0.010000 46.5250000 0.010000 46.5277778 0.010000 46.5305556 0.010000 46.5333333 0.010000 46.5361111 0.010000 46.5388889 0.010000 46.5416667 0.010000 46.5444444 0.010000 46.5472222 0.010000 46.5500000 0.010000 46.5527778 0.010000 46.5555556 0.010000 46.5583333 0.010000 46.5611111 0.010000 46.5638889 0.010000 46.5666667 0.010000 46.5694444 0.010000 46.5722222 0.010000 46.5750000 0.010000 46.5777778 0.010000 46.5805556 0.010000 46.5833333 0.010000 46.5861111 0.010000 46.5888889 0.010000 46.5916667 0.010000 46.5944444 0.010000 46.5972222 0.010000 46.6000000 0.010000 46.6027778 0.010000 46.6055556 0.010000 46.6083333 0.010000 46.6111111 0.010000 46.6138889 0.010000 46.6166667 0.010000 46.6194444 0.010000 46.6222222 0.010000 46.6250000 0.010000 46.6277778 0.010000 46.6305556 0.010000 46.6333333 0.010000 46.6361111 0.010000 46.6388889 0.010000 46.6416667 0.010000 46.6444444 0.010000 46.6472222 0.010000 46.6500000 0.010000 46.6527778 0.010000 46.6555556 0.010000 46.6583333 0.010000 46.6611111 0.010000 46.6638889 0.010000 46.6666667 0.010000 46.6694444 0.010000 46.6722222 0.010000 46.6750000 0.010000 46.6777778 0.010000 46.6805556 0.010000 46.6833333 0.010000 46.6861111 0.010000 46.6888889 0.010000 46.6916667 0.010000 46.6944444 0.010000 46.6972222 0.010000 46.7000000 0.010000 46.7027778 0.010000 46.7055556 0.010000 46.7083333 0.010000 46.7111111 0.010000 46.7138889 0.010000 46.7166667 0.010000 46.7194444 0.010000 46.7222222 0.010000 46.7250000 0.010000 46.7277778 0.010000 46.7305556 0.010000 46.7333333 0.010000 47.4333333 0.012885 47.4361111 0.014615 47.4388889 0.012885 47.4416667 0.010000 47.4444444 0.010000 47.4472222 0.010000 47.4500000 0.010000 47.4527778 0.010000 47.4555556 0.014615 47.4583333 0.014615 47.4611111 0.012885 47.4638889 0.019808 47.4666667 0.023269 47.4694444 0.019808 47.4722222 0.018077 47.4750000 0.014615 47.4777778 0.012885 47.4805556 0.012885 47.4833333 0.011154 47.4861111 0.014615 47.4888889 0.025000 47.4916667 0.031923 47.4944444 0.038846 47.4972222 0.042308 47.5000000 0.038846 47.5027778 0.035385 47.5055556 0.035385 47.5083333 0.033654 47.5111111 0.031923 47.5138889 0.030192 47.5166667 0.019808 47.5194444 0.021538 47.5222222 0.019808 47.5250000 0.026731 47.5277778 0.028462 47.5305556 0.028462 47.5333333 0.026731 47.5361111 0.025000 47.5388889 0.025000 47.5416667 0.025000 47.5444444 0.030192 47.5472222 0.037115 47.5500000 0.037115 47.5527778 0.038846 47.5555556 0.037115 47.5583333 0.037115 47.5611111 0.031923 47.5638889 0.023269 47.5666667 0.021538 47.5694444 0.011154 47.5722222 0.010000 47.5750000 0.010000 47.5777778 0.010000 47.5805556 0.010000 47.5833333 0.010000 47.5861111 0.010000 47.5888889 0.010000 47.5916667 0.014615 47.5944444 0.016346 47.5972222 0.018077 47.6000000 0.012885 47.6027778 0.011154 47.6055556 0.010000 47.6083333 0.010000 47.6111111 0.010000 47.6138889 0.010000 47.6166667 0.023269 47.6194444 0.056154 47.6222222 0.090769 47.6250000 0.121923 47.6277778 0.147885 47.6305556 0.158269 47.6333333 0.156538 47.6361111 0.135769 47.6388889 0.087308 47.6416667 0.035385 47.6444444 0.010000 47.6472222 0.010000 47.6500000 0.012885 47.6527778 0.082115 47.6555556 0.163462 47.6583333 0.248269 47.6611111 0.346923 47.6638889 0.426538 47.6666667 0.514808 47.6694444 0.590962 47.6722222 0.655000 47.6750000 0.710385 47.6777778 0.750192 47.6805556 0.770962 47.6833333 0.767500 47.6861111 0.746731 47.6888889 0.706923 47.6916667 0.648077 47.6944444 0.573654 47.6972222 0.488846 47.7000000 0.407500 47.7027778 0.320962 47.7055556 0.239615 47.7083333 0.163462 47.7111111 0.090769 47.7138889 0.026731 47.7166667 0.010000 47.7194444 0.010000 47.7222222 0.010000 47.7250000 0.010000 47.7277778 0.010000 47.7305556 0.010000 47.7333333 0.010000 47.7361111 0.010000 47.7388889 0.010000 47.7416667 0.010000 47.7444444 0.010000 47.7472222 0.010000 47.7500000 0.010000 47.7527778 0.010000 47.7555556 0.010000 47.7583333 0.010000 47.7611111 0.010000 47.7638889 0.010000 47.7666667 0.010000 47.7694444 0.010000 47.7722222 0.010000 47.7750000 0.010000 47.7777778 0.010000 47.7805556 0.010000 47.7833333 0.010000 47.7861111 0.010000 47.7888889 0.010000 47.7916667 0.010000 47.7944444 0.010000 47.7972222 0.010000 47.8000000 0.010000 47.8027778 0.010000 47.8055556 0.010000 47.8083333 0.010000 47.8111111 0.010000 47.8138889 0.010000 47.8166667 0.010000 47.8194444 0.010000 47.8222222 0.010000 47.8250000 0.010000 47.8277778 0.010000 47.8305556 0.010000 47.8333333 0.010000 47.8361111 0.010000 47.8388889 0.010000 47.8416667 0.010000 47.8444444 0.010000 47.8472222 0.010000 47.8500000 0.010000 47.8527778 0.010000 47.8555556 0.010000 47.8583333 0.010000 47.8611111 0.010000 47.8638889 0.010000 47.8666667 0.010000 47.8694444 0.010000 47.8722222 0.010000 47.8750000 0.010000 47.8777778 0.010000 47.8805556 0.010000 47.8833333 0.010000 47.8861111 0.010000 47.8888889 0.010000 47.8916667 0.010000 47.8944444 0.010000 47.8972222 0.010000 47.9000000 0.010000 47.9027778 0.010000 47.9055556 0.010000 47.9083333 0.010000 47.9111111 0.010000 47.9138889 0.010000 47.9166667 0.010000 47.9194444 0.010000 47.9222222 0.010000 47.9250000 0.010000 47.9277778 0.010000 47.9305556 0.010000 47.9333333 0.010000 47.9361111 0.010000 47.9388889 0.010000 47.9416667 0.010000 47.9444444 0.010000 47.9472222 0.010000 47.9500000 0.010000 47.9527778 0.010000 47.9555556 0.010000 47.9583333 0.010000 47.9611111 0.010000 47.9638889 0.010000 47.9666667 0.010000 47.9694444 0.010000 47.9722222 0.010000 47.9750000 0.010000 47.9777778 0.010000 47.9805556 0.010000 48.6694444 0.095962 48.6722222 0.094231 48.6750000 0.092500 48.6777778 0.092500 48.6805556 0.090769 48.6833333 0.094231 48.6861111 0.095962 48.6888889 0.095962 48.6916667 0.099423 48.6944444 0.101154 48.6972222 0.106346 48.7000000 0.104615 48.7027778 0.104615 48.7055556 0.101154 48.7083333 0.097692 48.7111111 0.095962 48.7138889 0.097692 48.7166667 0.102885 48.7194444 0.109808 48.7222222 0.111538 48.7250000 0.116731 48.7277778 0.120192 48.7305556 0.120192 48.7333333 0.118462 48.7361111 0.116731 48.7388889 0.109808 48.7416667 0.104615 48.7444444 0.102885 48.7472222 0.099423 48.7500000 0.101154 48.7527778 0.099423 48.7555556 0.101154 48.7583333 0.104615 48.7611111 0.108077 48.7638889 0.113269 48.7666667 0.115000 48.7694444 0.118462 48.7722222 0.118462 48.7750000 0.123654 48.7777778 0.116731 48.7805556 0.113269 48.7833333 0.108077 48.7861111 0.102885 48.7888889 0.101154 48.7916667 0.097692 48.7944444 0.092500 48.7972222 0.090769 48.8000000 0.082115 48.8027778 0.085577 48.8055556 0.083846 48.8083333 0.082115 48.8111111 0.078654 48.8138889 0.075192 48.8166667 0.080385 48.8194444 0.080385 48.8222222 0.085577 48.8250000 0.087308 48.8277778 0.085577 48.8305556 0.085577 48.8333333 0.082115 48.8361111 0.075192 48.8388889 0.076923 48.8416667 0.070000 48.8444444 0.073462 48.8472222 0.082115 48.8500000 0.102885 48.8527778 0.130577 48.8555556 0.161731 48.8583333 0.189423 48.8611111 0.211923 48.8638889 0.225769 48.8666667 0.218846 48.8694444 0.198077 48.8722222 0.154808 48.8750000 0.099423 48.8777778 0.050962 48.8805556 0.035385 48.8833333 0.052692 48.8861111 0.101154 48.8888889 0.173846 48.8916667 0.256923 48.8944444 0.345192 48.8972222 0.419615 48.9000000 0.494038 48.9027778 0.558077 48.9055556 0.623846 48.9083333 0.679231 48.9111111 0.722500 48.9138889 0.757115 48.9166667 0.772692 48.9194444 0.774423 48.9222222 0.764038 48.9250000 0.736346 48.9277778 0.696538 48.9305556 0.637692 48.9333333 0.570192 48.9361111 0.504423 48.9388889 0.436923 48.9416667 0.364231 48.9444444 0.286346 48.9472222 0.205000 48.9500000 0.134038 48.9527778 0.075192 48.9555556 0.028462 48.9583333 0.010000 48.9611111 0.010000 48.9638889 0.010000 48.9666667 0.010000 48.9694444 0.010000 48.9722222 0.010000 48.9750000 0.014615 48.9777778 0.018077 48.9805556 0.028462 48.9833333 0.037115 48.9861111 0.035385 48.9888889 0.040577 48.9916667 0.045769 48.9944444 0.045769 48.9972222 0.044038 49.0000000 0.037115 49.0027778 0.038846 49.0055556 0.037115 49.0083333 0.035385 49.0111111 0.033654 49.0138889 0.038846 49.0166667 0.035385 49.0194444 0.038846 49.0222222 0.038846 49.0250000 0.038846 49.0277778 0.042308 49.0305556 0.042308 49.0333333 0.038846 49.0361111 0.033654 49.0388889 0.038846 49.0416667 0.035385 49.0444444 0.033654 49.0472222 0.031923 49.0500000 0.031923 49.0527778 0.031923 49.0555556 0.033654 49.0583333 0.035385 49.0611111 0.038846 49.0638889 0.033654 49.0666667 0.037115 49.0694444 0.035385 49.0722222 0.030192 49.0750000 0.030192 49.0777778 0.025000 49.0805556 0.025000 49.0833333 0.023269 49.0861111 0.026731 49.0888889 0.028462 49.0916667 0.028462 49.0944444 0.031923 49.0972222 0.031923 49.1000000 0.026731 49.1027778 0.026731 49.1055556 0.023269 49.1083333 0.016346 49.1111111 0.018077 49.1138889 0.012885 49.1166667 0.010000 49.1194444 0.010000 49.1222222 0.012885 49.1250000 0.012885 49.1277778 0.012885 49.1305556 0.010000 49.1333333 0.010000 49.1361111 0.010000 49.1388889 0.010000 49.1416667 0.010000 49.1444444 0.010000 49.1472222 0.010000 49.1500000 0.010000 49.1527778 0.010000 49.1555556 0.010000 49.1583333 0.010000 49.1611111 0.010000 49.1638889 0.010000 49.1666667 0.010000 49.1694444 0.010000 49.1722222 0.010000 49.1750000 0.010000 49.1777778 0.010000 49.1805556 0.010000 49.1833333 0.010000 49.1861111 0.010000 49.1888889 0.010000 49.1916667 0.010000 49.1944444 0.010000 49.1972222 0.010000 49.2000000 0.010000 49.2027778 0.010000 49.2055556 0.010000 49.2083333 0.010000 49.2111111 0.010000 49.2138889 0.010000 49.2166667 0.010000 49.8722222 0.045769 49.8750000 0.047500 49.8777778 0.045769 49.8805556 0.042308 49.8833333 0.042308 49.8861111 0.045769 49.8888889 0.049231 49.8916667 0.047500 49.8944444 0.052692 49.8972222 0.050962 49.9000000 0.056154 49.9027778 0.056154 49.9055556 0.050962 49.9083333 0.047500 49.9111111 0.047500 49.9138889 0.047500 49.9166667 0.047500 49.9194444 0.044038 49.9222222 0.045769 49.9250000 0.052692 49.9277778 0.064808 49.9305556 0.066538 49.9333333 0.066538 49.9361111 0.070000 49.9388889 0.070000 49.9416667 0.063077 49.9444444 0.061346 49.9472222 0.059615 49.9500000 0.056154 49.9527778 0.054423 49.9555556 0.056154 49.9583333 0.054423 49.9611111 0.059615 49.9638889 0.054423 49.9666667 0.054423 49.9694444 0.052692 49.9722222 0.050962 49.9750000 0.056154 49.9777778 0.056154 49.9805556 0.054423 49.9833333 0.063077 49.9861111 0.064808 49.9888889 0.068269 49.9916667 0.064808 49.9944444 0.063077 49.9972222 0.061346 50.0000000 0.057885 50.0027778 0.045769 50.0055556 0.042308 50.0083333 0.033654 50.0111111 0.028462 50.0138889 0.021538 50.0166667 0.021538 50.0194444 0.019808 50.0222222 0.021538 50.0250000 0.025000 50.0277778 0.031923 50.0305556 0.035385 50.0333333 0.031923 50.0361111 0.030192 50.0388889 0.030192 50.0416667 0.025000 50.0444444 0.016346 50.0472222 0.014615 50.0500000 0.016346 50.0527778 0.028462 50.0555556 0.050962 50.0583333 0.082115 50.0611111 0.116731 50.0638889 0.146154 50.0666667 0.163462 50.0694444 0.173846 50.0722222 0.163462 50.0750000 0.132308 50.0777778 0.083846 50.0805556 0.037115 50.0833333 0.010000 50.0861111 0.010000 50.0888889 0.026731 50.0916667 0.097692 50.0944444 0.185962 50.0972222 0.275962 50.1000000 0.360769 50.1027778 0.438654 50.1055556 0.509615 50.1083333 0.571923 50.1111111 0.629038 50.1138889 0.674038 50.1166667 0.701731 50.1194444 0.719038 50.1222222 0.719038 50.1250000 0.700000 50.1277778 0.661923 50.1305556 0.618654 50.1333333 0.549423 50.1361111 0.473269 50.1388889 0.395385 50.1416667 0.319231 50.1444444 0.250000 50.1472222 0.182500 50.1500000 0.116731 50.1527778 0.052692 50.1555556 0.010000 50.1583333 0.010000 50.1611111 0.010000 50.1638889 0.010000 50.1666667 0.010000 50.1694444 0.010000 50.1722222 0.010000 50.1750000 0.010000 50.1777778 0.010000 50.1805556 0.010000 50.1833333 0.010000 50.1861111 0.010000 50.1888889 0.010000 50.1916667 0.010000 50.1944444 0.010000 50.1972222 0.010000 50.2000000 0.010000 50.2027778 0.010000 50.2055556 0.010000 50.2083333 0.010000 50.2111111 0.010000 50.2138889 0.010000 50.2166667 0.010000 50.2194444 0.010000 50.2222222 0.010000 50.2250000 0.010000 50.2277778 0.010000 50.2305556 0.010000 50.2333333 0.010000 50.2361111 0.010000 50.2388889 0.010000 50.2416667 0.010000 50.2444444 0.010000 50.2472222 0.010000 50.2500000 0.010000 50.2527778 0.010000 50.2555556 0.010000 50.2583333 0.010000 50.2611111 0.010000 50.2638889 0.010000 50.2666667 0.010000 50.2694444 0.010000 50.2722222 0.010000 50.2750000 0.010000 50.2777778 0.010000 50.2805556 0.010000 50.2833333 0.010000 50.2861111 0.010000 50.2888889 0.010000 50.2916667 0.010000 50.2944444 0.010000 50.2972222 0.010000 50.3000000 0.010000 50.3027778 0.010000 50.3055556 0.010000 50.3083333 0.010000 50.3111111 0.010000 50.3138889 0.010000 50.3166667 0.010000 50.3194444 0.010000 50.3222222 0.010000 50.3250000 0.010000 50.3277778 0.010000 50.3305556 0.010000 50.3333333 0.010000 50.3361111 0.010000 50.3388889 0.010000 50.3416667 0.010000 50.3444444 0.010000 50.3472222 0.010000 50.3500000 0.010000 50.3527778 0.010000 50.3555556 0.010000 50.3583333 0.010000 50.3611111 0.010000 50.3638889 0.010000 50.3666667 0.010000 50.3694444 0.010000 50.3722222 0.010000 50.3750000 0.010000 50.3777778 0.010000 50.3805556 0.010000 50.3833333 0.010000 50.3861111 0.010000 50.3888889 0.010000 50.3916667 0.010000 50.3944444 0.010000 50.3972222 0.010000 50.4000000 0.010000 50.4027778 0.010000 50.4055556 0.010000 50.4083333 0.010000 50.4111111 0.010000 50.4138889 0.010000 50.4166667 0.010000 50.4194444 0.010000 51.1305556 0.010000 51.1333333 0.010000 51.1361111 0.010000 51.1388889 0.010000 51.1416667 0.010000 51.1444444 0.010000 51.1472222 0.010000 51.1500000 0.010000 51.1527778 0.010000 51.1555556 0.010000 51.1583333 0.010000 51.1611111 0.010000 51.1638889 0.011154 51.1666667 0.011154 51.1694444 0.010000 51.1722222 0.010000 51.1750000 0.010000 51.1777778 0.010000 51.1805556 0.010000 51.1833333 0.010000 51.1861111 0.011154 51.1888889 0.014615 51.1916667 0.014615 51.1944444 0.018077 51.1972222 0.021538 51.2000000 0.021538 51.2027778 0.018077 51.2055556 0.010000 51.2083333 0.010000 51.2111111 0.010000 51.2138889 0.010000 51.2166667 0.010000 51.2194444 0.010000 51.2222222 0.010000 51.2250000 0.010000 51.2277778 0.010000 51.2305556 0.012885 51.2333333 0.018077 51.2361111 0.021538 51.2388889 0.025000 51.2416667 0.023269 51.2444444 0.019808 51.2472222 0.014615 51.2500000 0.012885 51.2527778 0.010000 51.2555556 0.010000 51.2583333 0.010000 51.2611111 0.010000 51.2638889 0.010000 51.2666667 0.010000 51.2694444 0.010000 51.2722222 0.010000 51.2750000 0.010000 51.2777778 0.010000 51.2805556 0.010000 51.2833333 0.010000 51.2861111 0.010000 51.2888889 0.010000 51.2916667 0.010000 51.2944444 0.010000 51.2972222 0.010000 51.3000000 0.010000 51.3027778 0.010000 51.3055556 0.010000 51.3083333 0.010000 51.3111111 0.010000 51.3138889 0.028462 51.3166667 0.064808 51.3194444 0.085577 51.3222222 0.109808 51.3250000 0.120192 51.3277778 0.120192 51.3305556 0.101154 51.3333333 0.061346 51.3361111 0.010000 51.3388889 0.010000 51.3416667 0.010000 51.3444444 0.010000 51.3472222 0.019808 51.3500000 0.101154 51.3527778 0.184231 51.3555556 0.277692 51.3583333 0.365962 51.3611111 0.442115 51.3638889 0.520000 51.3666667 0.584038 51.3694444 0.639423 51.3722222 0.677500 51.3750000 0.696538 51.3777778 0.703462 51.3805556 0.689615 51.3833333 0.670577 51.3861111 0.635962 51.3888889 0.585769 51.3916667 0.520000 51.3944444 0.454231 51.3972222 0.390192 51.4000000 0.326154 51.4027778 0.255192 51.4055556 0.182500 51.4083333 0.102885 51.4111111 0.031923 51.4138889 0.010000 51.4166667 0.010000 51.4194444 0.010000 51.4222222 0.010000 51.4250000 0.010000 51.4277778 0.010000 51.4305556 0.010000 51.4333333 0.010000 51.4361111 0.010000 51.4388889 0.010000 51.4416667 0.010000 51.4444444 0.010000 51.4472222 0.010000 51.4500000 0.010000 51.4527778 0.010000 51.4555556 0.010000 51.4583333 0.010000 51.4611111 0.010000 51.4638889 0.010000 51.4666667 0.010000 51.4694444 0.010000 51.4722222 0.010000 51.4750000 0.010000 51.4777778 0.010000 51.4805556 0.010000 51.4833333 0.010000 51.4861111 0.010000 51.4888889 0.010000 51.4916667 0.010000 51.4944444 0.010000 51.4972222 0.010000 51.5000000 0.010000 51.5027778 0.010000 51.5055556 0.010000 51.5083333 0.010000 51.5111111 0.010000 51.5138889 0.010000 51.5166667 0.010000 51.5194444 0.010000 51.5222222 0.010000 51.5250000 0.010000 51.5277778 0.010000 51.5305556 0.010000 51.5333333 0.010000 51.5361111 0.010000 51.5388889 0.010000 51.5416667 0.010000 51.5444444 0.010000 51.5472222 0.010000 51.5500000 0.010000 51.5527778 0.010000 51.5555556 0.010000 51.5583333 0.010000 51.5611111 0.010000 51.5638889 0.010000 51.5666667 0.010000 51.5694444 0.010000 51.5722222 0.010000 51.5750000 0.010000 51.5777778 0.010000 51.5805556 0.010000 51.5833333 0.010000 51.5861111 0.010000 51.5888889 0.010000 51.5916667 0.010000 51.5944444 0.010000 51.5972222 0.010000 51.6000000 0.010000 51.6027778 0.010000 51.6055556 0.010000 51.6083333 0.010000 51.6111111 0.010000 51.6138889 0.010000 51.6166667 0.010000 51.6194444 0.010000 51.6222222 0.010000 51.6250000 0.010000 51.6277778 0.010000 51.6305556 0.010000 51.6333333 0.010000 51.6361111 0.010000 51.6388889 0.010000 51.6416667 0.010000 51.6444444 0.010000 51.6472222 0.010000 51.6500000 0.010000 51.6527778 0.010000 51.6555556 0.010000 51.6583333 0.010000 51.6611111 0.010000 51.6638889 0.010000 51.6666667 0.010000 51.6694444 0.010000 51.6722222 0.010000 51.6750000 0.010000 51.6777778 0.010000 52.3777778 0.010000 52.3805556 0.010000 52.3833333 0.010000 52.3861111 0.010000 52.3888889 0.010000 52.3916667 0.010000 52.3944444 0.010000 52.3972222 0.010000 52.4000000 0.010000 52.4027778 0.010000 52.4055556 0.010000 52.4083333 0.010000 52.4111111 0.010000 52.4138889 0.010000 52.4166667 0.010000 52.4194444 0.010000 52.4222222 0.010000 52.4250000 0.010000 52.4277778 0.010000 52.4305556 0.010000 52.4333333 0.010000 52.4361111 0.010000 52.4388889 0.010000 52.4416667 0.010000 52.4444444 0.010000 52.4472222 0.010000 52.4500000 0.010000 52.4527778 0.010000 52.4555556 0.010000 52.4583333 0.010000 52.4611111 0.010000 52.4638889 0.010000 52.4666667 0.010000 52.4694444 0.010000 52.4722222 0.010000 52.4750000 0.010000 52.4777778 0.010000 52.4805556 0.010000 52.4833333 0.010000 52.4861111 0.010000 52.4888889 0.010000 52.4916667 0.010000 52.4944444 0.010000 52.4972222 0.010000 52.5000000 0.010000 52.5027778 0.010000 52.5055556 0.010000 52.5083333 0.010000 52.5111111 0.010000 52.5138889 0.010000 52.5166667 0.010000 52.5194444 0.010000 52.5222222 0.010000 52.5250000 0.010000 52.5277778 0.010000 52.5305556 0.010000 52.5333333 0.010000 52.5361111 0.010000 52.5388889 0.010000 52.5416667 0.010000 52.5444444 0.010000 52.5472222 0.010000 52.5500000 0.010000 52.5527778 0.010000 52.5555556 0.010000 52.5583333 0.010000 52.5611111 0.026731 52.5638889 0.059615 52.5666667 0.080385 52.5694444 0.092500 52.5722222 0.097692 52.5750000 0.083846 52.5777778 0.044038 52.5805556 0.010000 52.5833333 0.010000 52.5861111 0.010000 52.5888889 0.010000 52.5916667 0.010000 52.5944444 0.010000 52.5972222 0.073462 52.6000000 0.151346 52.6027778 0.225769 52.6055556 0.301923 52.6083333 0.365962 52.6111111 0.430000 52.6138889 0.487115 52.6166667 0.539038 52.6194444 0.580577 52.6222222 0.608269 52.6250000 0.618654 52.6277778 0.615192 52.6305556 0.597885 52.6333333 0.566731 52.6361111 0.520000 52.6388889 0.462885 52.6416667 0.390192 52.6444444 0.315769 52.6472222 0.243077 52.6500000 0.168654 52.6527778 0.092500 52.6555556 0.025000 52.6583333 0.010000 52.6611111 0.010000 52.6638889 0.010000 52.6666667 0.010000 52.6694444 0.010000 52.6722222 0.010000 52.6750000 0.010000 52.6777778 0.010000 52.6805556 0.010000 52.6833333 0.010000 52.6861111 0.010000 52.6888889 0.010000 52.6916667 0.010000 52.6944444 0.010000 52.6972222 0.010000 52.7000000 0.010000 52.7027778 0.010000 52.7055556 0.010000 52.7083333 0.010000 52.7111111 0.010000 52.7138889 0.010000 52.7166667 0.010000 52.7194444 0.010000 52.7222222 0.010000 52.7250000 0.010000 52.7277778 0.010000 52.7305556 0.010000 52.7333333 0.010000 52.7361111 0.010000 52.7388889 0.010000 52.7416667 0.010000 52.7444444 0.010000 52.7472222 0.010000 52.7500000 0.010000 52.7527778 0.010000 52.7555556 0.010000 52.7583333 0.010000 52.7611111 0.010000 52.7638889 0.010000 52.7666667 0.010000 52.7694444 0.010000 52.7722222 0.010000 52.7750000 0.010000 52.7777778 0.010000 52.7805556 0.010000 52.7833333 0.010000 52.7861111 0.010000 52.7888889 0.010000 52.7916667 0.010000 52.7944444 0.010000 52.7972222 0.010000 52.8000000 0.010000 52.8027778 0.010000 52.8055556 0.010000 52.8083333 0.010000 52.8111111 0.010000 52.8138889 0.010000 52.8166667 0.010000 52.8194444 0.010000 52.8222222 0.010000 52.8250000 0.010000 52.8277778 0.010000 52.8305556 0.010000 52.8333333 0.010000 52.8361111 0.010000 52.8388889 0.010000 52.8416667 0.010000 52.8444444 0.010000 52.8472222 0.010000 52.8500000 0.010000 52.8527778 0.010000 52.8555556 0.010000 52.8583333 0.010000 52.8611111 0.010000 52.8638889 0.010000 52.8666667 0.010000 52.8694444 0.010000 52.8722222 0.010000 52.8750000 0.010000 52.8777778 0.010000 52.8805556 0.010000 52.8833333 0.010000 52.8861111 0.010000 52.8888889 0.010000 52.8916667 0.010000 52.8944444 0.010000 52.8972222 0.010000 52.9000000 0.010000 52.9027778 0.010000 52.9055556 0.010000 52.9083333 0.010000 52.9111111 0.010000 52.9138889 0.010000 52.9166667 0.010000 52.9194444 0.010000 52.9222222 0.010000 52.9250000 0.010000 53.6388889 0.010000 53.6416667 0.010000 53.6444444 0.010000 53.6472222 0.010000 53.6500000 0.010000 53.6527778 0.010000 53.6555556 0.010000 53.6583333 0.010000 53.6611111 0.010000 53.6638889 0.010000 53.6666667 0.010000 53.6694444 0.010000 53.6722222 0.010000 53.6750000 0.010000 53.6777778 0.010000 53.6805556 0.010000 53.6833333 0.010000 53.6861111 0.010000 53.6888889 0.010000 53.6916667 0.010000 53.6944444 0.010000 53.6972222 0.010000 53.7000000 0.010000 53.7027778 0.010000 53.7055556 0.010000 53.7083333 0.010000 53.7111111 0.010000 53.7138889 0.010000 53.7166667 0.010000 53.7194444 0.010000 53.7222222 0.010000 53.7250000 0.010000 53.7277778 0.010000 53.7305556 0.010000 53.7333333 0.010000 53.7361111 0.010000 53.7388889 0.010000 53.7416667 0.010000 53.7444444 0.010000 53.7472222 0.010000 53.7500000 0.010000 53.7527778 0.010000 53.7555556 0.010000 53.7583333 0.010000 53.7611111 0.010000 53.7638889 0.010000 53.7666667 0.010000 53.7694444 0.010000 53.7722222 0.010000 53.7750000 0.010000 53.7777778 0.010000 53.7805556 0.010000 53.7833333 0.010000 53.7861111 0.010000 53.7888889 0.010000 53.7916667 0.010000 53.7944444 0.010000 53.7972222 0.010000 53.8000000 0.010000 53.8027778 0.010000 53.8055556 0.010000 53.8083333 0.010000 53.8111111 0.010000 53.8138889 0.010000 53.8166667 0.010000 53.8194444 0.010000 53.8222222 0.010000 53.8250000 0.010000 53.8277778 0.010000 53.8305556 0.010000 53.8333333 0.010000 53.8361111 0.040577 53.8388889 0.068269 53.8416667 0.080385 53.8444444 0.087308 53.8472222 0.068269 53.8500000 0.031923 53.8527778 0.010000 53.8555556 0.010000 53.8583333 0.010000 53.8611111 0.010000 53.8638889 0.050962 53.8666667 0.149615 53.8694444 0.253462 53.8722222 0.360769 53.8750000 0.455962 53.8777778 0.537308 53.8805556 0.610000 53.8833333 0.661923 53.8861111 0.693077 53.8888889 0.701731 53.8916667 0.684423 53.8944444 0.642885 53.8972222 0.590962 53.9000000 0.513077 53.9027778 0.421346 53.9055556 0.329615 53.9083333 0.241346 53.9111111 0.156538 53.9138889 0.076923 53.9166667 0.010000 53.9194444 0.010000 53.9222222 0.010000 53.9250000 0.010000 53.9277778 0.010000 53.9305556 0.010000 53.9333333 0.010000 53.9361111 0.010000 53.9388889 0.010000 53.9416667 0.010000 53.9444444 0.010000 53.9472222 0.010000 53.9500000 0.010000 53.9527778 0.010000 53.9555556 0.010000 53.9583333 0.010000 53.9611111 0.010000 53.9638889 0.010000 53.9666667 0.010000 53.9694444 0.010000 53.9722222 0.010000 53.9750000 0.010000 53.9777778 0.010000 53.9805556 0.010000 53.9833333 0.010000 53.9861111 0.010000 53.9888889 0.010000 53.9916667 0.010000 53.9944444 0.010000 53.9972222 0.010000 54.0000000 0.010000 54.0027778 0.010000 54.0055556 0.010000 54.0083333 0.010000 54.0111111 0.010000 54.0138889 0.010000 54.0166667 0.010000 54.0194444 0.010000 54.0222222 0.010000 54.0250000 0.010000 54.0277778 0.010000 54.0305556 0.010000 54.0333333 0.010000 54.0361111 0.010000 54.0388889 0.010000 54.0416667 0.010000 54.0444444 0.010000 54.0472222 0.010000 54.0500000 0.010000 54.0527778 0.010000 54.0555556 0.010000 54.0583333 0.010000 54.0611111 0.010000 54.0638889 0.010000 54.0666667 0.010000 54.0694444 0.010000 54.0722222 0.010000 54.0750000 0.010000 54.0777778 0.010000 54.0805556 0.010000 54.0833333 0.010000 54.0861111 0.010000 54.0888889 0.010000 54.0916667 0.010000 54.0944444 0.010000 54.0972222 0.010000 54.1000000 0.010000 54.1027778 0.010000 54.1055556 0.010000 54.1083333 0.010000 54.1111111 0.010000 54.1138889 0.010000 54.1166667 0.010000 54.1194444 0.010000 54.1222222 0.010000 54.1250000 0.010000 54.1277778 0.010000 54.1305556 0.010000 54.1333333 0.010000 54.1361111 0.010000 54.1388889 0.010000 54.1416667 0.010000 54.1444444 0.010000 54.1472222 0.010000 54.1500000 0.010000 54.1527778 0.010000 54.1555556 0.010000 54.1583333 0.010000 54.1611111 0.010000 54.1638889 0.010000 54.1666667 0.010000 54.1694444 0.010000 54.1722222 0.010000 54.1750000 0.010000 54.1777778 0.010000 54.1805556 0.010000 54.1833333 0.010000 54.1861111 0.010000 54.8888889 0.010000 54.8916667 0.010000 54.8944444 0.010000 54.8972222 0.010000 54.9000000 0.010000 54.9027778 0.010000 54.9055556 0.010000 54.9083333 0.010000 54.9111111 0.010000 54.9138889 0.010000 54.9166667 0.010000 54.9194444 0.010000 54.9222222 0.010000 54.9250000 0.010000 54.9277778 0.010000 54.9305556 0.010000 54.9333333 0.010000 54.9361111 0.010000 54.9388889 0.010000 54.9416667 0.010000 54.9444444 0.010000 54.9472222 0.010000 54.9500000 0.010000 54.9527778 0.010000 54.9555556 0.010000 54.9583333 0.010000 54.9611111 0.010000 54.9638889 0.010000 54.9666667 0.010000 54.9694444 0.010000 54.9722222 0.010000 54.9750000 0.010000 54.9777778 0.010000 54.9805556 0.010000 54.9833333 0.010000 54.9861111 0.010000 54.9888889 0.010000 54.9916667 0.010000 54.9944444 0.010000 54.9972222 0.010000 55.0000000 0.010000 55.0027778 0.010000 55.0055556 0.010000 55.0083333 0.010000 55.0111111 0.010000 55.0138889 0.010000 55.0166667 0.010000 55.0194444 0.010000 55.0222222 0.010000 55.0250000 0.010000 55.0277778 0.010000 55.0305556 0.010000 55.0333333 0.010000 55.0361111 0.010000 55.0388889 0.010000 55.0416667 0.010000 55.0444444 0.010000 55.0472222 0.010000 55.0500000 0.010000 55.0527778 0.010000 55.0555556 0.010000 55.0583333 0.010000 55.0611111 0.010000 55.0638889 0.010000 55.0666667 0.010000 55.0694444 0.010000 55.0722222 0.010000 55.0750000 0.010000 55.0777778 0.010000 55.0805556 0.019808 55.0833333 0.056154 55.0861111 0.085577 55.0888889 0.092500 55.0916667 0.078654 55.0944444 0.033654 55.0972222 0.010000 55.1000000 0.010000 55.1027778 0.010000 55.1055556 0.010000 55.1083333 0.010000 55.1111111 0.075192 55.1138889 0.161731 55.1166667 0.251731 55.1194444 0.334808 55.1222222 0.410962 55.1250000 0.481923 55.1277778 0.539038 55.1305556 0.584038 55.1333333 0.608269 55.1361111 0.615192 55.1388889 0.606538 55.1416667 0.587500 55.1444444 0.561538 55.1472222 0.509615 55.1500000 0.449038 55.1527778 0.381538 55.1555556 0.317500 55.1583333 0.255192 55.1611111 0.185962 55.1638889 0.111538 55.1666667 0.042308 55.1694444 0.010000 55.1722222 0.010000 55.1750000 0.010000 55.1777778 0.010000 55.1805556 0.010000 55.1833333 0.010000 55.1861111 0.010000 55.1888889 0.010000 55.1916667 0.010000 55.1944444 0.010000 55.1972222 0.010000 55.2000000 0.010000 55.2027778 0.010000 55.2055556 0.010000 55.2083333 0.010000 55.2111111 0.010000 55.2138889 0.010000 55.2166667 0.010000 55.2194444 0.010000 55.2222222 0.010000 55.2250000 0.010000 55.2277778 0.010000 55.2305556 0.010000 55.2333333 0.010000 55.2361111 0.010000 55.2388889 0.010000 55.2416667 0.010000 55.2444444 0.010000 55.2472222 0.010000 55.2500000 0.010000 55.2527778 0.010000 55.2555556 0.010000 55.2583333 0.010000 55.2611111 0.010000 55.2638889 0.010000 55.2666667 0.010000 55.2694444 0.010000 55.2722222 0.010000 55.2750000 0.010000 55.2777778 0.010000 55.2805556 0.010000 55.2833333 0.010000 55.2861111 0.010000 55.2888889 0.010000 55.2916667 0.010000 55.2944444 0.010000 55.2972222 0.010000 55.3000000 0.010000 55.3027778 0.010000 55.3055556 0.010000 55.3083333 0.010000 55.3111111 0.010000 55.3138889 0.010000 55.3166667 0.010000 55.3194444 0.010000 55.3222222 0.010000 55.3250000 0.010000 55.3277778 0.010000 55.3305556 0.010000 55.3333333 0.010000 55.3361111 0.010000 55.3388889 0.010000 55.3416667 0.010000 55.3444444 0.010000 55.3472222 0.010000 55.3500000 0.010000 55.3527778 0.010000 55.3555556 0.010000 55.3583333 0.010000 55.3611111 0.010000 55.3638889 0.010000 55.3666667 0.010000 55.3694444 0.010000 55.3722222 0.010000 55.3750000 0.010000 55.3777778 0.010000 55.3805556 0.010000 55.3833333 0.010000 55.3861111 0.010000 55.3888889 0.010000 55.3916667 0.010000 55.3944444 0.010000 55.3972222 0.010000 55.4000000 0.010000 55.4027778 0.010000 55.4055556 0.010000 55.4083333 0.010000 55.4111111 0.010000 55.4138889 0.010000 55.4166667 0.010000 55.4194444 0.010000 55.4222222 0.010000 55.4250000 0.010000 55.4277778 0.010000 55.4305556 0.010000 55.4333333 0.010000 55.4361111 0.010000 56.0805556 0.010000 56.0833333 0.010000 56.0861111 0.010000 56.0888889 0.010000 56.0916667 0.010000 56.0944444 0.010000 56.0972222 0.010000 56.1000000 0.010000 56.1027778 0.010000 56.1055556 0.010000 56.1083333 0.010000 56.1111111 0.010000 56.1138889 0.010000 56.1166667 0.010000 56.1194444 0.010000 56.1222222 0.010000 56.1250000 0.010000 56.1277778 0.010000 56.1305556 0.010000 56.1333333 0.010000 56.1361111 0.010000 56.1388889 0.010000 56.1416667 0.010000 56.1444444 0.010000 56.1472222 0.010000 56.1500000 0.010000 56.1527778 0.010000 56.1555556 0.010000 56.1583333 0.010000 56.1611111 0.010000 56.1638889 0.010000 56.1666667 0.010000 56.1694444 0.010000 56.1722222 0.010000 56.1750000 0.010000 56.1777778 0.010000 56.1805556 0.010000 56.1833333 0.010000 56.1861111 0.010000 56.1888889 0.010000 56.1916667 0.010000 56.1944444 0.010000 56.1972222 0.010000 56.2000000 0.010000 56.2027778 0.010000 56.2055556 0.010000 56.2083333 0.010000 56.2111111 0.010000 56.2138889 0.010000 56.2166667 0.010000 56.2194444 0.010000 56.2222222 0.010000 56.2250000 0.010000 56.2277778 0.010000 56.2305556 0.010000 56.2333333 0.010000 56.2361111 0.010000 56.2388889 0.010000 56.2416667 0.010000 56.2444444 0.010000 56.2472222 0.010000 56.2500000 0.010000 56.2527778 0.010000 56.2555556 0.010000 56.2583333 0.010000 56.2611111 0.010000 56.2638889 0.010000 56.2666667 0.010000 56.2694444 0.011154 56.2722222 0.038846 56.2750000 0.063077 56.2777778 0.083846 56.2805556 0.087308 56.2833333 0.087308 56.2861111 0.064808 56.2888889 0.026731 56.2916667 0.010000 56.2944444 0.010000 56.2972222 0.010000 56.3000000 0.010000 56.3027778 0.082115 56.3055556 0.175577 56.3083333 0.279423 56.3111111 0.379808 56.3138889 0.464615 56.3166667 0.544231 56.3194444 0.604808 56.3222222 0.653269 56.3250000 0.679231 56.3277778 0.687885 56.3305556 0.677500 56.3333333 0.655000 56.3361111 0.613462 56.3388889 0.554615 56.3416667 0.478462 56.3444444 0.397115 56.3472222 0.319231 56.3500000 0.251731 56.3527778 0.180769 56.3555556 0.113269 56.3583333 0.044038 56.3611111 0.010000 56.3638889 0.010000 56.3666667 0.010000 56.3694444 0.010000 56.3722222 0.010000 56.3750000 0.010000 56.3777778 0.010000 56.3805556 0.010000 56.3833333 0.010000 56.3861111 0.010000 56.3888889 0.010000 56.3916667 0.010000 56.3944444 0.010000 56.3972222 0.010000 56.4000000 0.010000 56.4027778 0.010000 56.4055556 0.010000 56.4083333 0.010000 56.4111111 0.010000 56.4138889 0.010000 56.4166667 0.010000 56.4194444 0.010000 56.4222222 0.010000 56.4250000 0.010000 56.4277778 0.010000 56.4305556 0.010000 56.4333333 0.010000 56.4361111 0.010000 56.4388889 0.010000 56.4416667 0.010000 56.4444444 0.010000 56.4472222 0.010000 56.4500000 0.010000 56.4527778 0.010000 56.4555556 0.010000 56.4583333 0.010000 56.4611111 0.010000 56.4638889 0.010000 56.4666667 0.010000 56.4694444 0.010000 56.4722222 0.010000 56.4750000 0.010000 56.4777778 0.010000 56.4805556 0.010000 56.4833333 0.010000 56.4861111 0.010000 56.4888889 0.010000 56.4916667 0.010000 56.4944444 0.010000 56.4972222 0.010000 56.5000000 0.010000 56.5027778 0.010000 56.5055556 0.010000 56.5083333 0.010000 56.5111111 0.010000 56.5138889 0.010000 56.5166667 0.010000 56.5194444 0.010000 56.5222222 0.010000 56.5250000 0.010000 56.5277778 0.010000 56.5305556 0.010000 56.5333333 0.010000 56.5361111 0.010000 56.5388889 0.010000 56.5416667 0.010000 56.5444444 0.010000 56.5472222 0.010000 56.5500000 0.010000 56.5527778 0.010000 56.5555556 0.010000 56.5583333 0.010000 56.5611111 0.010000 56.5638889 0.010000 56.5666667 0.010000 56.5694444 0.010000 56.5722222 0.010000 56.5750000 0.010000 56.5777778 0.010000 56.5805556 0.010000 56.5833333 0.010000 56.5861111 0.010000 56.5888889 0.010000 56.5916667 0.010000 56.5944444 0.010000 56.5972222 0.010000 56.6000000 0.010000 56.6027778 0.010000 56.6055556 0.010000 56.6083333 0.010000 56.6111111 0.010000 56.6138889 0.010000 56.6166667 0.010000 56.6194444 0.010000 56.6222222 0.010000 56.6250000 0.010000 56.6277778 0.010000 57.3083333 0.010000 57.3111111 0.010000 57.3138889 0.010000 57.3166667 0.010000 57.3194444 0.010000 57.3222222 0.010000 57.3250000 0.010000 57.3277778 0.010000 57.3305556 0.010000 57.3333333 0.010000 57.3361111 0.010000 57.3388889 0.010000 57.3416667 0.010000 57.3444444 0.010000 57.3472222 0.010000 57.3500000 0.010000 57.3527778 0.010000 57.3555556 0.010000 57.3583333 0.010000 57.3611111 0.010000 57.3638889 0.010000 57.3666667 0.010000 57.3694444 0.010000 57.3722222 0.010000 57.3750000 0.010000 57.3777778 0.010000 57.3805556 0.010000 57.3833333 0.010000 57.3861111 0.010000 57.3888889 0.010000 57.3916667 0.010000 57.3944444 0.010000 57.3972222 0.010000 57.4000000 0.010000 57.4027778 0.010000 57.4055556 0.010000 57.4083333 0.010000 57.4111111 0.010000 57.4138889 0.010000 57.4166667 0.010000 57.4194444 0.010000 57.4222222 0.010000 57.4250000 0.010000 57.4277778 0.010000 57.4305556 0.010000 57.4333333 0.010000 57.4361111 0.010000 57.4388889 0.010000 57.4416667 0.010000 57.4444444 0.010000 57.4472222 0.010000 57.4500000 0.010000 57.4527778 0.010000 57.4555556 0.010000 57.4583333 0.010000 57.4611111 0.010000 57.4638889 0.010000 57.4666667 0.010000 57.4694444 0.010000 57.4722222 0.010000 57.4750000 0.010000 57.4777778 0.010000 57.4805556 0.010000 57.4833333 0.010000 57.4861111 0.010000 57.4888889 0.010000 57.4916667 0.010000 57.4944444 0.010000 57.4972222 0.010000 57.5000000 0.014615 57.5027778 0.047500 57.5055556 0.075192 57.5083333 0.090769 57.5111111 0.102885 57.5138889 0.089038 57.5166667 0.057885 57.5194444 0.010000 57.5222222 0.010000 57.5250000 0.010000 57.5277778 0.010000 57.5305556 0.010000 57.5333333 0.090769 57.5361111 0.187692 57.5388889 0.289808 57.5416667 0.386731 57.5444444 0.471538 57.5472222 0.547692 57.5500000 0.608269 57.5527778 0.649808 57.5555556 0.675769 57.5583333 0.680962 57.5611111 0.668846 57.5638889 0.642885 57.5666667 0.596154 57.5694444 0.532115 57.5722222 0.454231 57.5750000 0.371154 57.5777778 0.289808 57.5805556 0.201538 57.5833333 0.111538 57.5861111 0.026731 57.5888889 0.010000 57.5916667 0.010000 57.5944444 0.010000 57.5972222 0.010000 57.6000000 0.010000 57.6027778 0.010000 57.6055556 0.010000 57.6083333 0.010000 57.6111111 0.010000 57.6138889 0.010000 57.6166667 0.010000 57.6194444 0.010000 57.6222222 0.010000 57.6250000 0.010000 57.6277778 0.010000 57.6305556 0.010000 57.6333333 0.010000 57.6361111 0.010000 57.6388889 0.010000 57.6416667 0.010000 57.6444444 0.010000 57.6472222 0.010000 57.6500000 0.010000 57.6527778 0.010000 57.6555556 0.010000 57.6583333 0.010000 57.6611111 0.010000 57.6638889 0.010000 57.6666667 0.010000 57.6694444 0.010000 57.6722222 0.010000 57.6750000 0.010000 57.6777778 0.010000 57.6805556 0.010000 57.6833333 0.010000 57.6861111 0.010000 57.6888889 0.010000 57.6916667 0.010000 57.6944444 0.010000 57.6972222 0.010000 57.7000000 0.010000 57.7027778 0.010000 57.7055556 0.010000 57.7083333 0.010000 57.7111111 0.010000 57.7138889 0.010000 57.7166667 0.010000 57.7194444 0.010000 57.7222222 0.010000 57.7250000 0.010000 57.7277778 0.010000 57.7305556 0.010000 57.7333333 0.010000 57.7361111 0.010000 57.7388889 0.010000 57.7416667 0.010000 57.7444444 0.010000 57.7472222 0.010000 57.7500000 0.010000 57.7527778 0.010000 57.7555556 0.010000 57.7583333 0.010000 57.7611111 0.010000 57.7638889 0.010000 57.7666667 0.010000 57.7694444 0.010000 57.7722222 0.010000 57.7750000 0.010000 57.7777778 0.010000 57.7805556 0.010000 57.7833333 0.010000 57.7861111 0.010000 57.7888889 0.010000 57.7916667 0.010000 57.7944444 0.010000 57.7972222 0.010000 57.8000000 0.010000 57.8027778 0.010000 57.8055556 0.010000 57.8083333 0.010000 57.8111111 0.010000 57.8138889 0.010000 57.8166667 0.010000 57.8194444 0.010000 57.8222222 0.010000 57.8250000 0.010000 57.8277778 0.010000 57.8305556 0.010000 57.8333333 0.010000 57.8361111 0.010000 57.8388889 0.010000 57.8416667 0.010000 57.8444444 0.010000 57.8472222 0.010000 57.8500000 0.010000 57.8527778 0.010000 57.8555556 0.010000 58.5277778 0.010000 58.5305556 0.010000 58.5333333 0.010000 58.5361111 0.010000 58.5388889 0.010000 58.5416667 0.010000 58.5444444 0.010000 58.5472222 0.010000 58.5500000 0.010000 58.5527778 0.010000 58.5555556 0.010000 58.5583333 0.010000 58.5611111 0.010000 58.5638889 0.010000 58.5666667 0.010000 58.5694444 0.010000 58.5722222 0.010000 58.5750000 0.010000 58.5777778 0.010000 58.5805556 0.010000 58.5833333 0.010000 58.5861111 0.010000 58.5888889 0.010000 58.5916667 0.010000 58.5944444 0.010000 58.5972222 0.010000 58.6000000 0.010000 58.6027778 0.010000 58.6055556 0.010000 58.6083333 0.010000 58.6111111 0.010000 58.6138889 0.010000 58.6166667 0.010000 58.6194444 0.010000 58.6222222 0.010000 58.6250000 0.010000 58.6277778 0.010000 58.6305556 0.010000 58.6333333 0.010000 58.6361111 0.010000 58.6388889 0.010000 58.6416667 0.010000 58.6444444 0.010000 58.6472222 0.010000 58.6500000 0.010000 58.6527778 0.010000 58.6555556 0.010000 58.6583333 0.010000 58.6611111 0.010000 58.6638889 0.010000 58.6666667 0.010000 58.6694444 0.010000 58.6722222 0.010000 58.6750000 0.010000 58.6777778 0.010000 58.6805556 0.010000 58.6833333 0.010000 58.6861111 0.010000 58.6888889 0.010000 58.6916667 0.010000 58.6944444 0.010000 58.6972222 0.010000 58.7000000 0.010000 58.7027778 0.010000 58.7055556 0.010000 58.7083333 0.010000 58.7111111 0.010000 58.7138889 0.010000 58.7166667 0.010000 58.7194444 0.010000 58.7222222 0.028462 58.7250000 0.063077 58.7277778 0.092500 58.7305556 0.115000 58.7333333 0.118462 58.7361111 0.097692 58.7388889 0.059615 58.7416667 0.010000 58.7444444 0.010000 58.7472222 0.010000 58.7500000 0.010000 58.7527778 0.075192 58.7555556 0.173846 58.7583333 0.279423 58.7611111 0.388462 58.7638889 0.487115 58.7666667 0.578846 58.7694444 0.648077 58.7722222 0.705192 58.7750000 0.732885 58.7777778 0.738077 58.7805556 0.719038 58.7833333 0.682692 58.7861111 0.629038 58.7888889 0.559808 58.7916667 0.478462 58.7944444 0.402308 58.7972222 0.322692 58.8000000 0.246538 58.8027778 0.161731 58.8055556 0.087308 58.8083333 0.012885 58.8111111 0.010000 58.8138889 0.010000 58.8166667 0.010000 58.8194444 0.010000 58.8222222 0.010000 58.8250000 0.010000 58.8277778 0.010000 58.8305556 0.010000 58.8333333 0.010000 58.8361111 0.010000 58.8388889 0.010000 58.8416667 0.010000 58.8444444 0.010000 58.8472222 0.010000 58.8500000 0.010000 58.8527778 0.010000 58.8555556 0.010000 58.8583333 0.010000 58.8611111 0.010000 58.8638889 0.010000 58.8666667 0.010000 58.8694444 0.010000 58.8722222 0.010000 58.8750000 0.010000 58.8777778 0.010000 58.8805556 0.010000 58.8833333 0.010000 58.8861111 0.010000 58.8888889 0.010000 58.8916667 0.010000 58.8944444 0.010000 58.8972222 0.010000 58.9000000 0.010000 58.9027778 0.010000 58.9055556 0.010000 58.9083333 0.010000 58.9111111 0.010000 58.9138889 0.010000 58.9166667 0.010000 58.9194444 0.010000 58.9222222 0.010000 58.9250000 0.010000 58.9277778 0.010000 58.9305556 0.010000 58.9333333 0.010000 58.9361111 0.010000 58.9388889 0.010000 58.9416667 0.010000 58.9444444 0.010000 58.9472222 0.010000 58.9500000 0.010000 58.9527778 0.010000 58.9555556 0.010000 58.9583333 0.010000 58.9611111 0.010000 58.9638889 0.010000 58.9666667 0.010000 58.9694444 0.010000 58.9722222 0.010000 58.9750000 0.010000 58.9777778 0.010000 58.9805556 0.010000 58.9833333 0.010000 58.9861111 0.010000 58.9888889 0.010000 58.9916667 0.010000 58.9944444 0.010000 58.9972222 0.010000 59.0000000 0.010000 59.0027778 0.010000 59.0055556 0.010000 59.0083333 0.010000 59.0111111 0.010000 59.0138889 0.010000 59.0166667 0.010000 59.0194444 0.010000 59.0222222 0.010000 59.0250000 0.010000 59.0277778 0.010000 59.0305556 0.010000 59.0333333 0.010000 59.0361111 0.010000 59.0388889 0.010000 59.0416667 0.010000 59.0444444 0.010000 59.0472222 0.010000 59.0500000 0.010000 59.0527778 0.010000 59.0555556 0.010000 59.0583333 0.010000 59.0611111 0.010000 59.0638889 0.010000 59.0666667 0.010000 59.0694444 0.010000 59.0722222 0.010000 59.0750000 0.010000 59.7944444 0.010000 59.7972222 0.010000 59.8000000 0.010000 59.8027778 0.010000 59.8055556 0.010000 59.8083333 0.010000 59.8111111 0.010000 59.8138889 0.010000 59.8166667 0.010000 59.8194444 0.010000 59.8222222 0.010000 59.8250000 0.010000 59.8277778 0.010000 59.8305556 0.010000 59.8333333 0.010000 59.8361111 0.010000 59.8388889 0.010000 59.8416667 0.010000 59.8444444 0.010000 59.8472222 0.010000 59.8500000 0.010000 59.8527778 0.010000 59.8555556 0.010000 59.8583333 0.010000 59.8611111 0.016346 59.8638889 0.018077 59.8666667 0.019808 59.8694444 0.018077 59.8722222 0.014615 59.8750000 0.011154 59.8777778 0.010000 59.8805556 0.010000 59.8833333 0.010000 59.8861111 0.010000 59.8888889 0.010000 59.8916667 0.010000 59.8944444 0.011154 59.8972222 0.010000 59.9000000 0.018077 59.9027778 0.019808 59.9055556 0.023269 59.9083333 0.021538 59.9111111 0.016346 59.9138889 0.016346 59.9166667 0.016346 59.9194444 0.010000 59.9222222 0.010000 59.9250000 0.010000 59.9277778 0.010000 59.9305556 0.010000 59.9333333 0.010000 59.9361111 0.010000 59.9388889 0.010000 59.9416667 0.010000 59.9444444 0.010000 59.9472222 0.010000 59.9500000 0.010000 59.9527778 0.010000 59.9555556 0.010000 59.9583333 0.010000 59.9611111 0.010000 59.9638889 0.010000 59.9666667 0.010000 59.9694444 0.010000 59.9722222 0.010000 59.9750000 0.010000 59.9777778 0.016346 59.9805556 0.045769 59.9833333 0.076923 59.9861111 0.104615 59.9888889 0.121923 59.9916667 0.125385 59.9944444 0.113269 59.9972222 0.076923 60.0000000 0.021538 60.0027778 0.010000 60.0055556 0.010000 60.0083333 0.010000 60.0111111 0.010000 60.0138889 0.014615 60.0166667 0.092500 60.0194444 0.170385 60.0222222 0.251731 60.0250000 0.326154 60.0277778 0.390192 60.0305556 0.447308 60.0333333 0.500962 60.0361111 0.535577 60.0388889 0.559808 60.0416667 0.568462 60.0444444 0.568462 60.0472222 0.556346 60.0500000 0.540769 60.0527778 0.500962 60.0555556 0.445577 60.0583333 0.385000 60.0611111 0.327885 60.0638889 0.270769 60.0666667 0.217115 60.0694444 0.156538 60.0722222 0.099423 60.0750000 0.040577 60.0777778 0.010000 60.0805556 0.010000 60.0833333 0.010000 60.0861111 0.010000 60.0888889 0.010000 60.0916667 0.010000 60.0944444 0.010000 60.0972222 0.010000 60.1000000 0.010000 60.1027778 0.010000 60.1055556 0.010000 60.1083333 0.010000 60.1111111 0.010000 60.1138889 0.010000 60.1166667 0.010000 60.1194444 0.010000 60.1222222 0.010000 60.1250000 0.010000 60.1277778 0.010000 60.1305556 0.010000 60.1333333 0.010000 60.1361111 0.010000 60.1388889 0.010000 60.1416667 0.010000 60.1444444 0.010000 60.1472222 0.010000 60.1500000 0.010000 60.1527778 0.010000 60.1555556 0.010000 60.1583333 0.010000 60.1611111 0.010000 60.1638889 0.010000 60.1666667 0.010000 60.1694444 0.010000 60.1722222 0.010000 60.1750000 0.010000 60.1777778 0.010000 60.1805556 0.010000 60.1833333 0.010000 60.1861111 0.010000 60.1888889 0.010000 60.1916667 0.010000 60.1944444 0.010000 60.1972222 0.010000 60.2000000 0.010000 60.2027778 0.010000 60.2055556 0.010000 60.2083333 0.010000 60.2111111 0.010000 60.2138889 0.010000 60.2166667 0.010000 60.2194444 0.010000 60.2222222 0.010000 60.2250000 0.010000 60.2277778 0.010000 60.2305556 0.010000 60.2333333 0.010000 60.2361111 0.010000 60.2388889 0.010000 60.2416667 0.010000 60.2444444 0.010000 60.2472222 0.010000 60.2500000 0.010000 60.2527778 0.010000 60.2555556 0.010000 60.2583333 0.010000 60.2611111 0.010000 60.2638889 0.010000 60.2666667 0.010000 60.2694444 0.010000 60.2722222 0.010000 60.2750000 0.010000 60.2777778 0.010000 60.2805556 0.010000 60.2833333 0.010000 60.2861111 0.010000 60.2888889 0.010000 60.2916667 0.010000 60.2944444 0.010000 60.2972222 0.010000 60.3000000 0.010000 60.3027778 0.010000 60.3055556 0.010000 60.3083333 0.010000 60.3111111 0.010000 60.3138889 0.010000 60.3166667 0.010000 60.3194444 0.010000 60.3222222 0.010000 60.3250000 0.010000 60.3277778 0.010000 60.3305556 0.010000 60.3333333 0.010000 60.3361111 0.010000 60.3388889 0.010000 60.3416667 0.010000 61.0027778 0.010000 61.0055556 0.010000 61.0083333 0.010000 61.0111111 0.010000 61.0138889 0.010000 61.0166667 0.010000 61.0194444 0.010000 61.0222222 0.010000 61.0250000 0.010000 61.0277778 0.010000 61.0305556 0.010000 61.0333333 0.010000 61.0361111 0.010000 61.0388889 0.010000 61.0416667 0.010000 61.0444444 0.010000 61.0472222 0.010000 61.0500000 0.010000 61.0527778 0.010000 61.0555556 0.010000 61.0583333 0.010000 61.0611111 0.010000 61.0638889 0.010000 61.0666667 0.010000 61.0694444 0.010000 61.0722222 0.010000 61.0750000 0.010000 61.0777778 0.010000 61.0805556 0.010000 61.0833333 0.010000 61.0861111 0.010000 61.0888889 0.010000 61.0916667 0.010000 61.0944444 0.010000 61.0972222 0.010000 61.1000000 0.010000 61.1027778 0.010000 61.1055556 0.010000 61.1083333 0.010000 61.1111111 0.010000 61.1138889 0.010000 61.1166667 0.010000 61.1194444 0.010000 61.1222222 0.010000 61.1250000 0.010000 61.1277778 0.010000 61.1305556 0.010000 61.1333333 0.010000 61.1361111 0.010000 61.1388889 0.010000 61.1416667 0.010000 61.1444444 0.010000 61.1472222 0.010000 61.1500000 0.010000 61.1527778 0.010000 61.1555556 0.010000 61.1583333 0.010000 61.1611111 0.010000 61.1638889 0.010000 61.1666667 0.010000 61.1694444 0.010000 61.1722222 0.010000 61.1750000 0.010000 61.1777778 0.010000 61.1805556 0.010000 61.1833333 0.010000 61.1861111 0.010000 61.1888889 0.010000 61.1916667 0.010000 61.1944444 0.040577 61.1972222 0.068269 61.2000000 0.085577 61.2027778 0.087308 61.2055556 0.070000 61.2083333 0.033654 61.2111111 0.010000 61.2138889 0.010000 61.2166667 0.010000 61.2194444 0.010000 61.2222222 0.025000 61.2250000 0.123654 61.2277778 0.225769 61.2305556 0.329615 61.2333333 0.423077 61.2361111 0.513077 61.2388889 0.584038 61.2416667 0.648077 61.2444444 0.691346 61.2472222 0.713846 61.2500000 0.712115 61.2527778 0.696538 61.2555556 0.674038 61.2583333 0.642885 61.2611111 0.594423 61.2638889 0.535577 61.2666667 0.468077 61.2694444 0.400577 61.2722222 0.331346 61.2750000 0.258654 61.2777778 0.175577 61.2805556 0.089038 61.2833333 0.014615 61.2861111 0.010000 61.2888889 0.010000 61.2916667 0.010000 61.2944444 0.010000 61.2972222 0.010000 61.3000000 0.010000 61.3027778 0.010000 61.3055556 0.010000 61.3083333 0.010000 61.3111111 0.010000 61.3138889 0.010000 61.3166667 0.010000 61.3194444 0.010000 61.3222222 0.010000 61.3250000 0.010000 61.3277778 0.010000 61.3305556 0.010000 61.3333333 0.010000 61.3361111 0.010000 61.3388889 0.010000 61.3416667 0.010000 61.3444444 0.010000 61.3472222 0.010000 61.3500000 0.010000 61.3527778 0.010000 61.3555556 0.010000 61.3583333 0.010000 61.3611111 0.010000 61.3638889 0.010000 61.3666667 0.010000 61.3694444 0.010000 61.3722222 0.010000 61.3750000 0.010000 61.3777778 0.010000 61.3805556 0.010000 61.3833333 0.010000 61.3861111 0.010000 61.3888889 0.010000 61.3916667 0.010000 61.3944444 0.010000 61.3972222 0.010000 61.4000000 0.010000 61.4027778 0.010000 61.4055556 0.010000 61.4083333 0.010000 61.4111111 0.010000 61.4138889 0.010000 61.4166667 0.010000 61.4194444 0.010000 61.4222222 0.010000 61.4250000 0.010000 61.4277778 0.010000 61.4305556 0.010000 61.4333333 0.010000 61.4361111 0.010000 61.4388889 0.010000 61.4416667 0.010000 61.4444444 0.010000 61.4472222 0.010000 61.4500000 0.010000 61.4527778 0.010000 61.4555556 0.010000 61.4583333 0.010000 61.4611111 0.010000 61.4638889 0.010000 61.4666667 0.010000 61.4694444 0.010000 61.4722222 0.010000 61.4750000 0.010000 61.4777778 0.010000 61.4805556 0.010000 61.4833333 0.010000 61.4861111 0.010000 61.4888889 0.010000 61.4916667 0.010000 61.4944444 0.010000 61.4972222 0.010000 61.5000000 0.010000 61.5027778 0.010000 61.5055556 0.010000 61.5083333 0.010000 61.5111111 0.010000 61.5138889 0.010000 61.5166667 0.010000 61.5194444 0.010000 61.5222222 0.010000 61.5250000 0.010000 61.5277778 0.010000 61.5305556 0.010000 61.5333333 0.010000 61.5361111 0.010000 61.5388889 0.010000 61.5416667 0.010000 61.5444444 0.010000 61.5472222 0.010000 61.5500000 0.010000 62.3222222 0.010000 62.3250000 0.010000 62.3277778 0.010000 62.3305556 0.010000 62.3333333 0.010000 62.3361111 0.010000 62.3388889 0.010000 62.3416667 0.010000 62.3444444 0.010000 62.3472222 0.010000 62.3500000 0.010000 62.3527778 0.010000 62.3555556 0.010000 62.3583333 0.010000 62.3611111 0.010000 62.3638889 0.010000 62.3666667 0.010000 62.3694444 0.010000 62.3722222 0.010000 62.3750000 0.010000 62.3777778 0.010000 62.3805556 0.010000 62.3833333 0.010000 62.3861111 0.010000 62.3888889 0.010000 62.3916667 0.010000 62.3944444 0.010000 62.3972222 0.010000 62.4000000 0.010000 62.4027778 0.010000 62.4055556 0.010000 62.4083333 0.010000 62.4111111 0.010000 62.4138889 0.010000 62.4166667 0.010000 62.4194444 0.010000 62.4222222 0.010000 62.4250000 0.010000 62.4277778 0.010000 62.4305556 0.010000 62.4333333 0.010000 62.4361111 0.010000 62.4388889 0.010000 62.4416667 0.010000 62.4444444 0.010000 62.4472222 0.010000 62.4500000 0.010000 62.4527778 0.010000 62.4555556 0.010000 62.4583333 0.010000 62.4611111 0.010000 62.4638889 0.010000 62.4666667 0.010000 62.4694444 0.010000 62.4722222 0.010000 62.4750000 0.010000 62.4777778 0.010000 62.4805556 0.010000 62.4833333 0.010000 62.4861111 0.010000 62.4888889 0.010000 62.4916667 0.010000 62.4944444 0.010000 62.4972222 0.010000 62.5000000 0.010000 62.5027778 0.010000 62.5055556 0.010000 62.5083333 0.010000 62.5111111 0.016346 62.5138889 0.045769 62.5166667 0.071731 62.5194444 0.090769 62.5222222 0.094231 62.5250000 0.087308 62.5277778 0.057885 62.5305556 0.018077 62.5333333 0.010000 62.5361111 0.010000 62.5388889 0.010000 62.5416667 0.021538 62.5444444 0.094231 62.5472222 0.187692 62.5500000 0.279423 62.5527778 0.364231 62.5555556 0.447308 62.5583333 0.525192 62.5611111 0.601346 62.5638889 0.660192 62.5666667 0.705192 62.5694444 0.724231 62.5722222 0.719038 62.5750000 0.696538 62.5777778 0.653269 62.5805556 0.594423 62.5833333 0.521731 62.5861111 0.440385 62.5888889 0.364231 62.5916667 0.288077 62.5944444 0.217115 62.5972222 0.142692 62.6000000 0.075192 62.6027778 0.010000 62.6055556 0.010000 62.6083333 0.010000 62.6111111 0.010000 62.6138889 0.010000 62.6166667 0.010000 62.6194444 0.010000 62.6222222 0.010000 62.6250000 0.010000 62.6277778 0.010000 62.6305556 0.010000 62.6333333 0.010000 62.6361111 0.010000 62.6388889 0.010000 62.6416667 0.010000 62.6444444 0.010000 62.6472222 0.010000 62.6500000 0.010000 62.6527778 0.010000 62.6555556 0.010000 62.6583333 0.010000 62.6611111 0.010000 62.6638889 0.010000 62.6666667 0.010000 62.6694444 0.010000 62.6722222 0.010000 62.6750000 0.010000 62.6777778 0.010000 62.6805556 0.010000 62.6833333 0.010000 62.6861111 0.010000 62.6888889 0.010000 62.6916667 0.010000 62.6944444 0.010000 62.6972222 0.010000 62.7000000 0.010000 62.7027778 0.010000 62.7055556 0.010000 62.7083333 0.010000 62.7111111 0.010000 62.7138889 0.010000 62.7166667 0.010000 62.7194444 0.010000 62.7222222 0.010000 62.7250000 0.010000 62.7277778 0.010000 62.7305556 0.010000 62.7333333 0.010000 62.7361111 0.010000 62.7388889 0.010000 62.7416667 0.010000 62.7444444 0.010000 62.7472222 0.010000 62.7500000 0.010000 62.7527778 0.010000 62.7555556 0.010000 62.7583333 0.010000 62.7611111 0.010000 62.7638889 0.010000 62.7666667 0.010000 62.7694444 0.010000 62.7722222 0.010000 62.7750000 0.010000 62.7777778 0.010000 62.7805556 0.010000 62.7833333 0.010000 62.7861111 0.010000 62.7888889 0.010000 62.7916667 0.010000 62.7944444 0.010000 62.7972222 0.010000 62.8000000 0.010000 62.8027778 0.010000 62.8055556 0.010000 62.8083333 0.010000 62.8111111 0.010000 62.8138889 0.010000 62.8166667 0.010000 62.8194444 0.010000 62.8222222 0.010000 62.8250000 0.010000 62.8277778 0.010000 62.8305556 0.010000 62.8333333 0.010000 62.8361111 0.010000 62.8388889 0.010000 62.8416667 0.010000 62.8444444 0.010000 62.8472222 0.010000 62.8500000 0.010000 62.8527778 0.010000 62.8555556 0.010000 62.8583333 0.010000 62.8611111 0.010000 62.8638889 0.010000 62.8666667 0.010000 62.8694444 0.010000 63.6111111 0.010000 63.6138889 0.010000 63.6166667 0.010000 63.6194444 0.010000 63.6222222 0.010000 63.6250000 0.010000 63.6277778 0.010000 63.6305556 0.010000 63.6333333 0.010000 63.6361111 0.010000 63.6388889 0.010000 63.6416667 0.010000 63.6444444 0.010000 63.6472222 0.010000 63.6500000 0.010000 63.6527778 0.010000 63.6555556 0.010000 63.6583333 0.010000 63.6611111 0.010000 63.6638889 0.010000 63.6666667 0.010000 63.6694444 0.010000 63.6722222 0.010000 63.6750000 0.010000 63.6777778 0.010000 63.6805556 0.010000 63.6833333 0.010000 63.6861111 0.010000 63.6888889 0.010000 63.6916667 0.010000 63.6944444 0.010000 63.6972222 0.010000 63.7000000 0.010000 63.7027778 0.010000 63.7055556 0.010000 63.7083333 0.011154 63.7111111 0.012885 63.7138889 0.010000 63.7166667 0.010000 63.7194444 0.010000 63.7222222 0.010000 63.7250000 0.010000 63.7277778 0.010000 63.7305556 0.010000 63.7333333 0.010000 63.7361111 0.010000 63.7388889 0.010000 63.7416667 0.010000 63.7444444 0.010000 63.7472222 0.010000 63.7500000 0.010000 63.7527778 0.010000 63.7555556 0.010000 63.7583333 0.010000 63.7611111 0.010000 63.7638889 0.010000 63.7666667 0.010000 63.7694444 0.010000 63.7722222 0.010000 63.7750000 0.010000 63.7777778 0.010000 63.7805556 0.010000 63.7833333 0.010000 63.7861111 0.010000 63.7888889 0.010000 63.7916667 0.010000 63.7944444 0.010000 63.7972222 0.042308 63.8000000 0.075192 63.8027778 0.094231 63.8055556 0.106346 63.8083333 0.113269 63.8111111 0.106346 63.8138889 0.078654 63.8166667 0.038846 63.8194444 0.010000 63.8222222 0.010000 63.8250000 0.010000 63.8277778 0.010000 63.8305556 0.057885 63.8333333 0.144423 63.8361111 0.234423 63.8388889 0.326154 63.8416667 0.410962 63.8444444 0.485385 63.8472222 0.545962 63.8500000 0.603077 63.8527778 0.653269 63.8555556 0.684423 63.8583333 0.700000 63.8611111 0.701731 63.8638889 0.687885 63.8666667 0.660192 63.8694444 0.625577 63.8722222 0.566731 63.8750000 0.495769 63.8777778 0.423077 63.8805556 0.348654 63.8833333 0.281154 63.8861111 0.211923 63.8888889 0.135769 63.8916667 0.061346 63.8944444 0.010000 63.8972222 0.010000 63.9000000 0.010000 63.9027778 0.010000 63.9055556 0.010000 63.9083333 0.010000 63.9111111 0.010000 63.9138889 0.010000 63.9166667 0.010000 63.9194444 0.010000 63.9222222 0.010000 63.9250000 0.010000 63.9277778 0.010000 63.9305556 0.010000 63.9333333 0.010000 63.9361111 0.010000 63.9388889 0.010000 63.9416667 0.010000 63.9444444 0.010000 63.9472222 0.010000 63.9500000 0.010000 63.9527778 0.010000 63.9555556 0.010000 63.9583333 0.010000 63.9611111 0.010000 63.9638889 0.010000 63.9666667 0.010000 63.9694444 0.010000 63.9722222 0.010000 63.9750000 0.010000 63.9777778 0.010000 63.9805556 0.010000 63.9833333 0.010000 63.9861111 0.010000 63.9888889 0.010000 63.9916667 0.010000 63.9944444 0.010000 63.9972222 0.010000 64.0000000 0.010000 64.0027778 0.010000 64.0055556 0.010000 64.0083333 0.010000 64.0111111 0.010000 64.0138889 0.010000 64.0166667 0.010000 64.0194444 0.010000 64.0222222 0.010000 64.0250000 0.010000 64.0277778 0.010000 64.0305556 0.010000 64.0333333 0.010000 64.0361111 0.010000 64.0388889 0.010000 64.0416667 0.010000 64.0444444 0.010000 64.0472222 0.010000 64.0500000 0.010000 64.0527778 0.010000 64.0555556 0.010000 64.0583333 0.010000 64.0611111 0.010000 64.0638889 0.010000 64.0666667 0.010000 64.0694444 0.010000 64.0722222 0.010000 64.0750000 0.010000 64.0777778 0.010000 64.0805556 0.010000 64.0833333 0.010000 64.0861111 0.010000 64.0888889 0.010000 64.0916667 0.010000 64.0944444 0.010000 64.0972222 0.010000 64.1000000 0.010000 64.1027778 0.010000 64.1055556 0.010000 64.1083333 0.010000 64.1111111 0.010000 64.1138889 0.010000 64.1166667 0.010000 64.1194444 0.010000 64.1222222 0.010000 64.1250000 0.010000 64.1277778 0.010000 64.1305556 0.010000 64.1333333 0.010000 64.1361111 0.010000 64.1388889 0.010000 64.1416667 0.010000 64.1444444 0.010000 64.1472222 0.010000 64.1500000 0.010000 64.1527778 0.010000 64.1555556 0.010000 64.1583333 0.010000 64.8694444 0.010000 64.8722222 0.010000 64.8750000 0.010000 64.8777778 0.010000 64.8805556 0.010000 64.8833333 0.010000 64.8861111 0.010000 64.8888889 0.010000 64.8916667 0.010000 64.8944444 0.010000 64.8972222 0.010000 64.9000000 0.010000 64.9027778 0.010000 64.9055556 0.010000 64.9083333 0.010000 64.9111111 0.010000 64.9138889 0.010000 64.9166667 0.010000 64.9194444 0.010000 64.9222222 0.010000 64.9250000 0.010000 64.9277778 0.010000 64.9305556 0.010000 64.9333333 0.010000 64.9361111 0.010000 64.9388889 0.010000 64.9416667 0.010000 64.9444444 0.010000 64.9472222 0.010000 64.9500000 0.010000 64.9527778 0.010000 64.9555556 0.010000 64.9583333 0.010000 64.9611111 0.010000 64.9638889 0.010000 64.9666667 0.010000 64.9694444 0.010000 64.9722222 0.010000 64.9750000 0.010000 64.9777778 0.010000 64.9805556 0.010000 64.9833333 0.010000 64.9861111 0.010000 64.9888889 0.010000 64.9916667 0.010000 64.9944444 0.010000 64.9972222 0.010000 65.0000000 0.010000 65.0027778 0.010000 65.0055556 0.010000 65.0083333 0.010000 65.0111111 0.010000 65.0138889 0.010000 65.0166667 0.010000 65.0194444 0.010000 65.0222222 0.010000 65.0250000 0.010000 65.0277778 0.010000 65.0305556 0.010000 65.0333333 0.010000 65.0361111 0.010000 65.0388889 0.010000 65.0416667 0.010000 65.0444444 0.010000 65.0472222 0.010000 65.0500000 0.010000 65.0527778 0.010000 65.0555556 0.010000 65.0583333 0.010000 65.0611111 0.012885 65.0638889 0.049231 65.0666667 0.076923 65.0694444 0.099423 65.0722222 0.106346 65.0750000 0.095962 65.0777778 0.052692 65.0805556 0.010000 65.0833333 0.010000 65.0861111 0.010000 65.0888889 0.010000 65.0916667 0.010000 65.0944444 0.066538 65.0972222 0.161731 65.1000000 0.262115 65.1027778 0.352115 65.1055556 0.442115 65.1083333 0.509615 65.1111111 0.570192 65.1138889 0.608269 65.1166667 0.629038 65.1194444 0.629038 65.1222222 0.610000 65.1250000 0.578846 65.1277778 0.528654 65.1305556 0.473269 65.1333333 0.398846 65.1361111 0.327885 65.1388889 0.251731 65.1416667 0.177308 65.1444444 0.097692 65.1472222 0.023269 65.1500000 0.010000 65.1527778 0.010000 65.1555556 0.010000 65.1583333 0.010000 65.1611111 0.010000 65.1638889 0.010000 65.1666667 0.010000 65.1694444 0.010000 65.1722222 0.010000 65.1750000 0.010000 65.1777778 0.010000 65.1805556 0.010000 65.1833333 0.010000 65.1861111 0.010000 65.1888889 0.010000 65.1916667 0.010000 65.1944444 0.010000 65.1972222 0.010000 65.2000000 0.010000 65.2027778 0.010000 65.2055556 0.010000 65.2083333 0.010000 65.2111111 0.010000 65.2138889 0.010000 65.2166667 0.010000 65.2194444 0.010000 65.2222222 0.010000 65.2250000 0.010000 65.2277778 0.010000 65.2305556 0.010000 65.2333333 0.010000 65.2361111 0.010000 65.2388889 0.010000 65.2416667 0.010000 65.2444444 0.010000 65.2472222 0.010000 65.2500000 0.010000 65.2527778 0.010000 65.2555556 0.010000 65.2583333 0.010000 65.2611111 0.010000 65.2638889 0.010000 65.2666667 0.010000 65.2694444 0.010000 65.2722222 0.010000 65.2750000 0.010000 65.2777778 0.010000 65.2805556 0.010000 65.2833333 0.010000 65.2861111 0.010000 65.2888889 0.010000 65.2916667 0.010000 65.2944444 0.010000 65.2972222 0.010000 65.3000000 0.010000 65.3027778 0.010000 65.3055556 0.010000 65.3083333 0.010000 65.3111111 0.010000 65.3138889 0.010000 65.3166667 0.010000 65.3194444 0.010000 65.3222222 0.010000 65.3250000 0.010000 65.3277778 0.010000 65.3305556 0.010000 65.3333333 0.010000 65.3361111 0.010000 65.3388889 0.010000 65.3416667 0.010000 65.3444444 0.010000 65.3472222 0.010000 65.3500000 0.010000 65.3527778 0.010000 65.3555556 0.010000 65.3583333 0.010000 65.3611111 0.010000 65.3638889 0.010000 65.3666667 0.010000 65.3694444 0.010000 65.3722222 0.010000 65.3750000 0.010000 65.3777778 0.010000 65.3805556 0.010000 65.3833333 0.010000 65.3861111 0.010000 65.3888889 0.010000 65.3916667 0.010000 65.3944444 0.010000 65.3972222 0.010000 65.4000000 0.010000 65.4027778 0.010000 65.4055556 0.010000 65.4083333 0.010000 65.4111111 0.010000 65.4138889 0.010000 65.4166667 0.010000 66.0833333 0.010000 66.0861111 0.010000 66.0888889 0.010000 66.0916667 0.010000 66.0944444 0.010000 66.0972222 0.010000 66.1000000 0.010000 66.1027778 0.010000 66.1055556 0.010000 66.1083333 0.010000 66.1111111 0.010000 66.1138889 0.010000 66.1166667 0.010000 66.1194444 0.010000 66.1222222 0.010000 66.1250000 0.010000 66.1277778 0.010000 66.1305556 0.010000 66.1333333 0.010000 66.1361111 0.010000 66.1388889 0.010000 66.1416667 0.010000 66.1444444 0.010000 66.1472222 0.010000 66.1500000 0.010000 66.1527778 0.010000 66.1555556 0.010000 66.1583333 0.010000 66.1611111 0.010000 66.1638889 0.010000 66.1666667 0.010000 66.1694444 0.010000 66.1722222 0.010000 66.1750000 0.010000 66.1777778 0.010000 66.1805556 0.010000 66.1833333 0.010000 66.1861111 0.010000 66.1888889 0.010000 66.1916667 0.010000 66.1944444 0.010000 66.1972222 0.010000 66.2000000 0.010000 66.2027778 0.010000 66.2055556 0.010000 66.2083333 0.010000 66.2111111 0.010000 66.2138889 0.010000 66.2166667 0.010000 66.2194444 0.010000 66.2222222 0.010000 66.2250000 0.010000 66.2277778 0.010000 66.2305556 0.010000 66.2333333 0.010000 66.2361111 0.010000 66.2388889 0.010000 66.2416667 0.010000 66.2444444 0.010000 66.2472222 0.010000 66.2500000 0.010000 66.2527778 0.010000 66.2555556 0.010000 66.2583333 0.010000 66.2611111 0.010000 66.2638889 0.010000 66.2666667 0.010000 66.2694444 0.010000 66.2722222 0.010000 66.2750000 0.031923 66.2777778 0.057885 66.2805556 0.076923 66.2833333 0.089038 66.2861111 0.080385 66.2888889 0.050962 66.2916667 0.012885 66.2944444 0.010000 66.2972222 0.010000 66.3000000 0.010000 66.3027778 0.010000 66.3055556 0.075192 66.3083333 0.166923 66.3111111 0.260385 66.3138889 0.353846 66.3166667 0.435192 66.3194444 0.516538 66.3222222 0.589231 66.3250000 0.651538 66.3277778 0.694808 66.3305556 0.719038 66.3333333 0.720769 66.3361111 0.706923 66.3388889 0.665385 66.3416667 0.616923 66.3444444 0.551154 66.3472222 0.466346 66.3500000 0.385000 66.3527778 0.303654 66.3555556 0.227500 66.3583333 0.151346 66.3611111 0.075192 66.3638889 0.010000 66.3666667 0.010000 66.3694444 0.010000 66.3722222 0.010000 66.3750000 0.010000 66.3777778 0.010000 66.3805556 0.010000 66.3833333 0.010000 66.3861111 0.010000 66.3888889 0.010000 66.3916667 0.010000 66.3944444 0.010000 66.3972222 0.010000 66.4000000 0.010000 66.4027778 0.010000 66.4055556 0.010000 66.4083333 0.010000 66.4111111 0.010000 66.4138889 0.010000 66.4166667 0.010000 66.4194444 0.010000 66.4222222 0.010000 66.4250000 0.010000 66.4277778 0.010000 66.4305556 0.010000 66.4333333 0.010000 66.4361111 0.010000 66.4388889 0.010000 66.4416667 0.010000 66.4444444 0.010000 66.4472222 0.010000 66.4500000 0.010000 66.4527778 0.010000 66.4555556 0.010000 66.4583333 0.010000 66.4611111 0.010000 66.4638889 0.010000 66.4666667 0.010000 66.4694444 0.010000 66.4722222 0.010000 66.4750000 0.010000 66.4777778 0.010000 66.4805556 0.010000 66.4833333 0.010000 66.4861111 0.010000 66.4888889 0.010000 66.4916667 0.010000 66.4944444 0.010000 66.4972222 0.010000 66.5000000 0.010000 66.5027778 0.010000 66.5055556 0.010000 66.5083333 0.010000 66.5111111 0.010000 66.5138889 0.010000 66.5166667 0.010000 66.5194444 0.010000 66.5222222 0.010000 66.5250000 0.010000 66.5277778 0.010000 66.5305556 0.010000 66.5333333 0.010000 66.5361111 0.010000 66.5388889 0.010000 66.5416667 0.010000 66.5444444 0.010000 66.5472222 0.010000 66.5500000 0.010000 66.5527778 0.010000 66.5555556 0.010000 66.5583333 0.010000 66.5611111 0.010000 66.5638889 0.010000 66.5666667 0.010000 66.5694444 0.010000 66.5722222 0.010000 66.5750000 0.010000 66.5777778 0.010000 66.5805556 0.010000 66.5833333 0.010000 66.5861111 0.010000 66.5888889 0.010000 66.5916667 0.010000 66.5944444 0.010000 66.5972222 0.010000 66.6000000 0.010000 66.6027778 0.010000 66.6055556 0.010000 66.6083333 0.010000 66.6111111 0.010000 66.6138889 0.010000 66.6166667 0.010000 66.6194444 0.010000 66.6222222 0.010000 66.6250000 0.010000 66.6277778 0.010000 66.6305556 0.010000 67.2944444 0.010000 67.2972222 0.010000 67.3000000 0.010000 67.3027778 0.010000 67.3055556 0.010000 67.3083333 0.010000 67.3111111 0.010000 67.3138889 0.010000 67.3166667 0.010000 67.3194444 0.010000 67.3222222 0.010000 67.3250000 0.010000 67.3277778 0.010000 67.3305556 0.010000 67.3333333 0.010000 67.3361111 0.010000 67.3388889 0.010000 67.3416667 0.010000 67.3444444 0.010000 67.3472222 0.010000 67.3500000 0.010000 67.3527778 0.010000 67.3555556 0.010000 67.3583333 0.010000 67.3611111 0.010000 67.3638889 0.010000 67.3666667 0.010000 67.3694444 0.010000 67.3722222 0.010000 67.3750000 0.010000 67.3777778 0.010000 67.3805556 0.010000 67.3833333 0.010000 67.3861111 0.010000 67.3888889 0.010000 67.3916667 0.010000 67.3944444 0.010000 67.3972222 0.010000 67.4000000 0.010000 67.4027778 0.014615 67.4055556 0.011154 67.4083333 0.010000 67.4111111 0.010000 67.4138889 0.010000 67.4166667 0.010000 67.4194444 0.010000 67.4222222 0.010000 67.4250000 0.010000 67.4277778 0.010000 67.4305556 0.010000 67.4333333 0.010000 67.4361111 0.010000 67.4388889 0.010000 67.4416667 0.010000 67.4444444 0.010000 67.4472222 0.010000 67.4500000 0.010000 67.4527778 0.010000 67.4555556 0.010000 67.4583333 0.010000 67.4611111 0.010000 67.4638889 0.010000 67.4666667 0.010000 67.4694444 0.010000 67.4722222 0.010000 67.4750000 0.010000 67.4777778 0.010000 67.4805556 0.012885 67.4833333 0.045769 67.4861111 0.080385 67.4888889 0.108077 67.4916667 0.132308 67.4944444 0.134038 67.4972222 0.116731 67.5000000 0.071731 67.5027778 0.018077 67.5055556 0.010000 67.5083333 0.010000 67.5111111 0.010000 67.5138889 0.010000 67.5166667 0.070000 67.5194444 0.153077 67.5222222 0.236154 67.5250000 0.314038 67.5277778 0.388462 67.5305556 0.459423 67.5333333 0.520000 67.5361111 0.577115 67.5388889 0.613462 67.5416667 0.635962 67.5444444 0.642885 67.5472222 0.630769 67.5500000 0.610000 67.5527778 0.577115 67.5555556 0.526923 67.5583333 0.471538 67.5611111 0.407500 67.5638889 0.345192 67.5666667 0.281154 67.5694444 0.222308 67.5722222 0.154808 67.5750000 0.085577 67.5777778 0.023269 67.5805556 0.010000 67.5833333 0.010000 67.5861111 0.010000 67.5888889 0.010000 67.5916667 0.010000 67.5944444 0.010000 67.5972222 0.010000 67.6000000 0.010000 67.6027778 0.010000 67.6055556 0.010000 67.6083333 0.010000 67.6111111 0.010000 67.6138889 0.010000 67.6166667 0.010000 67.6194444 0.010000 67.6222222 0.010000 67.6250000 0.010000 67.6277778 0.010000 67.6305556 0.010000 67.6333333 0.010000 67.6361111 0.010000 67.6388889 0.010000 67.6416667 0.010000 67.6444444 0.010000 67.6472222 0.010000 67.6500000 0.010000 67.6527778 0.010000 67.6555556 0.010000 67.6583333 0.010000 67.6611111 0.010000 67.6638889 0.010000 67.6666667 0.010000 67.6694444 0.010000 67.6722222 0.010000 67.6750000 0.010000 67.6777778 0.010000 67.6805556 0.010000 67.6833333 0.010000 67.6861111 0.010000 67.6888889 0.010000 67.6916667 0.010000 67.6944444 0.010000 67.6972222 0.010000 67.7000000 0.010000 67.7027778 0.010000 67.7055556 0.010000 67.7083333 0.010000 67.7111111 0.010000 67.7138889 0.010000 67.7166667 0.010000 67.7194444 0.010000 67.7222222 0.010000 67.7250000 0.010000 67.7277778 0.010000 67.7305556 0.010000 67.7333333 0.010000 67.7361111 0.010000 67.7388889 0.010000 67.7416667 0.010000 67.7444444 0.010000 67.7472222 0.010000 67.7500000 0.010000 67.7527778 0.010000 67.7555556 0.010000 67.7583333 0.010000 67.7611111 0.010000 67.7638889 0.010000 67.7666667 0.010000 67.7694444 0.010000 67.7722222 0.010000 67.7750000 0.010000 67.7777778 0.010000 67.7805556 0.010000 67.7833333 0.010000 67.7861111 0.010000 67.7888889 0.010000 67.7916667 0.010000 67.7944444 0.010000 67.7972222 0.010000 67.8000000 0.010000 67.8027778 0.010000 67.8055556 0.010000 67.8083333 0.010000 67.8111111 0.010000 67.8138889 0.010000 67.8166667 0.010000 67.8194444 0.010000 67.8222222 0.010000 67.8250000 0.010000 67.8277778 0.010000 67.8305556 0.010000 67.8333333 0.010000 67.8361111 0.010000 67.8388889 0.010000 67.8416667 0.010000 68.4611111 0.010000 68.4638889 0.011154 68.4666667 0.016346 68.4694444 0.018077 68.4722222 0.019808 68.4750000 0.018077 68.4777778 0.016346 68.4805556 0.012885 68.4833333 0.014615 68.4861111 0.014615 68.4888889 0.018077 68.4916667 0.019808 68.4944444 0.018077 68.4972222 0.023269 68.5000000 0.026731 68.5027778 0.028462 68.5055556 0.031923 68.5083333 0.026731 68.5111111 0.026731 68.5138889 0.028462 68.5166667 0.030192 68.5194444 0.025000 68.5222222 0.031923 68.5250000 0.033654 68.5277778 0.033654 68.5305556 0.035385 68.5333333 0.042308 68.5361111 0.040577 68.5388889 0.042308 68.5416667 0.035385 68.5444444 0.033654 68.5472222 0.026731 68.5500000 0.028462 68.5527778 0.021538 68.5555556 0.023269 68.5583333 0.023269 68.5611111 0.028462 68.5638889 0.028462 68.5666667 0.035385 68.5694444 0.042308 68.5722222 0.049231 68.5750000 0.050962 68.5777778 0.052692 68.5805556 0.049231 68.5833333 0.045769 68.5861111 0.038846 68.5888889 0.033654 68.5916667 0.035385 68.5944444 0.026731 68.5972222 0.025000 68.6000000 0.021538 68.6027778 0.018077 68.6055556 0.018077 68.6083333 0.018077 68.6111111 0.018077 68.6138889 0.014615 68.6166667 0.014615 68.6194444 0.014615 68.6222222 0.011154 68.6250000 0.014615 68.6277778 0.012885 68.6305556 0.016346 68.6333333 0.016346 68.6361111 0.014615 68.6388889 0.012885 68.6416667 0.011154 68.6444444 0.011154 68.6472222 0.023269 68.6500000 0.045769 68.6527778 0.075192 68.6555556 0.099423 68.6583333 0.121923 68.6611111 0.144423 68.6638889 0.154808 68.6666667 0.147885 68.6694444 0.120192 68.6722222 0.078654 68.6750000 0.035385 68.6777778 0.010000 68.6805556 0.014615 68.6833333 0.063077 68.6861111 0.137500 68.6888889 0.230962 68.6916667 0.331346 68.6944444 0.430000 68.6972222 0.532115 68.7000000 0.623846 68.7027778 0.706923 68.7055556 0.767500 68.7083333 0.798654 68.7111111 0.803846 68.7138889 0.777885 68.7166667 0.729423 68.7194444 0.668846 68.7222222 0.590962 68.7250000 0.504423 68.7277778 0.419615 68.7305556 0.338269 68.7333333 0.262115 68.7361111 0.185962 68.7388889 0.113269 68.7416667 0.040577 68.7444444 0.010000 68.7472222 0.010000 68.7500000 0.010000 68.7527778 0.010000 68.7555556 0.010000 68.7583333 0.010000 68.7611111 0.010000 68.7638889 0.010000 68.7666667 0.010000 68.7694444 0.010000 68.7722222 0.010000 68.7750000 0.010000 68.7777778 0.010000 68.7805556 0.010000 68.7833333 0.010000 68.7861111 0.010000 68.7888889 0.010000 68.7916667 0.010000 68.7944444 0.010000 68.7972222 0.010000 68.8000000 0.010000 68.8027778 0.010000 68.8055556 0.010000 68.8083333 0.010000 68.8111111 0.010000 68.8138889 0.010000 68.8166667 0.010000 68.8194444 0.010000 68.8222222 0.010000 68.8250000 0.010000 68.8277778 0.010000 68.8305556 0.010000 68.8333333 0.010000 68.8361111 0.010000 68.8388889 0.010000 68.8416667 0.010000 68.8444444 0.010000 68.8472222 0.010000 68.8500000 0.010000 68.8527778 0.010000 68.8555556 0.010000 68.8583333 0.010000 68.8611111 0.010000 68.8638889 0.010000 68.8666667 0.010000 68.8694444 0.010000 68.8722222 0.010000 68.8750000 0.010000 68.8777778 0.010000 68.8805556 0.010000 68.8833333 0.010000 68.8861111 0.010000 68.8888889 0.010000 68.8916667 0.010000 68.8944444 0.010000 68.8972222 0.010000 68.9000000 0.010000 68.9027778 0.010000 68.9055556 0.010000 68.9083333 0.010000 68.9111111 0.010000 68.9138889 0.010000 68.9166667 0.010000 68.9194444 0.010000 68.9222222 0.010000 68.9250000 0.010000 68.9277778 0.010000 68.9305556 0.010000 68.9333333 0.010000 68.9361111 0.010000 68.9388889 0.010000 68.9416667 0.010000 68.9444444 0.010000 68.9472222 0.010000 68.9500000 0.010000 68.9527778 0.010000 68.9555556 0.010000 68.9583333 0.010000 68.9611111 0.010000 68.9638889 0.010000 68.9666667 0.010000 68.9694444 0.010000 68.9722222 0.010000 68.9750000 0.010000 68.9777778 0.010000 68.9805556 0.010000 68.9833333 0.010000 68.9861111 0.010000 68.9888889 0.010000 68.9916667 0.010000 68.9944444 0.010000 68.9972222 0.010000 69.0000000 0.010000 69.0027778 0.010000 69.0055556 0.010000 69.0083333 0.010000 69.6611111 0.035385 69.6638889 0.037115 69.6666667 0.038846 69.6694444 0.040577 69.6722222 0.042308 69.6750000 0.042308 69.6777778 0.047500 69.6805556 0.044038 69.6833333 0.045769 69.6861111 0.040577 69.6888889 0.044038 69.6916667 0.037115 69.6944444 0.042308 69.6972222 0.049231 69.7000000 0.050962 69.7027778 0.050962 69.7055556 0.056154 69.7083333 0.050962 69.7111111 0.047500 69.7138889 0.050962 69.7166667 0.052692 69.7194444 0.054423 69.7222222 0.056154 69.7250000 0.057885 69.7277778 0.064808 69.7305556 0.070000 69.7333333 0.070000 69.7361111 0.073462 69.7388889 0.071731 69.7416667 0.064808 69.7444444 0.059615 69.7472222 0.054423 69.7500000 0.052692 69.7527778 0.050962 69.7555556 0.050962 69.7583333 0.050962 69.7611111 0.050962 69.7638889 0.052692 69.7666667 0.061346 69.7694444 0.068269 69.7722222 0.070000 69.7750000 0.071731 69.7777778 0.080385 69.7805556 0.073462 69.7833333 0.066538 69.7861111 0.064808 69.7888889 0.059615 69.7916667 0.052692 69.7944444 0.049231 69.7972222 0.045769 69.8000000 0.045769 69.8027778 0.040577 69.8055556 0.040577 69.8083333 0.037115 69.8111111 0.038846 69.8138889 0.040577 69.8166667 0.035385 69.8194444 0.035385 69.8222222 0.028462 69.8250000 0.033654 69.8277778 0.037115 69.8305556 0.038846 69.8333333 0.038846 69.8361111 0.038846 69.8388889 0.035385 69.8416667 0.035385 69.8444444 0.038846 69.8472222 0.056154 69.8500000 0.085577 69.8527778 0.113269 69.8555556 0.144423 69.8583333 0.170385 69.8611111 0.182500 69.8638889 0.177308 69.8666667 0.146154 69.8694444 0.090769 69.8722222 0.035385 69.8750000 0.010000 69.8777778 0.010000 69.8805556 0.042308 69.8833333 0.111538 69.8861111 0.199808 69.8888889 0.291538 69.8916667 0.379808 69.8944444 0.462885 69.8972222 0.544231 69.9000000 0.610000 69.9027778 0.660192 69.9055556 0.693077 69.9083333 0.713846 69.9111111 0.712115 69.9138889 0.689615 69.9166667 0.658462 69.9194444 0.606538 69.9222222 0.539038 69.9250000 0.461154 69.9277778 0.386731 69.9305556 0.310577 69.9333333 0.225769 69.9361111 0.146154 69.9388889 0.080385 69.9416667 0.019808 69.9444444 0.010000 69.9472222 0.010000 69.9500000 0.010000 69.9527778 0.010000 69.9555556 0.010000 69.9583333 0.010000 69.9611111 0.010000 69.9638889 0.010000 69.9666667 0.010000 69.9694444 0.010000 69.9722222 0.010000 69.9750000 0.010000 69.9777778 0.010000 69.9805556 0.010000 69.9833333 0.010000 69.9861111 0.010000 69.9888889 0.010000 69.9916667 0.010000 69.9944444 0.010000 69.9972222 0.010000 70.0000000 0.010000 70.0027778 0.010000 70.0055556 0.010000 70.0083333 0.010000 70.0111111 0.010000 70.0138889 0.010000 70.0166667 0.010000 70.0194444 0.010000 70.0222222 0.010000 70.0250000 0.010000 70.0277778 0.010000 70.0305556 0.010000 70.0333333 0.010000 70.0361111 0.010000 70.0388889 0.010000 70.0416667 0.010000 70.0444444 0.010000 70.0472222 0.010000 70.0500000 0.010000 70.0527778 0.010000 70.0555556 0.010000 70.0583333 0.010000 70.0611111 0.010000 70.0638889 0.010000 70.0666667 0.010000 70.0694444 0.010000 70.0722222 0.010000 70.0750000 0.010000 70.0777778 0.010000 70.0805556 0.010000 70.0833333 0.010000 70.0861111 0.010000 70.0888889 0.010000 70.0916667 0.010000 70.0944444 0.010000 70.0972222 0.010000 70.1000000 0.010000 70.1027778 0.010000 70.1055556 0.010000 70.1083333 0.010000 70.1111111 0.010000 70.1138889 0.010000 70.1166667 0.010000 70.1194444 0.010000 70.1222222 0.010000 70.1250000 0.010000 70.1277778 0.010000 70.1305556 0.010000 70.1333333 0.010000 70.1361111 0.010000 70.1388889 0.010000 70.1416667 0.010000 70.1444444 0.010000 70.1472222 0.010000 70.1500000 0.010000 70.1527778 0.010000 70.1555556 0.010000 70.1583333 0.010000 70.1611111 0.010000 70.1638889 0.010000 70.1666667 0.010000 70.1694444 0.010000 70.1722222 0.010000 70.1750000 0.010000 70.1777778 0.010000 70.1805556 0.010000 70.1833333 0.010000 70.1861111 0.010000 70.1888889 0.010000 70.1916667 0.010000 70.1944444 0.010000 70.1972222 0.010000 70.2000000 0.010000 70.2027778 0.010000 70.2055556 0.010000 70.2083333 0.010000 70.8083333 0.045769 70.8111111 0.047500 70.8138889 0.045769 70.8166667 0.044038 70.8194444 0.040577 70.8222222 0.045769 70.8250000 0.042308 70.8277778 0.040577 70.8305556 0.045769 70.8333333 0.042308 70.8361111 0.050962 70.8388889 0.057885 70.8416667 0.054423 70.8444444 0.054423 70.8472222 0.052692 70.8500000 0.052692 70.8527778 0.052692 70.8555556 0.049231 70.8583333 0.049231 70.8611111 0.050962 70.8638889 0.045769 70.8666667 0.047500 70.8694444 0.057885 70.8722222 0.059615 70.8750000 0.068269 70.8777778 0.068269 70.8805556 0.068269 70.8833333 0.064808 70.8861111 0.061346 70.8888889 0.059615 70.8916667 0.064808 70.8944444 0.059615 70.8972222 0.059615 70.9000000 0.057885 70.9027778 0.057885 70.9055556 0.061346 70.9083333 0.061346 70.9111111 0.054423 70.9138889 0.056154 70.9166667 0.054423 70.9194444 0.056154 70.9222222 0.059615 70.9250000 0.064808 70.9277778 0.068269 70.9305556 0.076923 70.9333333 0.078654 70.9361111 0.076923 70.9388889 0.075192 70.9416667 0.068269 70.9444444 0.061346 70.9472222 0.052692 70.9500000 0.040577 70.9527778 0.035385 70.9555556 0.035385 70.9583333 0.033654 70.9611111 0.035385 70.9638889 0.038846 70.9666667 0.040577 70.9694444 0.037115 70.9722222 0.044038 70.9750000 0.038846 70.9777778 0.042308 70.9805556 0.035385 70.9833333 0.033654 70.9861111 0.030192 70.9888889 0.026731 70.9916667 0.030192 70.9944444 0.049231 70.9972222 0.082115 71.0000000 0.120192 71.0027778 0.149615 71.0055556 0.173846 71.0083333 0.187692 71.0111111 0.184231 71.0138889 0.158269 71.0166667 0.111538 71.0194444 0.066538 71.0222222 0.028462 71.0250000 0.028462 71.0277778 0.070000 71.0305556 0.142692 71.0333333 0.234423 71.0361111 0.336538 71.0388889 0.435192 71.0416667 0.526923 71.0444444 0.613462 71.0472222 0.677500 71.0500000 0.731154 71.0527778 0.764038 71.0555556 0.777885 71.0583333 0.774423 71.0611111 0.757115 71.0638889 0.720769 71.0666667 0.675769 71.0694444 0.611731 71.0722222 0.539038 71.0750000 0.459423 71.0777778 0.386731 71.0805556 0.314038 71.0833333 0.239615 71.0861111 0.172115 71.0888889 0.106346 71.0916667 0.052692 71.0944444 0.010000 71.0972222 0.010000 71.1000000 0.010000 71.1027778 0.010000 71.1055556 0.010000 71.1083333 0.010000 71.1111111 0.010000 71.1138889 0.010000 71.1166667 0.010000 71.1194444 0.010000 71.1222222 0.010000 71.1250000 0.010000 71.1277778 0.010000 71.1305556 0.010000 71.1333333 0.010000 71.1361111 0.010000 71.1388889 0.010000 71.1416667 0.010000 71.1444444 0.010000 71.1472222 0.010000 71.1500000 0.010000 71.1527778 0.010000 71.1555556 0.010000 71.1583333 0.010000 71.1611111 0.010000 71.1638889 0.010000 71.1666667 0.010000 71.1694444 0.010000 71.1722222 0.010000 71.1750000 0.010000 71.1777778 0.010000 71.1805556 0.010000 71.1833333 0.010000 71.1861111 0.010000 71.1888889 0.010000 71.1916667 0.010000 71.1944444 0.010000 71.1972222 0.010000 71.2000000 0.010000 71.2027778 0.010000 71.2055556 0.010000 71.2083333 0.010000 71.2111111 0.010000 71.2138889 0.010000 71.2166667 0.010000 71.2194444 0.010000 71.2222222 0.010000 71.2250000 0.010000 71.2277778 0.010000 71.2305556 0.010000 71.2333333 0.010000 71.2361111 0.010000 71.2388889 0.010000 71.2416667 0.010000 71.2444444 0.010000 71.2472222 0.010000 71.2500000 0.010000 71.2527778 0.010000 71.2555556 0.010000 71.2583333 0.010000 71.2611111 0.010000 71.2638889 0.010000 71.2666667 0.010000 71.2694444 0.010000 71.2722222 0.010000 71.2750000 0.010000 71.2777778 0.010000 71.2805556 0.010000 71.2833333 0.010000 71.2861111 0.010000 71.2888889 0.010000 71.2916667 0.010000 71.2944444 0.010000 71.2972222 0.010000 71.3000000 0.010000 71.3027778 0.010000 71.3055556 0.010000 71.3083333 0.010000 71.3111111 0.010000 71.3138889 0.010000 71.3166667 0.010000 71.3194444 0.010000 71.3222222 0.010000 71.3250000 0.010000 71.3277778 0.010000 71.3305556 0.010000 71.3333333 0.010000 71.3361111 0.010000 71.3388889 0.010000 71.3416667 0.010000 71.3444444 0.010000 71.3472222 0.010000 71.3500000 0.010000 71.3527778 0.010000 71.3555556 0.010000 72.0388889 0.040577 72.0416667 0.042308 72.0444444 0.042308 72.0472222 0.040577 72.0500000 0.038846 72.0527778 0.040577 72.0555556 0.035385 72.0583333 0.033654 72.0611111 0.037115 72.0638889 0.042308 72.0666667 0.044038 72.0694444 0.047500 72.0722222 0.054423 72.0750000 0.052692 72.0777778 0.057885 72.0805556 0.052692 72.0833333 0.045769 72.0861111 0.045769 72.0888889 0.042308 72.0916667 0.044038 72.0944444 0.044038 72.0972222 0.047500 72.1000000 0.052692 72.1027778 0.066538 72.1055556 0.066538 72.1083333 0.064808 72.1111111 0.068269 72.1138889 0.064808 72.1166667 0.061346 72.1194444 0.059615 72.1222222 0.052692 72.1250000 0.054423 72.1277778 0.050962 72.1305556 0.050962 72.1333333 0.050962 72.1361111 0.054423 72.1388889 0.057885 72.1416667 0.056154 72.1444444 0.057885 72.1472222 0.061346 72.1500000 0.063077 72.1527778 0.071731 72.1555556 0.070000 72.1583333 0.070000 72.1611111 0.070000 72.1638889 0.064808 72.1666667 0.057885 72.1694444 0.056154 72.1722222 0.049231 72.1750000 0.042308 72.1777778 0.038846 72.1805556 0.037115 72.1833333 0.031923 72.1861111 0.031923 72.1888889 0.030192 72.1916667 0.028462 72.1944444 0.030192 72.1972222 0.035385 72.2000000 0.037115 72.2027778 0.037115 72.2055556 0.037115 72.2083333 0.035385 72.2111111 0.035385 72.2138889 0.031923 72.2166667 0.025000 72.2194444 0.025000 72.2222222 0.040577 72.2250000 0.063077 72.2277778 0.095962 72.2305556 0.127115 72.2333333 0.154808 72.2361111 0.173846 72.2388889 0.177308 72.2416667 0.158269 72.2444444 0.120192 72.2472222 0.071731 72.2500000 0.028462 72.2527778 0.010000 72.2555556 0.030192 72.2583333 0.085577 72.2611111 0.170385 72.2638889 0.267308 72.2666667 0.362500 72.2694444 0.457692 72.2722222 0.542500 72.2750000 0.618654 72.2777778 0.682692 72.2805556 0.734615 72.2833333 0.767500 72.2861111 0.783077 72.2888889 0.776154 72.2916667 0.755385 72.2944444 0.720769 72.2972222 0.665385 72.3000000 0.597885 72.3027778 0.526923 72.3055556 0.454231 72.3083333 0.379808 72.3111111 0.305385 72.3138889 0.227500 72.3166667 0.149615 72.3194444 0.076923 72.3222222 0.014615 72.3250000 0.010000 72.3277778 0.010000 72.3305556 0.010000 72.3333333 0.010000 72.3361111 0.010000 72.3388889 0.010000 72.3416667 0.010000 72.3444444 0.010000 72.3472222 0.010000 72.3500000 0.010000 72.3527778 0.010000 72.3555556 0.010000 72.3583333 0.010000 72.3611111 0.010000 72.3638889 0.010000 72.3666667 0.010000 72.3694444 0.010000 72.3722222 0.010000 72.3750000 0.010000 72.3777778 0.010000 72.3805556 0.010000 72.3833333 0.010000 72.3861111 0.010000 72.3888889 0.010000 72.3916667 0.010000 72.3944444 0.010000 72.3972222 0.010000 72.4000000 0.010000 72.4027778 0.010000 72.4055556 0.010000 72.4083333 0.010000 72.4111111 0.010000 72.4138889 0.010000 72.4166667 0.010000 72.4194444 0.010000 72.4222222 0.010000 72.4250000 0.010000 72.4277778 0.010000 72.4305556 0.010000 72.4333333 0.010000 72.4361111 0.010000 72.4388889 0.010000 72.4416667 0.010000 72.4444444 0.010000 72.4472222 0.010000 72.4500000 0.010000 72.4527778 0.010000 72.4555556 0.010000 72.4583333 0.010000 72.4611111 0.010000 72.4638889 0.010000 72.4666667 0.010000 72.4694444 0.010000 72.4722222 0.010000 72.4750000 0.010000 72.4777778 0.010000 72.4805556 0.010000 72.4833333 0.010000 72.4861111 0.010000 72.4888889 0.010000 72.4916667 0.010000 72.4944444 0.010000 72.4972222 0.010000 72.5000000 0.010000 72.5027778 0.010000 72.5055556 0.010000 72.5083333 0.010000 72.5111111 0.010000 72.5138889 0.010000 72.5166667 0.010000 72.5194444 0.010000 72.5222222 0.010000 72.5250000 0.010000 72.5277778 0.010000 72.5305556 0.010000 72.5333333 0.010000 72.5361111 0.010000 72.5388889 0.010000 72.5416667 0.010000 72.5444444 0.010000 72.5472222 0.010000 72.5500000 0.010000 72.5527778 0.010000 72.5555556 0.010000 72.5583333 0.010000 72.5611111 0.010000 72.5638889 0.010000 72.5666667 0.010000 72.5694444 0.010000 72.5722222 0.010000 72.5750000 0.010000 72.5777778 0.010000 72.5805556 0.010000 72.5833333 0.010000 72.5861111 0.010000 73.3055556 0.028462 73.3083333 0.026731 73.3111111 0.026731 73.3138889 0.025000 73.3166667 0.023269 73.3194444 0.018077 73.3222222 0.016346 73.3250000 0.023269 73.3277778 0.021538 73.3305556 0.025000 73.3333333 0.033654 73.3361111 0.031923 73.3388889 0.037115 73.3416667 0.035385 73.3444444 0.031923 73.3472222 0.028462 73.3500000 0.026731 73.3527778 0.028462 73.3555556 0.033654 73.3583333 0.031923 73.3611111 0.035385 73.3638889 0.035385 73.3666667 0.042308 73.3694444 0.050962 73.3722222 0.056154 73.3750000 0.052692 73.3777778 0.045769 73.3805556 0.042308 73.3833333 0.037115 73.3861111 0.031923 73.3888889 0.031923 73.3916667 0.030192 73.3944444 0.026731 73.3972222 0.030192 73.4000000 0.035385 73.4027778 0.042308 73.4055556 0.047500 73.4083333 0.052692 73.4111111 0.057885 73.4138889 0.059615 73.4166667 0.054423 73.4194444 0.047500 73.4222222 0.042308 73.4250000 0.031923 73.4277778 0.026731 73.4305556 0.031923 73.4333333 0.026731 73.4361111 0.021538 73.4388889 0.023269 73.4416667 0.019808 73.4444444 0.018077 73.4472222 0.018077 73.4500000 0.014615 73.4527778 0.016346 73.4555556 0.014615 73.4583333 0.012885 73.4611111 0.012885 73.4638889 0.011154 73.4666667 0.016346 73.4694444 0.018077 73.4722222 0.018077 73.4750000 0.021538 73.4777778 0.019808 73.4805556 0.019808 73.4833333 0.018077 73.4861111 0.023269 73.4888889 0.035385 73.4916667 0.057885 73.4944444 0.085577 73.4972222 0.113269 73.5000000 0.137500 73.5027778 0.156538 73.5055556 0.161731 73.5083333 0.142692 73.5111111 0.101154 73.5138889 0.047500 73.5166667 0.010000 73.5194444 0.010000 73.5222222 0.010000 73.5250000 0.033654 73.5277778 0.111538 73.5305556 0.192885 73.5333333 0.282885 73.5361111 0.360769 73.5388889 0.438654 73.5416667 0.506154 73.5444444 0.570192 73.5472222 0.620385 73.5500000 0.653269 73.5527778 0.670577 73.5555556 0.677500 73.5583333 0.665385 73.5611111 0.646346 73.5638889 0.616923 73.5666667 0.571923 73.5694444 0.523462 73.5722222 0.461154 73.5750000 0.386731 73.5777778 0.296731 73.5805556 0.201538 73.5833333 0.101154 73.5861111 0.019808 73.5888889 0.010000 73.5916667 0.010000 73.5944444 0.010000 73.5972222 0.010000 73.6000000 0.010000 73.6027778 0.010000 73.6055556 0.010000 73.6083333 0.010000 73.6111111 0.010000 73.6138889 0.010000 73.6166667 0.010000 73.6194444 0.010000 73.6222222 0.010000 73.6250000 0.010000 73.6277778 0.010000 73.6305556 0.010000 73.6333333 0.010000 73.6361111 0.010000 73.6388889 0.010000 73.6416667 0.010000 73.6444444 0.010000 73.6472222 0.010000 73.6500000 0.010000 73.6527778 0.010000 73.6555556 0.010000 73.6583333 0.010000 73.6611111 0.010000 73.6638889 0.010000 73.6666667 0.010000 73.6694444 0.010000 73.6722222 0.010000 73.6750000 0.010000 73.6777778 0.010000 73.6805556 0.010000 73.6833333 0.010000 73.6861111 0.010000 73.6888889 0.010000 73.6916667 0.010000 73.6944444 0.010000 73.6972222 0.010000 73.7000000 0.010000 73.7027778 0.010000 73.7055556 0.010000 73.7083333 0.010000 73.7111111 0.010000 73.7138889 0.010000 73.7166667 0.010000 73.7194444 0.010000 73.7222222 0.010000 73.7250000 0.010000 73.7277778 0.010000 73.7305556 0.010000 73.7333333 0.010000 73.7361111 0.010000 73.7388889 0.010000 73.7416667 0.010000 73.7444444 0.010000 73.7472222 0.010000 73.7500000 0.010000 73.7527778 0.010000 73.7555556 0.010000 73.7583333 0.010000 73.7611111 0.010000 73.7638889 0.010000 73.7666667 0.010000 73.7694444 0.010000 73.7722222 0.010000 73.7750000 0.010000 73.7777778 0.010000 73.7805556 0.010000 73.7833333 0.010000 73.7861111 0.010000 73.7888889 0.010000 73.7916667 0.010000 73.7944444 0.010000 73.7972222 0.010000 73.8000000 0.010000 73.8027778 0.010000 73.8055556 0.010000 73.8083333 0.010000 73.8111111 0.010000 73.8138889 0.010000 73.8166667 0.010000 73.8194444 0.010000 73.8222222 0.010000 73.8250000 0.010000 73.8277778 0.010000 73.8305556 0.010000 73.8333333 0.010000 73.8361111 0.010000 73.8388889 0.010000 73.8416667 0.010000 73.8444444 0.010000 73.8472222 0.010000 73.8500000 0.010000 73.8527778 0.010000 74.4888889 0.021538 74.4916667 0.019808 74.4944444 0.021538 74.4972222 0.023269 74.5000000 0.019808 74.5027778 0.023269 74.5055556 0.026731 74.5083333 0.030192 74.5111111 0.030192 74.5138889 0.030192 74.5166667 0.031923 74.5194444 0.030192 74.5222222 0.028462 74.5250000 0.028462 74.5277778 0.033654 74.5305556 0.031923 74.5333333 0.031923 74.5361111 0.033654 74.5388889 0.038846 74.5416667 0.040577 74.5444444 0.045769 74.5472222 0.045769 74.5500000 0.049231 74.5527778 0.050962 74.5555556 0.049231 74.5583333 0.049231 74.5611111 0.049231 74.5638889 0.050962 74.5666667 0.052692 74.5694444 0.052692 74.5722222 0.047500 74.5750000 0.047500 74.5777778 0.047500 74.5805556 0.044038 74.5833333 0.042308 74.5861111 0.040577 74.5888889 0.038846 74.5916667 0.040577 74.5944444 0.047500 74.5972222 0.050962 74.6000000 0.056154 74.6027778 0.061346 74.6055556 0.068269 74.6083333 0.064808 74.6111111 0.057885 74.6138889 0.054423 74.6166667 0.045769 74.6194444 0.038846 74.6222222 0.033654 74.6250000 0.028462 74.6277778 0.018077 74.6305556 0.021538 74.6333333 0.021538 74.6361111 0.023269 74.6388889 0.030192 74.6416667 0.031923 74.6444444 0.030192 74.6472222 0.031923 74.6500000 0.033654 74.6527778 0.033654 74.6555556 0.030192 74.6583333 0.023269 74.6611111 0.021538 74.6638889 0.019808 74.6666667 0.021538 74.6694444 0.035385 74.6722222 0.059615 74.6750000 0.092500 74.6777778 0.121923 74.6805556 0.151346 74.6833333 0.168654 74.6861111 0.180769 74.6888889 0.170385 74.6916667 0.135769 74.6944444 0.080385 74.6972222 0.035385 74.7000000 0.010000 74.7027778 0.010000 74.7055556 0.031923 74.7083333 0.102885 74.7111111 0.191154 74.7138889 0.281154 74.7166667 0.365962 74.7194444 0.436923 74.7222222 0.509615 74.7250000 0.570192 74.7277778 0.627308 74.7305556 0.672308 74.7333333 0.700000 74.7361111 0.708654 74.7388889 0.705192 74.7416667 0.689615 74.7444444 0.660192 74.7472222 0.611731 74.7500000 0.551154 74.7527778 0.487115 74.7555556 0.417885 74.7583333 0.348654 74.7611111 0.281154 74.7638889 0.211923 74.7666667 0.139231 74.7694444 0.075192 74.7722222 0.023269 74.7750000 0.010000 74.7777778 0.010000 74.7805556 0.010000 74.7833333 0.010000 74.7861111 0.010000 74.7888889 0.010000 74.7916667 0.010000 74.7944444 0.010000 74.7972222 0.010000 74.8000000 0.010000 74.8027778 0.010000 74.8055556 0.012885 74.8083333 0.014615 74.8111111 0.011154 74.8138889 0.010000 74.8166667 0.010000 74.8194444 0.010000 74.8222222 0.010000 74.8250000 0.010000 74.8277778 0.010000 74.8305556 0.010000 74.8333333 0.010000 74.8361111 0.012885 74.8388889 0.011154 74.8416667 0.012885 74.8444444 0.012885 74.8472222 0.011154 74.8500000 0.010000 74.8527778 0.010000 74.8555556 0.010000 74.8583333 0.010000 74.8611111 0.010000 74.8638889 0.010000 74.8666667 0.010000 74.8694444 0.010000 74.8722222 0.011154 74.8750000 0.012885 74.8777778 0.014615 74.8805556 0.012885 74.8833333 0.011154 74.8861111 0.010000 74.8888889 0.010000 74.8916667 0.010000 74.8944444 0.010000 74.8972222 0.010000 74.9000000 0.010000 74.9027778 0.010000 74.9055556 0.012885 74.9083333 0.010000 74.9111111 0.010000 74.9138889 0.010000 74.9166667 0.010000 74.9194444 0.010000 74.9222222 0.010000 74.9250000 0.010000 74.9277778 0.010000 74.9305556 0.010000 74.9333333 0.010000 74.9361111 0.010000 74.9388889 0.010000 74.9416667 0.010000 74.9444444 0.010000 74.9472222 0.010000 74.9500000 0.010000 74.9527778 0.010000 74.9555556 0.010000 74.9583333 0.010000 74.9611111 0.010000 74.9638889 0.010000 74.9666667 0.010000 74.9694444 0.010000 74.9722222 0.010000 74.9750000 0.010000 74.9777778 0.010000 74.9805556 0.010000 74.9833333 0.010000 74.9861111 0.010000 74.9888889 0.010000 74.9916667 0.010000 74.9944444 0.010000 74.9972222 0.010000 75.0000000 0.010000 75.0027778 0.010000 75.0055556 0.010000 75.0083333 0.010000 75.0111111 0.010000 75.0138889 0.010000 75.0166667 0.010000 75.0194444 0.010000 75.0222222 0.010000 75.0250000 0.010000 75.0277778 0.010000 75.0305556 0.010000 75.0333333 0.010000 75.0361111 0.010000 75.7333333 0.111538 75.7361111 0.115000 75.7388889 0.118462 75.7416667 0.123654 75.7444444 0.120192 75.7472222 0.116731 75.7500000 0.115000 75.7527778 0.118462 75.7555556 0.115000 75.7583333 0.111538 75.7611111 0.109808 75.7638889 0.111538 75.7666667 0.115000 75.7694444 0.118462 75.7722222 0.120192 75.7750000 0.125385 75.7777778 0.125385 75.7805556 0.128846 75.7833333 0.130577 75.7861111 0.132308 75.7888889 0.127115 75.7916667 0.127115 75.7944444 0.128846 75.7972222 0.125385 75.8000000 0.128846 75.8027778 0.128846 75.8055556 0.132308 75.8083333 0.127115 75.8111111 0.127115 75.8138889 0.121923 75.8166667 0.118462 75.8194444 0.115000 75.8222222 0.111538 75.8250000 0.111538 75.8277778 0.113269 75.8305556 0.116731 75.8333333 0.121923 75.8361111 0.128846 75.8388889 0.139231 75.8416667 0.144423 75.8444444 0.146154 75.8472222 0.144423 75.8500000 0.135769 75.8527778 0.128846 75.8555556 0.120192 75.8583333 0.113269 75.8611111 0.104615 75.8638889 0.097692 75.8666667 0.099423 75.8694444 0.099423 75.8722222 0.102885 75.8750000 0.099423 75.8777778 0.104615 75.8805556 0.104615 75.8833333 0.102885 75.8861111 0.101154 75.8888889 0.094231 75.8916667 0.094231 75.8944444 0.097692 75.8972222 0.097692 75.9000000 0.097692 75.9027778 0.099423 75.9055556 0.095962 75.9083333 0.092500 75.9111111 0.095962 75.9138889 0.104615 75.9166667 0.121923 75.9194444 0.149615 75.9222222 0.175577 75.9250000 0.199808 75.9277778 0.217115 75.9305556 0.225769 75.9333333 0.225769 75.9361111 0.205000 75.9388889 0.168654 75.9416667 0.123654 75.9444444 0.085577 75.9472222 0.073462 75.9500000 0.099423 75.9527778 0.160000 75.9555556 0.244808 75.9583333 0.333077 75.9611111 0.419615 75.9638889 0.506154 75.9666667 0.585769 75.9694444 0.653269 75.9722222 0.706923 75.9750000 0.751923 75.9777778 0.777885 75.9805556 0.790000 75.9833333 0.781346 75.9861111 0.760577 75.9888889 0.722500 75.9916667 0.667115 75.9944444 0.603077 75.9972222 0.537308 76.0000000 0.468077 76.0027778 0.409231 76.0055556 0.343462 76.0083333 0.277692 76.0111111 0.201538 76.0138889 0.130577 76.0166667 0.068269 76.0194444 0.026731 76.0222222 0.010000 76.0250000 0.010000 76.0277778 0.010000 76.0305556 0.011154 76.0333333 0.026731 76.0361111 0.035385 76.0388889 0.045769 76.0416667 0.054423 76.0444444 0.054423 76.0472222 0.054423 76.0500000 0.059615 76.0527778 0.057885 76.0555556 0.052692 76.0583333 0.049231 76.0611111 0.050962 76.0638889 0.050962 76.0666667 0.049231 76.0694444 0.050962 76.0722222 0.052692 76.0750000 0.052692 76.0777778 0.052692 76.0805556 0.050962 76.0833333 0.049231 76.0861111 0.045769 76.0888889 0.042308 76.0916667 0.045769 76.0944444 0.040577 76.0972222 0.042308 76.1000000 0.044038 76.1027778 0.045769 76.1055556 0.045769 76.1083333 0.045769 76.1111111 0.044038 76.1138889 0.040577 76.1166667 0.040577 76.1194444 0.040577 76.1222222 0.038846 76.1250000 0.037115 76.1277778 0.037115 76.1305556 0.037115 76.1333333 0.038846 76.1361111 0.038846 76.1388889 0.042308 76.1416667 0.040577 76.1444444 0.040577 76.1472222 0.040577 76.1500000 0.033654 76.1527778 0.031923 76.1555556 0.031923 76.1583333 0.031923 76.1611111 0.031923 76.1638889 0.030192 76.1666667 0.033654 76.1694444 0.035385 76.1722222 0.033654 76.1750000 0.035385 76.1777778 0.031923 76.1805556 0.028462 76.1833333 0.025000 76.1861111 0.018077 76.1888889 0.014615 76.1916667 0.012885 76.1944444 0.014615 76.1972222 0.014615 76.2000000 0.014615 76.2027778 0.010000 76.2055556 0.014615 76.2083333 0.014615 76.2111111 0.012885 76.2138889 0.010000 76.2166667 0.010000 76.2194444 0.010000 76.2222222 0.010000 76.2250000 0.010000 76.2277778 0.010000 76.2305556 0.010000 76.2333333 0.010000 76.2361111 0.010000 76.2388889 0.010000 76.2416667 0.010000 76.2444444 0.010000 76.2472222 0.010000 76.2500000 0.010000 76.2527778 0.010000 76.2555556 0.010000 76.2583333 0.010000 76.2611111 0.010000 76.2638889 0.010000 76.2666667 0.010000 76.2694444 0.010000 76.2722222 0.010000 76.2750000 0.010000 76.2777778 0.010000 76.2805556 0.010000 76.8805556 0.031923 76.8833333 0.028462 76.8861111 0.023269 76.8888889 0.021538 76.8916667 0.021538 76.8944444 0.021538 76.8972222 0.026731 76.9000000 0.028462 76.9027778 0.031923 76.9055556 0.035385 76.9083333 0.038846 76.9111111 0.033654 76.9138889 0.031923 76.9166667 0.026731 76.9194444 0.026731 76.9222222 0.018077 76.9250000 0.018077 76.9277778 0.023269 76.9305556 0.026731 76.9333333 0.037115 76.9361111 0.042308 76.9388889 0.044038 76.9416667 0.042308 76.9444444 0.045769 76.9472222 0.044038 76.9500000 0.044038 76.9527778 0.038846 76.9555556 0.033654 76.9583333 0.030192 76.9611111 0.030192 76.9638889 0.028462 76.9666667 0.025000 76.9694444 0.026731 76.9722222 0.028462 76.9750000 0.030192 76.9777778 0.028462 76.9805556 0.028462 76.9833333 0.028462 76.9861111 0.030192 76.9888889 0.030192 76.9916667 0.031923 76.9944444 0.031923 76.9972222 0.037115 77.0000000 0.038846 77.0027778 0.035385 77.0055556 0.033654 77.0083333 0.035385 77.0111111 0.030192 77.0138889 0.026731 77.0166667 0.018077 77.0194444 0.011154 77.0222222 0.010000 77.0250000 0.010000 77.0277778 0.010000 77.0305556 0.010000 77.0333333 0.010000 77.0361111 0.010000 77.0388889 0.010000 77.0416667 0.010000 77.0444444 0.010000 77.0472222 0.010000 77.0500000 0.010000 77.0527778 0.010000 77.0555556 0.010000 77.0583333 0.010000 77.0611111 0.010000 77.0638889 0.010000 77.0666667 0.033654 77.0694444 0.070000 77.0722222 0.097692 77.0750000 0.127115 77.0777778 0.140962 77.0805556 0.139231 77.0833333 0.113269 77.0861111 0.068269 77.0888889 0.012885 77.0916667 0.010000 77.0944444 0.010000 77.0972222 0.010000 77.1000000 0.054423 77.1027778 0.139231 77.1055556 0.236154 77.1083333 0.326154 77.1111111 0.409231 77.1138889 0.481923 77.1166667 0.544231 77.1194444 0.594423 77.1222222 0.632500 77.1250000 0.656731 77.1277778 0.667115 77.1305556 0.665385 77.1333333 0.646346 77.1361111 0.611731 77.1388889 0.561538 77.1416667 0.499231 77.1444444 0.428269 77.1472222 0.355577 77.1500000 0.282885 77.1527778 0.217115 77.1555556 0.144423 77.1583333 0.075192 77.1611111 0.012885 77.1638889 0.010000 77.1666667 0.010000 77.1694444 0.010000 77.1722222 0.010000 77.1750000 0.010000 77.1777778 0.010000 77.1805556 0.010000 77.1833333 0.010000 77.1861111 0.010000 77.1888889 0.010000 77.1916667 0.010000 77.1944444 0.010000 77.1972222 0.010000 77.2000000 0.010000 77.2027778 0.010000 77.2055556 0.010000 77.2083333 0.010000 77.2111111 0.010000 77.2138889 0.010000 77.2166667 0.010000 77.2194444 0.010000 77.2222222 0.010000 77.2250000 0.010000 77.2277778 0.010000 77.2305556 0.010000 77.2333333 0.010000 77.2361111 0.010000 77.2388889 0.010000 77.2416667 0.010000 77.2444444 0.010000 77.2472222 0.010000 77.2500000 0.010000 77.2527778 0.010000 77.2555556 0.010000 77.2583333 0.010000 77.2611111 0.010000 77.2638889 0.010000 77.2666667 0.010000 77.2694444 0.010000 77.2722222 0.010000 77.2750000 0.010000 77.2777778 0.010000 77.2805556 0.010000 77.2833333 0.010000 77.2861111 0.010000 77.2888889 0.010000 77.2916667 0.010000 77.2944444 0.010000 77.2972222 0.010000 77.3000000 0.010000 77.3027778 0.010000 77.3055556 0.010000 77.3083333 0.010000 77.3111111 0.010000 77.3138889 0.010000 77.3166667 0.010000 77.3194444 0.010000 77.3222222 0.010000 77.3250000 0.010000 77.3277778 0.010000 77.3305556 0.010000 77.3333333 0.010000 77.3361111 0.010000 77.3388889 0.010000 77.3416667 0.010000 77.3444444 0.010000 77.3472222 0.010000 77.3500000 0.010000 77.3527778 0.010000 77.3555556 0.010000 77.3583333 0.010000 77.3611111 0.010000 77.3638889 0.010000 77.3666667 0.010000 77.3694444 0.010000 77.3722222 0.010000 77.3750000 0.010000 77.3777778 0.010000 77.3805556 0.010000 77.3833333 0.010000 77.3861111 0.010000 77.3888889 0.010000 77.3916667 0.010000 77.3944444 0.010000 77.3972222 0.010000 77.4000000 0.010000 77.4027778 0.010000 77.4055556 0.010000 77.4083333 0.010000 77.4111111 0.010000 77.4138889 0.010000 77.4166667 0.010000 77.4194444 0.010000 77.4222222 0.010000 77.4250000 0.010000 77.4277778 0.010000 78.0916667 0.010000 78.0944444 0.010000 78.0972222 0.010000 78.1000000 0.010000 78.1027778 0.010000 78.1055556 0.010000 78.1083333 0.010000 78.1111111 0.010000 78.1138889 0.010000 78.1166667 0.010000 78.1194444 0.010000 78.1222222 0.010000 78.1250000 0.010000 78.1277778 0.010000 78.1305556 0.010000 78.1333333 0.010000 78.1361111 0.010000 78.1388889 0.010000 78.1416667 0.010000 78.1444444 0.010000 78.1472222 0.010000 78.1500000 0.010000 78.1527778 0.010000 78.1555556 0.010000 78.1583333 0.010000 78.1611111 0.010000 78.1638889 0.010000 78.1666667 0.010000 78.1694444 0.010000 78.1722222 0.010000 78.1750000 0.010000 78.1777778 0.010000 78.1805556 0.010000 78.1833333 0.010000 78.1861111 0.010000 78.1888889 0.010000 78.1916667 0.010000 78.1944444 0.010000 78.1972222 0.010000 78.2000000 0.010000 78.2027778 0.010000 78.2055556 0.010000 78.2083333 0.010000 78.2111111 0.010000 78.2138889 0.010000 78.2166667 0.010000 78.2194444 0.010000 78.2222222 0.010000 78.2250000 0.010000 78.2277778 0.010000 78.2305556 0.010000 78.2333333 0.010000 78.2361111 0.010000 78.2388889 0.010000 78.2416667 0.010000 78.2444444 0.010000 78.2472222 0.010000 78.2500000 0.010000 78.2527778 0.010000 78.2555556 0.010000 78.2583333 0.010000 78.2611111 0.010000 78.2638889 0.010000 78.2666667 0.010000 78.2694444 0.010000 78.2722222 0.010000 78.2750000 0.010000 78.2777778 0.010000 78.2805556 0.010000 78.2833333 0.010000 78.2861111 0.023269 78.2888889 0.033654 78.2916667 0.035385 78.2944444 0.016346 78.2972222 0.010000 78.3000000 0.010000 78.3027778 0.010000 78.3055556 0.010000 78.3083333 0.010000 78.3111111 0.010000 78.3138889 0.059615 78.3166667 0.154808 78.3194444 0.244808 78.3222222 0.333077 78.3250000 0.409231 78.3277778 0.480192 78.3305556 0.535577 78.3333333 0.584038 78.3361111 0.610000 78.3388889 0.625577 78.3416667 0.618654 78.3444444 0.601346 78.3472222 0.570192 78.3500000 0.521731 78.3527778 0.455962 78.3555556 0.381538 78.3583333 0.307115 78.3611111 0.232692 78.3638889 0.161731 78.3666667 0.087308 78.3694444 0.012885 78.3722222 0.010000 78.3750000 0.010000 78.3777778 0.010000 78.3805556 0.010000 78.3833333 0.010000 78.3861111 0.010000 78.3888889 0.010000 78.3916667 0.010000 78.3944444 0.010000 78.3972222 0.010000 78.4000000 0.010000 78.4027778 0.010000 78.4055556 0.010000 78.4083333 0.010000 78.4111111 0.010000 78.4138889 0.010000 78.4166667 0.010000 78.4194444 0.010000 78.4222222 0.010000 78.4250000 0.010000 78.4277778 0.010000 78.4305556 0.010000 78.4333333 0.010000 78.4361111 0.010000 78.4388889 0.010000 78.4416667 0.010000 78.4444444 0.010000 78.4472222 0.010000 78.4500000 0.010000 78.4527778 0.010000 78.4555556 0.010000 78.4583333 0.010000 78.4611111 0.010000 78.4638889 0.010000 78.4666667 0.010000 78.4694444 0.010000 78.4722222 0.010000 78.4750000 0.010000 78.4777778 0.010000 78.4805556 0.010000 78.4833333 0.010000 78.4861111 0.010000 78.4888889 0.010000 78.4916667 0.010000 78.4944444 0.010000 78.4972222 0.010000 78.5000000 0.010000 78.5027778 0.010000 78.5055556 0.010000 78.5083333 0.010000 78.5111111 0.010000 78.5138889 0.010000 78.5166667 0.010000 78.5194444 0.010000 78.5222222 0.010000 78.5250000 0.010000 78.5277778 0.010000 78.5305556 0.010000 78.5333333 0.010000 78.5361111 0.010000 78.5388889 0.010000 78.5416667 0.010000 78.5444444 0.010000 78.5472222 0.010000 78.5500000 0.010000 78.5527778 0.010000 78.5555556 0.010000 78.5583333 0.010000 78.5611111 0.010000 78.5638889 0.010000 78.5666667 0.010000 78.5694444 0.010000 78.5722222 0.010000 78.5750000 0.010000 78.5777778 0.010000 78.5805556 0.010000 78.5833333 0.010000 78.5861111 0.010000 78.5888889 0.010000 78.5916667 0.010000 78.5944444 0.010000 78.5972222 0.010000 78.6000000 0.010000 78.6027778 0.010000 78.6055556 0.010000 78.6083333 0.010000 78.6111111 0.010000 78.6138889 0.010000 78.6166667 0.010000 78.6194444 0.010000 78.6222222 0.010000 78.6250000 0.010000 78.6277778 0.010000 78.6305556 0.010000 78.6333333 0.010000 78.6361111 0.010000 78.6388889 0.010000 79.3333333 0.010000 79.3361111 0.010000 79.3388889 0.010000 79.3416667 0.010000 79.3444444 0.010000 79.3472222 0.010000 79.3500000 0.010000 79.3527778 0.010000 79.3555556 0.010000 79.3583333 0.010000 79.3611111 0.010000 79.3638889 0.010000 79.3666667 0.010000 79.3694444 0.010000 79.3722222 0.010000 79.3750000 0.010000 79.3777778 0.010000 79.3805556 0.010000 79.3833333 0.010000 79.3861111 0.010000 79.3888889 0.010000 79.3916667 0.010000 79.3944444 0.010000 79.3972222 0.010000 79.4000000 0.010000 79.4027778 0.010000 79.4055556 0.010000 79.4083333 0.010000 79.4111111 0.010000 79.4138889 0.010000 79.4166667 0.010000 79.4194444 0.010000 79.4222222 0.010000 79.4250000 0.010000 79.4277778 0.010000 79.4305556 0.010000 79.4333333 0.010000 79.4361111 0.010000 79.4388889 0.010000 79.4416667 0.010000 79.4444444 0.010000 79.4472222 0.010000 79.4500000 0.010000 79.4527778 0.010000 79.4555556 0.010000 79.4583333 0.010000 79.4611111 0.010000 79.4638889 0.010000 79.4666667 0.010000 79.4694444 0.010000 79.4722222 0.010000 79.4750000 0.010000 79.4777778 0.010000 79.4805556 0.010000 79.4833333 0.010000 79.4861111 0.010000 79.4888889 0.010000 79.4916667 0.010000 79.4944444 0.010000 79.4972222 0.010000 79.5000000 0.010000 79.5027778 0.010000 79.5055556 0.010000 79.5083333 0.010000 79.5111111 0.010000 79.5138889 0.010000 79.5166667 0.010000 79.5194444 0.010000 79.5222222 0.010000 79.5250000 0.010000 79.5277778 0.010000 79.5305556 0.016346 79.5333333 0.016346 79.5361111 0.010000 79.5388889 0.010000 79.5416667 0.010000 79.5444444 0.010000 79.5472222 0.010000 79.5500000 0.010000 79.5527778 0.010000 79.5555556 0.010000 79.5583333 0.102885 79.5611111 0.196346 79.5638889 0.288077 79.5666667 0.374615 79.5694444 0.443846 79.5722222 0.514808 79.5750000 0.561538 79.5777778 0.590962 79.5805556 0.603077 79.5833333 0.597885 79.5861111 0.575385 79.5888889 0.542500 79.5916667 0.494038 79.5944444 0.433462 79.5972222 0.365962 79.6000000 0.291538 79.6027778 0.220577 79.6055556 0.140962 79.6083333 0.063077 79.6111111 0.010000 79.6138889 0.010000 79.6166667 0.010000 79.6194444 0.010000 79.6222222 0.010000 79.6250000 0.010000 79.6277778 0.010000 79.6305556 0.010000 79.6333333 0.010000 79.6361111 0.010000 79.6388889 0.010000 79.6416667 0.010000 79.6444444 0.010000 79.6472222 0.010000 79.6500000 0.010000 79.6527778 0.010000 79.6555556 0.010000 79.6583333 0.010000 79.6611111 0.010000 79.6638889 0.010000 79.6666667 0.010000 79.6694444 0.010000 79.6722222 0.010000 79.6750000 0.010000 79.6777778 0.010000 79.6805556 0.010000 79.6833333 0.010000 79.6861111 0.010000 79.6888889 0.010000 79.6916667 0.010000 79.6944444 0.010000 79.6972222 0.010000 79.7000000 0.010000 79.7027778 0.010000 79.7055556 0.010000 79.7083333 0.010000 79.7111111 0.010000 79.7138889 0.010000 79.7166667 0.010000 79.7194444 0.010000 79.7222222 0.010000 79.7250000 0.010000 79.7277778 0.010000 79.7305556 0.010000 79.7333333 0.010000 79.7361111 0.010000 79.7388889 0.010000 79.7416667 0.010000 79.7444444 0.010000 79.7472222 0.010000 79.7500000 0.010000 79.7527778 0.010000 79.7555556 0.010000 79.7583333 0.010000 79.7611111 0.010000 79.7638889 0.010000 79.7666667 0.010000 79.7694444 0.010000 79.7722222 0.010000 79.7750000 0.010000 79.7777778 0.010000 79.7805556 0.010000 79.7833333 0.010000 79.7861111 0.010000 79.7888889 0.010000 79.7916667 0.010000 79.7944444 0.010000 79.7972222 0.010000 79.8000000 0.010000 79.8027778 0.010000 79.8055556 0.010000 79.8083333 0.010000 79.8111111 0.010000 79.8138889 0.010000 79.8166667 0.010000 79.8194444 0.010000 79.8222222 0.010000 79.8250000 0.010000 79.8277778 0.010000 79.8305556 0.010000 79.8333333 0.010000 79.8361111 0.010000 79.8388889 0.010000 79.8416667 0.010000 79.8444444 0.010000 79.8472222 0.010000 79.8500000 0.010000 79.8527778 0.010000 79.8555556 0.010000 79.8583333 0.010000 79.8611111 0.010000 79.8638889 0.010000 79.8666667 0.010000 79.8694444 0.010000 79.8722222 0.010000 79.8750000 0.010000 79.8777778 0.010000 79.8805556 0.010000 80.5222222 0.010000 80.5250000 0.010000 80.5277778 0.010000 80.5305556 0.010000 80.5333333 0.010000 80.5361111 0.010000 80.5388889 0.010000 80.5416667 0.010000 80.5444444 0.010000 80.5472222 0.010000 80.5500000 0.010000 80.5527778 0.010000 80.5555556 0.010000 80.5583333 0.010000 80.5611111 0.010000 80.5638889 0.010000 80.5666667 0.010000 80.5694444 0.010000 80.5722222 0.010000 80.5750000 0.010000 80.5777778 0.010000 80.5805556 0.010000 80.5833333 0.010000 80.5861111 0.010000 80.5888889 0.010000 80.5916667 0.010000 80.5944444 0.010000 80.5972222 0.010000 80.6000000 0.010000 80.6027778 0.010000 80.6055556 0.010000 80.6083333 0.010000 80.6111111 0.010000 80.6138889 0.010000 80.6166667 0.010000 80.6194444 0.010000 80.6222222 0.010000 80.6250000 0.010000 80.6277778 0.010000 80.6305556 0.010000 80.6333333 0.010000 80.6361111 0.010000 80.6388889 0.010000 80.6416667 0.010000 80.6444444 0.010000 80.6472222 0.010000 80.6500000 0.010000 80.6527778 0.010000 80.6555556 0.010000 80.6583333 0.010000 80.6611111 0.010000 80.6638889 0.010000 80.6666667 0.010000 80.6694444 0.010000 80.6722222 0.010000 80.6750000 0.010000 80.6777778 0.010000 80.6805556 0.010000 80.6833333 0.010000 80.6861111 0.010000 80.6888889 0.010000 80.6916667 0.010000 80.6944444 0.010000 80.6972222 0.010000 80.7000000 0.010000 80.7027778 0.010000 80.7055556 0.010000 80.7083333 0.010000 80.7111111 0.010000 80.7138889 0.016346 80.7166667 0.038846 80.7194444 0.045769 80.7222222 0.040577 80.7250000 0.012885 80.7277778 0.010000 80.7305556 0.010000 80.7333333 0.010000 80.7361111 0.010000 80.7388889 0.010000 80.7416667 0.010000 80.7444444 0.023269 80.7472222 0.106346 80.7500000 0.189423 80.7527778 0.265577 80.7555556 0.331346 80.7583333 0.405769 80.7611111 0.462885 80.7638889 0.516538 80.7666667 0.559808 80.7694444 0.578846 80.7722222 0.582308 80.7750000 0.571923 80.7777778 0.544231 80.7805556 0.506154 80.7833333 0.459423 80.7861111 0.397115 80.7888889 0.331346 80.7916667 0.269038 80.7944444 0.205000 80.7972222 0.142692 80.8000000 0.080385 80.8027778 0.010000 80.8055556 0.010000 80.8083333 0.010000 80.8111111 0.010000 80.8138889 0.010000 80.8166667 0.010000 80.8194444 0.010000 80.8222222 0.010000 80.8250000 0.010000 80.8277778 0.010000 80.8305556 0.010000 80.8333333 0.010000 80.8361111 0.010000 80.8388889 0.010000 80.8416667 0.010000 80.8444444 0.010000 80.8472222 0.010000 80.8500000 0.010000 80.8527778 0.010000 80.8555556 0.010000 80.8583333 0.010000 80.8611111 0.010000 80.8638889 0.010000 80.8666667 0.010000 80.8694444 0.010000 80.8722222 0.010000 80.8750000 0.010000 80.8777778 0.010000 80.8805556 0.010000 80.8833333 0.010000 80.8861111 0.010000 80.8888889 0.010000 80.8916667 0.010000 80.8944444 0.010000 80.8972222 0.010000 80.9000000 0.010000 80.9027778 0.010000 80.9055556 0.010000 80.9083333 0.010000 80.9111111 0.010000 80.9138889 0.010000 80.9166667 0.010000 80.9194444 0.010000 80.9222222 0.010000 80.9250000 0.010000 80.9277778 0.010000 80.9305556 0.010000 80.9333333 0.010000 80.9361111 0.010000 80.9388889 0.010000 80.9416667 0.010000 80.9444444 0.010000 80.9472222 0.010000 80.9500000 0.010000 80.9527778 0.010000 80.9555556 0.010000 80.9583333 0.010000 80.9611111 0.010000 80.9638889 0.010000 80.9666667 0.010000 80.9694444 0.010000 80.9722222 0.010000 80.9750000 0.010000 80.9777778 0.010000 80.9805556 0.010000 80.9833333 0.010000 80.9861111 0.010000 80.9888889 0.010000 80.9916667 0.010000 80.9944444 0.010000 80.9972222 0.010000 81.0000000 0.010000 81.0027778 0.010000 81.0055556 0.010000 81.0083333 0.010000 81.0111111 0.010000 81.0138889 0.010000 81.0166667 0.010000 81.0194444 0.010000 81.0222222 0.010000 81.0250000 0.010000 81.0277778 0.010000 81.0305556 0.010000 81.0333333 0.010000 81.0361111 0.010000 81.0388889 0.010000 81.0416667 0.010000 81.0444444 0.010000 81.0472222 0.010000 81.0500000 0.010000 81.0527778 0.010000 81.0555556 0.010000 81.0583333 0.010000 81.0611111 0.010000 81.0638889 0.010000 81.0666667 0.010000 81.0694444 0.010000 81.7388889 0.010000 81.7416667 0.010000 81.7444444 0.010000 81.7472222 0.010000 81.7500000 0.010000 81.7527778 0.010000 81.7555556 0.010000 81.7583333 0.010000 81.7611111 0.010000 81.7638889 0.010000 81.7666667 0.010000 81.7694444 0.010000 81.7722222 0.010000 81.7750000 0.010000 81.7777778 0.010000 81.7805556 0.010000 81.7833333 0.010000 81.7861111 0.010000 81.7888889 0.010000 81.7916667 0.010000 81.7944444 0.010000 81.7972222 0.010000 81.8000000 0.010000 81.8027778 0.010000 81.8055556 0.010000 81.8083333 0.010000 81.8111111 0.010000 81.8138889 0.010000 81.8166667 0.010000 81.8194444 0.010000 81.8222222 0.010000 81.8250000 0.010000 81.8277778 0.010000 81.8305556 0.010000 81.8333333 0.010000 81.8361111 0.010000 81.8388889 0.010000 81.8416667 0.010000 81.8444444 0.010000 81.8472222 0.010000 81.8500000 0.010000 81.8527778 0.010000 81.8555556 0.010000 81.8583333 0.010000 81.8611111 0.010000 81.8638889 0.010000 81.8666667 0.010000 81.8694444 0.010000 81.8722222 0.010000 81.8750000 0.010000 81.8777778 0.010000 81.8805556 0.010000 81.8833333 0.010000 81.8861111 0.010000 81.8888889 0.010000 81.8916667 0.010000 81.8944444 0.010000 81.8972222 0.010000 81.9000000 0.010000 81.9027778 0.010000 81.9055556 0.010000 81.9083333 0.010000 81.9111111 0.010000 81.9138889 0.010000 81.9166667 0.010000 81.9194444 0.010000 81.9222222 0.010000 81.9250000 0.010000 81.9277778 0.010000 81.9305556 0.010000 81.9333333 0.010000 81.9361111 0.010000 81.9388889 0.016346 81.9416667 0.040577 81.9444444 0.044038 81.9472222 0.031923 81.9500000 0.010000 81.9527778 0.010000 81.9555556 0.010000 81.9583333 0.010000 81.9611111 0.010000 81.9638889 0.018077 81.9666667 0.120192 81.9694444 0.236154 81.9722222 0.346923 81.9750000 0.449038 81.9777778 0.537308 81.9805556 0.608269 81.9833333 0.656731 81.9861111 0.672308 81.9888889 0.665385 81.9916667 0.634231 81.9944444 0.585769 81.9972222 0.521731 82.0000000 0.440385 82.0027778 0.355577 82.0055556 0.270769 82.0083333 0.192885 82.0111111 0.113269 82.0138889 0.026731 82.0166667 0.010000 82.0194444 0.010000 82.0222222 0.010000 82.0250000 0.010000 82.0277778 0.010000 82.0305556 0.010000 82.0333333 0.010000 82.0361111 0.010000 82.0388889 0.010000 82.0416667 0.010000 82.0444444 0.010000 82.0472222 0.010000 82.0500000 0.010000 82.0527778 0.010000 82.0555556 0.010000 82.0583333 0.010000 82.0611111 0.010000 82.0638889 0.010000 82.0666667 0.010000 82.0694444 0.010000 82.0722222 0.010000 82.0750000 0.010000 82.0777778 0.010000 82.0805556 0.010000 82.0833333 0.010000 82.0861111 0.010000 82.0888889 0.010000 82.0916667 0.010000 82.0944444 0.010000 82.0972222 0.010000 82.1000000 0.010000 82.1027778 0.010000 82.1055556 0.010000 82.1083333 0.010000 82.1111111 0.010000 82.1138889 0.010000 82.1166667 0.010000 82.1194444 0.010000 82.1222222 0.010000 82.1250000 0.010000 82.1277778 0.010000 82.1305556 0.010000 82.1333333 0.010000 82.1361111 0.010000 82.1388889 0.010000 82.1416667 0.010000 82.1444444 0.010000 82.1472222 0.010000 82.1500000 0.010000 82.1527778 0.010000 82.1555556 0.010000 82.1583333 0.010000 82.1611111 0.010000 82.1638889 0.010000 82.1666667 0.010000 82.1694444 0.010000 82.1722222 0.010000 82.1750000 0.010000 82.1777778 0.010000 82.1805556 0.010000 82.1833333 0.010000 82.1861111 0.010000 82.1888889 0.010000 82.1916667 0.010000 82.1944444 0.010000 82.1972222 0.010000 82.2000000 0.010000 82.2027778 0.010000 82.2055556 0.010000 82.2083333 0.010000 82.2111111 0.010000 82.2138889 0.010000 82.2166667 0.010000 82.2194444 0.010000 82.2222222 0.010000 82.2250000 0.010000 82.2277778 0.010000 82.2305556 0.010000 82.2333333 0.010000 82.2361111 0.010000 82.2388889 0.010000 82.2416667 0.010000 82.2444444 0.010000 82.2472222 0.010000 82.2500000 0.010000 82.2527778 0.010000 82.2555556 0.010000 82.2583333 0.010000 82.2611111 0.010000 82.2638889 0.010000 82.2666667 0.010000 82.2694444 0.010000 82.2722222 0.010000 82.2750000 0.010000 82.2777778 0.010000 82.2805556 0.010000 82.2833333 0.010000 82.2861111 0.010000 82.9361111 0.010000 82.9388889 0.010000 82.9416667 0.010000 82.9444444 0.010000 82.9472222 0.010000 82.9500000 0.010000 82.9527778 0.010000 82.9555556 0.010000 82.9583333 0.010000 82.9611111 0.010000 82.9638889 0.010000 82.9666667 0.010000 82.9694444 0.010000 82.9722222 0.010000 82.9750000 0.010000 82.9777778 0.010000 82.9805556 0.010000 82.9833333 0.010000 82.9861111 0.010000 82.9888889 0.010000 82.9916667 0.010000 82.9944444 0.010000 82.9972222 0.010000 83.0000000 0.010000 83.0027778 0.010000 83.0055556 0.010000 83.0083333 0.010000 83.0111111 0.010000 83.0138889 0.010000 83.0166667 0.010000 83.0194444 0.010000 83.0222222 0.010000 83.0250000 0.010000 83.0277778 0.010000 83.0305556 0.010000 83.0333333 0.010000 83.0361111 0.010000 83.0388889 0.010000 83.0416667 0.010000 83.0444444 0.010000 83.0472222 0.010000 83.0500000 0.010000 83.0527778 0.010000 83.0555556 0.010000 83.0583333 0.010000 83.0611111 0.010000 83.0638889 0.010000 83.0666667 0.010000 83.0694444 0.010000 83.0722222 0.010000 83.0750000 0.010000 83.0777778 0.010000 83.0805556 0.010000 83.0833333 0.010000 83.0861111 0.010000 83.0888889 0.010000 83.0916667 0.010000 83.0944444 0.010000 83.0972222 0.010000 83.1000000 0.010000 83.1027778 0.010000 83.1055556 0.010000 83.1083333 0.010000 83.1111111 0.010000 83.1138889 0.010000 83.1166667 0.010000 83.1194444 0.010000 83.1222222 0.010000 83.1250000 0.010000 83.1277778 0.010000 83.1305556 0.033654 83.1333333 0.066538 83.1361111 0.082115 83.1388889 0.071731 83.1416667 0.035385 83.1444444 0.010000 83.1472222 0.010000 83.1500000 0.010000 83.1527778 0.010000 83.1555556 0.010000 83.1583333 0.019808 83.1611111 0.111538 83.1638889 0.205000 83.1666667 0.291538 83.1694444 0.385000 83.1722222 0.459423 83.1750000 0.523462 83.1777778 0.575385 83.1805556 0.606538 83.1833333 0.622115 83.1861111 0.616923 83.1888889 0.599615 83.1916667 0.570192 83.1944444 0.526923 83.1972222 0.473269 83.2000000 0.405769 83.2027778 0.343462 83.2055556 0.282885 83.2083333 0.218846 83.2111111 0.153077 83.2138889 0.078654 83.2166667 0.010000 83.2194444 0.010000 83.2222222 0.010000 83.2250000 0.010000 83.2277778 0.010000 83.2305556 0.010000 83.2333333 0.010000 83.2361111 0.010000 83.2388889 0.010000 83.2416667 0.010000 83.2444444 0.010000 83.2472222 0.010000 83.2500000 0.010000 83.2527778 0.010000 83.2555556 0.010000 83.2583333 0.010000 83.2611111 0.010000 83.2638889 0.010000 83.2666667 0.010000 83.2694444 0.010000 83.2722222 0.010000 83.2750000 0.010000 83.2777778 0.010000 83.2805556 0.010000 83.2833333 0.010000 83.2861111 0.010000 83.2888889 0.010000 83.2916667 0.010000 83.2944444 0.010000 83.2972222 0.010000 83.3000000 0.010000 83.3027778 0.010000 83.3055556 0.010000 83.3083333 0.010000 83.3111111 0.010000 83.3138889 0.010000 83.3166667 0.010000 83.3194444 0.010000 83.3222222 0.010000 83.3250000 0.010000 83.3277778 0.010000 83.3305556 0.010000 83.3333333 0.010000 83.3361111 0.010000 83.3388889 0.010000 83.3416667 0.010000 83.3444444 0.010000 83.3472222 0.010000 83.3500000 0.010000 83.3527778 0.010000 83.3555556 0.010000 83.3583333 0.010000 83.3611111 0.010000 83.3638889 0.010000 83.3666667 0.010000 83.3694444 0.010000 83.3722222 0.010000 83.3750000 0.010000 83.3777778 0.010000 83.3805556 0.010000 83.3833333 0.010000 83.3861111 0.010000 83.3888889 0.010000 83.3916667 0.010000 83.3944444 0.010000 83.3972222 0.010000 83.4000000 0.010000 83.4027778 0.010000 83.4055556 0.010000 83.4083333 0.010000 83.4111111 0.010000 83.4138889 0.010000 83.4166667 0.010000 83.4194444 0.010000 83.4222222 0.010000 83.4250000 0.010000 83.4277778 0.010000 83.4305556 0.010000 83.4333333 0.010000 83.4361111 0.010000 83.4388889 0.010000 83.4416667 0.010000 83.4444444 0.010000 83.4472222 0.010000 83.4500000 0.010000 83.4527778 0.010000 83.4555556 0.010000 83.4583333 0.010000 83.4611111 0.010000 83.4638889 0.010000 83.4666667 0.010000 83.4694444 0.010000 83.4722222 0.010000 83.4750000 0.010000 83.4777778 0.010000 83.4805556 0.010000 83.4833333 0.010000 84.1472222 0.010000 84.1500000 0.010000 84.1527778 0.010000 84.1555556 0.010000 84.1583333 0.010000 84.1611111 0.010000 84.1638889 0.010000 84.1666667 0.010000 84.1694444 0.010000 84.1722222 0.010000 84.1750000 0.010000 84.1777778 0.010000 84.1805556 0.010000 84.1833333 0.010000 84.1861111 0.010000 84.1888889 0.010000 84.1916667 0.010000 84.1944444 0.010000 84.1972222 0.010000 84.2000000 0.010000 84.2027778 0.010000 84.2055556 0.010000 84.2083333 0.010000 84.2111111 0.010000 84.2138889 0.010000 84.2166667 0.010000 84.2194444 0.010000 84.2222222 0.010000 84.2250000 0.010000 84.2277778 0.010000 84.2305556 0.010000 84.2333333 0.010000 84.2361111 0.010000 84.2388889 0.010000 84.2416667 0.010000 84.2444444 0.010000 84.2472222 0.010000 84.2500000 0.010000 84.2527778 0.010000 84.2555556 0.010000 84.2583333 0.010000 84.2611111 0.010000 84.2638889 0.010000 84.2666667 0.010000 84.2694444 0.010000 84.2722222 0.010000 84.2750000 0.010000 84.2777778 0.010000 84.2805556 0.010000 84.2833333 0.010000 84.2861111 0.010000 84.2888889 0.010000 84.2916667 0.010000 84.2944444 0.010000 84.2972222 0.010000 84.3000000 0.010000 84.3027778 0.010000 84.3055556 0.010000 84.3083333 0.010000 84.3111111 0.010000 84.3138889 0.010000 84.3166667 0.010000 84.3194444 0.010000 84.3222222 0.010000 84.3250000 0.010000 84.3277778 0.010000 84.3305556 0.010000 84.3333333 0.010000 84.3361111 0.010000 84.3388889 0.037115 84.3416667 0.064808 84.3444444 0.087308 84.3472222 0.097692 84.3500000 0.089038 84.3527778 0.049231 84.3555556 0.010000 84.3583333 0.010000 84.3611111 0.010000 84.3638889 0.010000 84.3666667 0.030192 84.3694444 0.116731 84.3722222 0.218846 84.3750000 0.317500 84.3777778 0.409231 84.3805556 0.492308 84.3833333 0.566731 84.3861111 0.627308 84.3888889 0.674038 84.3916667 0.696538 84.3944444 0.701731 84.3972222 0.686154 84.4000000 0.655000 84.4027778 0.611731 84.4055556 0.558077 84.4083333 0.485385 84.4111111 0.412692 84.4138889 0.338269 84.4166667 0.267308 84.4194444 0.196346 84.4222222 0.128846 84.4250000 0.064808 84.4277778 0.010000 84.4305556 0.010000 84.4333333 0.010000 84.4361111 0.010000 84.4388889 0.010000 84.4416667 0.010000 84.4444444 0.010000 84.4472222 0.010000 84.4500000 0.010000 84.4527778 0.010000 84.4555556 0.010000 84.4583333 0.010000 84.4611111 0.010000 84.4638889 0.010000 84.4666667 0.010000 84.4694444 0.010000 84.4722222 0.010000 84.4750000 0.010000 84.4777778 0.010000 84.4805556 0.010000 84.4833333 0.010000 84.4861111 0.010000 84.4888889 0.010000 84.4916667 0.010000 84.4944444 0.010000 84.4972222 0.010000 84.5000000 0.010000 84.5027778 0.010000 84.5055556 0.010000 84.5083333 0.010000 84.5111111 0.010000 84.5138889 0.010000 84.5166667 0.010000 84.5194444 0.010000 84.5222222 0.010000 84.5250000 0.010000 84.5277778 0.010000 84.5305556 0.010000 84.5333333 0.010000 84.5361111 0.010000 84.5388889 0.010000 84.5416667 0.010000 84.5444444 0.010000 84.5472222 0.010000 84.5500000 0.010000 84.5527778 0.010000 84.5555556 0.010000 84.5583333 0.010000 84.5611111 0.010000 84.5638889 0.010000 84.5666667 0.010000 84.5694444 0.010000 84.5722222 0.010000 84.5750000 0.010000 84.5777778 0.010000 84.5805556 0.010000 84.5833333 0.010000 84.5861111 0.010000 84.5888889 0.010000 84.5916667 0.010000 84.5944444 0.010000 84.5972222 0.010000 84.6000000 0.010000 84.6027778 0.010000 84.6055556 0.010000 84.6083333 0.010000 84.6111111 0.010000 84.6138889 0.010000 84.6166667 0.010000 84.6194444 0.010000 84.6222222 0.010000 84.6250000 0.010000 84.6277778 0.010000 84.6305556 0.010000 84.6333333 0.010000 84.6361111 0.010000 84.6388889 0.010000 84.6416667 0.010000 84.6444444 0.010000 84.6472222 0.010000 84.6500000 0.010000 84.6527778 0.010000 84.6555556 0.010000 84.6583333 0.010000 84.6611111 0.010000 84.6638889 0.010000 84.6666667 0.010000 84.6694444 0.010000 84.6722222 0.010000 84.6750000 0.010000 84.6777778 0.010000 84.6805556 0.010000 84.6833333 0.010000 84.6861111 0.010000 84.6888889 0.010000 84.6916667 0.010000 84.6944444 0.010000 85.3722222 0.010000 85.3750000 0.010000 85.3777778 0.010000 85.3805556 0.010000 85.3833333 0.010000 85.3861111 0.010000 85.3888889 0.010000 85.3916667 0.010000 85.3944444 0.010000 85.3972222 0.010000 85.4000000 0.010000 85.4027778 0.010000 85.4055556 0.010000 85.4083333 0.010000 85.4111111 0.010000 85.4138889 0.010000 85.4166667 0.010000 85.4194444 0.010000 85.4222222 0.010000 85.4250000 0.010000 85.4277778 0.010000 85.4305556 0.010000 85.4333333 0.010000 85.4361111 0.010000 85.4388889 0.010000 85.4416667 0.010000 85.4444444 0.010000 85.4472222 0.010000 85.4500000 0.010000 85.4527778 0.010000 85.4555556 0.010000 85.4583333 0.010000 85.4611111 0.010000 85.4638889 0.010000 85.4666667 0.010000 85.4694444 0.010000 85.4722222 0.010000 85.4750000 0.010000 85.4777778 0.010000 85.4805556 0.010000 85.4833333 0.010000 85.4861111 0.010000 85.4888889 0.010000 85.4916667 0.010000 85.4944444 0.010000 85.4972222 0.010000 85.5000000 0.010000 85.5027778 0.010000 85.5055556 0.010000 85.5083333 0.010000 85.5111111 0.010000 85.5138889 0.010000 85.5166667 0.010000 85.5194444 0.010000 85.5222222 0.010000 85.5250000 0.010000 85.5277778 0.010000 85.5305556 0.010000 85.5333333 0.010000 85.5361111 0.010000 85.5388889 0.010000 85.5416667 0.010000 85.5444444 0.010000 85.5472222 0.010000 85.5500000 0.010000 85.5527778 0.010000 85.5555556 0.010000 85.5583333 0.010000 85.5611111 0.010000 85.5638889 0.010000 85.5666667 0.010000 85.5694444 0.044038 85.5722222 0.078654 85.5750000 0.097692 85.5777778 0.104615 85.5805556 0.082115 85.5833333 0.031923 85.5861111 0.010000 85.5888889 0.010000 85.5916667 0.010000 85.5944444 0.010000 85.5972222 0.059615 85.6000000 0.156538 85.6027778 0.260385 85.6055556 0.362500 85.6083333 0.462885 85.6111111 0.549423 85.6138889 0.618654 85.6166667 0.677500 85.6194444 0.708654 85.6222222 0.713846 85.6250000 0.693077 85.6277778 0.660192 85.6305556 0.606538 85.6333333 0.535577 85.6361111 0.455962 85.6388889 0.374615 85.6416667 0.296731 85.6444444 0.217115 85.6472222 0.140962 85.6500000 0.061346 85.6527778 0.010000 85.6555556 0.010000 85.6583333 0.010000 85.6611111 0.010000 85.6638889 0.010000 85.6666667 0.010000 85.6694444 0.010000 85.6722222 0.010000 85.6750000 0.010000 85.6777778 0.010000 85.6805556 0.010000 85.6833333 0.010000 85.6861111 0.010000 85.6888889 0.010000 85.6916667 0.010000 85.6944444 0.010000 85.6972222 0.010000 85.7000000 0.010000 85.7027778 0.010000 85.7055556 0.010000 85.7083333 0.010000 85.7111111 0.010000 85.7138889 0.010000 85.7166667 0.010000 85.7194444 0.010000 85.7222222 0.010000 85.7250000 0.010000 85.7277778 0.010000 85.7305556 0.010000 85.7333333 0.010000 85.7361111 0.010000 85.7388889 0.010000 85.7416667 0.010000 85.7444444 0.010000 85.7472222 0.010000 85.7500000 0.010000 85.7527778 0.010000 85.7555556 0.010000 85.7583333 0.010000 85.7611111 0.010000 85.7638889 0.010000 85.7666667 0.010000 85.7694444 0.010000 85.7722222 0.010000 85.7750000 0.010000 85.7777778 0.010000 85.7805556 0.010000 85.7833333 0.010000 85.7861111 0.010000 85.7888889 0.010000 85.7916667 0.010000 85.7944444 0.010000 85.7972222 0.010000 85.8000000 0.010000 85.8027778 0.010000 85.8055556 0.010000 85.8083333 0.010000 85.8111111 0.010000 85.8138889 0.010000 85.8166667 0.010000 85.8194444 0.010000 85.8222222 0.010000 85.8250000 0.010000 85.8277778 0.010000 85.8305556 0.010000 85.8333333 0.010000 85.8361111 0.010000 85.8388889 0.010000 85.8416667 0.010000 85.8444444 0.010000 85.8472222 0.010000 85.8500000 0.010000 85.8527778 0.010000 85.8555556 0.010000 85.8583333 0.010000 85.8611111 0.010000 85.8638889 0.010000 85.8666667 0.010000 85.8694444 0.010000 85.8722222 0.010000 85.8750000 0.010000 85.8777778 0.010000 85.8805556 0.010000 85.8833333 0.010000 85.8861111 0.010000 85.8888889 0.010000 85.8916667 0.010000 85.8944444 0.010000 85.8972222 0.010000 85.9000000 0.010000 85.9027778 0.010000 85.9055556 0.010000 85.9083333 0.010000 85.9111111 0.010000 85.9138889 0.010000 85.9166667 0.010000 85.9194444 0.010000 86.6111111 0.010000 86.6138889 0.010000 86.6166667 0.010000 86.6194444 0.010000 86.6222222 0.010000 86.6250000 0.010000 86.6277778 0.010000 86.6305556 0.010000 86.6333333 0.010000 86.6361111 0.010000 86.6388889 0.010000 86.6416667 0.010000 86.6444444 0.010000 86.6472222 0.010000 86.6500000 0.010000 86.6527778 0.010000 86.6555556 0.010000 86.6583333 0.010000 86.6611111 0.010000 86.6638889 0.010000 86.6666667 0.010000 86.6694444 0.010000 86.6722222 0.010000 86.6750000 0.010000 86.6777778 0.010000 86.6805556 0.010000 86.6833333 0.010000 86.6861111 0.010000 86.6888889 0.010000 86.6916667 0.010000 86.6944444 0.010000 86.6972222 0.010000 86.7000000 0.010000 86.7027778 0.010000 86.7055556 0.010000 86.7083333 0.010000 86.7111111 0.010000 86.7138889 0.010000 86.7166667 0.010000 86.7194444 0.010000 86.7222222 0.010000 86.7250000 0.010000 86.7277778 0.010000 86.7305556 0.010000 86.7333333 0.010000 86.7361111 0.010000 86.7388889 0.010000 86.7416667 0.010000 86.7444444 0.010000 86.7472222 0.010000 86.7500000 0.010000 86.7527778 0.010000 86.7555556 0.010000 86.7583333 0.010000 86.7611111 0.010000 86.7638889 0.010000 86.7666667 0.010000 86.7694444 0.010000 86.7722222 0.010000 86.7750000 0.010000 86.7777778 0.010000 86.7805556 0.010000 86.7833333 0.010000 86.7861111 0.010000 86.7888889 0.010000 86.7916667 0.010000 86.7944444 0.010000 86.7972222 0.010000 86.8000000 0.011154 86.8027778 0.047500 86.8055556 0.080385 86.8083333 0.104615 86.8111111 0.121923 86.8138889 0.116731 86.8166667 0.071731 86.8194444 0.014615 86.8222222 0.010000 86.8250000 0.010000 86.8277778 0.010000 86.8305556 0.010000 86.8333333 0.073462 86.8361111 0.172115 86.8388889 0.274231 86.8416667 0.365962 86.8444444 0.452500 86.8472222 0.525192 86.8500000 0.587500 86.8527778 0.635962 86.8555556 0.667115 86.8583333 0.679231 86.8611111 0.670577 86.8638889 0.655000 86.8666667 0.627308 86.8694444 0.584038 86.8722222 0.523462 86.8750000 0.457692 86.8777778 0.390192 86.8805556 0.322692 86.8833333 0.251731 86.8861111 0.185962 86.8888889 0.111538 86.8916667 0.037115 86.8944444 0.010000 86.8972222 0.010000 86.9000000 0.010000 86.9027778 0.010000 86.9055556 0.010000 86.9083333 0.010000 86.9111111 0.010000 86.9138889 0.010000 86.9166667 0.010000 86.9194444 0.010000 86.9222222 0.010000 86.9250000 0.010000 86.9277778 0.010000 86.9305556 0.010000 86.9333333 0.010000 86.9361111 0.010000 86.9388889 0.010000 86.9416667 0.010000 86.9444444 0.010000 86.9472222 0.010000 86.9500000 0.010000 86.9527778 0.010000 86.9555556 0.010000 86.9583333 0.010000 86.9611111 0.010000 86.9638889 0.010000 86.9666667 0.010000 86.9694444 0.010000 86.9722222 0.010000 86.9750000 0.010000 86.9777778 0.010000 86.9805556 0.010000 86.9833333 0.010000 86.9861111 0.010000 86.9888889 0.010000 86.9916667 0.010000 86.9944444 0.010000 86.9972222 0.010000 87.0000000 0.010000 87.0027778 0.010000 87.0055556 0.010000 87.0083333 0.010000 87.0111111 0.010000 87.0138889 0.010000 87.0166667 0.010000 87.0194444 0.010000 87.0222222 0.010000 87.0250000 0.010000 87.0277778 0.010000 87.0305556 0.010000 87.0333333 0.010000 87.0361111 0.010000 87.0388889 0.010000 87.0416667 0.010000 87.0444444 0.010000 87.0472222 0.010000 87.0500000 0.010000 87.0527778 0.010000 87.0555556 0.010000 87.0583333 0.010000 87.0611111 0.010000 87.0638889 0.010000 87.0666667 0.010000 87.0694444 0.010000 87.0722222 0.010000 87.0750000 0.010000 87.0777778 0.010000 87.0805556 0.010000 87.0833333 0.010000 87.0861111 0.010000 87.0888889 0.010000 87.0916667 0.010000 87.0944444 0.010000 87.0972222 0.010000 87.1000000 0.010000 87.1027778 0.010000 87.1055556 0.010000 87.1083333 0.010000 87.1111111 0.010000 87.1138889 0.010000 87.1166667 0.010000 87.1194444 0.010000 87.1222222 0.010000 87.1250000 0.010000 87.1277778 0.010000 87.1305556 0.010000 87.1333333 0.010000 87.1361111 0.010000 87.1388889 0.010000 87.1416667 0.010000 87.1444444 0.010000 87.1472222 0.010000 87.1500000 0.010000 87.1527778 0.010000 87.1555556 0.010000 87.1583333 0.010000 87.8416667 0.010000 87.8444444 0.010000 87.8472222 0.010000 87.8500000 0.010000 87.8527778 0.010000 87.8555556 0.010000 87.8583333 0.010000 87.8611111 0.010000 87.8638889 0.010000 87.8666667 0.010000 87.8694444 0.010000 87.8722222 0.010000 87.8750000 0.010000 87.8777778 0.010000 87.8805556 0.010000 87.8833333 0.010000 87.8861111 0.010000 87.8888889 0.010000 87.8916667 0.010000 87.8944444 0.010000 87.8972222 0.010000 87.9000000 0.010000 87.9027778 0.010000 87.9055556 0.010000 87.9083333 0.010000 87.9111111 0.010000 87.9138889 0.010000 87.9166667 0.010000 87.9194444 0.010000 87.9222222 0.010000 87.9250000 0.010000 87.9277778 0.010000 87.9305556 0.010000 87.9333333 0.010000 87.9361111 0.010000 87.9388889 0.010000 87.9416667 0.010000 87.9444444 0.010000 87.9472222 0.010000 87.9500000 0.010000 87.9527778 0.010000 87.9555556 0.010000 87.9583333 0.010000 87.9611111 0.010000 87.9638889 0.010000 87.9666667 0.010000 87.9694444 0.010000 87.9722222 0.010000 87.9750000 0.010000 87.9777778 0.010000 87.9805556 0.010000 87.9833333 0.010000 87.9861111 0.010000 87.9888889 0.010000 87.9916667 0.010000 87.9944444 0.010000 87.9972222 0.010000 88.0000000 0.010000 88.0027778 0.010000 88.0055556 0.010000 88.0083333 0.010000 88.0111111 0.010000 88.0138889 0.010000 88.0166667 0.010000 88.0194444 0.010000 88.0222222 0.010000 88.0250000 0.010000 88.0277778 0.010000 88.0305556 0.019808 88.0333333 0.047500 88.0361111 0.075192 88.0388889 0.092500 88.0416667 0.101154 88.0444444 0.087308 88.0472222 0.054423 88.0500000 0.010000 88.0527778 0.010000 88.0555556 0.010000 88.0583333 0.010000 88.0611111 0.010000 88.0638889 0.076923 88.0666667 0.168654 88.0694444 0.265577 88.0722222 0.357308 88.0750000 0.443846 88.0777778 0.526923 88.0805556 0.594423 88.0833333 0.653269 88.0861111 0.698269 88.0888889 0.720769 88.0916667 0.715577 88.0944444 0.701731 88.0972222 0.670577 88.1000000 0.616923 88.1027778 0.552885 88.1055556 0.478462 88.1083333 0.407500 88.1111111 0.336538 88.1138889 0.262115 88.1166667 0.199808 88.1194444 0.128846 88.1222222 0.061346 88.1250000 0.010000 88.1277778 0.010000 88.1305556 0.010000 88.1333333 0.010000 88.1361111 0.010000 88.1388889 0.010000 88.1416667 0.010000 88.1444444 0.010000 88.1472222 0.010000 88.1500000 0.010000 88.1527778 0.010000 88.1555556 0.010000 88.1583333 0.010000 88.1611111 0.010000 88.1638889 0.010000 88.1666667 0.010000 88.1694444 0.010000 88.1722222 0.010000 88.1750000 0.010000 88.1777778 0.010000 88.1805556 0.010000 88.1833333 0.010000 88.1861111 0.010000 88.1888889 0.010000 88.1916667 0.010000 88.1944444 0.010000 88.1972222 0.010000 88.2000000 0.010000 88.2027778 0.010000 88.2055556 0.010000 88.2083333 0.010000 88.2111111 0.010000 88.2138889 0.010000 88.2166667 0.010000 88.2194444 0.010000 88.2222222 0.010000 88.2250000 0.010000 88.2277778 0.010000 88.2305556 0.010000 88.2333333 0.010000 88.2361111 0.010000 88.2388889 0.010000 88.2416667 0.010000 88.2444444 0.010000 88.2472222 0.010000 88.2500000 0.010000 88.2527778 0.010000 88.2555556 0.010000 88.2583333 0.010000 88.2611111 0.010000 88.2638889 0.010000 88.2666667 0.010000 88.2694444 0.010000 88.2722222 0.010000 88.2750000 0.010000 88.2777778 0.010000 88.2805556 0.010000 88.2833333 0.010000 88.2861111 0.010000 88.2888889 0.010000 88.2916667 0.010000 88.2944444 0.010000 88.2972222 0.010000 88.3000000 0.010000 88.3027778 0.010000 88.3055556 0.010000 88.3083333 0.010000 88.3111111 0.010000 88.3138889 0.010000 88.3166667 0.010000 88.3194444 0.010000 88.3222222 0.010000 88.3250000 0.010000 88.3277778 0.010000 88.3305556 0.010000 88.3333333 0.010000 88.3361111 0.010000 88.3388889 0.010000 88.3416667 0.010000 88.3444444 0.010000 88.3472222 0.010000 88.3500000 0.010000 88.3527778 0.010000 88.3555556 0.010000 88.3583333 0.010000 88.3611111 0.010000 88.3638889 0.010000 88.3666667 0.010000 88.3694444 0.010000 88.3722222 0.010000 88.3750000 0.010000 88.3777778 0.010000 88.3805556 0.010000 88.3833333 0.010000 88.3861111 0.010000 88.3888889 0.010000 89.0416667 0.010000 89.0444444 0.010000 89.0472222 0.010000 89.0500000 0.010000 89.0527778 0.010000 89.0555556 0.010000 89.0583333 0.010000 89.0611111 0.010000 89.0638889 0.010000 89.0666667 0.010000 89.0694444 0.010000 89.0722222 0.010000 89.0750000 0.010000 89.0777778 0.010000 89.0805556 0.010000 89.0833333 0.010000 89.0861111 0.010000 89.0888889 0.010000 89.0916667 0.010000 89.0944444 0.010000 89.0972222 0.010000 89.1000000 0.010000 89.1027778 0.010000 89.1055556 0.010000 89.1083333 0.010000 89.1111111 0.010000 89.1138889 0.010000 89.1166667 0.010000 89.1194444 0.010000 89.1222222 0.010000 89.1250000 0.010000 89.1277778 0.010000 89.1305556 0.010000 89.1333333 0.010000 89.1361111 0.010000 89.1388889 0.010000 89.1416667 0.010000 89.1444444 0.010000 89.1472222 0.010000 89.1500000 0.010000 89.1527778 0.010000 89.1555556 0.010000 89.1583333 0.010000 89.1611111 0.010000 89.1638889 0.010000 89.1666667 0.010000 89.1694444 0.010000 89.1722222 0.010000 89.1750000 0.010000 89.1777778 0.010000 89.1805556 0.010000 89.1833333 0.010000 89.1861111 0.010000 89.1888889 0.010000 89.1916667 0.010000 89.1944444 0.010000 89.1972222 0.010000 89.2000000 0.010000 89.2027778 0.010000 89.2055556 0.010000 89.2083333 0.010000 89.2111111 0.010000 89.2138889 0.010000 89.2166667 0.010000 89.2194444 0.010000 89.2222222 0.010000 89.2250000 0.010000 89.2277778 0.010000 89.2305556 0.010000 89.2333333 0.021538 89.2361111 0.059615 89.2388889 0.090769 89.2416667 0.101154 89.2444444 0.097692 89.2472222 0.071731 89.2500000 0.023269 89.2527778 0.010000 89.2555556 0.010000 89.2583333 0.010000 89.2611111 0.010000 89.2638889 0.047500 89.2666667 0.139231 89.2694444 0.239615 89.2722222 0.341731 89.2750000 0.436923 89.2777778 0.518269 89.2805556 0.585769 89.2833333 0.639423 89.2861111 0.677500 89.2888889 0.694808 89.2916667 0.696538 89.2944444 0.672308 89.2972222 0.642885 89.3000000 0.596154 89.3027778 0.533846 89.3055556 0.462885 89.3083333 0.390192 89.3111111 0.320962 89.3138889 0.248269 89.3166667 0.170385 89.3194444 0.087308 89.3222222 0.010000 89.3250000 0.010000 89.3277778 0.010000 89.3305556 0.010000 89.3333333 0.010000 89.3361111 0.010000 89.3388889 0.010000 89.3416667 0.010000 89.3444444 0.010000 89.3472222 0.010000 89.3500000 0.010000 89.3527778 0.010000 89.3555556 0.010000 89.3583333 0.010000 89.3611111 0.010000 89.3638889 0.010000 89.3666667 0.010000 89.3694444 0.010000 89.3722222 0.010000 89.3750000 0.010000 89.3777778 0.010000 89.3805556 0.010000 89.3833333 0.010000 89.3861111 0.010000 89.3888889 0.010000 89.3916667 0.010000 89.3944444 0.010000 89.3972222 0.010000 89.4000000 0.010000 89.4027778 0.010000 89.4055556 0.010000 89.4083333 0.010000 89.4111111 0.010000 89.4138889 0.010000 89.4166667 0.010000 89.4194444 0.010000 89.4222222 0.010000 89.4250000 0.010000 89.4277778 0.010000 89.4305556 0.010000 89.4333333 0.010000 89.4361111 0.010000 89.4388889 0.010000 89.4416667 0.010000 89.4444444 0.010000 89.4472222 0.010000 89.4500000 0.010000 89.4527778 0.010000 89.4555556 0.010000 89.4583333 0.010000 89.4611111 0.010000 89.4638889 0.010000 89.4666667 0.010000 89.4694444 0.010000 89.4722222 0.010000 89.4750000 0.010000 89.4777778 0.010000 89.4805556 0.010000 89.4833333 0.010000 89.4861111 0.010000 89.4888889 0.010000 89.4916667 0.010000 89.4944444 0.010000 89.4972222 0.010000 89.5000000 0.010000 89.5027778 0.010000 89.5055556 0.010000 89.5083333 0.010000 89.5111111 0.010000 89.5138889 0.010000 89.5166667 0.010000 89.5194444 0.010000 89.5222222 0.010000 89.5250000 0.010000 89.5277778 0.010000 89.5305556 0.010000 89.5333333 0.010000 89.5361111 0.010000 89.5388889 0.010000 89.5416667 0.010000 89.5444444 0.010000 89.5472222 0.010000 89.5500000 0.010000 89.5527778 0.010000 89.5555556 0.010000 89.5583333 0.010000 89.5611111 0.010000 89.5638889 0.010000 89.5666667 0.010000 89.5694444 0.010000 89.5722222 0.010000 89.5750000 0.010000 89.5777778 0.010000 89.5805556 0.010000 89.5833333 0.010000 89.5861111 0.010000 89.5888889 0.010000 90.2638889 0.010000 90.2666667 0.010000 90.2694444 0.010000 90.2722222 0.010000 90.2750000 0.010000 90.2777778 0.010000 90.2805556 0.010000 90.2833333 0.010000 90.2861111 0.010000 90.2888889 0.010000 90.2916667 0.010000 90.2944444 0.010000 90.2972222 0.010000 90.3000000 0.010000 90.3027778 0.010000 90.3055556 0.010000 90.3083333 0.010000 90.3111111 0.010000 90.3138889 0.010000 90.3166667 0.010000 90.3194444 0.010000 90.3222222 0.010000 90.3250000 0.010000 90.3277778 0.010000 90.3305556 0.010000 90.3333333 0.010000 90.3361111 0.010000 90.3388889 0.010000 90.3416667 0.010000 90.3444444 0.010000 90.3472222 0.010000 90.3500000 0.010000 90.3527778 0.010000 90.3555556 0.010000 90.3583333 0.010000 90.3611111 0.010000 90.3638889 0.010000 90.3666667 0.010000 90.3694444 0.010000 90.3722222 0.010000 90.3750000 0.010000 90.3777778 0.010000 90.3805556 0.010000 90.3833333 0.010000 90.3861111 0.010000 90.3888889 0.010000 90.3916667 0.010000 90.3944444 0.010000 90.3972222 0.010000 90.4000000 0.010000 90.4027778 0.010000 90.4055556 0.010000 90.4083333 0.010000 90.4111111 0.010000 90.4138889 0.010000 90.4166667 0.010000 90.4194444 0.010000 90.4222222 0.010000 90.4250000 0.010000 90.4277778 0.010000 90.4305556 0.010000 90.4333333 0.010000 90.4361111 0.010000 90.4388889 0.010000 90.4416667 0.010000 90.4444444 0.010000 90.4472222 0.010000 90.4500000 0.010000 90.4527778 0.010000 90.4555556 0.030192 90.4583333 0.061346 90.4611111 0.085577 90.4638889 0.095962 90.4666667 0.085577 90.4694444 0.050962 90.4722222 0.010000 90.4750000 0.010000 90.4777778 0.010000 90.4805556 0.010000 90.4833333 0.010000 90.4861111 0.054423 90.4888889 0.153077 90.4916667 0.251731 90.4944444 0.341731 90.4972222 0.426538 90.5000000 0.502692 90.5027778 0.559808 90.5055556 0.604808 90.5083333 0.630769 90.5111111 0.637692 90.5138889 0.627308 90.5166667 0.599615 90.5194444 0.556346 90.5222222 0.500962 90.5250000 0.435192 90.5277778 0.364231 90.5305556 0.301923 90.5333333 0.237885 90.5361111 0.166923 90.5388889 0.095962 90.5416667 0.028462 90.5444444 0.010000 90.5472222 0.010000 90.5500000 0.010000 90.5527778 0.010000 90.5555556 0.010000 90.5583333 0.010000 90.5611111 0.010000 90.5638889 0.010000 90.5666667 0.010000 90.5694444 0.010000 90.5722222 0.010000 90.5750000 0.010000 90.5777778 0.010000 90.5805556 0.010000 90.5833333 0.010000 90.5861111 0.010000 90.5888889 0.010000 90.5916667 0.010000 90.5944444 0.010000 90.5972222 0.010000 90.6000000 0.010000 90.6027778 0.010000 90.6055556 0.010000 90.6083333 0.010000 90.6111111 0.010000 90.6138889 0.010000 90.6166667 0.010000 90.6194444 0.010000 90.6222222 0.010000 90.6250000 0.010000 90.6277778 0.010000 90.6305556 0.010000 90.6333333 0.010000 90.6361111 0.010000 90.6388889 0.010000 90.6416667 0.010000 90.6444444 0.010000 90.6472222 0.010000 90.6500000 0.010000 90.6527778 0.010000 90.6555556 0.010000 90.6583333 0.010000 90.6611111 0.010000 90.6638889 0.010000 90.6666667 0.010000 90.6694444 0.010000 90.6722222 0.010000 90.6750000 0.010000 90.6777778 0.010000 90.6805556 0.010000 90.6833333 0.010000 90.6861111 0.010000 90.6888889 0.010000 90.6916667 0.010000 90.6944444 0.010000 90.6972222 0.010000 90.7000000 0.010000 90.7027778 0.010000 90.7055556 0.010000 90.7083333 0.010000 90.7111111 0.010000 90.7138889 0.010000 90.7166667 0.010000 90.7194444 0.010000 90.7222222 0.010000 90.7250000 0.010000 90.7277778 0.010000 90.7305556 0.010000 90.7333333 0.010000 90.7361111 0.010000 90.7388889 0.010000 90.7416667 0.010000 90.7444444 0.010000 90.7472222 0.010000 90.7500000 0.010000 90.7527778 0.010000 90.7555556 0.010000 90.7583333 0.010000 90.7611111 0.010000 90.7638889 0.010000 90.7666667 0.010000 90.7694444 0.010000 90.7722222 0.010000 90.7750000 0.010000 90.7777778 0.010000 90.7805556 0.010000 90.7833333 0.010000 90.7861111 0.010000 90.7888889 0.010000 90.7916667 0.010000 90.7944444 0.010000 90.7972222 0.010000 90.8000000 0.010000 90.8027778 0.010000 90.8055556 0.010000 90.8083333 0.010000 90.8111111 0.010000 91.4861111 0.010000 91.4888889 0.010000 91.4916667 0.010000 91.4944444 0.010000 91.4972222 0.010000 91.5000000 0.010000 91.5027778 0.010000 91.5055556 0.010000 91.5083333 0.010000 91.5111111 0.010000 91.5138889 0.010000 91.5166667 0.010000 91.5194444 0.010000 91.5222222 0.010000 91.5250000 0.010000 91.5277778 0.010000 91.5305556 0.010000 91.5333333 0.010000 91.5361111 0.010000 91.5388889 0.010000 91.5416667 0.010000 91.5444444 0.010000 91.5472222 0.010000 91.5500000 0.010000 91.5527778 0.010000 91.5555556 0.010000 91.5583333 0.010000 91.5611111 0.010000 91.5638889 0.010000 91.5666667 0.010000 91.5694444 0.010000 91.5722222 0.010000 91.5750000 0.010000 91.5777778 0.010000 91.5805556 0.010000 91.5833333 0.010000 91.5861111 0.010000 91.5888889 0.010000 91.5916667 0.010000 91.5944444 0.010000 91.5972222 0.010000 91.6000000 0.010000 91.6027778 0.010000 91.6055556 0.010000 91.6083333 0.010000 91.6111111 0.010000 91.6138889 0.010000 91.6166667 0.010000 91.6194444 0.010000 91.6222222 0.010000 91.6250000 0.010000 91.6277778 0.010000 91.6305556 0.010000 91.6333333 0.010000 91.6361111 0.010000 91.6388889 0.010000 91.6416667 0.010000 91.6444444 0.010000 91.6472222 0.010000 91.6500000 0.010000 91.6527778 0.010000 91.6555556 0.010000 91.6583333 0.010000 91.6611111 0.010000 91.6638889 0.010000 91.6666667 0.010000 91.6694444 0.010000 91.6722222 0.010000 91.6750000 0.019808 91.6777778 0.056154 91.6805556 0.078654 91.6833333 0.090769 91.6861111 0.089038 91.6888889 0.064808 91.6916667 0.025000 91.6944444 0.010000 91.6972222 0.010000 91.7000000 0.010000 91.7027778 0.010000 91.7055556 0.016346 91.7083333 0.101154 91.7111111 0.194615 91.7138889 0.288077 91.7166667 0.381538 91.7194444 0.468077 91.7222222 0.544231 91.7250000 0.604808 91.7277778 0.655000 91.7305556 0.689615 91.7333333 0.706923 91.7361111 0.703462 91.7388889 0.686154 91.7416667 0.649808 91.7444444 0.603077 91.7472222 0.545962 91.7500000 0.478462 91.7527778 0.407500 91.7555556 0.340000 91.7583333 0.269038 91.7611111 0.191154 91.7638889 0.121923 91.7666667 0.050962 91.7694444 0.010000 91.7722222 0.010000 91.7750000 0.010000 91.7777778 0.010000 91.7805556 0.010000 91.7833333 0.010000 91.7861111 0.010000 91.7888889 0.010000 91.7916667 0.010000 91.7944444 0.010000 91.7972222 0.010000 91.8000000 0.010000 91.8027778 0.010000 91.8055556 0.010000 91.8083333 0.010000 91.8111111 0.010000 91.8138889 0.010000 91.8166667 0.010000 91.8194444 0.010000 91.8222222 0.010000 91.8250000 0.010000 91.8277778 0.010000 91.8305556 0.010000 91.8333333 0.010000 91.8361111 0.010000 91.8388889 0.010000 91.8416667 0.010000 91.8444444 0.010000 91.8472222 0.010000 91.8500000 0.010000 91.8527778 0.010000 91.8555556 0.010000 91.8583333 0.010000 91.8611111 0.010000 91.8638889 0.010000 91.8666667 0.010000 91.8694444 0.010000 91.8722222 0.010000 91.8750000 0.010000 91.8777778 0.010000 91.8805556 0.010000 91.8833333 0.010000 91.8861111 0.010000 91.8888889 0.010000 91.8916667 0.010000 91.8944444 0.010000 91.8972222 0.010000 91.9000000 0.010000 91.9027778 0.010000 91.9055556 0.010000 91.9083333 0.010000 91.9111111 0.010000 91.9138889 0.010000 91.9166667 0.010000 91.9194444 0.010000 91.9222222 0.010000 91.9250000 0.010000 91.9277778 0.010000 91.9305556 0.010000 91.9333333 0.010000 91.9361111 0.010000 91.9388889 0.010000 91.9416667 0.010000 91.9444444 0.010000 91.9472222 0.010000 91.9500000 0.010000 91.9527778 0.010000 91.9555556 0.010000 91.9583333 0.010000 91.9611111 0.010000 91.9638889 0.010000 91.9666667 0.010000 91.9694444 0.010000 91.9722222 0.010000 91.9750000 0.010000 91.9777778 0.010000 91.9805556 0.010000 91.9833333 0.010000 91.9861111 0.010000 91.9888889 0.010000 91.9916667 0.010000 91.9944444 0.010000 91.9972222 0.010000 92.0000000 0.010000 92.0027778 0.010000 92.0055556 0.010000 92.0083333 0.010000 92.0111111 0.010000 92.0138889 0.010000 92.0166667 0.010000 92.0194444 0.010000 92.0222222 0.010000 92.0250000 0.010000 92.0277778 0.010000 92.0305556 0.010000 92.0333333 0.010000 92.7250000 0.010000 92.7277778 0.010000 92.7305556 0.010000 92.7333333 0.010000 92.7361111 0.010000 92.7388889 0.010000 92.7416667 0.010000 92.7444444 0.010000 92.7472222 0.010000 92.7500000 0.010000 92.7527778 0.010000 92.7555556 0.010000 92.7583333 0.010000 92.7611111 0.010000 92.7638889 0.010000 92.7666667 0.010000 92.7694444 0.010000 92.7722222 0.010000 92.7750000 0.010000 92.7777778 0.010000 92.7805556 0.010000 92.7833333 0.010000 92.7861111 0.010000 92.7888889 0.010000 92.7916667 0.010000 92.7944444 0.010000 92.7972222 0.010000 92.8000000 0.010000 92.8027778 0.010000 92.8055556 0.010000 92.8083333 0.010000 92.8111111 0.010000 92.8138889 0.010000 92.8166667 0.010000 92.8194444 0.010000 92.8222222 0.010000 92.8250000 0.010000 92.8277778 0.010000 92.8305556 0.010000 92.8333333 0.010000 92.8361111 0.010000 92.8388889 0.010000 92.8416667 0.010000 92.8444444 0.010000 92.8472222 0.010000 92.8500000 0.010000 92.8527778 0.010000 92.8555556 0.010000 92.8583333 0.010000 92.8611111 0.010000 92.8638889 0.010000 92.8666667 0.010000 92.8694444 0.010000 92.8722222 0.010000 92.8750000 0.010000 92.8777778 0.010000 92.8805556 0.010000 92.8833333 0.010000 92.8861111 0.010000 92.8888889 0.010000 92.8916667 0.010000 92.8944444 0.010000 92.8972222 0.010000 92.9000000 0.010000 92.9027778 0.010000 92.9055556 0.010000 92.9083333 0.010000 92.9111111 0.010000 92.9138889 0.025000 92.9166667 0.052692 92.9194444 0.073462 92.9222222 0.080385 92.9250000 0.075192 92.9277778 0.038846 92.9305556 0.010000 92.9333333 0.010000 92.9361111 0.010000 92.9388889 0.010000 92.9416667 0.010000 92.9444444 0.010000 92.9472222 0.095962 92.9500000 0.189423 92.9527778 0.284615 92.9555556 0.365962 92.9583333 0.447308 92.9611111 0.520000 92.9638889 0.582308 92.9666667 0.625577 92.9694444 0.646346 92.9722222 0.653269 92.9750000 0.644615 92.9777778 0.622115 92.9805556 0.592692 92.9833333 0.535577 92.9861111 0.469808 92.9888889 0.397115 92.9916667 0.319231 92.9944444 0.236154 92.9972222 0.153077 93.0000000 0.064808 93.0027778 0.010000 93.0055556 0.010000 93.0083333 0.010000 93.0111111 0.010000 93.0138889 0.010000 93.0166667 0.010000 93.0194444 0.010000 93.0222222 0.010000 93.0250000 0.010000 93.0277778 0.010000 93.0305556 0.010000 93.0333333 0.010000 93.0361111 0.010000 93.0388889 0.010000 93.0416667 0.010000 93.0444444 0.010000 93.0472222 0.010000 93.0500000 0.010000 93.0527778 0.010000 93.0555556 0.010000 93.0583333 0.010000 93.0611111 0.010000 93.0638889 0.010000 93.0666667 0.010000 93.0694444 0.010000 93.0722222 0.010000 93.0750000 0.010000 93.0777778 0.010000 93.0805556 0.010000 93.0833333 0.010000 93.0861111 0.010000 93.0888889 0.010000 93.0916667 0.010000 93.0944444 0.010000 93.0972222 0.010000 93.1000000 0.010000 93.1027778 0.010000 93.1055556 0.010000 93.1083333 0.010000 93.1111111 0.010000 93.1138889 0.010000 93.1166667 0.010000 93.1194444 0.010000 93.1222222 0.010000 93.1250000 0.010000 93.1277778 0.010000 93.1305556 0.010000 93.1333333 0.010000 93.1361111 0.010000 93.1388889 0.010000 93.1416667 0.010000 93.1444444 0.010000 93.1472222 0.010000 93.1500000 0.010000 93.1527778 0.010000 93.1555556 0.010000 93.1583333 0.010000 93.1611111 0.010000 93.1638889 0.010000 93.1666667 0.010000 93.1694444 0.010000 93.1722222 0.010000 93.1750000 0.010000 93.1777778 0.010000 93.1805556 0.010000 93.1833333 0.010000 93.1861111 0.010000 93.1888889 0.010000 93.1916667 0.010000 93.1944444 0.010000 93.1972222 0.010000 93.2000000 0.010000 93.2027778 0.010000 93.2055556 0.010000 93.2083333 0.010000 93.2111111 0.010000 93.2138889 0.010000 93.2166667 0.010000 93.2194444 0.010000 93.2222222 0.010000 93.2250000 0.010000 93.2277778 0.010000 93.2305556 0.010000 93.2333333 0.010000 93.2361111 0.010000 93.2388889 0.010000 93.2416667 0.010000 93.2444444 0.010000 93.2472222 0.010000 93.2500000 0.010000 93.2527778 0.010000 93.2555556 0.010000 93.2583333 0.010000 93.2611111 0.010000 93.2638889 0.010000 93.2666667 0.010000 93.2694444 0.010000 93.2722222 0.010000 93.9000000 0.010000 93.9027778 0.010000 93.9055556 0.010000 93.9083333 0.010000 93.9111111 0.010000 93.9138889 0.010000 93.9166667 0.010000 93.9194444 0.010000 93.9222222 0.010000 93.9250000 0.010000 93.9277778 0.010000 93.9305556 0.010000 93.9333333 0.010000 93.9361111 0.010000 93.9388889 0.010000 93.9416667 0.010000 93.9444444 0.010000 93.9472222 0.010000 93.9500000 0.010000 93.9527778 0.010000 93.9555556 0.010000 93.9583333 0.010000 93.9611111 0.010000 93.9638889 0.010000 93.9666667 0.010000 93.9694444 0.010000 93.9722222 0.010000 93.9750000 0.010000 93.9777778 0.010000 93.9805556 0.010000 93.9833333 0.010000 93.9861111 0.010000 93.9888889 0.010000 93.9916667 0.010000 93.9944444 0.010000 93.9972222 0.010000 94.0000000 0.010000 94.0027778 0.010000 94.0055556 0.010000 94.0083333 0.010000 94.0111111 0.010000 94.0138889 0.010000 94.0166667 0.010000 94.0194444 0.010000 94.0222222 0.010000 94.0250000 0.010000 94.0277778 0.010000 94.0305556 0.010000 94.0333333 0.010000 94.0361111 0.010000 94.0388889 0.010000 94.0416667 0.010000 94.0444444 0.010000 94.0472222 0.010000 94.0500000 0.010000 94.0527778 0.010000 94.0555556 0.010000 94.0583333 0.010000 94.0611111 0.010000 94.0638889 0.010000 94.0666667 0.010000 94.0694444 0.010000 94.0722222 0.010000 94.0750000 0.010000 94.0777778 0.010000 94.0805556 0.010000 94.0833333 0.010000 94.0861111 0.010000 94.0888889 0.010000 94.0916667 0.010000 94.0944444 0.010000 94.0972222 0.010000 94.1000000 0.016346 94.1027778 0.035385 94.1055556 0.030192 94.1083333 0.010000 94.1111111 0.010000 94.1138889 0.010000 94.1166667 0.010000 94.1194444 0.010000 94.1222222 0.010000 94.1250000 0.089038 94.1277778 0.187692 94.1305556 0.286346 94.1333333 0.388462 94.1361111 0.471538 94.1388889 0.544231 94.1416667 0.596154 94.1444444 0.632500 94.1472222 0.658462 94.1500000 0.651538 94.1527778 0.622115 94.1555556 0.575385 94.1583333 0.511346 94.1611111 0.430000 94.1638889 0.345192 94.1666667 0.267308 94.1694444 0.192885 94.1722222 0.118462 94.1750000 0.045769 94.1777778 0.010000 94.1805556 0.010000 94.1833333 0.010000 94.1861111 0.010000 94.1888889 0.010000 94.1916667 0.010000 94.1944444 0.010000 94.1972222 0.010000 94.2000000 0.010000 94.2027778 0.010000 94.2055556 0.010000 94.2083333 0.010000 94.2111111 0.010000 94.2138889 0.010000 94.2166667 0.010000 94.2194444 0.010000 94.2222222 0.010000 94.2250000 0.010000 94.2277778 0.010000 94.2305556 0.010000 94.2333333 0.010000 94.2361111 0.010000 94.2388889 0.010000 94.2416667 0.010000 94.2444444 0.010000 94.2472222 0.010000 94.2500000 0.010000 94.2527778 0.010000 94.2555556 0.010000 94.2583333 0.010000 94.2611111 0.010000 94.2638889 0.010000 94.2666667 0.010000 94.2694444 0.010000 94.2722222 0.010000 94.2750000 0.010000 94.2777778 0.010000 94.2805556 0.010000 94.2833333 0.010000 94.2861111 0.010000 94.2888889 0.010000 94.2916667 0.010000 94.2944444 0.010000 94.2972222 0.010000 94.3000000 0.010000 94.3027778 0.010000 94.3055556 0.010000 94.3083333 0.010000 94.3111111 0.010000 94.3138889 0.010000 94.3166667 0.010000 94.3194444 0.010000 94.3222222 0.010000 94.3250000 0.010000 94.3277778 0.010000 94.3305556 0.010000 94.3333333 0.010000 94.3361111 0.010000 94.3388889 0.010000 94.3416667 0.010000 94.3444444 0.010000 94.3472222 0.010000 94.3500000 0.010000 94.3527778 0.010000 94.3555556 0.010000 94.3583333 0.010000 94.3611111 0.010000 94.3638889 0.010000 94.3666667 0.010000 94.3694444 0.010000 94.3722222 0.010000 94.3750000 0.010000 94.3777778 0.010000 94.3805556 0.010000 94.3833333 0.010000 94.3861111 0.010000 94.3888889 0.010000 94.3916667 0.010000 94.3944444 0.010000 94.3972222 0.010000 94.4000000 0.010000 94.4027778 0.010000 94.4055556 0.010000 94.4083333 0.010000 94.4111111 0.010000 94.4138889 0.010000 94.4166667 0.010000 94.4194444 0.010000 94.4222222 0.010000 94.4250000 0.010000 94.4277778 0.010000 94.4305556 0.010000 94.4333333 0.010000 94.4361111 0.010000 94.4388889 0.010000 94.4416667 0.010000 94.4444444 0.010000 94.4472222 0.010000 95.0750000 0.010000 95.0777778 0.010000 95.0805556 0.010000 95.0833333 0.010000 95.0861111 0.010000 95.0888889 0.010000 95.0916667 0.010000 95.0944444 0.010000 95.0972222 0.010000 95.1000000 0.010000 95.1027778 0.010000 95.1055556 0.010000 95.1083333 0.010000 95.1111111 0.010000 95.1138889 0.010000 95.1166667 0.010000 95.1194444 0.010000 95.1222222 0.010000 95.1250000 0.010000 95.1277778 0.010000 95.1305556 0.010000 95.1333333 0.010000 95.1361111 0.010000 95.1388889 0.010000 95.1416667 0.010000 95.1444444 0.010000 95.1472222 0.010000 95.1500000 0.010000 95.1527778 0.010000 95.1555556 0.010000 95.1583333 0.010000 95.1611111 0.010000 95.1638889 0.010000 95.1666667 0.010000 95.1694444 0.010000 95.1722222 0.010000 95.1750000 0.010000 95.1777778 0.010000 95.1805556 0.010000 95.1833333 0.010000 95.1861111 0.010000 95.1888889 0.010000 95.1916667 0.010000 95.1944444 0.010000 95.1972222 0.010000 95.2000000 0.010000 95.2027778 0.010000 95.2055556 0.010000 95.2083333 0.010000 95.2111111 0.010000 95.2138889 0.010000 95.2166667 0.010000 95.2194444 0.010000 95.2222222 0.010000 95.2250000 0.010000 95.2277778 0.010000 95.2305556 0.010000 95.2333333 0.010000 95.2361111 0.010000 95.2388889 0.010000 95.2416667 0.010000 95.2444444 0.010000 95.2472222 0.010000 95.2500000 0.010000 95.2527778 0.010000 95.2555556 0.010000 95.2583333 0.010000 95.2611111 0.010000 95.2638889 0.010000 95.2666667 0.010000 95.2694444 0.018077 95.2722222 0.035385 95.2750000 0.050962 95.2777778 0.050962 95.2805556 0.035385 95.2833333 0.010000 95.2861111 0.010000 95.2888889 0.010000 95.2916667 0.010000 95.2944444 0.010000 95.2972222 0.010000 95.3000000 0.019808 95.3027778 0.116731 95.3055556 0.217115 95.3083333 0.314038 95.3111111 0.405769 95.3138889 0.492308 95.3166667 0.566731 95.3194444 0.625577 95.3222222 0.665385 95.3250000 0.674038 95.3277778 0.658462 95.3305556 0.615192 95.3333333 0.547692 95.3361111 0.466346 95.3388889 0.376346 95.3416667 0.289808 95.3444444 0.217115 95.3472222 0.146154 95.3500000 0.071731 95.3527778 0.010000 95.3555556 0.010000 95.3583333 0.010000 95.3611111 0.010000 95.3638889 0.010000 95.3666667 0.010000 95.3694444 0.010000 95.3722222 0.010000 95.3750000 0.010000 95.3777778 0.010000 95.3805556 0.010000 95.3833333 0.010000 95.3861111 0.010000 95.3888889 0.010000 95.3916667 0.010000 95.3944444 0.010000 95.3972222 0.010000 95.4000000 0.010000 95.4027778 0.010000 95.4055556 0.010000 95.4083333 0.010000 95.4111111 0.010000 95.4138889 0.010000 95.4166667 0.010000 95.4194444 0.010000 95.4222222 0.010000 95.4250000 0.010000 95.4277778 0.010000 95.4305556 0.010000 95.4333333 0.010000 95.4361111 0.010000 95.4388889 0.010000 95.4416667 0.010000 95.4444444 0.010000 95.4472222 0.010000 95.4500000 0.010000 95.4527778 0.010000 95.4555556 0.010000 95.4583333 0.010000 95.4611111 0.010000 95.4638889 0.010000 95.4666667 0.010000 95.4694444 0.010000 95.4722222 0.010000 95.4750000 0.010000 95.4777778 0.010000 95.4805556 0.010000 95.4833333 0.010000 95.4861111 0.010000 95.4888889 0.010000 95.4916667 0.010000 95.4944444 0.010000 95.4972222 0.010000 95.5000000 0.010000 95.5027778 0.010000 95.5055556 0.010000 95.5083333 0.010000 95.5111111 0.010000 95.5138889 0.010000 95.5166667 0.010000 95.5194444 0.010000 95.5222222 0.010000 95.5250000 0.010000 95.5277778 0.010000 95.5305556 0.010000 95.5333333 0.010000 95.5361111 0.010000 95.5388889 0.010000 95.5416667 0.010000 95.5444444 0.010000 95.5472222 0.010000 95.5500000 0.010000 95.5527778 0.010000 95.5555556 0.010000 95.5583333 0.010000 95.5611111 0.010000 95.5638889 0.010000 95.5666667 0.010000 95.5694444 0.010000 95.5722222 0.010000 95.5750000 0.010000 95.5777778 0.010000 95.5805556 0.010000 95.5833333 0.010000 95.5861111 0.010000 95.5888889 0.010000 95.5916667 0.010000 95.5944444 0.010000 95.5972222 0.010000 95.6000000 0.010000 95.6027778 0.010000 95.6055556 0.010000 95.6083333 0.010000 95.6111111 0.010000 95.6138889 0.010000 95.6166667 0.010000 95.6194444 0.010000 95.6222222 0.010000 96.2916667 0.010000 96.2944444 0.010000 96.2972222 0.010000 96.3000000 0.010000 96.3027778 0.010000 96.3055556 0.010000 96.3083333 0.010000 96.3111111 0.010000 96.3138889 0.010000 96.3166667 0.010000 96.3194444 0.010000 96.3222222 0.010000 96.3250000 0.010000 96.3277778 0.010000 96.3305556 0.010000 96.3333333 0.010000 96.3361111 0.010000 96.3388889 0.010000 96.3416667 0.010000 96.3444444 0.010000 96.3472222 0.010000 96.3500000 0.010000 96.3527778 0.010000 96.3555556 0.010000 96.3583333 0.010000 96.3611111 0.010000 96.3638889 0.010000 96.3666667 0.010000 96.3694444 0.010000 96.3722222 0.010000 96.3750000 0.010000 96.3777778 0.010000 96.3805556 0.010000 96.3833333 0.010000 96.3861111 0.010000 96.3888889 0.010000 96.3916667 0.010000 96.3944444 0.010000 96.3972222 0.010000 96.4000000 0.010000 96.4027778 0.010000 96.4055556 0.010000 96.4083333 0.010000 96.4111111 0.010000 96.4138889 0.010000 96.4166667 0.010000 96.4194444 0.010000 96.4222222 0.010000 96.4250000 0.010000 96.4277778 0.010000 96.4305556 0.010000 96.4333333 0.010000 96.4361111 0.010000 96.4388889 0.010000 96.4416667 0.010000 96.4444444 0.010000 96.4472222 0.010000 96.4500000 0.010000 96.4527778 0.010000 96.4555556 0.010000 96.4583333 0.010000 96.4611111 0.010000 96.4638889 0.010000 96.4666667 0.010000 96.4694444 0.010000 96.4722222 0.010000 96.4750000 0.010000 96.4777778 0.010000 96.4805556 0.010000 96.4833333 0.033654 96.4861111 0.061346 96.4888889 0.082115 96.4916667 0.099423 96.4944444 0.097692 96.4972222 0.076923 96.5000000 0.040577 96.5027778 0.010000 96.5055556 0.010000 96.5083333 0.010000 96.5111111 0.010000 96.5138889 0.010000 96.5166667 0.075192 96.5194444 0.172115 96.5222222 0.269038 96.5250000 0.365962 96.5277778 0.449038 96.5305556 0.521731 96.5333333 0.589231 96.5361111 0.649808 96.5388889 0.686154 96.5416667 0.693077 96.5444444 0.675769 96.5472222 0.632500 96.5500000 0.563269 96.5527778 0.473269 96.5555556 0.374615 96.5583333 0.272500 96.5611111 0.182500 96.5638889 0.104615 96.5666667 0.030192 96.5694444 0.010000 96.5722222 0.010000 96.5750000 0.010000 96.5777778 0.010000 96.5805556 0.010000 96.5833333 0.010000 96.5861111 0.010000 96.5888889 0.010000 96.5916667 0.010000 96.5944444 0.010000 96.5972222 0.010000 96.6000000 0.010000 96.6027778 0.010000 96.6055556 0.010000 96.6083333 0.010000 96.6111111 0.010000 96.6138889 0.010000 96.6166667 0.010000 96.6194444 0.010000 96.6222222 0.010000 96.6250000 0.010000 96.6277778 0.010000 96.6305556 0.010000 96.6333333 0.010000 96.6361111 0.010000 96.6388889 0.010000 96.6416667 0.010000 96.6444444 0.010000 96.6472222 0.010000 96.6500000 0.010000 96.6527778 0.010000 96.6555556 0.010000 96.6583333 0.010000 96.6611111 0.010000 96.6638889 0.010000 96.6666667 0.010000 96.6694444 0.010000 96.6722222 0.010000 96.6750000 0.010000 96.6777778 0.010000 96.6805556 0.010000 96.6833333 0.010000 96.6861111 0.010000 96.6888889 0.010000 96.6916667 0.010000 96.6944444 0.010000 96.6972222 0.010000 96.7000000 0.010000 96.7027778 0.010000 96.7055556 0.010000 96.7083333 0.010000 96.7111111 0.010000 96.7138889 0.010000 96.7166667 0.010000 96.7194444 0.010000 96.7222222 0.010000 96.7250000 0.010000 96.7277778 0.010000 96.7305556 0.010000 96.7333333 0.010000 96.7361111 0.010000 96.7388889 0.010000 96.7416667 0.010000 96.7444444 0.010000 96.7472222 0.010000 96.7500000 0.010000 96.7527778 0.010000 96.7555556 0.010000 96.7583333 0.010000 96.7611111 0.010000 96.7638889 0.010000 96.7666667 0.010000 96.7694444 0.010000 96.7722222 0.010000 96.7750000 0.010000 96.7777778 0.010000 96.7805556 0.010000 96.7833333 0.010000 96.7861111 0.010000 96.7888889 0.010000 96.7916667 0.010000 96.7944444 0.010000 96.7972222 0.010000 96.8000000 0.010000 96.8027778 0.010000 96.8055556 0.010000 96.8083333 0.010000 96.8111111 0.010000 96.8138889 0.010000 96.8166667 0.010000 96.8194444 0.010000 96.8222222 0.010000 96.8250000 0.010000 96.8277778 0.010000 96.8305556 0.010000 96.8333333 0.010000 96.8361111 0.010000 96.8388889 0.010000 97.0416667 0.250000)
Vecg2 ecg_in_l1 0 PWL(0.0000000 0.250000 0.2500000 0.010000 0.2527778 0.010000 0.2555556 0.010000 0.2583333 0.010000 0.2611111 0.010000 0.2638889 0.010000 0.2666667 0.010000 0.2694444 0.010000 0.2722222 0.010000 0.2750000 0.010000 0.2777778 0.010000 0.2805556 0.010000 0.2833333 0.010000 0.2861111 0.010000 0.2888889 0.010000 0.2916667 0.010000 0.2944444 0.010000 0.2972222 0.010000 0.3000000 0.010000 0.3027778 0.010000 0.3055556 0.010000 0.3083333 0.010000 0.3111111 0.010000 0.3138889 0.010000 0.3166667 0.010000 0.3194444 0.010000 0.3222222 0.010000 0.3250000 0.010000 0.3277778 0.010000 0.3305556 0.010000 0.3333333 0.010000 0.3361111 0.010000 0.3388889 0.010000 0.3416667 0.010000 0.3444444 0.010000 0.3472222 0.010000 0.3500000 0.010000 0.3527778 0.010000 0.3555556 0.010000 0.3583333 0.010000 0.3611111 0.010000 0.3638889 0.010000 0.3666667 0.010000 0.3694444 0.010000 0.3722222 0.010000 0.3750000 0.010000 0.3777778 0.010000 0.3805556 0.010000 0.3833333 0.010000 0.3861111 0.010000 0.3888889 0.010000 0.3916667 0.010000 0.3944444 0.010000 0.3972222 0.010000 0.4000000 0.010000 0.4027778 0.010000 0.4055556 0.010000 0.4083333 0.010000 0.4111111 0.010000 0.4138889 0.010000 0.4166667 0.010000 0.4194444 0.010000 0.4222222 0.010000 0.4250000 0.010000 0.4277778 0.010000 0.4305556 0.010000 0.4333333 0.010000 0.4361111 0.044038 0.4388889 0.083846 0.4416667 0.108077 0.4444444 0.108077 0.4472222 0.085577 0.4500000 0.044038 0.4527778 0.010000 0.4555556 0.010000 0.4583333 0.010000 0.4611111 0.010000 0.4638889 0.010000 0.4666667 0.010000 0.4694444 0.010000 0.4722222 0.010000 0.4750000 0.010000 0.4777778 0.044038 0.4805556 0.078654 0.4833333 0.099423 0.4861111 0.111538 0.4888889 0.115000 0.4916667 0.111538 0.4944444 0.104615 0.4972222 0.087308 0.5000000 0.059615 0.5027778 0.023269 0.5055556 0.010000 0.5083333 0.010000 0.5111111 0.010000 0.5138889 0.010000 0.5166667 0.010000 0.5194444 0.010000 0.5222222 0.010000 0.5250000 0.010000 0.5277778 0.010000 0.5305556 0.010000 0.5333333 0.010000 0.5361111 0.010000 0.5388889 0.010000 0.5416667 0.010000 0.5444444 0.010000 0.5472222 0.010000 0.5500000 0.010000 0.5527778 0.010000 0.5555556 0.010000 0.5583333 0.010000 0.5611111 0.010000 0.5638889 0.010000 0.5666667 0.010000 0.5694444 0.014615 0.5722222 0.018077 0.5750000 0.023269 0.5777778 0.025000 0.5805556 0.019808 0.5833333 0.021538 0.5861111 0.019808 0.5888889 0.019808 0.5916667 0.021538 0.5944444 0.021538 0.5972222 0.021538 0.6000000 0.023269 0.6027778 0.026731 0.6055556 0.025000 0.6083333 0.033654 0.6111111 0.028462 0.6138889 0.028462 0.6166667 0.025000 0.6194444 0.023269 0.6222222 0.019808 0.6250000 0.018077 0.6277778 0.021538 0.6305556 0.018077 0.6333333 0.023269 0.6361111 0.019808 0.6388889 0.023269 0.6416667 0.025000 0.6444444 0.025000 0.6472222 0.025000 0.6500000 0.025000 0.6527778 0.021538 0.6555556 0.019808 0.6583333 0.016346 0.6611111 0.018077 0.6638889 0.019808 0.6666667 0.021538 0.6694444 0.023269 0.6722222 0.028462 0.6750000 0.030192 0.6777778 0.031923 0.6805556 0.025000 0.6833333 0.023269 0.6861111 0.019808 0.6888889 0.018077 0.6916667 0.010000 0.6944444 0.014615 0.6972222 0.014615 0.7000000 0.012885 0.7027778 0.016346 0.7055556 0.019808 0.7083333 0.021538 0.7111111 0.021538 0.7138889 0.016346 0.7166667 0.011154 0.7194444 0.010000 0.7222222 0.010000 0.7250000 0.010000 0.7277778 0.010000 0.7305556 0.010000 0.7333333 0.010000 0.7361111 0.010000 0.7388889 0.010000 0.7416667 0.010000 0.7444444 0.010000 0.7472222 0.010000 0.7500000 0.010000 0.7527778 0.010000 0.7555556 0.010000 0.7583333 0.010000 0.7611111 0.010000 0.7638889 0.010000 0.7666667 0.010000 0.7694444 0.010000 0.7722222 0.010000 0.7750000 0.010000 0.7777778 0.010000 0.7805556 0.010000 0.7833333 0.010000 0.7861111 0.010000 0.7888889 0.010000 0.7916667 0.010000 0.7944444 0.010000 0.7972222 0.010000 1.4638889 0.026731 1.4666667 0.025000 1.4694444 0.031923 1.4722222 0.035385 1.4750000 0.035385 1.4777778 0.037115 1.4805556 0.033654 1.4833333 0.030192 1.4861111 0.030192 1.4888889 0.030192 1.4916667 0.028462 1.4944444 0.028462 1.4972222 0.035385 1.5000000 0.035385 1.5027778 0.035385 1.5055556 0.035385 1.5083333 0.038846 1.5111111 0.035385 1.5138889 0.028462 1.5166667 0.035385 1.5194444 0.026731 1.5222222 0.028462 1.5250000 0.033654 1.5277778 0.035385 1.5305556 0.035385 1.5333333 0.037115 1.5361111 0.040577 1.5388889 0.045769 1.5416667 0.052692 1.5444444 0.049231 1.5472222 0.049231 1.5500000 0.045769 1.5527778 0.044038 1.5555556 0.040577 1.5583333 0.040577 1.5611111 0.042308 1.5638889 0.047500 1.5666667 0.049231 1.5694444 0.054423 1.5722222 0.056154 1.5750000 0.064808 1.5777778 0.064808 1.5805556 0.061346 1.5833333 0.063077 1.5861111 0.059615 1.5888889 0.052692 1.5916667 0.052692 1.5944444 0.052692 1.5972222 0.052692 1.6000000 0.049231 1.6027778 0.050962 1.6055556 0.049231 1.6083333 0.045769 1.6111111 0.045769 1.6138889 0.042308 1.6166667 0.042308 1.6194444 0.037115 1.6222222 0.038846 1.6250000 0.033654 1.6277778 0.033654 1.6305556 0.035385 1.6333333 0.037115 1.6361111 0.035385 1.6388889 0.033654 1.6416667 0.030192 1.6444444 0.028462 1.6472222 0.038846 1.6500000 0.073462 1.6527778 0.116731 1.6555556 0.154808 1.6583333 0.184231 1.6611111 0.187692 1.6638889 0.163462 1.6666667 0.109808 1.6694444 0.010000 1.6722222 0.010000 1.6750000 0.010000 1.6777778 0.010000 1.6805556 0.010000 1.6833333 0.010000 1.6861111 0.010000 1.6888889 0.010000 1.6916667 0.010000 1.6944444 0.047500 1.6972222 0.071731 1.7000000 0.083846 1.7027778 0.087308 1.7055556 0.090769 1.7083333 0.090769 1.7111111 0.078654 1.7138889 0.059615 1.7166667 0.047500 1.7194444 0.044038 1.7222222 0.045769 1.7250000 0.050962 1.7277778 0.054423 1.7305556 0.064808 1.7333333 0.073462 1.7361111 0.078654 1.7388889 0.078654 1.7416667 0.070000 1.7444444 0.050962 1.7472222 0.040577 1.7500000 0.031923 1.7527778 0.028462 1.7555556 0.035385 1.7583333 0.045769 1.7611111 0.061346 1.7638889 0.071731 1.7666667 0.080385 1.7694444 0.082115 1.7722222 0.094231 1.7750000 0.097692 1.7777778 0.101154 1.7805556 0.101154 1.7833333 0.102885 1.7861111 0.106346 1.7888889 0.101154 1.7916667 0.102885 1.7944444 0.099423 1.7972222 0.099423 1.8000000 0.108077 1.8027778 0.106346 1.8055556 0.109808 1.8083333 0.116731 1.8111111 0.120192 1.8138889 0.118462 1.8166667 0.116731 1.8194444 0.115000 1.8222222 0.109808 1.8250000 0.109808 1.8277778 0.109808 1.8305556 0.115000 1.8333333 0.115000 1.8361111 0.118462 1.8388889 0.123654 1.8416667 0.130577 1.8444444 0.125385 1.8472222 0.121923 1.8500000 0.121923 1.8527778 0.115000 1.8555556 0.116731 1.8583333 0.113269 1.8611111 0.113269 1.8638889 0.113269 1.8666667 0.116731 1.8694444 0.118462 1.8722222 0.123654 1.8750000 0.127115 1.8777778 0.128846 1.8805556 0.127115 1.8833333 0.118462 1.8861111 0.113269 1.8888889 0.111538 1.8916667 0.108077 1.8944444 0.109808 1.8972222 0.111538 1.9000000 0.116731 1.9027778 0.116731 1.9055556 0.116731 1.9083333 0.118462 1.9111111 0.113269 1.9138889 0.113269 1.9166667 0.108077 1.9194444 0.102885 1.9222222 0.097692 1.9250000 0.095962 1.9277778 0.092500 1.9305556 0.097692 1.9333333 0.095962 1.9361111 0.094231 1.9388889 0.094231 1.9416667 0.092500 1.9444444 0.090769 1.9472222 0.087308 1.9500000 0.082115 1.9527778 0.076923 1.9555556 0.071731 1.9583333 0.068269 1.9611111 0.070000 1.9638889 0.064808 1.9666667 0.059615 1.9694444 0.061346 1.9722222 0.059615 1.9750000 0.059615 1.9777778 0.052692 1.9805556 0.050962 1.9833333 0.047500 1.9861111 0.042308 1.9888889 0.037115 1.9916667 0.037115 1.9944444 0.035385 1.9972222 0.031923 2.0000000 0.028462 2.0027778 0.031923 2.0055556 0.030192 2.0083333 0.030192 2.0111111 0.028462 2.7277778 0.099423 2.7305556 0.102885 2.7333333 0.106346 2.7361111 0.102885 2.7388889 0.109808 2.7416667 0.111538 2.7444444 0.113269 2.7472222 0.108077 2.7500000 0.113269 2.7527778 0.108077 2.7555556 0.102885 2.7583333 0.102885 2.7611111 0.099423 2.7638889 0.102885 2.7666667 0.104615 2.7694444 0.104615 2.7722222 0.109808 2.7750000 0.115000 2.7777778 0.109808 2.7805556 0.111538 2.7833333 0.109808 2.7861111 0.109808 2.7888889 0.108077 2.7916667 0.102885 2.7944444 0.101154 2.7972222 0.099423 2.8000000 0.102885 2.8027778 0.108077 2.8055556 0.111538 2.8083333 0.115000 2.8111111 0.116731 2.8138889 0.116731 2.8166667 0.115000 2.8194444 0.115000 2.8222222 0.108077 2.8250000 0.102885 2.8277778 0.106346 2.8305556 0.109808 2.8333333 0.115000 2.8361111 0.120192 2.8388889 0.132308 2.8416667 0.134038 2.8444444 0.139231 2.8472222 0.132308 2.8500000 0.125385 2.8527778 0.123654 2.8555556 0.120192 2.8583333 0.116731 2.8611111 0.111538 2.8638889 0.109808 2.8666667 0.106346 2.8694444 0.106346 2.8722222 0.111538 2.8750000 0.113269 2.8777778 0.113269 2.8805556 0.111538 2.8833333 0.104615 2.8861111 0.104615 2.8888889 0.102885 2.8916667 0.099423 2.8944444 0.097692 2.8972222 0.094231 2.9000000 0.094231 2.9027778 0.092500 2.9055556 0.087308 2.9083333 0.094231 2.9111111 0.118462 2.9138889 0.156538 2.9166667 0.194615 2.9194444 0.222308 2.9222222 0.241346 2.9250000 0.232692 2.9277778 0.194615 2.9305556 0.134038 2.9333333 0.042308 2.9361111 0.010000 2.9388889 0.010000 2.9416667 0.010000 2.9444444 0.010000 2.9472222 0.010000 2.9500000 0.010000 2.9527778 0.082115 2.9555556 0.147885 2.9583333 0.194615 2.9611111 0.224038 2.9638889 0.237885 2.9666667 0.248269 2.9694444 0.246538 2.9722222 0.237885 2.9750000 0.220577 2.9777778 0.185962 2.9805556 0.153077 2.9833333 0.128846 2.9861111 0.104615 2.9888889 0.094231 2.9916667 0.099423 2.9944444 0.102885 2.9972222 0.116731 3.0000000 0.125385 3.0027778 0.127115 3.0055556 0.111538 3.0083333 0.097692 3.0111111 0.083846 3.0138889 0.075192 3.0166667 0.078654 3.0194444 0.083846 3.0222222 0.095962 3.0250000 0.104615 3.0277778 0.115000 3.0305556 0.128846 3.0333333 0.142692 3.0361111 0.142692 3.0388889 0.156538 3.0416667 0.158269 3.0444444 0.156538 3.0472222 0.151346 3.0500000 0.147885 3.0527778 0.149615 3.0555556 0.142692 3.0583333 0.144423 3.0611111 0.144423 3.0638889 0.144423 3.0666667 0.151346 3.0694444 0.151346 3.0722222 0.160000 3.0750000 0.158269 3.0777778 0.158269 3.0805556 0.158269 3.0833333 0.156538 3.0861111 0.151346 3.0888889 0.151346 3.0916667 0.147885 3.0944444 0.151346 3.0972222 0.151346 3.1000000 0.154808 3.1027778 0.156538 3.1055556 0.163462 3.1083333 0.161731 3.1111111 0.166923 3.1138889 0.161731 3.1166667 0.160000 3.1194444 0.156538 3.1222222 0.154808 3.1250000 0.156538 3.1277778 0.156538 3.1305556 0.156538 3.1333333 0.165192 3.1361111 0.161731 3.1388889 0.163462 3.1416667 0.161731 3.1444444 0.163462 3.1472222 0.161731 3.1500000 0.160000 3.1527778 0.153077 3.1555556 0.154808 3.1583333 0.151346 3.1611111 0.153077 3.1638889 0.147885 3.1666667 0.149615 3.1694444 0.151346 3.1722222 0.149615 3.1750000 0.149615 3.1777778 0.147885 3.1805556 0.147885 3.1833333 0.147885 3.1861111 0.142692 3.1888889 0.137500 3.1916667 0.134038 3.1944444 0.128846 3.1972222 0.127115 3.2000000 0.130577 3.2027778 0.130577 3.2055556 0.132308 3.2083333 0.132308 3.2111111 0.130577 3.2138889 0.128846 3.2166667 0.121923 3.2194444 0.113269 3.2222222 0.106346 3.2250000 0.101154 3.2277778 0.095962 3.2305556 0.095962 3.2333333 0.094231 3.2361111 0.095962 3.2388889 0.099423 3.2416667 0.101154 3.2444444 0.095962 3.2472222 0.094231 3.2500000 0.089038 3.2527778 0.089038 3.2555556 0.080385 3.2583333 0.076923 3.2611111 0.073462 3.2638889 0.070000 3.2666667 0.066538 3.2694444 0.070000 3.2722222 0.073462 3.2750000 0.076923 3.9527778 0.118462 3.9555556 0.115000 3.9583333 0.116731 3.9611111 0.111538 3.9638889 0.115000 3.9666667 0.116731 3.9694444 0.115000 3.9722222 0.120192 3.9750000 0.121923 3.9777778 0.121923 3.9805556 0.120192 3.9833333 0.116731 3.9861111 0.115000 3.9888889 0.109808 3.9916667 0.108077 3.9944444 0.109808 3.9972222 0.115000 4.0000000 0.116731 4.0027778 0.118462 4.0055556 0.118462 4.0083333 0.120192 4.0111111 0.125385 4.0138889 0.121923 4.0166667 0.120192 4.0194444 0.116731 4.0222222 0.116731 4.0250000 0.115000 4.0277778 0.115000 4.0305556 0.115000 4.0333333 0.120192 4.0361111 0.118462 4.0388889 0.127115 4.0416667 0.128846 4.0444444 0.134038 4.0472222 0.134038 4.0500000 0.134038 4.0527778 0.135769 4.0555556 0.130577 4.0583333 0.130577 4.0611111 0.127115 4.0638889 0.125385 4.0666667 0.121923 4.0694444 0.127115 4.0722222 0.123654 4.0750000 0.123654 4.0777778 0.123654 4.0805556 0.115000 4.0833333 0.109808 4.0861111 0.101154 4.0888889 0.101154 4.0916667 0.104615 4.0944444 0.097692 4.0972222 0.104615 4.1000000 0.104615 4.1027778 0.106346 4.1055556 0.106346 4.1083333 0.109808 4.1111111 0.102885 4.1138889 0.102885 4.1166667 0.097692 4.1194444 0.087308 4.1222222 0.082115 4.1250000 0.082115 4.1277778 0.097692 4.1305556 0.128846 4.1333333 0.170385 4.1361111 0.211923 4.1388889 0.243077 4.1416667 0.262115 4.1444444 0.262115 4.1472222 0.239615 4.1500000 0.184231 4.1527778 0.104615 4.1555556 0.010000 4.1583333 0.010000 4.1611111 0.010000 4.1638889 0.010000 4.1666667 0.010000 4.1694444 0.010000 4.1722222 0.010000 4.1750000 0.010000 4.1777778 0.030192 4.1805556 0.070000 4.1833333 0.099423 4.1861111 0.113269 4.1888889 0.123654 4.1916667 0.127115 4.1944444 0.130577 4.1972222 0.127115 4.2000000 0.120192 4.2027778 0.108077 4.2055556 0.102885 4.2083333 0.104615 4.2111111 0.113269 4.2138889 0.116731 4.2166667 0.118462 4.2194444 0.121923 4.2222222 0.125385 4.2250000 0.125385 4.2277778 0.121923 4.2305556 0.111538 4.2333333 0.101154 4.2361111 0.092500 4.2388889 0.083846 4.2416667 0.080385 4.2444444 0.087308 4.2472222 0.095962 4.2500000 0.104615 4.2527778 0.115000 4.2555556 0.123654 4.2583333 0.130577 4.2611111 0.134038 4.2638889 0.139231 4.2666667 0.142692 4.2694444 0.153077 4.2722222 0.158269 4.2750000 0.160000 4.2777778 0.156538 4.2805556 0.158269 4.2833333 0.154808 4.2861111 0.151346 4.2888889 0.147885 4.2916667 0.147885 4.2944444 0.146154 4.2972222 0.147885 4.3000000 0.147885 4.3027778 0.153077 4.3055556 0.153077 4.3083333 0.156538 4.3111111 0.160000 4.3138889 0.163462 4.3166667 0.158269 4.3194444 0.154808 4.3222222 0.153077 4.3250000 0.147885 4.3277778 0.147885 4.3305556 0.146154 4.3333333 0.153077 4.3361111 0.156538 4.3388889 0.160000 4.3416667 0.161731 4.3444444 0.165192 4.3472222 0.165192 4.3500000 0.158269 4.3527778 0.153077 4.3555556 0.149615 4.3583333 0.147885 4.3611111 0.151346 4.3638889 0.151346 4.3666667 0.153077 4.3694444 0.156538 4.3722222 0.156538 4.3750000 0.153077 4.3777778 0.153077 4.3805556 0.151346 4.3833333 0.154808 4.3861111 0.149615 4.3888889 0.147885 4.3916667 0.144423 4.3944444 0.140962 4.3972222 0.142692 4.4000000 0.147885 4.4027778 0.149615 4.4055556 0.149615 4.4083333 0.151346 4.4111111 0.154808 4.4138889 0.146154 4.4166667 0.139231 4.4194444 0.134038 4.4222222 0.132308 4.4250000 0.130577 4.4277778 0.127115 4.4305556 0.127115 4.4333333 0.127115 4.4361111 0.132308 4.4388889 0.128846 4.4416667 0.127115 4.4444444 0.116731 4.4472222 0.118462 4.4500000 0.113269 4.4527778 0.108077 4.4555556 0.101154 4.4583333 0.097692 4.4611111 0.092500 4.4638889 0.087308 4.4666667 0.090769 4.4694444 0.089038 4.4722222 0.087308 4.4750000 0.085577 4.4777778 0.082115 4.4805556 0.076923 4.4833333 0.071731 4.4861111 0.063077 4.4888889 0.061346 4.4916667 0.052692 4.4944444 0.054423 4.4972222 0.049231 4.5000000 0.049231 5.1250000 0.057885 5.1277778 0.057885 5.1305556 0.059615 5.1333333 0.057885 5.1361111 0.063077 5.1388889 0.066538 5.1416667 0.070000 5.1444444 0.066538 5.1472222 0.063077 5.1500000 0.057885 5.1527778 0.057885 5.1555556 0.056154 5.1583333 0.054423 5.1611111 0.054423 5.1638889 0.056154 5.1666667 0.059615 5.1694444 0.057885 5.1722222 0.061346 5.1750000 0.061346 5.1777778 0.066538 5.1805556 0.064808 5.1833333 0.068269 5.1861111 0.064808 5.1888889 0.064808 5.1916667 0.064808 5.1944444 0.063077 5.1972222 0.061346 5.2000000 0.066538 5.2027778 0.063077 5.2055556 0.064808 5.2083333 0.066538 5.2111111 0.068269 5.2138889 0.064808 5.2166667 0.064808 5.2194444 0.063077 5.2222222 0.063077 5.2250000 0.063077 5.2277778 0.066538 5.2305556 0.064808 5.2333333 0.064808 5.2361111 0.073462 5.2388889 0.078654 5.2416667 0.082115 5.2444444 0.082115 5.2472222 0.087308 5.2500000 0.080385 5.2527778 0.080385 5.2555556 0.070000 5.2583333 0.070000 5.2611111 0.059615 5.2638889 0.057885 5.2666667 0.057885 5.2694444 0.059615 5.2722222 0.052692 5.2750000 0.056154 5.2777778 0.057885 5.2805556 0.054423 5.2833333 0.054423 5.2861111 0.052692 5.2888889 0.052692 5.2916667 0.044038 5.2944444 0.044038 5.2972222 0.037115 5.3000000 0.033654 5.3027778 0.031923 5.3055556 0.038846 5.3083333 0.056154 5.3111111 0.092500 5.3138889 0.128846 5.3166667 0.163462 5.3194444 0.184231 5.3222222 0.184231 5.3250000 0.163462 5.3277778 0.108077 5.3305556 0.023269 5.3333333 0.010000 5.3361111 0.010000 5.3388889 0.010000 5.3416667 0.010000 5.3444444 0.010000 5.3472222 0.010000 5.3500000 0.019808 5.3527778 0.089038 5.3555556 0.135769 5.3583333 0.172115 5.3611111 0.184231 5.3638889 0.194615 5.3666667 0.198077 5.3694444 0.194615 5.3722222 0.180769 5.3750000 0.149615 5.3777778 0.116731 5.3805556 0.083846 5.3833333 0.064808 5.3861111 0.047500 5.3888889 0.044038 5.3916667 0.049231 5.3944444 0.059615 5.3972222 0.073462 5.4000000 0.078654 5.4027778 0.071731 5.4055556 0.063077 5.4083333 0.042308 5.4111111 0.028462 5.4138889 0.026731 5.4166667 0.025000 5.4194444 0.038846 5.4222222 0.042308 5.4250000 0.054423 5.4277778 0.066538 5.4305556 0.071731 5.4333333 0.078654 5.4361111 0.087308 5.4388889 0.095962 5.4416667 0.099423 5.4444444 0.106346 5.4472222 0.106346 5.4500000 0.104615 5.4527778 0.104615 5.4555556 0.102885 5.4583333 0.102885 5.4611111 0.102885 5.4638889 0.101154 5.4666667 0.108077 5.4694444 0.109808 5.4722222 0.109808 5.4750000 0.111538 5.4777778 0.118462 5.4805556 0.113269 5.4833333 0.115000 5.4861111 0.113269 5.4888889 0.109808 5.4916667 0.109808 5.4944444 0.109808 5.4972222 0.108077 5.5000000 0.111538 5.5027778 0.111538 5.5055556 0.120192 5.5083333 0.120192 5.5111111 0.123654 5.5138889 0.121923 5.5166667 0.120192 5.5194444 0.115000 5.5222222 0.109808 5.5250000 0.106346 5.5277778 0.104615 5.5305556 0.108077 5.5333333 0.109808 5.5361111 0.115000 5.5388889 0.113269 5.5416667 0.115000 5.5444444 0.120192 5.5472222 0.115000 5.5500000 0.113269 5.5527778 0.106346 5.5555556 0.102885 5.5583333 0.099423 5.5611111 0.095962 5.5638889 0.097692 5.5666667 0.097692 5.5694444 0.101154 5.5722222 0.101154 5.5750000 0.106346 5.5777778 0.106346 5.5805556 0.101154 5.5833333 0.095962 5.5861111 0.090769 5.5888889 0.089038 5.5916667 0.087308 5.5944444 0.082115 5.5972222 0.078654 5.6000000 0.083846 5.6027778 0.083846 5.6055556 0.082115 5.6083333 0.082115 5.6111111 0.085577 5.6138889 0.080385 5.6166667 0.076923 5.6194444 0.068269 5.6222222 0.066538 5.6250000 0.064808 5.6277778 0.057885 5.6305556 0.054423 5.6333333 0.054423 5.6361111 0.056154 5.6388889 0.057885 5.6416667 0.056154 5.6444444 0.050962 5.6472222 0.047500 5.6500000 0.045769 5.6527778 0.038846 5.6555556 0.033654 5.6583333 0.030192 5.6611111 0.028462 5.6638889 0.026731 5.6666667 0.030192 5.6694444 0.028462 5.6722222 0.028462 6.3388889 0.071731 6.3416667 0.075192 6.3444444 0.076923 6.3472222 0.071731 6.3500000 0.070000 6.3527778 0.068269 6.3555556 0.073462 6.3583333 0.066538 6.3611111 0.066538 6.3638889 0.068269 6.3666667 0.070000 6.3694444 0.066538 6.3722222 0.070000 6.3750000 0.075192 6.3777778 0.075192 6.3805556 0.073462 6.3833333 0.076923 6.3861111 0.075192 6.3888889 0.075192 6.3916667 0.070000 6.3944444 0.070000 6.3972222 0.071731 6.4000000 0.073462 6.4027778 0.071731 6.4055556 0.075192 6.4083333 0.076923 6.4111111 0.083846 6.4138889 0.080385 6.4166667 0.076923 6.4194444 0.078654 6.4222222 0.078654 6.4250000 0.080385 6.4277778 0.080385 6.4305556 0.082115 6.4333333 0.085577 6.4361111 0.085577 6.4388889 0.089038 6.4416667 0.094231 6.4444444 0.095962 6.4472222 0.097692 6.4500000 0.095962 6.4527778 0.094231 6.4555556 0.089038 6.4583333 0.087308 6.4611111 0.080385 6.4638889 0.080385 6.4666667 0.080385 6.4694444 0.078654 6.4722222 0.073462 6.4750000 0.075192 6.4777778 0.082115 6.4805556 0.085577 6.4833333 0.080385 6.4861111 0.071731 6.4888889 0.071731 6.4916667 0.068269 6.4944444 0.066538 6.4972222 0.064808 6.5000000 0.068269 6.5027778 0.066538 6.5055556 0.066538 6.5083333 0.064808 6.5111111 0.059615 6.5138889 0.050962 6.5166667 0.054423 6.5194444 0.066538 6.5222222 0.095962 6.5250000 0.134038 6.5277778 0.175577 6.5305556 0.205000 6.5333333 0.217115 6.5361111 0.213654 6.5388889 0.175577 6.5416667 0.099423 6.5444444 0.010000 6.5472222 0.010000 6.5500000 0.010000 6.5527778 0.010000 6.5555556 0.010000 6.5583333 0.010000 6.5611111 0.010000 6.5638889 0.010000 6.5666667 0.037115 6.5694444 0.076923 6.5722222 0.101154 6.5750000 0.106346 6.5777778 0.108077 6.5805556 0.109808 6.5833333 0.102885 6.5861111 0.090769 6.5888889 0.075192 6.5916667 0.064808 6.5944444 0.068269 6.5972222 0.073462 6.6000000 0.082115 6.6027778 0.089038 6.6055556 0.101154 6.6083333 0.102885 6.6111111 0.104615 6.6138889 0.099423 6.6166667 0.082115 6.6194444 0.068269 6.6222222 0.054423 6.6250000 0.044038 6.6277778 0.044038 6.6305556 0.050962 6.6333333 0.068269 6.6361111 0.083846 6.6388889 0.095962 6.6416667 0.102885 6.6444444 0.111538 6.6472222 0.111538 6.6500000 0.115000 6.6527778 0.118462 6.6555556 0.118462 6.6583333 0.120192 6.6611111 0.118462 6.6638889 0.120192 6.6666667 0.120192 6.6694444 0.127115 6.6722222 0.132308 6.6750000 0.127115 6.6777778 0.128846 6.6805556 0.132308 6.6833333 0.132308 6.6861111 0.130577 6.6888889 0.130577 6.6916667 0.127115 6.6944444 0.134038 6.6972222 0.128846 6.7000000 0.128846 6.7027778 0.128846 6.7055556 0.132308 6.7083333 0.137500 6.7111111 0.139231 6.7138889 0.139231 6.7166667 0.139231 6.7194444 0.135769 6.7222222 0.130577 6.7250000 0.127115 6.7277778 0.128846 6.7305556 0.123654 6.7333333 0.128846 6.7361111 0.134038 6.7388889 0.132308 6.7416667 0.137500 6.7444444 0.137500 6.7472222 0.135769 6.7500000 0.134038 6.7527778 0.130577 6.7555556 0.128846 6.7583333 0.125385 6.7611111 0.125385 6.7638889 0.120192 6.7666667 0.120192 6.7694444 0.120192 6.7722222 0.120192 6.7750000 0.123654 6.7777778 0.120192 6.7805556 0.120192 6.7833333 0.115000 6.7861111 0.109808 6.7888889 0.104615 6.7916667 0.108077 6.7944444 0.099423 6.7972222 0.102885 6.8000000 0.102885 6.8027778 0.101154 6.8055556 0.101154 6.8083333 0.101154 6.8111111 0.099423 6.8138889 0.092500 6.8166667 0.090769 6.8194444 0.087308 6.8222222 0.076923 6.8250000 0.073462 6.8277778 0.071731 6.8305556 0.070000 6.8333333 0.068269 6.8361111 0.068269 6.8388889 0.066538 6.8416667 0.063077 6.8444444 0.064808 6.8472222 0.056154 6.8500000 0.050962 6.8527778 0.045769 6.8555556 0.042308 6.8583333 0.038846 6.8611111 0.033654 6.8638889 0.033654 6.8666667 0.035385 6.8694444 0.035385 6.8722222 0.033654 6.8750000 0.030192 6.8777778 0.026731 6.8805556 0.023269 6.8833333 0.019808 6.8861111 0.016346 7.4833333 0.070000 7.4861111 0.068269 7.4888889 0.066538 7.4916667 0.063077 7.4944444 0.063077 7.4972222 0.064808 7.5000000 0.066538 7.5027778 0.064808 7.5055556 0.070000 7.5083333 0.073462 7.5111111 0.073462 7.5138889 0.071731 7.5166667 0.068269 7.5194444 0.066538 7.5222222 0.064808 7.5250000 0.063077 7.5277778 0.061346 7.5305556 0.063077 7.5333333 0.061346 7.5361111 0.068269 7.5388889 0.076923 7.5416667 0.080385 7.5444444 0.082115 7.5472222 0.075192 7.5500000 0.075192 7.5527778 0.075192 7.5555556 0.073462 7.5583333 0.075192 7.5611111 0.068269 7.5638889 0.066538 7.5666667 0.071731 7.5694444 0.076923 7.5722222 0.075192 7.5750000 0.082115 7.5777778 0.082115 7.5805556 0.083846 7.5833333 0.083846 7.5861111 0.082115 7.5888889 0.085577 7.5916667 0.087308 7.5944444 0.092500 7.5972222 0.094231 7.6000000 0.090769 7.6027778 0.092500 7.6055556 0.092500 7.6083333 0.089038 7.6111111 0.090769 7.6138889 0.085577 7.6166667 0.080385 7.6194444 0.073462 7.6222222 0.073462 7.6250000 0.070000 7.6277778 0.070000 7.6305556 0.070000 7.6333333 0.073462 7.6361111 0.068269 7.6388889 0.073462 7.6416667 0.076923 7.6444444 0.078654 7.6472222 0.075192 7.6500000 0.071731 7.6527778 0.066538 7.6555556 0.056154 7.6583333 0.049231 7.6611111 0.042308 7.6638889 0.045769 7.6666667 0.064808 7.6694444 0.095962 7.6722222 0.137500 7.6750000 0.180769 7.6777778 0.208462 7.6805556 0.208462 7.6833333 0.192885 7.6861111 0.147885 7.6888889 0.061346 7.6916667 0.010000 7.6944444 0.010000 7.6972222 0.010000 7.7000000 0.010000 7.7027778 0.010000 7.7055556 0.010000 7.7083333 0.035385 7.7111111 0.120192 7.7138889 0.175577 7.7166667 0.213654 7.7194444 0.227500 7.7222222 0.232692 7.7250000 0.224038 7.7277778 0.205000 7.7305556 0.168654 7.7333333 0.135769 7.7361111 0.113269 7.7388889 0.094231 7.7416667 0.083846 7.7444444 0.078654 7.7472222 0.085577 7.7500000 0.090769 7.7527778 0.099423 7.7555556 0.099423 7.7583333 0.090769 7.7611111 0.075192 7.7638889 0.059615 7.7666667 0.045769 7.7694444 0.047500 7.7722222 0.049231 7.7750000 0.061346 7.7777778 0.075192 7.7805556 0.083846 7.7833333 0.092500 7.7861111 0.101154 7.7888889 0.104615 7.7916667 0.109808 7.7944444 0.116731 7.7972222 0.123654 7.8000000 0.123654 7.8027778 0.128846 7.8055556 0.127115 7.8083333 0.132308 7.8111111 0.137500 7.8138889 0.135769 7.8166667 0.134038 7.8194444 0.130577 7.8222222 0.135769 7.8250000 0.135769 7.8277778 0.130577 7.8305556 0.130577 7.8333333 0.134038 7.8361111 0.139231 7.8388889 0.137500 7.8416667 0.142692 7.8444444 0.139231 7.8472222 0.144423 7.8500000 0.140962 7.8527778 0.146154 7.8555556 0.139231 7.8583333 0.140962 7.8611111 0.139231 7.8638889 0.140962 7.8666667 0.142692 7.8694444 0.140962 7.8722222 0.144423 7.8750000 0.144423 7.8777778 0.147885 7.8805556 0.147885 7.8833333 0.147885 7.8861111 0.144423 7.8888889 0.140962 7.8916667 0.139231 7.8944444 0.135769 7.8972222 0.135769 7.9000000 0.139231 7.9027778 0.139231 7.9055556 0.142692 7.9083333 0.142692 7.9111111 0.139231 7.9138889 0.142692 7.9166667 0.142692 7.9194444 0.139231 7.9222222 0.139231 7.9250000 0.134038 7.9277778 0.130577 7.9305556 0.128846 7.9333333 0.127115 7.9361111 0.130577 7.9388889 0.132308 7.9416667 0.130577 7.9444444 0.132308 7.9472222 0.130577 7.9500000 0.127115 7.9527778 0.125385 7.9555556 0.116731 7.9583333 0.113269 7.9611111 0.111538 7.9638889 0.106346 7.9666667 0.111538 7.9694444 0.106346 7.9722222 0.108077 7.9750000 0.108077 7.9777778 0.109808 7.9805556 0.101154 7.9833333 0.097692 7.9861111 0.092500 7.9888889 0.082115 7.9916667 0.078654 7.9944444 0.075192 7.9972222 0.076923 8.0000000 0.076923 8.0027778 0.078654 8.0055556 0.078654 8.0083333 0.082115 8.0111111 0.080385 8.0138889 0.082115 8.0166667 0.076923 8.0194444 0.071731 8.0222222 0.068269 8.0250000 0.063077 8.0277778 0.061346 8.0305556 0.057885 8.7000000 0.102885 8.7027778 0.108077 8.7055556 0.108077 8.7083333 0.111538 8.7111111 0.113269 8.7138889 0.111538 8.7166667 0.108077 8.7194444 0.104615 8.7222222 0.101154 8.7250000 0.099423 8.7277778 0.094231 8.7305556 0.101154 8.7333333 0.095962 8.7361111 0.101154 8.7388889 0.097692 8.7416667 0.101154 8.7444444 0.104615 8.7472222 0.108077 8.7500000 0.108077 8.7527778 0.101154 8.7555556 0.102885 8.7583333 0.095962 8.7611111 0.099423 8.7638889 0.097692 8.7666667 0.097692 8.7694444 0.102885 8.7722222 0.102885 8.7750000 0.104615 8.7777778 0.108077 8.7805556 0.109808 8.7833333 0.109808 8.7861111 0.113269 8.7888889 0.109808 8.7916667 0.109808 8.7944444 0.108077 8.7972222 0.109808 8.8000000 0.109808 8.8027778 0.118462 8.8055556 0.121923 8.8083333 0.118462 8.8111111 0.120192 8.8138889 0.125385 8.8166667 0.120192 8.8194444 0.118462 8.8222222 0.108077 8.8250000 0.102885 8.8277778 0.092500 8.8305556 0.092500 8.8333333 0.092500 8.8361111 0.095962 8.8388889 0.099423 8.8416667 0.101154 8.8444444 0.104615 8.8472222 0.102885 8.8500000 0.104615 8.8527778 0.099423 8.8555556 0.095962 8.8583333 0.092500 8.8611111 0.095962 8.8638889 0.092500 8.8666667 0.094231 8.8694444 0.089038 8.8722222 0.087308 8.8750000 0.085577 8.8777778 0.097692 8.8805556 0.123654 8.8833333 0.154808 8.8861111 0.191154 8.8888889 0.225769 8.8916667 0.236154 8.8944444 0.230962 8.8972222 0.210192 8.9000000 0.165192 8.9027778 0.087308 8.9055556 0.010000 8.9083333 0.010000 8.9111111 0.010000 8.9138889 0.010000 8.9166667 0.010000 8.9194444 0.010000 8.9222222 0.010000 8.9250000 0.010000 8.9277778 0.057885 8.9305556 0.097692 8.9333333 0.121923 8.9361111 0.130577 8.9388889 0.140962 8.9416667 0.144423 8.9444444 0.139231 8.9472222 0.121923 8.9500000 0.113269 8.9527778 0.101154 8.9555556 0.104615 8.9583333 0.109808 8.9611111 0.115000 8.9638889 0.121923 8.9666667 0.128846 8.9694444 0.130577 8.9722222 0.130577 8.9750000 0.121923 8.9777778 0.109808 8.9805556 0.090769 8.9833333 0.080385 8.9861111 0.076923 8.9888889 0.075192 8.9916667 0.083846 8.9944444 0.095962 8.9972222 0.111538 9.0000000 0.116731 9.0027778 0.127115 9.0055556 0.139231 9.0083333 0.144423 9.0111111 0.151346 9.0138889 0.153077 9.0166667 0.154808 9.0194444 0.153077 9.0222222 0.151346 9.0250000 0.149615 9.0277778 0.146154 9.0305556 0.147885 9.0333333 0.151346 9.0361111 0.149615 9.0388889 0.158269 9.0416667 0.158269 9.0444444 0.160000 9.0472222 0.158269 9.0500000 0.160000 9.0527778 0.156538 9.0555556 0.158269 9.0583333 0.160000 9.0611111 0.158269 9.0638889 0.154808 9.0666667 0.160000 9.0694444 0.160000 9.0722222 0.163462 9.0750000 0.165192 9.0777778 0.165192 9.0805556 0.166923 9.0833333 0.163462 9.0861111 0.166923 9.0888889 0.160000 9.0916667 0.156538 9.0944444 0.158269 9.0972222 0.156538 9.1000000 0.154808 9.1027778 0.153077 9.1055556 0.165192 9.1083333 0.165192 9.1111111 0.165192 9.1138889 0.165192 9.1166667 0.160000 9.1194444 0.160000 9.1222222 0.158269 9.1250000 0.156538 9.1277778 0.149615 9.1305556 0.151346 9.1333333 0.147885 9.1361111 0.147885 9.1388889 0.153077 9.1416667 0.149615 9.1444444 0.154808 9.1472222 0.154808 9.1500000 0.149615 9.1527778 0.147885 9.1555556 0.147885 9.1583333 0.139231 9.1611111 0.139231 9.1638889 0.137500 9.1666667 0.135769 9.1694444 0.140962 9.1722222 0.137500 9.1750000 0.135769 9.1777778 0.134038 9.1805556 0.132308 9.1833333 0.132308 9.1861111 0.125385 9.1888889 0.115000 9.1916667 0.113269 9.1944444 0.102885 9.1972222 0.102885 9.2000000 0.101154 9.2027778 0.102885 9.2055556 0.099423 9.2083333 0.101154 9.2111111 0.097692 9.2138889 0.092500 9.2166667 0.085577 9.2194444 0.083846 9.2222222 0.076923 9.2250000 0.071731 9.2277778 0.064808 9.2305556 0.063077 9.2333333 0.061346 9.2361111 0.064808 9.2388889 0.063077 9.2416667 0.061346 9.2444444 0.059615 9.2472222 0.056154 9.8722222 0.092500 9.8750000 0.092500 9.8777778 0.090769 9.8805556 0.094231 9.8833333 0.095962 9.8861111 0.092500 9.8888889 0.090769 9.8916667 0.089038 9.8944444 0.089038 9.8972222 0.085577 9.9000000 0.087308 9.9027778 0.089038 9.9055556 0.094231 9.9083333 0.092500 9.9111111 0.090769 9.9138889 0.090769 9.9166667 0.090769 9.9194444 0.090769 9.9222222 0.085577 9.9250000 0.085577 9.9277778 0.089038 9.9305556 0.087308 9.9333333 0.090769 9.9361111 0.090769 9.9388889 0.094231 9.9416667 0.095962 9.9444444 0.099423 9.9472222 0.099423 9.9500000 0.095962 9.9527778 0.090769 9.9555556 0.092500 9.9583333 0.090769 9.9611111 0.082115 9.9638889 0.087308 9.9666667 0.089038 9.9694444 0.090769 9.9722222 0.097692 9.9750000 0.106346 9.9777778 0.109808 9.9805556 0.113269 9.9833333 0.109808 9.9861111 0.108077 9.9888889 0.101154 9.9916667 0.095962 9.9944444 0.089038 9.9972222 0.092500 10.0000000 0.087308 10.0027778 0.092500 10.0055556 0.089038 10.0083333 0.089038 10.0111111 0.094231 10.0138889 0.089038 10.0166667 0.090769 10.0194444 0.089038 10.0222222 0.080385 10.0250000 0.075192 10.0277778 0.076923 10.0305556 0.080385 10.0333333 0.078654 10.0361111 0.078654 10.0388889 0.083846 10.0416667 0.078654 10.0444444 0.070000 10.0472222 0.066538 10.0500000 0.063077 10.0527778 0.066538 10.0555556 0.092500 10.0583333 0.125385 10.0611111 0.161731 10.0638889 0.191154 10.0666667 0.208462 10.0694444 0.201538 10.0722222 0.179038 10.0750000 0.113269 10.0777778 0.026731 10.0805556 0.010000 10.0833333 0.010000 10.0861111 0.010000 10.0888889 0.010000 10.0916667 0.010000 10.0944444 0.010000 10.0972222 0.049231 10.1000000 0.118462 10.1027778 0.173846 10.1055556 0.206731 10.1083333 0.225769 10.1111111 0.234423 10.1138889 0.234423 10.1166667 0.230962 10.1194444 0.206731 10.1222222 0.180769 10.1250000 0.144423 10.1277778 0.115000 10.1305556 0.099423 10.1333333 0.087308 10.1361111 0.083846 10.1388889 0.085577 10.1416667 0.094231 10.1444444 0.109808 10.1472222 0.115000 10.1500000 0.109808 10.1527778 0.095962 10.1555556 0.080385 10.1583333 0.057885 10.1611111 0.047500 10.1638889 0.049231 10.1666667 0.059615 10.1694444 0.070000 10.1722222 0.087308 10.1750000 0.104615 10.1777778 0.115000 10.1805556 0.121923 10.1833333 0.127115 10.1861111 0.127115 10.1888889 0.125385 10.1916667 0.128846 10.1944444 0.125385 10.1972222 0.130577 10.2000000 0.127115 10.2027778 0.132308 10.2055556 0.132308 10.2083333 0.137500 10.2111111 0.140962 10.2138889 0.142692 10.2166667 0.144423 10.2194444 0.144423 10.2222222 0.137500 10.2250000 0.137500 10.2277778 0.134038 10.2305556 0.132308 10.2333333 0.139231 10.2361111 0.135769 10.2388889 0.142692 10.2416667 0.142692 10.2444444 0.142692 10.2472222 0.139231 10.2500000 0.139231 10.2527778 0.137500 10.2555556 0.132308 10.2583333 0.130577 10.2611111 0.128846 10.2638889 0.128846 10.2666667 0.128846 10.2694444 0.132308 10.2722222 0.134038 10.2750000 0.139231 10.2777778 0.137500 10.2805556 0.137500 10.2833333 0.135769 10.2861111 0.134038 10.2888889 0.123654 10.2916667 0.123654 10.2944444 0.120192 10.2972222 0.116731 10.3000000 0.123654 10.3027778 0.125385 10.3055556 0.125385 10.3083333 0.128846 10.3111111 0.128846 10.3138889 0.127115 10.3166667 0.120192 10.3194444 0.120192 10.3222222 0.111538 10.3250000 0.108077 10.3277778 0.108077 10.3305556 0.108077 10.3333333 0.106346 10.3361111 0.104615 10.3388889 0.111538 10.3416667 0.106346 10.3444444 0.108077 10.3472222 0.108077 10.3500000 0.102885 10.3527778 0.092500 10.3555556 0.089038 10.3583333 0.083846 10.3611111 0.078654 10.3638889 0.076923 10.3666667 0.076923 10.3694444 0.075192 10.3722222 0.075192 10.3750000 0.076923 10.3777778 0.075192 10.3805556 0.073462 10.3833333 0.070000 10.3861111 0.066538 10.3888889 0.061346 10.3916667 0.054423 10.3944444 0.050962 10.3972222 0.049231 10.4000000 0.050962 10.4027778 0.054423 10.4055556 0.054423 10.4083333 0.056154 10.4111111 0.056154 10.4138889 0.056154 10.4166667 0.059615 10.4194444 0.057885 11.0972222 0.073462 11.1000000 0.076923 11.1027778 0.078654 11.1055556 0.080385 11.1083333 0.082115 11.1111111 0.087308 11.1138889 0.087308 11.1166667 0.085577 11.1194444 0.080385 11.1222222 0.080385 11.1250000 0.075192 11.1277778 0.071731 11.1305556 0.076923 11.1333333 0.071731 11.1361111 0.073462 11.1388889 0.075192 11.1416667 0.076923 11.1444444 0.082115 11.1472222 0.083846 11.1500000 0.082115 11.1527778 0.082115 11.1555556 0.076923 11.1583333 0.070000 11.1611111 0.070000 11.1638889 0.070000 11.1666667 0.071731 11.1694444 0.075192 11.1722222 0.078654 11.1750000 0.083846 11.1777778 0.083846 11.1805556 0.087308 11.1833333 0.083846 11.1861111 0.083846 11.1888889 0.078654 11.1916667 0.082115 11.1944444 0.075192 11.1972222 0.080385 11.2000000 0.090769 11.2027778 0.090769 11.2055556 0.099423 11.2083333 0.099423 11.2111111 0.099423 11.2138889 0.095962 11.2166667 0.090769 11.2194444 0.087308 11.2222222 0.075192 11.2250000 0.073462 11.2277778 0.064808 11.2305556 0.066538 11.2333333 0.068269 11.2361111 0.068269 11.2388889 0.071731 11.2416667 0.078654 11.2444444 0.078654 11.2472222 0.078654 11.2500000 0.075192 11.2527778 0.071731 11.2555556 0.066538 11.2583333 0.066538 11.2611111 0.059615 11.2638889 0.050962 11.2666667 0.049231 11.2694444 0.047500 11.2722222 0.047500 11.2750000 0.066538 11.2777778 0.092500 11.2805556 0.134038 11.2833333 0.172115 11.2861111 0.199808 11.2888889 0.213654 11.2916667 0.208462 11.2944444 0.184231 11.2972222 0.128846 11.3000000 0.050962 11.3027778 0.010000 11.3055556 0.010000 11.3083333 0.010000 11.3111111 0.010000 11.3138889 0.010000 11.3166667 0.010000 11.3194444 0.010000 11.3222222 0.010000 11.3250000 0.047500 11.3277778 0.089038 11.3305556 0.106346 11.3333333 0.113269 11.3361111 0.116731 11.3388889 0.118462 11.3416667 0.116731 11.3444444 0.108077 11.3472222 0.090769 11.3500000 0.080385 11.3527778 0.083846 11.3555556 0.089038 11.3583333 0.087308 11.3611111 0.092500 11.3638889 0.097692 11.3666667 0.095962 11.3694444 0.095962 11.3722222 0.082115 11.3750000 0.070000 11.3777778 0.057885 11.3805556 0.044038 11.3833333 0.044038 11.3861111 0.049231 11.3888889 0.059615 11.3916667 0.070000 11.3944444 0.076923 11.3972222 0.085577 11.4000000 0.092500 11.4027778 0.097692 11.4055556 0.102885 11.4083333 0.109808 11.4111111 0.109808 11.4138889 0.111538 11.4166667 0.109808 11.4194444 0.106346 11.4222222 0.104615 11.4250000 0.102885 11.4277778 0.102885 11.4305556 0.102885 11.4333333 0.102885 11.4361111 0.104615 11.4388889 0.109808 11.4416667 0.111538 11.4444444 0.115000 11.4472222 0.115000 11.4500000 0.109808 11.4527778 0.113269 11.4555556 0.109808 11.4583333 0.106346 11.4611111 0.104615 11.4638889 0.104615 11.4666667 0.108077 11.4694444 0.109808 11.4722222 0.116731 11.4750000 0.118462 11.4777778 0.115000 11.4805556 0.123654 11.4833333 0.109808 11.4861111 0.113269 11.4888889 0.109808 11.4916667 0.104615 11.4944444 0.106346 11.4972222 0.102885 11.5000000 0.108077 11.5027778 0.106346 11.5055556 0.113269 11.5083333 0.115000 11.5111111 0.113269 11.5138889 0.115000 11.5166667 0.109808 11.5194444 0.109808 11.5222222 0.106346 11.5250000 0.104615 11.5277778 0.102885 11.5305556 0.101154 11.5333333 0.104615 11.5361111 0.106346 11.5388889 0.108077 11.5416667 0.108077 11.5444444 0.106346 11.5472222 0.108077 11.5500000 0.106346 11.5527778 0.101154 11.5555556 0.095962 11.5583333 0.094231 11.5611111 0.089038 11.5638889 0.085577 11.5666667 0.087308 11.5694444 0.087308 11.5722222 0.087308 11.5750000 0.085577 11.5777778 0.087308 11.5805556 0.085577 11.5833333 0.076923 11.5861111 0.076923 11.5888889 0.068269 11.5916667 0.068269 11.5944444 0.061346 11.5972222 0.057885 11.6000000 0.056154 11.6027778 0.056154 11.6055556 0.056154 11.6083333 0.052692 11.6111111 0.052692 11.6138889 0.052692 11.6166667 0.047500 11.6194444 0.044038 11.6222222 0.033654 11.6250000 0.028462 11.6277778 0.023269 11.6305556 0.021538 11.6333333 0.018077 11.6361111 0.019808 11.6388889 0.023269 11.6416667 0.023269 11.6444444 0.025000 12.2666667 0.038846 12.2694444 0.045769 12.2722222 0.049231 12.2750000 0.049231 12.2777778 0.050962 12.2805556 0.050962 12.2833333 0.049231 12.2861111 0.049231 12.2888889 0.045769 12.2916667 0.044038 12.2944444 0.040577 12.2972222 0.037115 12.3000000 0.037115 12.3027778 0.040577 12.3055556 0.044038 12.3083333 0.042308 12.3111111 0.050962 12.3138889 0.047500 12.3166667 0.049231 12.3194444 0.045769 12.3222222 0.054423 12.3250000 0.054423 12.3277778 0.052692 12.3305556 0.047500 12.3333333 0.049231 12.3361111 0.050962 12.3388889 0.052692 12.3416667 0.054423 12.3444444 0.059615 12.3472222 0.061346 12.3500000 0.059615 12.3527778 0.061346 12.3555556 0.052692 12.3583333 0.050962 12.3611111 0.050962 12.3638889 0.050962 12.3666667 0.049231 12.3694444 0.052692 12.3722222 0.061346 12.3750000 0.066538 12.3777778 0.068269 12.3805556 0.073462 12.3833333 0.073462 12.3861111 0.076923 12.3888889 0.071731 12.3916667 0.063077 12.3944444 0.061346 12.3972222 0.052692 12.4000000 0.049231 12.4027778 0.047500 12.4055556 0.052692 12.4083333 0.050962 12.4111111 0.054423 12.4138889 0.054423 12.4166667 0.050962 12.4194444 0.052692 12.4222222 0.047500 12.4250000 0.044038 12.4277778 0.040577 12.4305556 0.040577 12.4333333 0.035385 12.4361111 0.035385 12.4388889 0.031923 12.4416667 0.028462 12.4444444 0.035385 12.4472222 0.054423 12.4500000 0.080385 12.4527778 0.116731 12.4555556 0.149615 12.4583333 0.175577 12.4611111 0.177308 12.4638889 0.160000 12.4666667 0.116731 12.4694444 0.040577 12.4722222 0.010000 12.4750000 0.010000 12.4777778 0.010000 12.4805556 0.010000 12.4833333 0.010000 12.4861111 0.010000 12.4888889 0.010000 12.4916667 0.042308 12.4944444 0.094231 12.4972222 0.130577 12.5000000 0.161731 12.5027778 0.172115 12.5055556 0.180769 12.5083333 0.189423 12.5111111 0.191154 12.5138889 0.179038 12.5166667 0.154808 12.5194444 0.118462 12.5222222 0.087308 12.5250000 0.061346 12.5277778 0.040577 12.5305556 0.031923 12.5333333 0.042308 12.5361111 0.052692 12.5388889 0.070000 12.5416667 0.075192 12.5444444 0.078654 12.5472222 0.063077 12.5500000 0.045769 12.5527778 0.026731 12.5555556 0.016346 12.5583333 0.016346 12.5611111 0.019808 12.5638889 0.033654 12.5666667 0.045769 12.5694444 0.056154 12.5722222 0.068269 12.5750000 0.073462 12.5777778 0.080385 12.5805556 0.089038 12.5833333 0.090769 12.5861111 0.090769 12.5888889 0.089038 12.5916667 0.094231 12.5944444 0.089038 12.5972222 0.089038 12.6000000 0.090769 12.6027778 0.092500 12.6055556 0.090769 12.6083333 0.094231 12.6111111 0.095962 12.6138889 0.099423 12.6166667 0.099423 12.6194444 0.102885 12.6222222 0.099423 12.6250000 0.095962 12.6277778 0.097692 12.6305556 0.090769 12.6333333 0.092500 12.6361111 0.094231 12.6388889 0.097692 12.6416667 0.102885 12.6444444 0.104615 12.6472222 0.108077 12.6500000 0.102885 12.6527778 0.099423 12.6555556 0.095962 12.6583333 0.092500 12.6611111 0.089038 12.6638889 0.090769 12.6666667 0.089038 12.6694444 0.094231 12.6722222 0.094231 12.6750000 0.097692 12.6777778 0.097692 12.6805556 0.099423 12.6833333 0.101154 12.6861111 0.095962 12.6888889 0.090769 12.6916667 0.092500 12.6944444 0.087308 12.6972222 0.082115 12.7000000 0.087308 12.7027778 0.085577 12.7055556 0.087308 12.7083333 0.087308 12.7111111 0.089038 12.7138889 0.092500 12.7166667 0.089038 12.7194444 0.083846 12.7222222 0.076923 12.7250000 0.073462 12.7277778 0.070000 12.7305556 0.068269 12.7333333 0.075192 12.7361111 0.071731 12.7388889 0.071731 12.7416667 0.070000 12.7444444 0.068269 12.7472222 0.066538 12.7500000 0.068269 12.7527778 0.063077 12.7555556 0.056154 12.7583333 0.052692 12.7611111 0.049231 12.7638889 0.047500 12.7666667 0.044038 12.7694444 0.045769 12.7722222 0.047500 12.7750000 0.038846 12.7777778 0.038846 12.7805556 0.037115 12.7833333 0.031923 12.7861111 0.030192 12.7888889 0.019808 12.7916667 0.018077 12.7944444 0.018077 12.7972222 0.014615 12.8000000 0.010000 12.8027778 0.011154 12.8055556 0.012885 12.8083333 0.019808 12.8111111 0.018077 12.8138889 0.023269 13.5138889 0.078654 13.5166667 0.075192 13.5194444 0.073462 13.5222222 0.071731 13.5250000 0.070000 13.5277778 0.064808 13.5305556 0.064808 13.5333333 0.066538 13.5361111 0.068269 13.5388889 0.070000 13.5416667 0.075192 13.5444444 0.076923 13.5472222 0.078654 13.5500000 0.076923 13.5527778 0.075192 13.5555556 0.073462 13.5583333 0.070000 13.5611111 0.064808 13.5638889 0.068269 13.5666667 0.073462 13.5694444 0.073462 13.5722222 0.075192 13.5750000 0.078654 13.5777778 0.080385 13.5805556 0.082115 13.5833333 0.078654 13.5861111 0.076923 13.5888889 0.076923 13.5916667 0.076923 13.5944444 0.071731 13.5972222 0.073462 13.6000000 0.071731 13.6027778 0.075192 13.6055556 0.083846 13.6083333 0.089038 13.6111111 0.092500 13.6138889 0.097692 13.6166667 0.095962 13.6194444 0.089038 13.6222222 0.087308 13.6250000 0.078654 13.6277778 0.073462 13.6305556 0.068269 13.6333333 0.068269 13.6361111 0.064808 13.6388889 0.063077 13.6416667 0.061346 13.6444444 0.066538 13.6472222 0.064808 13.6500000 0.070000 13.6527778 0.068269 13.6555556 0.064808 13.6583333 0.061346 13.6611111 0.057885 13.6638889 0.059615 13.6666667 0.057885 13.6694444 0.059615 13.6722222 0.056154 13.6750000 0.049231 13.6777778 0.047500 13.6805556 0.042308 13.6833333 0.045769 13.6861111 0.070000 13.6888889 0.095962 13.6916667 0.132308 13.6944444 0.166923 13.6972222 0.187692 13.7000000 0.198077 13.7027778 0.191154 13.7055556 0.177308 13.7083333 0.139231 13.7111111 0.076923 13.7138889 0.010000 13.7166667 0.010000 13.7194444 0.010000 13.7222222 0.010000 13.7250000 0.010000 13.7277778 0.010000 13.7305556 0.010000 13.7333333 0.010000 13.7361111 0.014615 13.7388889 0.070000 13.7416667 0.113269 13.7444444 0.142692 13.7472222 0.161731 13.7500000 0.160000 13.7527778 0.163462 13.7555556 0.147885 13.7583333 0.121923 13.7611111 0.099423 13.7638889 0.078654 13.7666667 0.068269 13.7694444 0.068269 13.7722222 0.075192 13.7750000 0.082115 13.7777778 0.089038 13.7805556 0.097692 13.7833333 0.097692 13.7861111 0.097692 13.7888889 0.087308 13.7916667 0.071731 13.7944444 0.056154 13.7972222 0.038846 13.8000000 0.026731 13.8027778 0.025000 13.8055556 0.031923 13.8083333 0.045769 13.8111111 0.059615 13.8138889 0.073462 13.8166667 0.082115 13.8194444 0.087308 13.8222222 0.090769 13.8250000 0.092500 13.8277778 0.094231 13.8305556 0.095962 13.8333333 0.094231 13.8361111 0.094231 13.8388889 0.104615 13.8416667 0.106346 13.8444444 0.111538 13.8472222 0.109808 13.8500000 0.108077 13.8527778 0.104615 13.8555556 0.104615 13.8583333 0.101154 13.8611111 0.102885 13.8638889 0.099423 13.8666667 0.102885 13.8694444 0.106346 13.8722222 0.115000 13.8750000 0.115000 13.8777778 0.115000 13.8805556 0.120192 13.8833333 0.116731 13.8861111 0.116731 13.8888889 0.113269 13.8916667 0.111538 13.8944444 0.111538 13.8972222 0.111538 13.9000000 0.108077 13.9027778 0.108077 13.9055556 0.118462 13.9083333 0.118462 13.9111111 0.125385 13.9138889 0.121923 13.9166667 0.121923 13.9194444 0.116731 13.9222222 0.115000 13.9250000 0.109808 13.9277778 0.113269 13.9305556 0.109808 13.9333333 0.116731 13.9361111 0.120192 13.9388889 0.120192 13.9416667 0.121923 13.9444444 0.123654 13.9472222 0.121923 13.9500000 0.116731 13.9527778 0.113269 13.9555556 0.115000 13.9583333 0.109808 13.9611111 0.104615 13.9638889 0.108077 13.9666667 0.108077 13.9694444 0.108077 13.9722222 0.106346 13.9750000 0.109808 13.9777778 0.102885 13.9805556 0.106346 13.9833333 0.106346 13.9861111 0.101154 13.9888889 0.095962 13.9916667 0.092500 13.9944444 0.085577 13.9972222 0.082115 14.0000000 0.078654 14.0027778 0.082115 14.0055556 0.080385 14.0083333 0.082115 14.0111111 0.080385 14.0138889 0.083846 14.0166667 0.073462 14.0194444 0.073462 14.0222222 0.066538 14.0250000 0.059615 14.0277778 0.057885 14.0305556 0.049231 14.0333333 0.045769 14.0361111 0.049231 14.0388889 0.044038 14.0416667 0.042308 14.0444444 0.044038 14.0472222 0.040577 14.0500000 0.040577 14.0527778 0.033654 14.0555556 0.030192 14.0583333 0.031923 14.0611111 0.028462 14.7055556 0.068269 14.7083333 0.071731 14.7111111 0.070000 14.7138889 0.073462 14.7166667 0.071731 14.7194444 0.071731 14.7222222 0.068269 14.7250000 0.064808 14.7277778 0.066538 14.7305556 0.061346 14.7333333 0.066538 14.7361111 0.066538 14.7388889 0.071731 14.7416667 0.070000 14.7444444 0.068269 14.7472222 0.068269 14.7500000 0.070000 14.7527778 0.068269 14.7555556 0.064808 14.7583333 0.064808 14.7611111 0.066538 14.7638889 0.068269 14.7666667 0.061346 14.7694444 0.073462 14.7722222 0.071731 14.7750000 0.073462 14.7777778 0.073462 14.7805556 0.071731 14.7833333 0.073462 14.7861111 0.068269 14.7888889 0.066538 14.7916667 0.063077 14.7944444 0.064808 14.7972222 0.066538 14.8000000 0.070000 14.8027778 0.070000 14.8055556 0.078654 14.8083333 0.073462 14.8111111 0.080385 14.8138889 0.080385 14.8166667 0.076923 14.8194444 0.082115 14.8222222 0.087308 14.8250000 0.087308 14.8277778 0.087308 14.8305556 0.083846 14.8333333 0.078654 14.8361111 0.078654 14.8388889 0.078654 14.8416667 0.076923 14.8444444 0.075192 14.8472222 0.075192 14.8500000 0.071731 14.8527778 0.066538 14.8555556 0.066538 14.8583333 0.064808 14.8611111 0.059615 14.8638889 0.057885 14.8666667 0.057885 14.8694444 0.057885 14.8722222 0.059615 14.8750000 0.056154 14.8777778 0.057885 14.8805556 0.054423 14.8833333 0.044038 14.8861111 0.038846 14.8888889 0.045769 14.8916667 0.063077 14.8944444 0.097692 14.8972222 0.140962 14.9000000 0.179038 14.9027778 0.198077 14.9055556 0.201538 14.9083333 0.170385 14.9111111 0.102885 14.9138889 0.010000 14.9166667 0.010000 14.9194444 0.010000 14.9222222 0.010000 14.9250000 0.010000 14.9277778 0.010000 14.9305556 0.010000 14.9333333 0.010000 14.9361111 0.068269 14.9388889 0.115000 14.9416667 0.144423 14.9444444 0.156538 14.9472222 0.161731 14.9500000 0.151346 14.9527778 0.140962 14.9555556 0.111538 14.9583333 0.089038 14.9611111 0.064808 14.9638889 0.049231 14.9666667 0.045769 14.9694444 0.056154 14.9722222 0.066538 14.9750000 0.082115 14.9777778 0.090769 14.9805556 0.087308 14.9833333 0.071731 14.9861111 0.054423 14.9888889 0.040577 14.9916667 0.035385 14.9944444 0.035385 14.9972222 0.049231 15.0000000 0.063077 15.0027778 0.073462 15.0055556 0.089038 15.0083333 0.097692 15.0111111 0.106346 15.0138889 0.115000 15.0166667 0.111538 15.0194444 0.109808 15.0222222 0.108077 15.0250000 0.109808 15.0277778 0.101154 15.0305556 0.104615 15.0333333 0.101154 15.0361111 0.101154 15.0388889 0.102885 15.0416667 0.108077 15.0444444 0.115000 15.0472222 0.115000 15.0500000 0.118462 15.0527778 0.116731 15.0555556 0.113269 15.0583333 0.111538 15.0611111 0.109808 15.0638889 0.108077 15.0666667 0.109808 15.0694444 0.106346 15.0722222 0.111538 15.0750000 0.116731 15.0777778 0.121923 15.0805556 0.123654 15.0833333 0.127115 15.0861111 0.118462 15.0888889 0.113269 15.0916667 0.111538 15.0944444 0.109808 15.0972222 0.104615 15.1000000 0.108077 15.1027778 0.111538 15.1055556 0.115000 15.1083333 0.116731 15.1111111 0.116731 15.1138889 0.113269 15.1166667 0.111538 15.1194444 0.109808 15.1222222 0.104615 15.1250000 0.101154 15.1277778 0.106346 15.1305556 0.102885 15.1333333 0.099423 15.1361111 0.099423 15.1388889 0.102885 15.1416667 0.102885 15.1444444 0.102885 15.1472222 0.102885 15.1500000 0.102885 15.1527778 0.094231 15.1555556 0.089038 15.1583333 0.087308 15.1611111 0.089038 15.1638889 0.089038 15.1666667 0.087308 15.1694444 0.089038 15.1722222 0.089038 15.1750000 0.083846 15.1777778 0.080385 15.1805556 0.080385 15.1833333 0.080385 15.1861111 0.073462 15.1888889 0.068269 15.1916667 0.068269 15.1944444 0.057885 15.1972222 0.057885 15.2000000 0.056154 15.2027778 0.049231 15.2055556 0.044038 15.2083333 0.044038 15.2111111 0.044038 15.2138889 0.040577 15.2166667 0.042308 15.2194444 0.038846 15.2222222 0.035385 15.2250000 0.030192 15.2277778 0.023269 15.2305556 0.025000 15.2333333 0.018077 15.2361111 0.016346 15.2388889 0.018077 15.2416667 0.014615 15.2444444 0.021538 15.2472222 0.019808 15.2500000 0.019808 15.2527778 0.018077 15.9388889 0.061346 15.9416667 0.064808 15.9444444 0.063077 15.9472222 0.071731 15.9500000 0.068269 15.9527778 0.063077 15.9555556 0.063077 15.9583333 0.054423 15.9611111 0.057885 15.9638889 0.054423 15.9666667 0.057885 15.9694444 0.061346 15.9722222 0.059615 15.9750000 0.061346 15.9777778 0.059615 15.9805556 0.061346 15.9833333 0.064808 15.9861111 0.061346 15.9888889 0.061346 15.9916667 0.057885 15.9944444 0.050962 15.9972222 0.052692 16.0000000 0.056154 16.0027778 0.061346 16.0055556 0.059615 16.0083333 0.063077 16.0111111 0.070000 16.0138889 0.068269 16.0166667 0.070000 16.0194444 0.066538 16.0222222 0.063077 16.0250000 0.059615 16.0277778 0.061346 16.0305556 0.059615 16.0333333 0.061346 16.0361111 0.068269 16.0388889 0.073462 16.0416667 0.076923 16.0444444 0.082115 16.0472222 0.082115 16.0500000 0.085577 16.0527778 0.083846 16.0555556 0.076923 16.0583333 0.073462 16.0611111 0.063077 16.0638889 0.064808 16.0666667 0.059615 16.0694444 0.057885 16.0722222 0.054423 16.0750000 0.054423 16.0777778 0.056154 16.0805556 0.061346 16.0833333 0.057885 16.0861111 0.057885 16.0888889 0.056154 16.0916667 0.052692 16.0944444 0.050962 16.0972222 0.047500 16.1000000 0.042308 16.1027778 0.040577 16.1055556 0.035385 16.1083333 0.030192 16.1111111 0.033654 16.1138889 0.045769 16.1166667 0.071731 16.1194444 0.109808 16.1222222 0.144423 16.1250000 0.165192 16.1277778 0.177308 16.1305556 0.172115 16.1333333 0.151346 16.1361111 0.106346 16.1388889 0.033654 16.1416667 0.010000 16.1444444 0.010000 16.1472222 0.010000 16.1500000 0.010000 16.1527778 0.010000 16.1555556 0.010000 16.1583333 0.010000 16.1611111 0.012885 16.1638889 0.071731 16.1666667 0.120192 16.1694444 0.146154 16.1722222 0.168654 16.1750000 0.179038 16.1777778 0.184231 16.1805556 0.179038 16.1833333 0.161731 16.1861111 0.130577 16.1888889 0.099423 16.1916667 0.070000 16.1944444 0.057885 16.1972222 0.054423 16.2000000 0.054423 16.2027778 0.059615 16.2055556 0.073462 16.2083333 0.083846 16.2111111 0.089038 16.2138889 0.082115 16.2166667 0.070000 16.2194444 0.049231 16.2222222 0.030192 16.2250000 0.018077 16.2277778 0.016346 16.2305556 0.028462 16.2333333 0.035385 16.2361111 0.052692 16.2388889 0.063077 16.2416667 0.076923 16.2444444 0.089038 16.2472222 0.097692 16.2500000 0.101154 16.2527778 0.104615 16.2555556 0.104615 16.2583333 0.101154 16.2611111 0.102885 16.2638889 0.097692 16.2666667 0.097692 16.2694444 0.102885 16.2722222 0.108077 16.2750000 0.111538 16.2777778 0.111538 16.2805556 0.115000 16.2833333 0.121923 16.2861111 0.115000 16.2888889 0.109808 16.2916667 0.109808 16.2944444 0.108077 16.2972222 0.111538 16.3000000 0.109808 16.3027778 0.111538 16.3055556 0.111538 16.3083333 0.116731 16.3111111 0.118462 16.3138889 0.116731 16.3166667 0.120192 16.3194444 0.121923 16.3222222 0.116731 16.3250000 0.111538 16.3277778 0.113269 16.3305556 0.108077 16.3333333 0.108077 16.3361111 0.109808 16.3388889 0.108077 16.3416667 0.111538 16.3444444 0.113269 16.3472222 0.115000 16.3500000 0.120192 16.3527778 0.115000 16.3555556 0.116731 16.3583333 0.109808 16.3611111 0.108077 16.3638889 0.106346 16.3666667 0.102885 16.3694444 0.104615 16.3722222 0.106346 16.3750000 0.106346 16.3777778 0.106346 16.3805556 0.115000 16.3833333 0.111538 16.3861111 0.111538 16.3888889 0.106346 16.3916667 0.099423 16.3944444 0.095962 16.3972222 0.090769 16.4000000 0.090769 16.4027778 0.090769 16.4055556 0.094231 16.4083333 0.095962 16.4111111 0.099423 16.4138889 0.099423 16.4166667 0.095962 16.4194444 0.097692 16.4222222 0.090769 16.4250000 0.082115 16.4277778 0.075192 16.4305556 0.070000 16.4333333 0.066538 16.4361111 0.066538 16.4388889 0.068269 16.4416667 0.070000 16.4444444 0.063077 16.4472222 0.066538 16.4500000 0.064808 16.4527778 0.057885 16.4555556 0.052692 16.4583333 0.047500 16.4611111 0.042308 16.4638889 0.042308 16.4666667 0.035385 16.4694444 0.031923 16.4722222 0.031923 16.4750000 0.035385 16.4777778 0.037115 16.4805556 0.033654 16.4833333 0.033654 16.4861111 0.033654 17.1416667 0.075192 17.1444444 0.076923 17.1472222 0.080385 17.1500000 0.080385 17.1527778 0.078654 17.1555556 0.076923 17.1583333 0.075192 17.1611111 0.071731 17.1638889 0.068269 17.1666667 0.068269 17.1694444 0.068269 17.1722222 0.070000 17.1750000 0.064808 17.1777778 0.073462 17.1805556 0.071731 17.1833333 0.075192 17.1861111 0.080385 17.1888889 0.076923 17.1916667 0.078654 17.1944444 0.070000 17.1972222 0.066538 17.2000000 0.070000 17.2027778 0.073462 17.2055556 0.078654 17.2083333 0.078654 17.2111111 0.080385 17.2138889 0.083846 17.2166667 0.087308 17.2194444 0.080385 17.2222222 0.082115 17.2250000 0.076923 17.2277778 0.082115 17.2305556 0.078654 17.2333333 0.073462 17.2361111 0.078654 17.2388889 0.085577 17.2416667 0.095962 17.2444444 0.101154 17.2472222 0.102885 17.2500000 0.102885 17.2527778 0.095962 17.2555556 0.092500 17.2583333 0.089038 17.2611111 0.078654 17.2638889 0.076923 17.2666667 0.076923 17.2694444 0.071731 17.2722222 0.071731 17.2750000 0.071731 17.2777778 0.071731 17.2805556 0.076923 17.2833333 0.071731 17.2861111 0.080385 17.2888889 0.073462 17.2916667 0.070000 17.2944444 0.063077 17.2972222 0.063077 17.3000000 0.063077 17.3027778 0.059615 17.3055556 0.056154 17.3083333 0.050962 17.3111111 0.049231 17.3138889 0.050962 17.3166667 0.068269 17.3194444 0.099423 17.3222222 0.137500 17.3250000 0.170385 17.3277778 0.201538 17.3305556 0.211923 17.3333333 0.205000 17.3361111 0.175577 17.3388889 0.125385 17.3416667 0.044038 17.3444444 0.010000 17.3472222 0.010000 17.3500000 0.010000 17.3527778 0.010000 17.3555556 0.010000 17.3583333 0.010000 17.3611111 0.010000 17.3638889 0.010000 17.3666667 0.035385 17.3694444 0.076923 17.3722222 0.109808 17.3750000 0.128846 17.3777778 0.139231 17.3805556 0.146154 17.3833333 0.151346 17.3861111 0.146154 17.3888889 0.127115 17.3916667 0.099423 17.3944444 0.075192 17.3972222 0.059615 17.4000000 0.054423 17.4027778 0.052692 17.4055556 0.061346 17.4083333 0.076923 17.4111111 0.087308 17.4138889 0.094231 17.4166667 0.092500 17.4194444 0.082115 17.4222222 0.064808 17.4250000 0.050962 17.4277778 0.038846 17.4305556 0.035385 17.4333333 0.042308 17.4361111 0.054423 17.4388889 0.064808 17.4416667 0.080385 17.4444444 0.083846 17.4472222 0.092500 17.4500000 0.101154 17.4527778 0.102885 17.4555556 0.106346 17.4583333 0.106346 17.4611111 0.102885 17.4638889 0.106346 17.4666667 0.106346 17.4694444 0.108077 17.4722222 0.111538 17.4750000 0.111538 17.4777778 0.116731 17.4805556 0.116731 17.4833333 0.121923 17.4861111 0.118462 17.4888889 0.113269 17.4916667 0.111538 17.4944444 0.113269 17.4972222 0.106346 17.5000000 0.109808 17.5027778 0.106346 17.5055556 0.115000 17.5083333 0.115000 17.5111111 0.116731 17.5138889 0.120192 17.5166667 0.120192 17.5194444 0.116731 17.5222222 0.118462 17.5250000 0.113269 17.5277778 0.111538 17.5305556 0.111538 17.5333333 0.109808 17.5361111 0.111538 17.5388889 0.109808 17.5416667 0.113269 17.5444444 0.118462 17.5472222 0.120192 17.5500000 0.121923 17.5527778 0.118462 17.5555556 0.118462 17.5583333 0.115000 17.5611111 0.116731 17.5638889 0.108077 17.5666667 0.106346 17.5694444 0.101154 17.5722222 0.104615 17.5750000 0.106346 17.5777778 0.111538 17.5805556 0.111538 17.5833333 0.115000 17.5861111 0.111538 17.5888889 0.108077 17.5916667 0.099423 17.5944444 0.090769 17.5972222 0.087308 17.6000000 0.089038 17.6027778 0.090769 17.6055556 0.094231 17.6083333 0.092500 17.6111111 0.097692 17.6138889 0.095962 17.6166667 0.089038 17.6194444 0.089038 17.6222222 0.080385 17.6250000 0.076923 17.6277778 0.071731 17.6305556 0.064808 17.6333333 0.066538 17.6361111 0.063077 17.6388889 0.064808 17.6416667 0.059615 17.6444444 0.063077 17.6472222 0.063077 17.6500000 0.059615 17.6527778 0.047500 17.6555556 0.047500 17.6583333 0.037115 17.6611111 0.030192 17.6638889 0.025000 17.6666667 0.023269 17.6694444 0.018077 17.6722222 0.016346 17.6750000 0.019808 17.6777778 0.016346 17.6805556 0.019808 17.6833333 0.011154 17.6861111 0.010000 17.6888889 0.010000 18.3611111 0.018077 18.3638889 0.014615 18.3666667 0.014615 18.3694444 0.018077 18.3722222 0.019808 18.3750000 0.023269 18.3777778 0.023269 18.3805556 0.021538 18.3833333 0.023269 18.3861111 0.021538 18.3888889 0.018077 18.3916667 0.014615 18.3944444 0.010000 18.3972222 0.012885 18.4000000 0.010000 18.4027778 0.018077 18.4055556 0.014615 18.4083333 0.018077 18.4111111 0.025000 18.4138889 0.021538 18.4166667 0.023269 18.4194444 0.028462 18.4222222 0.025000 18.4250000 0.019808 18.4277778 0.019808 18.4305556 0.018077 18.4333333 0.016346 18.4361111 0.019808 18.4388889 0.016346 18.4416667 0.021538 18.4444444 0.023269 18.4472222 0.021538 18.4500000 0.025000 18.4527778 0.023269 18.4555556 0.025000 18.4583333 0.021538 18.4611111 0.023269 18.4638889 0.021538 18.4666667 0.026731 18.4694444 0.031923 18.4722222 0.037115 18.4750000 0.038846 18.4777778 0.042308 18.4805556 0.040577 18.4833333 0.037115 18.4861111 0.035385 18.4888889 0.026731 18.4916667 0.021538 18.4944444 0.016346 18.4972222 0.011154 18.5000000 0.010000 18.5027778 0.010000 18.5055556 0.011154 18.5083333 0.014615 18.5111111 0.018077 18.5138889 0.021538 18.5166667 0.019808 18.5194444 0.016346 18.5222222 0.014615 18.5250000 0.011154 18.5277778 0.011154 18.5305556 0.010000 18.5333333 0.010000 18.5361111 0.010000 18.5388889 0.010000 18.5416667 0.010000 18.5444444 0.037115 18.5472222 0.078654 18.5500000 0.115000 18.5527778 0.137500 18.5555556 0.149615 18.5583333 0.130577 18.5611111 0.082115 18.5638889 0.011154 18.5666667 0.010000 18.5694444 0.010000 18.5722222 0.010000 18.5750000 0.010000 18.5777778 0.010000 18.5805556 0.010000 18.5833333 0.010000 18.5861111 0.010000 18.5888889 0.049231 18.5916667 0.089038 18.5944444 0.121923 18.5972222 0.132308 18.6000000 0.140962 18.6027778 0.140962 18.6055556 0.128846 18.6083333 0.108077 18.6111111 0.078654 18.6138889 0.052692 18.6166667 0.037115 18.6194444 0.023269 18.6222222 0.016346 18.6250000 0.018077 18.6277778 0.023269 18.6305556 0.035385 18.6333333 0.038846 18.6361111 0.040577 18.6388889 0.031923 18.6416667 0.016346 18.6444444 0.010000 18.6472222 0.010000 18.6500000 0.010000 18.6527778 0.010000 18.6555556 0.010000 18.6583333 0.010000 18.6611111 0.012885 18.6638889 0.021538 18.6666667 0.030192 18.6694444 0.040577 18.6722222 0.050962 18.6750000 0.050962 18.6777778 0.056154 18.6805556 0.063077 18.6833333 0.068269 18.6861111 0.061346 18.6888889 0.066538 18.6916667 0.061346 18.6944444 0.057885 18.6972222 0.056154 18.7000000 0.059615 18.7027778 0.059615 18.7055556 0.061346 18.7083333 0.064808 18.7111111 0.064808 18.7138889 0.066538 18.7166667 0.073462 18.7194444 0.070000 18.7222222 0.066538 18.7250000 0.068269 18.7277778 0.063077 18.7305556 0.061346 18.7333333 0.061346 18.7361111 0.059615 18.7388889 0.061346 18.7416667 0.064808 18.7444444 0.068269 18.7472222 0.063077 18.7500000 0.066538 18.7527778 0.061346 18.7555556 0.064808 18.7583333 0.063077 18.7611111 0.056154 18.7638889 0.059615 18.7666667 0.054423 18.7694444 0.057885 18.7722222 0.057885 18.7750000 0.063077 18.7777778 0.061346 18.7805556 0.063077 18.7833333 0.064808 18.7861111 0.061346 18.7888889 0.064808 18.7916667 0.059615 18.7944444 0.057885 18.7972222 0.054423 18.8000000 0.050962 18.8027778 0.047500 18.8055556 0.047500 18.8083333 0.050962 18.8111111 0.050962 18.8138889 0.056154 18.8166667 0.057885 18.8194444 0.056154 18.8222222 0.050962 18.8250000 0.049231 18.8277778 0.042308 18.8305556 0.030192 18.8333333 0.031923 18.8361111 0.031923 18.8388889 0.035385 18.8416667 0.035385 18.8444444 0.035385 18.8472222 0.031923 18.8500000 0.030192 18.8527778 0.021538 18.8555556 0.019808 18.8583333 0.014615 18.8611111 0.010000 18.8638889 0.010000 18.8666667 0.010000 18.8694444 0.010000 18.8722222 0.010000 18.8750000 0.010000 18.8777778 0.010000 18.8805556 0.010000 18.8833333 0.010000 18.8861111 0.010000 18.8888889 0.010000 18.8916667 0.010000 18.8944444 0.010000 18.8972222 0.010000 18.9000000 0.010000 18.9027778 0.010000 18.9055556 0.010000 18.9083333 0.010000 19.5500000 0.030192 19.5527778 0.028462 19.5555556 0.025000 19.5583333 0.023269 19.5611111 0.016346 19.5638889 0.018077 19.5666667 0.018077 19.5694444 0.021538 19.5722222 0.018077 19.5750000 0.019808 19.5777778 0.023269 19.5805556 0.023269 19.5833333 0.025000 19.5861111 0.025000 19.5888889 0.021538 19.5916667 0.023269 19.5944444 0.019808 19.5972222 0.016346 19.6000000 0.014615 19.6027778 0.016346 19.6055556 0.019808 19.6083333 0.021538 19.6111111 0.016346 19.6138889 0.021538 19.6166667 0.026731 19.6194444 0.026731 19.6222222 0.025000 19.6250000 0.021538 19.6277778 0.025000 19.6305556 0.023269 19.6333333 0.021538 19.6361111 0.023269 19.6388889 0.025000 19.6416667 0.030192 19.6444444 0.035385 19.6472222 0.037115 19.6500000 0.038846 19.6527778 0.040577 19.6555556 0.042308 19.6583333 0.044038 19.6611111 0.040577 19.6638889 0.044038 19.6666667 0.042308 19.6694444 0.035385 19.6722222 0.038846 19.6750000 0.040577 19.6777778 0.037115 19.6805556 0.037115 19.6833333 0.030192 19.6861111 0.030192 19.6888889 0.028462 19.6916667 0.019808 19.6944444 0.018077 19.6972222 0.018077 19.7000000 0.014615 19.7027778 0.010000 19.7055556 0.019808 19.7083333 0.021538 19.7111111 0.025000 19.7138889 0.023269 19.7166667 0.028462 19.7194444 0.018077 19.7222222 0.010000 19.7250000 0.010000 19.7277778 0.010000 19.7305556 0.010000 19.7333333 0.038846 19.7361111 0.087308 19.7388889 0.130577 19.7416667 0.168654 19.7444444 0.173846 19.7472222 0.166923 19.7500000 0.125385 19.7527778 0.033654 19.7555556 0.010000 19.7583333 0.010000 19.7611111 0.010000 19.7638889 0.010000 19.7666667 0.010000 19.7694444 0.010000 19.7722222 0.010000 19.7750000 0.010000 19.7777778 0.011154 19.7805556 0.056154 19.7833333 0.078654 19.7861111 0.080385 19.7888889 0.085577 19.7916667 0.082115 19.7944444 0.073462 19.7972222 0.059615 19.8000000 0.037115 19.8027778 0.026731 19.8055556 0.019808 19.8083333 0.021538 19.8111111 0.023269 19.8138889 0.026731 19.8166667 0.038846 19.8194444 0.045769 19.8222222 0.049231 19.8250000 0.052692 19.8277778 0.037115 19.8305556 0.026731 19.8333333 0.011154 19.8361111 0.010000 19.8388889 0.010000 19.8416667 0.011154 19.8444444 0.023269 19.8472222 0.037115 19.8500000 0.045769 19.8527778 0.052692 19.8555556 0.056154 19.8583333 0.057885 19.8611111 0.064808 19.8638889 0.066538 19.8666667 0.071731 19.8694444 0.075192 19.8722222 0.075192 19.8750000 0.080385 19.8777778 0.085577 19.8805556 0.087308 19.8833333 0.089038 19.8861111 0.092500 19.8888889 0.089038 19.8916667 0.085577 19.8944444 0.076923 19.8972222 0.076923 19.9000000 0.073462 19.9027778 0.075192 19.9055556 0.080385 19.9083333 0.090769 19.9111111 0.092500 19.9138889 0.099423 19.9166667 0.102885 19.9194444 0.097692 19.9222222 0.089038 19.9250000 0.090769 19.9277778 0.083846 19.9305556 0.080385 19.9333333 0.078654 19.9361111 0.082115 19.9388889 0.080385 19.9416667 0.083846 19.9444444 0.089038 19.9472222 0.090769 19.9500000 0.090769 19.9527778 0.092500 19.9555556 0.089038 19.9583333 0.087308 19.9611111 0.083846 19.9638889 0.083846 19.9666667 0.085577 19.9694444 0.085577 19.9722222 0.085577 19.9750000 0.083846 19.9777778 0.083846 19.9805556 0.085577 19.9833333 0.085577 19.9861111 0.083846 19.9888889 0.078654 19.9916667 0.075192 19.9944444 0.075192 19.9972222 0.071731 20.0000000 0.070000 20.0027778 0.066538 20.0055556 0.064808 20.0083333 0.066538 20.0111111 0.073462 20.0138889 0.071731 20.0166667 0.071731 20.0194444 0.071731 20.0222222 0.063077 20.0250000 0.057885 20.0277778 0.054423 20.0305556 0.049231 20.0333333 0.047500 20.0361111 0.047500 20.0388889 0.047500 20.0416667 0.047500 20.0444444 0.047500 20.0472222 0.045769 20.0500000 0.042308 20.0527778 0.031923 20.0555556 0.030192 20.0583333 0.025000 20.0611111 0.018077 20.0638889 0.016346 20.0666667 0.016346 20.0694444 0.014615 20.0722222 0.012885 20.0750000 0.010000 20.0777778 0.010000 20.0805556 0.010000 20.0833333 0.010000 20.0861111 0.010000 20.0888889 0.010000 20.0916667 0.010000 20.0944444 0.010000 20.0972222 0.010000 20.7611111 0.030192 20.7638889 0.028462 20.7666667 0.025000 20.7694444 0.026731 20.7722222 0.030192 20.7750000 0.026731 20.7777778 0.033654 20.7805556 0.031923 20.7833333 0.035385 20.7861111 0.035385 20.7888889 0.033654 20.7916667 0.028462 20.7944444 0.033654 20.7972222 0.025000 20.8000000 0.028462 20.8027778 0.030192 20.8055556 0.031923 20.8083333 0.035385 20.8111111 0.038846 20.8138889 0.040577 20.8166667 0.044038 20.8194444 0.044038 20.8222222 0.044038 20.8250000 0.037115 20.8277778 0.035385 20.8305556 0.031923 20.8333333 0.033654 20.8361111 0.033654 20.8388889 0.033654 20.8416667 0.038846 20.8444444 0.038846 20.8472222 0.047500 20.8500000 0.049231 20.8527778 0.052692 20.8555556 0.047500 20.8583333 0.044038 20.8611111 0.042308 20.8638889 0.044038 20.8666667 0.044038 20.8694444 0.050962 20.8722222 0.052692 20.8750000 0.054423 20.8777778 0.056154 20.8805556 0.054423 20.8833333 0.056154 20.8861111 0.049231 20.8888889 0.044038 20.8916667 0.042308 20.8944444 0.035385 20.8972222 0.028462 20.9000000 0.030192 20.9027778 0.028462 20.9055556 0.031923 20.9083333 0.031923 20.9111111 0.033654 20.9138889 0.038846 20.9166667 0.042308 20.9194444 0.037115 20.9222222 0.035385 20.9250000 0.030192 20.9277778 0.026731 20.9305556 0.018077 20.9333333 0.010000 20.9361111 0.010000 20.9388889 0.010000 20.9416667 0.033654 20.9444444 0.070000 20.9472222 0.109808 20.9500000 0.142692 20.9527778 0.161731 20.9555556 0.163462 20.9583333 0.137500 20.9611111 0.080385 20.9638889 0.010000 20.9666667 0.010000 20.9694444 0.010000 20.9722222 0.010000 20.9750000 0.010000 20.9777778 0.010000 20.9805556 0.010000 20.9833333 0.010000 20.9861111 0.018077 20.9888889 0.075192 20.9916667 0.116731 20.9944444 0.137500 20.9972222 0.149615 21.0000000 0.154808 21.0027778 0.154808 21.0055556 0.149615 21.0083333 0.134038 21.0111111 0.108077 21.0138889 0.082115 21.0166667 0.059615 21.0194444 0.044038 21.0222222 0.037115 21.0250000 0.030192 21.0277778 0.033654 21.0305556 0.038846 21.0333333 0.047500 21.0361111 0.050962 21.0388889 0.047500 21.0416667 0.040577 21.0444444 0.026731 21.0472222 0.018077 21.0500000 0.010000 21.0527778 0.010000 21.0555556 0.010000 21.0583333 0.012885 21.0611111 0.016346 21.0638889 0.026731 21.0666667 0.031923 21.0694444 0.044038 21.0722222 0.054423 21.0750000 0.066538 21.0777778 0.071731 21.0805556 0.082115 21.0833333 0.085577 21.0861111 0.082115 21.0888889 0.082115 21.0916667 0.082115 21.0944444 0.080385 21.0972222 0.076923 21.1000000 0.076923 21.1027778 0.082115 21.1055556 0.082115 21.1083333 0.082115 21.1111111 0.087308 21.1138889 0.089038 21.1166667 0.095962 21.1194444 0.094231 21.1222222 0.090769 21.1250000 0.087308 21.1277778 0.090769 21.1305556 0.083846 21.1333333 0.085577 21.1361111 0.087308 21.1388889 0.085577 21.1416667 0.092500 21.1444444 0.092500 21.1472222 0.094231 21.1500000 0.095962 21.1527778 0.094231 21.1555556 0.094231 21.1583333 0.087308 21.1611111 0.083846 21.1638889 0.083846 21.1666667 0.083846 21.1694444 0.085577 21.1722222 0.087308 21.1750000 0.092500 21.1777778 0.094231 21.1805556 0.095962 21.1833333 0.097692 21.1861111 0.090769 21.1888889 0.094231 21.1916667 0.089038 21.1944444 0.087308 21.1972222 0.085577 21.2000000 0.085577 21.2027778 0.082115 21.2055556 0.082115 21.2083333 0.083846 21.2111111 0.083846 21.2138889 0.083846 21.2166667 0.083846 21.2194444 0.082115 21.2222222 0.078654 21.2250000 0.076923 21.2277778 0.073462 21.2305556 0.071731 21.2333333 0.064808 21.2361111 0.061346 21.2388889 0.063077 21.2416667 0.061346 21.2444444 0.064808 21.2472222 0.061346 21.2500000 0.066538 21.2527778 0.063077 21.2555556 0.057885 21.2583333 0.052692 21.2611111 0.049231 21.2638889 0.042308 21.2666667 0.038846 21.2694444 0.035385 21.2722222 0.033654 21.2750000 0.037115 21.2777778 0.035385 21.2805556 0.035385 21.2833333 0.037115 21.2861111 0.035385 21.2888889 0.026731 21.2916667 0.021538 21.2944444 0.018077 21.2972222 0.016346 21.3000000 0.012885 21.3027778 0.011154 21.3055556 0.012885 21.3083333 0.016346 21.9277778 0.044038 21.9305556 0.038846 21.9333333 0.040577 21.9361111 0.038846 21.9388889 0.038846 21.9416667 0.038846 21.9444444 0.044038 21.9472222 0.040577 21.9500000 0.044038 21.9527778 0.045769 21.9555556 0.045769 21.9583333 0.042308 21.9611111 0.038846 21.9638889 0.033654 21.9666667 0.033654 21.9694444 0.031923 21.9722222 0.031923 21.9750000 0.033654 21.9777778 0.035385 21.9805556 0.044038 21.9833333 0.045769 21.9861111 0.049231 21.9888889 0.054423 21.9916667 0.049231 21.9944444 0.044038 21.9972222 0.042308 22.0000000 0.038846 22.0027778 0.035385 22.0055556 0.037115 22.0083333 0.047500 22.0111111 0.047500 22.0138889 0.054423 22.0166667 0.057885 22.0194444 0.057885 22.0222222 0.057885 22.0250000 0.054423 22.0277778 0.054423 22.0305556 0.057885 22.0333333 0.061346 22.0361111 0.057885 22.0388889 0.064808 22.0416667 0.063077 22.0444444 0.061346 22.0472222 0.056154 22.0500000 0.059615 22.0527778 0.050962 22.0555556 0.047500 22.0583333 0.040577 22.0611111 0.044038 22.0638889 0.038846 22.0666667 0.037115 22.0694444 0.035385 22.0722222 0.037115 22.0750000 0.038846 22.0777778 0.038846 22.0805556 0.044038 22.0833333 0.044038 22.0861111 0.042308 22.0888889 0.040577 22.0916667 0.031923 22.0944444 0.037115 22.0972222 0.030192 22.1000000 0.023269 22.1027778 0.018077 22.1055556 0.011154 22.1083333 0.018077 22.1111111 0.037115 22.1138889 0.070000 22.1166667 0.111538 22.1194444 0.147885 22.1222222 0.179038 22.1250000 0.187692 22.1277778 0.177308 22.1305556 0.134038 22.1333333 0.057885 22.1361111 0.010000 22.1388889 0.010000 22.1416667 0.010000 22.1444444 0.010000 22.1472222 0.010000 22.1500000 0.010000 22.1527778 0.010000 22.1555556 0.028462 22.1583333 0.078654 22.1611111 0.101154 22.1638889 0.101154 22.1666667 0.102885 22.1694444 0.095962 22.1722222 0.082115 22.1750000 0.070000 22.1777778 0.050962 22.1805556 0.047500 22.1833333 0.045769 22.1861111 0.049231 22.1888889 0.052692 22.1916667 0.056154 22.1944444 0.063077 22.1972222 0.068269 22.2000000 0.063077 22.2027778 0.052692 22.2055556 0.042308 22.2083333 0.028462 22.2111111 0.023269 22.2138889 0.028462 22.2166667 0.035385 22.2194444 0.044038 22.2222222 0.050962 22.2250000 0.054423 22.2277778 0.061346 22.2305556 0.064808 22.2333333 0.066538 22.2361111 0.071731 22.2388889 0.085577 22.2416667 0.089038 22.2444444 0.097692 22.2472222 0.099423 22.2500000 0.099423 22.2527778 0.097692 22.2555556 0.099423 22.2583333 0.094231 22.2611111 0.095962 22.2638889 0.099423 22.2666667 0.099423 22.2694444 0.099423 22.2722222 0.101154 22.2750000 0.102885 22.2777778 0.104615 22.2805556 0.109808 22.2833333 0.109808 22.2861111 0.106346 22.2888889 0.102885 22.2916667 0.102885 22.2944444 0.101154 22.2972222 0.102885 22.3000000 0.099423 22.3027778 0.099423 22.3055556 0.106346 22.3083333 0.106346 22.3111111 0.108077 22.3138889 0.101154 22.3166667 0.109808 22.3194444 0.104615 22.3222222 0.108077 22.3250000 0.108077 22.3277778 0.101154 22.3305556 0.099423 22.3333333 0.101154 22.3361111 0.099423 22.3388889 0.101154 22.3416667 0.099423 22.3444444 0.102885 22.3472222 0.104615 22.3500000 0.106346 22.3527778 0.106346 22.3555556 0.102885 22.3583333 0.099423 22.3611111 0.094231 22.3638889 0.090769 22.3666667 0.094231 22.3694444 0.092500 22.3722222 0.092500 22.3750000 0.094231 22.3777778 0.090769 22.3805556 0.092500 22.3833333 0.095962 22.3861111 0.095962 22.3888889 0.092500 22.3916667 0.089038 22.3944444 0.082115 22.3972222 0.075192 22.4000000 0.070000 22.4027778 0.066538 22.4055556 0.068269 22.4083333 0.063077 22.4111111 0.063077 22.4138889 0.063077 22.4166667 0.061346 22.4194444 0.056154 22.4222222 0.054423 22.4250000 0.052692 22.4277778 0.044038 22.4305556 0.038846 22.4333333 0.035385 22.4361111 0.033654 22.4388889 0.031923 22.4416667 0.030192 22.4444444 0.031923 22.4472222 0.028462 22.4500000 0.028462 22.4527778 0.023269 22.4555556 0.023269 22.4583333 0.012885 22.4611111 0.010000 22.4638889 0.011154 22.4666667 0.010000 22.4694444 0.010000 22.4722222 0.010000 22.4750000 0.010000 23.1444444 0.068269 23.1472222 0.075192 23.1500000 0.073462 23.1527778 0.071731 23.1555556 0.071731 23.1583333 0.064808 23.1611111 0.063077 23.1638889 0.063077 23.1666667 0.064808 23.1694444 0.064808 23.1722222 0.071731 23.1750000 0.071731 23.1777778 0.078654 23.1805556 0.076923 23.1833333 0.076923 23.1861111 0.078654 23.1888889 0.075192 23.1916667 0.070000 23.1944444 0.073462 23.1972222 0.073462 23.2000000 0.076923 23.2027778 0.075192 23.2055556 0.078654 23.2083333 0.082115 23.2111111 0.080385 23.2138889 0.085577 23.2166667 0.089038 23.2194444 0.087308 23.2222222 0.083846 23.2250000 0.080385 23.2277778 0.078654 23.2305556 0.073462 23.2333333 0.076923 23.2361111 0.073462 23.2388889 0.075192 23.2416667 0.082115 23.2444444 0.085577 23.2472222 0.087308 23.2500000 0.097692 23.2527778 0.097692 23.2555556 0.101154 23.2583333 0.106346 23.2611111 0.099423 23.2638889 0.094231 23.2666667 0.094231 23.2694444 0.092500 23.2722222 0.087308 23.2750000 0.087308 23.2777778 0.087308 23.2805556 0.083846 23.2833333 0.087308 23.2861111 0.083846 23.2888889 0.082115 23.2916667 0.078654 23.2944444 0.076923 23.2972222 0.075192 23.3000000 0.073462 23.3027778 0.073462 23.3055556 0.070000 23.3083333 0.071731 23.3111111 0.076923 23.3138889 0.070000 23.3166667 0.071731 23.3194444 0.063077 23.3222222 0.054423 23.3250000 0.047500 23.3277778 0.064808 23.3305556 0.095962 23.3333333 0.130577 23.3361111 0.166923 23.3388889 0.199808 23.3416667 0.206731 23.3444444 0.198077 23.3472222 0.165192 23.3500000 0.092500 23.3527778 0.010000 23.3555556 0.010000 23.3583333 0.010000 23.3611111 0.010000 23.3638889 0.010000 23.3666667 0.010000 23.3694444 0.035385 23.3722222 0.120192 23.3750000 0.184231 23.3777778 0.225769 23.3805556 0.236154 23.3833333 0.232692 23.3861111 0.222308 23.3888889 0.185962 23.3916667 0.153077 23.3944444 0.120192 23.3972222 0.092500 23.4000000 0.078654 23.4027778 0.075192 23.4055556 0.076923 23.4083333 0.090769 23.4111111 0.101154 23.4138889 0.106346 23.4166667 0.109808 23.4194444 0.102885 23.4222222 0.082115 23.4250000 0.066538 23.4277778 0.050962 23.4305556 0.042308 23.4333333 0.049231 23.4361111 0.054423 23.4388889 0.066538 23.4416667 0.076923 23.4444444 0.090769 23.4472222 0.104615 23.4500000 0.109808 23.4527778 0.120192 23.4555556 0.123654 23.4583333 0.123654 23.4611111 0.125385 23.4638889 0.127115 23.4666667 0.123654 23.4694444 0.123654 23.4722222 0.125385 23.4750000 0.128846 23.4777778 0.130577 23.4805556 0.130577 23.4833333 0.132308 23.4861111 0.135769 23.4888889 0.130577 23.4916667 0.132308 23.4944444 0.134038 23.4972222 0.128846 23.5000000 0.134038 23.5027778 0.127115 23.5055556 0.132308 23.5083333 0.134038 23.5111111 0.140962 23.5138889 0.139231 23.5166667 0.140962 23.5194444 0.142692 23.5222222 0.144423 23.5250000 0.139231 23.5277778 0.139231 23.5305556 0.139231 23.5333333 0.135769 23.5361111 0.132308 23.5388889 0.134038 23.5416667 0.137500 23.5444444 0.137500 23.5472222 0.142692 23.5500000 0.140962 23.5527778 0.140962 23.5555556 0.140962 23.5583333 0.135769 23.5611111 0.134038 23.5638889 0.132308 23.5666667 0.130577 23.5694444 0.128846 23.5722222 0.130577 23.5750000 0.134038 23.5777778 0.135769 23.5805556 0.134038 23.5833333 0.137500 23.5861111 0.137500 23.5888889 0.128846 23.5916667 0.128846 23.5944444 0.128846 23.5972222 0.121923 23.6000000 0.120192 23.6027778 0.115000 23.6055556 0.116731 23.6083333 0.116731 23.6111111 0.115000 23.6138889 0.116731 23.6166667 0.113269 23.6194444 0.108077 23.6222222 0.104615 23.6250000 0.101154 23.6277778 0.095962 23.6305556 0.094231 23.6333333 0.094231 23.6361111 0.092500 23.6388889 0.094231 23.6416667 0.097692 23.6444444 0.097692 23.6472222 0.092500 23.6500000 0.090769 23.6527778 0.085577 23.6555556 0.082115 23.6583333 0.078654 23.6611111 0.075192 23.6638889 0.073462 23.6666667 0.070000 23.6694444 0.064808 23.6722222 0.066538 23.6750000 0.064808 23.6777778 0.066538 23.6805556 0.066538 23.6833333 0.064808 23.6861111 0.064808 23.6888889 0.061346 23.6916667 0.056154 24.3277778 0.106346 24.3305556 0.109808 24.3333333 0.104615 24.3361111 0.104615 24.3388889 0.106346 24.3416667 0.108077 24.3444444 0.108077 24.3472222 0.108077 24.3500000 0.113269 24.3527778 0.113269 24.3555556 0.115000 24.3583333 0.108077 24.3611111 0.104615 24.3638889 0.106346 24.3666667 0.095962 24.3694444 0.099423 24.3722222 0.101154 24.3750000 0.102885 24.3777778 0.111538 24.3805556 0.116731 24.3833333 0.118462 24.3861111 0.123654 24.3888889 0.116731 24.3916667 0.111538 24.3944444 0.104615 24.3972222 0.108077 24.4000000 0.106346 24.4027778 0.106346 24.4055556 0.113269 24.4083333 0.118462 24.4111111 0.118462 24.4138889 0.127115 24.4166667 0.125385 24.4194444 0.132308 24.4222222 0.137500 24.4250000 0.135769 24.4277778 0.134038 24.4305556 0.125385 24.4333333 0.123654 24.4361111 0.121923 24.4388889 0.121923 24.4416667 0.123654 24.4444444 0.127115 24.4472222 0.127115 24.4500000 0.128846 24.4527778 0.123654 24.4555556 0.120192 24.4583333 0.115000 24.4611111 0.113269 24.4638889 0.111538 24.4666667 0.111538 24.4694444 0.111538 24.4722222 0.109808 24.4750000 0.116731 24.4777778 0.120192 24.4805556 0.123654 24.4833333 0.125385 24.4861111 0.123654 24.4888889 0.116731 24.4916667 0.109808 24.4944444 0.099423 24.4972222 0.094231 24.5000000 0.090769 24.5027778 0.104615 24.5055556 0.132308 24.5083333 0.173846 24.5111111 0.217115 24.5138889 0.253462 24.5166667 0.272500 24.5194444 0.274231 24.5222222 0.256923 24.5250000 0.215385 24.5277778 0.146154 24.5305556 0.056154 24.5333333 0.010000 24.5361111 0.010000 24.5388889 0.010000 24.5416667 0.010000 24.5444444 0.010000 24.5472222 0.010000 24.5500000 0.010000 24.5527778 0.049231 24.5555556 0.095962 24.5583333 0.130577 24.5611111 0.149615 24.5638889 0.158269 24.5666667 0.158269 24.5694444 0.161731 24.5722222 0.160000 24.5750000 0.153077 24.5777778 0.134038 24.5805556 0.127115 24.5833333 0.123654 24.5861111 0.115000 24.5888889 0.121923 24.5916667 0.127115 24.5944444 0.134038 24.5972222 0.140962 24.6000000 0.140962 24.6027778 0.135769 24.6055556 0.125385 24.6083333 0.111538 24.6111111 0.104615 24.6138889 0.095962 24.6166667 0.099423 24.6194444 0.111538 24.6222222 0.120192 24.6250000 0.130577 24.6277778 0.139231 24.6305556 0.144423 24.6333333 0.147885 24.6361111 0.149615 24.6388889 0.158269 24.6416667 0.161731 24.6444444 0.175577 24.6472222 0.173846 24.6500000 0.177308 24.6527778 0.185962 24.6555556 0.179038 24.6583333 0.177308 24.6611111 0.177308 24.6638889 0.173846 24.6666667 0.173846 24.6694444 0.172115 24.6722222 0.172115 24.6750000 0.173846 24.6777778 0.180769 24.6805556 0.184231 24.6833333 0.184231 24.6861111 0.187692 24.6888889 0.182500 24.6916667 0.179038 24.6944444 0.179038 24.6972222 0.180769 24.7000000 0.179038 24.7027778 0.182500 24.7055556 0.180769 24.7083333 0.184231 24.7111111 0.187692 24.7138889 0.185962 24.7166667 0.184231 24.7194444 0.185962 24.7222222 0.185962 24.7250000 0.185962 24.7277778 0.184231 24.7305556 0.182500 24.7333333 0.182500 24.7361111 0.182500 24.7388889 0.180769 24.7416667 0.180769 24.7444444 0.182500 24.7472222 0.184231 24.7500000 0.185962 24.7527778 0.185962 24.7555556 0.184231 24.7583333 0.180769 24.7611111 0.177308 24.7638889 0.173846 24.7666667 0.170385 24.7694444 0.170385 24.7722222 0.168654 24.7750000 0.172115 24.7777778 0.172115 24.7805556 0.175577 24.7833333 0.175577 24.7861111 0.177308 24.7888889 0.173846 24.7916667 0.170385 24.7944444 0.161731 24.7972222 0.158269 24.8000000 0.151346 24.8027778 0.149615 24.8055556 0.149615 24.8083333 0.154808 24.8111111 0.158269 24.8138889 0.154808 24.8166667 0.154808 24.8194444 0.147885 24.8222222 0.140962 24.8250000 0.139231 24.8277778 0.137500 24.8305556 0.130577 24.8333333 0.121923 24.8361111 0.120192 24.8388889 0.115000 24.8416667 0.118462 24.8444444 0.115000 24.8472222 0.116731 24.8500000 0.118462 24.8527778 0.118462 24.8555556 0.108077 24.8583333 0.106346 24.8611111 0.099423 24.8638889 0.092500 24.8666667 0.089038 24.8694444 0.080385 24.8722222 0.085577 24.8750000 0.089038 25.5527778 0.120192 25.5555556 0.121923 25.5583333 0.118462 25.5611111 0.115000 25.5638889 0.109808 25.5666667 0.113269 25.5694444 0.109808 25.5722222 0.115000 25.5750000 0.113269 25.5777778 0.118462 25.5805556 0.116731 25.5833333 0.120192 25.5861111 0.116731 25.5888889 0.116731 25.5916667 0.113269 25.5944444 0.115000 25.5972222 0.113269 25.6000000 0.113269 25.6027778 0.116731 25.6055556 0.116731 25.6083333 0.115000 25.6111111 0.120192 25.6138889 0.123654 25.6166667 0.125385 25.6194444 0.125385 25.6222222 0.123654 25.6250000 0.121923 25.6277778 0.123654 25.6305556 0.116731 25.6333333 0.109808 25.6361111 0.115000 25.6388889 0.118462 25.6416667 0.123654 25.6444444 0.121923 25.6472222 0.130577 25.6500000 0.135769 25.6527778 0.135769 25.6555556 0.134038 25.6583333 0.137500 25.6611111 0.135769 25.6638889 0.132308 25.6666667 0.127115 25.6694444 0.125385 25.6722222 0.120192 25.6750000 0.118462 25.6777778 0.123654 25.6805556 0.118462 25.6833333 0.116731 25.6861111 0.115000 25.6888889 0.113269 25.6916667 0.106346 25.6944444 0.102885 25.6972222 0.104615 25.7000000 0.102885 25.7027778 0.102885 25.7055556 0.099423 25.7083333 0.102885 25.7111111 0.108077 25.7138889 0.108077 25.7166667 0.108077 25.7194444 0.106346 25.7222222 0.095962 25.7250000 0.085577 25.7277778 0.076923 25.7305556 0.087308 25.7333333 0.106346 25.7361111 0.142692 25.7388889 0.180769 25.7416667 0.220577 25.7444444 0.239615 25.7472222 0.239615 25.7500000 0.211923 25.7527778 0.154808 25.7555556 0.070000 25.7583333 0.010000 25.7611111 0.010000 25.7638889 0.010000 25.7666667 0.010000 25.7694444 0.010000 25.7722222 0.010000 25.7750000 0.028462 25.7777778 0.102885 25.7805556 0.168654 25.7833333 0.213654 25.7861111 0.241346 25.7888889 0.253462 25.7916667 0.256923 25.7944444 0.246538 25.7972222 0.236154 25.8000000 0.206731 25.8027778 0.172115 25.8055556 0.140962 25.8083333 0.123654 25.8111111 0.108077 25.8138889 0.106346 25.8166667 0.113269 25.8194444 0.118462 25.8222222 0.130577 25.8250000 0.134038 25.8277778 0.130577 25.8305556 0.111538 25.8333333 0.092500 25.8361111 0.075192 25.8388889 0.063077 25.8416667 0.068269 25.8444444 0.082115 25.8472222 0.092500 25.8500000 0.109808 25.8527778 0.121923 25.8555556 0.132308 25.8583333 0.134038 25.8611111 0.135769 25.8638889 0.139231 25.8666667 0.140962 25.8694444 0.142692 25.8722222 0.144423 25.8750000 0.151346 25.8777778 0.153077 25.8805556 0.154808 25.8833333 0.165192 25.8861111 0.161731 25.8888889 0.161731 25.8916667 0.165192 25.8944444 0.160000 25.8972222 0.160000 25.9000000 0.160000 25.9027778 0.158269 25.9055556 0.156538 25.9083333 0.160000 25.9111111 0.158269 25.9138889 0.163462 25.9166667 0.165192 25.9194444 0.172115 25.9222222 0.170385 25.9250000 0.165192 25.9277778 0.165192 25.9305556 0.163462 25.9333333 0.160000 25.9361111 0.163462 25.9388889 0.158269 25.9416667 0.160000 25.9444444 0.163462 25.9472222 0.165192 25.9500000 0.163462 25.9527778 0.166923 25.9555556 0.163462 25.9583333 0.168654 25.9611111 0.160000 25.9638889 0.160000 25.9666667 0.154808 25.9694444 0.153077 25.9722222 0.156538 25.9750000 0.156538 25.9777778 0.158269 25.9805556 0.160000 25.9833333 0.161731 25.9861111 0.163462 25.9888889 0.161731 25.9916667 0.156538 25.9944444 0.149615 25.9972222 0.146154 26.0000000 0.144423 26.0027778 0.146154 26.0055556 0.140962 26.0083333 0.144423 26.0111111 0.151346 26.0138889 0.149615 26.0166667 0.151346 26.0194444 0.142692 26.0222222 0.140962 26.0250000 0.134038 26.0277778 0.128846 26.0305556 0.123654 26.0333333 0.116731 26.0361111 0.115000 26.0388889 0.115000 26.0416667 0.109808 26.0444444 0.109808 26.0472222 0.113269 26.0500000 0.113269 26.0527778 0.109808 26.0555556 0.104615 26.0583333 0.097692 26.0611111 0.094231 26.0638889 0.089038 26.0666667 0.083846 26.0694444 0.082115 26.0722222 0.082115 26.0750000 0.082115 26.0777778 0.085577 26.0805556 0.082115 26.0833333 0.082115 26.0861111 0.082115 26.0888889 0.076923 26.0916667 0.080385 26.0944444 0.073462 26.0972222 0.076923 26.1000000 0.068269 26.7361111 0.095962 26.7388889 0.094231 26.7416667 0.099423 26.7444444 0.104615 26.7472222 0.108077 26.7500000 0.108077 26.7527778 0.115000 26.7555556 0.113269 26.7583333 0.109808 26.7611111 0.106346 26.7638889 0.101154 26.7666667 0.099423 26.7694444 0.101154 26.7722222 0.102885 26.7750000 0.106346 26.7777778 0.108077 26.7805556 0.109808 26.7833333 0.111538 26.7861111 0.115000 26.7888889 0.109808 26.7916667 0.108077 26.7944444 0.108077 26.7972222 0.104615 26.8000000 0.104615 26.8027778 0.104615 26.8055556 0.109808 26.8083333 0.108077 26.8111111 0.116731 26.8138889 0.115000 26.8166667 0.121923 26.8194444 0.121923 26.8222222 0.115000 26.8250000 0.118462 26.8277778 0.115000 26.8305556 0.115000 26.8333333 0.111538 26.8361111 0.116731 26.8388889 0.120192 26.8416667 0.127115 26.8444444 0.132308 26.8472222 0.134038 26.8500000 0.137500 26.8527778 0.130577 26.8555556 0.130577 26.8583333 0.128846 26.8611111 0.123654 26.8638889 0.125385 26.8666667 0.120192 26.8694444 0.111538 26.8722222 0.108077 26.8750000 0.106346 26.8777778 0.106346 26.8805556 0.111538 26.8833333 0.113269 26.8861111 0.116731 26.8888889 0.113269 26.8916667 0.108077 26.8944444 0.104615 26.8972222 0.099423 26.9000000 0.094231 26.9027778 0.094231 26.9055556 0.089038 26.9083333 0.085577 26.9111111 0.083846 26.9138889 0.085577 26.9166667 0.108077 26.9194444 0.142692 26.9222222 0.185962 26.9250000 0.224038 26.9277778 0.246538 26.9305556 0.250000 26.9333333 0.234423 26.9361111 0.185962 26.9388889 0.109808 26.9416667 0.010000 26.9444444 0.010000 26.9472222 0.010000 26.9500000 0.010000 26.9527778 0.010000 26.9555556 0.010000 26.9583333 0.010000 26.9611111 0.028462 26.9638889 0.085577 26.9666667 0.115000 26.9694444 0.132308 26.9722222 0.142692 26.9750000 0.144423 26.9777778 0.139231 26.9805556 0.132308 26.9833333 0.120192 26.9861111 0.109808 26.9888889 0.111538 26.9916667 0.115000 26.9944444 0.116731 26.9972222 0.116731 27.0000000 0.120192 27.0027778 0.120192 27.0055556 0.127115 27.0083333 0.130577 27.0111111 0.125385 27.0138889 0.115000 27.0166667 0.102885 27.0194444 0.094231 27.0222222 0.085577 27.0250000 0.089038 27.0277778 0.097692 27.0305556 0.111538 27.0333333 0.121923 27.0361111 0.132308 27.0388889 0.135769 27.0416667 0.146154 27.0444444 0.151346 27.0472222 0.151346 27.0500000 0.154808 27.0527778 0.158269 27.0555556 0.161731 27.0583333 0.160000 27.0611111 0.158269 27.0638889 0.160000 27.0666667 0.153077 27.0694444 0.158269 27.0722222 0.158269 27.0750000 0.165192 27.0777778 0.163462 27.0805556 0.172115 27.0833333 0.172115 27.0861111 0.172115 27.0888889 0.170385 27.0916667 0.172115 27.0944444 0.166923 27.0972222 0.168654 27.1000000 0.166923 27.1027778 0.166923 27.1055556 0.168654 27.1083333 0.166923 27.1111111 0.170385 27.1138889 0.170385 27.1166667 0.173846 27.1194444 0.170385 27.1222222 0.170385 27.1250000 0.170385 27.1277778 0.166923 27.1305556 0.163462 27.1333333 0.161731 27.1361111 0.165192 27.1388889 0.158269 27.1416667 0.161731 27.1444444 0.160000 27.1472222 0.165192 27.1500000 0.165192 27.1527778 0.172115 27.1555556 0.166923 27.1583333 0.168654 27.1611111 0.161731 27.1638889 0.160000 27.1666667 0.156538 27.1694444 0.153077 27.1722222 0.154808 27.1750000 0.151346 27.1777778 0.158269 27.1805556 0.153077 27.1833333 0.153077 27.1861111 0.154808 27.1888889 0.147885 27.1916667 0.149615 27.1944444 0.142692 27.1972222 0.140962 27.2000000 0.140962 27.2027778 0.135769 27.2055556 0.134038 27.2083333 0.137500 27.2111111 0.134038 27.2138889 0.137500 27.2166667 0.132308 27.2194444 0.130577 27.2222222 0.128846 27.2250000 0.121923 27.2277778 0.115000 27.2305556 0.101154 27.2333333 0.099423 27.2361111 0.094231 27.2388889 0.087308 27.2416667 0.092500 27.2444444 0.089038 27.2472222 0.087308 27.2500000 0.083846 27.2527778 0.083846 27.2555556 0.082115 27.2583333 0.075192 27.2611111 0.073462 27.2638889 0.068269 27.2666667 0.064808 27.2694444 0.056154 27.2722222 0.057885 27.2750000 0.054423 27.2777778 0.056154 27.2805556 0.052692 27.2833333 0.052692 27.9305556 0.087308 27.9333333 0.089038 27.9361111 0.087308 27.9388889 0.089038 27.9416667 0.090769 27.9444444 0.089038 27.9472222 0.092500 27.9500000 0.092500 27.9527778 0.097692 27.9555556 0.094231 27.9583333 0.090769 27.9611111 0.092500 27.9638889 0.090769 27.9666667 0.089038 27.9694444 0.085577 27.9722222 0.090769 27.9750000 0.094231 27.9777778 0.092500 27.9805556 0.097692 27.9833333 0.101154 27.9861111 0.099423 27.9888889 0.097692 27.9916667 0.094231 27.9944444 0.094231 27.9972222 0.090769 28.0000000 0.090769 28.0027778 0.087308 28.0055556 0.083846 28.0083333 0.090769 28.0111111 0.092500 28.0138889 0.097692 28.0166667 0.102885 28.0194444 0.104615 28.0222222 0.101154 28.0250000 0.101154 28.0277778 0.102885 28.0305556 0.099423 28.0333333 0.099423 28.0361111 0.102885 28.0388889 0.108077 28.0416667 0.115000 28.0444444 0.111538 28.0472222 0.116731 28.0500000 0.115000 28.0527778 0.116731 28.0555556 0.106346 28.0583333 0.104615 28.0611111 0.095962 28.0638889 0.094231 28.0666667 0.087308 28.0694444 0.085577 28.0722222 0.090769 28.0750000 0.092500 28.0777778 0.090769 28.0805556 0.094231 28.0833333 0.099423 28.0861111 0.102885 28.0888889 0.101154 28.0916667 0.092500 28.0944444 0.080385 28.0972222 0.071731 28.1000000 0.066538 28.1027778 0.063077 28.1055556 0.071731 28.1083333 0.092500 28.1111111 0.132308 28.1138889 0.177308 28.1166667 0.208462 28.1194444 0.227500 28.1222222 0.229231 28.1250000 0.208462 28.1277778 0.165192 28.1305556 0.095962 28.1333333 0.010000 28.1361111 0.010000 28.1388889 0.010000 28.1416667 0.010000 28.1444444 0.010000 28.1472222 0.010000 28.1500000 0.010000 28.1527778 0.056154 28.1555556 0.120192 28.1583333 0.173846 28.1611111 0.201538 28.1638889 0.218846 28.1666667 0.232692 28.1694444 0.239615 28.1722222 0.244808 28.1750000 0.234423 28.1777778 0.220577 28.1805556 0.185962 28.1833333 0.158269 28.1861111 0.130577 28.1888889 0.108077 28.1916667 0.092500 28.1944444 0.085577 28.1972222 0.090769 28.2000000 0.095962 28.2027778 0.104615 28.2055556 0.115000 28.2083333 0.113269 28.2111111 0.108077 28.2138889 0.095962 28.2166667 0.078654 28.2194444 0.073462 28.2222222 0.059615 28.2250000 0.068269 28.2277778 0.075192 28.2305556 0.083846 28.2333333 0.095962 28.2361111 0.104615 28.2388889 0.108077 28.2416667 0.120192 28.2444444 0.132308 28.2472222 0.137500 28.2500000 0.146154 28.2527778 0.146154 28.2555556 0.151346 28.2583333 0.149615 28.2611111 0.144423 28.2638889 0.144423 28.2666667 0.144423 28.2694444 0.144423 28.2722222 0.147885 28.2750000 0.142692 28.2777778 0.146154 28.2805556 0.151346 28.2833333 0.153077 28.2861111 0.153077 28.2888889 0.149615 28.2916667 0.147885 28.2944444 0.147885 28.2972222 0.147885 28.3000000 0.142692 28.3027778 0.142692 28.3055556 0.147885 28.3083333 0.144423 28.3111111 0.147885 28.3138889 0.149615 28.3166667 0.151346 28.3194444 0.154808 28.3222222 0.154808 28.3250000 0.156538 28.3277778 0.149615 28.3305556 0.149615 28.3333333 0.140962 28.3361111 0.140962 28.3388889 0.146154 28.3416667 0.144423 28.3444444 0.146154 28.3472222 0.149615 28.3500000 0.153077 28.3527778 0.154808 28.3555556 0.146154 28.3583333 0.149615 28.3611111 0.144423 28.3638889 0.139231 28.3666667 0.137500 28.3694444 0.140962 28.3722222 0.142692 28.3750000 0.140962 28.3777778 0.140962 28.3805556 0.144423 28.3833333 0.146154 28.3861111 0.147885 28.3888889 0.146154 28.3916667 0.139231 28.3944444 0.135769 28.3972222 0.130577 28.4000000 0.128846 28.4027778 0.127115 28.4055556 0.121923 28.4083333 0.127115 28.4111111 0.128846 28.4138889 0.130577 28.4166667 0.125385 28.4194444 0.127115 28.4222222 0.123654 28.4250000 0.123654 28.4277778 0.116731 28.4305556 0.113269 28.4333333 0.106346 28.4361111 0.104615 28.4388889 0.101154 28.4416667 0.099423 28.4444444 0.099423 28.4472222 0.101154 28.4500000 0.101154 28.4527778 0.097692 28.4555556 0.094231 28.4583333 0.089038 28.4611111 0.087308 28.4638889 0.080385 28.4666667 0.075192 28.4694444 0.071731 28.4722222 0.073462 28.4750000 0.073462 28.4777778 0.073462 29.1388889 0.090769 29.1416667 0.090769 29.1444444 0.090769 29.1472222 0.094231 29.1500000 0.101154 29.1527778 0.102885 29.1555556 0.101154 29.1583333 0.094231 29.1611111 0.090769 29.1638889 0.085577 29.1666667 0.085577 29.1694444 0.087308 29.1722222 0.087308 29.1750000 0.092500 29.1777778 0.095962 29.1805556 0.097692 29.1833333 0.097692 29.1861111 0.101154 29.1888889 0.101154 29.1916667 0.101154 29.1944444 0.099423 29.1972222 0.097692 29.2000000 0.095962 29.2027778 0.095962 29.2055556 0.094231 29.2083333 0.092500 29.2111111 0.097692 29.2138889 0.102885 29.2166667 0.102885 29.2194444 0.106346 29.2222222 0.104615 29.2250000 0.102885 29.2277778 0.099423 29.2305556 0.099423 29.2333333 0.095962 29.2361111 0.097692 29.2388889 0.097692 29.2416667 0.099423 29.2444444 0.104615 29.2472222 0.108077 29.2500000 0.116731 29.2527778 0.118462 29.2555556 0.123654 29.2583333 0.116731 29.2611111 0.109808 29.2638889 0.108077 29.2666667 0.099423 29.2694444 0.095962 29.2722222 0.094231 29.2750000 0.090769 29.2777778 0.089038 29.2805556 0.089038 29.2833333 0.095962 29.2861111 0.101154 29.2888889 0.097692 29.2916667 0.094231 29.2944444 0.092500 29.2972222 0.083846 29.3000000 0.080385 29.3027778 0.076923 29.3055556 0.073462 29.3083333 0.070000 29.3111111 0.068269 29.3138889 0.063077 29.3166667 0.075192 29.3194444 0.099423 29.3222222 0.142692 29.3250000 0.191154 29.3277778 0.224038 29.3305556 0.239615 29.3333333 0.230962 29.3361111 0.199808 29.3388889 0.139231 29.3416667 0.044038 29.3444444 0.010000 29.3472222 0.010000 29.3500000 0.010000 29.3527778 0.010000 29.3555556 0.010000 29.3583333 0.010000 29.3611111 0.010000 29.3638889 0.028462 29.3666667 0.071731 29.3694444 0.106346 29.3722222 0.115000 29.3750000 0.127115 29.3777778 0.128846 29.3805556 0.128846 29.3833333 0.120192 29.3861111 0.111538 29.3888889 0.097692 29.3916667 0.095962 29.3944444 0.094231 29.3972222 0.102885 29.4000000 0.104615 29.4027778 0.106346 29.4055556 0.108077 29.4083333 0.113269 29.4111111 0.113269 29.4138889 0.111538 29.4166667 0.101154 29.4194444 0.087308 29.4222222 0.080385 29.4250000 0.075192 29.4277778 0.075192 29.4305556 0.078654 29.4333333 0.087308 29.4361111 0.097692 29.4388889 0.109808 29.4416667 0.116731 29.4444444 0.121923 29.4472222 0.132308 29.4500000 0.139231 29.4527778 0.147885 29.4555556 0.147885 29.4583333 0.149615 29.4611111 0.146154 29.4638889 0.142692 29.4666667 0.137500 29.4694444 0.139231 29.4722222 0.135769 29.4750000 0.139231 29.4777778 0.144423 29.4805556 0.146154 29.4833333 0.151346 29.4861111 0.149615 29.4888889 0.153077 29.4916667 0.149615 29.4944444 0.146154 29.4972222 0.146154 29.5000000 0.140962 29.5027778 0.142692 29.5055556 0.142692 29.5083333 0.146154 29.5111111 0.149615 29.5138889 0.151346 29.5166667 0.153077 29.5194444 0.158269 29.5222222 0.154808 29.5250000 0.151346 29.5277778 0.149615 29.5305556 0.146154 29.5333333 0.147885 29.5361111 0.144423 29.5388889 0.147885 29.5416667 0.149615 29.5444444 0.151346 29.5472222 0.153077 29.5500000 0.151346 29.5527778 0.154808 29.5555556 0.154808 29.5583333 0.149615 29.5611111 0.144423 29.5638889 0.142692 29.5666667 0.140962 29.5694444 0.137500 29.5722222 0.139231 29.5750000 0.139231 29.5777778 0.137500 29.5805556 0.140962 29.5833333 0.140962 29.5861111 0.144423 29.5888889 0.137500 29.5916667 0.139231 29.5944444 0.130577 29.5972222 0.127115 29.6000000 0.128846 29.6027778 0.125385 29.6055556 0.121923 29.6083333 0.121923 29.6111111 0.123654 29.6138889 0.118462 29.6166667 0.118462 29.6194444 0.111538 29.6222222 0.109808 29.6250000 0.108077 29.6277778 0.102885 29.6305556 0.095962 29.6333333 0.090769 29.6361111 0.083846 29.6388889 0.076923 29.6416667 0.075192 29.6444444 0.075192 29.6472222 0.073462 29.6500000 0.076923 29.6527778 0.073462 29.6555556 0.068269 29.6583333 0.063077 29.6611111 0.056154 29.6638889 0.056154 29.6666667 0.045769 29.6694444 0.044038 29.6722222 0.035385 29.6750000 0.038846 29.6777778 0.037115 29.6805556 0.035385 29.6833333 0.035385 29.6861111 0.040577 30.3444444 0.075192 30.3472222 0.078654 30.3500000 0.083846 30.3527778 0.087308 30.3555556 0.083846 30.3583333 0.087308 30.3611111 0.085577 30.3638889 0.082115 30.3666667 0.076923 30.3694444 0.076923 30.3722222 0.075192 30.3750000 0.076923 30.3777778 0.078654 30.3805556 0.078654 30.3833333 0.080385 30.3861111 0.087308 30.3888889 0.089038 30.3916667 0.085577 30.3944444 0.087308 30.3972222 0.087308 30.4000000 0.078654 30.4027778 0.078654 30.4055556 0.078654 30.4083333 0.082115 30.4111111 0.082115 30.4138889 0.087308 30.4166667 0.087308 30.4194444 0.087308 30.4222222 0.090769 30.4250000 0.089038 30.4277778 0.089038 30.4305556 0.087308 30.4333333 0.089038 30.4361111 0.083846 30.4388889 0.082115 30.4416667 0.089038 30.4444444 0.094231 30.4472222 0.102885 30.4500000 0.106346 30.4527778 0.106346 30.4555556 0.108077 30.4583333 0.108077 30.4611111 0.099423 30.4638889 0.095962 30.4666667 0.090769 30.4694444 0.085577 30.4722222 0.080385 30.4750000 0.080385 30.4777778 0.080385 30.4805556 0.082115 30.4833333 0.083846 30.4861111 0.083846 30.4888889 0.083846 30.4916667 0.076923 30.4944444 0.078654 30.4972222 0.070000 30.5000000 0.070000 30.5027778 0.068269 30.5055556 0.068269 30.5083333 0.066538 30.5111111 0.070000 30.5138889 0.063077 30.5166667 0.059615 30.5194444 0.052692 30.5222222 0.059615 30.5250000 0.071731 30.5277778 0.097692 30.5305556 0.134038 30.5333333 0.166923 30.5361111 0.191154 30.5388889 0.203269 30.5416667 0.194615 30.5444444 0.163462 30.5472222 0.102885 30.5500000 0.016346 30.5527778 0.010000 30.5555556 0.010000 30.5583333 0.010000 30.5611111 0.010000 30.5638889 0.010000 30.5666667 0.010000 30.5694444 0.052692 30.5722222 0.118462 30.5750000 0.168654 30.5777778 0.205000 30.5805556 0.222308 30.5833333 0.227500 30.5861111 0.230962 30.5888889 0.220577 30.5916667 0.194615 30.5944444 0.161731 30.5972222 0.121923 30.6000000 0.094231 30.6027778 0.076923 30.6055556 0.068269 30.6083333 0.071731 30.6111111 0.083846 30.6138889 0.094231 30.6166667 0.101154 30.6194444 0.101154 30.6222222 0.094231 30.6250000 0.068269 30.6277778 0.045769 30.6305556 0.040577 30.6333333 0.042308 30.6361111 0.050962 30.6388889 0.064808 30.6416667 0.076923 30.6444444 0.090769 30.6472222 0.102885 30.6500000 0.109808 30.6527778 0.116731 30.6555556 0.123654 30.6583333 0.121923 30.6611111 0.120192 30.6638889 0.121923 30.6666667 0.123654 30.6694444 0.123654 30.6722222 0.123654 30.6750000 0.128846 30.6777778 0.130577 30.6805556 0.135769 30.6833333 0.137500 30.6861111 0.139231 30.6888889 0.137500 30.6916667 0.135769 30.6944444 0.135769 30.6972222 0.135769 30.7000000 0.134038 30.7027778 0.135769 30.7055556 0.134038 30.7083333 0.137500 30.7111111 0.135769 30.7138889 0.144423 30.7166667 0.142692 30.7194444 0.147885 30.7222222 0.146154 30.7250000 0.140962 30.7277778 0.135769 30.7305556 0.130577 30.7333333 0.130577 30.7361111 0.127115 30.7388889 0.130577 30.7416667 0.127115 30.7444444 0.134038 30.7472222 0.134038 30.7500000 0.139231 30.7527778 0.140962 30.7555556 0.139231 30.7583333 0.134038 30.7611111 0.130577 30.7638889 0.130577 30.7666667 0.127115 30.7694444 0.128846 30.7722222 0.128846 30.7750000 0.128846 30.7777778 0.127115 30.7805556 0.128846 30.7833333 0.128846 30.7861111 0.128846 30.7888889 0.127115 30.7916667 0.118462 30.7944444 0.118462 30.7972222 0.113269 30.8000000 0.109808 30.8027778 0.109808 30.8055556 0.106346 30.8083333 0.113269 30.8111111 0.113269 30.8138889 0.111538 30.8166667 0.111538 30.8194444 0.104615 30.8222222 0.101154 30.8250000 0.097692 30.8277778 0.092500 30.8305556 0.082115 30.8333333 0.080385 30.8361111 0.078654 30.8388889 0.071731 30.8416667 0.075192 30.8444444 0.075192 30.8472222 0.075192 30.8500000 0.073462 30.8527778 0.073462 30.8555556 0.071731 30.8583333 0.068269 30.8611111 0.064808 30.8638889 0.056154 30.8666667 0.049231 30.8694444 0.049231 30.8722222 0.054423 30.8750000 0.050962 30.8777778 0.052692 30.8805556 0.054423 30.8833333 0.056154 30.8861111 0.059615 30.8888889 0.057885 30.8916667 0.061346 31.5277778 0.106346 31.5305556 0.101154 31.5333333 0.099423 31.5361111 0.095962 31.5388889 0.095962 31.5416667 0.097692 31.5444444 0.097692 31.5472222 0.102885 31.5500000 0.102885 31.5527778 0.108077 31.5555556 0.108077 31.5583333 0.102885 31.5611111 0.099423 31.5638889 0.094231 31.5666667 0.092500 31.5694444 0.090769 31.5722222 0.090769 31.5750000 0.090769 31.5777778 0.094231 31.5805556 0.097692 31.5833333 0.097692 31.5861111 0.099423 31.5888889 0.102885 31.5916667 0.101154 31.5944444 0.099423 31.5972222 0.101154 31.6000000 0.094231 31.6027778 0.097692 31.6055556 0.097692 31.6083333 0.099423 31.6111111 0.099423 31.6138889 0.097692 31.6166667 0.097692 31.6194444 0.102885 31.6222222 0.106346 31.6250000 0.102885 31.6277778 0.106346 31.6305556 0.104615 31.6333333 0.101154 31.6361111 0.102885 31.6388889 0.104615 31.6416667 0.111538 31.6444444 0.115000 31.6472222 0.120192 31.6500000 0.121923 31.6527778 0.123654 31.6555556 0.121923 31.6583333 0.120192 31.6611111 0.111538 31.6638889 0.104615 31.6666667 0.104615 31.6694444 0.094231 31.6722222 0.090769 31.6750000 0.094231 31.6777778 0.090769 31.6805556 0.097692 31.6833333 0.101154 31.6861111 0.101154 31.6888889 0.102885 31.6916667 0.097692 31.6944444 0.097692 31.6972222 0.092500 31.7000000 0.085577 31.7027778 0.071731 31.7055556 0.073462 31.7083333 0.073462 31.7111111 0.089038 31.7138889 0.125385 31.7166667 0.168654 31.7194444 0.206731 31.7222222 0.227500 31.7250000 0.222308 31.7277778 0.187692 31.7305556 0.113269 31.7333333 0.023269 31.7361111 0.010000 31.7388889 0.010000 31.7416667 0.010000 31.7444444 0.010000 31.7472222 0.010000 31.7500000 0.010000 31.7527778 0.040577 31.7555556 0.104615 31.7583333 0.144423 31.7611111 0.165192 31.7638889 0.170385 31.7666667 0.161731 31.7694444 0.147885 31.7722222 0.128846 31.7750000 0.109808 31.7777778 0.104615 31.7805556 0.099423 31.7833333 0.108077 31.7861111 0.115000 31.7888889 0.120192 31.7916667 0.123654 31.7944444 0.123654 31.7972222 0.121923 31.8000000 0.115000 31.8027778 0.097692 31.8055556 0.083846 31.8083333 0.071731 31.8111111 0.063077 31.8138889 0.064808 31.8166667 0.071731 31.8194444 0.083846 31.8222222 0.092500 31.8250000 0.097692 31.8277778 0.104615 31.8305556 0.111538 31.8333333 0.111538 31.8361111 0.111538 31.8388889 0.121923 31.8416667 0.127115 31.8444444 0.128846 31.8472222 0.134038 31.8500000 0.139231 31.8527778 0.142692 31.8555556 0.139231 31.8583333 0.135769 31.8611111 0.135769 31.8638889 0.132308 31.8666667 0.134038 31.8694444 0.132308 31.8722222 0.132308 31.8750000 0.134038 31.8777778 0.140962 31.8805556 0.146154 31.8833333 0.149615 31.8861111 0.147885 31.8888889 0.151346 31.8916667 0.144423 31.8944444 0.149615 31.8972222 0.142692 31.9000000 0.139231 31.9027778 0.137500 31.9055556 0.139231 31.9083333 0.140962 31.9111111 0.140962 31.9138889 0.146154 31.9166667 0.142692 31.9194444 0.144423 31.9222222 0.146154 31.9250000 0.142692 31.9277778 0.142692 31.9305556 0.140962 31.9333333 0.135769 31.9361111 0.135769 31.9388889 0.132308 31.9416667 0.132308 31.9444444 0.137500 31.9472222 0.137500 31.9500000 0.140962 31.9527778 0.142692 31.9555556 0.142692 31.9583333 0.140962 31.9611111 0.135769 31.9638889 0.130577 31.9666667 0.128846 31.9694444 0.128846 31.9722222 0.123654 31.9750000 0.127115 31.9777778 0.127115 31.9805556 0.128846 31.9833333 0.130577 31.9861111 0.123654 31.9888889 0.127115 31.9916667 0.123654 31.9944444 0.116731 31.9972222 0.115000 32.0000000 0.111538 32.0027778 0.106346 32.0055556 0.108077 32.0083333 0.106346 32.0111111 0.104615 32.0138889 0.106346 32.0166667 0.104615 32.0194444 0.102885 32.0222222 0.101154 32.0250000 0.095962 32.0277778 0.087308 32.0305556 0.087308 32.0333333 0.085577 32.0361111 0.080385 32.0388889 0.078654 32.0416667 0.078654 32.0444444 0.076923 32.0472222 0.071731 32.0500000 0.075192 32.0527778 0.071731 32.0555556 0.070000 32.0583333 0.066538 32.0611111 0.059615 32.0638889 0.052692 32.0666667 0.054423 32.0694444 0.050962 32.0722222 0.047500 32.0750000 0.045769 32.7055556 0.054423 32.7083333 0.054423 32.7111111 0.057885 32.7138889 0.057885 32.7166667 0.061346 32.7194444 0.061346 32.7222222 0.059615 32.7250000 0.054423 32.7277778 0.054423 32.7305556 0.050962 32.7333333 0.050962 32.7361111 0.049231 32.7388889 0.050962 32.7416667 0.054423 32.7444444 0.054423 32.7472222 0.057885 32.7500000 0.054423 32.7527778 0.061346 32.7555556 0.061346 32.7583333 0.064808 32.7611111 0.061346 32.7638889 0.059615 32.7666667 0.056154 32.7694444 0.052692 32.7722222 0.052692 32.7750000 0.054423 32.7777778 0.059615 32.7805556 0.061346 32.7833333 0.061346 32.7861111 0.066538 32.7888889 0.061346 32.7916667 0.064808 32.7944444 0.061346 32.7972222 0.059615 32.8000000 0.059615 32.8027778 0.054423 32.8055556 0.056154 32.8083333 0.056154 32.8111111 0.061346 32.8138889 0.070000 32.8166667 0.071731 32.8194444 0.080385 32.8222222 0.083846 32.8250000 0.075192 32.8277778 0.075192 32.8305556 0.070000 32.8333333 0.063077 32.8361111 0.059615 32.8388889 0.054423 32.8416667 0.054423 32.8444444 0.057885 32.8472222 0.059615 32.8500000 0.054423 32.8527778 0.059615 32.8555556 0.063077 32.8583333 0.057885 32.8611111 0.056154 32.8638889 0.050962 32.8666667 0.052692 32.8694444 0.049231 32.8722222 0.040577 32.8750000 0.044038 32.8777778 0.040577 32.8805556 0.042308 32.8833333 0.037115 32.8861111 0.033654 32.8888889 0.040577 32.8916667 0.061346 32.8944444 0.092500 32.8972222 0.130577 32.9000000 0.161731 32.9027778 0.180769 32.9055556 0.184231 32.9083333 0.161731 32.9111111 0.109808 32.9138889 0.023269 32.9166667 0.010000 32.9194444 0.010000 32.9222222 0.010000 32.9250000 0.010000 32.9277778 0.010000 32.9305556 0.010000 32.9333333 0.014615 32.9361111 0.087308 32.9388889 0.123654 32.9416667 0.144423 32.9444444 0.147885 32.9472222 0.146154 32.9500000 0.137500 32.9527778 0.113269 32.9555556 0.090769 32.9583333 0.068269 32.9611111 0.049231 32.9638889 0.042308 32.9666667 0.044038 32.9694444 0.047500 32.9722222 0.061346 32.9750000 0.070000 32.9777778 0.068269 32.9805556 0.063077 32.9833333 0.054423 32.9861111 0.040577 32.9888889 0.028462 32.9916667 0.025000 32.9944444 0.030192 32.9972222 0.038846 33.0000000 0.047500 33.0027778 0.059615 33.0055556 0.064808 33.0083333 0.075192 33.0111111 0.080385 33.0138889 0.087308 33.0166667 0.092500 33.0194444 0.099423 33.0222222 0.095962 33.0250000 0.101154 33.0277778 0.102885 33.0305556 0.099423 33.0333333 0.095962 33.0361111 0.090769 33.0388889 0.089038 33.0416667 0.095962 33.0444444 0.097692 33.0472222 0.104615 33.0500000 0.109808 33.0527778 0.113269 33.0555556 0.116731 33.0583333 0.116731 33.0611111 0.111538 33.0638889 0.106346 33.0666667 0.101154 33.0694444 0.102885 33.0722222 0.101154 33.0750000 0.102885 33.0777778 0.108077 33.0805556 0.111538 33.0833333 0.116731 33.0861111 0.116731 33.0888889 0.116731 33.0916667 0.116731 33.0944444 0.115000 33.0972222 0.106346 33.1000000 0.106346 33.1027778 0.101154 33.1055556 0.097692 33.1083333 0.099423 33.1111111 0.104615 33.1138889 0.104615 33.1166667 0.108077 33.1194444 0.111538 33.1222222 0.113269 33.1250000 0.108077 33.1277778 0.101154 33.1305556 0.094231 33.1333333 0.092500 33.1361111 0.090769 33.1388889 0.092500 33.1416667 0.092500 33.1444444 0.095962 33.1472222 0.095962 33.1500000 0.094231 33.1527778 0.094231 33.1555556 0.092500 33.1583333 0.089038 33.1611111 0.090769 33.1638889 0.085577 33.1666667 0.080385 33.1694444 0.076923 33.1722222 0.073462 33.1750000 0.071731 33.1777778 0.070000 33.1805556 0.068269 33.1833333 0.070000 33.1861111 0.070000 33.1888889 0.064808 33.1916667 0.056154 33.1944444 0.052692 33.1972222 0.049231 33.2000000 0.047500 33.2027778 0.038846 33.2055556 0.033654 33.2083333 0.035385 33.2111111 0.031923 33.2138889 0.033654 33.2166667 0.033654 33.2194444 0.030192 33.2222222 0.028462 33.2250000 0.025000 33.2277778 0.018077 33.2305556 0.016346 33.2333333 0.011154 33.2361111 0.011154 33.2388889 0.010000 33.2416667 0.010000 33.2444444 0.010000 33.2472222 0.010000 33.2500000 0.010000 33.2527778 0.010000 33.9138889 0.025000 33.9166667 0.033654 33.9194444 0.033654 33.9222222 0.028462 33.9250000 0.025000 33.9277778 0.026731 33.9305556 0.026731 33.9333333 0.019808 33.9361111 0.016346 33.9388889 0.014615 33.9416667 0.019808 33.9444444 0.026731 33.9472222 0.028462 33.9500000 0.028462 33.9527778 0.031923 33.9555556 0.026731 33.9583333 0.028462 33.9611111 0.028462 33.9638889 0.025000 33.9666667 0.021538 33.9694444 0.023269 33.9722222 0.019808 33.9750000 0.023269 33.9777778 0.025000 33.9805556 0.030192 33.9833333 0.030192 33.9861111 0.030192 33.9888889 0.031923 33.9916667 0.031923 33.9944444 0.028462 33.9972222 0.021538 34.0000000 0.019808 34.0027778 0.021538 34.0055556 0.019808 34.0083333 0.019808 34.0111111 0.026731 34.0138889 0.031923 34.0166667 0.040577 34.0194444 0.047500 34.0222222 0.050962 34.0250000 0.049231 34.0277778 0.040577 34.0305556 0.040577 34.0333333 0.033654 34.0361111 0.028462 34.0388889 0.021538 34.0416667 0.014615 34.0444444 0.023269 34.0472222 0.019808 34.0500000 0.023269 34.0527778 0.023269 34.0555556 0.023269 34.0583333 0.019808 34.0611111 0.021538 34.0638889 0.016346 34.0666667 0.014615 34.0694444 0.010000 34.0722222 0.011154 34.0750000 0.010000 34.0777778 0.011154 34.0805556 0.010000 34.0833333 0.010000 34.0861111 0.010000 34.0888889 0.010000 34.0916667 0.010000 34.0944444 0.014615 34.0972222 0.035385 34.1000000 0.073462 34.1027778 0.104615 34.1055556 0.130577 34.1083333 0.140962 34.1111111 0.132308 34.1138889 0.106346 34.1166667 0.052692 34.1194444 0.010000 34.1222222 0.010000 34.1250000 0.010000 34.1277778 0.010000 34.1305556 0.010000 34.1333333 0.010000 34.1361111 0.010000 34.1388889 0.010000 34.1416667 0.012885 34.1444444 0.075192 34.1472222 0.121923 34.1500000 0.144423 34.1527778 0.154808 34.1555556 0.151346 34.1583333 0.130577 34.1611111 0.102885 34.1638889 0.068269 34.1666667 0.038846 34.1694444 0.014615 34.1722222 0.010000 34.1750000 0.010000 34.1777778 0.011154 34.1805556 0.026731 34.1833333 0.040577 34.1861111 0.040577 34.1888889 0.033654 34.1916667 0.016346 34.1944444 0.010000 34.1972222 0.010000 34.2000000 0.010000 34.2027778 0.010000 34.2055556 0.010000 34.2083333 0.010000 34.2111111 0.016346 34.2138889 0.030192 34.2166667 0.040577 34.2194444 0.052692 34.2222222 0.052692 34.2250000 0.059615 34.2277778 0.061346 34.2305556 0.059615 34.2333333 0.056154 34.2361111 0.054423 34.2388889 0.054423 34.2416667 0.054423 34.2444444 0.057885 34.2472222 0.061346 34.2500000 0.066538 34.2527778 0.064808 34.2555556 0.068269 34.2583333 0.068269 34.2611111 0.066538 34.2638889 0.061346 34.2666667 0.063077 34.2694444 0.059615 34.2722222 0.063077 34.2750000 0.064808 34.2777778 0.064808 34.2805556 0.066538 34.2833333 0.071731 34.2861111 0.068269 34.2888889 0.071731 34.2916667 0.070000 34.2944444 0.068269 34.2972222 0.061346 34.3000000 0.064808 34.3027778 0.059615 34.3055556 0.057885 34.3083333 0.056154 34.3111111 0.059615 34.3138889 0.063077 34.3166667 0.066538 34.3194444 0.068269 34.3222222 0.073462 34.3250000 0.068269 34.3277778 0.064808 34.3305556 0.057885 34.3333333 0.059615 34.3361111 0.054423 34.3388889 0.049231 34.3416667 0.054423 34.3444444 0.054423 34.3472222 0.056154 34.3500000 0.059615 34.3527778 0.059615 34.3555556 0.057885 34.3583333 0.052692 34.3611111 0.045769 34.3638889 0.047500 34.3666667 0.044038 34.3694444 0.038846 34.3722222 0.035385 34.3750000 0.033654 34.3777778 0.033654 34.3805556 0.037115 34.3833333 0.033654 34.3861111 0.031923 34.3888889 0.033654 34.3916667 0.023269 34.3944444 0.018077 34.3972222 0.014615 34.4000000 0.010000 34.4027778 0.010000 34.4055556 0.010000 34.4083333 0.010000 34.4111111 0.010000 34.4138889 0.010000 34.4166667 0.010000 34.4194444 0.010000 34.4222222 0.010000 34.4250000 0.010000 34.4277778 0.010000 34.4305556 0.010000 34.4333333 0.010000 34.4361111 0.010000 34.4388889 0.010000 34.4416667 0.010000 34.4444444 0.010000 34.4472222 0.010000 34.4500000 0.010000 34.4527778 0.010000 34.4555556 0.010000 34.4583333 0.010000 34.4611111 0.010000 35.1055556 0.010000 35.1083333 0.010000 35.1111111 0.010000 35.1138889 0.010000 35.1166667 0.010000 35.1194444 0.010000 35.1222222 0.010000 35.1250000 0.010000 35.1277778 0.010000 35.1305556 0.010000 35.1333333 0.010000 35.1361111 0.010000 35.1388889 0.010000 35.1416667 0.010000 35.1444444 0.010000 35.1472222 0.010000 35.1500000 0.010000 35.1527778 0.010000 35.1555556 0.010000 35.1583333 0.010000 35.1611111 0.010000 35.1638889 0.010000 35.1666667 0.010000 35.1694444 0.010000 35.1722222 0.010000 35.1750000 0.010000 35.1777778 0.010000 35.1805556 0.010000 35.1833333 0.010000 35.1861111 0.011154 35.1888889 0.012885 35.1916667 0.014615 35.1944444 0.011154 35.1972222 0.012885 35.2000000 0.010000 35.2027778 0.010000 35.2055556 0.010000 35.2083333 0.010000 35.2111111 0.010000 35.2138889 0.019808 35.2166667 0.021538 35.2194444 0.021538 35.2222222 0.028462 35.2250000 0.023269 35.2277778 0.021538 35.2305556 0.014615 35.2333333 0.010000 35.2361111 0.010000 35.2388889 0.010000 35.2416667 0.010000 35.2444444 0.010000 35.2472222 0.010000 35.2500000 0.010000 35.2527778 0.010000 35.2555556 0.010000 35.2583333 0.010000 35.2611111 0.010000 35.2638889 0.010000 35.2666667 0.010000 35.2694444 0.010000 35.2722222 0.010000 35.2750000 0.010000 35.2777778 0.010000 35.2805556 0.010000 35.2833333 0.010000 35.2861111 0.010000 35.2888889 0.023269 35.2916667 0.061346 35.2944444 0.101154 35.2972222 0.128846 35.3000000 0.147885 35.3027778 0.139231 35.3055556 0.102885 35.3083333 0.045769 35.3111111 0.010000 35.3138889 0.010000 35.3166667 0.010000 35.3194444 0.010000 35.3222222 0.010000 35.3250000 0.010000 35.3277778 0.010000 35.3305556 0.010000 35.3333333 0.010000 35.3361111 0.010000 35.3388889 0.010000 35.3416667 0.021538 35.3444444 0.033654 35.3472222 0.028462 35.3500000 0.026731 35.3527778 0.014615 35.3555556 0.010000 35.3583333 0.010000 35.3611111 0.010000 35.3638889 0.012885 35.3666667 0.016346 35.3694444 0.023269 35.3722222 0.025000 35.3750000 0.018077 35.3777778 0.014615 35.3805556 0.010000 35.3833333 0.010000 35.3861111 0.010000 35.3888889 0.010000 35.3916667 0.010000 35.3944444 0.010000 35.3972222 0.010000 35.4000000 0.010000 35.4027778 0.014615 35.4055556 0.026731 35.4083333 0.033654 35.4111111 0.038846 35.4138889 0.045769 35.4166667 0.052692 35.4194444 0.054423 35.4222222 0.059615 35.4250000 0.059615 35.4277778 0.054423 35.4305556 0.050962 35.4333333 0.049231 35.4361111 0.049231 35.4388889 0.049231 35.4416667 0.050962 35.4444444 0.057885 35.4472222 0.059615 35.4500000 0.059615 35.4527778 0.063077 35.4555556 0.066538 35.4583333 0.066538 35.4611111 0.068269 35.4638889 0.063077 35.4666667 0.061346 35.4694444 0.061346 35.4722222 0.056154 35.4750000 0.057885 35.4777778 0.057885 35.4805556 0.063077 35.4833333 0.066538 35.4861111 0.068269 35.4888889 0.070000 35.4916667 0.068269 35.4944444 0.068269 35.4972222 0.064808 35.5000000 0.063077 35.5027778 0.059615 35.5055556 0.057885 35.5083333 0.061346 35.5111111 0.061346 35.5138889 0.064808 35.5166667 0.064808 35.5194444 0.070000 35.5222222 0.070000 35.5250000 0.064808 35.5277778 0.068269 35.5305556 0.064808 35.5333333 0.061346 35.5361111 0.061346 35.5388889 0.057885 35.5416667 0.059615 35.5444444 0.059615 35.5472222 0.061346 35.5500000 0.061346 35.5527778 0.066538 35.5555556 0.064808 35.5583333 0.064808 35.5611111 0.056154 35.5638889 0.052692 35.5666667 0.049231 35.5694444 0.045769 35.5722222 0.045769 35.5750000 0.047500 35.5777778 0.045769 35.5805556 0.049231 35.5833333 0.045769 35.5861111 0.045769 35.5888889 0.047500 35.5916667 0.040577 35.5944444 0.035385 35.5972222 0.031923 35.6000000 0.026731 35.6027778 0.021538 35.6055556 0.023269 35.6083333 0.018077 35.6111111 0.016346 35.6138889 0.016346 35.6166667 0.014615 35.6194444 0.012885 35.6222222 0.010000 35.6250000 0.010000 35.6277778 0.010000 35.6305556 0.010000 35.6333333 0.010000 35.6361111 0.010000 35.6388889 0.010000 35.6416667 0.010000 35.6444444 0.010000 35.6472222 0.010000 35.6500000 0.010000 35.6527778 0.010000 36.2944444 0.054423 36.2972222 0.049231 36.3000000 0.049231 36.3027778 0.044038 36.3055556 0.044038 36.3083333 0.044038 36.3111111 0.047500 36.3138889 0.052692 36.3166667 0.050962 36.3194444 0.054423 36.3222222 0.054423 36.3250000 0.049231 36.3277778 0.050962 36.3305556 0.047500 36.3333333 0.045769 36.3361111 0.047500 36.3388889 0.044038 36.3416667 0.049231 36.3444444 0.050962 36.3472222 0.057885 36.3500000 0.056154 36.3527778 0.057885 36.3555556 0.059615 36.3583333 0.061346 36.3611111 0.057885 36.3638889 0.056154 36.3666667 0.047500 36.3694444 0.049231 36.3722222 0.042308 36.3750000 0.045769 36.3777778 0.045769 36.3805556 0.057885 36.3833333 0.061346 36.3861111 0.063077 36.3888889 0.068269 36.3916667 0.071731 36.3944444 0.068269 36.3972222 0.071731 36.4000000 0.071731 36.4027778 0.070000 36.4055556 0.070000 36.4083333 0.066538 36.4111111 0.066538 36.4138889 0.066538 36.4166667 0.068269 36.4194444 0.064808 36.4222222 0.059615 36.4250000 0.056154 36.4277778 0.057885 36.4305556 0.054423 36.4333333 0.050962 36.4361111 0.050962 36.4388889 0.049231 36.4416667 0.047500 36.4444444 0.050962 36.4472222 0.050962 36.4500000 0.052692 36.4527778 0.052692 36.4555556 0.054423 36.4583333 0.042308 36.4611111 0.031923 36.4638889 0.028462 36.4666667 0.023269 36.4694444 0.038846 36.4722222 0.066538 36.4750000 0.113269 36.4777778 0.153077 36.4805556 0.182500 36.4833333 0.199808 36.4861111 0.192885 36.4888889 0.180769 36.4916667 0.127115 36.4944444 0.052692 36.4972222 0.010000 36.5000000 0.010000 36.5027778 0.010000 36.5055556 0.010000 36.5083333 0.010000 36.5111111 0.010000 36.5138889 0.010000 36.5166667 0.012885 36.5194444 0.076923 36.5222222 0.123654 36.5250000 0.153077 36.5277778 0.166923 36.5305556 0.172115 36.5333333 0.173846 36.5361111 0.165192 36.5388889 0.156538 36.5416667 0.135769 36.5444444 0.106346 36.5472222 0.080385 36.5500000 0.068269 36.5527778 0.061346 36.5555556 0.050962 36.5583333 0.052692 36.5611111 0.066538 36.5638889 0.070000 36.5666667 0.076923 36.5694444 0.076923 36.5722222 0.066538 36.5750000 0.052692 36.5777778 0.037115 36.5805556 0.030192 36.5833333 0.026731 36.5861111 0.044038 36.5888889 0.056154 36.5916667 0.068269 36.5944444 0.076923 36.5972222 0.082115 36.6000000 0.087308 36.6027778 0.092500 36.6055556 0.092500 36.6083333 0.097692 36.6111111 0.102885 36.6138889 0.102885 36.6166667 0.111538 36.6194444 0.113269 36.6222222 0.113269 36.6250000 0.109808 36.6277778 0.104615 36.6305556 0.101154 36.6333333 0.102885 36.6361111 0.101154 36.6388889 0.101154 36.6416667 0.104615 36.6444444 0.106346 36.6472222 0.108077 36.6500000 0.109808 36.6527778 0.113269 36.6555556 0.116731 36.6583333 0.120192 36.6611111 0.109808 36.6638889 0.115000 36.6666667 0.109808 36.6694444 0.109808 36.6722222 0.111538 36.6750000 0.108077 36.6777778 0.111538 36.6805556 0.116731 36.6833333 0.116731 36.6861111 0.118462 36.6888889 0.121923 36.6916667 0.121923 36.6944444 0.116731 36.6972222 0.109808 36.7000000 0.106346 36.7027778 0.108077 36.7055556 0.104615 36.7083333 0.104615 36.7111111 0.109808 36.7138889 0.111538 36.7166667 0.113269 36.7194444 0.113269 36.7222222 0.115000 36.7250000 0.111538 36.7277778 0.108077 36.7305556 0.106346 36.7333333 0.102885 36.7361111 0.099423 36.7388889 0.099423 36.7416667 0.099423 36.7444444 0.099423 36.7472222 0.101154 36.7500000 0.101154 36.7527778 0.102885 36.7555556 0.102885 36.7583333 0.101154 36.7611111 0.094231 36.7638889 0.094231 36.7666667 0.094231 36.7694444 0.092500 36.7722222 0.085577 36.7750000 0.087308 36.7777778 0.080385 36.7805556 0.083846 36.7833333 0.080385 36.7861111 0.076923 36.7888889 0.073462 36.7916667 0.070000 36.7944444 0.063077 36.7972222 0.061346 36.8000000 0.054423 36.8027778 0.049231 36.8055556 0.049231 36.8083333 0.044038 36.8111111 0.042308 36.8138889 0.042308 36.8166667 0.040577 36.8194444 0.040577 36.8222222 0.044038 36.8250000 0.035385 36.8277778 0.030192 36.8305556 0.028462 36.8333333 0.023269 36.8361111 0.019808 36.8388889 0.018077 36.8416667 0.012885 37.5527778 0.056154 37.5555556 0.057885 37.5583333 0.056154 37.5611111 0.056154 37.5638889 0.050962 37.5666667 0.050962 37.5694444 0.049231 37.5722222 0.049231 37.5750000 0.038846 37.5777778 0.047500 37.5805556 0.044038 37.5833333 0.047500 37.5861111 0.050962 37.5888889 0.049231 37.5916667 0.045769 37.5944444 0.050962 37.5972222 0.050962 37.6000000 0.049231 37.6027778 0.047500 37.6055556 0.054423 37.6083333 0.054423 37.6111111 0.057885 37.6138889 0.063077 37.6166667 0.068269 37.6194444 0.068269 37.6222222 0.070000 37.6250000 0.068269 37.6277778 0.066538 37.6305556 0.066538 37.6333333 0.059615 37.6361111 0.056154 37.6388889 0.056154 37.6416667 0.059615 37.6444444 0.063077 37.6472222 0.064808 37.6500000 0.073462 37.6527778 0.082115 37.6555556 0.087308 37.6583333 0.087308 37.6611111 0.082115 37.6638889 0.073462 37.6666667 0.071731 37.6694444 0.066538 37.6722222 0.061346 37.6750000 0.059615 37.6777778 0.056154 37.6805556 0.054423 37.6833333 0.057885 37.6861111 0.057885 37.6888889 0.059615 37.6916667 0.056154 37.6944444 0.057885 37.6972222 0.050962 37.7000000 0.047500 37.7027778 0.042308 37.7055556 0.040577 37.7083333 0.040577 37.7111111 0.042308 37.7138889 0.047500 37.7166667 0.050962 37.7194444 0.047500 37.7222222 0.042308 37.7250000 0.035385 37.7277778 0.026731 37.7305556 0.031923 37.7333333 0.044038 37.7361111 0.076923 37.7388889 0.116731 37.7416667 0.151346 37.7444444 0.173846 37.7472222 0.179038 37.7500000 0.165192 37.7527778 0.120192 37.7555556 0.054423 37.7583333 0.010000 37.7611111 0.010000 37.7638889 0.010000 37.7666667 0.010000 37.7694444 0.010000 37.7722222 0.010000 37.7750000 0.010000 37.7777778 0.010000 37.7805556 0.045769 37.7833333 0.090769 37.7861111 0.127115 37.7888889 0.158269 37.7916667 0.170385 37.7944444 0.173846 37.7972222 0.166923 37.8000000 0.151346 37.8027778 0.118462 37.8055556 0.085577 37.8083333 0.059615 37.8111111 0.047500 37.8138889 0.044038 37.8166667 0.052692 37.8194444 0.064808 37.8222222 0.076923 37.8250000 0.076923 37.8277778 0.070000 37.8305556 0.057885 37.8333333 0.037115 37.8361111 0.019808 37.8388889 0.014615 37.8416667 0.016346 37.8444444 0.025000 37.8472222 0.037115 37.8500000 0.056154 37.8527778 0.068269 37.8555556 0.078654 37.8583333 0.083846 37.8611111 0.089038 37.8638889 0.092500 37.8666667 0.097692 37.8694444 0.094231 37.8722222 0.092500 37.8750000 0.089038 37.8777778 0.092500 37.8805556 0.095962 37.8833333 0.102885 37.8861111 0.099423 37.8888889 0.104615 37.8916667 0.102885 37.8944444 0.104615 37.8972222 0.104615 37.9000000 0.102885 37.9027778 0.101154 37.9055556 0.095962 37.9083333 0.097692 37.9111111 0.097692 37.9138889 0.101154 37.9166667 0.104615 37.9194444 0.104615 37.9222222 0.109808 37.9250000 0.109808 37.9277778 0.108077 37.9305556 0.106346 37.9333333 0.102885 37.9361111 0.102885 37.9388889 0.101154 37.9416667 0.097692 37.9444444 0.097692 37.9472222 0.101154 37.9500000 0.104615 37.9527778 0.106346 37.9555556 0.109808 37.9583333 0.108077 37.9611111 0.102885 37.9638889 0.102885 37.9666667 0.097692 37.9694444 0.092500 37.9722222 0.089038 37.9750000 0.090769 37.9777778 0.092500 37.9805556 0.094231 37.9833333 0.092500 37.9861111 0.097692 37.9888889 0.102885 37.9916667 0.095962 37.9944444 0.095962 37.9972222 0.092500 38.0000000 0.094231 38.0027778 0.089038 38.0055556 0.085577 38.0083333 0.082115 38.0111111 0.083846 38.0138889 0.085577 38.0166667 0.085577 38.0194444 0.080385 38.0222222 0.082115 38.0250000 0.080385 38.0277778 0.076923 38.0305556 0.070000 38.0333333 0.061346 38.0361111 0.063077 38.0388889 0.059615 38.0416667 0.056154 38.0444444 0.049231 38.0472222 0.054423 38.0500000 0.050962 38.0527778 0.049231 38.0555556 0.049231 38.0583333 0.044038 38.0611111 0.045769 38.0638889 0.038846 38.0666667 0.031923 38.0694444 0.028462 38.0722222 0.019808 38.0750000 0.019808 38.0777778 0.021538 38.0805556 0.021538 38.0833333 0.021538 38.0861111 0.023269 38.0888889 0.025000 38.0916667 0.021538 38.0944444 0.018077 38.0972222 0.018077 38.1000000 0.011154 38.7694444 0.026731 38.7722222 0.021538 38.7750000 0.016346 38.7777778 0.019808 38.7805556 0.026731 38.7833333 0.028462 38.7861111 0.031923 38.7888889 0.031923 38.7916667 0.026731 38.7944444 0.026731 38.7972222 0.025000 38.8000000 0.023269 38.8027778 0.023269 38.8055556 0.018077 38.8083333 0.016346 38.8111111 0.023269 38.8138889 0.023269 38.8166667 0.025000 38.8194444 0.031923 38.8222222 0.038846 38.8250000 0.031923 38.8277778 0.030192 38.8305556 0.028462 38.8333333 0.030192 38.8361111 0.031923 38.8388889 0.028462 38.8416667 0.028462 38.8444444 0.023269 38.8472222 0.025000 38.8500000 0.031923 38.8527778 0.031923 38.8555556 0.033654 38.8583333 0.033654 38.8611111 0.035385 38.8638889 0.033654 38.8666667 0.035385 38.8694444 0.035385 38.8722222 0.042308 38.8750000 0.042308 38.8777778 0.040577 38.8805556 0.042308 38.8833333 0.044038 38.8861111 0.045769 38.8888889 0.042308 38.8916667 0.038846 38.8944444 0.038846 38.8972222 0.033654 38.9000000 0.025000 38.9027778 0.025000 38.9055556 0.018077 38.9083333 0.019808 38.9111111 0.016346 38.9138889 0.018077 38.9166667 0.025000 38.9194444 0.026731 38.9222222 0.028462 38.9250000 0.028462 38.9277778 0.028462 38.9305556 0.025000 38.9333333 0.019808 38.9361111 0.016346 38.9388889 0.010000 38.9416667 0.010000 38.9444444 0.010000 38.9472222 0.010000 38.9500000 0.028462 38.9527778 0.066538 38.9555556 0.111538 38.9583333 0.151346 38.9611111 0.172115 38.9638889 0.172115 38.9666667 0.156538 38.9694444 0.106346 38.9722222 0.033654 38.9750000 0.010000 38.9777778 0.010000 38.9805556 0.010000 38.9833333 0.010000 38.9861111 0.010000 38.9888889 0.010000 38.9916667 0.010000 38.9944444 0.010000 38.9972222 0.010000 39.0000000 0.010000 39.0027778 0.037115 39.0055556 0.044038 39.0083333 0.050962 39.0111111 0.050962 39.0138889 0.047500 39.0166667 0.037115 39.0194444 0.026731 39.0222222 0.025000 39.0250000 0.023269 39.0277778 0.026731 39.0305556 0.028462 39.0333333 0.038846 39.0361111 0.042308 39.0388889 0.044038 39.0416667 0.035385 39.0444444 0.023269 39.0472222 0.010000 39.0500000 0.010000 39.0527778 0.010000 39.0555556 0.010000 39.0583333 0.010000 39.0611111 0.012885 39.0638889 0.026731 39.0666667 0.037115 39.0694444 0.040577 39.0722222 0.047500 39.0750000 0.049231 39.0777778 0.059615 39.0805556 0.066538 39.0833333 0.070000 39.0861111 0.071731 39.0888889 0.075192 39.0916667 0.071731 39.0944444 0.071731 39.0972222 0.070000 39.1000000 0.070000 39.1027778 0.064808 39.1055556 0.064808 39.1083333 0.066538 39.1111111 0.064808 39.1138889 0.070000 39.1166667 0.075192 39.1194444 0.073462 39.1222222 0.082115 39.1250000 0.075192 39.1277778 0.075192 39.1305556 0.071731 39.1333333 0.070000 39.1361111 0.066538 39.1388889 0.068269 39.1416667 0.068269 39.1444444 0.070000 39.1472222 0.073462 39.1500000 0.078654 39.1527778 0.078654 39.1555556 0.078654 39.1583333 0.076923 39.1611111 0.078654 39.1638889 0.075192 39.1666667 0.076923 39.1694444 0.070000 39.1722222 0.070000 39.1750000 0.071731 39.1777778 0.068269 39.1805556 0.070000 39.1833333 0.071731 39.1861111 0.076923 39.1888889 0.078654 39.1916667 0.080385 39.1944444 0.073462 39.1972222 0.075192 39.2000000 0.066538 39.2027778 0.064808 39.2055556 0.063077 39.2083333 0.059615 39.2111111 0.064808 39.2138889 0.064808 39.2166667 0.070000 39.2194444 0.070000 39.2222222 0.064808 39.2250000 0.066538 39.2277778 0.064808 39.2305556 0.057885 39.2333333 0.056154 39.2361111 0.049231 39.2388889 0.045769 39.2416667 0.038846 39.2444444 0.040577 39.2472222 0.042308 39.2500000 0.038846 39.2527778 0.040577 39.2555556 0.040577 39.2583333 0.038846 39.2611111 0.030192 39.2638889 0.028462 39.2666667 0.018077 39.2694444 0.014615 39.2722222 0.010000 39.2750000 0.010000 39.2777778 0.010000 39.2805556 0.011154 39.2833333 0.010000 39.2861111 0.010000 39.2888889 0.010000 39.2916667 0.010000 39.2944444 0.010000 39.2972222 0.010000 39.3000000 0.010000 39.3027778 0.010000 39.3055556 0.010000 39.3083333 0.010000 39.3111111 0.010000 39.3138889 0.010000 39.3166667 0.010000 40.0083333 0.011154 40.0111111 0.010000 40.0138889 0.010000 40.0166667 0.010000 40.0194444 0.010000 40.0222222 0.016346 40.0250000 0.016346 40.0277778 0.018077 40.0305556 0.012885 40.0333333 0.012885 40.0361111 0.010000 40.0388889 0.010000 40.0416667 0.010000 40.0444444 0.010000 40.0472222 0.010000 40.0500000 0.012885 40.0527778 0.012885 40.0555556 0.018077 40.0583333 0.018077 40.0611111 0.016346 40.0638889 0.019808 40.0666667 0.016346 40.0694444 0.016346 40.0722222 0.011154 40.0750000 0.010000 40.0777778 0.014615 40.0805556 0.016346 40.0833333 0.016346 40.0861111 0.018077 40.0888889 0.021538 40.0916667 0.030192 40.0944444 0.025000 40.0972222 0.021538 40.1000000 0.019808 40.1027778 0.018077 40.1055556 0.021538 40.1083333 0.021538 40.1111111 0.028462 40.1138889 0.038846 40.1166667 0.038846 40.1194444 0.044038 40.1222222 0.044038 40.1250000 0.038846 40.1277778 0.037115 40.1305556 0.026731 40.1333333 0.025000 40.1361111 0.016346 40.1388889 0.014615 40.1416667 0.018077 40.1444444 0.012885 40.1472222 0.018077 40.1500000 0.018077 40.1527778 0.018077 40.1555556 0.016346 40.1583333 0.016346 40.1611111 0.014615 40.1638889 0.011154 40.1666667 0.010000 40.1694444 0.010000 40.1722222 0.010000 40.1750000 0.010000 40.1777778 0.010000 40.1805556 0.010000 40.1833333 0.010000 40.1861111 0.010000 40.1888889 0.010000 40.1916667 0.028462 40.1944444 0.063077 40.1972222 0.109808 40.2000000 0.140962 40.2027778 0.156538 40.2055556 0.156538 40.2083333 0.130577 40.2111111 0.075192 40.2138889 0.010000 40.2166667 0.010000 40.2194444 0.010000 40.2222222 0.010000 40.2250000 0.010000 40.2277778 0.010000 40.2305556 0.010000 40.2333333 0.010000 40.2361111 0.010000 40.2388889 0.010000 40.2416667 0.037115 40.2444444 0.064808 40.2472222 0.075192 40.2500000 0.078654 40.2527778 0.078654 40.2555556 0.063077 40.2583333 0.040577 40.2611111 0.023269 40.2638889 0.012885 40.2666667 0.010000 40.2694444 0.010000 40.2722222 0.014615 40.2750000 0.023269 40.2777778 0.033654 40.2805556 0.030192 40.2833333 0.026731 40.2861111 0.016346 40.2888889 0.010000 40.2916667 0.010000 40.2944444 0.010000 40.2972222 0.010000 40.3000000 0.010000 40.3027778 0.011154 40.3055556 0.019808 40.3083333 0.030192 40.3111111 0.038846 40.3138889 0.047500 40.3166667 0.054423 40.3194444 0.056154 40.3222222 0.064808 40.3250000 0.068269 40.3277778 0.059615 40.3305556 0.061346 40.3333333 0.054423 40.3361111 0.049231 40.3388889 0.049231 40.3416667 0.054423 40.3444444 0.059615 40.3472222 0.059615 40.3500000 0.068269 40.3527778 0.071731 40.3555556 0.073462 40.3583333 0.071731 40.3611111 0.071731 40.3638889 0.070000 40.3666667 0.066538 40.3694444 0.068269 40.3722222 0.063077 40.3750000 0.063077 40.3777778 0.066538 40.3805556 0.066538 40.3833333 0.073462 40.3861111 0.070000 40.3888889 0.070000 40.3916667 0.070000 40.3944444 0.070000 40.3972222 0.064808 40.4000000 0.064808 40.4027778 0.061346 40.4055556 0.061346 40.4083333 0.064808 40.4111111 0.061346 40.4138889 0.066538 40.4166667 0.064808 40.4194444 0.063077 40.4222222 0.064808 40.4250000 0.068269 40.4277778 0.063077 40.4305556 0.061346 40.4333333 0.057885 40.4361111 0.059615 40.4388889 0.052692 40.4416667 0.049231 40.4444444 0.052692 40.4472222 0.049231 40.4500000 0.054423 40.4527778 0.054423 40.4555556 0.057885 40.4583333 0.054423 40.4611111 0.056154 40.4638889 0.052692 40.4666667 0.047500 40.4694444 0.044038 40.4722222 0.037115 40.4750000 0.035385 40.4777778 0.033654 40.4805556 0.033654 40.4833333 0.031923 40.4861111 0.035385 40.4888889 0.030192 40.4916667 0.030192 40.4944444 0.019808 40.4972222 0.018077 40.5000000 0.011154 40.5027778 0.010000 40.5055556 0.010000 40.5083333 0.010000 40.5111111 0.010000 40.5138889 0.010000 40.5166667 0.010000 40.5194444 0.010000 40.5222222 0.010000 40.5250000 0.010000 40.5277778 0.010000 40.5305556 0.010000 40.5333333 0.010000 40.5361111 0.010000 40.5388889 0.010000 40.5416667 0.010000 40.5444444 0.010000 40.5472222 0.010000 40.5500000 0.010000 40.5527778 0.010000 40.5555556 0.010000 41.2611111 0.016346 41.2638889 0.016346 41.2666667 0.012885 41.2694444 0.011154 41.2722222 0.010000 41.2750000 0.010000 41.2777778 0.010000 41.2805556 0.010000 41.2833333 0.014615 41.2861111 0.016346 41.2888889 0.014615 41.2916667 0.019808 41.2944444 0.019808 41.2972222 0.018077 41.3000000 0.018077 41.3027778 0.019808 41.3055556 0.012885 41.3083333 0.012885 41.3111111 0.014615 41.3138889 0.012885 41.3166667 0.014615 41.3194444 0.019808 41.3222222 0.021538 41.3250000 0.021538 41.3277778 0.023269 41.3305556 0.021538 41.3333333 0.019808 41.3361111 0.021538 41.3388889 0.019808 41.3416667 0.018077 41.3444444 0.018077 41.3472222 0.023269 41.3500000 0.023269 41.3527778 0.030192 41.3555556 0.037115 41.3583333 0.042308 41.3611111 0.038846 41.3638889 0.042308 41.3666667 0.035385 41.3694444 0.037115 41.3722222 0.031923 41.3750000 0.028462 41.3777778 0.025000 41.3805556 0.025000 41.3833333 0.025000 41.3861111 0.023269 41.3888889 0.023269 41.3916667 0.021538 41.3944444 0.021538 41.3972222 0.012885 41.4000000 0.012885 41.4027778 0.011154 41.4055556 0.011154 41.4083333 0.010000 41.4111111 0.010000 41.4138889 0.012885 41.4166667 0.010000 41.4194444 0.010000 41.4222222 0.012885 41.4250000 0.010000 41.4277778 0.010000 41.4305556 0.010000 41.4333333 0.010000 41.4361111 0.010000 41.4388889 0.012885 41.4416667 0.040577 41.4444444 0.080385 41.4472222 0.111538 41.4500000 0.137500 41.4527778 0.147885 41.4555556 0.142692 41.4583333 0.113269 41.4611111 0.050962 41.4638889 0.010000 41.4666667 0.010000 41.4694444 0.010000 41.4722222 0.010000 41.4750000 0.010000 41.4777778 0.010000 41.4805556 0.010000 41.4833333 0.010000 41.4861111 0.010000 41.4888889 0.059615 41.4916667 0.106346 41.4944444 0.132308 41.4972222 0.144423 41.5000000 0.146154 41.5027778 0.144423 41.5055556 0.134038 41.5083333 0.111538 41.5111111 0.082115 41.5138889 0.054423 41.5166667 0.033654 41.5194444 0.025000 41.5222222 0.014615 41.5250000 0.012885 41.5277778 0.016346 41.5305556 0.023269 41.5333333 0.030192 41.5361111 0.033654 41.5388889 0.026731 41.5416667 0.011154 41.5444444 0.010000 41.5472222 0.010000 41.5500000 0.010000 41.5527778 0.010000 41.5555556 0.010000 41.5583333 0.010000 41.5611111 0.010000 41.5638889 0.018077 41.5666667 0.021538 41.5694444 0.026731 41.5722222 0.033654 41.5750000 0.040577 41.5777778 0.045769 41.5805556 0.049231 41.5833333 0.054423 41.5861111 0.064808 41.5888889 0.066538 41.5916667 0.066538 41.5944444 0.063077 41.5972222 0.061346 41.6000000 0.059615 41.6027778 0.063077 41.6055556 0.063077 41.6083333 0.061346 41.6111111 0.063077 41.6138889 0.066538 41.6166667 0.066538 41.6194444 0.071731 41.6222222 0.073462 41.6250000 0.075192 41.6277778 0.078654 41.6305556 0.073462 41.6333333 0.073462 41.6361111 0.070000 41.6388889 0.070000 41.6416667 0.070000 41.6444444 0.070000 41.6472222 0.070000 41.6500000 0.075192 41.6527778 0.078654 41.6555556 0.083846 41.6583333 0.085577 41.6611111 0.080385 41.6638889 0.075192 41.6666667 0.075192 41.6694444 0.068269 41.6722222 0.063077 41.6750000 0.064808 41.6777778 0.066538 41.6805556 0.068269 41.6833333 0.075192 41.6861111 0.073462 41.6888889 0.076923 41.6916667 0.080385 41.6944444 0.075192 41.6972222 0.075192 41.7000000 0.070000 41.7027778 0.063077 41.7055556 0.057885 41.7083333 0.057885 41.7111111 0.061346 41.7138889 0.056154 41.7166667 0.063077 41.7194444 0.059615 41.7222222 0.066538 41.7250000 0.066538 41.7277778 0.061346 41.7305556 0.059615 41.7333333 0.054423 41.7361111 0.054423 41.7388889 0.047500 41.7416667 0.038846 41.7444444 0.042308 41.7472222 0.040577 41.7500000 0.042308 41.7527778 0.037115 41.7555556 0.042308 41.7583333 0.040577 41.7611111 0.042308 41.7638889 0.040577 41.7666667 0.033654 41.7694444 0.026731 41.7722222 0.019808 41.7750000 0.014615 41.7777778 0.016346 41.7805556 0.012885 41.7833333 0.012885 41.7861111 0.014615 41.7888889 0.018077 41.7916667 0.012885 41.7944444 0.011154 41.7972222 0.010000 41.8000000 0.010000 41.8027778 0.010000 41.8055556 0.010000 41.8083333 0.010000 42.5166667 0.049231 42.5194444 0.052692 42.5222222 0.052692 42.5250000 0.059615 42.5277778 0.050962 42.5305556 0.050962 42.5333333 0.047500 42.5361111 0.045769 42.5388889 0.044038 42.5416667 0.042308 42.5444444 0.042308 42.5472222 0.047500 42.5500000 0.047500 42.5527778 0.050962 42.5555556 0.050962 42.5583333 0.052692 42.5611111 0.052692 42.5638889 0.049231 42.5666667 0.047500 42.5694444 0.044038 42.5722222 0.044038 42.5750000 0.044038 42.5777778 0.045769 42.5805556 0.047500 42.5833333 0.050962 42.5861111 0.056154 42.5888889 0.057885 42.5916667 0.054423 42.5944444 0.057885 42.5972222 0.054423 42.6000000 0.056154 42.6027778 0.049231 42.6055556 0.049231 42.6083333 0.047500 42.6111111 0.049231 42.6138889 0.056154 42.6166667 0.054423 42.6194444 0.061346 42.6222222 0.061346 42.6250000 0.063077 42.6277778 0.064808 42.6305556 0.068269 42.6333333 0.068269 42.6361111 0.068269 42.6388889 0.064808 42.6416667 0.063077 42.6444444 0.059615 42.6472222 0.063077 42.6500000 0.059615 42.6527778 0.061346 42.6555556 0.061346 42.6583333 0.057885 42.6611111 0.054423 42.6638889 0.049231 42.6666667 0.047500 42.6694444 0.042308 42.6722222 0.044038 42.6750000 0.038846 42.6777778 0.040577 42.6805556 0.042308 42.6833333 0.045769 42.6861111 0.047500 42.6888889 0.047500 42.6916667 0.042308 42.6944444 0.031923 42.6972222 0.026731 42.7000000 0.023269 42.7027778 0.040577 42.7055556 0.076923 42.7083333 0.116731 42.7111111 0.160000 42.7138889 0.182500 42.7166667 0.184231 42.7194444 0.153077 42.7222222 0.075192 42.7250000 0.010000 42.7277778 0.010000 42.7305556 0.010000 42.7333333 0.010000 42.7361111 0.010000 42.7388889 0.010000 42.7416667 0.010000 42.7444444 0.019808 42.7472222 0.082115 42.7500000 0.115000 42.7527778 0.132308 42.7555556 0.132308 42.7583333 0.130577 42.7611111 0.109808 42.7638889 0.090769 42.7666667 0.066538 42.7694444 0.052692 42.7722222 0.044038 42.7750000 0.040577 42.7777778 0.045769 42.7805556 0.056154 42.7833333 0.070000 42.7861111 0.076923 42.7888889 0.076923 42.7916667 0.064808 42.7944444 0.050962 42.7972222 0.031923 42.8000000 0.019808 42.8027778 0.016346 42.8055556 0.019808 42.8083333 0.033654 42.8111111 0.045769 42.8138889 0.059615 42.8166667 0.075192 42.8194444 0.083846 42.8222222 0.089038 42.8250000 0.092500 42.8277778 0.094231 42.8305556 0.094231 42.8333333 0.094231 42.8361111 0.089038 42.8388889 0.087308 42.8416667 0.087308 42.8444444 0.087308 42.8472222 0.092500 42.8500000 0.094231 42.8527778 0.099423 42.8555556 0.102885 42.8583333 0.106346 42.8611111 0.104615 42.8638889 0.101154 42.8666667 0.097692 42.8694444 0.097692 42.8722222 0.097692 42.8750000 0.092500 42.8777778 0.097692 42.8805556 0.102885 42.8833333 0.109808 42.8861111 0.106346 42.8888889 0.113269 42.8916667 0.109808 42.8944444 0.111538 42.8972222 0.109808 42.9000000 0.104615 42.9027778 0.097692 42.9055556 0.101154 42.9083333 0.097692 42.9111111 0.094231 42.9138889 0.097692 42.9166667 0.102885 42.9194444 0.102885 42.9222222 0.101154 42.9250000 0.102885 42.9277778 0.106346 42.9305556 0.101154 42.9333333 0.099423 42.9361111 0.095962 42.9388889 0.094231 42.9416667 0.097692 42.9444444 0.090769 42.9472222 0.094231 42.9500000 0.097692 42.9527778 0.099423 42.9555556 0.099423 42.9583333 0.097692 42.9611111 0.095962 42.9638889 0.090769 42.9666667 0.087308 42.9694444 0.087308 42.9722222 0.083846 42.9750000 0.083846 42.9777778 0.082115 42.9805556 0.080385 42.9833333 0.082115 42.9861111 0.085577 42.9888889 0.082115 42.9916667 0.082115 42.9944444 0.075192 42.9972222 0.073462 43.0000000 0.070000 43.0027778 0.061346 43.0055556 0.059615 43.0083333 0.056154 43.0111111 0.056154 43.0138889 0.056154 43.0166667 0.057885 43.0194444 0.054423 43.0222222 0.057885 43.0250000 0.057885 43.0277778 0.049231 43.0305556 0.042308 43.0333333 0.042308 43.0361111 0.033654 43.0388889 0.033654 43.0416667 0.031923 43.0444444 0.028462 43.0472222 0.026731 43.0500000 0.030192 43.0527778 0.030192 43.0555556 0.025000 43.0583333 0.028462 43.0611111 0.023269 43.0638889 0.018077 43.7166667 0.054423 43.7194444 0.056154 43.7222222 0.059615 43.7250000 0.064808 43.7277778 0.059615 43.7305556 0.064808 43.7333333 0.061346 43.7361111 0.057885 43.7388889 0.057885 43.7416667 0.059615 43.7444444 0.054423 43.7472222 0.059615 43.7500000 0.061346 43.7527778 0.066538 43.7555556 0.063077 43.7583333 0.066538 43.7611111 0.064808 43.7638889 0.063077 43.7666667 0.054423 43.7694444 0.050962 43.7722222 0.054423 43.7750000 0.056154 43.7777778 0.061346 43.7805556 0.059615 43.7833333 0.066538 43.7861111 0.066538 43.7888889 0.068269 43.7916667 0.071731 43.7944444 0.071731 43.7972222 0.066538 43.8000000 0.061346 43.8027778 0.059615 43.8055556 0.059615 43.8083333 0.061346 43.8111111 0.070000 43.8138889 0.071731 43.8166667 0.073462 43.8194444 0.076923 43.8222222 0.078654 43.8250000 0.082115 43.8277778 0.082115 43.8305556 0.085577 43.8333333 0.087308 43.8361111 0.085577 43.8388889 0.082115 43.8416667 0.080385 43.8444444 0.080385 43.8472222 0.075192 43.8500000 0.082115 43.8527778 0.076923 43.8555556 0.076923 43.8583333 0.076923 43.8611111 0.071731 43.8638889 0.068269 43.8666667 0.059615 43.8694444 0.057885 43.8722222 0.052692 43.8750000 0.054423 43.8777778 0.056154 43.8805556 0.056154 43.8833333 0.059615 43.8861111 0.063077 43.8888889 0.064808 43.8916667 0.057885 43.8944444 0.056154 43.8972222 0.049231 43.9000000 0.049231 43.9027778 0.066538 43.9055556 0.106346 43.9083333 0.153077 43.9111111 0.187692 43.9138889 0.206731 43.9166667 0.201538 43.9194444 0.168654 43.9222222 0.092500 43.9250000 0.010000 43.9277778 0.010000 43.9305556 0.010000 43.9333333 0.010000 43.9361111 0.010000 43.9388889 0.010000 43.9416667 0.010000 43.9444444 0.010000 43.9472222 0.073462 43.9500000 0.116731 43.9527778 0.140962 43.9555556 0.146154 43.9583333 0.147885 43.9611111 0.142692 43.9638889 0.127115 43.9666667 0.102885 43.9694444 0.078654 43.9722222 0.059615 43.9750000 0.049231 43.9777778 0.044038 43.9805556 0.050962 43.9833333 0.068269 43.9861111 0.078654 43.9888889 0.095962 43.9916667 0.097692 43.9944444 0.094231 43.9972222 0.075192 44.0000000 0.056154 44.0027778 0.038846 44.0055556 0.033654 44.0083333 0.037115 44.0111111 0.049231 44.0138889 0.063077 44.0166667 0.075192 44.0194444 0.083846 44.0222222 0.094231 44.0250000 0.102885 44.0277778 0.113269 44.0305556 0.113269 44.0333333 0.113269 44.0361111 0.115000 44.0388889 0.116731 44.0416667 0.113269 44.0444444 0.116731 44.0472222 0.118462 44.0500000 0.121923 44.0527778 0.121923 44.0555556 0.125385 44.0583333 0.128846 44.0611111 0.125385 44.0638889 0.123654 44.0666667 0.120192 44.0694444 0.121923 44.0722222 0.118462 44.0750000 0.120192 44.0777778 0.120192 44.0805556 0.123654 44.0833333 0.121923 44.0861111 0.125385 44.0888889 0.127115 44.0916667 0.132308 44.0944444 0.128846 44.0972222 0.128846 44.1000000 0.121923 44.1027778 0.121923 44.1055556 0.115000 44.1083333 0.120192 44.1111111 0.115000 44.1138889 0.121923 44.1166667 0.118462 44.1194444 0.120192 44.1222222 0.120192 44.1250000 0.127115 44.1277778 0.127115 44.1305556 0.127115 44.1333333 0.123654 44.1361111 0.111538 44.1388889 0.113269 44.1416667 0.109808 44.1444444 0.108077 44.1472222 0.111538 44.1500000 0.111538 44.1527778 0.113269 44.1555556 0.113269 44.1583333 0.116731 44.1611111 0.113269 44.1638889 0.109808 44.1666667 0.101154 44.1694444 0.095962 44.1722222 0.090769 44.1750000 0.089038 44.1777778 0.089038 44.1805556 0.090769 44.1833333 0.090769 44.1861111 0.094231 44.1888889 0.095962 44.1916667 0.095962 44.1944444 0.087308 44.1972222 0.087308 44.2000000 0.083846 44.2027778 0.080385 44.2055556 0.070000 44.2083333 0.064808 44.2111111 0.061346 44.2138889 0.057885 44.2166667 0.063077 44.2194444 0.061346 44.2222222 0.063077 44.2250000 0.057885 44.2277778 0.054423 44.2305556 0.047500 44.2333333 0.044038 44.2361111 0.035385 44.2388889 0.031923 44.2416667 0.031923 44.2444444 0.025000 44.2472222 0.026731 44.2500000 0.028462 44.2527778 0.028462 44.2555556 0.025000 44.2583333 0.028462 44.2611111 0.023269 44.2638889 0.021538 44.9666667 0.037115 44.9694444 0.035385 44.9722222 0.033654 44.9750000 0.031923 44.9777778 0.030192 44.9805556 0.033654 44.9833333 0.040577 44.9861111 0.038846 44.9888889 0.044038 44.9916667 0.044038 44.9944444 0.038846 44.9972222 0.037115 45.0000000 0.033654 45.0027778 0.031923 45.0055556 0.031923 45.0083333 0.031923 45.0111111 0.038846 45.0138889 0.038846 45.0166667 0.042308 45.0194444 0.044038 45.0222222 0.045769 45.0250000 0.049231 45.0277778 0.049231 45.0305556 0.049231 45.0333333 0.045769 45.0361111 0.044038 45.0388889 0.040577 45.0416667 0.038846 45.0444444 0.037115 45.0472222 0.044038 45.0500000 0.042308 45.0527778 0.049231 45.0555556 0.050962 45.0583333 0.054423 45.0611111 0.057885 45.0638889 0.061346 45.0666667 0.063077 45.0694444 0.063077 45.0722222 0.061346 45.0750000 0.056154 45.0777778 0.059615 45.0805556 0.056154 45.0833333 0.054423 45.0861111 0.054423 45.0888889 0.054423 45.0916667 0.056154 45.0944444 0.047500 45.0972222 0.047500 45.1000000 0.042308 45.1027778 0.037115 45.1055556 0.031923 45.1083333 0.030192 45.1111111 0.030192 45.1138889 0.030192 45.1166667 0.037115 45.1194444 0.035385 45.1222222 0.035385 45.1250000 0.035385 45.1277778 0.033654 45.1305556 0.028462 45.1333333 0.018077 45.1361111 0.011154 45.1388889 0.010000 45.1416667 0.010000 45.1444444 0.026731 45.1472222 0.066538 45.1500000 0.106346 45.1527778 0.142692 45.1555556 0.160000 45.1583333 0.165192 45.1611111 0.144423 45.1638889 0.094231 45.1666667 0.021538 45.1694444 0.010000 45.1722222 0.010000 45.1750000 0.010000 45.1777778 0.010000 45.1805556 0.010000 45.1833333 0.010000 45.1861111 0.010000 45.1888889 0.010000 45.1916667 0.052692 45.1944444 0.099423 45.1972222 0.127115 45.2000000 0.149615 45.2027778 0.154808 45.2055556 0.154808 45.2083333 0.158269 45.2111111 0.146154 45.2138889 0.134038 45.2166667 0.108077 45.2194444 0.078654 45.2222222 0.054423 45.2250000 0.042308 45.2277778 0.031923 45.2305556 0.028462 45.2333333 0.030192 45.2361111 0.033654 45.2388889 0.040577 45.2416667 0.047500 45.2444444 0.044038 45.2472222 0.040577 45.2500000 0.025000 45.2527778 0.014615 45.2555556 0.010000 45.2583333 0.010000 45.2611111 0.010000 45.2638889 0.012885 45.2666667 0.021538 45.2694444 0.030192 45.2722222 0.035385 45.2750000 0.044038 45.2777778 0.049231 45.2805556 0.059615 45.2833333 0.064808 45.2861111 0.073462 45.2888889 0.078654 45.2916667 0.082115 45.2944444 0.083846 45.2972222 0.083846 45.3000000 0.083846 45.3027778 0.080385 45.3055556 0.080385 45.3083333 0.080385 45.3111111 0.085577 45.3138889 0.083846 45.3166667 0.085577 45.3194444 0.089038 45.3222222 0.090769 45.3250000 0.090769 45.3277778 0.090769 45.3305556 0.090769 45.3333333 0.092500 45.3361111 0.089038 45.3388889 0.083846 45.3416667 0.082115 45.3444444 0.080385 45.3472222 0.082115 45.3500000 0.082115 45.3527778 0.089038 45.3555556 0.092500 45.3583333 0.095962 45.3611111 0.094231 45.3638889 0.090769 45.3666667 0.089038 45.3694444 0.089038 45.3722222 0.085577 45.3750000 0.085577 45.3777778 0.085577 45.3805556 0.087308 45.3833333 0.085577 45.3861111 0.092500 45.3888889 0.094231 45.3916667 0.094231 45.3944444 0.090769 45.3972222 0.089038 45.4000000 0.087308 45.4027778 0.085577 45.4055556 0.078654 45.4083333 0.078654 45.4111111 0.078654 45.4138889 0.083846 45.4166667 0.082115 45.4194444 0.085577 45.4222222 0.085577 45.4250000 0.085577 45.4277778 0.082115 45.4305556 0.080385 45.4333333 0.073462 45.4361111 0.071731 45.4388889 0.066538 45.4416667 0.064808 45.4444444 0.063077 45.4472222 0.064808 45.4500000 0.066538 45.4527778 0.063077 45.4555556 0.066538 45.4583333 0.064808 45.4611111 0.064808 45.4638889 0.056154 45.4666667 0.056154 45.4694444 0.049231 45.4722222 0.044038 45.4750000 0.042308 45.4777778 0.042308 45.4805556 0.040577 45.4833333 0.038846 45.4861111 0.035385 45.4888889 0.035385 45.4916667 0.030192 45.4944444 0.031923 45.4972222 0.030192 45.5000000 0.026731 45.5027778 0.021538 45.5055556 0.016346 45.5083333 0.014615 45.5111111 0.014615 45.5138889 0.011154 46.1861111 0.080385 46.1888889 0.087308 46.1916667 0.094231 46.1944444 0.089038 46.1972222 0.089038 46.2000000 0.089038 46.2027778 0.085577 46.2055556 0.080385 46.2083333 0.083846 46.2111111 0.083846 46.2138889 0.082115 46.2166667 0.082115 46.2194444 0.080385 46.2222222 0.087308 46.2250000 0.092500 46.2277778 0.092500 46.2305556 0.083846 46.2333333 0.087308 46.2361111 0.082115 46.2388889 0.080385 46.2416667 0.076923 46.2444444 0.083846 46.2472222 0.085577 46.2500000 0.090769 46.2527778 0.094231 46.2555556 0.097692 46.2583333 0.099423 46.2611111 0.099423 46.2638889 0.097692 46.2666667 0.094231 46.2694444 0.092500 46.2722222 0.087308 46.2750000 0.089038 46.2777778 0.089038 46.2805556 0.095962 46.2833333 0.102885 46.2861111 0.106346 46.2888889 0.108077 46.2916667 0.111538 46.2944444 0.113269 46.2972222 0.111538 46.3000000 0.111538 46.3027778 0.115000 46.3055556 0.111538 46.3083333 0.108077 46.3111111 0.108077 46.3138889 0.106346 46.3166667 0.108077 46.3194444 0.109808 46.3222222 0.108077 46.3250000 0.109808 46.3277778 0.108077 46.3305556 0.104615 46.3333333 0.099423 46.3361111 0.094231 46.3388889 0.092500 46.3416667 0.090769 46.3444444 0.094231 46.3472222 0.092500 46.3500000 0.090769 46.3527778 0.092500 46.3555556 0.087308 46.3583333 0.089038 46.3611111 0.078654 46.3638889 0.080385 46.3666667 0.085577 46.3694444 0.104615 46.3722222 0.135769 46.3750000 0.177308 46.3777778 0.213654 46.3805556 0.236154 46.3833333 0.241346 46.3861111 0.217115 46.3888889 0.156538 46.3916667 0.063077 46.3944444 0.010000 46.3972222 0.010000 46.4000000 0.010000 46.4027778 0.010000 46.4055556 0.010000 46.4083333 0.010000 46.4111111 0.010000 46.4138889 0.035385 46.4166667 0.087308 46.4194444 0.115000 46.4222222 0.130577 46.4250000 0.134038 46.4277778 0.135769 46.4305556 0.130577 46.4333333 0.121923 46.4361111 0.101154 46.4388889 0.092500 46.4416667 0.087308 46.4444444 0.095962 46.4472222 0.101154 46.4500000 0.113269 46.4527778 0.120192 46.4555556 0.127115 46.4583333 0.127115 46.4611111 0.123654 46.4638889 0.109808 46.4666667 0.095962 46.4694444 0.076923 46.4722222 0.068269 46.4750000 0.068269 46.4777778 0.078654 46.4805556 0.087308 46.4833333 0.106346 46.4861111 0.120192 46.4888889 0.130577 46.4916667 0.140962 46.4944444 0.142692 46.4972222 0.147885 46.5000000 0.146154 46.5027778 0.147885 46.5055556 0.146154 46.5083333 0.146154 46.5111111 0.147885 46.5138889 0.153077 46.5166667 0.154808 46.5194444 0.156538 46.5222222 0.160000 46.5250000 0.166923 46.5277778 0.163462 46.5305556 0.161731 46.5333333 0.160000 46.5361111 0.160000 46.5388889 0.161731 46.5416667 0.158269 46.5444444 0.154808 46.5472222 0.156538 46.5500000 0.160000 46.5527778 0.158269 46.5555556 0.161731 46.5583333 0.165192 46.5611111 0.161731 46.5638889 0.160000 46.5666667 0.158269 46.5694444 0.156538 46.5722222 0.158269 46.5750000 0.154808 46.5777778 0.153077 46.5805556 0.156538 46.5833333 0.154808 46.5861111 0.161731 46.5888889 0.166923 46.5916667 0.161731 46.5944444 0.160000 46.5972222 0.160000 46.6000000 0.158269 46.6027778 0.153077 46.6055556 0.153077 46.6083333 0.149615 46.6111111 0.151346 46.6138889 0.151346 46.6166667 0.151346 46.6194444 0.154808 46.6222222 0.151346 46.6250000 0.154808 46.6277778 0.149615 46.6305556 0.146154 46.6333333 0.139231 46.6361111 0.139231 46.6388889 0.135769 46.6416667 0.137500 46.6444444 0.130577 46.6472222 0.130577 46.6500000 0.137500 46.6527778 0.130577 46.6555556 0.132308 46.6583333 0.134038 46.6611111 0.130577 46.6638889 0.127115 46.6666667 0.118462 46.6694444 0.116731 46.6722222 0.111538 46.6750000 0.108077 46.6777778 0.108077 46.6805556 0.101154 46.6833333 0.101154 46.6861111 0.101154 46.6888889 0.099423 46.6916667 0.099423 46.6944444 0.101154 46.6972222 0.092500 46.7000000 0.085577 46.7027778 0.082115 46.7055556 0.078654 46.7083333 0.076923 46.7111111 0.066538 46.7138889 0.068269 46.7166667 0.068269 46.7194444 0.066538 46.7222222 0.066538 46.7250000 0.070000 46.7277778 0.066538 46.7305556 0.059615 46.7333333 0.059615 47.4333333 0.082115 47.4361111 0.082115 47.4388889 0.082115 47.4416667 0.080385 47.4444444 0.080385 47.4472222 0.085577 47.4500000 0.083846 47.4527778 0.082115 47.4555556 0.082115 47.4583333 0.089038 47.4611111 0.085577 47.4638889 0.085577 47.4666667 0.087308 47.4694444 0.078654 47.4722222 0.080385 47.4750000 0.076923 47.4777778 0.082115 47.4805556 0.082115 47.4833333 0.085577 47.4861111 0.087308 47.4888889 0.090769 47.4916667 0.094231 47.4944444 0.094231 47.4972222 0.089038 47.5000000 0.087308 47.5027778 0.085577 47.5055556 0.085577 47.5083333 0.082115 47.5111111 0.082115 47.5138889 0.082115 47.5166667 0.085577 47.5194444 0.090769 47.5222222 0.089038 47.5250000 0.095962 47.5277778 0.097692 47.5305556 0.099423 47.5333333 0.095962 47.5361111 0.095962 47.5388889 0.099423 47.5416667 0.099423 47.5444444 0.101154 47.5472222 0.101154 47.5500000 0.104615 47.5527778 0.101154 47.5555556 0.104615 47.5583333 0.104615 47.5611111 0.101154 47.5638889 0.099423 47.5666667 0.095962 47.5694444 0.087308 47.5722222 0.082115 47.5750000 0.078654 47.5777778 0.075192 47.5805556 0.076923 47.5833333 0.073462 47.5861111 0.076923 47.5888889 0.080385 47.5916667 0.082115 47.5944444 0.080385 47.5972222 0.076923 47.6000000 0.070000 47.6027778 0.061346 47.6055556 0.052692 47.6083333 0.047500 47.6111111 0.049231 47.6138889 0.071731 47.6166667 0.106346 47.6194444 0.151346 47.6222222 0.189423 47.6250000 0.210192 47.6277778 0.215385 47.6305556 0.198077 47.6333333 0.144423 47.6361111 0.066538 47.6388889 0.010000 47.6416667 0.010000 47.6444444 0.010000 47.6472222 0.010000 47.6500000 0.010000 47.6527778 0.010000 47.6555556 0.010000 47.6583333 0.054423 47.6611111 0.115000 47.6638889 0.151346 47.6666667 0.182500 47.6694444 0.198077 47.6722222 0.199808 47.6750000 0.203269 47.6777778 0.194615 47.6805556 0.182500 47.6833333 0.156538 47.6861111 0.125385 47.6888889 0.095962 47.6916667 0.080385 47.6944444 0.075192 47.6972222 0.071731 47.7000000 0.076923 47.7027778 0.087308 47.7055556 0.092500 47.7083333 0.092500 47.7111111 0.080385 47.7138889 0.068269 47.7166667 0.052692 47.7194444 0.050962 47.7222222 0.038846 47.7250000 0.045769 47.7277778 0.059615 47.7305556 0.068269 47.7333333 0.075192 47.7361111 0.078654 47.7388889 0.089038 47.7416667 0.094231 47.7444444 0.102885 47.7472222 0.109808 47.7500000 0.111538 47.7527778 0.118462 47.7555556 0.123654 47.7583333 0.123654 47.7611111 0.125385 47.7638889 0.123654 47.7666667 0.127115 47.7694444 0.125385 47.7722222 0.127115 47.7750000 0.121923 47.7777778 0.125385 47.7805556 0.123654 47.7833333 0.127115 47.7861111 0.128846 47.7888889 0.134038 47.7916667 0.130577 47.7944444 0.132308 47.7972222 0.132308 47.8000000 0.128846 47.8027778 0.123654 47.8055556 0.121923 47.8083333 0.120192 47.8111111 0.118462 47.8138889 0.120192 47.8166667 0.127115 47.8194444 0.125385 47.8222222 0.127115 47.8250000 0.128846 47.8277778 0.127115 47.8305556 0.128846 47.8333333 0.125385 47.8361111 0.120192 47.8388889 0.120192 47.8416667 0.113269 47.8444444 0.113269 47.8472222 0.113269 47.8500000 0.120192 47.8527778 0.118462 47.8555556 0.120192 47.8583333 0.120192 47.8611111 0.123654 47.8638889 0.118462 47.8666667 0.115000 47.8694444 0.115000 47.8722222 0.108077 47.8750000 0.109808 47.8777778 0.106346 47.8805556 0.108077 47.8833333 0.108077 47.8861111 0.111538 47.8888889 0.108077 47.8916667 0.108077 47.8944444 0.106346 47.8972222 0.102885 47.9000000 0.099423 47.9027778 0.092500 47.9055556 0.087308 47.9083333 0.083846 47.9111111 0.087308 47.9138889 0.087308 47.9166667 0.089038 47.9194444 0.087308 47.9222222 0.082115 47.9250000 0.082115 47.9277778 0.083846 47.9305556 0.080385 47.9333333 0.071731 47.9361111 0.066538 47.9388889 0.061346 47.9416667 0.054423 47.9444444 0.052692 47.9472222 0.052692 47.9500000 0.054423 47.9527778 0.049231 47.9555556 0.054423 47.9583333 0.056154 47.9611111 0.049231 47.9638889 0.049231 47.9666667 0.045769 47.9694444 0.040577 47.9722222 0.033654 47.9750000 0.030192 47.9777778 0.025000 47.9805556 0.026731 48.6694444 0.054423 48.6722222 0.054423 48.6750000 0.050962 48.6777778 0.047500 48.6805556 0.052692 48.6833333 0.054423 48.6861111 0.059615 48.6888889 0.061346 48.6916667 0.064808 48.6944444 0.064808 48.6972222 0.064808 48.7000000 0.061346 48.7027778 0.056154 48.7055556 0.050962 48.7083333 0.050962 48.7111111 0.047500 48.7138889 0.049231 48.7166667 0.052692 48.7194444 0.054423 48.7222222 0.057885 48.7250000 0.057885 48.7277778 0.059615 48.7305556 0.054423 48.7333333 0.057885 48.7361111 0.052692 48.7388889 0.056154 48.7416667 0.045769 48.7444444 0.047500 48.7472222 0.050962 48.7500000 0.056154 48.7527778 0.059615 48.7555556 0.064808 48.7583333 0.068269 48.7611111 0.071731 48.7638889 0.075192 48.7666667 0.080385 48.7694444 0.076923 48.7722222 0.073462 48.7750000 0.071731 48.7777778 0.064808 48.7805556 0.066538 48.7833333 0.064808 48.7861111 0.064808 48.7888889 0.063077 48.7916667 0.063077 48.7944444 0.061346 48.7972222 0.059615 48.8000000 0.056154 48.8027778 0.050962 48.8055556 0.050962 48.8083333 0.047500 48.8111111 0.045769 48.8138889 0.045769 48.8166667 0.050962 48.8194444 0.052692 48.8222222 0.056154 48.8250000 0.056154 48.8277778 0.052692 48.8305556 0.047500 48.8333333 0.042308 48.8361111 0.028462 48.8388889 0.021538 48.8416667 0.021538 48.8444444 0.033654 48.8472222 0.059615 48.8500000 0.097692 48.8527778 0.139231 48.8555556 0.172115 48.8583333 0.192885 48.8611111 0.191154 48.8638889 0.168654 48.8666667 0.120192 48.8694444 0.038846 48.8722222 0.010000 48.8750000 0.010000 48.8777778 0.010000 48.8805556 0.010000 48.8833333 0.010000 48.8861111 0.010000 48.8888889 0.010000 48.8916667 0.010000 48.8944444 0.037115 48.8972222 0.078654 48.9000000 0.109808 48.9027778 0.121923 48.9055556 0.128846 48.9083333 0.134038 48.9111111 0.130577 48.9138889 0.120192 48.9166667 0.099423 48.9194444 0.082115 48.9222222 0.064808 48.9250000 0.059615 48.9277778 0.061346 48.9305556 0.063077 48.9333333 0.061346 48.9361111 0.068269 48.9388889 0.073462 48.9416667 0.073462 48.9444444 0.066538 48.9472222 0.064808 48.9500000 0.050962 48.9527778 0.035385 48.9555556 0.030192 48.9583333 0.021538 48.9611111 0.026731 48.9638889 0.030192 48.9666667 0.038846 48.9694444 0.050962 48.9722222 0.059615 48.9750000 0.070000 48.9777778 0.075192 48.9805556 0.082115 48.9833333 0.090769 48.9861111 0.097692 48.9888889 0.101154 48.9916667 0.102885 48.9944444 0.101154 48.9972222 0.097692 49.0000000 0.099423 49.0027778 0.099423 49.0055556 0.099423 49.0083333 0.102885 49.0111111 0.101154 49.0138889 0.099423 49.0166667 0.102885 49.0194444 0.104615 49.0222222 0.106346 49.0250000 0.108077 49.0277778 0.116731 49.0305556 0.111538 49.0333333 0.111538 49.0361111 0.113269 49.0388889 0.108077 49.0416667 0.104615 49.0444444 0.106346 49.0472222 0.104615 49.0500000 0.109808 49.0527778 0.115000 49.0555556 0.120192 49.0583333 0.118462 49.0611111 0.120192 49.0638889 0.116731 49.0666667 0.113269 49.0694444 0.113269 49.0722222 0.111538 49.0750000 0.109808 49.0777778 0.108077 49.0805556 0.106346 49.0833333 0.108077 49.0861111 0.113269 49.0888889 0.111538 49.0916667 0.113269 49.0944444 0.120192 49.0972222 0.118462 49.1000000 0.118462 49.1027778 0.113269 49.1055556 0.113269 49.1083333 0.106346 49.1111111 0.102885 49.1138889 0.104615 49.1166667 0.104615 49.1194444 0.106346 49.1222222 0.109808 49.1250000 0.106346 49.1277778 0.106346 49.1305556 0.101154 49.1333333 0.097692 49.1361111 0.094231 49.1388889 0.090769 49.1416667 0.087308 49.1444444 0.087308 49.1472222 0.083846 49.1500000 0.087308 49.1527778 0.087308 49.1555556 0.087308 49.1583333 0.083846 49.1611111 0.085577 49.1638889 0.080385 49.1666667 0.073462 49.1694444 0.070000 49.1722222 0.068269 49.1750000 0.059615 49.1777778 0.059615 49.1805556 0.054423 49.1833333 0.056154 49.1861111 0.054423 49.1888889 0.056154 49.1916667 0.054423 49.1944444 0.052692 49.1972222 0.047500 49.2000000 0.040577 49.2027778 0.038846 49.2055556 0.037115 49.2083333 0.031923 49.2111111 0.026731 49.2138889 0.026731 49.2166667 0.026731 49.8722222 0.089038 49.8750000 0.089038 49.8777778 0.087308 49.8805556 0.082115 49.8833333 0.087308 49.8861111 0.089038 49.8888889 0.094231 49.8916667 0.094231 49.8944444 0.095962 49.8972222 0.090769 49.9000000 0.085577 49.9027778 0.087308 49.9055556 0.082115 49.9083333 0.082115 49.9111111 0.080385 49.9138889 0.085577 49.9166667 0.087308 49.9194444 0.090769 49.9222222 0.094231 49.9250000 0.094231 49.9277778 0.104615 49.9305556 0.097692 49.9333333 0.094231 49.9361111 0.092500 49.9388889 0.090769 49.9416667 0.090769 49.9444444 0.090769 49.9472222 0.092500 49.9500000 0.092500 49.9527778 0.094231 49.9555556 0.101154 49.9583333 0.097692 49.9611111 0.101154 49.9638889 0.101154 49.9666667 0.102885 49.9694444 0.101154 49.9722222 0.099423 49.9750000 0.102885 49.9777778 0.102885 49.9805556 0.106346 49.9833333 0.109808 49.9861111 0.115000 49.9888889 0.115000 49.9916667 0.113269 49.9944444 0.111538 49.9972222 0.106346 50.0000000 0.108077 50.0027778 0.102885 50.0055556 0.094231 50.0083333 0.090769 50.0111111 0.092500 50.0138889 0.087308 50.0166667 0.087308 50.0194444 0.087308 50.0222222 0.092500 50.0250000 0.094231 50.0277778 0.097692 50.0305556 0.094231 50.0333333 0.090769 50.0361111 0.087308 50.0388889 0.080385 50.0416667 0.070000 50.0444444 0.061346 50.0472222 0.057885 50.0500000 0.071731 50.0527778 0.094231 50.0555556 0.140962 50.0583333 0.184231 50.0611111 0.217115 50.0638889 0.236154 50.0666667 0.229231 50.0694444 0.201538 50.0722222 0.140962 50.0750000 0.054423 50.0777778 0.010000 50.0805556 0.010000 50.0833333 0.010000 50.0861111 0.010000 50.0888889 0.010000 50.0916667 0.010000 50.0944444 0.010000 50.0972222 0.068269 50.1000000 0.116731 50.1027778 0.153077 50.1055556 0.172115 50.1083333 0.179038 50.1111111 0.184231 50.1138889 0.185962 50.1166667 0.185962 50.1194444 0.173846 50.1222222 0.158269 50.1250000 0.132308 50.1277778 0.111538 50.1305556 0.083846 50.1333333 0.080385 50.1361111 0.078654 50.1388889 0.087308 50.1416667 0.104615 50.1444444 0.116731 50.1472222 0.116731 50.1500000 0.109808 50.1527778 0.099423 50.1555556 0.085577 50.1583333 0.078654 50.1611111 0.071731 50.1638889 0.075192 50.1666667 0.083846 50.1694444 0.092500 50.1722222 0.097692 50.1750000 0.106346 50.1777778 0.111538 50.1805556 0.121923 50.1833333 0.121923 50.1861111 0.132308 50.1888889 0.139231 50.1916667 0.139231 50.1944444 0.147885 50.1972222 0.146154 50.2000000 0.144423 50.2027778 0.144423 50.2055556 0.140962 50.2083333 0.140962 50.2111111 0.142692 50.2138889 0.146154 50.2166667 0.147885 50.2194444 0.151346 50.2222222 0.151346 50.2250000 0.156538 50.2277778 0.160000 50.2305556 0.158269 50.2333333 0.156538 50.2361111 0.156538 50.2388889 0.156538 50.2416667 0.149615 50.2444444 0.146154 50.2472222 0.147885 50.2500000 0.146154 50.2527778 0.151346 50.2555556 0.158269 50.2583333 0.156538 50.2611111 0.158269 50.2638889 0.156538 50.2666667 0.156538 50.2694444 0.153077 50.2722222 0.153077 50.2750000 0.151346 50.2777778 0.147885 50.2805556 0.147885 50.2833333 0.146154 50.2861111 0.147885 50.2888889 0.151346 50.2916667 0.151346 50.2944444 0.151346 50.2972222 0.151346 50.3000000 0.147885 50.3027778 0.147885 50.3055556 0.142692 50.3083333 0.139231 50.3111111 0.137500 50.3138889 0.137500 50.3166667 0.139231 50.3194444 0.139231 50.3222222 0.140962 50.3250000 0.144423 50.3277778 0.144423 50.3305556 0.135769 50.3333333 0.134038 50.3361111 0.127115 50.3388889 0.125385 50.3416667 0.125385 50.3444444 0.123654 50.3472222 0.123654 50.3500000 0.120192 50.3527778 0.121923 50.3555556 0.118462 50.3583333 0.121923 50.3611111 0.118462 50.3638889 0.118462 50.3666667 0.113269 50.3694444 0.102885 50.3722222 0.097692 50.3750000 0.099423 50.3777778 0.090769 50.3805556 0.085577 50.3833333 0.087308 50.3861111 0.089038 50.3888889 0.087308 50.3916667 0.087308 50.3944444 0.087308 50.3972222 0.080385 50.4000000 0.073462 50.4027778 0.070000 50.4055556 0.064808 50.4083333 0.061346 50.4111111 0.059615 50.4138889 0.059615 50.4166667 0.059615 50.4194444 0.057885 51.1305556 0.104615 51.1333333 0.101154 51.1361111 0.101154 51.1388889 0.095962 51.1416667 0.092500 51.1444444 0.092500 51.1472222 0.094231 51.1500000 0.092500 51.1527778 0.095962 51.1555556 0.099423 51.1583333 0.106346 51.1611111 0.102885 51.1638889 0.106346 51.1666667 0.106346 51.1694444 0.101154 51.1722222 0.101154 51.1750000 0.090769 51.1777778 0.094231 51.1805556 0.092500 51.1833333 0.094231 51.1861111 0.102885 51.1888889 0.102885 51.1916667 0.101154 51.1944444 0.106346 51.1972222 0.104615 51.2000000 0.097692 51.2027778 0.101154 51.2055556 0.097692 51.2083333 0.097692 51.2111111 0.097692 51.2138889 0.094231 51.2166667 0.097692 51.2194444 0.101154 51.2222222 0.101154 51.2250000 0.108077 51.2277778 0.115000 51.2305556 0.109808 51.2333333 0.113269 51.2361111 0.111538 51.2388889 0.109808 51.2416667 0.111538 51.2444444 0.108077 51.2472222 0.104615 51.2500000 0.106346 51.2527778 0.102885 51.2555556 0.102885 51.2583333 0.102885 51.2611111 0.095962 51.2638889 0.095962 51.2666667 0.089038 51.2694444 0.082115 51.2722222 0.085577 51.2750000 0.082115 51.2777778 0.078654 51.2805556 0.082115 51.2833333 0.080385 51.2861111 0.085577 51.2888889 0.089038 51.2916667 0.087308 51.2944444 0.083846 51.2972222 0.073462 51.3000000 0.068269 51.3027778 0.061346 51.3055556 0.063077 51.3083333 0.083846 51.3111111 0.113269 51.3138889 0.158269 51.3166667 0.191154 51.3194444 0.217115 51.3222222 0.222308 51.3250000 0.206731 51.3277778 0.160000 51.3305556 0.082115 51.3333333 0.010000 51.3361111 0.010000 51.3388889 0.010000 51.3416667 0.010000 51.3444444 0.010000 51.3472222 0.010000 51.3500000 0.010000 51.3527778 0.031923 51.3555556 0.097692 51.3583333 0.147885 51.3611111 0.184231 51.3638889 0.199808 51.3666667 0.208462 51.3694444 0.206731 51.3722222 0.199808 51.3750000 0.182500 51.3777778 0.154808 51.3805556 0.123654 51.3833333 0.104615 51.3861111 0.092500 51.3888889 0.092500 51.3916667 0.094231 51.3944444 0.099423 51.3972222 0.101154 51.4000000 0.113269 51.4027778 0.118462 51.4055556 0.113269 51.4083333 0.104615 51.4111111 0.087308 51.4138889 0.066538 51.4166667 0.057885 51.4194444 0.052692 51.4222222 0.059615 51.4250000 0.071731 51.4277778 0.083846 51.4305556 0.099423 51.4333333 0.108077 51.4361111 0.108077 51.4388889 0.116731 51.4416667 0.125385 51.4444444 0.127115 51.4472222 0.127115 51.4500000 0.134038 51.4527778 0.134038 51.4555556 0.137500 51.4583333 0.139231 51.4611111 0.140962 51.4638889 0.142692 51.4666667 0.144423 51.4694444 0.142692 51.4722222 0.139231 51.4750000 0.135769 51.4777778 0.135769 51.4805556 0.135769 51.4833333 0.140962 51.4861111 0.142692 51.4888889 0.146154 51.4916667 0.146154 51.4944444 0.146154 51.4972222 0.147885 51.5000000 0.142692 51.5027778 0.144423 51.5055556 0.142692 51.5083333 0.139231 51.5111111 0.134038 51.5138889 0.139231 51.5166667 0.137500 51.5194444 0.142692 51.5222222 0.144423 51.5250000 0.147885 51.5277778 0.146154 51.5305556 0.149615 51.5333333 0.146154 51.5361111 0.139231 51.5388889 0.140962 51.5416667 0.140962 51.5444444 0.134038 51.5472222 0.139231 51.5500000 0.137500 51.5527778 0.137500 51.5555556 0.142692 51.5583333 0.146154 51.5611111 0.142692 51.5638889 0.140962 51.5666667 0.142692 51.5694444 0.140962 51.5722222 0.134038 51.5750000 0.137500 51.5777778 0.128846 51.5805556 0.130577 51.5833333 0.130577 51.5861111 0.128846 51.5888889 0.134038 51.5916667 0.130577 51.5944444 0.128846 51.5972222 0.130577 51.6000000 0.127115 51.6027778 0.123654 51.6055556 0.121923 51.6083333 0.115000 51.6111111 0.115000 51.6138889 0.113269 51.6166667 0.108077 51.6194444 0.111538 51.6222222 0.109808 51.6250000 0.106346 51.6277778 0.104615 51.6305556 0.101154 51.6333333 0.099423 51.6361111 0.092500 51.6388889 0.085577 51.6416667 0.082115 51.6444444 0.082115 51.6472222 0.080385 51.6500000 0.076923 51.6527778 0.078654 51.6555556 0.076923 51.6583333 0.076923 51.6611111 0.078654 51.6638889 0.075192 51.6666667 0.070000 51.6694444 0.063077 51.6722222 0.059615 51.6750000 0.056154 51.6777778 0.052692 52.3777778 0.078654 52.3805556 0.073462 52.3833333 0.075192 52.3861111 0.078654 52.3888889 0.076923 52.3916667 0.080385 52.3944444 0.082115 52.3972222 0.083846 52.4000000 0.080385 52.4027778 0.082115 52.4055556 0.075192 52.4083333 0.078654 52.4111111 0.082115 52.4138889 0.080385 52.4166667 0.082115 52.4194444 0.085577 52.4222222 0.085577 52.4250000 0.089038 52.4277778 0.085577 52.4305556 0.085577 52.4333333 0.087308 52.4361111 0.089038 52.4388889 0.085577 52.4416667 0.082115 52.4444444 0.082115 52.4472222 0.080385 52.4500000 0.078654 52.4527778 0.085577 52.4555556 0.089038 52.4583333 0.094231 52.4611111 0.099423 52.4638889 0.102885 52.4666667 0.101154 52.4694444 0.106346 52.4722222 0.102885 52.4750000 0.095962 52.4777778 0.095962 52.4805556 0.090769 52.4833333 0.094231 52.4861111 0.089038 52.4888889 0.090769 52.4916667 0.092500 52.4944444 0.089038 52.4972222 0.090769 52.5000000 0.083846 52.5027778 0.080385 52.5055556 0.073462 52.5083333 0.073462 52.5111111 0.071731 52.5138889 0.071731 52.5166667 0.075192 52.5194444 0.078654 52.5222222 0.076923 52.5250000 0.076923 52.5277778 0.082115 52.5305556 0.082115 52.5333333 0.076923 52.5361111 0.075192 52.5388889 0.068269 52.5416667 0.059615 52.5444444 0.054423 52.5472222 0.044038 52.5500000 0.056154 52.5527778 0.078654 52.5555556 0.115000 52.5583333 0.158269 52.5611111 0.196346 52.5638889 0.220577 52.5666667 0.229231 52.5694444 0.218846 52.5722222 0.180769 52.5750000 0.113269 52.5777778 0.019808 52.5805556 0.010000 52.5833333 0.010000 52.5861111 0.010000 52.5888889 0.010000 52.5916667 0.010000 52.5944444 0.010000 52.5972222 0.010000 52.6000000 0.010000 52.6027778 0.028462 52.6055556 0.068269 52.6083333 0.092500 52.6111111 0.104615 52.6138889 0.111538 52.6166667 0.116731 52.6194444 0.120192 52.6222222 0.121923 52.6250000 0.109808 52.6277778 0.094231 52.6305556 0.085577 52.6333333 0.078654 52.6361111 0.078654 52.6388889 0.078654 52.6416667 0.080385 52.6444444 0.080385 52.6472222 0.092500 52.6500000 0.095962 52.6527778 0.092500 52.6555556 0.082115 52.6583333 0.076923 52.6611111 0.059615 52.6638889 0.052692 52.6666667 0.049231 52.6694444 0.057885 52.6722222 0.066538 52.6750000 0.071731 52.6777778 0.083846 52.6805556 0.092500 52.6833333 0.106346 52.6861111 0.113269 52.6888889 0.121923 52.6916667 0.125385 52.6944444 0.128846 52.6972222 0.130577 52.7000000 0.128846 52.7027778 0.125385 52.7055556 0.121923 52.7083333 0.120192 52.7111111 0.121923 52.7138889 0.123654 52.7166667 0.127115 52.7194444 0.128846 52.7222222 0.132308 52.7250000 0.132308 52.7277778 0.132308 52.7305556 0.135769 52.7333333 0.128846 52.7361111 0.128846 52.7388889 0.125385 52.7416667 0.127115 52.7444444 0.123654 52.7472222 0.127115 52.7500000 0.127115 52.7527778 0.130577 52.7555556 0.130577 52.7583333 0.137500 52.7611111 0.135769 52.7638889 0.140962 52.7666667 0.135769 52.7694444 0.135769 52.7722222 0.130577 52.7750000 0.128846 52.7777778 0.123654 52.7805556 0.120192 52.7833333 0.125385 52.7861111 0.128846 52.7888889 0.130577 52.7916667 0.134038 52.7944444 0.132308 52.7972222 0.134038 52.8000000 0.134038 52.8027778 0.125385 52.8055556 0.127115 52.8083333 0.120192 52.8111111 0.115000 52.8138889 0.116731 52.8166667 0.115000 52.8194444 0.115000 52.8222222 0.120192 52.8250000 0.118462 52.8277778 0.123654 52.8305556 0.120192 52.8333333 0.118462 52.8361111 0.111538 52.8388889 0.106346 52.8416667 0.104615 52.8444444 0.101154 52.8472222 0.101154 52.8500000 0.101154 52.8527778 0.097692 52.8555556 0.099423 52.8583333 0.097692 52.8611111 0.097692 52.8638889 0.094231 52.8666667 0.094231 52.8694444 0.092500 52.8722222 0.089038 52.8750000 0.083846 52.8777778 0.078654 52.8805556 0.070000 52.8833333 0.068269 52.8861111 0.064808 52.8888889 0.068269 52.8916667 0.070000 52.8944444 0.068269 52.8972222 0.063077 52.9000000 0.057885 52.9027778 0.052692 52.9055556 0.045769 52.9083333 0.044038 52.9111111 0.037115 52.9138889 0.035385 52.9166667 0.030192 52.9194444 0.035385 52.9222222 0.035385 52.9250000 0.037115 53.6388889 0.037115 53.6416667 0.031923 53.6444444 0.033654 53.6472222 0.037115 53.6500000 0.037115 53.6527778 0.040577 53.6555556 0.038846 53.6583333 0.044038 53.6611111 0.044038 53.6638889 0.045769 53.6666667 0.040577 53.6694444 0.035385 53.6722222 0.037115 53.6750000 0.033654 53.6777778 0.033654 53.6805556 0.033654 53.6833333 0.035385 53.6861111 0.035385 53.6888889 0.037115 53.6916667 0.042308 53.6944444 0.042308 53.6972222 0.047500 53.7000000 0.045769 53.7027778 0.038846 53.7055556 0.040577 53.7083333 0.037115 53.7111111 0.042308 53.7138889 0.045769 53.7166667 0.045769 53.7194444 0.040577 53.7222222 0.047500 53.7250000 0.044038 53.7277778 0.047500 53.7305556 0.044038 53.7333333 0.044038 53.7361111 0.044038 53.7388889 0.038846 53.7416667 0.042308 53.7444444 0.040577 53.7472222 0.045769 53.7500000 0.049231 53.7527778 0.054423 53.7555556 0.057885 53.7583333 0.057885 53.7611111 0.057885 53.7638889 0.061346 53.7666667 0.054423 53.7694444 0.045769 53.7722222 0.042308 53.7750000 0.040577 53.7777778 0.033654 53.7805556 0.033654 53.7833333 0.031923 53.7861111 0.031923 53.7888889 0.033654 53.7916667 0.033654 53.7944444 0.040577 53.7972222 0.040577 53.8000000 0.037115 53.8027778 0.038846 53.8055556 0.031923 53.8083333 0.031923 53.8111111 0.025000 53.8138889 0.019808 53.8166667 0.011154 53.8194444 0.011154 53.8222222 0.014615 53.8250000 0.021538 53.8277778 0.056154 53.8305556 0.094231 53.8333333 0.130577 53.8361111 0.156538 53.8388889 0.163462 53.8416667 0.153077 53.8444444 0.113269 53.8472222 0.040577 53.8500000 0.010000 53.8527778 0.010000 53.8555556 0.010000 53.8583333 0.010000 53.8611111 0.010000 53.8638889 0.010000 53.8666667 0.010000 53.8694444 0.059615 53.8722222 0.120192 53.8750000 0.153077 53.8777778 0.166923 53.8805556 0.172115 53.8833333 0.165192 53.8861111 0.147885 53.8888889 0.121923 53.8916667 0.089038 53.8944444 0.063077 53.8972222 0.040577 53.9000000 0.026731 53.9027778 0.030192 53.9055556 0.035385 53.9083333 0.047500 53.9111111 0.049231 53.9138889 0.047500 53.9166667 0.037115 53.9194444 0.019808 53.9222222 0.010000 53.9250000 0.010000 53.9277778 0.010000 53.9305556 0.010000 53.9333333 0.025000 53.9361111 0.033654 53.9388889 0.047500 53.9416667 0.050962 53.9444444 0.057885 53.9472222 0.063077 53.9500000 0.068269 53.9527778 0.073462 53.9555556 0.075192 53.9583333 0.080385 53.9611111 0.080385 53.9638889 0.082115 53.9666667 0.083846 53.9694444 0.082115 53.9722222 0.078654 53.9750000 0.082115 53.9777778 0.075192 53.9805556 0.078654 53.9833333 0.075192 53.9861111 0.083846 53.9888889 0.083846 53.9916667 0.087308 53.9944444 0.089038 53.9972222 0.094231 54.0000000 0.090769 54.0027778 0.087308 54.0055556 0.087308 54.0083333 0.085577 54.0111111 0.082115 54.0138889 0.083846 54.0166667 0.087308 54.0194444 0.089038 54.0222222 0.092500 54.0250000 0.090769 54.0277778 0.092500 54.0305556 0.095962 54.0333333 0.092500 54.0361111 0.089038 54.0388889 0.085577 54.0416667 0.082115 54.0444444 0.080385 54.0472222 0.080385 54.0500000 0.080385 54.0527778 0.080385 54.0555556 0.083846 54.0583333 0.085577 54.0611111 0.083846 54.0638889 0.085577 54.0666667 0.080385 54.0694444 0.080385 54.0722222 0.076923 54.0750000 0.075192 54.0777778 0.068269 54.0805556 0.068269 54.0833333 0.068269 54.0861111 0.070000 54.0888889 0.071731 54.0916667 0.070000 54.0944444 0.073462 54.0972222 0.070000 54.1000000 0.066538 54.1027778 0.066538 54.1055556 0.059615 54.1083333 0.054423 54.1111111 0.049231 54.1138889 0.044038 54.1166667 0.042308 54.1194444 0.040577 54.1222222 0.042308 54.1250000 0.044038 54.1277778 0.042308 54.1305556 0.040577 54.1333333 0.033654 54.1361111 0.031923 54.1388889 0.025000 54.1416667 0.016346 54.1444444 0.011154 54.1472222 0.010000 54.1500000 0.010000 54.1527778 0.010000 54.1555556 0.010000 54.1583333 0.010000 54.1611111 0.010000 54.1638889 0.010000 54.1666667 0.010000 54.1694444 0.010000 54.1722222 0.010000 54.1750000 0.010000 54.1777778 0.010000 54.1805556 0.010000 54.1833333 0.010000 54.1861111 0.010000 54.8888889 0.016346 54.8916667 0.018077 54.8944444 0.021538 54.8972222 0.025000 54.9000000 0.021538 54.9027778 0.023269 54.9055556 0.023269 54.9083333 0.023269 54.9111111 0.018077 54.9138889 0.016346 54.9166667 0.019808 54.9194444 0.018077 54.9222222 0.019808 54.9250000 0.025000 54.9277778 0.026731 54.9305556 0.023269 54.9333333 0.021538 54.9361111 0.021538 54.9388889 0.012885 54.9416667 0.014615 54.9444444 0.016346 54.9472222 0.018077 54.9500000 0.018077 54.9527778 0.021538 54.9555556 0.025000 54.9583333 0.026731 54.9611111 0.025000 54.9638889 0.025000 54.9666667 0.030192 54.9694444 0.026731 54.9722222 0.025000 54.9750000 0.023269 54.9777778 0.023269 54.9805556 0.019808 54.9833333 0.023269 54.9861111 0.026731 54.9888889 0.030192 54.9916667 0.037115 54.9944444 0.042308 54.9972222 0.044038 55.0000000 0.044038 55.0027778 0.042308 55.0055556 0.035385 55.0083333 0.026731 55.0111111 0.026731 55.0138889 0.023269 55.0166667 0.019808 55.0194444 0.023269 55.0222222 0.023269 55.0250000 0.019808 55.0277778 0.021538 55.0305556 0.023269 55.0333333 0.018077 55.0361111 0.016346 55.0388889 0.010000 55.0416667 0.010000 55.0444444 0.010000 55.0472222 0.010000 55.0500000 0.010000 55.0527778 0.012885 55.0555556 0.012885 55.0583333 0.016346 55.0611111 0.014615 55.0638889 0.010000 55.0666667 0.010000 55.0694444 0.010000 55.0722222 0.010000 55.0750000 0.033654 55.0777778 0.075192 55.0805556 0.120192 55.0833333 0.144423 55.0861111 0.144423 55.0888889 0.113269 55.0916667 0.035385 55.0944444 0.010000 55.0972222 0.010000 55.1000000 0.010000 55.1027778 0.010000 55.1055556 0.010000 55.1083333 0.010000 55.1111111 0.010000 55.1138889 0.010000 55.1166667 0.010000 55.1194444 0.023269 55.1222222 0.042308 55.1250000 0.049231 55.1277778 0.052692 55.1305556 0.049231 55.1333333 0.038846 55.1361111 0.021538 55.1388889 0.012885 55.1416667 0.014615 55.1444444 0.014615 55.1472222 0.026731 55.1500000 0.035385 55.1527778 0.038846 55.1555556 0.040577 55.1583333 0.042308 55.1611111 0.045769 55.1638889 0.038846 55.1666667 0.021538 55.1694444 0.010000 55.1722222 0.010000 55.1750000 0.010000 55.1777778 0.010000 55.1805556 0.010000 55.1833333 0.010000 55.1861111 0.010000 55.1888889 0.019808 55.1916667 0.031923 55.1944444 0.037115 55.1972222 0.044038 55.2000000 0.047500 55.2027778 0.052692 55.2055556 0.050962 55.2083333 0.049231 55.2111111 0.047500 55.2138889 0.044038 55.2166667 0.049231 55.2194444 0.050962 55.2222222 0.054423 55.2250000 0.057885 55.2277778 0.061346 55.2305556 0.063077 55.2333333 0.059615 55.2361111 0.061346 55.2388889 0.059615 55.2416667 0.054423 55.2444444 0.052692 55.2472222 0.050962 55.2500000 0.050962 55.2527778 0.052692 55.2555556 0.059615 55.2583333 0.064808 55.2611111 0.070000 55.2638889 0.068269 55.2666667 0.068269 55.2694444 0.063077 55.2722222 0.061346 55.2750000 0.057885 55.2777778 0.054423 55.2805556 0.052692 55.2833333 0.052692 55.2861111 0.052692 55.2888889 0.057885 55.2916667 0.059615 55.2944444 0.064808 55.2972222 0.064808 55.3000000 0.061346 55.3027778 0.059615 55.3055556 0.057885 55.3083333 0.054423 55.3111111 0.052692 55.3138889 0.050962 55.3166667 0.050962 55.3194444 0.052692 55.3222222 0.057885 55.3250000 0.056154 55.3277778 0.056154 55.3305556 0.054423 55.3333333 0.049231 55.3361111 0.045769 55.3388889 0.044038 55.3416667 0.044038 55.3444444 0.042308 55.3472222 0.040577 55.3500000 0.042308 55.3527778 0.040577 55.3555556 0.040577 55.3583333 0.037115 55.3611111 0.038846 55.3638889 0.037115 55.3666667 0.031923 55.3694444 0.030192 55.3722222 0.016346 55.3750000 0.018077 55.3777778 0.014615 55.3805556 0.012885 55.3833333 0.011154 55.3861111 0.010000 55.3888889 0.010000 55.3916667 0.010000 55.3944444 0.011154 55.3972222 0.010000 55.4000000 0.010000 55.4027778 0.010000 55.4055556 0.010000 55.4083333 0.010000 55.4111111 0.010000 55.4138889 0.010000 55.4166667 0.010000 55.4194444 0.010000 55.4222222 0.010000 55.4250000 0.010000 55.4277778 0.010000 55.4305556 0.010000 55.4333333 0.010000 55.4361111 0.010000 56.0805556 0.019808 56.0833333 0.014615 56.0861111 0.014615 56.0888889 0.014615 56.0916667 0.023269 56.0944444 0.021538 56.0972222 0.026731 56.1000000 0.031923 56.1027778 0.028462 56.1055556 0.026731 56.1083333 0.028462 56.1111111 0.028462 56.1138889 0.028462 56.1166667 0.030192 56.1194444 0.031923 56.1222222 0.037115 56.1250000 0.035385 56.1277778 0.042308 56.1305556 0.042308 56.1333333 0.040577 56.1361111 0.040577 56.1388889 0.037115 56.1416667 0.030192 56.1444444 0.023269 56.1472222 0.021538 56.1500000 0.025000 56.1527778 0.030192 56.1555556 0.031923 56.1583333 0.035385 56.1611111 0.038846 56.1638889 0.038846 56.1666667 0.031923 56.1694444 0.028462 56.1722222 0.028462 56.1750000 0.025000 56.1777778 0.026731 56.1805556 0.021538 56.1833333 0.023269 56.1861111 0.023269 56.1888889 0.026731 56.1916667 0.025000 56.1944444 0.031923 56.1972222 0.033654 56.2000000 0.031923 56.2027778 0.023269 56.2055556 0.019808 56.2083333 0.012885 56.2111111 0.010000 56.2138889 0.010000 56.2166667 0.010000 56.2194444 0.010000 56.2222222 0.016346 56.2250000 0.014615 56.2277778 0.016346 56.2305556 0.012885 56.2333333 0.011154 56.2361111 0.011154 56.2388889 0.011154 56.2416667 0.010000 56.2444444 0.010000 56.2472222 0.010000 56.2500000 0.010000 56.2527778 0.010000 56.2555556 0.010000 56.2583333 0.010000 56.2611111 0.010000 56.2638889 0.030192 56.2666667 0.063077 56.2694444 0.099423 56.2722222 0.127115 56.2750000 0.140962 56.2777778 0.142692 56.2805556 0.127115 56.2833333 0.082115 56.2861111 0.010000 56.2888889 0.010000 56.2916667 0.010000 56.2944444 0.010000 56.2972222 0.010000 56.3000000 0.010000 56.3027778 0.010000 56.3055556 0.010000 56.3083333 0.045769 56.3111111 0.090769 56.3138889 0.123654 56.3166667 0.125385 56.3194444 0.135769 56.3222222 0.137500 56.3250000 0.130577 56.3277778 0.118462 56.3305556 0.089038 56.3333333 0.061346 56.3361111 0.038846 56.3388889 0.016346 56.3416667 0.010000 56.3444444 0.010000 56.3472222 0.012885 56.3500000 0.028462 56.3527778 0.038846 56.3555556 0.040577 56.3583333 0.037115 56.3611111 0.025000 56.3638889 0.011154 56.3666667 0.010000 56.3694444 0.010000 56.3722222 0.010000 56.3750000 0.010000 56.3777778 0.012885 56.3805556 0.023269 56.3833333 0.028462 56.3861111 0.038846 56.3888889 0.044038 56.3916667 0.052692 56.3944444 0.063077 56.3972222 0.070000 56.4000000 0.073462 56.4027778 0.071731 56.4055556 0.071731 56.4083333 0.066538 56.4111111 0.063077 56.4138889 0.068269 56.4166667 0.066538 56.4194444 0.070000 56.4222222 0.078654 56.4250000 0.078654 56.4277778 0.078654 56.4305556 0.080385 56.4333333 0.080385 56.4361111 0.078654 56.4388889 0.076923 56.4416667 0.073462 56.4444444 0.071731 56.4472222 0.073462 56.4500000 0.073462 56.4527778 0.076923 56.4555556 0.080385 56.4583333 0.082115 56.4611111 0.085577 56.4638889 0.085577 56.4666667 0.080385 56.4694444 0.080385 56.4722222 0.078654 56.4750000 0.076923 56.4777778 0.073462 56.4805556 0.071731 56.4833333 0.075192 56.4861111 0.078654 56.4888889 0.083846 56.4916667 0.082115 56.4944444 0.083846 56.4972222 0.085577 56.5000000 0.083846 56.5027778 0.075192 56.5055556 0.076923 56.5083333 0.071731 56.5111111 0.070000 56.5138889 0.068269 56.5166667 0.063077 56.5194444 0.064808 56.5222222 0.068269 56.5250000 0.066538 56.5277778 0.073462 56.5305556 0.071731 56.5333333 0.071731 56.5361111 0.063077 56.5388889 0.063077 56.5416667 0.059615 56.5444444 0.054423 56.5472222 0.054423 56.5500000 0.052692 56.5527778 0.057885 56.5555556 0.057885 56.5583333 0.056154 56.5611111 0.054423 56.5638889 0.050962 56.5666667 0.052692 56.5694444 0.044038 56.5722222 0.035385 56.5750000 0.026731 56.5777778 0.021538 56.5805556 0.025000 56.5833333 0.023269 56.5861111 0.025000 56.5888889 0.030192 56.5916667 0.026731 56.5944444 0.028462 56.5972222 0.025000 56.6000000 0.018077 56.6027778 0.016346 56.6055556 0.012885 56.6083333 0.010000 56.6111111 0.010000 56.6138889 0.010000 56.6166667 0.010000 56.6194444 0.010000 56.6222222 0.010000 56.6250000 0.010000 56.6277778 0.010000 57.3083333 0.035385 57.3111111 0.031923 57.3138889 0.033654 57.3166667 0.030192 57.3194444 0.031923 57.3222222 0.033654 57.3250000 0.037115 57.3277778 0.037115 57.3305556 0.035385 57.3333333 0.033654 57.3361111 0.033654 57.3388889 0.035385 57.3416667 0.035385 57.3444444 0.031923 57.3472222 0.031923 57.3500000 0.030192 57.3527778 0.031923 57.3555556 0.037115 57.3583333 0.044038 57.3611111 0.049231 57.3638889 0.057885 57.3666667 0.057885 57.3694444 0.057885 57.3722222 0.050962 57.3750000 0.047500 57.3777778 0.038846 57.3805556 0.035385 57.3833333 0.031923 57.3861111 0.028462 57.3888889 0.031923 57.3916667 0.038846 57.3944444 0.040577 57.3972222 0.040577 57.4000000 0.040577 57.4027778 0.040577 57.4055556 0.042308 57.4083333 0.038846 57.4111111 0.038846 57.4138889 0.035385 57.4166667 0.042308 57.4194444 0.050962 57.4222222 0.050962 57.4250000 0.054423 57.4277778 0.052692 57.4305556 0.056154 57.4333333 0.057885 57.4361111 0.049231 57.4388889 0.042308 57.4416667 0.038846 57.4444444 0.033654 57.4472222 0.028462 57.4500000 0.028462 57.4527778 0.026731 57.4555556 0.030192 57.4583333 0.035385 57.4611111 0.033654 57.4638889 0.035385 57.4666667 0.038846 57.4694444 0.033654 57.4722222 0.028462 57.4750000 0.025000 57.4777778 0.019808 57.4805556 0.012885 57.4833333 0.010000 57.4861111 0.010000 57.4888889 0.010000 57.4916667 0.010000 57.4944444 0.033654 57.4972222 0.068269 57.5000000 0.108077 57.5027778 0.140962 57.5055556 0.161731 57.5083333 0.163462 57.5111111 0.134038 57.5138889 0.073462 57.5166667 0.010000 57.5194444 0.010000 57.5222222 0.010000 57.5250000 0.010000 57.5277778 0.010000 57.5305556 0.010000 57.5333333 0.010000 57.5361111 0.010000 57.5388889 0.052692 57.5416667 0.099423 57.5444444 0.116731 57.5472222 0.121923 57.5500000 0.120192 57.5527778 0.102885 57.5555556 0.085577 57.5583333 0.061346 57.5611111 0.049231 57.5638889 0.045769 57.5666667 0.050962 57.5694444 0.047500 57.5722222 0.049231 57.5750000 0.052692 57.5777778 0.057885 57.5805556 0.056154 57.5833333 0.045769 57.5861111 0.030192 57.5888889 0.011154 57.5916667 0.010000 57.5944444 0.010000 57.5972222 0.010000 57.6000000 0.010000 57.6027778 0.021538 57.6055556 0.025000 57.6083333 0.038846 57.6111111 0.045769 57.6138889 0.050962 57.6166667 0.057885 57.6194444 0.054423 57.6222222 0.063077 57.6250000 0.066538 57.6277778 0.068269 57.6305556 0.070000 57.6333333 0.068269 57.6361111 0.064808 57.6388889 0.061346 57.6416667 0.063077 57.6444444 0.061346 57.6472222 0.061346 57.6500000 0.066538 57.6527778 0.064808 57.6555556 0.068269 57.6583333 0.070000 57.6611111 0.073462 57.6638889 0.075192 57.6666667 0.073462 57.6694444 0.070000 57.6722222 0.066538 57.6750000 0.063077 57.6777778 0.063077 57.6805556 0.063077 57.6833333 0.061346 57.6861111 0.071731 57.6888889 0.066538 57.6916667 0.073462 57.6944444 0.075192 57.6972222 0.076923 57.7000000 0.075192 57.7027778 0.071731 57.7055556 0.070000 57.7083333 0.064808 57.7111111 0.063077 57.7138889 0.063077 57.7166667 0.059615 57.7194444 0.063077 57.7222222 0.061346 57.7250000 0.066538 57.7277778 0.066538 57.7305556 0.070000 57.7333333 0.068269 57.7361111 0.064808 57.7388889 0.056154 57.7416667 0.056154 57.7444444 0.054423 57.7472222 0.054423 57.7500000 0.049231 57.7527778 0.050962 57.7555556 0.049231 57.7583333 0.049231 57.7611111 0.052692 57.7638889 0.054423 57.7666667 0.049231 57.7694444 0.045769 57.7722222 0.042308 57.7750000 0.033654 57.7777778 0.028462 57.7805556 0.026731 57.7833333 0.023269 57.7861111 0.021538 57.7888889 0.026731 57.7916667 0.023269 57.7944444 0.021538 57.7972222 0.021538 57.8000000 0.018077 57.8027778 0.010000 57.8055556 0.010000 57.8083333 0.010000 57.8111111 0.010000 57.8138889 0.010000 57.8166667 0.010000 57.8194444 0.010000 57.8222222 0.010000 57.8250000 0.010000 57.8277778 0.010000 57.8305556 0.010000 57.8333333 0.010000 57.8361111 0.010000 57.8388889 0.010000 57.8416667 0.010000 57.8444444 0.010000 57.8472222 0.010000 57.8500000 0.010000 57.8527778 0.010000 57.8555556 0.010000 58.5277778 0.010000 58.5305556 0.010000 58.5333333 0.010000 58.5361111 0.010000 58.5388889 0.010000 58.5416667 0.010000 58.5444444 0.010000 58.5472222 0.010000 58.5500000 0.010000 58.5527778 0.010000 58.5555556 0.010000 58.5583333 0.010000 58.5611111 0.010000 58.5638889 0.010000 58.5666667 0.010000 58.5694444 0.010000 58.5722222 0.010000 58.5750000 0.010000 58.5777778 0.010000 58.5805556 0.010000 58.5833333 0.010000 58.5861111 0.010000 58.5888889 0.010000 58.5916667 0.010000 58.5944444 0.010000 58.5972222 0.010000 58.6000000 0.010000 58.6027778 0.010000 58.6055556 0.010000 58.6083333 0.010000 58.6111111 0.010000 58.6138889 0.010000 58.6166667 0.010000 58.6194444 0.010000 58.6222222 0.010000 58.6250000 0.010000 58.6277778 0.010000 58.6305556 0.010000 58.6333333 0.010000 58.6361111 0.010000 58.6388889 0.010000 58.6416667 0.010000 58.6444444 0.010000 58.6472222 0.010000 58.6500000 0.010000 58.6527778 0.010000 58.6555556 0.010000 58.6583333 0.010000 58.6611111 0.010000 58.6638889 0.010000 58.6666667 0.010000 58.6694444 0.010000 58.6722222 0.010000 58.6750000 0.010000 58.6777778 0.010000 58.6805556 0.010000 58.6833333 0.010000 58.6861111 0.010000 58.6888889 0.010000 58.6916667 0.010000 58.6944444 0.010000 58.6972222 0.010000 58.7000000 0.010000 58.7027778 0.010000 58.7055556 0.010000 58.7083333 0.010000 58.7111111 0.010000 58.7138889 0.010000 58.7166667 0.010000 58.7194444 0.010000 58.7222222 0.049231 58.7250000 0.083846 58.7277778 0.106346 58.7305556 0.102885 58.7333333 0.066538 58.7361111 0.010000 58.7388889 0.010000 58.7416667 0.010000 58.7444444 0.010000 58.7472222 0.010000 58.7500000 0.010000 58.7527778 0.010000 58.7555556 0.010000 58.7583333 0.010000 58.7611111 0.044038 58.7638889 0.082115 58.7666667 0.095962 58.7694444 0.102885 58.7722222 0.097692 58.7750000 0.089038 58.7777778 0.068269 58.7805556 0.031923 58.7833333 0.010000 58.7861111 0.010000 58.7888889 0.010000 58.7916667 0.010000 58.7944444 0.010000 58.7972222 0.010000 58.8000000 0.010000 58.8027778 0.010000 58.8055556 0.010000 58.8083333 0.010000 58.8111111 0.010000 58.8138889 0.010000 58.8166667 0.010000 58.8194444 0.010000 58.8222222 0.010000 58.8250000 0.010000 58.8277778 0.010000 58.8305556 0.010000 58.8333333 0.010000 58.8361111 0.010000 58.8388889 0.010000 58.8416667 0.010000 58.8444444 0.010000 58.8472222 0.010000 58.8500000 0.010000 58.8527778 0.010000 58.8555556 0.010000 58.8583333 0.010000 58.8611111 0.010000 58.8638889 0.010000 58.8666667 0.010000 58.8694444 0.010000 58.8722222 0.010000 58.8750000 0.010000 58.8777778 0.010000 58.8805556 0.010000 58.8833333 0.010000 58.8861111 0.010000 58.8888889 0.010000 58.8916667 0.010000 58.8944444 0.010000 58.8972222 0.011154 58.9000000 0.011154 58.9027778 0.011154 58.9055556 0.010000 58.9083333 0.010000 58.9111111 0.010000 58.9138889 0.010000 58.9166667 0.010000 58.9194444 0.010000 58.9222222 0.010000 58.9250000 0.010000 58.9277778 0.010000 58.9305556 0.011154 58.9333333 0.011154 58.9361111 0.010000 58.9388889 0.010000 58.9416667 0.010000 58.9444444 0.010000 58.9472222 0.010000 58.9500000 0.010000 58.9527778 0.010000 58.9555556 0.010000 58.9583333 0.010000 58.9611111 0.010000 58.9638889 0.010000 58.9666667 0.010000 58.9694444 0.010000 58.9722222 0.010000 58.9750000 0.010000 58.9777778 0.010000 58.9805556 0.010000 58.9833333 0.010000 58.9861111 0.010000 58.9888889 0.010000 58.9916667 0.010000 58.9944444 0.010000 58.9972222 0.010000 59.0000000 0.010000 59.0027778 0.010000 59.0055556 0.010000 59.0083333 0.010000 59.0111111 0.010000 59.0138889 0.010000 59.0166667 0.010000 59.0194444 0.010000 59.0222222 0.010000 59.0250000 0.010000 59.0277778 0.010000 59.0305556 0.010000 59.0333333 0.010000 59.0361111 0.010000 59.0388889 0.010000 59.0416667 0.010000 59.0444444 0.010000 59.0472222 0.010000 59.0500000 0.010000 59.0527778 0.010000 59.0555556 0.010000 59.0583333 0.010000 59.0611111 0.010000 59.0638889 0.010000 59.0666667 0.010000 59.0694444 0.010000 59.0722222 0.010000 59.0750000 0.010000 59.7944444 0.010000 59.7972222 0.010000 59.8000000 0.010000 59.8027778 0.010000 59.8055556 0.010000 59.8083333 0.010000 59.8111111 0.010000 59.8138889 0.010000 59.8166667 0.010000 59.8194444 0.010000 59.8222222 0.010000 59.8250000 0.010000 59.8277778 0.010000 59.8305556 0.010000 59.8333333 0.010000 59.8361111 0.010000 59.8388889 0.010000 59.8416667 0.010000 59.8444444 0.010000 59.8472222 0.010000 59.8500000 0.010000 59.8527778 0.010000 59.8555556 0.010000 59.8583333 0.010000 59.8611111 0.010000 59.8638889 0.010000 59.8666667 0.010000 59.8694444 0.010000 59.8722222 0.010000 59.8750000 0.010000 59.8777778 0.010000 59.8805556 0.010000 59.8833333 0.010000 59.8861111 0.010000 59.8888889 0.010000 59.8916667 0.010000 59.8944444 0.012885 59.8972222 0.018077 59.9000000 0.021538 59.9027778 0.023269 59.9055556 0.019808 59.9083333 0.016346 59.9111111 0.011154 59.9138889 0.011154 59.9166667 0.012885 59.9194444 0.016346 59.9222222 0.014615 59.9250000 0.016346 59.9277778 0.011154 59.9305556 0.010000 59.9333333 0.010000 59.9361111 0.010000 59.9388889 0.010000 59.9416667 0.010000 59.9444444 0.010000 59.9472222 0.010000 59.9500000 0.010000 59.9527778 0.010000 59.9555556 0.010000 59.9583333 0.010000 59.9611111 0.010000 59.9638889 0.010000 59.9666667 0.010000 59.9694444 0.010000 59.9722222 0.010000 59.9750000 0.010000 59.9777778 0.047500 59.9805556 0.094231 59.9833333 0.125385 59.9861111 0.144423 59.9888889 0.142692 59.9916667 0.118462 59.9944444 0.059615 59.9972222 0.010000 60.0000000 0.010000 60.0027778 0.010000 60.0055556 0.010000 60.0083333 0.010000 60.0111111 0.010000 60.0138889 0.010000 60.0166667 0.010000 60.0194444 0.010000 60.0222222 0.010000 60.0250000 0.010000 60.0277778 0.010000 60.0305556 0.010000 60.0333333 0.010000 60.0361111 0.010000 60.0388889 0.010000 60.0416667 0.010000 60.0444444 0.010000 60.0472222 0.010000 60.0500000 0.016346 60.0527778 0.025000 60.0555556 0.030192 60.0583333 0.025000 60.0611111 0.026731 60.0638889 0.037115 60.0666667 0.044038 60.0694444 0.035385 60.0722222 0.025000 60.0750000 0.011154 60.0777778 0.010000 60.0805556 0.010000 60.0833333 0.010000 60.0861111 0.010000 60.0888889 0.010000 60.0916667 0.014615 60.0944444 0.026731 60.0972222 0.035385 60.1000000 0.044038 60.1027778 0.049231 60.1055556 0.049231 60.1083333 0.049231 60.1111111 0.054423 60.1138889 0.054423 60.1166667 0.056154 60.1194444 0.061346 60.1222222 0.066538 60.1250000 0.070000 60.1277778 0.071731 60.1305556 0.075192 60.1333333 0.078654 60.1361111 0.075192 60.1388889 0.070000 60.1416667 0.068269 60.1444444 0.063077 60.1472222 0.066538 60.1500000 0.076923 60.1527778 0.076923 60.1555556 0.076923 60.1583333 0.076923 60.1611111 0.080385 60.1638889 0.078654 60.1666667 0.080385 60.1694444 0.080385 60.1722222 0.080385 60.1750000 0.078654 60.1777778 0.075192 60.1805556 0.068269 60.1833333 0.064808 60.1861111 0.070000 60.1888889 0.073462 60.1916667 0.082115 60.1944444 0.083846 60.1972222 0.087308 60.2000000 0.090769 60.2027778 0.087308 60.2055556 0.082115 60.2083333 0.075192 60.2111111 0.076923 60.2138889 0.068269 60.2166667 0.073462 60.2194444 0.073462 60.2222222 0.076923 60.2250000 0.080385 60.2277778 0.080385 60.2305556 0.085577 60.2333333 0.083846 60.2361111 0.080385 60.2388889 0.073462 60.2416667 0.073462 60.2444444 0.070000 60.2472222 0.068269 60.2500000 0.063077 60.2527778 0.061346 60.2555556 0.061346 60.2583333 0.059615 60.2611111 0.056154 60.2638889 0.059615 60.2666667 0.059615 60.2694444 0.057885 60.2722222 0.052692 60.2750000 0.049231 60.2777778 0.042308 60.2805556 0.033654 60.2833333 0.031923 60.2861111 0.030192 60.2888889 0.030192 60.2916667 0.030192 60.2944444 0.026731 60.2972222 0.025000 60.3000000 0.021538 60.3027778 0.018077 60.3055556 0.010000 60.3083333 0.010000 60.3111111 0.010000 60.3138889 0.010000 60.3166667 0.010000 60.3194444 0.010000 60.3222222 0.010000 60.3250000 0.010000 60.3277778 0.010000 60.3305556 0.010000 60.3333333 0.010000 60.3361111 0.010000 60.3388889 0.010000 60.3416667 0.010000 61.0027778 0.023269 61.0055556 0.023269 61.0083333 0.018077 61.0111111 0.018077 61.0138889 0.016346 61.0166667 0.014615 61.0194444 0.018077 61.0222222 0.021538 61.0250000 0.021538 61.0277778 0.028462 61.0305556 0.028462 61.0333333 0.028462 61.0361111 0.026731 61.0388889 0.026731 61.0416667 0.021538 61.0444444 0.023269 61.0472222 0.021538 61.0500000 0.019808 61.0527778 0.023269 61.0555556 0.025000 61.0583333 0.030192 61.0611111 0.033654 61.0638889 0.040577 61.0666667 0.038846 61.0694444 0.040577 61.0722222 0.044038 61.0750000 0.038846 61.0777778 0.033654 61.0805556 0.028462 61.0833333 0.021538 61.0861111 0.021538 61.0888889 0.021538 61.0916667 0.023269 61.0944444 0.030192 61.0972222 0.031923 61.1000000 0.037115 61.1027778 0.031923 61.1055556 0.035385 61.1083333 0.031923 61.1111111 0.030192 61.1138889 0.033654 61.1166667 0.030192 61.1194444 0.030192 61.1222222 0.035385 61.1250000 0.038846 61.1277778 0.037115 61.1305556 0.040577 61.1333333 0.038846 61.1361111 0.031923 61.1388889 0.030192 61.1416667 0.028462 61.1444444 0.019808 61.1472222 0.018077 61.1500000 0.014615 61.1527778 0.014615 61.1555556 0.011154 61.1583333 0.014615 61.1611111 0.018077 61.1638889 0.021538 61.1666667 0.021538 61.1694444 0.019808 61.1722222 0.011154 61.1750000 0.010000 61.1777778 0.010000 61.1805556 0.010000 61.1833333 0.010000 61.1861111 0.023269 61.1888889 0.059615 61.1916667 0.094231 61.1944444 0.123654 61.1972222 0.137500 61.2000000 0.127115 61.2027778 0.083846 61.2055556 0.018077 61.2083333 0.010000 61.2111111 0.010000 61.2138889 0.010000 61.2166667 0.010000 61.2194444 0.010000 61.2222222 0.010000 61.2250000 0.010000 61.2277778 0.030192 61.2305556 0.097692 61.2333333 0.142692 61.2361111 0.161731 61.2388889 0.166923 61.2416667 0.163462 61.2444444 0.146154 61.2472222 0.118462 61.2500000 0.089038 61.2527778 0.061346 61.2555556 0.045769 61.2583333 0.035385 61.2611111 0.033654 61.2638889 0.033654 61.2666667 0.037115 61.2694444 0.038846 61.2722222 0.047500 61.2750000 0.050962 61.2777778 0.045769 61.2805556 0.037115 61.2833333 0.019808 61.2861111 0.010000 61.2888889 0.010000 61.2916667 0.010000 61.2944444 0.010000 61.2972222 0.010000 61.3000000 0.010000 61.3027778 0.014615 61.3055556 0.023269 61.3083333 0.026731 61.3111111 0.037115 61.3138889 0.038846 61.3166667 0.049231 61.3194444 0.052692 61.3222222 0.052692 61.3250000 0.057885 61.3277778 0.057885 61.3305556 0.061346 61.3333333 0.068269 61.3361111 0.063077 61.3388889 0.061346 61.3416667 0.057885 61.3444444 0.061346 61.3472222 0.057885 61.3500000 0.057885 61.3527778 0.061346 61.3555556 0.063077 61.3583333 0.064808 61.3611111 0.070000 61.3638889 0.066538 61.3666667 0.071731 61.3694444 0.071731 61.3722222 0.068269 61.3750000 0.061346 61.3777778 0.066538 61.3805556 0.064808 61.3833333 0.063077 61.3861111 0.066538 61.3888889 0.068269 61.3916667 0.070000 61.3944444 0.073462 61.3972222 0.073462 61.4000000 0.078654 61.4027778 0.073462 61.4055556 0.071731 61.4083333 0.066538 61.4111111 0.063077 61.4138889 0.063077 61.4166667 0.061346 61.4194444 0.068269 61.4222222 0.070000 61.4250000 0.073462 61.4277778 0.076923 61.4305556 0.076923 61.4333333 0.078654 61.4361111 0.073462 61.4388889 0.064808 61.4416667 0.063077 61.4444444 0.063077 61.4472222 0.061346 61.4500000 0.054423 61.4527778 0.052692 61.4555556 0.059615 61.4583333 0.061346 61.4611111 0.059615 61.4638889 0.061346 61.4666667 0.059615 61.4694444 0.061346 61.4722222 0.059615 61.4750000 0.054423 61.4777778 0.049231 61.4805556 0.042308 61.4833333 0.040577 61.4861111 0.040577 61.4888889 0.040577 61.4916667 0.038846 61.4944444 0.038846 61.4972222 0.038846 61.5000000 0.040577 61.5027778 0.033654 61.5055556 0.028462 61.5083333 0.023269 61.5111111 0.021538 61.5138889 0.016346 61.5166667 0.016346 61.5194444 0.016346 61.5222222 0.014615 61.5250000 0.018077 61.5277778 0.012885 61.5305556 0.012885 61.5333333 0.012885 61.5361111 0.010000 61.5388889 0.010000 61.5416667 0.010000 61.5444444 0.010000 61.5472222 0.010000 61.5500000 0.010000 62.3222222 0.038846 62.3250000 0.045769 62.3277778 0.044038 62.3305556 0.044038 62.3333333 0.047500 62.3361111 0.042308 62.3388889 0.042308 62.3416667 0.042308 62.3444444 0.035385 62.3472222 0.031923 62.3500000 0.037115 62.3527778 0.035385 62.3555556 0.037115 62.3583333 0.037115 62.3611111 0.042308 62.3638889 0.038846 62.3666667 0.040577 62.3694444 0.042308 62.3722222 0.040577 62.3750000 0.047500 62.3777778 0.044038 62.3805556 0.044038 62.3833333 0.040577 62.3861111 0.038846 62.3888889 0.038846 62.3916667 0.040577 62.3944444 0.040577 62.3972222 0.050962 62.4000000 0.052692 62.4027778 0.049231 62.4055556 0.047500 62.4083333 0.044038 62.4111111 0.040577 62.4138889 0.038846 62.4166667 0.040577 62.4194444 0.040577 62.4222222 0.047500 62.4250000 0.056154 62.4277778 0.063077 62.4305556 0.066538 62.4333333 0.066538 62.4361111 0.064808 62.4388889 0.059615 62.4416667 0.052692 62.4444444 0.045769 62.4472222 0.042308 62.4500000 0.040577 62.4527778 0.035385 62.4555556 0.035385 62.4583333 0.040577 62.4611111 0.035385 62.4638889 0.038846 62.4666667 0.044038 62.4694444 0.042308 62.4722222 0.035385 62.4750000 0.033654 62.4777778 0.030192 62.4805556 0.028462 62.4833333 0.028462 62.4861111 0.026731 62.4888889 0.030192 62.4916667 0.025000 62.4944444 0.019808 62.4972222 0.018077 62.5000000 0.012885 62.5027778 0.019808 62.5055556 0.042308 62.5083333 0.075192 62.5111111 0.109808 62.5138889 0.140962 62.5166667 0.153077 62.5194444 0.154808 62.5222222 0.128846 62.5250000 0.071731 62.5277778 0.010000 62.5305556 0.010000 62.5333333 0.010000 62.5361111 0.010000 62.5388889 0.010000 62.5416667 0.010000 62.5444444 0.010000 62.5472222 0.010000 62.5500000 0.061346 62.5527778 0.108077 62.5555556 0.144423 62.5583333 0.163462 62.5611111 0.173846 62.5638889 0.180769 62.5666667 0.175577 62.5694444 0.158269 62.5722222 0.128846 62.5750000 0.095962 62.5777778 0.064808 62.5805556 0.047500 62.5833333 0.035385 62.5861111 0.026731 62.5888889 0.035385 62.5916667 0.042308 62.5944444 0.054423 62.5972222 0.061346 62.6000000 0.059615 62.6027778 0.045769 62.6055556 0.030192 62.6083333 0.012885 62.6111111 0.010000 62.6138889 0.010000 62.6166667 0.011154 62.6194444 0.021538 62.6222222 0.033654 62.6250000 0.050962 62.6277778 0.063077 62.6305556 0.071731 62.6333333 0.080385 62.6361111 0.082115 62.6388889 0.078654 62.6416667 0.078654 62.6444444 0.076923 62.6472222 0.080385 62.6500000 0.083846 62.6527778 0.085577 62.6555556 0.089038 62.6583333 0.094231 62.6611111 0.099423 62.6638889 0.101154 62.6666667 0.099423 62.6694444 0.097692 62.6722222 0.094231 62.6750000 0.095962 62.6777778 0.095962 62.6805556 0.092500 62.6833333 0.090769 62.6861111 0.095962 62.6888889 0.097692 62.6916667 0.102885 62.6944444 0.102885 62.6972222 0.106346 62.7000000 0.104615 62.7027778 0.104615 62.7055556 0.101154 62.7083333 0.095962 62.7111111 0.095962 62.7138889 0.090769 62.7166667 0.094231 62.7194444 0.095962 62.7222222 0.099423 62.7250000 0.097692 62.7277778 0.102885 62.7305556 0.102885 62.7333333 0.101154 62.7361111 0.101154 62.7388889 0.099423 62.7416667 0.090769 62.7444444 0.090769 62.7472222 0.089038 62.7500000 0.089038 62.7527778 0.090769 62.7555556 0.090769 62.7583333 0.090769 62.7611111 0.094231 62.7638889 0.094231 62.7666667 0.097692 62.7694444 0.095962 62.7722222 0.092500 62.7750000 0.087308 62.7777778 0.087308 62.7805556 0.080385 62.7833333 0.076923 62.7861111 0.080385 62.7888889 0.078654 62.7916667 0.076923 62.7944444 0.076923 62.7972222 0.073462 62.8000000 0.071731 62.8027778 0.068269 62.8055556 0.063077 62.8083333 0.059615 62.8111111 0.057885 62.8138889 0.049231 62.8166667 0.047500 62.8194444 0.047500 62.8222222 0.042308 62.8250000 0.040577 62.8277778 0.042308 62.8305556 0.042308 62.8333333 0.042308 62.8361111 0.040577 62.8388889 0.038846 62.8416667 0.037115 62.8444444 0.033654 62.8472222 0.026731 62.8500000 0.025000 62.8527778 0.016346 62.8555556 0.018077 62.8583333 0.014615 62.8611111 0.018077 62.8638889 0.014615 62.8666667 0.018077 62.8694444 0.012885 63.6111111 0.082115 63.6138889 0.075192 63.6166667 0.078654 63.6194444 0.078654 63.6222222 0.078654 63.6250000 0.082115 63.6277778 0.080385 63.6305556 0.085577 63.6333333 0.083846 63.6361111 0.087308 63.6388889 0.083846 63.6416667 0.082115 63.6444444 0.076923 63.6472222 0.082115 63.6500000 0.080385 63.6527778 0.080385 63.6555556 0.083846 63.6583333 0.085577 63.6611111 0.089038 63.6638889 0.090769 63.6666667 0.094231 63.6694444 0.092500 63.6722222 0.094231 63.6750000 0.090769 63.6777778 0.085577 63.6805556 0.080385 63.6833333 0.080385 63.6861111 0.080385 63.6888889 0.080385 63.6916667 0.085577 63.6944444 0.087308 63.6972222 0.095962 63.7000000 0.099423 63.7027778 0.099423 63.7055556 0.102885 63.7083333 0.102885 63.7111111 0.104615 63.7138889 0.099423 63.7166667 0.092500 63.7194444 0.090769 63.7222222 0.089038 63.7250000 0.094231 63.7277778 0.094231 63.7305556 0.090769 63.7333333 0.087308 63.7361111 0.083846 63.7388889 0.080385 63.7416667 0.083846 63.7444444 0.073462 63.7472222 0.075192 63.7500000 0.073462 63.7527778 0.075192 63.7555556 0.073462 63.7583333 0.073462 63.7611111 0.076923 63.7638889 0.076923 63.7666667 0.082115 63.7694444 0.080385 63.7722222 0.076923 63.7750000 0.075192 63.7777778 0.061346 63.7805556 0.052692 63.7833333 0.045769 63.7861111 0.047500 63.7888889 0.066538 63.7916667 0.095962 63.7944444 0.135769 63.7972222 0.173846 63.8000000 0.199808 63.8027778 0.211923 63.8055556 0.206731 63.8083333 0.185962 63.8111111 0.135769 63.8138889 0.056154 63.8166667 0.010000 63.8194444 0.010000 63.8222222 0.010000 63.8250000 0.010000 63.8277778 0.010000 63.8305556 0.010000 63.8333333 0.010000 63.8361111 0.056154 63.8388889 0.106346 63.8416667 0.146154 63.8444444 0.168654 63.8472222 0.175577 63.8500000 0.184231 63.8527778 0.182500 63.8555556 0.175577 63.8583333 0.163462 63.8611111 0.137500 63.8638889 0.116731 63.8666667 0.095962 63.8694444 0.085577 63.8722222 0.078654 63.8750000 0.075192 63.8777778 0.076923 63.8805556 0.078654 63.8833333 0.089038 63.8861111 0.095962 63.8888889 0.099423 63.8916667 0.092500 63.8944444 0.078654 63.8972222 0.068269 63.9000000 0.056154 63.9027778 0.045769 63.9055556 0.044038 63.9083333 0.049231 63.9111111 0.054423 63.9138889 0.061346 63.9166667 0.070000 63.9194444 0.080385 63.9222222 0.089038 63.9250000 0.094231 63.9277778 0.108077 63.9305556 0.115000 63.9333333 0.121923 63.9361111 0.123654 63.9388889 0.123654 63.9416667 0.120192 63.9444444 0.118462 63.9472222 0.113269 63.9500000 0.111538 63.9527778 0.116731 63.9555556 0.121923 63.9583333 0.123654 63.9611111 0.130577 63.9638889 0.132308 63.9666667 0.128846 63.9694444 0.132308 63.9722222 0.128846 63.9750000 0.123654 63.9777778 0.125385 63.9805556 0.125385 63.9833333 0.127115 63.9861111 0.127115 63.9888889 0.128846 63.9916667 0.128846 63.9944444 0.132308 63.9972222 0.135769 64.0000000 0.137500 64.0027778 0.134038 64.0055556 0.139231 64.0083333 0.134038 64.0111111 0.130577 64.0138889 0.130577 64.0166667 0.128846 64.0194444 0.127115 64.0222222 0.132308 64.0250000 0.135769 64.0277778 0.140962 64.0305556 0.139231 64.0333333 0.140962 64.0361111 0.139231 64.0388889 0.137500 64.0416667 0.130577 64.0444444 0.128846 64.0472222 0.127115 64.0500000 0.125385 64.0527778 0.123654 64.0555556 0.128846 64.0583333 0.130577 64.0611111 0.130577 64.0638889 0.132308 64.0666667 0.132308 64.0694444 0.127115 64.0722222 0.125385 64.0750000 0.123654 64.0777778 0.121923 64.0805556 0.118462 64.0833333 0.121923 64.0861111 0.116731 64.0888889 0.121923 64.0916667 0.118462 64.0944444 0.118462 64.0972222 0.120192 64.1000000 0.116731 64.1027778 0.115000 64.1055556 0.111538 64.1083333 0.104615 64.1111111 0.104615 64.1138889 0.097692 64.1166667 0.094231 64.1194444 0.092500 64.1222222 0.092500 64.1250000 0.092500 64.1277778 0.092500 64.1305556 0.094231 64.1333333 0.094231 64.1361111 0.085577 64.1388889 0.083846 64.1416667 0.080385 64.1444444 0.075192 64.1472222 0.070000 64.1500000 0.068269 64.1527778 0.066538 64.1555556 0.063077 64.1583333 0.061346 64.8694444 0.102885 64.8722222 0.097692 64.8750000 0.095962 64.8777778 0.099423 64.8805556 0.094231 64.8833333 0.094231 64.8861111 0.095962 64.8888889 0.092500 64.8916667 0.095962 64.8944444 0.102885 64.8972222 0.104615 64.9000000 0.101154 64.9027778 0.104615 64.9055556 0.102885 64.9083333 0.099423 64.9111111 0.095962 64.9138889 0.092500 64.9166667 0.094231 64.9194444 0.090769 64.9222222 0.089038 64.9250000 0.094231 64.9277778 0.097692 64.9305556 0.099423 64.9333333 0.102885 64.9361111 0.104615 64.9388889 0.097692 64.9416667 0.102885 64.9444444 0.095962 64.9472222 0.094231 64.9500000 0.092500 64.9527778 0.094231 64.9555556 0.102885 64.9583333 0.104615 64.9611111 0.111538 64.9638889 0.111538 64.9666667 0.113269 64.9694444 0.106346 64.9722222 0.109808 64.9750000 0.108077 64.9777778 0.108077 64.9805556 0.113269 64.9833333 0.113269 64.9861111 0.115000 64.9888889 0.113269 64.9916667 0.111538 64.9944444 0.113269 64.9972222 0.115000 65.0000000 0.109808 65.0027778 0.108077 65.0055556 0.102885 65.0083333 0.099423 65.0111111 0.095962 65.0138889 0.095962 65.0166667 0.090769 65.0194444 0.094231 65.0222222 0.095962 65.0250000 0.101154 65.0277778 0.101154 65.0305556 0.102885 65.0333333 0.106346 65.0361111 0.102885 65.0388889 0.097692 65.0416667 0.092500 65.0444444 0.083846 65.0472222 0.075192 65.0500000 0.073462 65.0527778 0.076923 65.0555556 0.101154 65.0583333 0.140962 65.0611111 0.185962 65.0638889 0.222308 65.0666667 0.248269 65.0694444 0.246538 65.0722222 0.213654 65.0750000 0.140962 65.0777778 0.045769 65.0805556 0.010000 65.0833333 0.010000 65.0861111 0.010000 65.0888889 0.010000 65.0916667 0.010000 65.0944444 0.010000 65.0972222 0.011154 65.1000000 0.076923 65.1027778 0.121923 65.1055556 0.144423 65.1083333 0.146154 65.1111111 0.142692 65.1138889 0.135769 65.1166667 0.121923 65.1194444 0.108077 65.1222222 0.097692 65.1250000 0.095962 65.1277778 0.097692 65.1305556 0.108077 65.1333333 0.113269 65.1361111 0.116731 65.1388889 0.125385 65.1416667 0.120192 65.1444444 0.113269 65.1472222 0.101154 65.1500000 0.094231 65.1527778 0.075192 65.1555556 0.076923 65.1583333 0.078654 65.1611111 0.089038 65.1638889 0.099423 65.1666667 0.108077 65.1694444 0.120192 65.1722222 0.128846 65.1750000 0.135769 65.1777778 0.137500 65.1805556 0.142692 65.1833333 0.139231 65.1861111 0.140962 65.1888889 0.142692 65.1916667 0.144423 65.1944444 0.151346 65.1972222 0.149615 65.2000000 0.151346 65.2027778 0.153077 65.2055556 0.153077 65.2083333 0.153077 65.2111111 0.158269 65.2138889 0.154808 65.2166667 0.156538 65.2194444 0.153077 65.2222222 0.154808 65.2250000 0.154808 65.2277778 0.154808 65.2305556 0.161731 65.2333333 0.161731 65.2361111 0.158269 65.2388889 0.154808 65.2416667 0.153077 65.2444444 0.153077 65.2472222 0.147885 65.2500000 0.147885 65.2527778 0.151346 65.2555556 0.153077 65.2583333 0.160000 65.2611111 0.158269 65.2638889 0.153077 65.2666667 0.154808 65.2694444 0.156538 65.2722222 0.158269 65.2750000 0.153077 65.2777778 0.151346 65.2805556 0.151346 65.2833333 0.153077 65.2861111 0.149615 65.2888889 0.151346 65.2916667 0.151346 65.2944444 0.153077 65.2972222 0.149615 65.3000000 0.147885 65.3027778 0.151346 65.3055556 0.147885 65.3083333 0.144423 65.3111111 0.137500 65.3138889 0.135769 65.3166667 0.128846 65.3194444 0.125385 65.3222222 0.120192 65.3250000 0.123654 65.3277778 0.127115 65.3305556 0.125385 65.3333333 0.127115 65.3361111 0.121923 65.3388889 0.115000 65.3416667 0.111538 65.3444444 0.102885 65.3472222 0.095962 65.3500000 0.094231 65.3527778 0.089038 65.3555556 0.089038 65.3583333 0.089038 65.3611111 0.089038 65.3638889 0.085577 65.3666667 0.085577 65.3694444 0.082115 65.3722222 0.073462 65.3750000 0.071731 65.3777778 0.066538 65.3805556 0.061346 65.3833333 0.057885 65.3861111 0.050962 65.3888889 0.050962 65.3916667 0.049231 65.3944444 0.050962 65.3972222 0.050962 65.4000000 0.050962 65.4027778 0.044038 65.4055556 0.045769 65.4083333 0.040577 65.4111111 0.031923 65.4138889 0.031923 65.4166667 0.028462 66.0833333 0.071731 66.0861111 0.075192 66.0888889 0.073462 66.0916667 0.076923 66.0944444 0.080385 66.0972222 0.082115 66.1000000 0.082115 66.1027778 0.082115 66.1055556 0.083846 66.1083333 0.078654 66.1111111 0.075192 66.1138889 0.075192 66.1166667 0.071731 66.1194444 0.071731 66.1222222 0.068269 66.1250000 0.073462 66.1277778 0.076923 66.1305556 0.076923 66.1333333 0.082115 66.1361111 0.083846 66.1388889 0.087308 66.1416667 0.080385 66.1444444 0.080385 66.1472222 0.076923 66.1500000 0.076923 66.1527778 0.073462 66.1555556 0.075192 66.1583333 0.085577 66.1611111 0.085577 66.1638889 0.083846 66.1666667 0.085577 66.1694444 0.085577 66.1722222 0.082115 66.1750000 0.082115 66.1777778 0.080385 66.1805556 0.080385 66.1833333 0.078654 66.1861111 0.080385 66.1888889 0.085577 66.1916667 0.087308 66.1944444 0.095962 66.1972222 0.102885 66.2000000 0.102885 66.2027778 0.101154 66.2055556 0.094231 66.2083333 0.089038 66.2111111 0.082115 66.2138889 0.075192 66.2166667 0.071731 66.2194444 0.068269 66.2222222 0.071731 66.2250000 0.070000 66.2277778 0.076923 66.2305556 0.076923 66.2333333 0.076923 66.2361111 0.076923 66.2388889 0.076923 66.2416667 0.073462 66.2444444 0.070000 66.2472222 0.066538 66.2500000 0.066538 66.2527778 0.061346 66.2555556 0.063077 66.2583333 0.054423 66.2611111 0.047500 66.2638889 0.054423 66.2666667 0.073462 66.2694444 0.101154 66.2722222 0.142692 66.2750000 0.179038 66.2777778 0.196346 66.2805556 0.199808 66.2833333 0.175577 66.2861111 0.125385 66.2888889 0.042308 66.2916667 0.010000 66.2944444 0.010000 66.2972222 0.010000 66.3000000 0.010000 66.3027778 0.010000 66.3055556 0.010000 66.3083333 0.030192 66.3111111 0.104615 66.3138889 0.156538 66.3166667 0.189423 66.3194444 0.210192 66.3222222 0.217115 66.3250000 0.217115 66.3277778 0.215385 66.3305556 0.198077 66.3333333 0.173846 66.3361111 0.140962 66.3388889 0.109808 66.3416667 0.090769 66.3444444 0.073462 66.3472222 0.068269 66.3500000 0.071731 66.3527778 0.080385 66.3555556 0.092500 66.3583333 0.101154 66.3611111 0.094231 66.3638889 0.078654 66.3666667 0.061346 66.3694444 0.045769 66.3722222 0.038846 66.3750000 0.037115 66.3777778 0.040577 66.3805556 0.054423 66.3833333 0.063077 66.3861111 0.071731 66.3888889 0.082115 66.3916667 0.092500 66.3944444 0.109808 66.3972222 0.116731 66.4000000 0.120192 66.4027778 0.121923 66.4055556 0.121923 66.4083333 0.116731 66.4111111 0.116731 66.4138889 0.116731 66.4166667 0.116731 66.4194444 0.116731 66.4222222 0.118462 66.4250000 0.118462 66.4277778 0.127115 66.4305556 0.130577 66.4333333 0.132308 66.4361111 0.134038 66.4388889 0.130577 66.4416667 0.127115 66.4444444 0.127115 66.4472222 0.123654 66.4500000 0.123654 66.4527778 0.125385 66.4555556 0.125385 66.4583333 0.130577 66.4611111 0.134038 66.4638889 0.134038 66.4666667 0.137500 66.4694444 0.137500 66.4722222 0.130577 66.4750000 0.128846 66.4777778 0.127115 66.4805556 0.125385 66.4833333 0.121923 66.4861111 0.121923 66.4888889 0.120192 66.4916667 0.128846 66.4944444 0.130577 66.4972222 0.128846 66.5000000 0.132308 66.5027778 0.130577 66.5055556 0.125385 66.5083333 0.125385 66.5111111 0.120192 66.5138889 0.118462 66.5166667 0.118462 66.5194444 0.118462 66.5222222 0.118462 66.5250000 0.121923 66.5277778 0.120192 66.5305556 0.120192 66.5333333 0.118462 66.5361111 0.118462 66.5388889 0.118462 66.5416667 0.113269 66.5444444 0.109808 66.5472222 0.111538 66.5500000 0.101154 66.5527778 0.099423 66.5555556 0.097692 66.5583333 0.099423 66.5611111 0.099423 66.5638889 0.095962 66.5666667 0.090769 66.5694444 0.092500 66.5722222 0.092500 66.5750000 0.085577 66.5777778 0.082115 66.5805556 0.080385 66.5833333 0.073462 66.5861111 0.073462 66.5888889 0.066538 66.5916667 0.066538 66.5944444 0.068269 66.5972222 0.064808 66.6000000 0.068269 66.6027778 0.064808 66.6055556 0.057885 66.6083333 0.052692 66.6111111 0.049231 66.6138889 0.045769 66.6166667 0.042308 66.6194444 0.044038 66.6222222 0.044038 66.6250000 0.044038 66.6277778 0.045769 66.6305556 0.045769 67.2944444 0.066538 67.2972222 0.066538 67.3000000 0.068269 67.3027778 0.071731 67.3055556 0.070000 67.3083333 0.064808 67.3111111 0.064808 67.3138889 0.061346 67.3166667 0.066538 67.3194444 0.064808 67.3222222 0.063077 67.3250000 0.066538 67.3277778 0.071731 67.3305556 0.070000 67.3333333 0.071731 67.3361111 0.073462 67.3388889 0.070000 67.3416667 0.068269 67.3444444 0.066538 67.3472222 0.070000 67.3500000 0.066538 67.3527778 0.066538 67.3555556 0.066538 67.3583333 0.068269 67.3611111 0.071731 67.3638889 0.075192 67.3666667 0.078654 67.3694444 0.075192 67.3722222 0.076923 67.3750000 0.071731 67.3777778 0.070000 67.3805556 0.070000 67.3833333 0.071731 67.3861111 0.073462 67.3888889 0.073462 67.3916667 0.076923 67.3944444 0.082115 67.3972222 0.082115 67.4000000 0.090769 67.4027778 0.094231 67.4055556 0.090769 67.4083333 0.087308 67.4111111 0.083846 67.4138889 0.078654 67.4166667 0.068269 67.4194444 0.063077 67.4222222 0.063077 67.4250000 0.061346 67.4277778 0.066538 67.4305556 0.066538 67.4333333 0.070000 67.4361111 0.068269 67.4388889 0.068269 67.4416667 0.064808 67.4444444 0.061346 67.4472222 0.059615 67.4500000 0.056154 67.4527778 0.054423 67.4555556 0.052692 67.4583333 0.054423 67.4611111 0.054423 67.4638889 0.061346 67.4666667 0.056154 67.4694444 0.050962 67.4722222 0.045769 67.4750000 0.050962 67.4777778 0.075192 67.4805556 0.115000 67.4833333 0.158269 67.4861111 0.198077 67.4888889 0.213654 67.4916667 0.206731 67.4944444 0.170385 67.4972222 0.101154 67.5000000 0.010000 67.5027778 0.010000 67.5055556 0.010000 67.5083333 0.010000 67.5111111 0.010000 67.5138889 0.010000 67.5166667 0.010000 67.5194444 0.010000 67.5222222 0.010000 67.5250000 0.049231 67.5277778 0.076923 67.5305556 0.090769 67.5333333 0.097692 67.5361111 0.101154 67.5388889 0.101154 67.5416667 0.099423 67.5444444 0.082115 67.5472222 0.063077 67.5500000 0.052692 67.5527778 0.061346 67.5555556 0.063077 67.5583333 0.078654 67.5611111 0.085577 67.5638889 0.089038 67.5666667 0.092500 67.5694444 0.092500 67.5722222 0.089038 67.5750000 0.078654 67.5777778 0.061346 67.5805556 0.049231 67.5833333 0.040577 67.5861111 0.035385 67.5888889 0.035385 67.5916667 0.045769 67.5944444 0.061346 67.5972222 0.071731 67.6000000 0.085577 67.6027778 0.090769 67.6055556 0.097692 67.6083333 0.101154 67.6111111 0.104615 67.6138889 0.109808 67.6166667 0.109808 67.6194444 0.109808 67.6222222 0.111538 67.6250000 0.113269 67.6277778 0.116731 67.6305556 0.116731 67.6333333 0.121923 67.6361111 0.125385 67.6388889 0.125385 67.6416667 0.121923 67.6444444 0.121923 67.6472222 0.118462 67.6500000 0.116731 67.6527778 0.116731 67.6555556 0.120192 67.6583333 0.123654 67.6611111 0.123654 67.6638889 0.132308 67.6666667 0.127115 67.6694444 0.130577 67.6722222 0.132308 67.6750000 0.132308 67.6777778 0.127115 67.6805556 0.127115 67.6833333 0.125385 67.6861111 0.127115 67.6888889 0.128846 67.6916667 0.132308 67.6944444 0.127115 67.6972222 0.132308 67.7000000 0.132308 67.7027778 0.132308 67.7055556 0.130577 67.7083333 0.130577 67.7111111 0.130577 67.7138889 0.127115 67.7166667 0.120192 67.7194444 0.116731 67.7222222 0.120192 67.7250000 0.121923 67.7277778 0.125385 67.7305556 0.127115 67.7333333 0.128846 67.7361111 0.125385 67.7388889 0.128846 67.7416667 0.125385 67.7444444 0.118462 67.7472222 0.118462 67.7500000 0.115000 67.7527778 0.113269 67.7555556 0.108077 67.7583333 0.111538 67.7611111 0.115000 67.7638889 0.115000 67.7666667 0.113269 67.7694444 0.111538 67.7722222 0.109808 67.7750000 0.106346 67.7777778 0.104615 67.7805556 0.097692 67.7833333 0.089038 67.7861111 0.085577 67.7888889 0.085577 67.7916667 0.082115 67.7944444 0.085577 67.7972222 0.085577 67.8000000 0.080385 67.8027778 0.080385 67.8055556 0.075192 67.8083333 0.073462 67.8111111 0.063077 67.8138889 0.059615 67.8166667 0.059615 67.8194444 0.054423 67.8222222 0.047500 67.8250000 0.050962 67.8277778 0.047500 67.8305556 0.049231 67.8333333 0.050962 67.8361111 0.047500 67.8388889 0.044038 67.8416667 0.033654 68.4611111 0.078654 68.4638889 0.080385 68.4666667 0.085577 68.4694444 0.087308 68.4722222 0.080385 68.4750000 0.080385 68.4777778 0.076923 68.4805556 0.070000 68.4833333 0.070000 68.4861111 0.066538 68.4888889 0.071731 68.4916667 0.073462 68.4944444 0.075192 68.4972222 0.075192 68.5000000 0.082115 68.5027778 0.080385 68.5055556 0.080385 68.5083333 0.076923 68.5111111 0.076923 68.5138889 0.076923 68.5166667 0.075192 68.5194444 0.073462 68.5222222 0.076923 68.5250000 0.080385 68.5277778 0.083846 68.5305556 0.085577 68.5333333 0.087308 68.5361111 0.085577 68.5388889 0.085577 68.5416667 0.083846 68.5444444 0.080385 68.5472222 0.080385 68.5500000 0.075192 68.5527778 0.071731 68.5555556 0.076923 68.5583333 0.078654 68.5611111 0.082115 68.5638889 0.085577 68.5666667 0.090769 68.5694444 0.097692 68.5722222 0.094231 68.5750000 0.101154 68.5777778 0.097692 68.5805556 0.094231 68.5833333 0.089038 68.5861111 0.089038 68.5888889 0.089038 68.5916667 0.083846 68.5944444 0.085577 68.5972222 0.085577 68.6000000 0.083846 68.6027778 0.082115 68.6055556 0.080385 68.6083333 0.076923 68.6111111 0.071731 68.6138889 0.066538 68.6166667 0.066538 68.6194444 0.066538 68.6222222 0.066538 68.6250000 0.068269 68.6277778 0.066538 68.6305556 0.071731 68.6333333 0.068269 68.6361111 0.066538 68.6388889 0.052692 68.6416667 0.056154 68.6444444 0.059615 68.6472222 0.080385 68.6500000 0.116731 68.6527778 0.156538 68.6555556 0.180769 68.6583333 0.198077 68.6611111 0.196346 68.6638889 0.173846 68.6666667 0.123654 68.6694444 0.042308 68.6722222 0.010000 68.6750000 0.010000 68.6777778 0.010000 68.6805556 0.010000 68.6833333 0.010000 68.6861111 0.010000 68.6888889 0.033654 68.6916667 0.104615 68.6944444 0.165192 68.6972222 0.213654 68.7000000 0.232692 68.7027778 0.244808 68.7055556 0.237885 68.7083333 0.217115 68.7111111 0.175577 68.7138889 0.137500 68.7166667 0.102885 68.7194444 0.082115 68.7222222 0.070000 68.7250000 0.073462 68.7277778 0.082115 68.7305556 0.092500 68.7333333 0.106346 68.7361111 0.108077 68.7388889 0.097692 68.7416667 0.078654 68.7444444 0.061346 68.7472222 0.045769 68.7500000 0.042308 68.7527778 0.045769 68.7555556 0.056154 68.7583333 0.073462 68.7611111 0.080385 68.7638889 0.097692 68.7666667 0.104615 68.7694444 0.111538 68.7722222 0.116731 68.7750000 0.125385 68.7777778 0.121923 68.7805556 0.123654 68.7833333 0.127115 68.7861111 0.123654 68.7888889 0.123654 68.7916667 0.123654 68.7944444 0.128846 68.7972222 0.135769 68.8000000 0.135769 68.8027778 0.137500 68.8055556 0.139231 68.8083333 0.139231 68.8111111 0.140962 68.8138889 0.137500 68.8166667 0.132308 68.8194444 0.137500 68.8222222 0.135769 68.8250000 0.142692 68.8277778 0.140962 68.8305556 0.146154 68.8333333 0.147885 68.8361111 0.149615 68.8388889 0.144423 68.8416667 0.142692 68.8444444 0.139231 68.8472222 0.134038 68.8500000 0.130577 68.8527778 0.128846 68.8555556 0.130577 68.8583333 0.135769 68.8611111 0.139231 68.8638889 0.137500 68.8666667 0.142692 68.8694444 0.140962 68.8722222 0.139231 68.8750000 0.140962 68.8777778 0.137500 68.8805556 0.134038 68.8833333 0.132308 68.8861111 0.134038 68.8888889 0.132308 68.8916667 0.135769 68.8944444 0.140962 68.8972222 0.137500 68.9000000 0.139231 68.9027778 0.140962 68.9055556 0.139231 68.9083333 0.132308 68.9111111 0.130577 68.9138889 0.123654 68.9166667 0.118462 68.9194444 0.118462 68.9222222 0.121923 68.9250000 0.116731 68.9277778 0.118462 68.9305556 0.118462 68.9333333 0.120192 68.9361111 0.118462 68.9388889 0.116731 68.9416667 0.109808 68.9444444 0.099423 68.9472222 0.097692 68.9500000 0.092500 68.9527778 0.087308 68.9555556 0.089038 68.9583333 0.087308 68.9611111 0.087308 68.9638889 0.085577 68.9666667 0.085577 68.9694444 0.082115 68.9722222 0.078654 68.9750000 0.070000 68.9777778 0.066538 68.9805556 0.066538 68.9833333 0.064808 68.9861111 0.066538 68.9888889 0.061346 68.9916667 0.064808 68.9944444 0.068269 68.9972222 0.066538 69.0000000 0.068269 69.0027778 0.068269 69.0055556 0.064808 69.0083333 0.059615 69.6611111 0.115000 69.6638889 0.115000 69.6666667 0.118462 69.6694444 0.115000 69.6722222 0.116731 69.6750000 0.118462 69.6777778 0.113269 69.6805556 0.109808 69.6833333 0.113269 69.6861111 0.104615 69.6888889 0.106346 69.6916667 0.106346 69.6944444 0.106346 69.6972222 0.109808 69.7000000 0.109808 69.7027778 0.113269 69.7055556 0.115000 69.7083333 0.113269 69.7111111 0.111538 69.7138889 0.108077 69.7166667 0.106346 69.7194444 0.111538 69.7222222 0.108077 69.7250000 0.109808 69.7277778 0.109808 69.7305556 0.111538 69.7333333 0.118462 69.7361111 0.118462 69.7388889 0.120192 69.7416667 0.116731 69.7444444 0.116731 69.7472222 0.115000 69.7500000 0.113269 69.7527778 0.111538 69.7555556 0.115000 69.7583333 0.116731 69.7611111 0.120192 69.7638889 0.125385 69.7666667 0.130577 69.7694444 0.134038 69.7722222 0.132308 69.7750000 0.132308 69.7777778 0.128846 69.7805556 0.121923 69.7833333 0.116731 69.7861111 0.115000 69.7888889 0.113269 69.7916667 0.111538 69.7944444 0.111538 69.7972222 0.104615 69.8000000 0.109808 69.8027778 0.109808 69.8055556 0.102885 69.8083333 0.102885 69.8111111 0.101154 69.8138889 0.099423 69.8166667 0.095962 69.8194444 0.092500 69.8222222 0.095962 69.8250000 0.095962 69.8277778 0.097692 69.8305556 0.099423 69.8333333 0.095962 69.8361111 0.092500 69.8388889 0.085577 69.8416667 0.083846 69.8444444 0.095962 69.8472222 0.125385 69.8500000 0.163462 69.8527778 0.206731 69.8555556 0.236154 69.8583333 0.241346 69.8611111 0.227500 69.8638889 0.179038 69.8666667 0.087308 69.8694444 0.010000 69.8722222 0.010000 69.8750000 0.010000 69.8777778 0.010000 69.8805556 0.010000 69.8833333 0.010000 69.8861111 0.010000 69.8888889 0.031923 69.8916667 0.087308 69.8944444 0.121923 69.8972222 0.135769 69.9000000 0.140962 69.9027778 0.140962 69.9055556 0.134038 69.9083333 0.118462 69.9111111 0.106346 69.9138889 0.097692 69.9166667 0.095962 69.9194444 0.108077 69.9222222 0.109808 69.9250000 0.120192 69.9277778 0.123654 69.9305556 0.123654 69.9333333 0.125385 69.9361111 0.115000 69.9388889 0.095962 69.9416667 0.076923 69.9444444 0.070000 69.9472222 0.063077 69.9500000 0.070000 69.9527778 0.073462 69.9555556 0.085577 69.9583333 0.101154 69.9611111 0.115000 69.9638889 0.121923 69.9666667 0.128846 69.9694444 0.134038 69.9722222 0.137500 69.9750000 0.134038 69.9777778 0.135769 69.9805556 0.128846 69.9833333 0.125385 69.9861111 0.130577 69.9888889 0.130577 69.9916667 0.130577 69.9944444 0.134038 69.9972222 0.137500 70.0000000 0.142692 70.0027778 0.144423 70.0055556 0.140962 70.0083333 0.139231 70.0111111 0.135769 70.0138889 0.137500 70.0166667 0.130577 70.0194444 0.130577 70.0222222 0.132308 70.0250000 0.134038 70.0277778 0.139231 70.0305556 0.140962 70.0333333 0.142692 70.0361111 0.146154 70.0388889 0.139231 70.0416667 0.137500 70.0444444 0.139231 70.0472222 0.134038 70.0500000 0.134038 70.0527778 0.135769 70.0555556 0.134038 70.0583333 0.134038 70.0611111 0.134038 70.0638889 0.137500 70.0666667 0.142692 70.0694444 0.142692 70.0722222 0.139231 70.0750000 0.139231 70.0777778 0.135769 70.0805556 0.128846 70.0833333 0.127115 70.0861111 0.127115 70.0888889 0.128846 70.0916667 0.128846 70.0944444 0.130577 70.0972222 0.132308 70.1000000 0.128846 70.1027778 0.137500 70.1055556 0.128846 70.1083333 0.127115 70.1111111 0.123654 70.1138889 0.120192 70.1166667 0.115000 70.1194444 0.113269 70.1222222 0.111538 70.1250000 0.108077 70.1277778 0.106346 70.1305556 0.109808 70.1333333 0.109808 70.1361111 0.111538 70.1388889 0.108077 70.1416667 0.102885 70.1444444 0.095962 70.1472222 0.089038 70.1500000 0.085577 70.1527778 0.082115 70.1555556 0.076923 70.1583333 0.078654 70.1611111 0.075192 70.1638889 0.078654 70.1666667 0.076923 70.1694444 0.076923 70.1722222 0.073462 70.1750000 0.066538 70.1777778 0.066538 70.1805556 0.054423 70.1833333 0.054423 70.1861111 0.047500 70.1888889 0.045769 70.1916667 0.045769 70.1944444 0.047500 70.1972222 0.047500 70.2000000 0.047500 70.2027778 0.045769 70.2055556 0.042308 70.2083333 0.037115 70.8083333 0.090769 70.8111111 0.087308 70.8138889 0.085577 70.8166667 0.087308 70.8194444 0.087308 70.8222222 0.083846 70.8250000 0.082115 70.8277778 0.087308 70.8305556 0.087308 70.8333333 0.092500 70.8361111 0.092500 70.8388889 0.092500 70.8416667 0.095962 70.8444444 0.094231 70.8472222 0.087308 70.8500000 0.083846 70.8527778 0.083846 70.8555556 0.082115 70.8583333 0.085577 70.8611111 0.085577 70.8638889 0.089038 70.8666667 0.092500 70.8694444 0.095962 70.8722222 0.094231 70.8750000 0.099423 70.8777778 0.090769 70.8805556 0.087308 70.8833333 0.087308 70.8861111 0.085577 70.8888889 0.089038 70.8916667 0.090769 70.8944444 0.097692 70.8972222 0.097692 70.9000000 0.101154 70.9027778 0.108077 70.9055556 0.106346 70.9083333 0.102885 70.9111111 0.097692 70.9138889 0.094231 70.9166667 0.097692 70.9194444 0.097692 70.9222222 0.102885 70.9250000 0.106346 70.9277778 0.113269 70.9305556 0.113269 70.9333333 0.120192 70.9361111 0.120192 70.9388889 0.109808 70.9416667 0.106346 70.9444444 0.101154 70.9472222 0.097692 70.9500000 0.090769 70.9527778 0.089038 70.9555556 0.085577 70.9583333 0.085577 70.9611111 0.087308 70.9638889 0.089038 70.9666667 0.089038 70.9694444 0.094231 70.9722222 0.095962 70.9750000 0.095962 70.9777778 0.085577 70.9805556 0.082115 70.9833333 0.066538 70.9861111 0.057885 70.9888889 0.059615 70.9916667 0.075192 70.9944444 0.111538 70.9972222 0.151346 71.0000000 0.198077 71.0027778 0.222308 71.0055556 0.227500 71.0083333 0.210192 71.0111111 0.163462 71.0138889 0.083846 71.0166667 0.010000 71.0194444 0.010000 71.0222222 0.010000 71.0250000 0.010000 71.0277778 0.010000 71.0305556 0.010000 71.0333333 0.019808 71.0361111 0.097692 71.0388889 0.154808 71.0416667 0.192885 71.0444444 0.210192 71.0472222 0.215385 71.0500000 0.215385 71.0527778 0.211923 71.0555556 0.198077 71.0583333 0.170385 71.0611111 0.144423 71.0638889 0.120192 71.0666667 0.106346 71.0694444 0.095962 71.0722222 0.095962 71.0750000 0.099423 71.0777778 0.101154 71.0805556 0.108077 71.0833333 0.111538 71.0861111 0.102885 71.0888889 0.094231 71.0916667 0.080385 71.0944444 0.070000 71.0972222 0.066538 71.1000000 0.059615 71.1027778 0.066538 71.1055556 0.073462 71.1083333 0.080385 71.1111111 0.090769 71.1138889 0.095962 71.1166667 0.101154 71.1194444 0.102885 71.1222222 0.109808 71.1250000 0.111538 71.1277778 0.125385 71.1305556 0.130577 71.1333333 0.135769 71.1361111 0.139231 71.1388889 0.139231 71.1416667 0.137500 71.1444444 0.134038 71.1472222 0.132308 71.1500000 0.134038 71.1527778 0.130577 71.1555556 0.130577 71.1583333 0.132308 71.1611111 0.137500 71.1638889 0.140962 71.1666667 0.140962 71.1694444 0.140962 71.1722222 0.137500 71.1750000 0.135769 71.1777778 0.137500 71.1805556 0.134038 71.1833333 0.134038 71.1861111 0.130577 71.1888889 0.128846 71.1916667 0.128846 71.1944444 0.140962 71.1972222 0.146154 71.2000000 0.146154 71.2027778 0.146154 71.2055556 0.146154 71.2083333 0.144423 71.2111111 0.139231 71.2138889 0.139231 71.2166667 0.134038 71.2194444 0.132308 71.2222222 0.130577 71.2250000 0.130577 71.2277778 0.137500 71.2305556 0.139231 71.2333333 0.139231 71.2361111 0.139231 71.2388889 0.137500 71.2416667 0.134038 71.2444444 0.135769 71.2472222 0.132308 71.2500000 0.134038 71.2527778 0.128846 71.2555556 0.130577 71.2583333 0.127115 71.2611111 0.127115 71.2638889 0.121923 71.2666667 0.123654 71.2694444 0.118462 71.2722222 0.120192 71.2750000 0.121923 71.2777778 0.120192 71.2805556 0.118462 71.2833333 0.111538 71.2861111 0.111538 71.2888889 0.104615 71.2916667 0.108077 71.2944444 0.109808 71.2972222 0.113269 71.3000000 0.106346 71.3027778 0.104615 71.3055556 0.104615 71.3083333 0.097692 71.3111111 0.099423 71.3138889 0.090769 71.3166667 0.092500 71.3194444 0.082115 71.3222222 0.080385 71.3250000 0.080385 71.3277778 0.078654 71.3305556 0.082115 71.3333333 0.076923 71.3361111 0.078654 71.3388889 0.076923 71.3416667 0.071731 71.3444444 0.066538 71.3472222 0.059615 71.3500000 0.056154 71.3527778 0.049231 71.3555556 0.052692 72.0388889 0.085577 72.0416667 0.087308 72.0444444 0.080385 72.0472222 0.078654 72.0500000 0.078654 72.0527778 0.082115 72.0555556 0.078654 72.0583333 0.083846 72.0611111 0.083846 72.0638889 0.083846 72.0666667 0.085577 72.0694444 0.085577 72.0722222 0.090769 72.0750000 0.083846 72.0777778 0.082115 72.0805556 0.080385 72.0833333 0.075192 72.0861111 0.075192 72.0888889 0.073462 72.0916667 0.073462 72.0944444 0.078654 72.0972222 0.082115 72.1000000 0.087308 72.1027778 0.087308 72.1055556 0.089038 72.1083333 0.087308 72.1111111 0.087308 72.1138889 0.082115 72.1166667 0.080385 72.1194444 0.078654 72.1222222 0.076923 72.1250000 0.080385 72.1277778 0.085577 72.1305556 0.090769 72.1333333 0.089038 72.1361111 0.092500 72.1388889 0.095962 72.1416667 0.092500 72.1444444 0.094231 72.1472222 0.094231 72.1500000 0.097692 72.1527778 0.095962 72.1555556 0.095962 72.1583333 0.099423 72.1611111 0.097692 72.1638889 0.094231 72.1666667 0.092500 72.1694444 0.090769 72.1722222 0.092500 72.1750000 0.083846 72.1777778 0.082115 72.1805556 0.076923 72.1833333 0.076923 72.1861111 0.073462 72.1888889 0.066538 72.1916667 0.070000 72.1944444 0.071731 72.1972222 0.076923 72.2000000 0.078654 72.2027778 0.080385 72.2055556 0.078654 72.2083333 0.071731 72.2111111 0.061346 72.2138889 0.050962 72.2166667 0.044038 72.2194444 0.054423 72.2222222 0.085577 72.2250000 0.120192 72.2277778 0.161731 72.2305556 0.192885 72.2333333 0.203269 72.2361111 0.199808 72.2388889 0.163462 72.2416667 0.092500 72.2444444 0.010000 72.2472222 0.010000 72.2500000 0.010000 72.2527778 0.010000 72.2555556 0.010000 72.2583333 0.010000 72.2611111 0.010000 72.2638889 0.040577 72.2666667 0.104615 72.2694444 0.163462 72.2722222 0.192885 72.2750000 0.203269 72.2777778 0.206731 72.2805556 0.201538 72.2833333 0.191154 72.2861111 0.168654 72.2888889 0.137500 72.2916667 0.115000 72.2944444 0.095962 72.2972222 0.087308 72.3000000 0.080385 72.3027778 0.080385 72.3055556 0.089038 72.3083333 0.094231 72.3111111 0.104615 72.3138889 0.104615 72.3166667 0.095962 72.3194444 0.073462 72.3222222 0.052692 72.3250000 0.044038 72.3277778 0.037115 72.3305556 0.045769 72.3333333 0.052692 72.3361111 0.066538 72.3388889 0.075192 72.3416667 0.090769 72.3444444 0.090769 72.3472222 0.095962 72.3500000 0.099423 72.3527778 0.099423 72.3555556 0.108077 72.3583333 0.111538 72.3611111 0.113269 72.3638889 0.121923 72.3666667 0.121923 72.3694444 0.123654 72.3722222 0.123654 72.3750000 0.123654 72.3777778 0.121923 72.3805556 0.120192 72.3833333 0.120192 72.3861111 0.115000 72.3888889 0.113269 72.3916667 0.116731 72.3944444 0.118462 72.3972222 0.120192 72.4000000 0.123654 72.4027778 0.123654 72.4055556 0.127115 72.4083333 0.125385 72.4111111 0.125385 72.4138889 0.120192 72.4166667 0.121923 72.4194444 0.123654 72.4222222 0.123654 72.4250000 0.127115 72.4277778 0.125385 72.4305556 0.132308 72.4333333 0.134038 72.4361111 0.132308 72.4388889 0.130577 72.4416667 0.132308 72.4444444 0.128846 72.4472222 0.120192 72.4500000 0.125385 72.4527778 0.118462 72.4555556 0.115000 72.4583333 0.121923 72.4611111 0.123654 72.4638889 0.121923 72.4666667 0.127115 72.4694444 0.127115 72.4722222 0.123654 72.4750000 0.125385 72.4777778 0.118462 72.4805556 0.115000 72.4833333 0.116731 72.4861111 0.111538 72.4888889 0.108077 72.4916667 0.109808 72.4944444 0.111538 72.4972222 0.111538 72.5000000 0.109808 72.5027778 0.111538 72.5055556 0.109808 72.5083333 0.108077 72.5111111 0.099423 72.5138889 0.094231 72.5166667 0.092500 72.5194444 0.092500 72.5222222 0.087308 72.5250000 0.087308 72.5277778 0.087308 72.5305556 0.085577 72.5333333 0.089038 72.5361111 0.089038 72.5388889 0.089038 72.5416667 0.082115 72.5444444 0.080385 72.5472222 0.075192 72.5500000 0.068269 72.5527778 0.064808 72.5555556 0.059615 72.5583333 0.054423 72.5611111 0.056154 72.5638889 0.054423 72.5666667 0.054423 72.5694444 0.056154 72.5722222 0.052692 72.5750000 0.049231 72.5777778 0.044038 72.5805556 0.037115 72.5833333 0.033654 72.5861111 0.037115 73.3055556 0.094231 73.3083333 0.089038 73.3111111 0.089038 73.3138889 0.085577 73.3166667 0.075192 73.3194444 0.075192 73.3222222 0.073462 73.3250000 0.078654 73.3277778 0.078654 73.3305556 0.080385 73.3333333 0.082115 73.3361111 0.085577 73.3388889 0.089038 73.3416667 0.082115 73.3444444 0.078654 73.3472222 0.076923 73.3500000 0.080385 73.3527778 0.076923 73.3555556 0.075192 73.3583333 0.075192 73.3611111 0.078654 73.3638889 0.082115 73.3666667 0.085577 73.3694444 0.087308 73.3722222 0.083846 73.3750000 0.083846 73.3777778 0.082115 73.3805556 0.071731 73.3833333 0.071731 73.3861111 0.070000 73.3888889 0.071731 73.3916667 0.075192 73.3944444 0.078654 73.3972222 0.082115 73.4000000 0.083846 73.4027778 0.087308 73.4055556 0.092500 73.4083333 0.090769 73.4111111 0.089038 73.4138889 0.087308 73.4166667 0.087308 73.4194444 0.078654 73.4222222 0.078654 73.4250000 0.076923 73.4277778 0.075192 73.4305556 0.071731 73.4333333 0.070000 73.4361111 0.071731 73.4388889 0.076923 73.4416667 0.073462 73.4444444 0.070000 73.4472222 0.068269 73.4500000 0.066538 73.4527778 0.064808 73.4555556 0.063077 73.4583333 0.066538 73.4611111 0.063077 73.4638889 0.061346 73.4666667 0.070000 73.4694444 0.070000 73.4722222 0.064808 73.4750000 0.061346 73.4777778 0.052692 73.4805556 0.050962 73.4833333 0.054423 73.4861111 0.070000 73.4888889 0.102885 73.4916667 0.142692 73.4944444 0.175577 73.4972222 0.194615 73.5000000 0.206731 73.5027778 0.192885 73.5055556 0.151346 73.5083333 0.076923 73.5111111 0.010000 73.5138889 0.010000 73.5166667 0.010000 73.5194444 0.010000 73.5222222 0.010000 73.5250000 0.010000 73.5277778 0.010000 73.5305556 0.010000 73.5333333 0.035385 73.5361111 0.087308 73.5388889 0.109808 73.5416667 0.127115 73.5444444 0.127115 73.5472222 0.118462 73.5500000 0.111538 73.5527778 0.099423 73.5555556 0.080385 73.5583333 0.070000 73.5611111 0.068269 73.5638889 0.075192 73.5666667 0.085577 73.5694444 0.095962 73.5722222 0.102885 73.5750000 0.102885 73.5777778 0.097692 73.5805556 0.082115 73.5833333 0.057885 73.5861111 0.038846 73.5888889 0.025000 73.5916667 0.030192 73.5944444 0.037115 73.5972222 0.050962 73.6000000 0.070000 73.6027778 0.080385 73.6055556 0.087308 73.6083333 0.092500 73.6111111 0.094231 73.6138889 0.095962 73.6166667 0.095962 73.6194444 0.095962 73.6222222 0.101154 73.6250000 0.108077 73.6277778 0.104615 73.6305556 0.111538 73.6333333 0.115000 73.6361111 0.116731 73.6388889 0.120192 73.6416667 0.113269 73.6444444 0.113269 73.6472222 0.109808 73.6500000 0.109808 73.6527778 0.111538 73.6555556 0.109808 73.6583333 0.111538 73.6611111 0.113269 73.6638889 0.115000 73.6666667 0.116731 73.6694444 0.116731 73.6722222 0.120192 73.6750000 0.121923 73.6777778 0.120192 73.6805556 0.116731 73.6833333 0.111538 73.6861111 0.109808 73.6888889 0.113269 73.6916667 0.108077 73.6944444 0.108077 73.6972222 0.111538 73.7000000 0.115000 73.7027778 0.113269 73.7055556 0.120192 73.7083333 0.116731 73.7111111 0.113269 73.7138889 0.108077 73.7166667 0.106346 73.7194444 0.104615 73.7222222 0.109808 73.7250000 0.102885 73.7277778 0.108077 73.7305556 0.104615 73.7333333 0.109808 73.7361111 0.115000 73.7388889 0.113269 73.7416667 0.109808 73.7444444 0.106346 73.7472222 0.104615 73.7500000 0.101154 73.7527778 0.097692 73.7555556 0.092500 73.7583333 0.090769 73.7611111 0.092500 73.7638889 0.095962 73.7666667 0.095962 73.7694444 0.095962 73.7722222 0.094231 73.7750000 0.090769 73.7777778 0.083846 73.7805556 0.076923 73.7833333 0.071731 73.7861111 0.068269 73.7888889 0.066538 73.7916667 0.070000 73.7944444 0.068269 73.7972222 0.068269 73.8000000 0.064808 73.8027778 0.059615 73.8055556 0.059615 73.8083333 0.052692 73.8111111 0.049231 73.8138889 0.040577 73.8166667 0.033654 73.8194444 0.026731 73.8222222 0.023269 73.8250000 0.019808 73.8277778 0.019808 73.8305556 0.019808 73.8333333 0.018077 73.8361111 0.021538 73.8388889 0.021538 73.8416667 0.016346 73.8444444 0.012885 73.8472222 0.010000 73.8500000 0.010000 73.8527778 0.010000 74.4888889 0.021538 74.4916667 0.023269 74.4944444 0.025000 74.4972222 0.025000 74.5000000 0.026731 74.5027778 0.033654 74.5055556 0.035385 74.5083333 0.031923 74.5111111 0.028462 74.5138889 0.026731 74.5166667 0.021538 74.5194444 0.021538 74.5222222 0.019808 74.5250000 0.018077 74.5277778 0.019808 74.5305556 0.025000 74.5333333 0.028462 74.5361111 0.030192 74.5388889 0.030192 74.5416667 0.031923 74.5444444 0.028462 74.5472222 0.030192 74.5500000 0.025000 74.5527778 0.018077 74.5555556 0.018077 74.5583333 0.025000 74.5611111 0.021538 74.5638889 0.028462 74.5666667 0.035385 74.5694444 0.038846 74.5722222 0.031923 74.5750000 0.033654 74.5777778 0.026731 74.5805556 0.026731 74.5833333 0.026731 74.5861111 0.025000 74.5888889 0.033654 74.5916667 0.037115 74.5944444 0.042308 74.5972222 0.045769 74.6000000 0.045769 74.6027778 0.049231 74.6055556 0.047500 74.6083333 0.044038 74.6111111 0.038846 74.6138889 0.040577 74.6166667 0.031923 74.6194444 0.026731 74.6222222 0.025000 74.6250000 0.019808 74.6277778 0.019808 74.6305556 0.018077 74.6333333 0.023269 74.6361111 0.023269 74.6388889 0.021538 74.6416667 0.023269 74.6444444 0.018077 74.6472222 0.012885 74.6500000 0.016346 74.6527778 0.010000 74.6555556 0.010000 74.6583333 0.010000 74.6611111 0.010000 74.6638889 0.010000 74.6666667 0.010000 74.6694444 0.037115 74.6722222 0.076923 74.6750000 0.120192 74.6777778 0.149615 74.6805556 0.161731 74.6833333 0.156538 74.6861111 0.127115 74.6888889 0.061346 74.6916667 0.010000 74.6944444 0.010000 74.6972222 0.010000 74.7000000 0.010000 74.7027778 0.010000 74.7055556 0.010000 74.7083333 0.010000 74.7111111 0.010000 74.7138889 0.010000 74.7166667 0.026731 74.7194444 0.047500 74.7222222 0.059615 74.7250000 0.064808 74.7277778 0.070000 74.7305556 0.076923 74.7333333 0.070000 74.7361111 0.054423 74.7388889 0.042308 74.7416667 0.030192 74.7444444 0.026731 74.7472222 0.026731 74.7500000 0.030192 74.7527778 0.033654 74.7555556 0.038846 74.7583333 0.047500 74.7611111 0.047500 74.7638889 0.042308 74.7666667 0.031923 74.7694444 0.021538 74.7722222 0.014615 74.7750000 0.010000 74.7777778 0.010000 74.7805556 0.010000 74.7833333 0.014615 74.7861111 0.023269 74.7888889 0.033654 74.7916667 0.044038 74.7944444 0.050962 74.7972222 0.063077 74.8000000 0.070000 74.8027778 0.073462 74.8055556 0.071731 74.8083333 0.073462 74.8111111 0.073462 74.8138889 0.068269 74.8166667 0.068269 74.8194444 0.061346 74.8222222 0.063077 74.8250000 0.068269 74.8277778 0.073462 74.8305556 0.075192 74.8333333 0.078654 74.8361111 0.080385 74.8388889 0.080385 74.8416667 0.080385 74.8444444 0.073462 74.8472222 0.070000 74.8500000 0.068269 74.8527778 0.068269 74.8555556 0.070000 74.8583333 0.071731 74.8611111 0.071731 74.8638889 0.078654 74.8666667 0.078654 74.8694444 0.082115 74.8722222 0.087308 74.8750000 0.083846 74.8777778 0.085577 74.8805556 0.083846 74.8833333 0.076923 74.8861111 0.076923 74.8888889 0.076923 74.8916667 0.075192 74.8944444 0.076923 74.8972222 0.076923 74.9000000 0.082115 74.9027778 0.083846 74.9055556 0.087308 74.9083333 0.083846 74.9111111 0.083846 74.9138889 0.080385 74.9166667 0.078654 74.9194444 0.073462 74.9222222 0.070000 74.9250000 0.075192 74.9277778 0.076923 74.9305556 0.080385 74.9333333 0.078654 74.9361111 0.082115 74.9388889 0.075192 74.9416667 0.075192 74.9444444 0.073462 74.9472222 0.075192 74.9500000 0.071731 74.9527778 0.068269 74.9555556 0.073462 74.9583333 0.066538 74.9611111 0.068269 74.9638889 0.064808 74.9666667 0.061346 74.9694444 0.059615 74.9722222 0.059615 74.9750000 0.054423 74.9777778 0.056154 74.9805556 0.050962 74.9833333 0.044038 74.9861111 0.035385 74.9888889 0.037115 74.9916667 0.033654 74.9944444 0.031923 74.9972222 0.031923 75.0000000 0.033654 75.0027778 0.035385 75.0055556 0.028462 75.0083333 0.028462 75.0111111 0.019808 75.0138889 0.014615 75.0166667 0.010000 75.0194444 0.010000 75.0222222 0.010000 75.0250000 0.010000 75.0277778 0.010000 75.0305556 0.010000 75.0333333 0.010000 75.0361111 0.010000 75.7333333 0.099423 75.7361111 0.102885 75.7388889 0.104615 75.7416667 0.102885 75.7444444 0.104615 75.7472222 0.097692 75.7500000 0.095962 75.7527778 0.085577 75.7555556 0.092500 75.7583333 0.092500 75.7611111 0.094231 75.7638889 0.095962 75.7666667 0.099423 75.7694444 0.102885 75.7722222 0.111538 75.7750000 0.108077 75.7777778 0.102885 75.7805556 0.104615 75.7833333 0.102885 75.7861111 0.095962 75.7888889 0.097692 75.7916667 0.101154 75.7944444 0.108077 75.7972222 0.106346 75.8000000 0.113269 75.8027778 0.120192 75.8055556 0.116731 75.8083333 0.113269 75.8111111 0.108077 75.8138889 0.108077 75.8166667 0.109808 75.8194444 0.111538 75.8222222 0.108077 75.8250000 0.113269 75.8277778 0.120192 75.8305556 0.128846 75.8333333 0.132308 75.8361111 0.137500 75.8388889 0.137500 75.8416667 0.135769 75.8444444 0.130577 75.8472222 0.125385 75.8500000 0.120192 75.8527778 0.121923 75.8555556 0.118462 75.8583333 0.116731 75.8611111 0.116731 75.8638889 0.113269 75.8666667 0.115000 75.8694444 0.118462 75.8722222 0.111538 75.8750000 0.111538 75.8777778 0.109808 75.8805556 0.108077 75.8833333 0.102885 75.8861111 0.102885 75.8888889 0.104615 75.8916667 0.104615 75.8944444 0.108077 75.8972222 0.104615 75.9000000 0.101154 75.9027778 0.095962 75.9055556 0.089038 75.9083333 0.083846 75.9111111 0.092500 75.9138889 0.116731 75.9166667 0.153077 75.9194444 0.191154 75.9222222 0.217115 75.9250000 0.236154 75.9277778 0.232692 75.9305556 0.208462 75.9333333 0.163462 75.9361111 0.083846 75.9388889 0.010000 75.9416667 0.010000 75.9444444 0.010000 75.9472222 0.010000 75.9500000 0.010000 75.9527778 0.010000 75.9555556 0.049231 75.9583333 0.118462 75.9611111 0.177308 75.9638889 0.217115 75.9666667 0.243077 75.9694444 0.255192 75.9722222 0.260385 75.9750000 0.253462 75.9777778 0.239615 75.9805556 0.213654 75.9833333 0.175577 75.9861111 0.146154 75.9888889 0.128846 75.9916667 0.115000 75.9944444 0.111538 75.9972222 0.120192 76.0000000 0.134038 76.0027778 0.140962 76.0055556 0.147885 76.0083333 0.142692 76.0111111 0.134038 76.0138889 0.118462 76.0166667 0.099423 76.0194444 0.080385 76.0222222 0.078654 76.0250000 0.089038 76.0277778 0.101154 76.0305556 0.118462 76.0333333 0.137500 76.0361111 0.147885 76.0388889 0.160000 76.0416667 0.160000 76.0444444 0.161731 76.0472222 0.165192 76.0500000 0.163462 76.0527778 0.156538 76.0555556 0.158269 76.0583333 0.161731 76.0611111 0.166923 76.0638889 0.168654 76.0666667 0.172115 76.0694444 0.180769 76.0722222 0.182500 76.0750000 0.177308 76.0777778 0.175577 76.0805556 0.170385 76.0833333 0.166923 76.0861111 0.172115 76.0888889 0.166923 76.0916667 0.175577 76.0944444 0.182500 76.0972222 0.182500 76.1000000 0.187692 76.1027778 0.184231 76.1055556 0.189423 76.1083333 0.184231 76.1111111 0.184231 76.1138889 0.177308 76.1166667 0.179038 76.1194444 0.179038 76.1222222 0.182500 76.1250000 0.184231 76.1277778 0.184231 76.1305556 0.184231 76.1333333 0.187692 76.1361111 0.191154 76.1388889 0.185962 76.1416667 0.184231 76.1444444 0.185962 76.1472222 0.177308 76.1500000 0.173846 76.1527778 0.173846 76.1555556 0.177308 76.1583333 0.180769 76.1611111 0.184231 76.1638889 0.182500 76.1666667 0.184231 76.1694444 0.184231 76.1722222 0.182500 76.1750000 0.180769 76.1777778 0.180769 76.1805556 0.175577 76.1833333 0.175577 76.1861111 0.172115 76.1888889 0.168654 76.1916667 0.170385 76.1944444 0.172115 76.1972222 0.175577 76.2000000 0.175577 76.2027778 0.173846 76.2055556 0.173846 76.2083333 0.172115 76.2111111 0.170385 76.2138889 0.160000 76.2166667 0.160000 76.2194444 0.158269 76.2222222 0.154808 76.2250000 0.158269 76.2277778 0.154808 76.2305556 0.153077 76.2333333 0.154808 76.2361111 0.149615 76.2388889 0.146154 76.2416667 0.142692 76.2444444 0.139231 76.2472222 0.139231 76.2500000 0.132308 76.2527778 0.130577 76.2555556 0.135769 76.2583333 0.125385 76.2611111 0.123654 76.2638889 0.118462 76.2666667 0.120192 76.2694444 0.123654 76.2722222 0.125385 76.2750000 0.121923 76.2777778 0.120192 76.2805556 0.123654 76.8805556 0.153077 76.8833333 0.151346 76.8861111 0.147885 76.8888889 0.147885 76.8916667 0.146154 76.8944444 0.149615 76.8972222 0.147885 76.9000000 0.147885 76.9027778 0.147885 76.9055556 0.149615 76.9083333 0.146154 76.9111111 0.146154 76.9138889 0.146154 76.9166667 0.144423 76.9194444 0.144423 76.9222222 0.142692 76.9250000 0.147885 76.9277778 0.149615 76.9305556 0.147885 76.9333333 0.154808 76.9361111 0.158269 76.9388889 0.156538 76.9416667 0.151346 76.9444444 0.149615 76.9472222 0.149615 76.9500000 0.147885 76.9527778 0.146154 76.9555556 0.144423 76.9583333 0.140962 76.9611111 0.146154 76.9638889 0.147885 76.9666667 0.151346 76.9694444 0.156538 76.9722222 0.161731 76.9750000 0.166923 76.9777778 0.161731 76.9805556 0.160000 76.9833333 0.160000 76.9861111 0.158269 76.9888889 0.158269 76.9916667 0.161731 76.9944444 0.158269 76.9972222 0.163462 77.0000000 0.166923 77.0027778 0.172115 77.0055556 0.168654 77.0083333 0.166923 77.0111111 0.161731 77.0138889 0.156538 77.0166667 0.153077 77.0194444 0.149615 77.0222222 0.142692 77.0250000 0.142692 77.0277778 0.137500 77.0305556 0.142692 77.0333333 0.140962 77.0361111 0.147885 77.0388889 0.147885 77.0416667 0.146154 77.0444444 0.139231 77.0472222 0.134038 77.0500000 0.125385 77.0527778 0.113269 77.0555556 0.108077 77.0583333 0.109808 77.0611111 0.134038 77.0638889 0.175577 77.0666667 0.222308 77.0694444 0.255192 77.0722222 0.277692 77.0750000 0.274231 77.0777778 0.246538 77.0805556 0.189423 77.0833333 0.101154 77.0861111 0.010000 77.0888889 0.010000 77.0916667 0.010000 77.0944444 0.010000 77.0972222 0.010000 77.1000000 0.010000 77.1027778 0.054423 77.1055556 0.120192 77.1083333 0.175577 77.1111111 0.206731 77.1138889 0.215385 77.1166667 0.224038 77.1194444 0.229231 77.1222222 0.230962 77.1250000 0.227500 77.1277778 0.206731 77.1305556 0.189423 77.1333333 0.165192 77.1361111 0.140962 77.1388889 0.135769 77.1416667 0.127115 77.1444444 0.128846 77.1472222 0.135769 77.1500000 0.149615 77.1527778 0.154808 77.1555556 0.154808 77.1583333 0.146154 77.1611111 0.132308 77.1638889 0.118462 77.1666667 0.108077 77.1694444 0.109808 77.1722222 0.113269 77.1750000 0.125385 77.1777778 0.134038 77.1805556 0.144423 77.1833333 0.149615 77.1861111 0.158269 77.1888889 0.163462 77.1916667 0.166923 77.1944444 0.172115 77.1972222 0.173846 77.2000000 0.177308 77.2027778 0.179038 77.2055556 0.180769 77.2083333 0.185962 77.2111111 0.180769 77.2138889 0.180769 77.2166667 0.180769 77.2194444 0.175577 77.2222222 0.175577 77.2250000 0.173846 77.2277778 0.173846 77.2305556 0.180769 77.2333333 0.180769 77.2361111 0.184231 77.2388889 0.189423 77.2416667 0.191154 77.2444444 0.184231 77.2472222 0.184231 77.2500000 0.184231 77.2527778 0.180769 77.2555556 0.177308 77.2583333 0.180769 77.2611111 0.180769 77.2638889 0.182500 77.2666667 0.184231 77.2694444 0.192885 77.2722222 0.192885 77.2750000 0.189423 77.2777778 0.187692 77.2805556 0.180769 77.2833333 0.173846 77.2861111 0.170385 77.2888889 0.163462 77.2916667 0.166923 77.2944444 0.177308 77.2972222 0.177308 77.3000000 0.175577 77.3027778 0.177308 77.3055556 0.179038 77.3083333 0.177308 77.3111111 0.170385 77.3138889 0.168654 77.3166667 0.163462 77.3194444 0.161731 77.3222222 0.166923 77.3250000 0.163462 77.3277778 0.165192 77.3305556 0.160000 77.3333333 0.160000 77.3361111 0.160000 77.3388889 0.147885 77.3416667 0.149615 77.3444444 0.146154 77.3472222 0.144423 77.3500000 0.149615 77.3527778 0.139231 77.3555556 0.137500 77.3583333 0.134038 77.3611111 0.128846 77.3638889 0.130577 77.3666667 0.127115 77.3694444 0.125385 77.3722222 0.127115 77.3750000 0.121923 77.3777778 0.120192 77.3805556 0.118462 77.3833333 0.115000 77.3861111 0.115000 77.3888889 0.108077 77.3916667 0.099423 77.3944444 0.095962 77.3972222 0.094231 77.4000000 0.090769 77.4027778 0.087308 77.4055556 0.090769 77.4083333 0.089038 77.4111111 0.089038 77.4138889 0.083846 77.4166667 0.080385 77.4194444 0.076923 77.4222222 0.075192 77.4250000 0.068269 77.4277778 0.075192 78.0916667 0.057885 78.0944444 0.054423 78.0972222 0.056154 78.1000000 0.059615 78.1027778 0.063077 78.1055556 0.068269 78.1083333 0.064808 78.1111111 0.066538 78.1138889 0.059615 78.1166667 0.056154 78.1194444 0.052692 78.1222222 0.049231 78.1250000 0.052692 78.1277778 0.050962 78.1305556 0.054423 78.1333333 0.059615 78.1361111 0.066538 78.1388889 0.066538 78.1416667 0.063077 78.1444444 0.061346 78.1472222 0.061346 78.1500000 0.057885 78.1527778 0.054423 78.1555556 0.050962 78.1583333 0.049231 78.1611111 0.050962 78.1638889 0.054423 78.1666667 0.056154 78.1694444 0.063077 78.1722222 0.061346 78.1750000 0.064808 78.1777778 0.064808 78.1805556 0.061346 78.1833333 0.057885 78.1861111 0.052692 78.1888889 0.052692 78.1916667 0.056154 78.1944444 0.063077 78.1972222 0.068269 78.2000000 0.075192 78.2027778 0.078654 78.2055556 0.078654 78.2083333 0.080385 78.2111111 0.073462 78.2138889 0.068269 78.2166667 0.064808 78.2194444 0.050962 78.2222222 0.052692 78.2250000 0.045769 78.2277778 0.052692 78.2305556 0.049231 78.2333333 0.054423 78.2361111 0.052692 78.2388889 0.052692 78.2416667 0.050962 78.2444444 0.049231 78.2472222 0.042308 78.2500000 0.040577 78.2527778 0.037115 78.2555556 0.035385 78.2583333 0.033654 78.2611111 0.031923 78.2638889 0.025000 78.2666667 0.021538 78.2694444 0.031923 78.2722222 0.049231 78.2750000 0.078654 78.2777778 0.120192 78.2805556 0.149615 78.2833333 0.166923 78.2861111 0.168654 78.2888889 0.149615 78.2916667 0.099423 78.2944444 0.018077 78.2972222 0.010000 78.3000000 0.010000 78.3027778 0.010000 78.3055556 0.010000 78.3083333 0.010000 78.3111111 0.010000 78.3138889 0.010000 78.3166667 0.050962 78.3194444 0.104615 78.3222222 0.135769 78.3250000 0.154808 78.3277778 0.160000 78.3305556 0.163462 78.3333333 0.156538 78.3361111 0.151346 78.3388889 0.128846 78.3416667 0.101154 78.3444444 0.075192 78.3472222 0.056154 78.3500000 0.040577 78.3527778 0.031923 78.3555556 0.035385 78.3583333 0.037115 78.3611111 0.050962 78.3638889 0.056154 78.3666667 0.057885 78.3694444 0.054423 78.3722222 0.037115 78.3750000 0.023269 78.3777778 0.011154 78.3805556 0.010000 78.3833333 0.011154 78.3861111 0.016346 78.3888889 0.025000 78.3916667 0.035385 78.3944444 0.042308 78.3972222 0.052692 78.4000000 0.063077 78.4027778 0.070000 78.4055556 0.076923 78.4083333 0.083846 78.4111111 0.085577 78.4138889 0.089038 78.4166667 0.083846 78.4194444 0.080385 78.4222222 0.075192 78.4250000 0.075192 78.4277778 0.076923 78.4305556 0.075192 78.4333333 0.083846 78.4361111 0.082115 78.4388889 0.090769 78.4416667 0.095962 78.4444444 0.092500 78.4472222 0.087308 78.4500000 0.080385 78.4527778 0.078654 78.4555556 0.078654 78.4583333 0.082115 78.4611111 0.083846 78.4638889 0.082115 78.4666667 0.089038 78.4694444 0.087308 78.4722222 0.090769 78.4750000 0.090769 78.4777778 0.085577 78.4805556 0.082115 78.4833333 0.082115 78.4861111 0.078654 78.4888889 0.080385 78.4916667 0.082115 78.4944444 0.082115 78.4972222 0.087308 78.5000000 0.083846 78.5027778 0.082115 78.5055556 0.085577 78.5083333 0.087308 78.5111111 0.080385 78.5138889 0.078654 78.5166667 0.076923 78.5194444 0.073462 78.5222222 0.075192 78.5250000 0.073462 78.5277778 0.078654 78.5305556 0.078654 78.5333333 0.080385 78.5361111 0.080385 78.5388889 0.073462 78.5416667 0.073462 78.5444444 0.068269 78.5472222 0.071731 78.5500000 0.064808 78.5527778 0.059615 78.5555556 0.054423 78.5583333 0.052692 78.5611111 0.054423 78.5638889 0.056154 78.5666667 0.054423 78.5694444 0.050962 78.5722222 0.052692 78.5750000 0.047500 78.5777778 0.045769 78.5805556 0.040577 78.5833333 0.042308 78.5861111 0.035385 78.5888889 0.033654 78.5916667 0.031923 78.5944444 0.031923 78.5972222 0.030192 78.6000000 0.031923 78.6027778 0.030192 78.6055556 0.025000 78.6083333 0.021538 78.6111111 0.021538 78.6138889 0.014615 78.6166667 0.014615 78.6194444 0.012885 78.6222222 0.010000 78.6250000 0.010000 78.6277778 0.010000 78.6305556 0.010000 78.6333333 0.010000 78.6361111 0.010000 78.6388889 0.010000 79.3333333 0.033654 79.3361111 0.035385 79.3388889 0.037115 79.3416667 0.035385 79.3444444 0.028462 79.3472222 0.028462 79.3500000 0.021538 79.3527778 0.023269 79.3555556 0.023269 79.3583333 0.018077 79.3611111 0.021538 79.3638889 0.026731 79.3666667 0.028462 79.3694444 0.033654 79.3722222 0.035385 79.3750000 0.031923 79.3777778 0.026731 79.3805556 0.026731 79.3833333 0.023269 79.3861111 0.025000 79.3888889 0.025000 79.3916667 0.026731 79.3944444 0.028462 79.3972222 0.033654 79.4000000 0.037115 79.4027778 0.035385 79.4055556 0.035385 79.4083333 0.033654 79.4111111 0.026731 79.4138889 0.025000 79.4166667 0.028462 79.4194444 0.028462 79.4222222 0.031923 79.4250000 0.035385 79.4277778 0.037115 79.4305556 0.037115 79.4333333 0.037115 79.4361111 0.042308 79.4388889 0.047500 79.4416667 0.047500 79.4444444 0.047500 79.4472222 0.045769 79.4500000 0.045769 79.4527778 0.042308 79.4555556 0.038846 79.4583333 0.033654 79.4611111 0.033654 79.4638889 0.025000 79.4666667 0.021538 79.4694444 0.019808 79.4722222 0.018077 79.4750000 0.019808 79.4777778 0.023269 79.4805556 0.023269 79.4833333 0.019808 79.4861111 0.014615 79.4888889 0.016346 79.4916667 0.014615 79.4944444 0.011154 79.4972222 0.010000 79.5000000 0.010000 79.5027778 0.010000 79.5055556 0.010000 79.5083333 0.010000 79.5111111 0.010000 79.5138889 0.026731 79.5166667 0.063077 79.5194444 0.097692 79.5222222 0.130577 79.5250000 0.146154 79.5277778 0.149615 79.5305556 0.134038 79.5333333 0.087308 79.5361111 0.012885 79.5388889 0.010000 79.5416667 0.010000 79.5444444 0.010000 79.5472222 0.010000 79.5500000 0.010000 79.5527778 0.010000 79.5555556 0.010000 79.5583333 0.010000 79.5611111 0.033654 79.5638889 0.078654 79.5666667 0.109808 79.5694444 0.123654 79.5722222 0.130577 79.5750000 0.125385 79.5777778 0.106346 79.5805556 0.083846 79.5833333 0.054423 79.5861111 0.037115 79.5888889 0.019808 79.5916667 0.016346 79.5944444 0.019808 79.5972222 0.025000 79.6000000 0.035385 79.6027778 0.050962 79.6055556 0.052692 79.6083333 0.049231 79.6111111 0.033654 79.6138889 0.016346 79.6166667 0.010000 79.6194444 0.010000 79.6222222 0.010000 79.6250000 0.010000 79.6277778 0.010000 79.6305556 0.023269 79.6333333 0.035385 79.6361111 0.047500 79.6388889 0.054423 79.6416667 0.056154 79.6444444 0.061346 79.6472222 0.056154 79.6500000 0.059615 79.6527778 0.063077 79.6555556 0.063077 79.6583333 0.064808 79.6611111 0.068269 79.6638889 0.071731 79.6666667 0.075192 79.6694444 0.076923 79.6722222 0.076923 79.6750000 0.078654 79.6777778 0.080385 79.6805556 0.080385 79.6833333 0.078654 79.6861111 0.080385 79.6888889 0.083846 79.6916667 0.080385 79.6944444 0.082115 79.6972222 0.080385 79.7000000 0.082115 79.7027778 0.082115 79.7055556 0.083846 79.7083333 0.089038 79.7111111 0.089038 79.7138889 0.087308 79.7166667 0.087308 79.7194444 0.082115 79.7222222 0.082115 79.7250000 0.078654 79.7277778 0.080385 79.7305556 0.083846 79.7333333 0.083846 79.7361111 0.085577 79.7388889 0.089038 79.7416667 0.090769 79.7444444 0.090769 79.7472222 0.085577 79.7500000 0.080385 79.7527778 0.082115 79.7555556 0.076923 79.7583333 0.076923 79.7611111 0.073462 79.7638889 0.073462 79.7666667 0.080385 79.7694444 0.080385 79.7722222 0.083846 79.7750000 0.083846 79.7777778 0.082115 79.7805556 0.076923 79.7833333 0.073462 79.7861111 0.064808 79.7888889 0.061346 79.7916667 0.064808 79.7944444 0.064808 79.7972222 0.063077 79.8000000 0.070000 79.8027778 0.066538 79.8055556 0.068269 79.8083333 0.064808 79.8111111 0.059615 79.8138889 0.054423 79.8166667 0.049231 79.8194444 0.042308 79.8222222 0.042308 79.8250000 0.038846 79.8277778 0.035385 79.8305556 0.038846 79.8333333 0.040577 79.8361111 0.038846 79.8388889 0.040577 79.8416667 0.037115 79.8444444 0.028462 79.8472222 0.023269 79.8500000 0.014615 79.8527778 0.014615 79.8555556 0.011154 79.8583333 0.011154 79.8611111 0.011154 79.8638889 0.012885 79.8666667 0.014615 79.8694444 0.012885 79.8722222 0.011154 79.8750000 0.010000 79.8777778 0.010000 79.8805556 0.010000 80.5222222 0.054423 80.5250000 0.054423 80.5277778 0.057885 80.5305556 0.059615 80.5333333 0.061346 80.5361111 0.059615 80.5388889 0.068269 80.5416667 0.064808 80.5444444 0.064808 80.5472222 0.064808 80.5500000 0.056154 80.5527778 0.059615 80.5555556 0.057885 80.5583333 0.061346 80.5611111 0.063077 80.5638889 0.068269 80.5666667 0.068269 80.5694444 0.071731 80.5722222 0.068269 80.5750000 0.063077 80.5777778 0.066538 80.5805556 0.061346 80.5833333 0.059615 80.5861111 0.056154 80.5888889 0.056154 80.5916667 0.057885 80.5944444 0.059615 80.5972222 0.063077 80.6000000 0.064808 80.6027778 0.066538 80.6055556 0.076923 80.6083333 0.080385 80.6111111 0.082115 80.6138889 0.080385 80.6166667 0.082115 80.6194444 0.083846 80.6222222 0.085577 80.6250000 0.083846 80.6277778 0.087308 80.6305556 0.090769 80.6333333 0.090769 80.6361111 0.087308 80.6388889 0.090769 80.6416667 0.083846 80.6444444 0.078654 80.6472222 0.073462 80.6500000 0.071731 80.6527778 0.071731 80.6555556 0.064808 80.6583333 0.063077 80.6611111 0.059615 80.6638889 0.066538 80.6666667 0.063077 80.6694444 0.064808 80.6722222 0.064808 80.6750000 0.066538 80.6777778 0.066538 80.6805556 0.064808 80.6833333 0.066538 80.6861111 0.059615 80.6888889 0.052692 80.6916667 0.044038 80.6944444 0.037115 80.6972222 0.040577 80.7000000 0.050962 80.7027778 0.082115 80.7055556 0.123654 80.7083333 0.170385 80.7111111 0.198077 80.7138889 0.213654 80.7166667 0.208462 80.7194444 0.177308 80.7222222 0.115000 80.7250000 0.023269 80.7277778 0.010000 80.7305556 0.010000 80.7333333 0.010000 80.7361111 0.010000 80.7388889 0.010000 80.7416667 0.010000 80.7444444 0.010000 80.7472222 0.010000 80.7500000 0.040577 80.7527778 0.073462 80.7555556 0.087308 80.7583333 0.094231 80.7611111 0.099423 80.7638889 0.101154 80.7666667 0.101154 80.7694444 0.099423 80.7722222 0.085577 80.7750000 0.075192 80.7777778 0.068269 80.7805556 0.070000 80.7833333 0.070000 80.7861111 0.071731 80.7888889 0.075192 80.7916667 0.080385 80.7944444 0.085577 80.7972222 0.087308 80.8000000 0.085577 80.8027778 0.080385 80.8055556 0.071731 80.8083333 0.064808 80.8111111 0.054423 80.8138889 0.047500 80.8166667 0.054423 80.8194444 0.057885 80.8222222 0.066538 80.8250000 0.073462 80.8277778 0.085577 80.8305556 0.089038 80.8333333 0.099423 80.8361111 0.104615 80.8388889 0.113269 80.8416667 0.116731 80.8444444 0.118462 80.8472222 0.121923 80.8500000 0.120192 80.8527778 0.113269 80.8555556 0.113269 80.8583333 0.113269 80.8611111 0.111538 80.8638889 0.115000 80.8666667 0.115000 80.8694444 0.118462 80.8722222 0.121923 80.8750000 0.121923 80.8777778 0.125385 80.8805556 0.125385 80.8833333 0.121923 80.8861111 0.116731 80.8888889 0.111538 80.8916667 0.116731 80.8944444 0.118462 80.8972222 0.125385 80.9000000 0.128846 80.9027778 0.128846 80.9055556 0.134038 80.9083333 0.132308 80.9111111 0.125385 80.9138889 0.121923 80.9166667 0.118462 80.9194444 0.115000 80.9222222 0.116731 80.9250000 0.120192 80.9277778 0.121923 80.9305556 0.121923 80.9333333 0.125385 80.9361111 0.123654 80.9388889 0.127115 80.9416667 0.127115 80.9444444 0.123654 80.9472222 0.118462 80.9500000 0.115000 80.9527778 0.113269 80.9555556 0.115000 80.9583333 0.118462 80.9611111 0.116731 80.9638889 0.116731 80.9666667 0.123654 80.9694444 0.115000 80.9722222 0.115000 80.9750000 0.116731 80.9777778 0.113269 80.9805556 0.108077 80.9833333 0.106346 80.9861111 0.099423 80.9888889 0.099423 80.9916667 0.097692 80.9944444 0.095962 80.9972222 0.101154 81.0000000 0.094231 81.0027778 0.097692 81.0055556 0.097692 81.0083333 0.095962 81.0111111 0.090769 81.0138889 0.087308 81.0166667 0.080385 81.0194444 0.078654 81.0222222 0.073462 81.0250000 0.071731 81.0277778 0.066538 81.0305556 0.063077 81.0333333 0.059615 81.0361111 0.061346 81.0388889 0.057885 81.0416667 0.057885 81.0444444 0.059615 81.0472222 0.050962 81.0500000 0.044038 81.0527778 0.040577 81.0555556 0.033654 81.0583333 0.033654 81.0611111 0.026731 81.0638889 0.026731 81.0666667 0.026731 81.0694444 0.033654 81.7388889 0.083846 81.7416667 0.083846 81.7444444 0.087308 81.7472222 0.085577 81.7500000 0.087308 81.7527778 0.087308 81.7555556 0.082115 81.7583333 0.076923 81.7611111 0.076923 81.7638889 0.075192 81.7666667 0.076923 81.7694444 0.080385 81.7722222 0.089038 81.7750000 0.087308 81.7777778 0.087308 81.7805556 0.092500 81.7833333 0.087308 81.7861111 0.076923 81.7888889 0.075192 81.7916667 0.075192 81.7944444 0.073462 81.7972222 0.076923 81.8000000 0.083846 81.8027778 0.092500 81.8055556 0.092500 81.8083333 0.097692 81.8111111 0.094231 81.8138889 0.085577 81.8166667 0.087308 81.8194444 0.080385 81.8222222 0.078654 81.8250000 0.076923 81.8277778 0.082115 81.8305556 0.080385 81.8333333 0.087308 81.8361111 0.090769 81.8388889 0.095962 81.8416667 0.099423 81.8444444 0.089038 81.8472222 0.089038 81.8500000 0.089038 81.8527778 0.090769 81.8555556 0.095962 81.8583333 0.092500 81.8611111 0.095962 81.8638889 0.102885 81.8666667 0.102885 81.8694444 0.104615 81.8722222 0.101154 81.8750000 0.102885 81.8777778 0.095962 81.8805556 0.089038 81.8833333 0.082115 81.8861111 0.076923 81.8888889 0.073462 81.8916667 0.075192 81.8944444 0.078654 81.8972222 0.078654 81.9000000 0.080385 81.9027778 0.078654 81.9055556 0.080385 81.9083333 0.080385 81.9111111 0.076923 81.9138889 0.070000 81.9166667 0.061346 81.9194444 0.050962 81.9222222 0.049231 81.9250000 0.057885 81.9277778 0.082115 81.9305556 0.116731 81.9333333 0.160000 81.9361111 0.194615 81.9388889 0.208462 81.9416667 0.199808 81.9444444 0.156538 81.9472222 0.071731 81.9500000 0.010000 81.9527778 0.010000 81.9555556 0.010000 81.9583333 0.010000 81.9611111 0.010000 81.9638889 0.010000 81.9666667 0.066538 81.9694444 0.140962 81.9722222 0.192885 81.9750000 0.217115 81.9777778 0.225769 81.9805556 0.220577 81.9833333 0.199808 81.9861111 0.168654 81.9888889 0.130577 81.9916667 0.095962 81.9944444 0.078654 81.9972222 0.071731 82.0000000 0.073462 82.0027778 0.082115 82.0055556 0.097692 82.0083333 0.104615 82.0111111 0.104615 82.0138889 0.092500 82.0166667 0.070000 82.0194444 0.054423 82.0222222 0.037115 82.0250000 0.038846 82.0277778 0.049231 82.0305556 0.063077 82.0333333 0.082115 82.0361111 0.094231 82.0388889 0.109808 82.0416667 0.115000 82.0444444 0.115000 82.0472222 0.120192 82.0500000 0.123654 82.0527778 0.123654 82.0555556 0.125385 82.0583333 0.128846 82.0611111 0.125385 82.0638889 0.130577 82.0666667 0.127115 82.0694444 0.127115 82.0722222 0.132308 82.0750000 0.130577 82.0777778 0.135769 82.0805556 0.135769 82.0833333 0.132308 82.0861111 0.130577 82.0888889 0.134038 82.0916667 0.130577 82.0944444 0.134038 82.0972222 0.128846 82.1000000 0.135769 82.1027778 0.130577 82.1055556 0.135769 82.1083333 0.139231 82.1111111 0.139231 82.1138889 0.139231 82.1166667 0.132308 82.1194444 0.128846 82.1222222 0.128846 82.1250000 0.127115 82.1277778 0.123654 82.1305556 0.125385 82.1333333 0.128846 82.1361111 0.132308 82.1388889 0.134038 82.1416667 0.137500 82.1444444 0.132308 82.1472222 0.130577 82.1500000 0.125385 82.1527778 0.121923 82.1555556 0.118462 82.1583333 0.120192 82.1611111 0.118462 82.1638889 0.125385 82.1666667 0.125385 82.1694444 0.125385 82.1722222 0.125385 82.1750000 0.121923 82.1777778 0.118462 82.1805556 0.116731 82.1833333 0.113269 82.1861111 0.108077 82.1888889 0.108077 82.1916667 0.102885 82.1944444 0.106346 82.1972222 0.109808 82.2000000 0.108077 82.2027778 0.108077 82.2055556 0.104615 82.2083333 0.095962 82.2111111 0.090769 82.2138889 0.087308 82.2166667 0.089038 82.2194444 0.087308 82.2222222 0.085577 82.2250000 0.080385 82.2277778 0.078654 82.2305556 0.075192 82.2333333 0.076923 82.2361111 0.073462 82.2388889 0.070000 82.2416667 0.070000 82.2444444 0.068269 82.2472222 0.061346 82.2500000 0.057885 82.2527778 0.052692 82.2555556 0.054423 82.2583333 0.050962 82.2611111 0.050962 82.2638889 0.052692 82.2666667 0.052692 82.2694444 0.050962 82.2722222 0.050962 82.2750000 0.052692 82.2777778 0.050962 82.2805556 0.049231 82.2833333 0.042308 82.2861111 0.045769 82.9361111 0.090769 82.9388889 0.092500 82.9416667 0.094231 82.9444444 0.087308 82.9472222 0.083846 82.9500000 0.076923 82.9527778 0.075192 82.9555556 0.078654 82.9583333 0.080385 82.9611111 0.082115 82.9638889 0.085577 82.9666667 0.082115 82.9694444 0.082115 82.9722222 0.083846 82.9750000 0.075192 82.9777778 0.073462 82.9805556 0.075192 82.9833333 0.078654 82.9861111 0.073462 82.9888889 0.078654 82.9916667 0.080385 82.9944444 0.082115 82.9972222 0.083846 83.0000000 0.083846 83.0027778 0.085577 83.0055556 0.087308 83.0083333 0.082115 83.0111111 0.083846 83.0138889 0.087308 83.0166667 0.083846 83.0194444 0.090769 83.0222222 0.087308 83.0250000 0.090769 83.0277778 0.090769 83.0305556 0.089038 83.0333333 0.092500 83.0361111 0.095962 83.0388889 0.097692 83.0416667 0.106346 83.0444444 0.104615 83.0472222 0.109808 83.0500000 0.108077 83.0527778 0.102885 83.0555556 0.095962 83.0583333 0.095962 83.0611111 0.087308 83.0638889 0.085577 83.0666667 0.090769 83.0694444 0.087308 83.0722222 0.090769 83.0750000 0.092500 83.0777778 0.089038 83.0805556 0.087308 83.0833333 0.085577 83.0861111 0.082115 83.0888889 0.078654 83.0916667 0.082115 83.0944444 0.076923 83.0972222 0.078654 83.1000000 0.080385 83.1027778 0.082115 83.1055556 0.082115 83.1083333 0.078654 83.1111111 0.075192 83.1138889 0.066538 83.1166667 0.066538 83.1194444 0.075192 83.1222222 0.104615 83.1250000 0.153077 83.1277778 0.194615 83.1305556 0.218846 83.1333333 0.218846 83.1361111 0.184231 83.1388889 0.099423 83.1416667 0.010000 83.1444444 0.010000 83.1472222 0.010000 83.1500000 0.010000 83.1527778 0.010000 83.1555556 0.010000 83.1583333 0.010000 83.1611111 0.010000 83.1638889 0.061346 83.1666667 0.104615 83.1694444 0.127115 83.1722222 0.132308 83.1750000 0.135769 83.1777778 0.125385 83.1805556 0.116731 83.1833333 0.097692 83.1861111 0.082115 83.1888889 0.082115 83.1916667 0.085577 83.1944444 0.097692 83.1972222 0.101154 83.2000000 0.109808 83.2027778 0.115000 83.2055556 0.118462 83.2083333 0.120192 83.2111111 0.116731 83.2138889 0.101154 83.2166667 0.085577 83.2194444 0.066538 83.2222222 0.056154 83.2250000 0.049231 83.2277778 0.054423 83.2305556 0.066538 83.2333333 0.078654 83.2361111 0.094231 83.2388889 0.097692 83.2416667 0.104615 83.2444444 0.108077 83.2472222 0.108077 83.2500000 0.111538 83.2527778 0.113269 83.2555556 0.116731 83.2583333 0.116731 83.2611111 0.121923 83.2638889 0.123654 83.2666667 0.127115 83.2694444 0.127115 83.2722222 0.123654 83.2750000 0.125385 83.2777778 0.127115 83.2805556 0.125385 83.2833333 0.125385 83.2861111 0.125385 83.2888889 0.125385 83.2916667 0.125385 83.2944444 0.123654 83.2972222 0.125385 83.3000000 0.125385 83.3027778 0.128846 83.3055556 0.127115 83.3083333 0.128846 83.3111111 0.132308 83.3138889 0.130577 83.3166667 0.125385 83.3194444 0.128846 83.3222222 0.128846 83.3250000 0.127115 83.3277778 0.125385 83.3305556 0.125385 83.3333333 0.120192 83.3361111 0.121923 83.3388889 0.125385 83.3416667 0.130577 83.3444444 0.128846 83.3472222 0.130577 83.3500000 0.125385 83.3527778 0.123654 83.3555556 0.120192 83.3583333 0.111538 83.3611111 0.115000 83.3638889 0.111538 83.3666667 0.118462 83.3694444 0.121923 83.3722222 0.123654 83.3750000 0.125385 83.3777778 0.120192 83.3805556 0.116731 83.3833333 0.118462 83.3861111 0.109808 83.3888889 0.108077 83.3916667 0.102885 83.3944444 0.108077 83.3972222 0.104615 83.4000000 0.108077 83.4027778 0.106346 83.4055556 0.108077 83.4083333 0.109808 83.4111111 0.106346 83.4138889 0.099423 83.4166667 0.094231 83.4194444 0.089038 83.4222222 0.082115 83.4250000 0.082115 83.4277778 0.082115 83.4305556 0.085577 83.4333333 0.083846 83.4361111 0.085577 83.4388889 0.082115 83.4416667 0.075192 83.4444444 0.071731 83.4472222 0.066538 83.4500000 0.059615 83.4527778 0.054423 83.4555556 0.052692 83.4583333 0.052692 83.4611111 0.050962 83.4638889 0.054423 83.4666667 0.054423 83.4694444 0.052692 83.4722222 0.049231 83.4750000 0.047500 83.4777778 0.042308 83.4805556 0.038846 83.4833333 0.031923 84.1472222 0.082115 84.1500000 0.082115 84.1527778 0.078654 84.1555556 0.078654 84.1583333 0.071731 84.1611111 0.070000 84.1638889 0.071731 84.1666667 0.075192 84.1694444 0.075192 84.1722222 0.082115 84.1750000 0.082115 84.1777778 0.083846 84.1805556 0.080385 84.1833333 0.080385 84.1861111 0.076923 84.1888889 0.075192 84.1916667 0.075192 84.1944444 0.075192 84.1972222 0.078654 84.2000000 0.080385 84.2027778 0.083846 84.2055556 0.085577 84.2083333 0.085577 84.2111111 0.089038 84.2138889 0.085577 84.2166667 0.080385 84.2194444 0.078654 84.2222222 0.075192 84.2250000 0.076923 84.2277778 0.078654 84.2305556 0.080385 84.2333333 0.087308 84.2361111 0.089038 84.2388889 0.094231 84.2416667 0.099423 84.2444444 0.099423 84.2472222 0.097692 84.2500000 0.099423 84.2527778 0.097692 84.2555556 0.092500 84.2583333 0.090769 84.2611111 0.095962 84.2638889 0.090769 84.2666667 0.092500 84.2694444 0.090769 84.2722222 0.090769 84.2750000 0.090769 84.2777778 0.082115 84.2805556 0.080385 84.2833333 0.078654 84.2861111 0.075192 84.2888889 0.070000 84.2916667 0.068269 84.2944444 0.071731 84.2972222 0.073462 84.3000000 0.078654 84.3027778 0.080385 84.3055556 0.080385 84.3083333 0.085577 84.3111111 0.078654 84.3138889 0.070000 84.3166667 0.059615 84.3194444 0.047500 84.3222222 0.044038 84.3250000 0.045769 84.3277778 0.063077 84.3305556 0.090769 84.3333333 0.128846 84.3361111 0.172115 84.3388889 0.201538 84.3416667 0.217115 84.3444444 0.206731 84.3472222 0.163462 84.3500000 0.089038 84.3527778 0.010000 84.3555556 0.010000 84.3583333 0.010000 84.3611111 0.010000 84.3638889 0.010000 84.3666667 0.010000 84.3694444 0.010000 84.3722222 0.078654 84.3750000 0.134038 84.3777778 0.166923 84.3805556 0.185962 84.3833333 0.192885 84.3861111 0.196346 84.3888889 0.189423 84.3916667 0.175577 84.3944444 0.153077 84.3972222 0.127115 84.4000000 0.104615 84.4027778 0.087308 84.4055556 0.073462 84.4083333 0.073462 84.4111111 0.078654 84.4138889 0.080385 84.4166667 0.095962 84.4194444 0.102885 84.4222222 0.099423 84.4250000 0.090769 84.4277778 0.075192 84.4305556 0.063077 84.4333333 0.052692 84.4361111 0.047500 84.4388889 0.050962 84.4416667 0.061346 84.4444444 0.070000 84.4472222 0.076923 84.4500000 0.089038 84.4527778 0.089038 84.4555556 0.094231 84.4583333 0.099423 84.4611111 0.109808 84.4638889 0.115000 84.4666667 0.120192 84.4694444 0.125385 84.4722222 0.128846 84.4750000 0.134038 84.4777778 0.130577 84.4805556 0.130577 84.4833333 0.125385 84.4861111 0.130577 84.4888889 0.130577 84.4916667 0.127115 84.4944444 0.123654 84.4972222 0.128846 84.5000000 0.130577 84.5027778 0.135769 84.5055556 0.135769 84.5083333 0.135769 84.5111111 0.139231 84.5138889 0.139231 84.5166667 0.134038 84.5194444 0.134038 84.5222222 0.128846 84.5250000 0.130577 84.5277778 0.130577 84.5305556 0.130577 84.5333333 0.132308 84.5361111 0.135769 84.5388889 0.142692 84.5416667 0.146154 84.5444444 0.144423 84.5472222 0.140962 84.5500000 0.139231 84.5527778 0.134038 84.5555556 0.130577 84.5583333 0.127115 84.5611111 0.125385 84.5638889 0.125385 84.5666667 0.132308 84.5694444 0.132308 84.5722222 0.135769 84.5750000 0.142692 84.5777778 0.139231 84.5805556 0.132308 84.5833333 0.134038 84.5861111 0.125385 84.5888889 0.127115 84.5916667 0.125385 84.5944444 0.118462 84.5972222 0.123654 84.6000000 0.128846 84.6027778 0.127115 84.6055556 0.134038 84.6083333 0.134038 84.6111111 0.125385 84.6138889 0.118462 84.6166667 0.115000 84.6194444 0.113269 84.6222222 0.109808 84.6250000 0.108077 84.6277778 0.108077 84.6305556 0.106346 84.6333333 0.109808 84.6361111 0.102885 84.6388889 0.106346 84.6416667 0.102885 84.6444444 0.094231 84.6472222 0.087308 84.6500000 0.078654 84.6527778 0.075192 84.6555556 0.073462 84.6583333 0.070000 84.6611111 0.073462 84.6638889 0.075192 84.6666667 0.071731 84.6694444 0.071731 84.6722222 0.075192 84.6750000 0.066538 84.6777778 0.061346 84.6805556 0.052692 84.6833333 0.054423 84.6861111 0.049231 84.6888889 0.049231 84.6916667 0.049231 84.6944444 0.047500 85.3722222 0.090769 85.3750000 0.092500 85.3777778 0.087308 85.3805556 0.083846 85.3833333 0.085577 85.3861111 0.082115 85.3888889 0.078654 85.3916667 0.083846 85.3944444 0.078654 85.3972222 0.082115 85.4000000 0.089038 85.4027778 0.087308 85.4055556 0.083846 85.4083333 0.083846 85.4111111 0.080385 85.4138889 0.078654 85.4166667 0.080385 85.4194444 0.078654 85.4222222 0.075192 85.4250000 0.078654 85.4277778 0.075192 85.4305556 0.076923 85.4333333 0.082115 85.4361111 0.078654 85.4388889 0.080385 85.4416667 0.087308 85.4444444 0.090769 85.4472222 0.087308 85.4500000 0.083846 85.4527778 0.083846 85.4555556 0.083846 85.4583333 0.082115 85.4611111 0.080385 85.4638889 0.078654 85.4666667 0.076923 85.4694444 0.083846 85.4722222 0.085577 85.4750000 0.094231 85.4777778 0.095962 85.4805556 0.099423 85.4833333 0.102885 85.4861111 0.101154 85.4888889 0.101154 85.4916667 0.095962 85.4944444 0.094231 85.4972222 0.089038 85.5000000 0.089038 85.5027778 0.089038 85.5055556 0.089038 85.5083333 0.085577 85.5111111 0.085577 85.5138889 0.082115 85.5166667 0.082115 85.5194444 0.075192 85.5222222 0.071731 85.5250000 0.066538 85.5277778 0.066538 85.5305556 0.063077 85.5333333 0.068269 85.5361111 0.068269 85.5388889 0.071731 85.5416667 0.071731 85.5444444 0.071731 85.5472222 0.066538 85.5500000 0.061346 85.5527778 0.050962 85.5555556 0.045769 85.5583333 0.049231 85.5611111 0.070000 85.5638889 0.108077 85.5666667 0.153077 85.5694444 0.189423 85.5722222 0.205000 85.5750000 0.184231 85.5777778 0.127115 85.5805556 0.023269 85.5833333 0.010000 85.5861111 0.010000 85.5888889 0.010000 85.5916667 0.010000 85.5944444 0.010000 85.5972222 0.010000 85.6000000 0.035385 85.6027778 0.106346 85.6055556 0.149615 85.6083333 0.180769 85.6111111 0.185962 85.6138889 0.184231 85.6166667 0.172115 85.6194444 0.149615 85.6222222 0.118462 85.6250000 0.094231 85.6277778 0.076923 85.6305556 0.071731 85.6333333 0.070000 85.6361111 0.076923 85.6388889 0.087308 85.6416667 0.099423 85.6444444 0.104615 85.6472222 0.095962 85.6500000 0.078654 85.6527778 0.057885 85.6555556 0.042308 85.6583333 0.031923 85.6611111 0.030192 85.6638889 0.038846 85.6666667 0.050962 85.6694444 0.063077 85.6722222 0.071731 85.6750000 0.083846 85.6777778 0.090769 85.6805556 0.099423 85.6833333 0.104615 85.6861111 0.104615 85.6888889 0.109808 85.6916667 0.108077 85.6944444 0.108077 85.6972222 0.102885 85.7000000 0.109808 85.7027778 0.111538 85.7055556 0.113269 85.7083333 0.123654 85.7111111 0.125385 85.7138889 0.125385 85.7166667 0.127115 85.7194444 0.121923 85.7222222 0.121923 85.7250000 0.115000 85.7277778 0.118462 85.7305556 0.111538 85.7333333 0.116731 85.7361111 0.127115 85.7388889 0.128846 85.7416667 0.128846 85.7444444 0.127115 85.7472222 0.128846 85.7500000 0.121923 85.7527778 0.116731 85.7555556 0.120192 85.7583333 0.113269 85.7611111 0.115000 85.7638889 0.118462 85.7666667 0.121923 85.7694444 0.123654 85.7722222 0.125385 85.7750000 0.130577 85.7777778 0.128846 85.7805556 0.120192 85.7833333 0.115000 85.7861111 0.111538 85.7888889 0.111538 85.7916667 0.109808 85.7944444 0.115000 85.7972222 0.111538 85.8000000 0.111538 85.8027778 0.113269 85.8055556 0.115000 85.8083333 0.121923 85.8111111 0.116731 85.8138889 0.111538 85.8166667 0.111538 85.8194444 0.106346 85.8222222 0.101154 85.8250000 0.106346 85.8277778 0.101154 85.8305556 0.097692 85.8333333 0.102885 85.8361111 0.104615 85.8388889 0.101154 85.8416667 0.099423 85.8444444 0.094231 85.8472222 0.087308 85.8500000 0.083846 85.8527778 0.078654 85.8555556 0.078654 85.8583333 0.078654 85.8611111 0.073462 85.8638889 0.073462 85.8666667 0.073462 85.8694444 0.070000 85.8722222 0.073462 85.8750000 0.066538 85.8777778 0.066538 85.8805556 0.059615 85.8833333 0.059615 85.8861111 0.059615 85.8888889 0.054423 85.8916667 0.050962 85.8944444 0.054423 85.8972222 0.050962 85.9000000 0.054423 85.9027778 0.049231 85.9055556 0.047500 85.9083333 0.044038 85.9111111 0.044038 85.9138889 0.040577 85.9166667 0.037115 85.9194444 0.031923 86.6111111 0.064808 86.6138889 0.064808 86.6166667 0.059615 86.6194444 0.057885 86.6222222 0.049231 86.6250000 0.052692 86.6277778 0.052692 86.6305556 0.059615 86.6333333 0.059615 86.6361111 0.064808 86.6388889 0.068269 86.6416667 0.066538 86.6444444 0.066538 86.6472222 0.056154 86.6500000 0.056154 86.6527778 0.052692 86.6555556 0.052692 86.6583333 0.056154 86.6611111 0.052692 86.6638889 0.059615 86.6666667 0.064808 86.6694444 0.066538 86.6722222 0.066538 86.6750000 0.070000 86.6777778 0.064808 86.6805556 0.061346 86.6833333 0.063077 86.6861111 0.061346 86.6888889 0.056154 86.6916667 0.057885 86.6944444 0.057885 86.6972222 0.061346 86.7000000 0.059615 86.7027778 0.064808 86.7055556 0.068269 86.7083333 0.070000 86.7111111 0.071731 86.7138889 0.070000 86.7166667 0.075192 86.7194444 0.075192 86.7222222 0.075192 86.7250000 0.076923 86.7277778 0.076923 86.7305556 0.078654 86.7333333 0.073462 86.7361111 0.075192 86.7388889 0.073462 86.7416667 0.073462 86.7444444 0.075192 86.7472222 0.068269 86.7500000 0.066538 86.7527778 0.059615 86.7555556 0.059615 86.7583333 0.057885 86.7611111 0.056154 86.7638889 0.059615 86.7666667 0.059615 86.7694444 0.061346 86.7722222 0.061346 86.7750000 0.064808 86.7777778 0.063077 86.7805556 0.061346 86.7833333 0.052692 86.7861111 0.044038 86.7888889 0.035385 86.7916667 0.037115 86.7944444 0.059615 86.7972222 0.101154 86.8000000 0.147885 86.8027778 0.185962 86.8055556 0.210192 86.8083333 0.206731 86.8111111 0.165192 86.8138889 0.087308 86.8166667 0.010000 86.8194444 0.010000 86.8222222 0.010000 86.8250000 0.010000 86.8277778 0.010000 86.8305556 0.010000 86.8333333 0.010000 86.8361111 0.010000 86.8388889 0.070000 86.8416667 0.113269 86.8444444 0.128846 86.8472222 0.134038 86.8500000 0.132308 86.8527778 0.128846 86.8555556 0.123654 86.8583333 0.102885 86.8611111 0.083846 86.8638889 0.073462 86.8666667 0.064808 86.8694444 0.063077 86.8722222 0.066538 86.8750000 0.070000 86.8777778 0.071731 86.8805556 0.082115 86.8833333 0.085577 86.8861111 0.082115 86.8888889 0.073462 86.8916667 0.056154 86.8944444 0.047500 86.8972222 0.040577 86.9000000 0.035385 86.9027778 0.038846 86.9055556 0.047500 86.9083333 0.061346 86.9111111 0.070000 86.9138889 0.070000 86.9166667 0.078654 86.9194444 0.087308 86.9222222 0.095962 86.9250000 0.095962 86.9277778 0.106346 86.9305556 0.108077 86.9333333 0.109808 86.9361111 0.111538 86.9388889 0.111538 86.9416667 0.113269 86.9444444 0.111538 86.9472222 0.109808 86.9500000 0.108077 86.9527778 0.111538 86.9555556 0.109808 86.9583333 0.113269 86.9611111 0.111538 86.9638889 0.111538 86.9666667 0.111538 86.9694444 0.111538 86.9722222 0.113269 86.9750000 0.115000 86.9777778 0.118462 86.9805556 0.118462 86.9833333 0.120192 86.9861111 0.115000 86.9888889 0.109808 86.9916667 0.109808 86.9944444 0.113269 86.9972222 0.115000 87.0000000 0.111538 87.0027778 0.109808 87.0055556 0.111538 87.0083333 0.113269 87.0111111 0.111538 87.0138889 0.115000 87.0166667 0.109808 87.0194444 0.109808 87.0222222 0.108077 87.0250000 0.104615 87.0277778 0.102885 87.0305556 0.104615 87.0333333 0.106346 87.0361111 0.106346 87.0388889 0.106346 87.0416667 0.113269 87.0444444 0.115000 87.0472222 0.109808 87.0500000 0.109808 87.0527778 0.102885 87.0555556 0.099423 87.0583333 0.097692 87.0611111 0.094231 87.0638889 0.094231 87.0666667 0.092500 87.0694444 0.099423 87.0722222 0.095962 87.0750000 0.099423 87.0777778 0.097692 87.0805556 0.090769 87.0833333 0.092500 87.0861111 0.085577 87.0888889 0.078654 87.0916667 0.076923 87.0944444 0.070000 87.0972222 0.070000 87.1000000 0.070000 87.1027778 0.070000 87.1055556 0.071731 87.1083333 0.075192 87.1111111 0.073462 87.1138889 0.068269 87.1166667 0.066538 87.1194444 0.056154 87.1222222 0.052692 87.1250000 0.045769 87.1277778 0.038846 87.1305556 0.042308 87.1333333 0.047500 87.1361111 0.042308 87.1388889 0.047500 87.1416667 0.047500 87.1444444 0.042308 87.1472222 0.038846 87.1500000 0.031923 87.1527778 0.025000 87.1555556 0.019808 87.1583333 0.014615 87.8416667 0.061346 87.8444444 0.064808 87.8472222 0.057885 87.8500000 0.052692 87.8527778 0.047500 87.8555556 0.045769 87.8583333 0.044038 87.8611111 0.040577 87.8638889 0.044038 87.8666667 0.047500 87.8694444 0.054423 87.8722222 0.057885 87.8750000 0.057885 87.8777778 0.056154 87.8805556 0.057885 87.8833333 0.054423 87.8861111 0.049231 87.8888889 0.052692 87.8916667 0.049231 87.8944444 0.052692 87.8972222 0.056154 87.9000000 0.059615 87.9027778 0.063077 87.9055556 0.061346 87.9083333 0.064808 87.9111111 0.064808 87.9138889 0.057885 87.9166667 0.059615 87.9194444 0.052692 87.9222222 0.050962 87.9250000 0.050962 87.9277778 0.050962 87.9305556 0.059615 87.9333333 0.056154 87.9361111 0.057885 87.9388889 0.064808 87.9416667 0.071731 87.9444444 0.075192 87.9472222 0.073462 87.9500000 0.070000 87.9527778 0.071731 87.9555556 0.066538 87.9583333 0.068269 87.9611111 0.068269 87.9638889 0.068269 87.9666667 0.070000 87.9694444 0.068269 87.9722222 0.064808 87.9750000 0.064808 87.9777778 0.063077 87.9805556 0.052692 87.9833333 0.050962 87.9861111 0.052692 87.9888889 0.045769 87.9916667 0.052692 87.9944444 0.050962 87.9972222 0.056154 88.0000000 0.057885 88.0027778 0.057885 88.0055556 0.056154 88.0083333 0.054423 88.0111111 0.047500 88.0138889 0.037115 88.0166667 0.028462 88.0194444 0.033654 88.0222222 0.054423 88.0250000 0.083846 88.0277778 0.120192 88.0305556 0.154808 88.0333333 0.175577 88.0361111 0.179038 88.0388889 0.163462 88.0416667 0.121923 88.0444444 0.050962 88.0472222 0.010000 88.0500000 0.010000 88.0527778 0.010000 88.0555556 0.010000 88.0583333 0.010000 88.0611111 0.010000 88.0638889 0.010000 88.0666667 0.021538 88.0694444 0.080385 88.0722222 0.125385 88.0750000 0.158269 88.0777778 0.172115 88.0805556 0.179038 88.0833333 0.182500 88.0861111 0.175577 88.0888889 0.165192 88.0916667 0.132308 88.0944444 0.101154 88.0972222 0.070000 88.1000000 0.049231 88.1027778 0.037115 88.1055556 0.035385 88.1083333 0.045769 88.1111111 0.059615 88.1138889 0.070000 88.1166667 0.070000 88.1194444 0.073462 88.1222222 0.061346 88.1250000 0.045769 88.1277778 0.030192 88.1305556 0.019808 88.1333333 0.016346 88.1361111 0.025000 88.1388889 0.035385 88.1416667 0.050962 88.1444444 0.063077 88.1472222 0.073462 88.1500000 0.080385 88.1527778 0.082115 88.1555556 0.083846 88.1583333 0.087308 88.1611111 0.085577 88.1638889 0.090769 88.1666667 0.094231 88.1694444 0.095962 88.1722222 0.102885 88.1750000 0.106346 88.1777778 0.108077 88.1805556 0.106346 88.1833333 0.102885 88.1861111 0.101154 88.1888889 0.099423 88.1916667 0.095962 88.1944444 0.095962 88.1972222 0.097692 88.2000000 0.101154 88.2027778 0.108077 88.2055556 0.109808 88.2083333 0.113269 88.2111111 0.111538 88.2138889 0.116731 88.2166667 0.113269 88.2194444 0.113269 88.2222222 0.111538 88.2250000 0.111538 88.2277778 0.108077 88.2305556 0.109808 88.2333333 0.115000 88.2361111 0.118462 88.2388889 0.123654 88.2416667 0.121923 88.2444444 0.121923 88.2472222 0.121923 88.2500000 0.115000 88.2527778 0.106346 88.2555556 0.106346 88.2583333 0.102885 88.2611111 0.106346 88.2638889 0.108077 88.2666667 0.108077 88.2694444 0.109808 88.2722222 0.108077 88.2750000 0.108077 88.2777778 0.104615 88.2805556 0.101154 88.2833333 0.095962 88.2861111 0.095962 88.2888889 0.094231 88.2916667 0.095962 88.2944444 0.089038 88.2972222 0.092500 88.3000000 0.090769 88.3027778 0.089038 88.3055556 0.090769 88.3083333 0.090769 88.3111111 0.083846 88.3138889 0.082115 88.3166667 0.078654 88.3194444 0.071731 88.3222222 0.071731 88.3250000 0.066538 88.3277778 0.068269 88.3305556 0.064808 88.3333333 0.066538 88.3361111 0.061346 88.3388889 0.059615 88.3416667 0.064808 88.3444444 0.057885 88.3472222 0.056154 88.3500000 0.054423 88.3527778 0.049231 88.3555556 0.045769 88.3583333 0.037115 88.3611111 0.033654 88.3638889 0.028462 88.3666667 0.021538 88.3694444 0.030192 88.3722222 0.026731 88.3750000 0.030192 88.3777778 0.031923 88.3805556 0.028462 88.3833333 0.026731 88.3861111 0.021538 88.3888889 0.016346 89.0416667 0.052692 89.0444444 0.054423 89.0472222 0.057885 89.0500000 0.057885 89.0527778 0.056154 89.0555556 0.052692 89.0583333 0.052692 89.0611111 0.049231 89.0638889 0.050962 89.0666667 0.049231 89.0694444 0.056154 89.0722222 0.057885 89.0750000 0.059615 89.0777778 0.066538 89.0805556 0.063077 89.0833333 0.057885 89.0861111 0.054423 89.0888889 0.045769 89.0916667 0.047500 89.0944444 0.045769 89.0972222 0.047500 89.1000000 0.050962 89.1027778 0.054423 89.1055556 0.059615 89.1083333 0.063077 89.1111111 0.066538 89.1138889 0.057885 89.1166667 0.054423 89.1194444 0.050962 89.1222222 0.047500 89.1250000 0.047500 89.1277778 0.044038 89.1305556 0.045769 89.1333333 0.050962 89.1361111 0.050962 89.1388889 0.059615 89.1416667 0.064808 89.1444444 0.068269 89.1472222 0.066538 89.1500000 0.068269 89.1527778 0.070000 89.1555556 0.070000 89.1583333 0.059615 89.1611111 0.063077 89.1638889 0.068269 89.1666667 0.063077 89.1694444 0.064808 89.1722222 0.066538 89.1750000 0.061346 89.1777778 0.061346 89.1805556 0.056154 89.1833333 0.047500 89.1861111 0.047500 89.1888889 0.042308 89.1916667 0.044038 89.1944444 0.047500 89.1972222 0.045769 89.2000000 0.049231 89.2027778 0.050962 89.2055556 0.052692 89.2083333 0.054423 89.2111111 0.049231 89.2138889 0.038846 89.2166667 0.030192 89.2194444 0.025000 89.2222222 0.023269 89.2250000 0.040577 89.2277778 0.076923 89.2305556 0.120192 89.2333333 0.160000 89.2361111 0.184231 89.2388889 0.180769 89.2416667 0.149615 89.2444444 0.082115 89.2472222 0.010000 89.2500000 0.010000 89.2527778 0.010000 89.2555556 0.010000 89.2583333 0.010000 89.2611111 0.010000 89.2638889 0.010000 89.2666667 0.010000 89.2694444 0.059615 89.2722222 0.111538 89.2750000 0.142692 89.2777778 0.154808 89.2805556 0.156538 89.2833333 0.153077 89.2861111 0.144423 89.2888889 0.123654 89.2916667 0.095962 89.2944444 0.068269 89.2972222 0.044038 89.3000000 0.038846 89.3027778 0.042308 89.3055556 0.045769 89.3083333 0.057885 89.3111111 0.070000 89.3138889 0.076923 89.3166667 0.076923 89.3194444 0.061346 89.3222222 0.047500 89.3250000 0.028462 89.3277778 0.011154 89.3305556 0.010000 89.3333333 0.012885 89.3361111 0.028462 89.3388889 0.040577 89.3416667 0.056154 89.3444444 0.070000 89.3472222 0.073462 89.3500000 0.082115 89.3527778 0.085577 89.3555556 0.085577 89.3583333 0.087308 89.3611111 0.089038 89.3638889 0.092500 89.3666667 0.094231 89.3694444 0.099423 89.3722222 0.102885 89.3750000 0.101154 89.3777778 0.106346 89.3805556 0.106346 89.3833333 0.104615 89.3861111 0.101154 89.3888889 0.101154 89.3916667 0.095962 89.3944444 0.095962 89.3972222 0.101154 89.4000000 0.104615 89.4027778 0.108077 89.4055556 0.109808 89.4083333 0.109808 89.4111111 0.115000 89.4138889 0.106346 89.4166667 0.108077 89.4194444 0.106346 89.4222222 0.106346 89.4250000 0.099423 89.4277778 0.099423 89.4305556 0.099423 89.4333333 0.102885 89.4361111 0.106346 89.4388889 0.104615 89.4416667 0.108077 89.4444444 0.106346 89.4472222 0.108077 89.4500000 0.102885 89.4527778 0.104615 89.4555556 0.101154 89.4583333 0.102885 89.4611111 0.099423 89.4638889 0.101154 89.4666667 0.102885 89.4694444 0.101154 89.4722222 0.108077 89.4750000 0.102885 89.4777778 0.104615 89.4805556 0.104615 89.4833333 0.101154 89.4861111 0.095962 89.4888889 0.095962 89.4916667 0.090769 89.4944444 0.094231 89.4972222 0.089038 89.5000000 0.085577 89.5027778 0.089038 89.5055556 0.087308 89.5083333 0.094231 89.5111111 0.087308 89.5138889 0.087308 89.5166667 0.087308 89.5194444 0.080385 89.5222222 0.073462 89.5250000 0.070000 89.5277778 0.064808 89.5305556 0.064808 89.5333333 0.059615 89.5361111 0.059615 89.5388889 0.063077 89.5416667 0.064808 89.5444444 0.064808 89.5472222 0.061346 89.5500000 0.056154 89.5527778 0.052692 89.5555556 0.047500 89.5583333 0.042308 89.5611111 0.035385 89.5638889 0.033654 89.5666667 0.033654 89.5694444 0.035385 89.5722222 0.033654 89.5750000 0.037115 89.5777778 0.031923 89.5805556 0.033654 89.5833333 0.025000 89.5861111 0.021538 89.5888889 0.016346 90.2638889 0.054423 90.2666667 0.063077 90.2694444 0.066538 90.2722222 0.070000 90.2750000 0.068269 90.2777778 0.071731 90.2805556 0.073462 90.2833333 0.066538 90.2861111 0.061346 90.2888889 0.056154 90.2916667 0.052692 90.2944444 0.049231 90.2972222 0.054423 90.3000000 0.057885 90.3027778 0.061346 90.3055556 0.066538 90.3083333 0.071731 90.3111111 0.064808 90.3138889 0.064808 90.3166667 0.061346 90.3194444 0.059615 90.3222222 0.056154 90.3250000 0.056154 90.3277778 0.056154 90.3305556 0.059615 90.3333333 0.061346 90.3361111 0.066538 90.3388889 0.068269 90.3416667 0.070000 90.3444444 0.071731 90.3472222 0.064808 90.3500000 0.063077 90.3527778 0.064808 90.3555556 0.064808 90.3583333 0.061346 90.3611111 0.063077 90.3638889 0.071731 90.3666667 0.073462 90.3694444 0.078654 90.3722222 0.080385 90.3750000 0.085577 90.3777778 0.089038 90.3805556 0.083846 90.3833333 0.082115 90.3861111 0.076923 90.3888889 0.073462 90.3916667 0.070000 90.3944444 0.068269 90.3972222 0.068269 90.4000000 0.061346 90.4027778 0.059615 90.4055556 0.063077 90.4083333 0.064808 90.4111111 0.061346 90.4138889 0.064808 90.4166667 0.059615 90.4194444 0.061346 90.4222222 0.057885 90.4250000 0.052692 90.4277778 0.052692 90.4305556 0.050962 90.4333333 0.049231 90.4361111 0.047500 90.4388889 0.044038 90.4416667 0.040577 90.4444444 0.050962 90.4472222 0.070000 90.4500000 0.102885 90.4527778 0.146154 90.4555556 0.177308 90.4583333 0.199808 90.4611111 0.191154 90.4638889 0.154808 90.4666667 0.078654 90.4694444 0.010000 90.4722222 0.010000 90.4750000 0.010000 90.4777778 0.010000 90.4805556 0.010000 90.4833333 0.010000 90.4861111 0.010000 90.4888889 0.010000 90.4916667 0.040577 90.4944444 0.083846 90.4972222 0.104615 90.5000000 0.115000 90.5027778 0.116731 90.5055556 0.116731 90.5083333 0.102885 90.5111111 0.087308 90.5138889 0.066538 90.5166667 0.057885 90.5194444 0.050962 90.5222222 0.054423 90.5250000 0.061346 90.5277778 0.071731 90.5305556 0.076923 90.5333333 0.087308 90.5361111 0.089038 90.5388889 0.083846 90.5416667 0.075192 90.5444444 0.059615 90.5472222 0.047500 90.5500000 0.042308 90.5527778 0.038846 90.5555556 0.050962 90.5583333 0.056154 90.5611111 0.064808 90.5638889 0.076923 90.5666667 0.089038 90.5694444 0.095962 90.5722222 0.102885 90.5750000 0.108077 90.5777778 0.115000 90.5805556 0.115000 90.5833333 0.111538 90.5861111 0.113269 90.5888889 0.116731 90.5916667 0.111538 90.5944444 0.115000 90.5972222 0.116731 90.6000000 0.116731 90.6027778 0.120192 90.6055556 0.121923 90.6083333 0.125385 90.6111111 0.128846 90.6138889 0.125385 90.6166667 0.130577 90.6194444 0.128846 90.6222222 0.128846 90.6250000 0.127115 90.6277778 0.125385 90.6305556 0.123654 90.6333333 0.123654 90.6361111 0.123654 90.6388889 0.123654 90.6416667 0.125385 90.6444444 0.125385 90.6472222 0.130577 90.6500000 0.128846 90.6527778 0.123654 90.6555556 0.121923 90.6583333 0.118462 90.6611111 0.115000 90.6638889 0.111538 90.6666667 0.116731 90.6694444 0.120192 90.6722222 0.123654 90.6750000 0.121923 90.6777778 0.125385 90.6805556 0.123654 90.6833333 0.121923 90.6861111 0.113269 90.6888889 0.108077 90.6916667 0.104615 90.6944444 0.102885 90.6972222 0.106346 90.7000000 0.106346 90.7027778 0.109808 90.7055556 0.106346 90.7083333 0.108077 90.7111111 0.108077 90.7138889 0.106346 90.7166667 0.104615 90.7194444 0.094231 90.7222222 0.087308 90.7250000 0.087308 90.7277778 0.085577 90.7305556 0.082115 90.7333333 0.087308 90.7361111 0.089038 90.7388889 0.092500 90.7416667 0.089038 90.7444444 0.089038 90.7472222 0.082115 90.7500000 0.073462 90.7527778 0.071731 90.7555556 0.063077 90.7583333 0.059615 90.7611111 0.059615 90.7638889 0.059615 90.7666667 0.056154 90.7694444 0.057885 90.7722222 0.056154 90.7750000 0.056154 90.7777778 0.052692 90.7805556 0.045769 90.7833333 0.040577 90.7861111 0.033654 90.7888889 0.030192 90.7916667 0.026731 90.7944444 0.025000 90.7972222 0.023269 90.8000000 0.025000 90.8027778 0.023269 90.8055556 0.019808 90.8083333 0.023269 90.8111111 0.019808 91.4861111 0.054423 91.4888889 0.049231 91.4916667 0.052692 91.4944444 0.049231 91.4972222 0.045769 91.5000000 0.049231 91.5027778 0.049231 91.5055556 0.054423 91.5083333 0.056154 91.5111111 0.056154 91.5138889 0.059615 91.5166667 0.059615 91.5194444 0.054423 91.5222222 0.052692 91.5250000 0.052692 91.5277778 0.054423 91.5305556 0.054423 91.5333333 0.054423 91.5361111 0.057885 91.5388889 0.056154 91.5416667 0.061346 91.5444444 0.066538 91.5472222 0.068269 91.5500000 0.066538 91.5527778 0.064808 91.5555556 0.063077 91.5583333 0.063077 91.5611111 0.063077 91.5638889 0.059615 91.5666667 0.059615 91.5694444 0.061346 91.5722222 0.063077 91.5750000 0.059615 91.5777778 0.068269 91.5805556 0.063077 91.5833333 0.073462 91.5861111 0.071731 91.5888889 0.073462 91.5916667 0.068269 91.5944444 0.073462 91.5972222 0.073462 91.6000000 0.064808 91.6027778 0.068269 91.6055556 0.070000 91.6083333 0.070000 91.6111111 0.075192 91.6138889 0.066538 91.6166667 0.063077 91.6194444 0.059615 91.6222222 0.052692 91.6250000 0.052692 91.6277778 0.047500 91.6305556 0.044038 91.6333333 0.050962 91.6361111 0.047500 91.6388889 0.052692 91.6416667 0.056154 91.6444444 0.061346 91.6472222 0.059615 91.6500000 0.054423 91.6527778 0.047500 91.6555556 0.042308 91.6583333 0.031923 91.6611111 0.023269 91.6638889 0.025000 91.6666667 0.045769 91.6694444 0.083846 91.6722222 0.127115 91.6750000 0.158269 91.6777778 0.177308 91.6805556 0.173846 91.6833333 0.144423 91.6861111 0.087308 91.6888889 0.010000 91.6916667 0.010000 91.6944444 0.010000 91.6972222 0.010000 91.7000000 0.010000 91.7027778 0.010000 91.7055556 0.010000 91.7083333 0.010000 91.7111111 0.050962 91.7138889 0.104615 91.7166667 0.144423 91.7194444 0.163462 91.7222222 0.170385 91.7250000 0.172115 91.7277778 0.173846 91.7305556 0.163462 91.7333333 0.142692 91.7361111 0.116731 91.7388889 0.097692 91.7416667 0.075192 91.7444444 0.064808 91.7472222 0.052692 91.7500000 0.049231 91.7527778 0.047500 91.7555556 0.054423 91.7583333 0.059615 91.7611111 0.066538 91.7638889 0.063077 91.7666667 0.057885 91.7694444 0.049231 91.7722222 0.035385 91.7750000 0.026731 91.7777778 0.025000 91.7805556 0.023269 91.7833333 0.030192 91.7861111 0.038846 91.7888889 0.044038 91.7916667 0.050962 91.7944444 0.061346 91.7972222 0.070000 91.8000000 0.078654 91.8027778 0.089038 91.8055556 0.094231 91.8083333 0.095962 91.8111111 0.099423 91.8138889 0.097692 91.8166667 0.099423 91.8194444 0.095962 91.8222222 0.094231 91.8250000 0.094231 91.8277778 0.094231 91.8305556 0.097692 91.8333333 0.099423 91.8361111 0.104615 91.8388889 0.109808 91.8416667 0.109808 91.8444444 0.113269 91.8472222 0.113269 91.8500000 0.104615 91.8527778 0.101154 91.8555556 0.104615 91.8583333 0.104615 91.8611111 0.106346 91.8638889 0.109808 91.8666667 0.108077 91.8694444 0.111538 91.8722222 0.111538 91.8750000 0.111538 91.8777778 0.108077 91.8805556 0.106346 91.8833333 0.102885 91.8861111 0.104615 91.8888889 0.102885 91.8916667 0.104615 91.8944444 0.101154 91.8972222 0.101154 91.9000000 0.099423 91.9027778 0.102885 91.9055556 0.101154 91.9083333 0.104615 91.9111111 0.101154 91.9138889 0.099423 91.9166667 0.097692 91.9194444 0.101154 91.9222222 0.097692 91.9250000 0.099423 91.9277778 0.097692 91.9305556 0.097692 91.9333333 0.095962 91.9361111 0.094231 91.9388889 0.095962 91.9416667 0.092500 91.9444444 0.097692 91.9472222 0.094231 91.9500000 0.092500 91.9527778 0.085577 91.9555556 0.083846 91.9583333 0.082115 91.9611111 0.080385 91.9638889 0.076923 91.9666667 0.080385 91.9694444 0.080385 91.9722222 0.080385 91.9750000 0.080385 91.9777778 0.082115 91.9805556 0.071731 91.9833333 0.071731 91.9861111 0.066538 91.9888889 0.064808 91.9916667 0.061346 91.9944444 0.059615 91.9972222 0.054423 92.0000000 0.054423 92.0027778 0.049231 92.0055556 0.049231 92.0083333 0.045769 92.0111111 0.052692 92.0138889 0.047500 92.0166667 0.042308 92.0194444 0.038846 92.0222222 0.033654 92.0250000 0.030192 92.0277778 0.023269 92.0305556 0.018077 92.0333333 0.021538 92.7250000 0.057885 92.7277778 0.059615 92.7305556 0.056154 92.7333333 0.054423 92.7361111 0.054423 92.7388889 0.059615 92.7416667 0.059615 92.7444444 0.061346 92.7472222 0.061346 92.7500000 0.059615 92.7527778 0.059615 92.7555556 0.054423 92.7583333 0.057885 92.7611111 0.050962 92.7638889 0.054423 92.7666667 0.052692 92.7694444 0.059615 92.7722222 0.061346 92.7750000 0.063077 92.7777778 0.068269 92.7805556 0.064808 92.7833333 0.071731 92.7861111 0.064808 92.7888889 0.061346 92.7916667 0.061346 92.7944444 0.059615 92.7972222 0.057885 92.8000000 0.059615 92.8027778 0.061346 92.8055556 0.064808 92.8083333 0.066538 92.8111111 0.071731 92.8138889 0.071731 92.8166667 0.068269 92.8194444 0.071731 92.8222222 0.068269 92.8250000 0.068269 92.8277778 0.066538 92.8305556 0.068269 92.8333333 0.070000 92.8361111 0.068269 92.8388889 0.071731 92.8416667 0.075192 92.8444444 0.075192 92.8472222 0.071731 92.8500000 0.068269 92.8527778 0.064808 92.8555556 0.054423 92.8583333 0.049231 92.8611111 0.044038 92.8638889 0.045769 92.8666667 0.045769 92.8694444 0.049231 92.8722222 0.050962 92.8750000 0.052692 92.8777778 0.056154 92.8805556 0.050962 92.8833333 0.049231 92.8861111 0.047500 92.8888889 0.040577 92.8916667 0.033654 92.8944444 0.030192 92.8972222 0.025000 92.9000000 0.021538 92.9027778 0.033654 92.9055556 0.061346 92.9083333 0.099423 92.9111111 0.142692 92.9138889 0.172115 92.9166667 0.184231 92.9194444 0.175577 92.9222222 0.139231 92.9250000 0.075192 92.9277778 0.010000 92.9305556 0.010000 92.9333333 0.010000 92.9361111 0.010000 92.9388889 0.010000 92.9416667 0.010000 92.9444444 0.010000 92.9472222 0.010000 92.9500000 0.019808 92.9527778 0.068269 92.9555556 0.099423 92.9583333 0.113269 92.9611111 0.116731 92.9638889 0.115000 92.9666667 0.108077 92.9694444 0.090769 92.9722222 0.071731 92.9750000 0.061346 92.9777778 0.056154 92.9805556 0.059615 92.9833333 0.066538 92.9861111 0.071731 92.9888889 0.073462 92.9916667 0.075192 92.9944444 0.076923 92.9972222 0.070000 93.0000000 0.059615 93.0027778 0.042308 93.0055556 0.028462 93.0083333 0.019808 93.0111111 0.021538 93.0138889 0.023269 93.0166667 0.033654 93.0194444 0.044038 93.0222222 0.050962 93.0250000 0.061346 93.0277778 0.064808 93.0305556 0.073462 93.0333333 0.071731 93.0361111 0.082115 93.0388889 0.083846 93.0416667 0.089038 93.0444444 0.089038 93.0472222 0.087308 93.0500000 0.089038 93.0527778 0.087308 93.0555556 0.085577 93.0583333 0.085577 93.0611111 0.085577 93.0638889 0.080385 93.0666667 0.083846 93.0694444 0.087308 93.0722222 0.087308 93.0750000 0.094231 93.0777778 0.097692 93.0805556 0.095962 93.0833333 0.094231 93.0861111 0.090769 93.0888889 0.085577 93.0916667 0.082115 93.0944444 0.076923 93.0972222 0.083846 93.1000000 0.085577 93.1027778 0.090769 93.1055556 0.089038 93.1083333 0.092500 93.1111111 0.095962 93.1138889 0.090769 93.1166667 0.092500 93.1194444 0.087308 93.1222222 0.083846 93.1250000 0.083846 93.1277778 0.083846 93.1305556 0.085577 93.1333333 0.087308 93.1361111 0.090769 93.1388889 0.090769 93.1416667 0.087308 93.1444444 0.090769 93.1472222 0.085577 93.1500000 0.083846 93.1527778 0.080385 93.1555556 0.076923 93.1583333 0.078654 93.1611111 0.082115 93.1638889 0.075192 93.1666667 0.073462 93.1694444 0.076923 93.1722222 0.068269 93.1750000 0.076923 93.1777778 0.071731 93.1805556 0.071731 93.1833333 0.068269 93.1861111 0.064808 93.1888889 0.059615 93.1916667 0.054423 93.1944444 0.052692 93.1972222 0.044038 93.2000000 0.042308 93.2027778 0.040577 93.2055556 0.045769 93.2083333 0.045769 93.2111111 0.045769 93.2138889 0.047500 93.2166667 0.042308 93.2194444 0.033654 93.2222222 0.025000 93.2250000 0.019808 93.2277778 0.016346 93.2305556 0.012885 93.2333333 0.014615 93.2361111 0.014615 93.2388889 0.014615 93.2416667 0.016346 93.2444444 0.018077 93.2472222 0.010000 93.2500000 0.011154 93.2527778 0.010000 93.2555556 0.010000 93.2583333 0.010000 93.2611111 0.010000 93.2638889 0.010000 93.2666667 0.010000 93.2694444 0.010000 93.2722222 0.010000 93.9000000 0.010000 93.9027778 0.010000 93.9055556 0.014615 93.9083333 0.019808 93.9111111 0.011154 93.9138889 0.014615 93.9166667 0.010000 93.9194444 0.010000 93.9222222 0.010000 93.9250000 0.010000 93.9277778 0.010000 93.9305556 0.010000 93.9333333 0.010000 93.9361111 0.010000 93.9388889 0.010000 93.9416667 0.010000 93.9444444 0.010000 93.9472222 0.010000 93.9500000 0.010000 93.9527778 0.010000 93.9555556 0.010000 93.9583333 0.010000 93.9611111 0.010000 93.9638889 0.010000 93.9666667 0.010000 93.9694444 0.010000 93.9722222 0.010000 93.9750000 0.010000 93.9777778 0.011154 93.9805556 0.018077 93.9833333 0.014615 93.9861111 0.012885 93.9888889 0.012885 93.9916667 0.012885 93.9944444 0.010000 93.9972222 0.010000 94.0000000 0.010000 94.0027778 0.014615 94.0055556 0.021538 94.0083333 0.028462 94.0111111 0.035385 94.0138889 0.042308 94.0166667 0.035385 94.0194444 0.031923 94.0222222 0.028462 94.0250000 0.025000 94.0277778 0.019808 94.0305556 0.016346 94.0333333 0.012885 94.0361111 0.014615 94.0388889 0.014615 94.0416667 0.016346 94.0444444 0.019808 94.0472222 0.012885 94.0500000 0.012885 94.0527778 0.010000 94.0555556 0.010000 94.0583333 0.010000 94.0611111 0.010000 94.0638889 0.010000 94.0666667 0.010000 94.0694444 0.010000 94.0722222 0.010000 94.0750000 0.010000 94.0777778 0.010000 94.0805556 0.010000 94.0833333 0.010000 94.0861111 0.010000 94.0888889 0.019808 94.0916667 0.054423 94.0944444 0.089038 94.0972222 0.113269 94.1000000 0.121923 94.1027778 0.097692 94.1055556 0.021538 94.1083333 0.010000 94.1111111 0.010000 94.1138889 0.010000 94.1166667 0.010000 94.1194444 0.010000 94.1222222 0.010000 94.1250000 0.010000 94.1277778 0.031923 94.1305556 0.087308 94.1333333 0.116731 94.1361111 0.121923 94.1388889 0.132308 94.1416667 0.134038 94.1444444 0.123654 94.1472222 0.099423 94.1500000 0.066538 94.1527778 0.035385 94.1555556 0.012885 94.1583333 0.010000 94.1611111 0.010000 94.1638889 0.010000 94.1666667 0.010000 94.1694444 0.014615 94.1722222 0.021538 94.1750000 0.021538 94.1777778 0.014615 94.1805556 0.010000 94.1833333 0.010000 94.1861111 0.010000 94.1888889 0.010000 94.1916667 0.010000 94.1944444 0.010000 94.1972222 0.010000 94.2000000 0.010000 94.2027778 0.011154 94.2055556 0.018077 94.2083333 0.023269 94.2111111 0.038846 94.2138889 0.045769 94.2166667 0.050962 94.2194444 0.045769 94.2222222 0.047500 94.2250000 0.045769 94.2277778 0.044038 94.2305556 0.047500 94.2333333 0.044038 94.2361111 0.047500 94.2388889 0.050962 94.2416667 0.057885 94.2444444 0.063077 94.2472222 0.066538 94.2500000 0.063077 94.2527778 0.061346 94.2555556 0.056154 94.2583333 0.054423 94.2611111 0.049231 94.2638889 0.047500 94.2666667 0.050962 94.2694444 0.057885 94.2722222 0.056154 94.2750000 0.057885 94.2777778 0.061346 94.2805556 0.059615 94.2833333 0.057885 94.2861111 0.057885 94.2888889 0.059615 94.2916667 0.050962 94.2944444 0.047500 94.2972222 0.047500 94.3000000 0.047500 94.3027778 0.054423 94.3055556 0.056154 94.3083333 0.052692 94.3111111 0.056154 94.3138889 0.050962 94.3166667 0.049231 94.3194444 0.047500 94.3222222 0.040577 94.3250000 0.042308 94.3277778 0.044038 94.3305556 0.044038 94.3333333 0.049231 94.3361111 0.049231 94.3388889 0.045769 94.3416667 0.044038 94.3444444 0.049231 94.3472222 0.045769 94.3500000 0.042308 94.3527778 0.038846 94.3555556 0.033654 94.3583333 0.030192 94.3611111 0.030192 94.3638889 0.030192 94.3666667 0.026731 94.3694444 0.021538 94.3722222 0.026731 94.3750000 0.023269 94.3777778 0.021538 94.3805556 0.025000 94.3833333 0.021538 94.3861111 0.019808 94.3888889 0.012885 94.3916667 0.010000 94.3944444 0.010000 94.3972222 0.010000 94.4000000 0.010000 94.4027778 0.010000 94.4055556 0.010000 94.4083333 0.010000 94.4111111 0.010000 94.4138889 0.010000 94.4166667 0.010000 94.4194444 0.010000 94.4222222 0.010000 94.4250000 0.010000 94.4277778 0.010000 94.4305556 0.010000 94.4333333 0.010000 94.4361111 0.010000 94.4388889 0.010000 94.4416667 0.010000 94.4444444 0.010000 94.4472222 0.010000 95.0750000 0.010000 95.0777778 0.010000 95.0805556 0.010000 95.0833333 0.010000 95.0861111 0.010000 95.0888889 0.010000 95.0916667 0.010000 95.0944444 0.010000 95.0972222 0.010000 95.1000000 0.010000 95.1027778 0.010000 95.1055556 0.010000 95.1083333 0.010000 95.1111111 0.010000 95.1138889 0.010000 95.1166667 0.010000 95.1194444 0.010000 95.1222222 0.010000 95.1250000 0.010000 95.1277778 0.010000 95.1305556 0.010000 95.1333333 0.010000 95.1361111 0.010000 95.1388889 0.010000 95.1416667 0.010000 95.1444444 0.010000 95.1472222 0.010000 95.1500000 0.010000 95.1527778 0.010000 95.1555556 0.010000 95.1583333 0.010000 95.1611111 0.010000 95.1638889 0.010000 95.1666667 0.010000 95.1694444 0.010000 95.1722222 0.010000 95.1750000 0.010000 95.1777778 0.010000 95.1805556 0.010000 95.1833333 0.010000 95.1861111 0.010000 95.1888889 0.010000 95.1916667 0.010000 95.1944444 0.010000 95.1972222 0.010000 95.2000000 0.010000 95.2027778 0.010000 95.2055556 0.010000 95.2083333 0.010000 95.2111111 0.010000 95.2138889 0.010000 95.2166667 0.010000 95.2194444 0.010000 95.2222222 0.010000 95.2250000 0.010000 95.2277778 0.010000 95.2305556 0.010000 95.2333333 0.010000 95.2361111 0.010000 95.2388889 0.010000 95.2416667 0.010000 95.2444444 0.010000 95.2472222 0.010000 95.2500000 0.010000 95.2527778 0.010000 95.2555556 0.010000 95.2583333 0.010000 95.2611111 0.031923 95.2638889 0.070000 95.2666667 0.092500 95.2694444 0.106346 95.2722222 0.106346 95.2750000 0.083846 95.2777778 0.038846 95.2805556 0.010000 95.2833333 0.010000 95.2861111 0.010000 95.2888889 0.010000 95.2916667 0.010000 95.2944444 0.010000 95.2972222 0.010000 95.3000000 0.010000 95.3027778 0.010000 95.3055556 0.010000 95.3083333 0.050962 95.3111111 0.085577 95.3138889 0.102885 95.3166667 0.101154 95.3194444 0.097692 95.3222222 0.082115 95.3250000 0.052692 95.3277778 0.012885 95.3305556 0.010000 95.3333333 0.010000 95.3361111 0.010000 95.3388889 0.010000 95.3416667 0.010000 95.3444444 0.010000 95.3472222 0.010000 95.3500000 0.010000 95.3527778 0.010000 95.3555556 0.010000 95.3583333 0.010000 95.3611111 0.010000 95.3638889 0.010000 95.3666667 0.010000 95.3694444 0.010000 95.3722222 0.010000 95.3750000 0.010000 95.3777778 0.010000 95.3805556 0.010000 95.3833333 0.011154 95.3861111 0.010000 95.3888889 0.012885 95.3916667 0.012885 95.3944444 0.019808 95.3972222 0.018077 95.4000000 0.023269 95.4027778 0.025000 95.4055556 0.025000 95.4083333 0.030192 95.4111111 0.030192 95.4138889 0.035385 95.4166667 0.030192 95.4194444 0.030192 95.4222222 0.025000 95.4250000 0.023269 95.4277778 0.023269 95.4305556 0.023269 95.4333333 0.025000 95.4361111 0.033654 95.4388889 0.031923 95.4416667 0.033654 95.4444444 0.038846 95.4472222 0.035385 95.4500000 0.026731 95.4527778 0.031923 95.4555556 0.030192 95.4583333 0.025000 95.4611111 0.026731 95.4638889 0.025000 95.4666667 0.033654 95.4694444 0.033654 95.4722222 0.035385 95.4750000 0.035385 95.4777778 0.038846 95.4805556 0.042308 95.4833333 0.035385 95.4861111 0.031923 95.4888889 0.030192 95.4916667 0.028462 95.4944444 0.023269 95.4972222 0.026731 95.5000000 0.028462 95.5027778 0.026731 95.5055556 0.035385 95.5083333 0.035385 95.5111111 0.037115 95.5138889 0.033654 95.5166667 0.028462 95.5194444 0.026731 95.5222222 0.019808 95.5250000 0.019808 95.5277778 0.019808 95.5305556 0.023269 95.5333333 0.021538 95.5361111 0.021538 95.5388889 0.021538 95.5416667 0.023269 95.5444444 0.021538 95.5472222 0.019808 95.5500000 0.018077 95.5527778 0.018077 95.5555556 0.012885 95.5583333 0.010000 95.5611111 0.010000 95.5638889 0.010000 95.5666667 0.010000 95.5694444 0.010000 95.5722222 0.010000 95.5750000 0.010000 95.5777778 0.010000 95.5805556 0.010000 95.5833333 0.010000 95.5861111 0.010000 95.5888889 0.010000 95.5916667 0.010000 95.5944444 0.010000 95.5972222 0.010000 95.6000000 0.010000 95.6027778 0.010000 95.6055556 0.010000 95.6083333 0.010000 95.6111111 0.010000 95.6138889 0.010000 95.6166667 0.010000 95.6194444 0.010000 95.6222222 0.010000 96.2916667 0.010000 96.2944444 0.010000 96.2972222 0.010000 96.3000000 0.010000 96.3027778 0.010000 96.3055556 0.010000 96.3083333 0.010000 96.3111111 0.010000 96.3138889 0.010000 96.3166667 0.010000 96.3194444 0.010000 96.3222222 0.010000 96.3250000 0.010000 96.3277778 0.010000 96.3305556 0.010000 96.3333333 0.010000 96.3361111 0.010000 96.3388889 0.010000 96.3416667 0.010000 96.3444444 0.010000 96.3472222 0.010000 96.3500000 0.010000 96.3527778 0.010000 96.3555556 0.010000 96.3583333 0.010000 96.3611111 0.010000 96.3638889 0.010000 96.3666667 0.010000 96.3694444 0.010000 96.3722222 0.010000 96.3750000 0.010000 96.3777778 0.010000 96.3805556 0.010000 96.3833333 0.010000 96.3861111 0.010000 96.3888889 0.010000 96.3916667 0.010000 96.3944444 0.010000 96.3972222 0.010000 96.4000000 0.010000 96.4027778 0.012885 96.4055556 0.016346 96.4083333 0.012885 96.4111111 0.018077 96.4138889 0.016346 96.4166667 0.012885 96.4194444 0.010000 96.4222222 0.010000 96.4250000 0.010000 96.4277778 0.010000 96.4305556 0.010000 96.4333333 0.010000 96.4361111 0.010000 96.4388889 0.010000 96.4416667 0.010000 96.4444444 0.010000 96.4472222 0.010000 96.4500000 0.010000 96.4527778 0.010000 96.4555556 0.010000 96.4583333 0.010000 96.4611111 0.010000 96.4638889 0.010000 96.4666667 0.010000 96.4694444 0.010000 96.4722222 0.010000 96.4750000 0.010000 96.4777778 0.033654 96.4805556 0.080385 96.4833333 0.109808 96.4861111 0.130577 96.4888889 0.128846 96.4916667 0.109808 96.4944444 0.063077 96.4972222 0.010000 96.5000000 0.010000 96.5027778 0.010000 96.5055556 0.010000 96.5083333 0.010000 96.5111111 0.010000 96.5138889 0.010000 96.5166667 0.010000 96.5194444 0.010000 96.5222222 0.010000 96.5250000 0.044038 96.5277778 0.070000 96.5305556 0.073462 96.5333333 0.085577 96.5361111 0.089038 96.5388889 0.080385 96.5416667 0.052692 96.5444444 0.028462 96.5472222 0.010000 96.5500000 0.010000 96.5527778 0.010000 96.5555556 0.010000 96.5583333 0.010000 96.5611111 0.010000 96.5638889 0.011154 96.5666667 0.010000 96.5694444 0.010000 96.5722222 0.010000 96.5750000 0.010000 96.5777778 0.010000 96.5805556 0.010000 96.5833333 0.010000 96.5861111 0.010000 96.5888889 0.010000 96.5916667 0.011154 96.5944444 0.011154 96.5972222 0.016346 96.6000000 0.021538 96.6027778 0.025000 96.6055556 0.035385 96.6083333 0.038846 96.6111111 0.045769 96.6138889 0.047500 96.6166667 0.044038 96.6194444 0.044038 96.6222222 0.042308 96.6250000 0.035385 96.6277778 0.030192 96.6305556 0.033654 96.6333333 0.031923 96.6361111 0.037115 96.6388889 0.047500 96.6416667 0.049231 96.6444444 0.045769 96.6472222 0.049231 96.6500000 0.044038 96.6527778 0.040577 96.6555556 0.035385 96.6583333 0.035385 96.6611111 0.031923 96.6638889 0.028462 96.6666667 0.031923 96.6694444 0.035385 96.6722222 0.031923 96.6750000 0.038846 96.6777778 0.040577 96.6805556 0.044038 96.6833333 0.040577 96.6861111 0.038846 96.6888889 0.031923 96.6916667 0.028462 96.6944444 0.030192 96.6972222 0.030192 96.7000000 0.033654 96.7027778 0.038846 96.7055556 0.040577 96.7083333 0.044038 96.7111111 0.042308 96.7138889 0.044038 96.7166667 0.040577 96.7194444 0.030192 96.7222222 0.030192 96.7250000 0.026731 96.7277778 0.026731 96.7305556 0.026731 96.7333333 0.030192 96.7361111 0.028462 96.7388889 0.030192 96.7416667 0.030192 96.7444444 0.028462 96.7472222 0.026731 96.7500000 0.016346 96.7527778 0.018077 96.7555556 0.014615 96.7583333 0.014615 96.7611111 0.016346 96.7638889 0.012885 96.7666667 0.012885 96.7694444 0.010000 96.7722222 0.010000 96.7750000 0.010000 96.7777778 0.010000 96.7805556 0.010000 96.7833333 0.010000 96.7861111 0.010000 96.7888889 0.010000 96.7916667 0.010000 96.7944444 0.010000 96.7972222 0.010000 96.8000000 0.010000 96.8027778 0.010000 96.8055556 0.010000 96.8083333 0.010000 96.8111111 0.010000 96.8138889 0.010000 96.8166667 0.010000 96.8194444 0.010000 96.8222222 0.010000 96.8250000 0.010000 96.8277778 0.010000 96.8305556 0.010000 96.8333333 0.010000 96.8361111 0.010000 96.8388889 0.010000 97.0416667 0.250000)
Vrpeak rpeak_trigger 0 PWL(0.0000000 0.000000 0.4990000 0.000000 0.5000000 0.900000 0.5010000 0.900000 0.5020000 0.000000 1.7128889 0.000000 1.7138889 0.900000 1.7148889 0.900000 1.7158889 0.000000 2.9767778 0.000000 2.9777778 0.900000 2.9787778 0.900000 2.9797778 0.000000 4.2017778 0.000000 4.2027778 0.900000 4.2037778 0.900000 4.2047778 0.000000 5.3740000 0.000000 5.3750000 0.900000 5.3760000 0.900000 5.3770000 0.000000 6.5878889 0.000000 6.5888889 0.900000 6.5898889 0.900000 6.5908889 0.000000 7.7323333 0.000000 7.7333333 0.900000 7.7343333 0.900000 7.7353333 0.000000 8.9490000 0.000000 8.9500000 0.900000 8.9510000 0.900000 8.9520000 0.000000 10.1212222 0.000000 10.1222222 0.900000 10.1232222 0.900000 10.1242222 0.000000 11.3462222 0.000000 11.3472222 0.900000 11.3482222 0.900000 11.3492222 0.000000 12.5156667 0.000000 12.5166667 0.900000 12.5176667 0.900000 12.5186667 0.000000 13.7628889 0.000000 13.7638889 0.900000 13.7648889 0.900000 13.7658889 0.000000 14.9545556 0.000000 14.9555556 0.900000 14.9565556 0.900000 14.9575556 0.000000 16.1878889 0.000000 16.1888889 0.900000 16.1898889 0.900000 16.1908889 0.000000 17.3906667 0.000000 17.3916667 0.900000 17.3926667 0.900000 17.3936667 0.000000 18.6101111 0.000000 18.6111111 0.900000 18.6121111 0.900000 18.6131111 0.000000 19.7990000 0.000000 19.8000000 0.900000 19.8010000 0.900000 19.8020000 0.000000 21.0101111 0.000000 21.0111111 0.900000 21.0121111 0.900000 21.0131111 0.000000 22.1767778 0.000000 22.1777778 0.900000 22.1787778 0.900000 22.1797778 0.000000 23.3934444 0.000000 23.3944444 0.900000 23.3954444 0.900000 23.3964444 0.000000 24.5767778 0.000000 24.5777778 0.900000 24.5787778 0.900000 24.5797778 0.000000 25.8017778 0.000000 25.8027778 0.900000 25.8037778 0.900000 25.8047778 0.000000 26.9851111 0.000000 26.9861111 0.900000 26.9871111 0.900000 26.9881111 0.000000 28.1795556 0.000000 28.1805556 0.900000 28.1815556 0.900000 28.1825556 0.000000 29.3878889 0.000000 29.3888889 0.900000 29.3898889 0.900000 29.3908889 0.000000 30.5934444 0.000000 30.5944444 0.900000 30.5954444 0.900000 30.5964444 0.000000 31.7767778 0.000000 31.7777778 0.900000 31.7787778 0.900000 31.7797778 0.000000 32.9545556 0.000000 32.9555556 0.900000 32.9565556 0.900000 32.9575556 0.000000 34.1628889 0.000000 34.1638889 0.900000 34.1648889 0.900000 34.1658889 0.000000 35.3545556 0.000000 35.3555556 0.900000 35.3565556 0.900000 35.3575556 0.000000 36.5434444 0.000000 36.5444444 0.900000 36.5454444 0.900000 36.5464444 0.000000 37.8017778 0.000000 37.8027778 0.900000 37.8037778 0.900000 37.8047778 0.000000 39.0184444 0.000000 39.0194444 0.900000 39.0204444 0.900000 39.0214444 0.000000 40.2573333 0.000000 40.2583333 0.900000 40.2593333 0.900000 40.2603333 0.000000 41.5101111 0.000000 41.5111111 0.900000 41.5121111 0.900000 41.5131111 0.000000 42.7656667 0.000000 42.7666667 0.900000 42.7676667 0.900000 42.7686667 0.000000 43.9656667 0.000000 43.9666667 0.900000 43.9676667 0.900000 43.9686667 0.000000 45.2156667 0.000000 45.2166667 0.900000 45.2176667 0.900000 45.2186667 0.000000 46.4351111 0.000000 46.4361111 0.900000 46.4371111 0.900000 46.4381111 0.000000 47.6823333 0.000000 47.6833333 0.900000 47.6843333 0.900000 47.6853333 0.000000 48.9184444 0.000000 48.9194444 0.900000 48.9204444 0.900000 48.9214444 0.000000 50.1212222 0.000000 50.1222222 0.900000 50.1232222 0.900000 50.1242222 0.000000 51.3795556 0.000000 51.3805556 0.900000 51.3815556 0.900000 51.3825556 0.000000 52.6267778 0.000000 52.6277778 0.900000 52.6287778 0.900000 52.6297778 0.000000 53.8878889 0.000000 53.8888889 0.900000 53.8898889 0.900000 53.8908889 0.000000 55.1378889 0.000000 55.1388889 0.900000 55.1398889 0.900000 55.1408889 0.000000 56.3295556 0.000000 56.3305556 0.900000 56.3315556 0.900000 56.3325556 0.000000 57.5573333 0.000000 57.5583333 0.900000 57.5593333 0.900000 57.5603333 0.000000 58.7767778 0.000000 58.7777778 0.900000 58.7787778 0.900000 58.7797778 0.000000 60.0434444 0.000000 60.0444444 0.900000 60.0454444 0.900000 60.0464444 0.000000 61.2517778 0.000000 61.2527778 0.900000 61.2537778 0.900000 61.2547778 0.000000 62.5712222 0.000000 62.5722222 0.900000 62.5732222 0.900000 62.5742222 0.000000 63.8601111 0.000000 63.8611111 0.900000 63.8621111 0.900000 63.8631111 0.000000 65.1184444 0.000000 65.1194444 0.900000 65.1204444 0.900000 65.1214444 0.000000 66.3323333 0.000000 66.3333333 0.900000 66.3343333 0.900000 66.3353333 0.000000 67.5434444 0.000000 67.5444444 0.900000 67.5454444 0.900000 67.5464444 0.000000 68.7101111 0.000000 68.7111111 0.900000 68.7121111 0.900000 68.7131111 0.000000 69.9101111 0.000000 69.9111111 0.900000 69.9121111 0.900000 69.9131111 0.000000 71.0573333 0.000000 71.0583333 0.900000 71.0593333 0.900000 71.0603333 0.000000 72.2878889 0.000000 72.2888889 0.900000 72.2898889 0.900000 72.2908889 0.000000 73.5545556 0.000000 73.5555556 0.900000 73.5565556 0.900000 73.5575556 0.000000 74.7378889 0.000000 74.7388889 0.900000 74.7398889 0.900000 74.7408889 0.000000 75.9823333 0.000000 75.9833333 0.900000 75.9843333 0.900000 75.9853333 0.000000 77.1295556 0.000000 77.1305556 0.900000 77.1315556 0.900000 77.1325556 0.000000 78.3406667 0.000000 78.3416667 0.900000 78.3426667 0.900000 78.3436667 0.000000 79.5823333 0.000000 79.5833333 0.900000 79.5843333 0.900000 79.5853333 0.000000 80.7712222 0.000000 80.7722222 0.900000 80.7732222 0.900000 80.7742222 0.000000 81.9878889 0.000000 81.9888889 0.900000 81.9898889 0.900000 81.9908889 0.000000 83.1851111 0.000000 83.1861111 0.900000 83.1871111 0.900000 83.1881111 0.000000 84.3962222 0.000000 84.3972222 0.900000 84.3982222 0.900000 84.3992222 0.000000 85.6212222 0.000000 85.6222222 0.900000 85.6232222 0.900000 85.6242222 0.000000 86.8601111 0.000000 86.8611111 0.900000 86.8621111 0.900000 86.8631111 0.000000 88.0906667 0.000000 88.0916667 0.900000 88.0926667 0.900000 88.0936667 0.000000 89.2906667 0.000000 89.2916667 0.900000 89.2926667 0.900000 89.2936667 0.000000 90.5128889 0.000000 90.5138889 0.900000 90.5148889 0.900000 90.5158889 0.000000 91.7351111 0.000000 91.7361111 0.900000 91.7371111 0.900000 91.7381111 0.000000 92.9740000 0.000000 92.9750000 0.900000 92.9760000 0.900000 92.9770000 0.000000 94.1490000 0.000000 94.1500000 0.900000 94.1510000 0.900000 94.1520000 0.000000 95.3240000 0.000000 95.3250000 0.900000 95.3260000 0.900000 95.3270000 0.000000 96.5406667 0.000000 96.5416667 0.900000 96.5426667 0.900000 96.5436667 0.000000 97.0416667 0.000000)
Vqrs qrs_gate 0 PWL(0.0000000 0.000000 0.4551111 0.000000 0.4561111 0.900000 0.6133333 0.900000 0.6143333 0.000000 1.6662222 0.000000 1.6672222 0.900000 1.8272222 0.900000 1.8282222 0.000000 2.9162222 0.000000 2.9172222 0.900000 3.0911111 0.900000 3.0921111 0.000000 4.1412222 0.000000 4.1422222 0.900000 4.3161111 0.900000 4.3171111 0.000000 5.3134444 0.000000 5.3144444 0.900000 5.4883333 0.900000 5.4893333 0.000000 6.5273333 0.000000 6.5283333 0.900000 6.7022222 0.900000 6.7032222 0.000000 7.6717778 0.000000 7.6727778 0.900000 7.8466667 0.900000 7.8476667 0.000000 8.8884444 0.000000 8.8894444 0.900000 9.0633333 0.900000 9.0643333 0.000000 10.0606667 0.000000 10.0616667 0.900000 10.2355556 0.900000 10.2365556 0.000000 11.2856667 0.000000 11.2866667 0.900000 11.4605556 0.900000 11.4615556 0.000000 12.4551111 0.000000 12.4561111 0.900000 12.6300000 0.900000 12.6310000 0.000000 13.7023333 0.000000 13.7033333 0.900000 13.8772222 0.900000 13.8782222 0.000000 14.8940000 0.000000 14.8950000 0.900000 15.0688889 0.900000 15.0698889 0.000000 16.1273333 0.000000 16.1283333 0.900000 16.3022222 0.900000 16.3032222 0.000000 17.3301111 0.000000 17.3311111 0.900000 17.5050000 0.900000 17.5060000 0.000000 18.5495556 0.000000 18.5505556 0.900000 18.7244444 0.900000 18.7254444 0.000000 19.7384444 0.000000 19.7394444 0.900000 19.9133333 0.900000 19.9143333 0.000000 20.9495556 0.000000 20.9505556 0.900000 21.1244444 0.900000 21.1254444 0.000000 22.1162222 0.000000 22.1172222 0.900000 22.2911111 0.900000 22.2921111 0.000000 23.3328889 0.000000 23.3338889 0.900000 23.5077778 0.900000 23.5087778 0.000000 24.5162222 0.000000 24.5172222 0.900000 24.6911111 0.900000 24.6921111 0.000000 25.7412222 0.000000 25.7422222 0.900000 25.9161111 0.900000 25.9171111 0.000000 26.9245556 0.000000 26.9255556 0.900000 27.0994444 0.900000 27.1004444 0.000000 28.1245556 0.000000 28.1255556 0.900000 28.2938889 0.900000 28.2948889 0.000000 29.3273333 0.000000 29.3283333 0.900000 29.5022222 0.900000 29.5032222 0.000000 30.5328889 0.000000 30.5338889 0.900000 30.7077778 0.900000 30.7087778 0.000000 31.7162222 0.000000 31.7172222 0.900000 31.8911111 0.900000 31.8921111 0.000000 32.8940000 0.000000 32.8950000 0.900000 33.0688889 0.900000 33.0698889 0.000000 34.1023333 0.000000 34.1033333 0.900000 34.2772222 0.900000 34.2782222 0.000000 35.3078889 0.000000 35.3088889 0.900000 35.4688889 0.900000 35.4698889 0.000000 36.4912222 0.000000 36.4922222 0.900000 36.6577778 0.900000 36.6587778 0.000000 37.7412222 0.000000 37.7422222 0.900000 37.9161111 0.900000 37.9171111 0.000000 38.9578889 0.000000 38.9588889 0.900000 39.1327778 0.900000 39.1337778 0.000000 40.1967778 0.000000 40.1977778 0.900000 40.3716667 0.900000 40.3726667 0.000000 41.4495556 0.000000 41.4505556 0.900000 41.6244444 0.900000 41.6254444 0.000000 42.7051111 0.000000 42.7061111 0.900000 42.8800000 0.900000 42.8810000 0.000000 43.9051111 0.000000 43.9061111 0.900000 44.0800000 0.900000 44.0810000 0.000000 45.1551111 0.000000 45.1561111 0.900000 45.3300000 0.900000 45.3310000 0.000000 46.3745556 0.000000 46.3755556 0.900000 46.5494444 0.900000 46.5504444 0.000000 47.6328889 0.000000 47.6338889 0.900000 47.7966667 0.900000 47.7976667 0.000000 48.8717778 0.000000 48.8727778 0.900000 49.0327778 0.900000 49.0337778 0.000000 50.0717778 0.000000 50.0727778 0.900000 50.2355556 0.900000 50.2365556 0.000000 51.3245556 0.000000 51.3255556 0.900000 51.4938889 0.900000 51.4948889 0.000000 52.5662222 0.000000 52.5672222 0.900000 52.7411111 0.900000 52.7421111 0.000000 53.8273333 0.000000 53.8283333 0.900000 54.0022222 0.900000 54.0032222 0.000000 55.0773333 0.000000 55.0783333 0.900000 55.2522222 0.900000 55.2532222 0.000000 56.2690000 0.000000 56.2700000 0.900000 56.4438889 0.900000 56.4448889 0.000000 57.4967778 0.000000 57.4977778 0.900000 57.6716667 0.900000 57.6726667 0.000000 58.7162222 0.000000 58.7172222 0.900000 58.8911111 0.900000 58.8921111 0.000000 59.9828889 0.000000 59.9838889 0.900000 60.1577778 0.900000 60.1587778 0.000000 61.1912222 0.000000 61.1922222 0.900000 61.3661111 0.900000 61.3671111 0.000000 62.5106667 0.000000 62.5116667 0.900000 62.6855556 0.900000 62.6865556 0.000000 63.7995556 0.000000 63.8005556 0.900000 63.9744444 0.900000 63.9754444 0.000000 65.0578889 0.000000 65.0588889 0.900000 65.2327778 0.900000 65.2337778 0.000000 66.2717778 0.000000 66.2727778 0.900000 66.4466667 0.900000 66.4476667 0.000000 67.4828889 0.000000 67.4838889 0.900000 67.6577778 0.900000 67.6587778 0.000000 68.6662222 0.000000 68.6672222 0.900000 68.8244444 0.900000 68.8254444 0.000000 69.8634444 0.000000 69.8644444 0.900000 70.0244444 0.900000 70.0254444 0.000000 71.0134444 0.000000 71.0144444 0.900000 71.1716667 0.900000 71.1726667 0.000000 72.2412222 0.000000 72.2422222 0.900000 72.4022222 0.900000 72.4032222 0.000000 73.5051111 0.000000 73.5061111 0.900000 73.6688889 0.900000 73.6698889 0.000000 74.6884444 0.000000 74.6894444 0.900000 74.8522222 0.900000 74.8532222 0.000000 75.9384444 0.000000 75.9394444 0.900000 76.0966667 0.900000 76.0976667 0.000000 77.0773333 0.000000 77.0783333 0.900000 77.2438889 0.900000 77.2448889 0.000000 78.2801111 0.000000 78.2811111 0.900000 78.4550000 0.900000 78.4560000 0.000000 79.5217778 0.000000 79.5227778 0.900000 79.6966667 0.900000 79.6976667 0.000000 80.7106667 0.000000 80.7116667 0.900000 80.8855556 0.900000 80.8865556 0.000000 81.9273333 0.000000 81.9283333 0.900000 82.1022222 0.900000 82.1032222 0.000000 83.1245556 0.000000 83.1255556 0.900000 83.2994444 0.900000 83.3004444 0.000000 84.3356667 0.000000 84.3366667 0.900000 84.5105556 0.900000 84.5115556 0.000000 85.5606667 0.000000 85.5616667 0.900000 85.7355556 0.900000 85.7365556 0.000000 86.7995556 0.000000 86.8005556 0.900000 86.9744444 0.900000 86.9754444 0.000000 88.0301111 0.000000 88.0311111 0.900000 88.2050000 0.900000 88.2060000 0.000000 89.2301111 0.000000 89.2311111 0.900000 89.4050000 0.900000 89.4060000 0.000000 90.4523333 0.000000 90.4533333 0.900000 90.6272222 0.900000 90.6282222 0.000000 91.6745556 0.000000 91.6755556 0.900000 91.8494444 0.900000 91.8504444 0.000000 92.9134444 0.000000 92.9144444 0.900000 93.0883333 0.900000 93.0893333 0.000000 94.0884444 0.000000 94.0894444 0.900000 94.2633333 0.900000 94.2643333 0.000000 95.2634444 0.000000 95.2644444 0.900000 95.4383333 0.900000 95.4393333 0.000000 96.4801111 0.000000 96.4811111 0.900000 96.6550000 0.900000 96.6560000 0.000000 97.0416667 0.000000)
Vsym qrs_sym_gate 0 PWL(0.0000000 0.000000 0.4831111 0.000000 0.4841111 0.900000 0.5131111 0.900000 0.5141111 0.000000 1.6997778 0.000000 1.7007778 0.900000 1.7242222 0.900000 1.7252222 0.000000 2.9636667 0.000000 2.9646667 0.900000 3.0270000 0.900000 3.0280000 0.000000 4.1553333 0.000000 4.1563333 0.900000 4.3131111 0.900000 4.3141111 0.000000 5.3331111 0.000000 5.3341111 0.900000 5.4853333 0.900000 5.4863333 0.000000 6.5470000 0.000000 6.5480000 0.900000 6.6992222 0.900000 6.7002222 0.000000 7.7192222 0.000000 7.7202222 0.900000 7.8436667 0.900000 7.8446667 0.000000 8.9081111 0.000000 8.9091111 0.900000 9.0603333 0.900000 9.0613333 0.000000 10.1081111 0.000000 10.1091111 0.900000 10.1770000 0.900000 10.1780000 0.000000 11.3053333 0.000000 11.3063333 0.900000 11.4575556 0.900000 11.4585556 0.000000 12.5025556 0.000000 12.5035556 0.900000 12.6270000 0.900000 12.6280000 0.000000 13.7192222 0.000000 13.7202222 0.900000 13.8742222 0.900000 13.8752222 0.000000 14.9192222 0.000000 14.9202222 0.900000 15.0658889 0.900000 15.0668889 0.000000 16.1747778 0.000000 16.1757778 0.900000 16.2992222 0.900000 16.3002222 0.000000 17.3470000 0.000000 17.3480000 0.900000 17.5020000 0.900000 17.5030000 0.000000 18.5720000 0.000000 18.5730000 0.900000 18.7214444 0.900000 18.7224444 0.000000 19.7581111 0.000000 19.7591111 0.900000 19.9103333 0.900000 19.9113333 0.000000 20.9970000 0.000000 20.9980000 0.900000 21.1020000 0.900000 21.1030000 0.000000 22.1386667 0.000000 22.1396667 0.900000 22.2881111 0.900000 22.2891111 0.000000 23.3803333 0.000000 23.3813333 0.900000 23.4464444 0.900000 23.4474444 0.000000 24.5358889 0.000000 24.5368889 0.900000 24.6881111 0.900000 24.6891111 0.000000 25.7886667 0.000000 25.7896667 0.900000 25.8575556 0.900000 25.8585556 0.000000 26.9442222 0.000000 26.9452222 0.900000 27.0964444 0.900000 27.0974444 0.000000 28.1664444 0.000000 28.1674444 0.900000 28.2797778 0.900000 28.2807778 0.000000 29.3442222 0.000000 29.3452222 0.900000 29.4992222 0.900000 29.5002222 0.000000 30.5803333 0.000000 30.5813333 0.900000 30.7047778 0.900000 30.7057778 0.000000 31.7358889 0.000000 31.7368889 0.900000 31.8881111 0.900000 31.8891111 0.000000 32.9164444 0.000000 32.9174444 0.900000 33.0658889 0.900000 33.0668889 0.000000 34.1525556 0.000000 34.1535556 0.900000 34.2742222 0.900000 34.2752222 0.000000 35.3442222 0.000000 35.3452222 0.900000 35.3658889 0.900000 35.3668889 0.000000 36.5275556 0.000000 36.5285556 0.900000 36.5964444 0.900000 36.5974444 0.000000 37.7914444 0.000000 37.7924444 0.900000 37.9131111 0.900000 37.9141111 0.000000 38.9775556 0.000000 38.9785556 0.900000 39.1297778 0.900000 39.1307778 0.000000 40.2164444 0.000000 40.2174444 0.900000 40.3686667 0.900000 40.3696667 0.000000 41.4720000 0.000000 41.4730000 0.900000 41.6214444 0.900000 41.6224444 0.000000 42.7275556 0.000000 42.7285556 0.900000 42.8770000 0.900000 42.8780000 0.000000 43.9275556 0.000000 43.9285556 0.900000 44.0770000 0.900000 44.0780000 0.000000 45.1747778 0.000000 45.1757778 0.900000 45.3270000 0.900000 45.3280000 0.000000 46.3942222 0.000000 46.3952222 0.900000 46.5464444 0.900000 46.5474444 0.000000 47.6692222 0.000000 47.6702222 0.900000 47.6936667 0.900000 47.6946667 0.000000 48.9025556 0.000000 48.9035556 0.900000 48.9325556 0.900000 48.9335556 0.000000 50.1081111 0.000000 50.1091111 0.900000 50.1325556 0.900000 50.1335556 0.000000 51.3636667 0.000000 51.3646667 0.900000 51.4908889 0.900000 51.4918889 0.000000 52.5803333 0.000000 52.5813333 0.900000 52.7381111 0.900000 52.7391111 0.000000 53.8775556 0.000000 53.8785556 0.900000 53.9992222 0.900000 54.0002222 0.000000 55.0942222 0.000000 55.0952222 0.900000 55.2492222 0.900000 55.2502222 0.000000 56.3164444 0.000000 56.3174444 0.900000 56.4408889 0.900000 56.4418889 0.000000 57.5220000 0.000000 57.5230000 0.900000 57.6686667 0.900000 57.6696667 0.000000 58.7664444 0.000000 58.7674444 0.900000 58.8297778 0.900000 58.8307778 0.000000 59.9997778 0.000000 60.0007778 0.900000 60.1547778 0.900000 60.1557778 0.000000 61.2358889 0.000000 61.2368889 0.900000 61.3631111 0.900000 61.3641111 0.000000 62.5581111 0.000000 62.5591111 0.900000 62.6825556 0.900000 62.6835556 0.000000 63.8470000 0.000000 63.8480000 0.900000 63.9714444 0.900000 63.9724444 0.000000 65.0803333 0.000000 65.0813333 0.900000 65.2297778 0.900000 65.2307778 0.000000 66.3192222 0.000000 66.3202222 0.900000 66.4436667 0.900000 66.4446667 0.000000 67.5025556 0.000000 67.5035556 0.900000 67.6547778 0.900000 67.6557778 0.000000 68.6997778 0.000000 68.7007778 0.900000 68.7214444 0.900000 68.7224444 0.000000 69.8970000 0.000000 69.8980000 0.900000 69.9214444 0.900000 69.9224444 0.000000 71.0442222 0.000000 71.0452222 0.900000 71.0686667 0.900000 71.0696667 0.000000 72.2747778 0.000000 72.2757778 0.900000 72.2992222 0.900000 72.3002222 0.000000 73.5414444 0.000000 73.5424444 0.900000 73.6020000 0.900000 73.6030000 0.000000 74.7247778 0.000000 74.7257778 0.900000 74.7492222 0.900000 74.7502222 0.000000 75.9664444 0.000000 75.9674444 0.900000 75.9936667 0.900000 75.9946667 0.000000 77.1136667 0.000000 77.1146667 0.900000 77.2408889 0.900000 77.2418889 0.000000 78.2970000 0.000000 78.2980000 0.900000 78.4520000 0.900000 78.4530000 0.000000 79.5386667 0.000000 79.5396667 0.900000 79.6936667 0.900000 79.6946667 0.000000 80.7275556 0.000000 80.7285556 0.900000 80.8825556 0.900000 80.8835556 0.000000 81.9525556 0.000000 81.9535556 0.900000 82.0992222 0.900000 82.1002222 0.000000 83.1414444 0.000000 83.1424444 0.900000 83.2964444 0.900000 83.2974444 0.000000 84.3803333 0.000000 84.3813333 0.900000 84.5075556 0.900000 84.5085556 0.000000 85.6108889 0.000000 85.6118889 0.900000 85.7325556 0.900000 85.7335556 0.000000 86.8220000 0.000000 86.8230000 0.900000 86.9714444 0.900000 86.9724444 0.000000 88.0775556 0.000000 88.0785556 0.900000 88.2020000 0.900000 88.2030000 0.000000 89.2525556 0.000000 89.2535556 0.900000 89.4020000 0.900000 89.4030000 0.000000 90.4720000 0.000000 90.4730000 0.900000 90.6242222 0.900000 90.6252222 0.000000 91.7220000 0.000000 91.7230000 0.900000 91.8464444 0.900000 91.8474444 0.000000 92.9303333 0.000000 92.9313333 0.900000 93.0853333 0.900000 93.0863333 0.000000 94.1108889 0.000000 94.1118889 0.900000 94.2603333 0.900000 94.2613333 0.000000 95.2858889 0.000000 95.2868889 0.900000 95.4353333 0.900000 95.4363333 0.000000 96.5053333 0.000000 96.5063333 0.900000 96.6520000 0.900000 96.6530000 0.000000 97.0416667 0.000000)
Vpwave pwave_gate 0 PWL(0.0000000 0.000000 0.2934444 0.000000 0.2944444 0.900000 0.4444444 0.900000 0.4454444 0.000000 1.5073333 0.000000 1.5083333 0.900000 1.6583333 0.900000 1.6593333 0.000000 2.7712222 0.000000 2.7722222 0.900000 2.9222222 0.900000 2.9232222 0.000000 3.9962222 0.000000 3.9972222 0.900000 4.1472222 0.900000 4.1482222 0.000000 5.1684444 0.000000 5.1694444 0.900000 5.3194444 0.900000 5.3204444 0.000000 6.3823333 0.000000 6.3833333 0.900000 6.5333333 0.900000 6.5343333 0.000000 7.5267778 0.000000 7.5277778 0.900000 7.6777778 0.900000 7.6787778 0.000000 8.7434444 0.000000 8.7444444 0.900000 8.8944444 0.900000 8.8954444 0.000000 9.9156667 0.000000 9.9166667 0.900000 10.0666667 0.900000 10.0676667 0.000000 11.1406667 0.000000 11.1416667 0.900000 11.2916667 0.900000 11.2926667 0.000000 12.3101111 0.000000 12.3111111 0.900000 12.4611111 0.900000 12.4621111 0.000000 13.5573333 0.000000 13.5583333 0.900000 13.7083333 0.900000 13.7093333 0.000000 14.7490000 0.000000 14.7500000 0.900000 14.9000000 0.900000 14.9010000 0.000000 15.9823333 0.000000 15.9833333 0.900000 16.1333333 0.900000 16.1343333 0.000000 17.1851111 0.000000 17.1861111 0.900000 17.3361111 0.900000 17.3371111 0.000000 18.4045556 0.000000 18.4055556 0.900000 18.5555556 0.900000 18.5565556 0.000000 19.5934444 0.000000 19.5944444 0.900000 19.7444444 0.900000 19.7454444 0.000000 20.8045556 0.000000 20.8055556 0.900000 20.9555556 0.900000 20.9565556 0.000000 21.9712222 0.000000 21.9722222 0.900000 22.1222222 0.900000 22.1232222 0.000000 23.1878889 0.000000 23.1888889 0.900000 23.3388889 0.900000 23.3398889 0.000000 24.3712222 0.000000 24.3722222 0.900000 24.5222222 0.900000 24.5232222 0.000000 25.5962222 0.000000 25.5972222 0.900000 25.7472222 0.900000 25.7482222 0.000000 26.7795556 0.000000 26.7805556 0.900000 26.9305556 0.900000 26.9315556 0.000000 27.9740000 0.000000 27.9750000 0.900000 28.1250000 0.900000 28.1260000 0.000000 29.1823333 0.000000 29.1833333 0.900000 29.3333333 0.900000 29.3343333 0.000000 30.3878889 0.000000 30.3888889 0.900000 30.5388889 0.900000 30.5398889 0.000000 31.5712222 0.000000 31.5722222 0.900000 31.7222222 0.900000 31.7232222 0.000000 32.7490000 0.000000 32.7500000 0.900000 32.9000000 0.900000 32.9010000 0.000000 33.9573333 0.000000 33.9583333 0.900000 34.1083333 0.900000 34.1093333 0.000000 35.1490000 0.000000 35.1500000 0.900000 35.3000000 0.900000 35.3010000 0.000000 36.3378889 0.000000 36.3388889 0.900000 36.4888889 0.900000 36.4898889 0.000000 37.5962222 0.000000 37.5972222 0.900000 37.7472222 0.900000 37.7482222 0.000000 38.8128889 0.000000 38.8138889 0.900000 38.9638889 0.900000 38.9648889 0.000000 40.0517778 0.000000 40.0527778 0.900000 40.2027778 0.900000 40.2037778 0.000000 41.3045556 0.000000 41.3055556 0.900000 41.4555556 0.900000 41.4565556 0.000000 42.5601111 0.000000 42.5611111 0.900000 42.7111111 0.900000 42.7121111 0.000000 43.7601111 0.000000 43.7611111 0.900000 43.9111111 0.900000 43.9121111 0.000000 45.0101111 0.000000 45.0111111 0.900000 45.1611111 0.900000 45.1621111 0.000000 46.2295556 0.000000 46.2305556 0.900000 46.3805556 0.900000 46.3815556 0.000000 47.4767778 0.000000 47.4777778 0.900000 47.6277778 0.900000 47.6287778 0.000000 48.7128889 0.000000 48.7138889 0.900000 48.8638889 0.900000 48.8648889 0.000000 49.9156667 0.000000 49.9166667 0.900000 50.0666667 0.900000 50.0676667 0.000000 51.1740000 0.000000 51.1750000 0.900000 51.3250000 0.900000 51.3260000 0.000000 52.4212222 0.000000 52.4222222 0.900000 52.5722222 0.900000 52.5732222 0.000000 53.6823333 0.000000 53.6833333 0.900000 53.8333333 0.900000 53.8343333 0.000000 54.9323333 0.000000 54.9333333 0.900000 55.0833333 0.900000 55.0843333 0.000000 56.1240000 0.000000 56.1250000 0.900000 56.2750000 0.900000 56.2760000 0.000000 57.3517778 0.000000 57.3527778 0.900000 57.5027778 0.900000 57.5037778 0.000000 58.5712222 0.000000 58.5722222 0.900000 58.7222222 0.900000 58.7232222 0.000000 59.8378889 0.000000 59.8388889 0.900000 59.9888889 0.900000 59.9898889 0.000000 61.0462222 0.000000 61.0472222 0.900000 61.1972222 0.900000 61.1982222 0.000000 62.3656667 0.000000 62.3666667 0.900000 62.5166667 0.900000 62.5176667 0.000000 63.6545556 0.000000 63.6555556 0.900000 63.8055556 0.900000 63.8065556 0.000000 64.9128889 0.000000 64.9138889 0.900000 65.0638889 0.900000 65.0648889 0.000000 66.1267778 0.000000 66.1277778 0.900000 66.2777778 0.900000 66.2787778 0.000000 67.3378889 0.000000 67.3388889 0.900000 67.4888889 0.900000 67.4898889 0.000000 68.5045556 0.000000 68.5055556 0.900000 68.6555556 0.900000 68.6565556 0.000000 69.7045556 0.000000 69.7055556 0.900000 69.8555556 0.900000 69.8565556 0.000000 70.8517778 0.000000 70.8527778 0.900000 71.0027778 0.900000 71.0037778 0.000000 72.0823333 0.000000 72.0833333 0.900000 72.2333333 0.900000 72.2343333 0.000000 73.3490000 0.000000 73.3500000 0.900000 73.5000000 0.900000 73.5010000 0.000000 74.5323333 0.000000 74.5333333 0.900000 74.6833333 0.900000 74.6843333 0.000000 75.7767778 0.000000 75.7777778 0.900000 75.9277778 0.900000 75.9287778 0.000000 76.9240000 0.000000 76.9250000 0.900000 77.0750000 0.900000 77.0760000 0.000000 78.1351111 0.000000 78.1361111 0.900000 78.2861111 0.900000 78.2871111 0.000000 79.3767778 0.000000 79.3777778 0.900000 79.5277778 0.900000 79.5287778 0.000000 80.5656667 0.000000 80.5666667 0.900000 80.7166667 0.900000 80.7176667 0.000000 81.7823333 0.000000 81.7833333 0.900000 81.9333333 0.900000 81.9343333 0.000000 82.9795556 0.000000 82.9805556 0.900000 83.1305556 0.900000 83.1315556 0.000000 84.1906667 0.000000 84.1916667 0.900000 84.3416667 0.900000 84.3426667 0.000000 85.4156667 0.000000 85.4166667 0.900000 85.5666667 0.900000 85.5676667 0.000000 86.6545556 0.000000 86.6555556 0.900000 86.8055556 0.900000 86.8065556 0.000000 87.8851111 0.000000 87.8861111 0.900000 88.0361111 0.900000 88.0371111 0.000000 89.0851111 0.000000 89.0861111 0.900000 89.2361111 0.900000 89.2371111 0.000000 90.3073333 0.000000 90.3083333 0.900000 90.4583333 0.900000 90.4593333 0.000000 91.5295556 0.000000 91.5305556 0.900000 91.6805556 0.900000 91.6815556 0.000000 92.7684444 0.000000 92.7694444 0.900000 92.9194444 0.900000 92.9204444 0.000000 93.9434444 0.000000 93.9444444 0.900000 94.0944444 0.900000 94.0954444 0.000000 95.1184444 0.000000 95.1194444 0.900000 95.2694444 0.900000 95.2704444 0.000000 96.3351111 0.000000 96.3361111 0.900000 96.4861111 0.900000 96.4871111 0.000000 97.0416667 0.000000)

Xrr rpeak_trigger f_rr_ratio f_rr_asym vdd vss vbias rr_timing
Xinstab0 ecg_in qrs_gate rpeak_trigger f_instab_l0 peak_out_l0 vdd vss vbias vref beat_instability
Xinstab1 ecg_in_l1 qrs_gate rpeak_trigger f_instab_l1 peak_out_l1 vdd vss vbias vref beat_instability
Xpwave ecg_in_l1 pwave_gate rpeak_trigger f_pwave vdd vss vbias vref pwave_energy
Xwidth vref ecg_in qrs_gate rpeak_trigger f_width vdd vss vbias qrs_width
Xsym qrs_sym_gate rpeak_trigger f_sym rise_timer_out fall_timer_out vdd vss vbias qrs_symmetry
Xslope rise_timer_out fall_timer_out f_slope vdd vss vbias slope_ratio

.tran 0.5m 97.0417

.meas tran f_rr_ratio_b0 FIND V(f_rr_ratio) AT=0.4950000
.meas tran f_rr_asym_b0 FIND V(f_rr_asym) AT=0.4950000
.meas tran f_instab_l0_b0 FIND V(f_instab_l0) AT=0.4950000
.meas tran f_instab_l1_b0 FIND V(f_instab_l1) AT=0.4950000
.meas tran f_pwave_b0 FIND V(f_pwave) AT=0.4950000
.meas tran f_width_b0 FIND V(f_width) AT=0.4950000
.meas tran f_sym_b0 FIND V(f_sym) AT=0.5121111
.meas tran f_slope_b0 FIND V(f_slope) AT=0.5121111
.meas tran f_rr_ratio_b1 FIND V(f_rr_ratio) AT=1.7088889
.meas tran f_rr_asym_b1 FIND V(f_rr_asym) AT=1.7088889
.meas tran f_instab_l0_b1 FIND V(f_instab_l0) AT=1.7088889
.meas tran f_instab_l1_b1 FIND V(f_instab_l1) AT=1.7088889
.meas tran f_pwave_b1 FIND V(f_pwave) AT=1.7088889
.meas tran f_width_b1 FIND V(f_width) AT=1.7088889
.meas tran f_sym_b1 FIND V(f_sym) AT=1.7232222
.meas tran f_slope_b1 FIND V(f_slope) AT=1.7232222
.meas tran f_rr_ratio_b2 FIND V(f_rr_ratio) AT=2.9727778
.meas tran f_rr_asym_b2 FIND V(f_rr_asym) AT=2.9727778
.meas tran f_instab_l0_b2 FIND V(f_instab_l0) AT=2.9727778
.meas tran f_instab_l1_b2 FIND V(f_instab_l1) AT=2.9727778
.meas tran f_pwave_b2 FIND V(f_pwave) AT=2.9727778
.meas tran f_width_b2 FIND V(f_width) AT=2.9727778
.meas tran f_sym_b2 FIND V(f_sym) AT=3.0260000
.meas tran f_slope_b2 FIND V(f_slope) AT=3.0260000
.meas tran f_rr_ratio_b3 FIND V(f_rr_ratio) AT=4.1977778
.meas tran f_rr_asym_b3 FIND V(f_rr_asym) AT=4.1977778
.meas tran f_instab_l0_b3 FIND V(f_instab_l0) AT=4.1977778
.meas tran f_instab_l1_b3 FIND V(f_instab_l1) AT=4.1977778
.meas tran f_pwave_b3 FIND V(f_pwave) AT=4.1977778
.meas tran f_width_b3 FIND V(f_width) AT=4.1977778
.meas tran f_sym_b3 FIND V(f_sym) AT=4.3121111
.meas tran f_slope_b3 FIND V(f_slope) AT=4.3121111
.meas tran f_rr_ratio_b4 FIND V(f_rr_ratio) AT=5.3700000
.meas tran f_rr_asym_b4 FIND V(f_rr_asym) AT=5.3700000
.meas tran f_instab_l0_b4 FIND V(f_instab_l0) AT=5.3700000
.meas tran f_instab_l1_b4 FIND V(f_instab_l1) AT=5.3700000
.meas tran f_pwave_b4 FIND V(f_pwave) AT=5.3700000
.meas tran f_width_b4 FIND V(f_width) AT=5.3700000
.meas tran f_sym_b4 FIND V(f_sym) AT=5.4843333
.meas tran f_slope_b4 FIND V(f_slope) AT=5.4843333
.meas tran f_rr_ratio_b5 FIND V(f_rr_ratio) AT=6.5838889
.meas tran f_rr_asym_b5 FIND V(f_rr_asym) AT=6.5838889
.meas tran f_instab_l0_b5 FIND V(f_instab_l0) AT=6.5838889
.meas tran f_instab_l1_b5 FIND V(f_instab_l1) AT=6.5838889
.meas tran f_pwave_b5 FIND V(f_pwave) AT=6.5838889
.meas tran f_width_b5 FIND V(f_width) AT=6.5838889
.meas tran f_sym_b5 FIND V(f_sym) AT=6.6982222
.meas tran f_slope_b5 FIND V(f_slope) AT=6.6982222
.meas tran f_rr_ratio_b6 FIND V(f_rr_ratio) AT=7.7283333
.meas tran f_rr_asym_b6 FIND V(f_rr_asym) AT=7.7283333
.meas tran f_instab_l0_b6 FIND V(f_instab_l0) AT=7.7283333
.meas tran f_instab_l1_b6 FIND V(f_instab_l1) AT=7.7283333
.meas tran f_pwave_b6 FIND V(f_pwave) AT=7.7283333
.meas tran f_width_b6 FIND V(f_width) AT=7.7283333
.meas tran f_sym_b6 FIND V(f_sym) AT=7.8426667
.meas tran f_slope_b6 FIND V(f_slope) AT=7.8426667
.meas tran f_rr_ratio_b7 FIND V(f_rr_ratio) AT=8.9450000
.meas tran f_rr_asym_b7 FIND V(f_rr_asym) AT=8.9450000
.meas tran f_instab_l0_b7 FIND V(f_instab_l0) AT=8.9450000
.meas tran f_instab_l1_b7 FIND V(f_instab_l1) AT=8.9450000
.meas tran f_pwave_b7 FIND V(f_pwave) AT=8.9450000
.meas tran f_width_b7 FIND V(f_width) AT=8.9450000
.meas tran f_sym_b7 FIND V(f_sym) AT=9.0593333
.meas tran f_slope_b7 FIND V(f_slope) AT=9.0593333
.meas tran f_rr_ratio_b8 FIND V(f_rr_ratio) AT=10.1172222
.meas tran f_rr_asym_b8 FIND V(f_rr_asym) AT=10.1172222
.meas tran f_instab_l0_b8 FIND V(f_instab_l0) AT=10.1172222
.meas tran f_instab_l1_b8 FIND V(f_instab_l1) AT=10.1172222
.meas tran f_pwave_b8 FIND V(f_pwave) AT=10.1172222
.meas tran f_width_b8 FIND V(f_width) AT=10.1172222
.meas tran f_sym_b8 FIND V(f_sym) AT=10.1760000
.meas tran f_slope_b8 FIND V(f_slope) AT=10.1760000
.meas tran f_rr_ratio_b9 FIND V(f_rr_ratio) AT=11.3422222
.meas tran f_rr_asym_b9 FIND V(f_rr_asym) AT=11.3422222
.meas tran f_instab_l0_b9 FIND V(f_instab_l0) AT=11.3422222
.meas tran f_instab_l1_b9 FIND V(f_instab_l1) AT=11.3422222
.meas tran f_pwave_b9 FIND V(f_pwave) AT=11.3422222
.meas tran f_width_b9 FIND V(f_width) AT=11.3422222
.meas tran f_sym_b9 FIND V(f_sym) AT=11.4565556
.meas tran f_slope_b9 FIND V(f_slope) AT=11.4565556
.meas tran f_rr_ratio_b10 FIND V(f_rr_ratio) AT=12.5116667
.meas tran f_rr_asym_b10 FIND V(f_rr_asym) AT=12.5116667
.meas tran f_instab_l0_b10 FIND V(f_instab_l0) AT=12.5116667
.meas tran f_instab_l1_b10 FIND V(f_instab_l1) AT=12.5116667
.meas tran f_pwave_b10 FIND V(f_pwave) AT=12.5116667
.meas tran f_width_b10 FIND V(f_width) AT=12.5116667
.meas tran f_sym_b10 FIND V(f_sym) AT=12.6260000
.meas tran f_slope_b10 FIND V(f_slope) AT=12.6260000
.meas tran f_rr_ratio_b11 FIND V(f_rr_ratio) AT=13.7588889
.meas tran f_rr_asym_b11 FIND V(f_rr_asym) AT=13.7588889
.meas tran f_instab_l0_b11 FIND V(f_instab_l0) AT=13.7588889
.meas tran f_instab_l1_b11 FIND V(f_instab_l1) AT=13.7588889
.meas tran f_pwave_b11 FIND V(f_pwave) AT=13.7588889
.meas tran f_width_b11 FIND V(f_width) AT=13.7588889
.meas tran f_sym_b11 FIND V(f_sym) AT=13.8732222
.meas tran f_slope_b11 FIND V(f_slope) AT=13.8732222
.meas tran f_rr_ratio_b12 FIND V(f_rr_ratio) AT=14.9505556
.meas tran f_rr_asym_b12 FIND V(f_rr_asym) AT=14.9505556
.meas tran f_instab_l0_b12 FIND V(f_instab_l0) AT=14.9505556
.meas tran f_instab_l1_b12 FIND V(f_instab_l1) AT=14.9505556
.meas tran f_pwave_b12 FIND V(f_pwave) AT=14.9505556
.meas tran f_width_b12 FIND V(f_width) AT=14.9505556
.meas tran f_sym_b12 FIND V(f_sym) AT=15.0648889
.meas tran f_slope_b12 FIND V(f_slope) AT=15.0648889
.meas tran f_rr_ratio_b13 FIND V(f_rr_ratio) AT=16.1838889
.meas tran f_rr_asym_b13 FIND V(f_rr_asym) AT=16.1838889
.meas tran f_instab_l0_b13 FIND V(f_instab_l0) AT=16.1838889
.meas tran f_instab_l1_b13 FIND V(f_instab_l1) AT=16.1838889
.meas tran f_pwave_b13 FIND V(f_pwave) AT=16.1838889
.meas tran f_width_b13 FIND V(f_width) AT=16.1838889
.meas tran f_sym_b13 FIND V(f_sym) AT=16.2982222
.meas tran f_slope_b13 FIND V(f_slope) AT=16.2982222
.meas tran f_rr_ratio_b14 FIND V(f_rr_ratio) AT=17.3866667
.meas tran f_rr_asym_b14 FIND V(f_rr_asym) AT=17.3866667
.meas tran f_instab_l0_b14 FIND V(f_instab_l0) AT=17.3866667
.meas tran f_instab_l1_b14 FIND V(f_instab_l1) AT=17.3866667
.meas tran f_pwave_b14 FIND V(f_pwave) AT=17.3866667
.meas tran f_width_b14 FIND V(f_width) AT=17.3866667
.meas tran f_sym_b14 FIND V(f_sym) AT=17.5010000
.meas tran f_slope_b14 FIND V(f_slope) AT=17.5010000
.meas tran f_rr_ratio_b15 FIND V(f_rr_ratio) AT=18.6061111
.meas tran f_rr_asym_b15 FIND V(f_rr_asym) AT=18.6061111
.meas tran f_instab_l0_b15 FIND V(f_instab_l0) AT=18.6061111
.meas tran f_instab_l1_b15 FIND V(f_instab_l1) AT=18.6061111
.meas tran f_pwave_b15 FIND V(f_pwave) AT=18.6061111
.meas tran f_width_b15 FIND V(f_width) AT=18.6061111
.meas tran f_sym_b15 FIND V(f_sym) AT=18.7204444
.meas tran f_slope_b15 FIND V(f_slope) AT=18.7204444
.meas tran f_rr_ratio_b16 FIND V(f_rr_ratio) AT=19.7950000
.meas tran f_rr_asym_b16 FIND V(f_rr_asym) AT=19.7950000
.meas tran f_instab_l0_b16 FIND V(f_instab_l0) AT=19.7950000
.meas tran f_instab_l1_b16 FIND V(f_instab_l1) AT=19.7950000
.meas tran f_pwave_b16 FIND V(f_pwave) AT=19.7950000
.meas tran f_width_b16 FIND V(f_width) AT=19.7950000
.meas tran f_sym_b16 FIND V(f_sym) AT=19.9093333
.meas tran f_slope_b16 FIND V(f_slope) AT=19.9093333
.meas tran f_rr_ratio_b17 FIND V(f_rr_ratio) AT=21.0061111
.meas tran f_rr_asym_b17 FIND V(f_rr_asym) AT=21.0061111
.meas tran f_instab_l0_b17 FIND V(f_instab_l0) AT=21.0061111
.meas tran f_instab_l1_b17 FIND V(f_instab_l1) AT=21.0061111
.meas tran f_pwave_b17 FIND V(f_pwave) AT=21.0061111
.meas tran f_width_b17 FIND V(f_width) AT=21.0061111
.meas tran f_sym_b17 FIND V(f_sym) AT=21.1010000
.meas tran f_slope_b17 FIND V(f_slope) AT=21.1010000
.meas tran f_rr_ratio_b18 FIND V(f_rr_ratio) AT=22.1727778
.meas tran f_rr_asym_b18 FIND V(f_rr_asym) AT=22.1727778
.meas tran f_instab_l0_b18 FIND V(f_instab_l0) AT=22.1727778
.meas tran f_instab_l1_b18 FIND V(f_instab_l1) AT=22.1727778
.meas tran f_pwave_b18 FIND V(f_pwave) AT=22.1727778
.meas tran f_width_b18 FIND V(f_width) AT=22.1727778
.meas tran f_sym_b18 FIND V(f_sym) AT=22.2871111
.meas tran f_slope_b18 FIND V(f_slope) AT=22.2871111
.meas tran f_rr_ratio_b19 FIND V(f_rr_ratio) AT=23.3894444
.meas tran f_rr_asym_b19 FIND V(f_rr_asym) AT=23.3894444
.meas tran f_instab_l0_b19 FIND V(f_instab_l0) AT=23.3894444
.meas tran f_instab_l1_b19 FIND V(f_instab_l1) AT=23.3894444
.meas tran f_pwave_b19 FIND V(f_pwave) AT=23.3894444
.meas tran f_width_b19 FIND V(f_width) AT=23.3894444
.meas tran f_sym_b19 FIND V(f_sym) AT=23.4454444
.meas tran f_slope_b19 FIND V(f_slope) AT=23.4454444
.meas tran f_rr_ratio_b20 FIND V(f_rr_ratio) AT=24.5727778
.meas tran f_rr_asym_b20 FIND V(f_rr_asym) AT=24.5727778
.meas tran f_instab_l0_b20 FIND V(f_instab_l0) AT=24.5727778
.meas tran f_instab_l1_b20 FIND V(f_instab_l1) AT=24.5727778
.meas tran f_pwave_b20 FIND V(f_pwave) AT=24.5727778
.meas tran f_width_b20 FIND V(f_width) AT=24.5727778
.meas tran f_sym_b20 FIND V(f_sym) AT=24.6871111
.meas tran f_slope_b20 FIND V(f_slope) AT=24.6871111
.meas tran f_rr_ratio_b21 FIND V(f_rr_ratio) AT=25.7977778
.meas tran f_rr_asym_b21 FIND V(f_rr_asym) AT=25.7977778
.meas tran f_instab_l0_b21 FIND V(f_instab_l0) AT=25.7977778
.meas tran f_instab_l1_b21 FIND V(f_instab_l1) AT=25.7977778
.meas tran f_pwave_b21 FIND V(f_pwave) AT=25.7977778
.meas tran f_width_b21 FIND V(f_width) AT=25.7977778
.meas tran f_sym_b21 FIND V(f_sym) AT=25.8565556
.meas tran f_slope_b21 FIND V(f_slope) AT=25.8565556
.meas tran f_rr_ratio_b22 FIND V(f_rr_ratio) AT=26.9811111
.meas tran f_rr_asym_b22 FIND V(f_rr_asym) AT=26.9811111
.meas tran f_instab_l0_b22 FIND V(f_instab_l0) AT=26.9811111
.meas tran f_instab_l1_b22 FIND V(f_instab_l1) AT=26.9811111
.meas tran f_pwave_b22 FIND V(f_pwave) AT=26.9811111
.meas tran f_width_b22 FIND V(f_width) AT=26.9811111
.meas tran f_sym_b22 FIND V(f_sym) AT=27.0954444
.meas tran f_slope_b22 FIND V(f_slope) AT=27.0954444
.meas tran f_rr_ratio_b23 FIND V(f_rr_ratio) AT=28.1755556
.meas tran f_rr_asym_b23 FIND V(f_rr_asym) AT=28.1755556
.meas tran f_instab_l0_b23 FIND V(f_instab_l0) AT=28.1755556
.meas tran f_instab_l1_b23 FIND V(f_instab_l1) AT=28.1755556
.meas tran f_pwave_b23 FIND V(f_pwave) AT=28.1755556
.meas tran f_width_b23 FIND V(f_width) AT=28.1755556
.meas tran f_sym_b23 FIND V(f_sym) AT=28.2787778
.meas tran f_slope_b23 FIND V(f_slope) AT=28.2787778
.meas tran f_rr_ratio_b24 FIND V(f_rr_ratio) AT=29.3838889
.meas tran f_rr_asym_b24 FIND V(f_rr_asym) AT=29.3838889
.meas tran f_instab_l0_b24 FIND V(f_instab_l0) AT=29.3838889
.meas tran f_instab_l1_b24 FIND V(f_instab_l1) AT=29.3838889
.meas tran f_pwave_b24 FIND V(f_pwave) AT=29.3838889
.meas tran f_width_b24 FIND V(f_width) AT=29.3838889
.meas tran f_sym_b24 FIND V(f_sym) AT=29.4982222
.meas tran f_slope_b24 FIND V(f_slope) AT=29.4982222
.meas tran f_rr_ratio_b25 FIND V(f_rr_ratio) AT=30.5894444
.meas tran f_rr_asym_b25 FIND V(f_rr_asym) AT=30.5894444
.meas tran f_instab_l0_b25 FIND V(f_instab_l0) AT=30.5894444
.meas tran f_instab_l1_b25 FIND V(f_instab_l1) AT=30.5894444
.meas tran f_pwave_b25 FIND V(f_pwave) AT=30.5894444
.meas tran f_width_b25 FIND V(f_width) AT=30.5894444
.meas tran f_sym_b25 FIND V(f_sym) AT=30.7037778
.meas tran f_slope_b25 FIND V(f_slope) AT=30.7037778
.meas tran f_rr_ratio_b26 FIND V(f_rr_ratio) AT=31.7727778
.meas tran f_rr_asym_b26 FIND V(f_rr_asym) AT=31.7727778
.meas tran f_instab_l0_b26 FIND V(f_instab_l0) AT=31.7727778
.meas tran f_instab_l1_b26 FIND V(f_instab_l1) AT=31.7727778
.meas tran f_pwave_b26 FIND V(f_pwave) AT=31.7727778
.meas tran f_width_b26 FIND V(f_width) AT=31.7727778
.meas tran f_sym_b26 FIND V(f_sym) AT=31.8871111
.meas tran f_slope_b26 FIND V(f_slope) AT=31.8871111
.meas tran f_rr_ratio_b27 FIND V(f_rr_ratio) AT=32.9505556
.meas tran f_rr_asym_b27 FIND V(f_rr_asym) AT=32.9505556
.meas tran f_instab_l0_b27 FIND V(f_instab_l0) AT=32.9505556
.meas tran f_instab_l1_b27 FIND V(f_instab_l1) AT=32.9505556
.meas tran f_pwave_b27 FIND V(f_pwave) AT=32.9505556
.meas tran f_width_b27 FIND V(f_width) AT=32.9505556
.meas tran f_sym_b27 FIND V(f_sym) AT=33.0648889
.meas tran f_slope_b27 FIND V(f_slope) AT=33.0648889
.meas tran f_rr_ratio_b28 FIND V(f_rr_ratio) AT=34.1588889
.meas tran f_rr_asym_b28 FIND V(f_rr_asym) AT=34.1588889
.meas tran f_instab_l0_b28 FIND V(f_instab_l0) AT=34.1588889
.meas tran f_instab_l1_b28 FIND V(f_instab_l1) AT=34.1588889
.meas tran f_pwave_b28 FIND V(f_pwave) AT=34.1588889
.meas tran f_width_b28 FIND V(f_width) AT=34.1588889
.meas tran f_sym_b28 FIND V(f_sym) AT=34.2732222
.meas tran f_slope_b28 FIND V(f_slope) AT=34.2732222
.meas tran f_rr_ratio_b29 FIND V(f_rr_ratio) AT=35.3505556
.meas tran f_rr_asym_b29 FIND V(f_rr_asym) AT=35.3505556
.meas tran f_instab_l0_b29 FIND V(f_instab_l0) AT=35.3505556
.meas tran f_instab_l1_b29 FIND V(f_instab_l1) AT=35.3505556
.meas tran f_pwave_b29 FIND V(f_pwave) AT=35.3505556
.meas tran f_width_b29 FIND V(f_width) AT=35.3505556
.meas tran f_sym_b29 FIND V(f_sym) AT=35.3648889
.meas tran f_slope_b29 FIND V(f_slope) AT=35.3648889
.meas tran f_rr_ratio_b30 FIND V(f_rr_ratio) AT=36.5394444
.meas tran f_rr_asym_b30 FIND V(f_rr_asym) AT=36.5394444
.meas tran f_instab_l0_b30 FIND V(f_instab_l0) AT=36.5394444
.meas tran f_instab_l1_b30 FIND V(f_instab_l1) AT=36.5394444
.meas tran f_pwave_b30 FIND V(f_pwave) AT=36.5394444
.meas tran f_width_b30 FIND V(f_width) AT=36.5394444
.meas tran f_sym_b30 FIND V(f_sym) AT=36.5954444
.meas tran f_slope_b30 FIND V(f_slope) AT=36.5954444
.meas tran f_rr_ratio_b31 FIND V(f_rr_ratio) AT=37.7977778
.meas tran f_rr_asym_b31 FIND V(f_rr_asym) AT=37.7977778
.meas tran f_instab_l0_b31 FIND V(f_instab_l0) AT=37.7977778
.meas tran f_instab_l1_b31 FIND V(f_instab_l1) AT=37.7977778
.meas tran f_pwave_b31 FIND V(f_pwave) AT=37.7977778
.meas tran f_width_b31 FIND V(f_width) AT=37.7977778
.meas tran f_sym_b31 FIND V(f_sym) AT=37.9121111
.meas tran f_slope_b31 FIND V(f_slope) AT=37.9121111
.meas tran f_rr_ratio_b32 FIND V(f_rr_ratio) AT=39.0144444
.meas tran f_rr_asym_b32 FIND V(f_rr_asym) AT=39.0144444
.meas tran f_instab_l0_b32 FIND V(f_instab_l0) AT=39.0144444
.meas tran f_instab_l1_b32 FIND V(f_instab_l1) AT=39.0144444
.meas tran f_pwave_b32 FIND V(f_pwave) AT=39.0144444
.meas tran f_width_b32 FIND V(f_width) AT=39.0144444
.meas tran f_sym_b32 FIND V(f_sym) AT=39.1287778
.meas tran f_slope_b32 FIND V(f_slope) AT=39.1287778
.meas tran f_rr_ratio_b33 FIND V(f_rr_ratio) AT=40.2533333
.meas tran f_rr_asym_b33 FIND V(f_rr_asym) AT=40.2533333
.meas tran f_instab_l0_b33 FIND V(f_instab_l0) AT=40.2533333
.meas tran f_instab_l1_b33 FIND V(f_instab_l1) AT=40.2533333
.meas tran f_pwave_b33 FIND V(f_pwave) AT=40.2533333
.meas tran f_width_b33 FIND V(f_width) AT=40.2533333
.meas tran f_sym_b33 FIND V(f_sym) AT=40.3676667
.meas tran f_slope_b33 FIND V(f_slope) AT=40.3676667
.meas tran f_rr_ratio_b34 FIND V(f_rr_ratio) AT=41.5061111
.meas tran f_rr_asym_b34 FIND V(f_rr_asym) AT=41.5061111
.meas tran f_instab_l0_b34 FIND V(f_instab_l0) AT=41.5061111
.meas tran f_instab_l1_b34 FIND V(f_instab_l1) AT=41.5061111
.meas tran f_pwave_b34 FIND V(f_pwave) AT=41.5061111
.meas tran f_width_b34 FIND V(f_width) AT=41.5061111
.meas tran f_sym_b34 FIND V(f_sym) AT=41.6204444
.meas tran f_slope_b34 FIND V(f_slope) AT=41.6204444
.meas tran f_rr_ratio_b35 FIND V(f_rr_ratio) AT=42.7616667
.meas tran f_rr_asym_b35 FIND V(f_rr_asym) AT=42.7616667
.meas tran f_instab_l0_b35 FIND V(f_instab_l0) AT=42.7616667
.meas tran f_instab_l1_b35 FIND V(f_instab_l1) AT=42.7616667
.meas tran f_pwave_b35 FIND V(f_pwave) AT=42.7616667
.meas tran f_width_b35 FIND V(f_width) AT=42.7616667
.meas tran f_sym_b35 FIND V(f_sym) AT=42.8760000
.meas tran f_slope_b35 FIND V(f_slope) AT=42.8760000
.meas tran f_rr_ratio_b36 FIND V(f_rr_ratio) AT=43.9616667
.meas tran f_rr_asym_b36 FIND V(f_rr_asym) AT=43.9616667
.meas tran f_instab_l0_b36 FIND V(f_instab_l0) AT=43.9616667
.meas tran f_instab_l1_b36 FIND V(f_instab_l1) AT=43.9616667
.meas tran f_pwave_b36 FIND V(f_pwave) AT=43.9616667
.meas tran f_width_b36 FIND V(f_width) AT=43.9616667
.meas tran f_sym_b36 FIND V(f_sym) AT=44.0760000
.meas tran f_slope_b36 FIND V(f_slope) AT=44.0760000
.meas tran f_rr_ratio_b37 FIND V(f_rr_ratio) AT=45.2116667
.meas tran f_rr_asym_b37 FIND V(f_rr_asym) AT=45.2116667
.meas tran f_instab_l0_b37 FIND V(f_instab_l0) AT=45.2116667
.meas tran f_instab_l1_b37 FIND V(f_instab_l1) AT=45.2116667
.meas tran f_pwave_b37 FIND V(f_pwave) AT=45.2116667
.meas tran f_width_b37 FIND V(f_width) AT=45.2116667
.meas tran f_sym_b37 FIND V(f_sym) AT=45.3260000
.meas tran f_slope_b37 FIND V(f_slope) AT=45.3260000
.meas tran f_rr_ratio_b38 FIND V(f_rr_ratio) AT=46.4311111
.meas tran f_rr_asym_b38 FIND V(f_rr_asym) AT=46.4311111
.meas tran f_instab_l0_b38 FIND V(f_instab_l0) AT=46.4311111
.meas tran f_instab_l1_b38 FIND V(f_instab_l1) AT=46.4311111
.meas tran f_pwave_b38 FIND V(f_pwave) AT=46.4311111
.meas tran f_width_b38 FIND V(f_width) AT=46.4311111
.meas tran f_sym_b38 FIND V(f_sym) AT=46.5454444
.meas tran f_slope_b38 FIND V(f_slope) AT=46.5454444
.meas tran f_rr_ratio_b39 FIND V(f_rr_ratio) AT=47.6783333
.meas tran f_rr_asym_b39 FIND V(f_rr_asym) AT=47.6783333
.meas tran f_instab_l0_b39 FIND V(f_instab_l0) AT=47.6783333
.meas tran f_instab_l1_b39 FIND V(f_instab_l1) AT=47.6783333
.meas tran f_pwave_b39 FIND V(f_pwave) AT=47.6783333
.meas tran f_width_b39 FIND V(f_width) AT=47.6783333
.meas tran f_sym_b39 FIND V(f_sym) AT=47.6926667
.meas tran f_slope_b39 FIND V(f_slope) AT=47.6926667
.meas tran f_rr_ratio_b40 FIND V(f_rr_ratio) AT=48.9144444
.meas tran f_rr_asym_b40 FIND V(f_rr_asym) AT=48.9144444
.meas tran f_instab_l0_b40 FIND V(f_instab_l0) AT=48.9144444
.meas tran f_instab_l1_b40 FIND V(f_instab_l1) AT=48.9144444
.meas tran f_pwave_b40 FIND V(f_pwave) AT=48.9144444
.meas tran f_width_b40 FIND V(f_width) AT=48.9144444
.meas tran f_sym_b40 FIND V(f_sym) AT=48.9315556
.meas tran f_slope_b40 FIND V(f_slope) AT=48.9315556
.meas tran f_rr_ratio_b41 FIND V(f_rr_ratio) AT=50.1172222
.meas tran f_rr_asym_b41 FIND V(f_rr_asym) AT=50.1172222
.meas tran f_instab_l0_b41 FIND V(f_instab_l0) AT=50.1172222
.meas tran f_instab_l1_b41 FIND V(f_instab_l1) AT=50.1172222
.meas tran f_pwave_b41 FIND V(f_pwave) AT=50.1172222
.meas tran f_width_b41 FIND V(f_width) AT=50.1172222
.meas tran f_sym_b41 FIND V(f_sym) AT=50.1315556
.meas tran f_slope_b41 FIND V(f_slope) AT=50.1315556
.meas tran f_rr_ratio_b42 FIND V(f_rr_ratio) AT=51.3755556
.meas tran f_rr_asym_b42 FIND V(f_rr_asym) AT=51.3755556
.meas tran f_instab_l0_b42 FIND V(f_instab_l0) AT=51.3755556
.meas tran f_instab_l1_b42 FIND V(f_instab_l1) AT=51.3755556
.meas tran f_pwave_b42 FIND V(f_pwave) AT=51.3755556
.meas tran f_width_b42 FIND V(f_width) AT=51.3755556
.meas tran f_sym_b42 FIND V(f_sym) AT=51.4898889
.meas tran f_slope_b42 FIND V(f_slope) AT=51.4898889
.meas tran f_rr_ratio_b43 FIND V(f_rr_ratio) AT=52.6227778
.meas tran f_rr_asym_b43 FIND V(f_rr_asym) AT=52.6227778
.meas tran f_instab_l0_b43 FIND V(f_instab_l0) AT=52.6227778
.meas tran f_instab_l1_b43 FIND V(f_instab_l1) AT=52.6227778
.meas tran f_pwave_b43 FIND V(f_pwave) AT=52.6227778
.meas tran f_width_b43 FIND V(f_width) AT=52.6227778
.meas tran f_sym_b43 FIND V(f_sym) AT=52.7371111
.meas tran f_slope_b43 FIND V(f_slope) AT=52.7371111
.meas tran f_rr_ratio_b44 FIND V(f_rr_ratio) AT=53.8838889
.meas tran f_rr_asym_b44 FIND V(f_rr_asym) AT=53.8838889
.meas tran f_instab_l0_b44 FIND V(f_instab_l0) AT=53.8838889
.meas tran f_instab_l1_b44 FIND V(f_instab_l1) AT=53.8838889
.meas tran f_pwave_b44 FIND V(f_pwave) AT=53.8838889
.meas tran f_width_b44 FIND V(f_width) AT=53.8838889
.meas tran f_sym_b44 FIND V(f_sym) AT=53.9982222
.meas tran f_slope_b44 FIND V(f_slope) AT=53.9982222
.meas tran f_rr_ratio_b45 FIND V(f_rr_ratio) AT=55.1338889
.meas tran f_rr_asym_b45 FIND V(f_rr_asym) AT=55.1338889
.meas tran f_instab_l0_b45 FIND V(f_instab_l0) AT=55.1338889
.meas tran f_instab_l1_b45 FIND V(f_instab_l1) AT=55.1338889
.meas tran f_pwave_b45 FIND V(f_pwave) AT=55.1338889
.meas tran f_width_b45 FIND V(f_width) AT=55.1338889
.meas tran f_sym_b45 FIND V(f_sym) AT=55.2482222
.meas tran f_slope_b45 FIND V(f_slope) AT=55.2482222
.meas tran f_rr_ratio_b46 FIND V(f_rr_ratio) AT=56.3255556
.meas tran f_rr_asym_b46 FIND V(f_rr_asym) AT=56.3255556
.meas tran f_instab_l0_b46 FIND V(f_instab_l0) AT=56.3255556
.meas tran f_instab_l1_b46 FIND V(f_instab_l1) AT=56.3255556
.meas tran f_pwave_b46 FIND V(f_pwave) AT=56.3255556
.meas tran f_width_b46 FIND V(f_width) AT=56.3255556
.meas tran f_sym_b46 FIND V(f_sym) AT=56.4398889
.meas tran f_slope_b46 FIND V(f_slope) AT=56.4398889
.meas tran f_rr_ratio_b47 FIND V(f_rr_ratio) AT=57.5533333
.meas tran f_rr_asym_b47 FIND V(f_rr_asym) AT=57.5533333
.meas tran f_instab_l0_b47 FIND V(f_instab_l0) AT=57.5533333
.meas tran f_instab_l1_b47 FIND V(f_instab_l1) AT=57.5533333
.meas tran f_pwave_b47 FIND V(f_pwave) AT=57.5533333
.meas tran f_width_b47 FIND V(f_width) AT=57.5533333
.meas tran f_sym_b47 FIND V(f_sym) AT=57.6676667
.meas tran f_slope_b47 FIND V(f_slope) AT=57.6676667
.meas tran f_rr_ratio_b48 FIND V(f_rr_ratio) AT=58.7727778
.meas tran f_rr_asym_b48 FIND V(f_rr_asym) AT=58.7727778
.meas tran f_instab_l0_b48 FIND V(f_instab_l0) AT=58.7727778
.meas tran f_instab_l1_b48 FIND V(f_instab_l1) AT=58.7727778
.meas tran f_pwave_b48 FIND V(f_pwave) AT=58.7727778
.meas tran f_width_b48 FIND V(f_width) AT=58.7727778
.meas tran f_sym_b48 FIND V(f_sym) AT=58.8287778
.meas tran f_slope_b48 FIND V(f_slope) AT=58.8287778
.meas tran f_rr_ratio_b49 FIND V(f_rr_ratio) AT=60.0394444
.meas tran f_rr_asym_b49 FIND V(f_rr_asym) AT=60.0394444
.meas tran f_instab_l0_b49 FIND V(f_instab_l0) AT=60.0394444
.meas tran f_instab_l1_b49 FIND V(f_instab_l1) AT=60.0394444
.meas tran f_pwave_b49 FIND V(f_pwave) AT=60.0394444
.meas tran f_width_b49 FIND V(f_width) AT=60.0394444
.meas tran f_sym_b49 FIND V(f_sym) AT=60.1537778
.meas tran f_slope_b49 FIND V(f_slope) AT=60.1537778
.meas tran f_rr_ratio_b50 FIND V(f_rr_ratio) AT=61.2477778
.meas tran f_rr_asym_b50 FIND V(f_rr_asym) AT=61.2477778
.meas tran f_instab_l0_b50 FIND V(f_instab_l0) AT=61.2477778
.meas tran f_instab_l1_b50 FIND V(f_instab_l1) AT=61.2477778
.meas tran f_pwave_b50 FIND V(f_pwave) AT=61.2477778
.meas tran f_width_b50 FIND V(f_width) AT=61.2477778
.meas tran f_sym_b50 FIND V(f_sym) AT=61.3621111
.meas tran f_slope_b50 FIND V(f_slope) AT=61.3621111
.meas tran f_rr_ratio_b51 FIND V(f_rr_ratio) AT=62.5672222
.meas tran f_rr_asym_b51 FIND V(f_rr_asym) AT=62.5672222
.meas tran f_instab_l0_b51 FIND V(f_instab_l0) AT=62.5672222
.meas tran f_instab_l1_b51 FIND V(f_instab_l1) AT=62.5672222
.meas tran f_pwave_b51 FIND V(f_pwave) AT=62.5672222
.meas tran f_width_b51 FIND V(f_width) AT=62.5672222
.meas tran f_sym_b51 FIND V(f_sym) AT=62.6815556
.meas tran f_slope_b51 FIND V(f_slope) AT=62.6815556
.meas tran f_rr_ratio_b52 FIND V(f_rr_ratio) AT=63.8561111
.meas tran f_rr_asym_b52 FIND V(f_rr_asym) AT=63.8561111
.meas tran f_instab_l0_b52 FIND V(f_instab_l0) AT=63.8561111
.meas tran f_instab_l1_b52 FIND V(f_instab_l1) AT=63.8561111
.meas tran f_pwave_b52 FIND V(f_pwave) AT=63.8561111
.meas tran f_width_b52 FIND V(f_width) AT=63.8561111
.meas tran f_sym_b52 FIND V(f_sym) AT=63.9704444
.meas tran f_slope_b52 FIND V(f_slope) AT=63.9704444
.meas tran f_rr_ratio_b53 FIND V(f_rr_ratio) AT=65.1144444
.meas tran f_rr_asym_b53 FIND V(f_rr_asym) AT=65.1144444
.meas tran f_instab_l0_b53 FIND V(f_instab_l0) AT=65.1144444
.meas tran f_instab_l1_b53 FIND V(f_instab_l1) AT=65.1144444
.meas tran f_pwave_b53 FIND V(f_pwave) AT=65.1144444
.meas tran f_width_b53 FIND V(f_width) AT=65.1144444
.meas tran f_sym_b53 FIND V(f_sym) AT=65.2287778
.meas tran f_slope_b53 FIND V(f_slope) AT=65.2287778
.meas tran f_rr_ratio_b54 FIND V(f_rr_ratio) AT=66.3283333
.meas tran f_rr_asym_b54 FIND V(f_rr_asym) AT=66.3283333
.meas tran f_instab_l0_b54 FIND V(f_instab_l0) AT=66.3283333
.meas tran f_instab_l1_b54 FIND V(f_instab_l1) AT=66.3283333
.meas tran f_pwave_b54 FIND V(f_pwave) AT=66.3283333
.meas tran f_width_b54 FIND V(f_width) AT=66.3283333
.meas tran f_sym_b54 FIND V(f_sym) AT=66.4426667
.meas tran f_slope_b54 FIND V(f_slope) AT=66.4426667
.meas tran f_rr_ratio_b55 FIND V(f_rr_ratio) AT=67.5394444
.meas tran f_rr_asym_b55 FIND V(f_rr_asym) AT=67.5394444
.meas tran f_instab_l0_b55 FIND V(f_instab_l0) AT=67.5394444
.meas tran f_instab_l1_b55 FIND V(f_instab_l1) AT=67.5394444
.meas tran f_pwave_b55 FIND V(f_pwave) AT=67.5394444
.meas tran f_width_b55 FIND V(f_width) AT=67.5394444
.meas tran f_sym_b55 FIND V(f_sym) AT=67.6537778
.meas tran f_slope_b55 FIND V(f_slope) AT=67.6537778
.meas tran f_rr_ratio_b56 FIND V(f_rr_ratio) AT=68.7061111
.meas tran f_rr_asym_b56 FIND V(f_rr_asym) AT=68.7061111
.meas tran f_instab_l0_b56 FIND V(f_instab_l0) AT=68.7061111
.meas tran f_instab_l1_b56 FIND V(f_instab_l1) AT=68.7061111
.meas tran f_pwave_b56 FIND V(f_pwave) AT=68.7061111
.meas tran f_width_b56 FIND V(f_width) AT=68.7061111
.meas tran f_sym_b56 FIND V(f_sym) AT=68.7204444
.meas tran f_slope_b56 FIND V(f_slope) AT=68.7204444
.meas tran f_rr_ratio_b57 FIND V(f_rr_ratio) AT=69.9061111
.meas tran f_rr_asym_b57 FIND V(f_rr_asym) AT=69.9061111
.meas tran f_instab_l0_b57 FIND V(f_instab_l0) AT=69.9061111
.meas tran f_instab_l1_b57 FIND V(f_instab_l1) AT=69.9061111
.meas tran f_pwave_b57 FIND V(f_pwave) AT=69.9061111
.meas tran f_width_b57 FIND V(f_width) AT=69.9061111
.meas tran f_sym_b57 FIND V(f_sym) AT=69.9204444
.meas tran f_slope_b57 FIND V(f_slope) AT=69.9204444
.meas tran f_rr_ratio_b58 FIND V(f_rr_ratio) AT=71.0533333
.meas tran f_rr_asym_b58 FIND V(f_rr_asym) AT=71.0533333
.meas tran f_instab_l0_b58 FIND V(f_instab_l0) AT=71.0533333
.meas tran f_instab_l1_b58 FIND V(f_instab_l1) AT=71.0533333
.meas tran f_pwave_b58 FIND V(f_pwave) AT=71.0533333
.meas tran f_width_b58 FIND V(f_width) AT=71.0533333
.meas tran f_sym_b58 FIND V(f_sym) AT=71.0676667
.meas tran f_slope_b58 FIND V(f_slope) AT=71.0676667
.meas tran f_rr_ratio_b59 FIND V(f_rr_ratio) AT=72.2838889
.meas tran f_rr_asym_b59 FIND V(f_rr_asym) AT=72.2838889
.meas tran f_instab_l0_b59 FIND V(f_instab_l0) AT=72.2838889
.meas tran f_instab_l1_b59 FIND V(f_instab_l1) AT=72.2838889
.meas tran f_pwave_b59 FIND V(f_pwave) AT=72.2838889
.meas tran f_width_b59 FIND V(f_width) AT=72.2838889
.meas tran f_sym_b59 FIND V(f_sym) AT=72.2982222
.meas tran f_slope_b59 FIND V(f_slope) AT=72.2982222
.meas tran f_rr_ratio_b60 FIND V(f_rr_ratio) AT=73.5505556
.meas tran f_rr_asym_b60 FIND V(f_rr_asym) AT=73.5505556
.meas tran f_instab_l0_b60 FIND V(f_instab_l0) AT=73.5505556
.meas tran f_instab_l1_b60 FIND V(f_instab_l1) AT=73.5505556
.meas tran f_pwave_b60 FIND V(f_pwave) AT=73.5505556
.meas tran f_width_b60 FIND V(f_width) AT=73.5505556
.meas tran f_sym_b60 FIND V(f_sym) AT=73.6010000
.meas tran f_slope_b60 FIND V(f_slope) AT=73.6010000
.meas tran f_rr_ratio_b61 FIND V(f_rr_ratio) AT=74.7338889
.meas tran f_rr_asym_b61 FIND V(f_rr_asym) AT=74.7338889
.meas tran f_instab_l0_b61 FIND V(f_instab_l0) AT=74.7338889
.meas tran f_instab_l1_b61 FIND V(f_instab_l1) AT=74.7338889
.meas tran f_pwave_b61 FIND V(f_pwave) AT=74.7338889
.meas tran f_width_b61 FIND V(f_width) AT=74.7338889
.meas tran f_sym_b61 FIND V(f_sym) AT=74.7482222
.meas tran f_slope_b61 FIND V(f_slope) AT=74.7482222
.meas tran f_rr_ratio_b62 FIND V(f_rr_ratio) AT=75.9783333
.meas tran f_rr_asym_b62 FIND V(f_rr_asym) AT=75.9783333
.meas tran f_instab_l0_b62 FIND V(f_instab_l0) AT=75.9783333
.meas tran f_instab_l1_b62 FIND V(f_instab_l1) AT=75.9783333
.meas tran f_pwave_b62 FIND V(f_pwave) AT=75.9783333
.meas tran f_width_b62 FIND V(f_width) AT=75.9783333
.meas tran f_sym_b62 FIND V(f_sym) AT=75.9926667
.meas tran f_slope_b62 FIND V(f_slope) AT=75.9926667
.meas tran f_rr_ratio_b63 FIND V(f_rr_ratio) AT=77.1255556
.meas tran f_rr_asym_b63 FIND V(f_rr_asym) AT=77.1255556
.meas tran f_instab_l0_b63 FIND V(f_instab_l0) AT=77.1255556
.meas tran f_instab_l1_b63 FIND V(f_instab_l1) AT=77.1255556
.meas tran f_pwave_b63 FIND V(f_pwave) AT=77.1255556
.meas tran f_width_b63 FIND V(f_width) AT=77.1255556
.meas tran f_sym_b63 FIND V(f_sym) AT=77.2398889
.meas tran f_slope_b63 FIND V(f_slope) AT=77.2398889
.meas tran f_rr_ratio_b64 FIND V(f_rr_ratio) AT=78.3366667
.meas tran f_rr_asym_b64 FIND V(f_rr_asym) AT=78.3366667
.meas tran f_instab_l0_b64 FIND V(f_instab_l0) AT=78.3366667
.meas tran f_instab_l1_b64 FIND V(f_instab_l1) AT=78.3366667
.meas tran f_pwave_b64 FIND V(f_pwave) AT=78.3366667
.meas tran f_width_b64 FIND V(f_width) AT=78.3366667
.meas tran f_sym_b64 FIND V(f_sym) AT=78.4510000
.meas tran f_slope_b64 FIND V(f_slope) AT=78.4510000
.meas tran f_rr_ratio_b65 FIND V(f_rr_ratio) AT=79.5783333
.meas tran f_rr_asym_b65 FIND V(f_rr_asym) AT=79.5783333
.meas tran f_instab_l0_b65 FIND V(f_instab_l0) AT=79.5783333
.meas tran f_instab_l1_b65 FIND V(f_instab_l1) AT=79.5783333
.meas tran f_pwave_b65 FIND V(f_pwave) AT=79.5783333
.meas tran f_width_b65 FIND V(f_width) AT=79.5783333
.meas tran f_sym_b65 FIND V(f_sym) AT=79.6926667
.meas tran f_slope_b65 FIND V(f_slope) AT=79.6926667
.meas tran f_rr_ratio_b66 FIND V(f_rr_ratio) AT=80.7672222
.meas tran f_rr_asym_b66 FIND V(f_rr_asym) AT=80.7672222
.meas tran f_instab_l0_b66 FIND V(f_instab_l0) AT=80.7672222
.meas tran f_instab_l1_b66 FIND V(f_instab_l1) AT=80.7672222
.meas tran f_pwave_b66 FIND V(f_pwave) AT=80.7672222
.meas tran f_width_b66 FIND V(f_width) AT=80.7672222
.meas tran f_sym_b66 FIND V(f_sym) AT=80.8815556
.meas tran f_slope_b66 FIND V(f_slope) AT=80.8815556
.meas tran f_rr_ratio_b67 FIND V(f_rr_ratio) AT=81.9838889
.meas tran f_rr_asym_b67 FIND V(f_rr_asym) AT=81.9838889
.meas tran f_instab_l0_b67 FIND V(f_instab_l0) AT=81.9838889
.meas tran f_instab_l1_b67 FIND V(f_instab_l1) AT=81.9838889
.meas tran f_pwave_b67 FIND V(f_pwave) AT=81.9838889
.meas tran f_width_b67 FIND V(f_width) AT=81.9838889
.meas tran f_sym_b67 FIND V(f_sym) AT=82.0982222
.meas tran f_slope_b67 FIND V(f_slope) AT=82.0982222
.meas tran f_rr_ratio_b68 FIND V(f_rr_ratio) AT=83.1811111
.meas tran f_rr_asym_b68 FIND V(f_rr_asym) AT=83.1811111
.meas tran f_instab_l0_b68 FIND V(f_instab_l0) AT=83.1811111
.meas tran f_instab_l1_b68 FIND V(f_instab_l1) AT=83.1811111
.meas tran f_pwave_b68 FIND V(f_pwave) AT=83.1811111
.meas tran f_width_b68 FIND V(f_width) AT=83.1811111
.meas tran f_sym_b68 FIND V(f_sym) AT=83.2954444
.meas tran f_slope_b68 FIND V(f_slope) AT=83.2954444
.meas tran f_rr_ratio_b69 FIND V(f_rr_ratio) AT=84.3922222
.meas tran f_rr_asym_b69 FIND V(f_rr_asym) AT=84.3922222
.meas tran f_instab_l0_b69 FIND V(f_instab_l0) AT=84.3922222
.meas tran f_instab_l1_b69 FIND V(f_instab_l1) AT=84.3922222
.meas tran f_pwave_b69 FIND V(f_pwave) AT=84.3922222
.meas tran f_width_b69 FIND V(f_width) AT=84.3922222
.meas tran f_sym_b69 FIND V(f_sym) AT=84.5065556
.meas tran f_slope_b69 FIND V(f_slope) AT=84.5065556
.meas tran f_rr_ratio_b70 FIND V(f_rr_ratio) AT=85.6172222
.meas tran f_rr_asym_b70 FIND V(f_rr_asym) AT=85.6172222
.meas tran f_instab_l0_b70 FIND V(f_instab_l0) AT=85.6172222
.meas tran f_instab_l1_b70 FIND V(f_instab_l1) AT=85.6172222
.meas tran f_pwave_b70 FIND V(f_pwave) AT=85.6172222
.meas tran f_width_b70 FIND V(f_width) AT=85.6172222
.meas tran f_sym_b70 FIND V(f_sym) AT=85.7315556
.meas tran f_slope_b70 FIND V(f_slope) AT=85.7315556
.meas tran f_rr_ratio_b71 FIND V(f_rr_ratio) AT=86.8561111
.meas tran f_rr_asym_b71 FIND V(f_rr_asym) AT=86.8561111
.meas tran f_instab_l0_b71 FIND V(f_instab_l0) AT=86.8561111
.meas tran f_instab_l1_b71 FIND V(f_instab_l1) AT=86.8561111
.meas tran f_pwave_b71 FIND V(f_pwave) AT=86.8561111
.meas tran f_width_b71 FIND V(f_width) AT=86.8561111
.meas tran f_sym_b71 FIND V(f_sym) AT=86.9704444
.meas tran f_slope_b71 FIND V(f_slope) AT=86.9704444
.meas tran f_rr_ratio_b72 FIND V(f_rr_ratio) AT=88.0866667
.meas tran f_rr_asym_b72 FIND V(f_rr_asym) AT=88.0866667
.meas tran f_instab_l0_b72 FIND V(f_instab_l0) AT=88.0866667
.meas tran f_instab_l1_b72 FIND V(f_instab_l1) AT=88.0866667
.meas tran f_pwave_b72 FIND V(f_pwave) AT=88.0866667
.meas tran f_width_b72 FIND V(f_width) AT=88.0866667
.meas tran f_sym_b72 FIND V(f_sym) AT=88.2010000
.meas tran f_slope_b72 FIND V(f_slope) AT=88.2010000
.meas tran f_rr_ratio_b73 FIND V(f_rr_ratio) AT=89.2866667
.meas tran f_rr_asym_b73 FIND V(f_rr_asym) AT=89.2866667
.meas tran f_instab_l0_b73 FIND V(f_instab_l0) AT=89.2866667
.meas tran f_instab_l1_b73 FIND V(f_instab_l1) AT=89.2866667
.meas tran f_pwave_b73 FIND V(f_pwave) AT=89.2866667
.meas tran f_width_b73 FIND V(f_width) AT=89.2866667
.meas tran f_sym_b73 FIND V(f_sym) AT=89.4010000
.meas tran f_slope_b73 FIND V(f_slope) AT=89.4010000
.meas tran f_rr_ratio_b74 FIND V(f_rr_ratio) AT=90.5088889
.meas tran f_rr_asym_b74 FIND V(f_rr_asym) AT=90.5088889
.meas tran f_instab_l0_b74 FIND V(f_instab_l0) AT=90.5088889
.meas tran f_instab_l1_b74 FIND V(f_instab_l1) AT=90.5088889
.meas tran f_pwave_b74 FIND V(f_pwave) AT=90.5088889
.meas tran f_width_b74 FIND V(f_width) AT=90.5088889
.meas tran f_sym_b74 FIND V(f_sym) AT=90.6232222
.meas tran f_slope_b74 FIND V(f_slope) AT=90.6232222
.meas tran f_rr_ratio_b75 FIND V(f_rr_ratio) AT=91.7311111
.meas tran f_rr_asym_b75 FIND V(f_rr_asym) AT=91.7311111
.meas tran f_instab_l0_b75 FIND V(f_instab_l0) AT=91.7311111
.meas tran f_instab_l1_b75 FIND V(f_instab_l1) AT=91.7311111
.meas tran f_pwave_b75 FIND V(f_pwave) AT=91.7311111
.meas tran f_width_b75 FIND V(f_width) AT=91.7311111
.meas tran f_sym_b75 FIND V(f_sym) AT=91.8454444
.meas tran f_slope_b75 FIND V(f_slope) AT=91.8454444
.meas tran f_rr_ratio_b76 FIND V(f_rr_ratio) AT=92.9700000
.meas tran f_rr_asym_b76 FIND V(f_rr_asym) AT=92.9700000
.meas tran f_instab_l0_b76 FIND V(f_instab_l0) AT=92.9700000
.meas tran f_instab_l1_b76 FIND V(f_instab_l1) AT=92.9700000
.meas tran f_pwave_b76 FIND V(f_pwave) AT=92.9700000
.meas tran f_width_b76 FIND V(f_width) AT=92.9700000
.meas tran f_sym_b76 FIND V(f_sym) AT=93.0843333
.meas tran f_slope_b76 FIND V(f_slope) AT=93.0843333
.meas tran f_rr_ratio_b77 FIND V(f_rr_ratio) AT=94.1450000
.meas tran f_rr_asym_b77 FIND V(f_rr_asym) AT=94.1450000
.meas tran f_instab_l0_b77 FIND V(f_instab_l0) AT=94.1450000
.meas tran f_instab_l1_b77 FIND V(f_instab_l1) AT=94.1450000
.meas tran f_pwave_b77 FIND V(f_pwave) AT=94.1450000
.meas tran f_width_b77 FIND V(f_width) AT=94.1450000
.meas tran f_sym_b77 FIND V(f_sym) AT=94.2593333
.meas tran f_slope_b77 FIND V(f_slope) AT=94.2593333
.meas tran f_rr_ratio_b78 FIND V(f_rr_ratio) AT=95.3200000
.meas tran f_rr_asym_b78 FIND V(f_rr_asym) AT=95.3200000
.meas tran f_instab_l0_b78 FIND V(f_instab_l0) AT=95.3200000
.meas tran f_instab_l1_b78 FIND V(f_instab_l1) AT=95.3200000
.meas tran f_pwave_b78 FIND V(f_pwave) AT=95.3200000
.meas tran f_width_b78 FIND V(f_width) AT=95.3200000
.meas tran f_sym_b78 FIND V(f_sym) AT=95.4343333
.meas tran f_slope_b78 FIND V(f_slope) AT=95.4343333
.meas tran f_rr_ratio_b79 FIND V(f_rr_ratio) AT=96.5366667
.meas tran f_rr_asym_b79 FIND V(f_rr_asym) AT=96.5366667
.meas tran f_instab_l0_b79 FIND V(f_instab_l0) AT=96.5366667
.meas tran f_instab_l1_b79 FIND V(f_instab_l1) AT=96.5366667
.meas tran f_pwave_b79 FIND V(f_pwave) AT=96.5366667
.meas tran f_width_b79 FIND V(f_width) AT=96.5366667
.meas tran f_sym_b79 FIND V(f_sym) AT=96.6510000
.meas tran f_slope_b79 FIND V(f_slope) AT=96.6510000

.end
