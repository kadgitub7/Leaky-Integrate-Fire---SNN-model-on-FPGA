.title s14_prop_delay_cross_2ms
.lib "sky130_minimal.lib.spice" tt
.option scale=1.0u method=gear reltol=0.001 gmin=1e-15
.temp 27
Vdd vdd 0 0.9
Vss vss 0 0
Vbias vbias 0 0.300
Vrpk rpk 0 PWL(0.0000000 0.000000 0.4996000 0.000000 0.5000000 0.900000 0.5050000 0.900000 0.5054000 0.000000 1.2996000 0.000000 1.3000000 0.900000 1.3050000 0.900000 1.3054000 0.000000 2.0996000 0.000000 2.1000000 0.900000 2.1050000 0.900000 2.1054000 0.000000 2.8996000 0.000000 2.9000000 0.900000 2.9050000 0.900000 2.9054000 0.000000 3.6996000 0.000000 3.7000000 0.900000 3.7050000 0.900000 3.7054000 0.000000 4.4996000 0.000000 4.5000000 0.900000 4.5050000 0.900000 4.5054000 0.000000 5.0000000 0.000000)
.include "C:/Users/kadhi/OneDrive/Desktop/amux/verilogLearning/Leaky-Integrate-Fire---SNN-model-on-FPGA/experiments/frontend_optimization/complete_frontend_v9b/inverter.spice"
.include "C:/Users/kadhi/OneDrive/Desktop/amux/verilogLearning/Leaky-Integrate-Fire---SNN-model-on-FPGA/experiments/frontend_optimization/complete_frontend_v9b/delay_timer.spice"
.include "C:/Users/kadhi/OneDrive/Desktop/amux/verilogLearning/Leaky-Integrate-Fire---SNN-model-on-FPGA/experiments/frontend_optimization/complete_frontend_v9b/edge_buffer.spice"
.include "C:/Users/kadhi/OneDrive/Desktop/amux/verilogLearning/Leaky-Integrate-Fire---SNN-model-on-FPGA/experiments/frontend_optimization/complete_frontend_v9b/pulse_gen.spice"
Vth14 nth14 0 0.448578
Xdt rpk dt_s14 dt_s69 dt_wid dt_bi dt_rr dt_rpk sf_out
+ vdd vss vbias nth14 0.200 0.200 0.200 0.200 0.200 delay_timer
Xeb dt_s14 s14_sharp vdd vss edge_buffer
Xpg s14_sharp pulse_s14 vdd vss vbias pulse_gen
.tran 0.01m 5.0000
.meas tran t_s14_2 WHEN V(pulse_s14)=0.45 RISE=1 TD=2.1010000
.meas tran t_s14_3 WHEN V(pulse_s14)=0.45 RISE=1 TD=2.9010000
.meas tran t_s14_4 WHEN V(pulse_s14)=0.45 RISE=1 TD=3.7010000
.meas tran t_s14_5 WHEN V(pulse_s14)=0.45 RISE=1 TD=4.5010000

.end
