.title analog_triggers
.lib "C:/Users/kadhi/OneDrive/Desktop/amux/verilogLearning/Leaky-Integrate-Fire---SNN-model-on-FPGA/experiments/frontend_optimization/ngspice_frontend/sky130_minimal.lib.spice" tt
.option scale=1.0u method=gear reltol=0.01 gmin=1e-15 itl4=200
.temp 27
Vdd vdd 0 0.9
Vss vss 0 0

Vecg0 ecg_l0 0 PWL(0.0000000 0.300000 0.5608889 0.300000 0.5638889 0.253524 0.5666667 0.252762 0.5694444 0.254286 0.5722222 0.253524 0.5750000 0.255810 0.5777778 0.254286 0.5805556 0.254286 0.5833333 0.253524 0.5861111 0.253524 0.5888889 0.255810 0.5916667 0.257333 0.5944444 0.255048 0.5972222 0.253524 0.6000000 0.252000 0.6027778 0.253524 0.6055556 0.255048 0.6083333 0.255810 0.6111111 0.257333 0.6138889 0.258857 0.6166667 0.258095 0.6194444 0.258095 0.6222222 0.258857 0.6250000 0.261905 0.6277778 0.261905 0.6305556 0.261143 0.6333333 0.265714 0.6361111 0.266476 0.6388889 0.268762 0.6416667 0.269524 0.6444444 0.268762 0.6472222 0.267238 0.6500000 0.264952 0.6527778 0.266476 0.6555556 0.265714 0.6583333 0.265714 0.6611111 0.265714 0.6638889 0.264952 0.6666667 0.264190 0.6694444 0.263429 0.6722222 0.264190 0.6750000 0.266476 0.6777778 0.268000 0.6805556 0.268762 0.6833333 0.262667 0.6861111 0.256571 0.6888889 0.256571 0.6916667 0.254286 0.6944444 0.252762 0.6972222 0.249714 0.7000000 0.249714 0.7027778 0.250476 0.7055556 0.252000 0.7083333 0.251238 0.7111111 0.252000 0.7138889 0.250476 0.7166667 0.248190 0.7194444 0.247429 0.7222222 0.248190 0.7250000 0.248190 0.7277778 0.246667 0.7305556 0.247429 0.7333333 0.245905 0.7361111 0.249714 0.7388889 0.248952 0.7416667 0.249714 0.7444444 0.251238 0.7472222 0.247429 0.7500000 0.245905 0.7527778 0.248190 0.7555556 0.249714 0.7583333 0.250476 0.7611111 0.249714 0.7638889 0.246667 0.7666667 0.244381 0.7694444 0.245143 0.7722222 0.242095 0.7750000 0.235238 0.7777778 0.232190 0.7805556 0.227619 0.7833333 0.222286 0.7861111 0.218476 0.7888889 0.223048 0.7916667 0.236762 0.7944444 0.254286 0.7972222 0.275619 0.8000000 0.297714 0.8027778 0.335810 0.8055556 0.374667 0.8083333 0.409714 0.8111111 0.433333 0.8138889 0.443238 0.8166667 0.437905 0.8194444 0.415048 0.8222222 0.374667 0.8250000 0.325143 0.8277778 0.283238 0.8305556 0.258857 0.8333333 0.240571 0.8361111 0.231429 0.8388889 0.227619 0.8416667 0.230667 0.8444444 0.235238 0.8472222 0.240571 0.8500000 0.240571 0.8527778 0.241333 0.8555556 0.240571 0.8583333 0.242095 0.8611111 0.242095 0.8638889 0.242095 0.8666667 0.239810 0.8694444 0.241333 0.8722222 0.241333 0.8750000 0.241333 0.8777778 0.242857 0.8805556 0.239810 0.8833333 0.237524 0.8861111 0.237524 0.8888889 0.239048 0.8916667 0.239810 0.8944444 0.240571 0.8972222 0.238286 0.9000000 0.239810 0.9027778 0.241333 0.9055556 0.242857 0.9083333 0.240571 0.9111111 0.240571 0.9138889 0.238286 0.9166667 0.237524 0.9194444 0.237524 0.9222222 0.240571 0.9250000 0.240571 0.9277778 0.239810 0.9305556 0.238286 0.9333333 0.236762 0.9361111 0.239048 0.9388889 0.237524 0.9416667 0.238286 0.9444444 0.237524 0.9472222 0.236762 0.9500000 0.237524 0.9527778 0.239048 0.9555556 0.239048 0.9583333 0.239810 0.9611111 0.240571 0.9638889 0.238286 0.9666667 0.237524 0.9694444 0.240571 0.9722222 0.240571 0.9750000 0.241333 0.9777778 0.241333 0.9805556 0.237524 0.9833333 0.238286 0.9861111 0.239810 0.9888889 0.240571 0.9916667 0.242857 0.9944444 0.240571 0.9972222 0.239810 1.0000000 0.237524 1.0027778 0.239048 1.0055556 0.240571 1.0083333 0.240571 1.0111111 0.241333 1.0138889 0.238286 1.0166667 0.236762 1.0194444 0.236762 1.0222222 0.239048 1.0250000 0.239810 1.0277778 0.238286 1.0305556 0.236762 1.0333333 0.236000 1.0361111 0.236000 1.0388889 0.237524 1.0416667 0.236762 1.0444444 0.235238 1.0472222 0.236000 1.0500000 0.233714 1.0527778 0.234476 1.0555556 0.234476 1.0583333 0.236000 1.0611111 0.234476 1.0638889 0.231429 1.0666667 0.230667 1.0694444 0.231429 1.0722222 0.233714 1.0750000 0.232190 1.0777778 0.231429 1.0805556 0.230667 1.0833333 0.228381 1.0861111 0.229905 1.0888889 0.230667 1.0916667 0.231429 1.0944444 0.230667 1.0972222 0.228381 1.1000000 0.227619 1.1027778 0.229905 1.1055556 0.231429 1.1083333 0.232190 1.1111111 0.232952 1.1168889 0.300000 1.3720000 0.300000 1.3750000 0.249714 1.3777778 0.247429 1.3805556 0.247429 1.3833333 0.245905 1.3861111 0.246667 1.3888889 0.248190 1.3916667 0.249714 1.3944444 0.248190 1.3972222 0.248190 1.4000000 0.248190 1.4027778 0.249714 1.4055556 0.248952 1.4083333 0.249714 1.4111111 0.248952 1.4138889 0.247429 1.4166667 0.247429 1.4194444 0.248190 1.4222222 0.249714 1.4250000 0.252000 1.4277778 0.255048 1.4305556 0.254286 1.4333333 0.255048 1.4361111 0.256571 1.4388889 0.258095 1.4416667 0.259619 1.4444444 0.259619 1.4472222 0.259619 1.4500000 0.261143 1.4527778 0.261905 1.4555556 0.263429 1.4583333 0.265714 1.4611111 0.267238 1.4638889 0.263429 1.4666667 0.262667 1.4694444 0.263429 1.4722222 0.262667 1.4750000 0.264190 1.4777778 0.262667 1.4805556 0.261905 1.4833333 0.258095 1.4861111 0.258095 1.4888889 0.259619 1.4916667 0.261905 1.4944444 0.265714 1.4972222 0.266476 1.5000000 0.264952 1.5027778 0.259619 1.5055556 0.258857 1.5083333 0.257333 1.5111111 0.256571 1.5138889 0.253524 1.5166667 0.251238 1.5194444 0.248190 1.5222222 0.249714 1.5250000 0.248952 1.5277778 0.248952 1.5305556 0.245905 1.5333333 0.243619 1.5361111 0.245143 1.5388889 0.247429 1.5416667 0.246667 1.5444444 0.245905 1.5472222 0.244381 1.5500000 0.242857 1.5527778 0.242095 1.5555556 0.243619 1.5583333 0.244381 1.5611111 0.244381 1.5638889 0.242095 1.5666667 0.241333 1.5694444 0.242095 1.5722222 0.242857 1.5750000 0.245905 1.5777778 0.243619 1.5805556 0.240571 1.5833333 0.238286 1.5861111 0.237524 1.5888889 0.233714 1.5916667 0.229143 1.5944444 0.225333 1.5972222 0.220762 1.6000000 0.215429 1.6027778 0.213143 1.6055556 0.220000 1.6083333 0.238286 1.6111111 0.261905 1.6138889 0.286286 1.6166667 0.318286 1.6194444 0.362476 1.6222222 0.405143 1.6250000 0.434857 1.6277778 0.446286 1.6305556 0.429524 1.6333333 0.379238 1.6361111 0.307619 1.6388889 0.251238 1.6416667 0.223810 1.6444444 0.223048 1.6472222 0.232190 1.6500000 0.236762 1.6527778 0.239810 1.6555556 0.240571 1.6583333 0.239810 1.6611111 0.240571 1.6638889 0.239810 1.6666667 0.238286 1.6694444 0.239810 1.6722222 0.238286 1.6750000 0.240571 1.6777778 0.239810 1.6805556 0.239810 1.6833333 0.237524 1.6861111 0.238286 1.6888889 0.239048 1.6916667 0.239048 1.6944444 0.236762 1.6972222 0.238286 1.7000000 0.236000 1.7027778 0.236762 1.7055556 0.238286 1.7083333 0.238286 1.7111111 0.236000 1.7138889 0.236000 1.7166667 0.233714 1.7194444 0.236000 1.7222222 0.237524 1.7250000 0.237524 1.7277778 0.238286 1.7305556 0.235238 1.7333333 0.234476 1.7361111 0.236000 1.7388889 0.236762 1.7416667 0.237524 1.7444444 0.237524 1.7472222 0.235238 1.7500000 0.236000 1.7527778 0.239048 1.7555556 0.239810 1.7583333 0.239048 1.7611111 0.239048 1.7638889 0.239810 1.7666667 0.236762 1.7694444 0.238286 1.7722222 0.240571 1.7750000 0.239048 1.7777778 0.239048 1.7805556 0.236762 1.7833333 0.235238 1.7861111 0.235238 1.7888889 0.236762 1.7916667 0.236762 1.7944444 0.237524 1.7972222 0.235238 1.8000000 0.235238 1.8027778 0.236000 1.8055556 0.236762 1.8083333 0.239048 1.8111111 0.239048 1.8138889 0.237524 1.8166667 0.235238 1.8194444 0.237524 1.8222222 0.238286 1.8250000 0.239810 1.8277778 0.239048 1.8305556 0.239048 1.8333333 0.238286 1.8361111 0.241333 1.8388889 0.239048 1.8416667 0.240571 1.8444444 0.240571 1.8472222 0.239048 1.8500000 0.236762 1.8527778 0.238286 1.8555556 0.238286 1.8583333 0.237524 1.8611111 0.236762 1.8638889 0.236000 1.8666667 0.236000 1.8694444 0.235238 1.8722222 0.236762 1.8750000 0.236762 1.8777778 0.237524 1.8805556 0.233714 1.8833333 0.234476 1.8861111 0.233714 1.8888889 0.236000 1.8916667 0.236000 1.8944444 0.236000 1.8972222 0.236000 1.9000000 0.235238 1.9027778 0.235238 1.9055556 0.236762 1.9083333 0.239810 1.9111111 0.239810 1.9138889 0.240571 1.9166667 0.242857 1.9194444 0.245143 1.9222222 0.248190 1.9280000 0.300000 2.1608889 0.300000 2.1638889 0.242857 2.1666667 0.241333 2.1694444 0.245905 2.1722222 0.245143 2.1750000 0.245905 2.1777778 0.245143 2.1805556 0.245143 2.1833333 0.243619 2.1861111 0.245143 2.1888889 0.247429 2.1916667 0.245905 2.1944444 0.247429 2.1972222 0.247429 2.2000000 0.247429 2.2027778 0.248190 2.2055556 0.252762 2.2083333 0.253524 2.2111111 0.253524 2.2138889 0.252762 2.2166667 0.253524 2.2194444 0.255810 2.2222222 0.256571 2.2250000 0.258095 2.2277778 0.257333 2.2305556 0.257333 2.2333333 0.258095 2.2361111 0.259619 2.2388889 0.261143 2.2416667 0.262667 2.2444444 0.260381 2.2472222 0.259619 2.2500000 0.258095 2.2527778 0.257333 2.2555556 0.259619 2.2583333 0.258857 2.2611111 0.258095 2.2638889 0.257333 2.2666667 0.258095 2.2694444 0.257333 2.2722222 0.258095 2.2750000 0.259619 2.2777778 0.261143 2.2805556 0.263429 2.2833333 0.260381 2.2861111 0.257333 2.2888889 0.252762 2.2916667 0.252762 2.2944444 0.247429 2.2972222 0.245143 2.3000000 0.242095 2.3027778 0.241333 2.3055556 0.242095 2.3083333 0.243619 2.3111111 0.242857 2.3138889 0.241333 2.3166667 0.240571 2.3194444 0.239810 2.3222222 0.241333 2.3250000 0.241333 2.3277778 0.241333 2.3305556 0.239810 2.3333333 0.238286 2.3361111 0.239048 2.3388889 0.242857 2.3416667 0.242857 2.3444444 0.240571 2.3472222 0.239810 2.3500000 0.236762 2.3527778 0.238286 2.3555556 0.239048 2.3583333 0.240571 2.3611111 0.238286 2.3638889 0.235238 2.3666667 0.229905 2.3694444 0.227619 2.3722222 0.223048 2.3750000 0.222286 2.3777778 0.220000 2.3805556 0.217714 2.3833333 0.208571 2.3861111 0.201714 2.3888889 0.204000 2.3916667 0.212381 2.3944444 0.224571 2.3972222 0.241333 2.4000000 0.258857 2.4027778 0.282476 2.4055556 0.313714 2.4083333 0.356381 2.4111111 0.396762 2.4138889 0.423429 2.4166667 0.431048 2.4194444 0.417333 2.4222222 0.372381 2.4250000 0.309905 2.4277778 0.253524 2.4305556 0.223810 2.4333333 0.220762 2.4361111 0.227619 2.4388889 0.237524 2.4416667 0.240571 2.4444444 0.240571 2.4472222 0.239048 2.4500000 0.237524 2.4527778 0.238286 2.4555556 0.241333 2.4583333 0.240571 2.4611111 0.239810 2.4638889 0.238286 2.4666667 0.237524 2.4694444 0.238286 2.4722222 0.239048 2.4750000 0.240571 2.4777778 0.239810 2.4805556 0.237524 2.4833333 0.236762 2.4861111 0.237524 2.4888889 0.239810 2.4916667 0.238286 2.4944444 0.237524 2.4972222 0.238286 2.5000000 0.238286 2.5027778 0.237524 2.5055556 0.240571 2.5083333 0.241333 2.5111111 0.240571 2.5138889 0.239810 2.5166667 0.239048 2.5194444 0.239048 2.5222222 0.239048 2.5250000 0.239810 2.5277778 0.239810 2.5305556 0.238286 2.5333333 0.238286 2.5361111 0.239048 2.5388889 0.239810 2.5416667 0.241333 2.5444444 0.242857 2.5472222 0.241333 2.5500000 0.239810 2.5527778 0.240571 2.5555556 0.241333 2.5583333 0.242857 2.5611111 0.241333 2.5638889 0.239810 2.5666667 0.239810 2.5694444 0.241333 2.5722222 0.242857 2.5750000 0.242857 2.5777778 0.241333 2.5805556 0.239810 2.5833333 0.240571 2.5861111 0.240571 2.5888889 0.244381 2.5916667 0.242857 2.5944444 0.241333 2.5972222 0.239810 2.6000000 0.242095 2.6027778 0.241333 2.6055556 0.242857 2.6083333 0.242095 2.6111111 0.240571 2.6138889 0.242095 2.6166667 0.242857 2.6194444 0.242857 2.6222222 0.242857 2.6250000 0.242857 2.6277778 0.242095 2.6305556 0.240571 2.6333333 0.240571 2.6361111 0.244381 2.6388889 0.243619 2.6416667 0.242857 2.6444444 0.241333 2.6472222 0.240571 2.6500000 0.240571 2.6527778 0.242857 2.6555556 0.244381 2.6583333 0.241333 2.6611111 0.242095 2.6638889 0.240571 2.6666667 0.242857 2.6694444 0.242857 2.6722222 0.244381 2.6750000 0.243619 2.6777778 0.241333 2.6805556 0.239810 2.6833333 0.241333 2.6861111 0.241333 2.6888889 0.243619 2.6916667 0.244381 2.6944444 0.243619 2.6972222 0.242857 2.7000000 0.246667 2.7027778 0.248952 2.7055556 0.251238 2.7083333 0.252000 2.7111111 0.251238 2.7168889 0.300000 2.9525556 0.300000 2.9555556 0.247429 2.9583333 0.247429 2.9611111 0.246667 2.9638889 0.245905 2.9666667 0.247429 2.9694444 0.249714 2.9722222 0.249714 2.9750000 0.248952 2.9777778 0.248952 2.9805556 0.248190 2.9833333 0.249714 2.9861111 0.251238 2.9888889 0.255810 2.9916667 0.255810 2.9944444 0.254286 2.9972222 0.253524 3.0000000 0.256571 3.0027778 0.257333 3.0055556 0.258095 3.0083333 0.257333 3.0111111 0.258095 3.0138889 0.258857 3.0166667 0.259619 3.0194444 0.261905 3.0222222 0.264952 3.0250000 0.262667 3.0277778 0.263429 3.0305556 0.261143 3.0333333 0.261143 3.0361111 0.262667 3.0388889 0.264190 3.0416667 0.261143 3.0444444 0.259619 3.0472222 0.260381 3.0500000 0.261143 3.0527778 0.258857 3.0555556 0.259619 3.0583333 0.257333 3.0611111 0.261143 3.0638889 0.261905 3.0666667 0.262667 3.0694444 0.259619 3.0722222 0.257333 3.0750000 0.254286 3.0777778 0.252000 3.0805556 0.250476 3.0833333 0.248952 3.0861111 0.247429 3.0888889 0.249714 3.0916667 0.248952 3.0944444 0.247429 3.0972222 0.245143 3.1000000 0.246667 3.1027778 0.248190 3.1055556 0.248952 3.1083333 0.247429 3.1111111 0.245143 3.1138889 0.244381 3.1166667 0.242857 3.1194444 0.243619 3.1222222 0.244381 3.1250000 0.244381 3.1277778 0.242095 3.1305556 0.242857 3.1333333 0.242857 3.1361111 0.244381 3.1388889 0.243619 3.1416667 0.245143 3.1444444 0.243619 3.1472222 0.242095 3.1500000 0.244381 3.1527778 0.245143 3.1555556 0.246667 3.1583333 0.245905 3.1611111 0.243619 3.1638889 0.241333 3.1666667 0.239810 3.1694444 0.234476 3.1722222 0.232190 3.1750000 0.226095 3.1777778 0.221524 3.1805556 0.213905 3.1833333 0.215429 3.1861111 0.227619 3.1888889 0.245905 3.1916667 0.266476 3.1944444 0.291619 3.1972222 0.328190 3.2000000 0.372381 3.2027778 0.407429 3.2055556 0.424952 3.2083333 0.418857 3.2111111 0.381524 3.2138889 0.322095 3.2166667 0.269524 3.2194444 0.236000 3.2222222 0.223810 3.2250000 0.226857 3.2277778 0.231429 3.2305556 0.237524 3.2333333 0.239048 3.2361111 0.240571 3.2388889 0.240571 3.2416667 0.239048 3.2444444 0.238286 3.2472222 0.235238 3.2500000 0.235238 3.2527778 0.238286 3.2555556 0.239810 3.2583333 0.238286 3.2611111 0.238286 3.2638889 0.236762 3.2666667 0.238286 3.2694444 0.241333 3.2722222 0.240571 3.2750000 0.239810 3.2777778 0.239810 3.2805556 0.239810 3.2833333 0.239810 3.2861111 0.241333 3.2888889 0.240571 3.2916667 0.240571 3.2944444 0.239048 3.2972222 0.235238 3.3000000 0.237524 3.3027778 0.239048 3.3055556 0.239810 3.3083333 0.239048 3.3111111 0.238286 3.3138889 0.235238 3.3166667 0.236762 3.3194444 0.238286 3.3222222 0.238286 3.3250000 0.238286 3.3277778 0.237524 3.3305556 0.236762 3.3333333 0.238286 3.3361111 0.236000 3.3388889 0.238286 3.3416667 0.237524 3.3444444 0.237524 3.3472222 0.236000 3.3500000 0.236762 3.3527778 0.238286 3.3555556 0.239810 3.3583333 0.239810 3.3611111 0.239810 3.3638889 0.239048 3.3666667 0.239810 3.3694444 0.239810 3.3722222 0.238286 3.3750000 0.238286 3.3777778 0.236000 3.3805556 0.233714 3.3833333 0.236762 3.3861111 0.238286 3.3888889 0.239810 3.3916667 0.240571 3.3944444 0.236762 3.3972222 0.238286 3.4000000 0.238286 3.4027778 0.239048 3.4055556 0.239810 3.4083333 0.239810 3.4111111 0.238286 3.4138889 0.236000 3.4166667 0.236762 3.4194444 0.239048 3.4222222 0.239810 3.4250000 0.239048 3.4277778 0.238286 3.4305556 0.235238 3.4333333 0.235238 3.4361111 0.235238 3.4388889 0.236000 3.4416667 0.235238 3.4444444 0.231429 3.4472222 0.232190 3.4500000 0.231429 3.4527778 0.233714 3.4555556 0.232190 3.4583333 0.228381 3.4611111 0.230667 3.4638889 0.229905 3.4666667 0.232952 3.4694444 0.233714 3.4722222 0.235238 3.4750000 0.234476 3.4777778 0.232190 3.4805556 0.231429 3.4833333 0.232190 3.4861111 0.234476 3.4888889 0.236000 3.4916667 0.237524 3.4944444 0.235238 3.4972222 0.236000 3.5000000 0.238286 3.5027778 0.242095 3.5085556 0.300000 3.7414444 0.300000 3.7444444 0.248190 3.7472222 0.248190 3.7500000 0.248190 3.7527778 0.250476 3.7555556 0.250476 3.7583333 0.250476 3.7611111 0.247429 3.7638889 0.246667 3.7666667 0.248190 3.7694444 0.249714 3.7722222 0.251238 3.7750000 0.252762 3.7777778 0.253524 3.7805556 0.253524 3.7833333 0.258095 3.7861111 0.258857 3.7888889 0.261143 3.7916667 0.260381 3.7944444 0.259619 3.7972222 0.260381 3.8000000 0.261905 3.8027778 0.264190 3.8055556 0.264190 3.8083333 0.266476 3.8111111 0.264190 3.8138889 0.264190 3.8166667 0.266476 3.8194444 0.264952 3.8222222 0.265714 3.8250000 0.264190 3.8277778 0.262667 3.8305556 0.261143 3.8333333 0.263429 3.8361111 0.264952 3.8388889 0.264952 3.8416667 0.261905 3.8444444 0.261143 3.8472222 0.261905 3.8500000 0.264952 3.8527778 0.268762 3.8555556 0.270286 3.8583333 0.268000 3.8611111 0.264952 3.8638889 0.258857 3.8666667 0.258857 3.8694444 0.256571 3.8722222 0.256571 3.8750000 0.252762 3.8777778 0.249714 3.8805556 0.248190 3.8833333 0.248190 3.8861111 0.247429 3.8888889 0.246667 3.8916667 0.246667 3.8944444 0.248190 3.8972222 0.245905 3.9000000 0.247429 3.9027778 0.248190 3.9055556 0.248190 3.9083333 0.247429 3.9111111 0.245905 3.9138889 0.243619 3.9166667 0.245905 3.9194444 0.243619 3.9222222 0.247429 3.9250000 0.248190 3.9277778 0.245143 3.9305556 0.242095 3.9333333 0.245143 3.9361111 0.247429 3.9388889 0.246667 3.9416667 0.246667 3.9444444 0.245905 3.9472222 0.242095 3.9500000 0.240571 3.9527778 0.239810 3.9555556 0.235238 3.9583333 0.230667 3.9611111 0.227619 3.9638889 0.222286 3.9666667 0.216952 3.9694444 0.217714 3.9722222 0.224571 3.9750000 0.238286 3.9777778 0.255048 3.9805556 0.275619 3.9833333 0.306095 3.9861111 0.348000 3.9888889 0.390667 3.9916667 0.421905 3.9944444 0.434857 3.9972222 0.421143 4.0000000 0.379238 4.0027778 0.319810 4.0055556 0.267238 4.0083333 0.235238 4.0111111 0.223810 4.0138889 0.225333 4.0166667 0.231429 4.0194444 0.239048 4.0222222 0.240571 4.0250000 0.239810 4.0277778 0.239810 4.0305556 0.239048 4.0333333 0.240571 4.0361111 0.242095 4.0388889 0.241333 4.0416667 0.241333 4.0444444 0.239048 4.0472222 0.237524 4.0500000 0.237524 4.0527778 0.240571 4.0555556 0.240571 4.0583333 0.238286 4.0611111 0.238286 4.0638889 0.236762 4.0666667 0.237524 4.0694444 0.239810 4.0722222 0.239810 4.0750000 0.239048 4.0777778 0.236762 4.0805556 0.236762 4.0833333 0.236762 4.0861111 0.239048 4.0888889 0.240571 4.0916667 0.240571 4.0944444 0.237524 4.0972222 0.236762 4.1000000 0.238286 4.1027778 0.239810 4.1055556 0.239810 4.1083333 0.239810 4.1111111 0.238286 4.1138889 0.237524 4.1166667 0.237524 4.1194444 0.239048 4.1222222 0.240571 4.1250000 0.239810 4.1277778 0.237524 4.1305556 0.235238 4.1333333 0.236762 4.1361111 0.238286 4.1388889 0.237524 4.1416667 0.238286 4.1444444 0.236762 4.1472222 0.235238 4.1500000 0.235238 4.1527778 0.237524 4.1555556 0.239810 4.1583333 0.240571 4.1611111 0.239048 4.1638889 0.237524 4.1666667 0.237524 4.1694444 0.239048 4.1722222 0.240571 4.1750000 0.237524 4.1777778 0.236000 4.1805556 0.236000 4.1833333 0.236762 4.1861111 0.236762 4.1888889 0.238286 4.1916667 0.236000 4.1944444 0.236762 4.1972222 0.235238 4.2000000 0.237524 4.2027778 0.239048 4.2055556 0.238286 4.2083333 0.239048 4.2111111 0.239048 4.2138889 0.237524 4.2166667 0.239048 4.2194444 0.239810 4.2222222 0.239810 4.2250000 0.238286 4.2277778 0.237524 4.2305556 0.235238 4.2333333 0.235238 4.2361111 0.237524 4.2388889 0.237524 4.2416667 0.236000 4.2444444 0.234476 4.2472222 0.232190 4.2500000 0.232952 4.2527778 0.233714 4.2555556 0.234476 4.2583333 0.234476 4.2611111 0.231429 4.2638889 0.232190 4.2666667 0.232190 4.2694444 0.233714 4.2722222 0.233714 4.2750000 0.232190 4.2777778 0.232952 4.2805556 0.231429 4.2833333 0.234476 4.2861111 0.234476 4.2888889 0.236762 4.2916667 0.239048 4.2974444 0.300000 4.5581111 0.300000 4.5611111 0.249714 4.5638889 0.249714 4.5666667 0.250476 4.5694444 0.252000 4.5722222 0.252000 4.5750000 0.252000 4.5777778 0.249714 4.5805556 0.249714 4.5833333 0.251238 4.5861111 0.252000 4.5888889 0.253524 4.5916667 0.253524 4.5944444 0.255048 4.5972222 0.252000 4.6000000 0.254286 4.6027778 0.258095 4.6055556 0.261143 4.6083333 0.261143 4.6111111 0.260381 4.6138889 0.259619 4.6166667 0.261143 4.6194444 0.264190 4.6222222 0.264952 4.6250000 0.265714 4.6277778 0.266476 4.6305556 0.266476 4.6333333 0.267238 4.6361111 0.269524 4.6388889 0.268762 4.6416667 0.268762 4.6444444 0.265714 4.6472222 0.264190 4.6500000 0.263429 4.6527778 0.264952 4.6555556 0.267238 4.6583333 0.263429 4.6611111 0.263429 4.6638889 0.261905 4.6666667 0.264190 4.6694444 0.268000 4.6722222 0.269524 4.6750000 0.266476 4.6777778 0.261143 4.6805556 0.258095 4.6833333 0.256571 4.6861111 0.254286 4.6888889 0.253524 4.6916667 0.251238 4.6944444 0.249714 4.6972222 0.250476 4.7000000 0.251238 4.7027778 0.249714 4.7055556 0.249714 4.7083333 0.248952 4.7111111 0.248190 4.7138889 0.247429 4.7166667 0.248190 4.7194444 0.248952 4.7222222 0.251238 4.7250000 0.250476 4.7277778 0.248952 4.7305556 0.247429 4.7333333 0.247429 4.7361111 0.247429 4.7388889 0.248952 4.7416667 0.248190 4.7444444 0.247429 4.7472222 0.245905 4.7500000 0.248190 4.7527778 0.248190 4.7555556 0.248190 4.7583333 0.248190 4.7611111 0.247429 4.7638889 0.245905 4.7666667 0.244381 4.7694444 0.243619 4.7722222 0.238286 4.7750000 0.232190 4.7777778 0.226857 4.7805556 0.224571 4.7833333 0.220762 4.7861111 0.218476 4.7888889 0.223048 4.7916667 0.236762 4.7944444 0.257333 4.7972222 0.279429 4.8000000 0.309905 4.8027778 0.345714 4.8055556 0.388381 4.8083333 0.423429 4.8111111 0.444000 4.8138889 0.440190 4.8166667 0.418095 4.8194444 0.367810 4.8222222 0.303048 4.8250000 0.255048 4.8277778 0.232190 4.8305556 0.228381 4.8333333 0.235238 4.8361111 0.242095 4.8388889 0.245143 4.8416667 0.245143 4.8444444 0.243619 4.8472222 0.242095 4.8500000 0.242095 4.8527778 0.242857 4.8555556 0.243619 4.8583333 0.244381 4.8611111 0.243619 4.8638889 0.241333 4.8666667 0.241333 4.8694444 0.242857 4.8722222 0.243619 4.8750000 0.243619 4.8777778 0.241333 4.8805556 0.239810 4.8833333 0.241333 4.8861111 0.241333 4.8888889 0.240571 4.8916667 0.241333 4.8944444 0.239810 4.8972222 0.237524 4.9000000 0.239048 4.9027778 0.239810 4.9055556 0.242095 4.9083333 0.239810 4.9111111 0.239810 4.9138889 0.239048 4.9166667 0.239048 4.9194444 0.239810 4.9222222 0.240571 4.9250000 0.240571 4.9277778 0.239810 4.9305556 0.238286 4.9333333 0.240571 4.9361111 0.241333 4.9388889 0.242857 4.9416667 0.242857 4.9444444 0.242095 4.9472222 0.240571 4.9500000 0.241333 4.9527778 0.243619 4.9555556 0.243619 4.9583333 0.243619 4.9611111 0.242857 4.9638889 0.241333 4.9666667 0.243619 4.9694444 0.240571 4.9722222 0.242857 4.9750000 0.243619 4.9777778 0.242095 4.9805556 0.240571 4.9833333 0.240571 4.9861111 0.241333 4.9888889 0.242857 4.9916667 0.242857 4.9944444 0.241333 4.9972222 0.239810 5.0000000 0.240571 5.0027778 0.241333 5.0055556 0.242857 5.0083333 0.242095 5.0111111 0.241333 5.0138889 0.240571 5.0166667 0.242095 5.0194444 0.242095 5.0222222 0.243619 5.0250000 0.243619 5.0277778 0.244381 5.0305556 0.240571 5.0333333 0.244381 5.0361111 0.244381 5.0388889 0.245143 5.0416667 0.242857 5.0444444 0.242095 5.0472222 0.239048 5.0500000 0.240571 5.0527778 0.242857 5.0555556 0.242857 5.0583333 0.243619 5.0611111 0.241333 5.0638889 0.240571 5.0666667 0.240571 5.0694444 0.240571 5.0722222 0.240571 5.0750000 0.242857 5.0777778 0.241333 5.0805556 0.239810 5.0833333 0.242095 5.0861111 0.243619 5.0888889 0.242857 5.0916667 0.242857 5.0944444 0.240571 5.0972222 0.238286 5.1000000 0.242857 5.1027778 0.243619 5.1055556 0.245143 5.1083333 0.242857 5.1141111 0.300000 5.2108889 0.300000 5.2138889 0.255048 5.2166667 0.256571 5.2194444 0.257333 5.2222222 0.258095 5.2250000 0.257333 5.2277778 0.255810 5.2305556 0.252762 5.2333333 0.253524 5.2361111 0.256571 5.2388889 0.258857 5.2416667 0.258857 5.2444444 0.258095 5.2472222 0.256571 5.2500000 0.256571 5.2527778 0.258857 5.2555556 0.259619 5.2583333 0.259619 5.2611111 0.259619 5.2638889 0.257333 5.2666667 0.259619 5.2694444 0.262667 5.2722222 0.264190 5.2750000 0.264190 5.2777778 0.261905 5.2805556 0.261905 5.2833333 0.262667 5.2861111 0.267238 5.2888889 0.266476 5.2916667 0.262667 5.2944444 0.261143 5.2972222 0.264952 5.3000000 0.268762 5.3027778 0.268000 5.3055556 0.266476 5.3083333 0.264952 5.3111111 0.263429 5.3138889 0.263429 5.3166667 0.262667 5.3194444 0.261905 5.3222222 0.258857 5.3250000 0.256571 5.3277778 0.252000 5.3305556 0.251238 5.3333333 0.251238 5.3361111 0.252762 5.3388889 0.249714 5.3416667 0.248190 5.3444444 0.247429 5.3472222 0.245143 5.3500000 0.244381 5.3527778 0.245143 5.3555556 0.246667 5.3583333 0.245905 5.3611111 0.242857 5.3638889 0.241333 5.3666667 0.242857 5.3694444 0.243619 5.3722222 0.244381 5.3750000 0.244381 5.3777778 0.243619 5.3805556 0.242095 5.3833333 0.245143 5.3861111 0.246667 5.3888889 0.245905 5.3916667 0.245905 5.3944444 0.246667 5.3972222 0.244381 5.4000000 0.246667 5.4027778 0.246667 5.4055556 0.248190 5.4083333 0.245905 5.4111111 0.246667 5.4138889 0.242857 5.4166667 0.244381 5.4194444 0.242857 5.4222222 0.239048 5.4250000 0.234476 5.4277778 0.227619 5.4305556 0.220762 5.4333333 0.220762 5.4361111 0.216190 5.4388889 0.213143 5.4416667 0.217714 5.4444444 0.232190 5.4472222 0.253524 5.4500000 0.278667 5.4527778 0.303810 5.4555556 0.339619 5.4583333 0.377714 5.4611111 0.412000 5.4638889 0.428762 5.4666667 0.433333 5.4694444 0.412000 5.4722222 0.360952 5.4750000 0.296190 5.4777778 0.248952 5.4805556 0.226857 5.4833333 0.228381 5.4861111 0.236762 5.4888889 0.242857 5.4916667 0.244381 5.4944444 0.241333 5.4972222 0.239048 5.5000000 0.242095 5.5027778 0.240571 5.5055556 0.242857 5.5083333 0.241333 5.5111111 0.239810 5.5138889 0.238286 5.5166667 0.240571 5.5194444 0.242095 5.5222222 0.241333 5.5250000 0.241333 5.5277778 0.239810 5.5305556 0.239048 5.5333333 0.238286 5.5361111 0.239048 5.5388889 0.240571 5.5416667 0.240571 5.5444444 0.239810 5.5472222 0.239048 5.5500000 0.240571 5.5527778 0.241333 5.5555556 0.240571 5.5583333 0.241333 5.5611111 0.237524 5.5638889 0.236000 5.5666667 0.238286 5.5694444 0.237524 5.5722222 0.240571 5.5750000 0.240571 5.5777778 0.240571 5.5805556 0.239048 5.5833333 0.239048 5.5861111 0.240571 5.5888889 0.242857 5.5916667 0.242095 5.5944444 0.239810 5.5972222 0.239048 5.6000000 0.240571 5.6027778 0.239048 5.6055556 0.240571 5.6083333 0.239810 5.6111111 0.237524 5.6138889 0.236762 5.6166667 0.238286 5.6194444 0.241333 5.6222222 0.241333 5.6250000 0.242095 5.6277778 0.239048 5.6305556 0.239048 5.6333333 0.239810 5.6361111 0.240571 5.6388889 0.242095 5.6416667 0.242857 5.6444444 0.239810 5.6472222 0.239810 5.6500000 0.241333 5.6527778 0.242095 5.6555556 0.242857 5.6583333 0.241333 5.6611111 0.240571 5.6638889 0.239048 5.6666667 0.239048 5.6694444 0.241333 5.6722222 0.242095 5.6750000 0.239810 5.6777778 0.240571 5.6805556 0.239048 5.6833333 0.239810 5.6861111 0.241333 5.6888889 0.242095 5.6916667 0.241333 5.6944444 0.239810 5.6972222 0.238286 5.7000000 0.239048 5.7027778 0.240571 5.7055556 0.242095 5.7083333 0.242095 5.7111111 0.241333 5.7138889 0.238286 5.7166667 0.239810 5.7194444 0.239048 5.7222222 0.240571 5.7250000 0.239048 5.7277778 0.238286 5.7305556 0.235238 5.7333333 0.236000 5.7361111 0.238286 5.7388889 0.239048 5.7416667 0.238286 5.7444444 0.238286 5.7472222 0.236762 5.7500000 0.239048 5.7527778 0.240571 5.7555556 0.242095 5.7583333 0.241333 5.7611111 0.239810 5.7668889 0.300000 6.2053333 0.300000 6.2083333 0.247429 6.2111111 0.245905 6.2138889 0.245143 6.2166667 0.245143 6.2194444 0.244381 6.2222222 0.247429 6.2250000 0.245905 6.2277778 0.246667 6.2305556 0.245143 6.2333333 0.245905 6.2361111 0.245143 6.2388889 0.247429 6.2416667 0.248952 6.2444444 0.249714 6.2472222 0.249714 6.2500000 0.252762 6.2527778 0.253524 6.2555556 0.254286 6.2583333 0.253524 6.2611111 0.255048 6.2638889 0.253524 6.2666667 0.256571 6.2694444 0.258095 6.2722222 0.259619 6.2750000 0.261143 6.2777778 0.261143 6.2805556 0.260381 6.2833333 0.259619 6.2861111 0.261143 6.2888889 0.261143 6.2916667 0.260381 6.2944444 0.257333 6.2972222 0.255810 6.3000000 0.257333 6.3027778 0.258857 6.3055556 0.261143 6.3083333 0.258095 6.3111111 0.255810 6.3138889 0.251238 6.3166667 0.254286 6.3194444 0.255048 6.3222222 0.258857 6.3250000 0.259619 6.3277778 0.258857 6.3305556 0.256571 6.3333333 0.254286 6.3361111 0.252762 6.3388889 0.252000 6.3416667 0.251238 6.3444444 0.246667 6.3472222 0.243619 6.3500000 0.244381 6.3527778 0.244381 6.3555556 0.244381 6.3583333 0.243619 6.3611111 0.243619 6.3638889 0.243619 6.3666667 0.242095 6.3694444 0.245143 6.3722222 0.242857 6.3750000 0.242857 6.3777778 0.239048 6.3805556 0.236000 6.3833333 0.238286 6.3861111 0.239048 6.3888889 0.241333 6.3916667 0.242095 6.3944444 0.239048 6.3972222 0.236762 6.4000000 0.238286 6.4027778 0.239810 6.4055556 0.239810 6.4083333 0.239810 6.4111111 0.237524 6.4138889 0.234476 6.4166667 0.232952 6.4194444 0.230667 6.4222222 0.225333 6.4250000 0.226095 6.4277778 0.220762 6.4305556 0.213143 6.4333333 0.212381 6.4361111 0.220000 6.4388889 0.236000 6.4416667 0.253524 6.4444444 0.271048 6.4472222 0.296952 6.4500000 0.333524 6.4527778 0.373905 6.4555556 0.408952 6.4583333 0.428762 6.4611111 0.434857 6.4638889 0.420381 6.4666667 0.385333 6.4694444 0.334286 6.4722222 0.289333 6.4750000 0.256571 6.4777778 0.235238 6.4805556 0.223810 6.4833333 0.216190 6.4861111 0.218476 6.4888889 0.223810 6.4916667 0.229143 6.4944444 0.231429 6.4972222 0.231429 6.5000000 0.233714 6.5027778 0.236000 6.5055556 0.237524 6.5083333 0.237524 6.5111111 0.236762 6.5138889 0.236000 6.5166667 0.235238 6.5194444 0.236000 6.5222222 0.234476 6.5250000 0.234476 6.5277778 0.232952 6.5305556 0.231429 6.5333333 0.231429 6.5361111 0.234476 6.5388889 0.234476 6.5416667 0.234476 6.5444444 0.232190 6.5472222 0.232190 6.5500000 0.232952 6.5527778 0.235238 6.5555556 0.234476 6.5583333 0.234476 6.5611111 0.235238 6.5638889 0.232190 6.5666667 0.232190 6.5694444 0.234476 6.5722222 0.233714 6.5750000 0.233714 6.5777778 0.232190 6.5805556 0.232190 6.5833333 0.233714 6.5861111 0.234476 6.5888889 0.235238 6.5916667 0.234476 6.5944444 0.234476 6.5972222 0.232952 6.6000000 0.236000 6.6027778 0.234476 6.6055556 0.235238 6.6083333 0.234476 6.6111111 0.232952 6.6138889 0.232952 6.6166667 0.234476 6.6194444 0.234476 6.6222222 0.236762 6.6250000 0.235238 6.6277778 0.234476 6.6305556 0.230667 6.6333333 0.232190 6.6361111 0.232190 6.6388889 0.234476 6.6416667 0.234476 6.6444444 0.232952 6.6472222 0.232952 6.6500000 0.233714 6.6527778 0.234476 6.6555556 0.236762 6.6583333 0.236762 6.6611111 0.235238 6.6638889 0.235238 6.6666667 0.236000 6.6694444 0.238286 6.6722222 0.238286 6.6750000 0.236762 6.6777778 0.236762 6.6805556 0.235238 6.6833333 0.234476 6.6861111 0.238286 6.6888889 0.238286 6.6916667 0.238286 6.6944444 0.238286 6.6972222 0.234476 6.7000000 0.236762 6.7027778 0.237524 6.7055556 0.236762 6.7083333 0.234476 6.7111111 0.232190 6.7138889 0.229143 6.7166667 0.229905 6.7194444 0.231429 6.7222222 0.230667 6.7250000 0.229905 6.7277778 0.229143 6.7305556 0.226095 6.7333333 0.224571 6.7361111 0.227619 6.7388889 0.225333 6.7416667 0.223810 6.7444444 0.224571 6.7472222 0.221524 6.7500000 0.223810 6.7527778 0.226095 6.7555556 0.225333 6.7613333 0.300000 7.0497778 0.300000 7.0527778 0.245905 7.0555556 0.248190 7.0583333 0.247429 7.0611111 0.245905 7.0638889 0.245905 7.0666667 0.245905 7.0694444 0.248190 7.0722222 0.248190 7.0750000 0.247429 7.0777778 0.244381 7.0805556 0.243619 7.0833333 0.246667 7.0861111 0.249714 7.0888889 0.251238 7.0916667 0.252000 7.0944444 0.255048 7.0972222 0.253524 7.1000000 0.255048 7.1027778 0.254286 7.1055556 0.256571 7.1083333 0.258095 7.1111111 0.260381 7.1138889 0.258095 7.1166667 0.259619 7.1194444 0.260381 7.1222222 0.261905 7.1250000 0.262667 7.1277778 0.261143 7.1305556 0.259619 7.1333333 0.260381 7.1361111 0.260381 7.1388889 0.261905 7.1416667 0.260381 7.1444444 0.257333 7.1472222 0.257333 7.1500000 0.258095 7.1527778 0.256571 7.1555556 0.257333 7.1583333 0.261143 7.1611111 0.262667 7.1638889 0.262667 7.1666667 0.260381 7.1694444 0.256571 7.1722222 0.255810 7.1750000 0.254286 7.1777778 0.251238 7.1805556 0.248952 7.1833333 0.245905 7.1861111 0.246667 7.1888889 0.245905 7.1916667 0.245905 7.1944444 0.242857 7.1972222 0.241333 7.2000000 0.242095 7.2027778 0.245143 7.2055556 0.246667 7.2083333 0.245143 7.2111111 0.244381 7.2138889 0.243619 7.2166667 0.243619 7.2194444 0.244381 7.2222222 0.245143 7.2250000 0.244381 7.2277778 0.243619 7.2305556 0.241333 7.2333333 0.241333 7.2361111 0.244381 7.2388889 0.245143 7.2416667 0.242095 7.2444444 0.241333 7.2472222 0.239810 7.2500000 0.239810 7.2527778 0.241333 7.2555556 0.242095 7.2583333 0.239810 7.2611111 0.235238 7.2638889 0.229143 7.2666667 0.223810 7.2694444 0.221524 7.2722222 0.219238 7.2750000 0.214667 7.2777778 0.210857 7.2805556 0.219238 7.2833333 0.237524 7.2861111 0.261143 7.2888889 0.284000 7.2916667 0.316000 7.2944444 0.354095 7.2972222 0.391429 7.3000000 0.423429 7.3027778 0.435619 7.3055556 0.426476 7.3083333 0.388381 7.3111111 0.328190 7.3138889 0.268762 7.3166667 0.231429 7.3194444 0.220000 7.3222222 0.224571 7.3250000 0.229143 7.3277778 0.233714 7.3305556 0.236762 7.3333333 0.236762 7.3361111 0.236762 7.3388889 0.239048 7.3416667 0.239810 7.3444444 0.238286 7.3472222 0.235238 7.3500000 0.233714 7.3527778 0.236762 7.3555556 0.236762 7.3583333 0.236762 7.3611111 0.236762 7.3638889 0.234476 7.3666667 0.236000 7.3694444 0.237524 7.3722222 0.238286 7.3750000 0.236000 7.3777778 0.237524 7.3805556 0.236000 7.3833333 0.239048 7.3861111 0.239810 7.3888889 0.241333 7.3916667 0.239048 7.3944444 0.239048 7.3972222 0.239048 7.4000000 0.239048 7.4027778 0.239810 7.4055556 0.239048 7.4083333 0.239048 7.4111111 0.239048 7.4138889 0.237524 7.4166667 0.239810 7.4194444 0.237524 7.4222222 0.239048 7.4250000 0.239810 7.4277778 0.238286 7.4305556 0.237524 7.4333333 0.236762 7.4361111 0.238286 7.4388889 0.239048 7.4416667 0.239810 7.4444444 0.238286 7.4472222 0.236762 7.4500000 0.238286 7.4527778 0.236762 7.4555556 0.237524 7.4583333 0.238286 7.4611111 0.238286 7.4638889 0.237524 7.4666667 0.238286 7.4694444 0.239048 7.4722222 0.239810 7.4750000 0.238286 7.4777778 0.238286 7.4805556 0.239048 7.4833333 0.239810 7.4861111 0.240571 7.4888889 0.239810 7.4916667 0.240571 7.4944444 0.239810 7.4972222 0.236000 7.5000000 0.236762 7.5027778 0.238286 7.5055556 0.239048 7.5083333 0.239048 7.5111111 0.236762 7.5138889 0.236000 7.5166667 0.237524 7.5194444 0.239810 7.5222222 0.239048 7.5250000 0.238286 7.5277778 0.236762 7.5305556 0.233714 7.5333333 0.236762 7.5361111 0.236762 7.5388889 0.239048 7.5416667 0.238286 7.5444444 0.236000 7.5472222 0.234476 7.5500000 0.235238 7.5527778 0.237524 7.5555556 0.237524 7.5583333 0.238286 7.5611111 0.236762 7.5638889 0.235238 7.5666667 0.235238 7.5694444 0.236000 7.5722222 0.237524 7.5750000 0.237524 7.5777778 0.236000 7.5805556 0.234476 7.5833333 0.235238 7.5861111 0.236000 7.5888889 0.238286 7.5916667 0.236762 7.5944444 0.237524 7.5972222 0.237524 7.6000000 0.241333 7.6057778 0.300000 7.8608889 0.300000 7.8638889 0.248952 7.8666667 0.251238 7.8694444 0.250476 7.8722222 0.252000 7.8750000 0.251238 7.8777778 0.251238 7.8805556 0.247429 7.8833333 0.248952 7.8861111 0.251238 7.8888889 0.252762 7.8916667 0.251238 7.8944444 0.251238 7.8972222 0.248190 7.9000000 0.249714 7.9027778 0.251238 7.9055556 0.252762 7.9083333 0.252762 7.9111111 0.252762 7.9138889 0.255048 7.9166667 0.257333 7.9194444 0.261143 7.9222222 0.261905 7.9250000 0.261905 7.9277778 0.261143 7.9305556 0.260381 7.9333333 0.263429 7.9361111 0.266476 7.9388889 0.264952 7.9416667 0.264952 7.9444444 0.267238 7.9472222 0.266476 7.9500000 0.265714 7.9527778 0.264952 7.9555556 0.264952 7.9583333 0.264190 7.9611111 0.262667 7.9638889 0.261143 7.9666667 0.263429 7.9694444 0.264190 7.9722222 0.262667 7.9750000 0.264190 7.9777778 0.264952 7.9805556 0.266476 7.9833333 0.270286 7.9861111 0.266476 7.9888889 0.262667 7.9916667 0.260381 7.9944444 0.258857 7.9972222 0.255810 8.0000000 0.254286 8.0027778 0.253524 8.0055556 0.253524 8.0083333 0.251238 8.0111111 0.249714 8.0138889 0.246667 8.0166667 0.246667 8.0194444 0.248952 8.0222222 0.248952 8.0250000 0.248952 8.0277778 0.248190 8.0305556 0.246667 8.0333333 0.246667 8.0361111 0.247429 8.0388889 0.248952 8.0416667 0.247429 8.0444444 0.245905 8.0472222 0.243619 8.0500000 0.246667 8.0527778 0.247429 8.0555556 0.248952 8.0583333 0.248952 8.0611111 0.248952 8.0638889 0.245905 8.0666667 0.245905 8.0694444 0.247429 8.0722222 0.245905 8.0750000 0.239810 8.0777778 0.231429 8.0805556 0.226857 8.0833333 0.223048 8.0861111 0.220000 8.0888889 0.216952 8.0916667 0.223810 8.0944444 0.239810 8.0972222 0.261143 8.1000000 0.289333 8.1027778 0.322095 8.1055556 0.364762 8.1083333 0.404381 8.1111111 0.433333 8.1138889 0.440952 8.1166667 0.421143 8.1194444 0.371619 8.1222222 0.303048 8.1250000 0.250476 8.1277778 0.228381 8.1305556 0.226095 8.1333333 0.237524 8.1361111 0.244381 8.1388889 0.245905 8.1416667 0.244381 8.1444444 0.242095 8.1472222 0.241333 8.1500000 0.242095 8.1527778 0.243619 8.1555556 0.243619 8.1583333 0.242857 8.1611111 0.241333 8.1638889 0.239810 8.1666667 0.241333 8.1694444 0.242095 8.1722222 0.241333 8.1750000 0.242857 8.1777778 0.240571 8.1805556 0.238286 8.1833333 0.238286 8.1861111 0.240571 8.1888889 0.241333 8.1916667 0.241333 8.1944444 0.240571 8.1972222 0.237524 8.2000000 0.239048 8.2027778 0.240571 8.2055556 0.241333 8.2083333 0.241333 8.2111111 0.239810 8.2138889 0.240571 8.2166667 0.239810 8.2194444 0.242095 8.2222222 0.242857 8.2250000 0.242095 8.2277778 0.241333 8.2305556 0.239048 8.2333333 0.241333 8.2361111 0.242095 8.2388889 0.242857 8.2416667 0.242095 8.2444444 0.239810 8.2472222 0.239810 8.2500000 0.241333 8.2527778 0.242857 8.2555556 0.243619 8.2583333 0.244381 8.2611111 0.241333 8.2638889 0.239810 8.2666667 0.241333 8.2694444 0.241333 8.2722222 0.243619 8.2750000 0.242857 8.2777778 0.243619 8.2805556 0.242857 8.2833333 0.242857 8.2861111 0.243619 8.2888889 0.245905 8.2916667 0.244381 8.2944444 0.242095 8.2972222 0.242857 8.3000000 0.243619 8.3027778 0.242095 8.3055556 0.244381 8.3083333 0.243619 8.3111111 0.242857 8.3138889 0.240571 8.3166667 0.242095 8.3194444 0.242857 8.3222222 0.242095 8.3250000 0.243619 8.3277778 0.242857 8.3305556 0.242095 8.3333333 0.241333 8.3361111 0.241333 8.3388889 0.243619 8.3416667 0.242857 8.3444444 0.242857 8.3472222 0.242095 8.3500000 0.242095 8.3527778 0.242095 8.3555556 0.242095 8.3583333 0.242857 8.3611111 0.240571 8.3638889 0.239810 8.3666667 0.241333 8.3694444 0.241333 8.3722222 0.242857 8.3750000 0.242857 8.3777778 0.241333 8.3805556 0.241333 8.3833333 0.240571 8.3861111 0.243619 8.3888889 0.244381 8.3916667 0.244381 8.3944444 0.242857 8.3972222 0.241333 8.4000000 0.246667 8.4027778 0.247429 8.4055556 0.250476 8.4083333 0.250476 8.4111111 0.249714 8.4168889 0.300000 8.6497778 0.300000 8.6527778 0.253524 8.6555556 0.255810 8.6583333 0.256571 8.6611111 0.255810 8.6638889 0.253524 8.6666667 0.252762 8.6694444 0.254286 8.6722222 0.254286 8.6750000 0.252762 8.6777778 0.252000 8.6805556 0.252000 8.6833333 0.252762 8.6861111 0.255048 8.6888889 0.254286 8.6916667 0.255048 8.6944444 0.252000 8.6972222 0.252762 8.7000000 0.255810 8.7027778 0.259619 8.7055556 0.263429 8.7083333 0.261143 8.7111111 0.263429 8.7138889 0.261905 8.7166667 0.265714 8.7194444 0.265714 8.7222222 0.267238 8.7250000 0.268000 8.7277778 0.269524 8.7305556 0.270286 8.7333333 0.270286 8.7361111 0.272571 8.7388889 0.273333 8.7416667 0.272571 8.7444444 0.268762 8.7472222 0.267238 8.7500000 0.268000 8.7527778 0.268000 8.7555556 0.268000 8.7583333 0.268000 8.7611111 0.267238 8.7638889 0.265714 8.7666667 0.268000 8.7694444 0.272571 8.7722222 0.274095 8.7750000 0.271810 8.7777778 0.263429 8.7805556 0.261143 8.7833333 0.261143 8.7861111 0.258857 8.7888889 0.258095 8.7916667 0.256571 8.7944444 0.254286 8.7972222 0.254286 8.8000000 0.252000 8.8027778 0.253524 8.8055556 0.254286 8.8083333 0.255048 8.8111111 0.254286 8.8138889 0.252000 8.8166667 0.252762 8.8194444 0.252762 8.8222222 0.254286 8.8250000 0.254286 8.8277778 0.253524 8.8305556 0.252000 8.8333333 0.250476 8.8361111 0.251238 8.8388889 0.251238 8.8416667 0.251238 8.8444444 0.250476 8.8472222 0.248190 8.8500000 0.248952 8.8527778 0.250476 8.8555556 0.252000 8.8583333 0.251238 8.8611111 0.247429 8.8638889 0.243619 8.8666667 0.239810 8.8694444 0.235238 8.8722222 0.232190 8.8750000 0.229143 8.8777778 0.222286 8.8805556 0.219238 8.8833333 0.226095 8.8861111 0.243619 8.8888889 0.264190 8.8916667 0.286286 8.8944444 0.316000 8.8972222 0.357143 8.9000000 0.399810 8.9027778 0.424952 8.9055556 0.431810 8.9083333 0.412000 8.9111111 0.368571 8.9138889 0.309143 8.9166667 0.258857 8.9194444 0.234476 8.9222222 0.229905 8.9250000 0.236762 8.9277778 0.241333 8.9305556 0.244381 8.9333333 0.245905 8.9361111 0.245905 8.9388889 0.247429 8.9416667 0.246667 8.9444444 0.246667 8.9472222 0.245143 8.9500000 0.247429 8.9527778 0.248190 8.9555556 0.248190 8.9583333 0.248952 8.9611111 0.248952 8.9638889 0.245905 8.9666667 0.247429 8.9694444 0.248190 8.9722222 0.248952 8.9750000 0.248190 8.9777778 0.246667 8.9805556 0.244381 8.9833333 0.245143 8.9861111 0.244381 8.9888889 0.246667 8.9916667 0.247429 8.9944444 0.244381 8.9972222 0.245143 9.0000000 0.246667 9.0027778 0.245905 9.0055556 0.246667 9.0083333 0.245905 9.0111111 0.246667 9.0138889 0.245143 9.0166667 0.248952 9.0194444 0.248952 9.0222222 0.249714 9.0250000 0.248190 9.0277778 0.246667 9.0305556 0.246667 9.0333333 0.247429 9.0361111 0.248952 9.0388889 0.247429 9.0416667 0.245905 9.0444444 0.245905 9.0472222 0.243619 9.0500000 0.245905 9.0527778 0.246667 9.0555556 0.247429 9.0583333 0.244381 9.0611111 0.244381 9.0638889 0.243619 9.0666667 0.244381 9.0694444 0.245905 9.0722222 0.247429 9.0750000 0.247429 9.0777778 0.247429 9.0805556 0.248190 9.0833333 0.248952 9.0861111 0.250476 9.0888889 0.248952 9.0916667 0.247429 9.0944444 0.246667 9.0972222 0.246667 9.1000000 0.245905 9.1027778 0.245905 9.1055556 0.245143 9.1083333 0.246667 9.1111111 0.245143 9.1138889 0.244381 9.1166667 0.247429 9.1194444 0.247429 9.1222222 0.249714 9.1250000 0.246667 9.1277778 0.247429 9.1305556 0.245905 9.1333333 0.246667 9.1361111 0.248190 9.1388889 0.248952 9.1416667 0.246667 9.1444444 0.244381 9.1472222 0.242095 9.1500000 0.241333 9.1527778 0.245905 9.1555556 0.245143 9.1583333 0.245905 9.1611111 0.243619 9.1638889 0.241333 9.1666667 0.243619 9.1694444 0.243619 9.1722222 0.246667 9.1750000 0.247429 9.1777778 0.244381 9.1805556 0.244381 9.1833333 0.245143 9.1861111 0.247429 9.1888889 0.249714 9.1916667 0.249714 9.1944444 0.249714 9.1972222 0.248952 9.2000000 0.252000 9.2057778 0.300000 9.4220000 0.300000 9.4250000 0.253524 9.4277778 0.252762 9.4305556 0.251238 9.4333333 0.252762 9.4361111 0.254286 9.4388889 0.255048 9.4416667 0.254286 9.4444444 0.252000 9.4472222 0.250476 9.4500000 0.250476 9.4527778 0.253524 9.4555556 0.252762 9.4583333 0.255810 9.4611111 0.252000 9.4638889 0.250476 9.4666667 0.251238 9.4694444 0.255810 9.4722222 0.257333 9.4750000 0.260381 9.4777778 0.260381 9.4805556 0.259619 9.4833333 0.260381 9.4861111 0.261905 9.4888889 0.264952 9.4916667 0.266476 9.4944444 0.266476 9.4972222 0.264190 9.5000000 0.266476 9.5027778 0.268762 9.5055556 0.268762 9.5083333 0.268000 9.5111111 0.268000 9.5138889 0.264952 9.5166667 0.263429 9.5194444 0.264952 9.5222222 0.265714 9.5250000 0.264190 9.5277778 0.261905 9.5305556 0.259619 9.5333333 0.260381 9.5361111 0.262667 9.5388889 0.267238 9.5416667 0.267238 9.5444444 0.262667 9.5472222 0.257333 9.5500000 0.258095 9.5527778 0.258095 9.5555556 0.255048 9.5583333 0.252762 9.5611111 0.250476 9.5638889 0.248190 9.5666667 0.248190 9.5694444 0.250476 9.5722222 0.252000 9.5750000 0.252762 9.5777778 0.252000 9.5805556 0.249714 9.5833333 0.249714 9.5861111 0.250476 9.5888889 0.250476 9.5916667 0.248952 9.5944444 0.247429 9.5972222 0.246667 9.6000000 0.246667 9.6027778 0.246667 9.6055556 0.247429 9.6083333 0.246667 9.6111111 0.244381 9.6138889 0.245143 9.6166667 0.246667 9.6194444 0.245905 9.6222222 0.247429 9.6250000 0.247429 9.6277778 0.246667 9.6305556 0.244381 9.6333333 0.242095 9.6361111 0.238286 9.6388889 0.235238 9.6416667 0.232952 9.6444444 0.228381 9.6472222 0.220762 9.6500000 0.217714 9.6527778 0.225333 9.6555556 0.240571 9.6583333 0.260381 9.6611111 0.282476 9.6638889 0.312952 9.6666667 0.354857 9.6694444 0.393714 9.6722222 0.418857 9.6750000 0.427238 9.6777778 0.409714 9.6805556 0.362476 9.6833333 0.304571 9.6861111 0.261143 9.6888889 0.236762 9.6916667 0.228381 9.6944444 0.229143 9.6972222 0.233714 9.7000000 0.239810 9.7027778 0.242857 9.7055556 0.243619 9.7083333 0.242857 9.7111111 0.242857 9.7138889 0.240571 9.7166667 0.239048 9.7194444 0.242095 9.7222222 0.241333 9.7250000 0.241333 9.7277778 0.241333 9.7305556 0.241333 9.7333333 0.243619 9.7361111 0.243619 9.7388889 0.245143 9.7416667 0.242095 9.7444444 0.242095 9.7472222 0.241333 9.7500000 0.243619 9.7527778 0.243619 9.7555556 0.244381 9.7583333 0.242857 9.7611111 0.241333 9.7638889 0.240571 9.7666667 0.240571 9.7694444 0.241333 9.7722222 0.241333 9.7750000 0.239810 9.7777778 0.240571 9.7805556 0.239048 9.7833333 0.238286 9.7861111 0.240571 9.7888889 0.239810 9.7916667 0.240571 9.7944444 0.238286 9.7972222 0.238286 9.8000000 0.239048 9.8027778 0.242857 9.8055556 0.242095 9.8083333 0.240571 9.8111111 0.239810 9.8138889 0.239810 9.8166667 0.240571 9.8194444 0.240571 9.8222222 0.241333 9.8250000 0.238286 9.8277778 0.239048 9.8305556 0.238286 9.8333333 0.239810 9.8361111 0.240571 9.8388889 0.239810 9.8416667 0.240571 9.8444444 0.239048 9.8472222 0.238286 9.8500000 0.238286 9.8527778 0.240571 9.8555556 0.240571 9.8583333 0.239810 9.8611111 0.239048 9.8638889 0.239048 9.8666667 0.239810 9.8694444 0.242095 9.8722222 0.243619 9.8750000 0.242095 9.8777778 0.241333 9.8805556 0.239810 9.8833333 0.240571 9.8861111 0.242095 9.8888889 0.242095 9.8916667 0.241333 9.8944444 0.240571 9.8972222 0.240571 9.9000000 0.239048 9.9027778 0.239048 9.9055556 0.238286 9.9083333 0.236762 9.9111111 0.236000 9.9138889 0.234476 9.9166667 0.234476 9.9194444 0.235238 9.9222222 0.236000 9.9250000 0.234476 9.9277778 0.232190 9.9305556 0.229143 9.9333333 0.230667 9.9361111 0.232952 9.9388889 0.235238 9.9416667 0.233714 9.9444444 0.231429 9.9472222 0.232952 9.9500000 0.232190 9.9527778 0.235238 9.9555556 0.235238 9.9583333 0.235238 9.9611111 0.234476 9.9638889 0.234476 9.9666667 0.236762 9.9694444 0.236762 9.9722222 0.241333 9.9780000 0.300000 10.2608889 0.300000 10.2638889 0.251238 10.2666667 0.252000 10.2694444 0.252762 10.2722222 0.255048 10.2750000 0.255048 10.2777778 0.253524 10.2805556 0.252762 10.2833333 0.254286 10.2861111 0.257333 10.2888889 0.258095 10.2916667 0.259619 10.2944444 0.258095 10.2972222 0.258095 10.3000000 0.260381 10.3027778 0.263429 10.3055556 0.263429 10.3083333 0.264190 10.3111111 0.263429 10.3138889 0.264190 10.3166667 0.265714 10.3194444 0.267238 10.3222222 0.268762 10.3250000 0.268762 10.3277778 0.268000 10.3305556 0.267238 10.3333333 0.266476 10.3361111 0.266476 10.3388889 0.267238 10.3416667 0.266476 10.3444444 0.266476 10.3472222 0.264952 10.3500000 0.264952 10.3527778 0.263429 10.3555556 0.268000 10.3583333 0.266476 10.3611111 0.264952 10.3638889 0.261143 10.3666667 0.264190 10.3694444 0.268000 10.3722222 0.271048 10.3750000 0.268762 10.3777778 0.265714 10.3805556 0.260381 10.3833333 0.258095 10.3861111 0.257333 10.3888889 0.256571 10.3916667 0.253524 10.3944444 0.251238 10.3972222 0.252000 10.4000000 0.248952 10.4027778 0.250476 10.4055556 0.248952 10.4083333 0.251238 10.4111111 0.250476 10.4138889 0.251238 10.4166667 0.250476 10.4194444 0.250476 10.4222222 0.252762 10.4250000 0.253524 10.4277778 0.251238 10.4305556 0.251238 10.4333333 0.249714 10.4361111 0.251238 10.4388889 0.251238 10.4416667 0.249714 10.4444444 0.249714 10.4472222 0.245143 10.4500000 0.245905 10.4527778 0.249714 10.4555556 0.250476 10.4583333 0.250476 10.4611111 0.248952 10.4638889 0.246667 10.4666667 0.248190 10.4694444 0.247429 10.4722222 0.245905 10.4750000 0.241333 10.4777778 0.235238 10.4805556 0.231429 10.4833333 0.228381 10.4861111 0.226095 10.4888889 0.222286 10.4916667 0.221524 10.4944444 0.230667 10.4972222 0.250476 10.5000000 0.274857 10.5027778 0.301524 10.5055556 0.338095 10.5083333 0.378476 10.5111111 0.412762 10.5138889 0.434857 10.5166667 0.442476 10.5194444 0.427238 10.5222222 0.380000 10.5250000 0.318286 10.5277778 0.264952 10.5305556 0.235238 10.5333333 0.230667 10.5361111 0.236000 10.5388889 0.242095 10.5416667 0.245143 10.5444444 0.244381 10.5472222 0.242857 10.5500000 0.242095 10.5527778 0.245905 10.5555556 0.245905 10.5583333 0.243619 10.5611111 0.242857 10.5638889 0.241333 10.5666667 0.242095 10.5694444 0.244381 10.5722222 0.243619 10.5750000 0.243619 10.5777778 0.244381 10.5805556 0.242095 10.5833333 0.243619 10.5861111 0.242857 10.5888889 0.244381 10.5916667 0.243619 10.5944444 0.242095 10.5972222 0.242857 10.6000000 0.244381 10.6027778 0.245143 10.6055556 0.245143 10.6083333 0.245905 10.6111111 0.245905 10.6138889 0.243619 10.6166667 0.244381 10.6194444 0.245905 10.6222222 0.246667 10.6250000 0.246667 10.6277778 0.246667 10.6305556 0.245143 10.6333333 0.245143 10.6361111 0.245143 10.6388889 0.246667 10.6416667 0.245905 10.6444444 0.244381 10.6472222 0.243619 10.6500000 0.245143 10.6527778 0.246667 10.6555556 0.245905 10.6583333 0.246667 10.6611111 0.245905 10.6638889 0.243619 10.6666667 0.242857 10.6694444 0.245143 10.6722222 0.246667 10.6750000 0.247429 10.6777778 0.246667 10.6805556 0.243619 10.6833333 0.243619 10.6861111 0.245905 10.6888889 0.246667 10.6916667 0.247429 10.6944444 0.245143 10.6972222 0.243619 10.7000000 0.244381 10.7027778 0.245143 10.7055556 0.246667 10.7083333 0.245905 10.7111111 0.244381 10.7138889 0.244381 10.7166667 0.243619 10.7194444 0.244381 10.7222222 0.246667 10.7250000 0.246667 10.7277778 0.245143 10.7305556 0.245143 10.7333333 0.245905 10.7361111 0.247429 10.7388889 0.246667 10.7416667 0.247429 10.7444444 0.245905 10.7472222 0.243619 10.7500000 0.244381 10.7527778 0.245905 10.7555556 0.245143 10.7583333 0.244381 10.7611111 0.244381 10.7638889 0.242095 10.7666667 0.241333 10.7694444 0.242857 10.7722222 0.243619 10.7750000 0.242857 10.7777778 0.241333 10.7805556 0.239810 10.7833333 0.242857 10.7861111 0.241333 10.7888889 0.242095 10.7916667 0.243619 10.7944444 0.241333 10.7972222 0.241333 10.8000000 0.242095 10.8027778 0.243619 10.8055556 0.245143 10.8083333 0.246667 10.8111111 0.248952 10.8168889 0.300000 11.1164444 0.300000 11.1194444 0.255048 11.1222222 0.256571 11.1250000 0.255048 11.1277778 0.255048 11.1305556 0.252762 11.1333333 0.254286 11.1361111 0.256571 11.1388889 0.257333 11.1416667 0.258095 11.1444444 0.257333 11.1472222 0.259619 11.1500000 0.262667 11.1527778 0.264952 11.1555556 0.263429 11.1583333 0.263429 11.1611111 0.263429 11.1638889 0.262667 11.1666667 0.266476 11.1694444 0.266476 11.1722222 0.267238 11.1750000 0.269524 11.1777778 0.269524 11.1805556 0.268000 11.1833333 0.268762 11.1861111 0.270286 11.1888889 0.268762 11.1916667 0.268000 11.1944444 0.267238 11.1972222 0.265714 11.2000000 0.265714 11.2027778 0.269524 11.2055556 0.269524 11.2083333 0.268000 11.2111111 0.265714 11.2138889 0.266476 11.2166667 0.270286 11.2194444 0.272571 11.2222222 0.273333 11.2250000 0.268762 11.2277778 0.262667 11.2305556 0.259619 11.2333333 0.258095 11.2361111 0.257333 11.2388889 0.256571 11.2416667 0.254286 11.2444444 0.252762 11.2472222 0.250476 11.2500000 0.251238 11.2527778 0.250476 11.2555556 0.252762 11.2583333 0.250476 11.2611111 0.249714 11.2638889 0.248190 11.2666667 0.248952 11.2694444 0.249714 11.2722222 0.250476 11.2750000 0.251238 11.2777778 0.248190 11.2805556 0.247429 11.2833333 0.248190 11.2861111 0.249714 11.2888889 0.248952 11.2916667 0.249714 11.2944444 0.248190 11.2972222 0.248190 11.3000000 0.248952 11.3027778 0.248952 11.3055556 0.249714 11.3083333 0.248952 11.3111111 0.247429 11.3138889 0.242857 11.3166667 0.239810 11.3194444 0.234476 11.3222222 0.232952 11.3250000 0.231429 11.3277778 0.231429 11.3305556 0.227619 11.3333333 0.226857 11.3361111 0.222286 11.3388889 0.216190 11.3416667 0.212381 11.3444444 0.216952 11.3472222 0.225333 11.3500000 0.242857 11.3527778 0.261905 11.3555556 0.281714 11.3583333 0.309143 11.3611111 0.343429 11.3638889 0.380000 11.3666667 0.412762 11.3694444 0.431048 11.3722222 0.435619 11.3750000 0.411238 11.3777778 0.364762 11.3805556 0.302286 11.3833333 0.256571 11.3861111 0.233714 11.3888889 0.231429 11.3916667 0.233714 11.3944444 0.241333 11.3972222 0.242095 11.4000000 0.243619 11.4027778 0.243619 11.4055556 0.243619 11.4083333 0.245143 11.4111111 0.245143 11.4138889 0.243619 11.4166667 0.241333 11.4194444 0.244381 11.4222222 0.245143 11.4250000 0.244381 11.4277778 0.244381 11.4305556 0.242857 11.4333333 0.241333 11.4361111 0.245143 11.4388889 0.244381 11.4416667 0.245905 11.4444444 0.242857 11.4472222 0.242095 11.4500000 0.242857 11.4527778 0.245905 11.4555556 0.245905 11.4583333 0.245143 11.4611111 0.244381 11.4638889 0.242095 11.4666667 0.243619 11.4694444 0.245905 11.4722222 0.246667 11.4750000 0.245905 11.4777778 0.244381 11.4805556 0.242095 11.4833333 0.244381 11.4861111 0.245905 11.4888889 0.245905 11.4916667 0.244381 11.4944444 0.241333 11.4972222 0.240571 11.5000000 0.242857 11.5027778 0.245905 11.5055556 0.244381 11.5083333 0.245143 11.5111111 0.245905 11.5138889 0.244381 11.5166667 0.244381 11.5194444 0.245905 11.5222222 0.247429 11.5250000 0.247429 11.5277778 0.244381 11.5305556 0.245143 11.5333333 0.242857 11.5361111 0.245905 11.5388889 0.245143 11.5416667 0.244381 11.5444444 0.244381 11.5472222 0.243619 11.5500000 0.245143 11.5527778 0.245905 11.5555556 0.245143 11.5583333 0.244381 11.5611111 0.241333 11.5638889 0.242095 11.5666667 0.244381 11.5694444 0.245905 11.5722222 0.248952 11.5750000 0.245143 11.5777778 0.245143 11.5805556 0.241333 11.5833333 0.242095 11.5861111 0.242857 11.5888889 0.245143 11.5916667 0.245143 11.5944444 0.244381 11.5972222 0.242857 11.6000000 0.244381 11.6027778 0.245905 11.6055556 0.245143 11.6083333 0.246667 11.6111111 0.245143 11.6138889 0.243619 11.6166667 0.243619 11.6194444 0.244381 11.6222222 0.243619 11.6250000 0.242095 11.6277778 0.240571 11.6305556 0.241333 11.6333333 0.242095 11.6361111 0.243619 11.6388889 0.243619 11.6416667 0.244381 11.6444444 0.244381 11.6472222 0.240571 11.6500000 0.242857 11.6527778 0.243619 11.6555556 0.245905 11.6583333 0.244381 11.6611111 0.245143 11.6638889 0.243619 11.6666667 0.246667 11.6724444 0.300000 11.9386667 0.300000 11.9416667 0.252000 11.9444444 0.248952 11.9472222 0.248952 11.9500000 0.249714 11.9527778 0.252762 11.9555556 0.252762 11.9583333 0.252000 11.9611111 0.249714 11.9638889 0.251238 11.9666667 0.252000 11.9694444 0.254286 11.9722222 0.256571 11.9750000 0.257333 11.9777778 0.259619 11.9805556 0.260381 11.9833333 0.259619 11.9861111 0.260381 11.9888889 0.261143 11.9916667 0.260381 11.9944444 0.261905 11.9972222 0.261143 12.0000000 0.263429 12.0027778 0.264952 12.0055556 0.268762 12.0083333 0.268000 12.0111111 0.265714 12.0138889 0.264190 12.0166667 0.265714 12.0194444 0.265714 12.0222222 0.264952 12.0250000 0.265714 12.0277778 0.263429 12.0305556 0.263429 12.0333333 0.264952 12.0361111 0.264190 12.0388889 0.261905 12.0416667 0.261905 12.0444444 0.261143 12.0472222 0.264190 12.0500000 0.266476 12.0527778 0.268762 12.0555556 0.267238 12.0583333 0.263429 12.0611111 0.259619 12.0638889 0.257333 12.0666667 0.257333 12.0694444 0.258857 12.0722222 0.258857 12.0750000 0.255810 12.0777778 0.251238 12.0805556 0.248952 12.0833333 0.248190 12.0861111 0.249714 12.0888889 0.249714 12.0916667 0.248952 12.0944444 0.246667 12.0972222 0.245143 12.1000000 0.246667 12.1027778 0.246667 12.1055556 0.247429 12.1083333 0.246667 12.1111111 0.245905 12.1138889 0.244381 12.1166667 0.245143 12.1194444 0.245905 12.1222222 0.246667 12.1250000 0.248190 12.1277778 0.245143 12.1305556 0.243619 12.1333333 0.243619 12.1361111 0.245905 12.1388889 0.247429 12.1416667 0.246667 12.1444444 0.243619 12.1472222 0.241333 12.1500000 0.237524 12.1527778 0.232952 12.1555556 0.229905 12.1583333 0.225333 12.1611111 0.217714 12.1638889 0.213905 12.1666667 0.216190 12.1694444 0.226095 12.1722222 0.244381 12.1750000 0.261143 12.1777778 0.280952 12.1805556 0.313714 12.1833333 0.354857 12.1861111 0.391429 12.1888889 0.414286 12.1916667 0.421143 12.1944444 0.406667 12.1972222 0.367048 12.2000000 0.314476 12.2027778 0.271810 12.2055556 0.243619 12.2083333 0.228381 12.2111111 0.225333 12.2138889 0.228381 12.2166667 0.232952 12.2194444 0.235238 12.2222222 0.237524 12.2250000 0.237524 12.2277778 0.237524 12.2305556 0.236000 12.2333333 0.239048 12.2361111 0.239810 12.2388889 0.238286 12.2416667 0.237524 12.2444444 0.238286 12.2472222 0.236000 12.2500000 0.239810 12.2527778 0.239810 12.2555556 0.240571 12.2583333 0.239810 12.2611111 0.239810 12.2638889 0.237524 12.2666667 0.239048 12.2694444 0.239048 12.2722222 0.237524 12.2750000 0.239048 12.2777778 0.238286 12.2805556 0.237524 12.2833333 0.237524 12.2861111 0.239048 12.2888889 0.240571 12.2916667 0.240571 12.2944444 0.239048 12.2972222 0.239048 12.3000000 0.239810 12.3027778 0.240571 12.3055556 0.241333 12.3083333 0.240571 12.3111111 0.237524 12.3138889 0.237524 12.3166667 0.237524 12.3194444 0.236762 12.3222222 0.237524 12.3250000 0.238286 12.3277778 0.236000 12.3305556 0.236000 12.3333333 0.236000 12.3361111 0.236762 12.3388889 0.237524 12.3416667 0.236762 12.3444444 0.235238 12.3472222 0.235238 12.3500000 0.236000 12.3527778 0.235238 12.3555556 0.236000 12.3583333 0.237524 12.3611111 0.237524 12.3638889 0.236762 12.3666667 0.237524 12.3694444 0.237524 12.3722222 0.239048 12.3750000 0.238286 12.3777778 0.238286 12.3805556 0.235238 12.3833333 0.236000 12.3861111 0.237524 12.3888889 0.239048 12.3916667 0.238286 12.3944444 0.236762 12.3972222 0.236000 12.4000000 0.237524 12.4027778 0.237524 12.4055556 0.239048 12.4083333 0.237524 12.4111111 0.236762 12.4138889 0.236000 12.4166667 0.237524 12.4194444 0.239048 12.4222222 0.240571 12.4250000 0.239048 12.4277778 0.236762 12.4305556 0.236000 12.4333333 0.236762 12.4361111 0.236762 12.4388889 0.239048 12.4416667 0.236762 12.4444444 0.234476 12.4472222 0.231429 12.4500000 0.232952 12.4527778 0.232952 12.4555556 0.233714 12.4583333 0.233714 12.4611111 0.232952 12.4638889 0.231429 12.4666667 0.233714 12.4694444 0.232952 12.4722222 0.234476 12.4750000 0.232952 12.4777778 0.232190 12.4805556 0.232190 12.4833333 0.232952 12.4861111 0.233714 12.4888889 0.236000 12.4946667 0.300000 12.7664444 0.300000 12.7694444 0.246667 12.7722222 0.248952 12.7750000 0.247429 12.7777778 0.246667 12.7805556 0.246667 12.7833333 0.245905 12.7861111 0.248190 12.7888889 0.248952 12.7916667 0.249714 12.7944444 0.248190 12.7972222 0.245905 12.8000000 0.245905 12.8027778 0.249714 12.8055556 0.252000 12.8083333 0.252000 12.8111111 0.252000 12.8138889 0.251238 12.8166667 0.254286 12.8194444 0.254286 12.8222222 0.257333 12.8250000 0.259619 12.8277778 0.257333 12.8305556 0.256571 12.8333333 0.259619 12.8361111 0.264190 12.8388889 0.264952 12.8416667 0.264952 12.8444444 0.262667 12.8472222 0.261143 12.8500000 0.261905 12.8527778 0.262667 12.8555556 0.261905 12.8583333 0.261143 12.8611111 0.259619 12.8638889 0.258857 12.8666667 0.255810 12.8694444 0.257333 12.8722222 0.258095 12.8750000 0.260381 12.8777778 0.261143 12.8805556 0.260381 12.8833333 0.258095 12.8861111 0.255048 12.8888889 0.254286 12.8916667 0.253524 12.8944444 0.248952 12.8972222 0.245905 12.9000000 0.246667 12.9027778 0.246667 12.9055556 0.246667 12.9083333 0.245905 12.9111111 0.243619 12.9138889 0.243619 12.9166667 0.245143 12.9194444 0.244381 12.9222222 0.245905 12.9250000 0.244381 12.9277778 0.242857 12.9305556 0.241333 12.9333333 0.242095 12.9361111 0.242857 12.9388889 0.245905 12.9416667 0.243619 12.9444444 0.241333 12.9472222 0.240571 12.9500000 0.240571 12.9527778 0.243619 12.9555556 0.245143 12.9583333 0.243619 12.9611111 0.242095 12.9638889 0.241333 12.9666667 0.242095 12.9694444 0.242857 12.9722222 0.243619 12.9750000 0.242095 12.9777778 0.238286 12.9805556 0.232190 12.9833333 0.229143 12.9861111 0.226857 12.9888889 0.226095 12.9916667 0.220000 12.9944444 0.215429 12.9972222 0.218476 13.0000000 0.231429 13.0027778 0.250476 13.0055556 0.271810 13.0083333 0.296190 13.0111111 0.328190 13.0138889 0.365524 13.0166667 0.400571 13.0194444 0.424190 13.0222222 0.429524 13.0250000 0.414286 13.0277778 0.373905 13.0305556 0.316762 13.0333333 0.268000 13.0361111 0.240571 13.0388889 0.229905 13.0416667 0.226095 13.0444444 0.228381 13.0472222 0.231429 13.0500000 0.235238 13.0527778 0.236762 13.0555556 0.238286 13.0583333 0.236762 13.0611111 0.236762 13.0638889 0.236000 13.0666667 0.239048 13.0694444 0.239810 13.0722222 0.241333 13.0750000 0.239810 13.0777778 0.239048 13.0805556 0.236000 13.0833333 0.237524 13.0861111 0.239048 13.0888889 0.239048 13.0916667 0.238286 13.0944444 0.238286 13.0972222 0.233714 13.1000000 0.236000 13.1027778 0.237524 13.1055556 0.238286 13.1083333 0.236762 13.1111111 0.234476 13.1138889 0.232952 13.1166667 0.233714 13.1194444 0.236762 13.1222222 0.236000 13.1250000 0.234476 13.1277778 0.236762 13.1305556 0.234476 13.1333333 0.235238 13.1361111 0.236000 13.1388889 0.236000 13.1416667 0.236762 13.1444444 0.235238 13.1472222 0.235238 13.1500000 0.236000 13.1527778 0.237524 13.1555556 0.237524 13.1583333 0.237524 13.1611111 0.236000 13.1638889 0.234476 13.1666667 0.236000 13.1694444 0.236762 13.1722222 0.239810 13.1750000 0.238286 13.1777778 0.236762 13.1805556 0.234476 13.1833333 0.236000 13.1861111 0.236000 13.1888889 0.236762 13.1916667 0.236000 13.1944444 0.235238 13.1972222 0.232952 13.2000000 0.234476 13.2027778 0.235238 13.2055556 0.236762 13.2083333 0.236000 13.2111111 0.235238 13.2138889 0.232952 13.2166667 0.234476 13.2194444 0.234476 13.2222222 0.235238 13.2250000 0.236000 13.2277778 0.236762 13.2305556 0.235238 13.2333333 0.234476 13.2361111 0.235238 13.2388889 0.236762 13.2416667 0.238286 13.2444444 0.238286 13.2472222 0.235238 13.2500000 0.236762 13.2527778 0.236000 13.2555556 0.236000 13.2583333 0.236000 13.2611111 0.233714 13.2638889 0.233714 13.2666667 0.232952 13.2694444 0.236000 13.2722222 0.234476 13.2750000 0.231429 13.2777778 0.230667 13.2805556 0.229143 13.2833333 0.229143 13.2861111 0.229143 13.2888889 0.229143 13.2916667 0.229143 13.2944444 0.228381 13.2972222 0.225333 13.3000000 0.226095 13.3027778 0.229905 13.3055556 0.230667 13.3083333 0.229905 13.3111111 0.230667 13.3138889 0.230667 13.3166667 0.232952 13.3224444 0.300000 13.5886667 0.300000 13.5916667 0.248952 13.5944444 0.245905 13.5972222 0.247429 13.6000000 0.248190 13.6027778 0.249714 13.6055556 0.248190 13.6083333 0.247429 13.6111111 0.246667 13.6138889 0.245905 13.6166667 0.246667 13.6194444 0.248952 13.6222222 0.249714 13.6250000 0.249714 13.6277778 0.249714 13.6305556 0.249714 13.6333333 0.253524 13.6361111 0.256571 13.6388889 0.258095 13.6416667 0.257333 13.6444444 0.256571 13.6472222 0.255810 13.6500000 0.258095 13.6527778 0.260381 13.6555556 0.262667 13.6583333 0.263429 13.6611111 0.263429 13.6638889 0.263429 13.6666667 0.264190 13.6694444 0.265714 13.6722222 0.266476 13.6750000 0.264952 13.6777778 0.263429 13.6805556 0.261143 13.6833333 0.261143 13.6861111 0.263429 13.6888889 0.263429 13.6916667 0.261905 13.6944444 0.258857 13.6972222 0.258857 13.7000000 0.263429 13.7027778 0.264952 13.7055556 0.265714 13.7083333 0.259619 13.7111111 0.255048 13.7138889 0.253524 13.7166667 0.250476 13.7194444 0.252000 13.7222222 0.250476 13.7250000 0.249714 13.7277778 0.247429 13.7305556 0.245143 13.7333333 0.244381 13.7361111 0.245905 13.7388889 0.247429 13.7416667 0.248190 13.7444444 0.248952 13.7472222 0.245143 13.7500000 0.245905 13.7527778 0.247429 13.7555556 0.248952 13.7583333 0.245905 13.7611111 0.246667 13.7638889 0.242857 13.7666667 0.242857 13.7694444 0.244381 13.7722222 0.244381 13.7750000 0.246667 13.7777778 0.243619 13.7805556 0.242095 13.7833333 0.244381 13.7861111 0.243619 13.7888889 0.245905 13.7916667 0.243619 13.7944444 0.242095 13.7972222 0.241333 13.8000000 0.241333 13.8027778 0.239048 13.8055556 0.234476 13.8083333 0.229143 13.8111111 0.226095 13.8138889 0.220762 13.8166667 0.215429 13.8194444 0.220000 13.8222222 0.233714 13.8250000 0.253524 13.8277778 0.276381 13.8305556 0.301524 13.8333333 0.339619 13.8361111 0.381524 13.8388889 0.415810 13.8416667 0.435619 13.8444444 0.437905 13.8472222 0.407429 13.8500000 0.354857 13.8527778 0.295429 13.8555556 0.251238 13.8583333 0.230667 13.8611111 0.227619 13.8638889 0.232952 13.8666667 0.239810 13.8694444 0.242095 13.8722222 0.242095 13.8750000 0.241333 13.8777778 0.239810 13.8805556 0.239048 13.8833333 0.238286 13.8861111 0.239810 13.8888889 0.237524 13.8916667 0.240571 13.8944444 0.239810 13.8972222 0.238286 13.9000000 0.238286 13.9027778 0.239810 13.9055556 0.241333 13.9083333 0.241333 13.9111111 0.238286 13.9138889 0.238286 13.9166667 0.239048 13.9194444 0.241333 13.9222222 0.242095 13.9250000 0.241333 13.9277778 0.238286 13.9305556 0.237524 13.9333333 0.239048 13.9361111 0.239810 13.9388889 0.241333 13.9416667 0.239810 13.9444444 0.237524 13.9472222 0.238286 13.9500000 0.238286 13.9527778 0.239810 13.9555556 0.240571 13.9583333 0.239810 13.9611111 0.239810 13.9638889 0.238286 13.9666667 0.237524 13.9694444 0.239048 13.9722222 0.241333 13.9750000 0.239810 13.9777778 0.239048 13.9805556 0.239810 13.9833333 0.241333 13.9861111 0.241333 13.9888889 0.242857 13.9916667 0.242857 13.9944444 0.242095 13.9972222 0.239810 14.0000000 0.241333 14.0027778 0.240571 14.0055556 0.241333 14.0083333 0.242095 14.0111111 0.240571 14.0138889 0.239048 14.0166667 0.239048 14.0194444 0.240571 14.0222222 0.244381 14.0250000 0.242857 14.0277778 0.241333 14.0305556 0.239048 14.0333333 0.239048 14.0361111 0.240571 14.0388889 0.242095 14.0416667 0.242857 14.0444444 0.241333 14.0472222 0.239810 14.0500000 0.242095 14.0527778 0.243619 14.0555556 0.244381 14.0583333 0.244381 14.0611111 0.242857 14.0638889 0.241333 14.0666667 0.242857 14.0694444 0.242857 14.0722222 0.244381 14.0750000 0.243619 14.0777778 0.242857 14.0805556 0.239048 14.0833333 0.239810 14.0861111 0.238286 14.0888889 0.243619 14.0916667 0.241333 14.0944444 0.239048 14.0972222 0.237524 14.1000000 0.239048 14.1027778 0.239810 14.1055556 0.242857 14.1083333 0.242095 14.1111111 0.241333 14.1138889 0.238286 14.1166667 0.241333 14.1194444 0.242857 14.1222222 0.243619 14.1250000 0.244381 14.1277778 0.244381 14.1305556 0.246667 14.1333333 0.245905 14.1361111 0.251238 14.1388889 0.252762 14.1446667 0.300000 14.3831111 0.300000 14.3861111 0.251238 14.3888889 0.252762 14.3916667 0.253524 14.3944444 0.252000 14.3972222 0.249714 14.4000000 0.251238 14.4027778 0.252762 14.4055556 0.253524 14.4083333 0.254286 14.4111111 0.255048 14.4138889 0.251238 14.4166667 0.252762 14.4194444 0.254286 14.4222222 0.258095 14.4250000 0.258857 14.4277778 0.260381 14.4305556 0.261905 14.4333333 0.264190 14.4361111 0.264952 14.4388889 0.265714 14.4416667 0.264952 14.4444444 0.264952 14.4472222 0.263429 14.4500000 0.264952 14.4527778 0.265714 14.4555556 0.268762 14.4583333 0.268762 14.4611111 0.269524 14.4638889 0.268000 14.4666667 0.270286 14.4694444 0.269524 14.4722222 0.271048 14.4750000 0.269524 14.4777778 0.268000 14.4805556 0.265714 14.4833333 0.265714 14.4861111 0.266476 14.4888889 0.266476 14.4916667 0.266476 14.4944444 0.264952 14.4972222 0.261905 14.5000000 0.262667 14.5027778 0.264952 14.5055556 0.268762 14.5083333 0.271810 14.5111111 0.270286 14.5138889 0.265714 14.5166667 0.261905 14.5194444 0.261143 14.5222222 0.259619 14.5250000 0.258095 14.5277778 0.253524 14.5305556 0.251238 14.5333333 0.250476 14.5361111 0.250476 14.5388889 0.249714 14.5416667 0.249714 14.5444444 0.250476 14.5472222 0.248952 14.5500000 0.248190 14.5527778 0.248952 14.5555556 0.251238 14.5583333 0.248952 14.5611111 0.247429 14.5638889 0.245905 14.5666667 0.246667 14.5694444 0.245905 14.5722222 0.246667 14.5750000 0.247429 14.5777778 0.248190 14.5805556 0.245905 14.5833333 0.246667 14.5861111 0.248190 14.5888889 0.248190 14.5916667 0.248190 14.5944444 0.245905 14.5972222 0.239048 14.6000000 0.233714 14.6027778 0.230667 14.6055556 0.228381 14.6083333 0.223810 14.6111111 0.217714 14.6138889 0.216952 14.6166667 0.229143 14.6194444 0.245905 14.6222222 0.268000 14.6250000 0.294667 14.6277778 0.328190 14.6305556 0.366286 14.6333333 0.402857 14.6361111 0.424952 14.6388889 0.425714 14.6416667 0.397524 14.6444444 0.348762 14.6472222 0.289333 14.6500000 0.248190 14.6527778 0.232190 14.6555556 0.232190 14.6583333 0.237524 14.6611111 0.242095 14.6638889 0.242857 14.6666667 0.242857 14.6694444 0.243619 14.6722222 0.244381 14.6750000 0.245143 14.6777778 0.243619 14.6805556 0.242857 14.6833333 0.243619 14.6861111 0.245143 14.6888889 0.246667 14.6916667 0.245905 14.6944444 0.244381 14.6972222 0.242095 14.7000000 0.242095 14.7027778 0.243619 14.7055556 0.244381 14.7083333 0.244381 14.7111111 0.242095 14.7138889 0.241333 14.7166667 0.240571 14.7194444 0.242095 14.7222222 0.242857 14.7250000 0.242857 14.7277778 0.242095 14.7305556 0.240571 14.7333333 0.242095 14.7361111 0.242857 14.7388889 0.243619 14.7416667 0.244381 14.7444444 0.242857 14.7472222 0.241333 14.7500000 0.244381 14.7527778 0.245143 14.7555556 0.246667 14.7583333 0.245905 14.7611111 0.245905 14.7638889 0.243619 14.7666667 0.244381 14.7694444 0.246667 14.7722222 0.245143 14.7750000 0.244381 14.7777778 0.244381 14.7805556 0.242857 14.7833333 0.242857 14.7861111 0.245905 14.7888889 0.245905 14.7916667 0.243619 14.7944444 0.242857 14.7972222 0.242095 14.8000000 0.241333 14.8027778 0.243619 14.8055556 0.243619 14.8083333 0.245143 14.8111111 0.243619 14.8138889 0.242857 14.8166667 0.244381 14.8194444 0.245905 14.8222222 0.247429 14.8250000 0.245143 14.8277778 0.245905 14.8305556 0.244381 14.8333333 0.245143 14.8361111 0.247429 14.8388889 0.248952 14.8416667 0.248952 14.8444444 0.245905 14.8472222 0.245905 14.8500000 0.246667 14.8527778 0.248190 14.8555556 0.246667 14.8583333 0.246667 14.8611111 0.245905 14.8638889 0.244381 14.8666667 0.245143 14.8694444 0.244381 14.8722222 0.244381 14.8750000 0.244381 14.8777778 0.243619 14.8805556 0.242857 14.8833333 0.242095 14.8861111 0.244381 14.8888889 0.246667 14.8916667 0.245143 14.8944444 0.244381 14.8972222 0.242095 14.9000000 0.242857 14.9027778 0.243619 14.9055556 0.245143 14.9083333 0.244381 14.9111111 0.242857 14.9138889 0.242095 14.9166667 0.242857 14.9194444 0.245143 14.9222222 0.245905 14.9250000 0.245905 14.9277778 0.245905 14.9305556 0.246667 14.9333333 0.246667 14.9391111 0.300000 15.1803333 0.300000 15.1833333 0.248952 15.1861111 0.250476 15.1888889 0.250476 15.1916667 0.251238 15.1944444 0.250476 15.1972222 0.248952 15.2000000 0.251238 15.2027778 0.251238 15.2055556 0.252762 15.2083333 0.252762 15.2111111 0.251238 15.2138889 0.249714 15.2166667 0.248190 15.2194444 0.250476 15.2222222 0.253524 15.2250000 0.253524 15.2277778 0.255810 15.2305556 0.255810 15.2333333 0.258857 15.2361111 0.259619 15.2388889 0.259619 15.2416667 0.260381 15.2444444 0.260381 15.2472222 0.258857 15.2500000 0.258095 15.2527778 0.260381 15.2555556 0.262667 15.2583333 0.264190 15.2611111 0.264952 15.2638889 0.262667 15.2666667 0.263429 15.2694444 0.264952 15.2722222 0.263429 15.2750000 0.265714 15.2777778 0.263429 15.2805556 0.262667 15.2833333 0.263429 15.2861111 0.266476 15.2888889 0.266476 15.2916667 0.264952 15.2944444 0.262667 15.2972222 0.261143 15.3000000 0.263429 15.3027778 0.267238 15.3055556 0.265714 15.3083333 0.261143 15.3111111 0.256571 15.3138889 0.252762 15.3166667 0.252762 15.3194444 0.249714 15.3222222 0.248952 15.3250000 0.246667 15.3277778 0.246667 15.3305556 0.245143 15.3333333 0.245905 15.3361111 0.248190 15.3388889 0.248190 15.3416667 0.248952 15.3444444 0.246667 15.3472222 0.245143 15.3500000 0.245143 15.3527778 0.247429 15.3555556 0.247429 15.3583333 0.246667 15.3611111 0.246667 15.3638889 0.245143 15.3666667 0.246667 15.3694444 0.246667 15.3722222 0.247429 15.3750000 0.245905 15.3777778 0.245905 15.3805556 0.243619 15.3833333 0.242857 15.3861111 0.240571 15.3888889 0.235238 15.3916667 0.230667 15.3944444 0.227619 15.3972222 0.223810 15.4000000 0.217714 15.4027778 0.213143 15.4055556 0.222286 15.4083333 0.236762 15.4111111 0.248952 15.4138889 0.260381 15.4166667 0.277143 15.4194444 0.299238 15.4222222 0.331238 15.4250000 0.371619 15.4277778 0.403619 15.4305556 0.425714 15.4333333 0.440952 15.4361111 0.447810 15.4388889 0.434857 15.4416667 0.405143 15.4444444 0.363238 15.4472222 0.316000 15.4500000 0.277143 15.4527778 0.247429 15.4555556 0.233714 15.4583333 0.229143 15.4611111 0.230667 15.4638889 0.235238 15.4666667 0.236762 15.4694444 0.239810 15.4722222 0.242857 15.4750000 0.243619 15.4777778 0.239810 15.4805556 0.239048 15.4833333 0.239048 15.4861111 0.237524 15.4888889 0.239048 15.4916667 0.238286 15.4944444 0.239048 15.4972222 0.238286 15.5000000 0.239810 15.5027778 0.240571 15.5055556 0.242095 15.5083333 0.241333 15.5111111 0.238286 15.5138889 0.236000 15.5166667 0.238286 15.5194444 0.239048 15.5222222 0.240571 15.5250000 0.242095 15.5277778 0.239810 15.5305556 0.239810 15.5333333 0.239048 15.5361111 0.240571 15.5388889 0.237524 15.5416667 0.238286 15.5444444 0.237524 15.5472222 0.237524 15.5500000 0.239810 15.5527778 0.241333 15.5555556 0.239810 15.5583333 0.238286 15.5611111 0.236000 15.5638889 0.233714 15.5666667 0.236762 15.5694444 0.238286 15.5722222 0.237524 15.5750000 0.239048 15.5777778 0.237524 15.5805556 0.236762 15.5833333 0.237524 15.5861111 0.239048 15.5888889 0.238286 15.5916667 0.240571 15.5944444 0.240571 15.5972222 0.239048 15.6000000 0.240571 15.6027778 0.240571 15.6055556 0.240571 15.6083333 0.239810 15.6111111 0.236000 15.6138889 0.236000 15.6166667 0.236762 15.6194444 0.237524 15.6222222 0.239810 15.6250000 0.239810 15.6277778 0.239048 15.6305556 0.236762 15.6333333 0.236762 15.6361111 0.239048 15.6388889 0.239048 15.6416667 0.241333 15.6444444 0.240571 15.6472222 0.237524 15.6500000 0.239810 15.6527778 0.240571 15.6555556 0.242095 15.6583333 0.242857 15.6611111 0.240571 15.6638889 0.238286 15.6666667 0.236000 15.6694444 0.236762 15.6722222 0.236762 15.6750000 0.236762 15.6777778 0.233714 15.6805556 0.229143 15.6833333 0.230667 15.6861111 0.229143 15.6888889 0.229905 15.6916667 0.232190 15.6944444 0.230667 15.6972222 0.229143 15.7000000 0.227619 15.7027778 0.230667 15.7055556 0.229905 15.7083333 0.231429 15.7111111 0.230667 15.7138889 0.228381 15.7166667 0.230667 15.7194444 0.232952 15.7222222 0.236000 15.7250000 0.236762 15.7277778 0.236000 15.7305556 0.237524 15.7363333 0.300000 15.9720000 0.300000 15.9750000 0.246667 15.9777778 0.244381 15.9805556 0.245905 15.9833333 0.246667 15.9861111 0.248190 15.9888889 0.248190 15.9916667 0.245905 15.9944444 0.245905 15.9972222 0.246667 16.0000000 0.246667 16.0027778 0.248952 16.0055556 0.248190 16.0083333 0.248190 16.0111111 0.249714 16.0138889 0.246667 16.0166667 0.252000 16.0194444 0.254286 16.0222222 0.255810 16.0250000 0.258095 16.0277778 0.257333 16.0305556 0.256571 16.0333333 0.258095 16.0361111 0.258857 16.0388889 0.261143 16.0416667 0.263429 16.0444444 0.261905 16.0472222 0.261143 16.0500000 0.263429 16.0527778 0.265714 16.0555556 0.265714 16.0583333 0.263429 16.0611111 0.261143 16.0638889 0.260381 16.0666667 0.258095 16.0694444 0.260381 16.0722222 0.262667 16.0750000 0.261143 16.0777778 0.259619 16.0805556 0.257333 16.0833333 0.258857 16.0861111 0.261905 16.0888889 0.264190 16.0916667 0.264952 16.0944444 0.262667 16.0972222 0.258857 16.1000000 0.257333 16.1027778 0.257333 16.1055556 0.255810 16.1083333 0.252000 16.1111111 0.248952 16.1138889 0.245905 16.1166667 0.245905 16.1194444 0.245905 16.1222222 0.245143 16.1250000 0.245143 16.1277778 0.242857 16.1305556 0.242095 16.1333333 0.245143 16.1361111 0.245905 16.1388889 0.246667 16.1416667 0.247429 16.1444444 0.243619 16.1472222 0.243619 16.1500000 0.245905 16.1527778 0.245905 16.1555556 0.246667 16.1583333 0.247429 16.1611111 0.245905 16.1638889 0.245905 16.1666667 0.245143 16.1694444 0.245905 16.1722222 0.245905 16.1750000 0.245905 16.1777778 0.245143 16.1805556 0.242857 16.1833333 0.243619 16.1861111 0.240571 16.1888889 0.235238 16.1916667 0.229143 16.1944444 0.225333 16.1972222 0.220000 16.2000000 0.214667 16.2027778 0.214667 16.2055556 0.224571 16.2083333 0.245143 16.2111111 0.266476 16.2138889 0.293143 16.2166667 0.328952 16.2194444 0.372381 16.2222222 0.410476 16.2250000 0.436381 16.2277778 0.436381 16.2305556 0.408190 16.2333333 0.353333 16.2361111 0.291619 16.2388889 0.246667 16.2416667 0.226857 16.2444444 0.225333 16.2472222 0.229143 16.2500000 0.236762 16.2527778 0.238286 16.2555556 0.239810 16.2583333 0.238286 16.2611111 0.236000 16.2638889 0.239810 16.2666667 0.236762 16.2694444 0.239048 16.2722222 0.240571 16.2750000 0.241333 16.2777778 0.239810 16.2805556 0.238286 16.2833333 0.239810 16.2861111 0.239048 16.2888889 0.240571 16.2916667 0.240571 16.2944444 0.239048 16.2972222 0.236762 16.3000000 0.238286 16.3027778 0.240571 16.3055556 0.242095 16.3083333 0.242095 16.3111111 0.238286 16.3138889 0.240571 16.3166667 0.239048 16.3194444 0.240571 16.3222222 0.242095 16.3250000 0.242095 16.3277778 0.238286 16.3305556 0.239048 16.3333333 0.237524 16.3361111 0.239048 16.3388889 0.239810 16.3416667 0.239048 16.3444444 0.239048 16.3472222 0.238286 16.3500000 0.240571 16.3527778 0.242095 16.3555556 0.241333 16.3583333 0.241333 16.3611111 0.240571 16.3638889 0.238286 16.3666667 0.239048 16.3694444 0.239048 16.3722222 0.240571 16.3750000 0.240571 16.3777778 0.237524 16.3805556 0.237524 16.3833333 0.238286 16.3861111 0.239048 16.3888889 0.237524 16.3916667 0.238286 16.3944444 0.237524 16.3972222 0.236762 16.4000000 0.237524 16.4027778 0.238286 16.4055556 0.239810 16.4083333 0.238286 16.4111111 0.239048 16.4138889 0.239048 16.4166667 0.239810 16.4194444 0.238286 16.4222222 0.242095 16.4250000 0.241333 16.4277778 0.240571 16.4305556 0.237524 16.4333333 0.239810 16.4361111 0.240571 16.4388889 0.242095 16.4416667 0.241333 16.4444444 0.238286 16.4472222 0.238286 16.4500000 0.238286 16.4527778 0.239048 16.4555556 0.237524 16.4583333 0.237524 16.4611111 0.236762 16.4638889 0.233714 16.4666667 0.234476 16.4694444 0.236762 16.4722222 0.236000 16.4750000 0.236000 16.4777778 0.232952 16.4805556 0.232952 16.4833333 0.233714 16.4861111 0.233714 16.4888889 0.233714 16.4916667 0.234476 16.4944444 0.232190 16.4972222 0.232190 16.5000000 0.236000 16.5027778 0.235238 16.5055556 0.237524 16.5083333 0.238286 16.5111111 0.239048 16.5138889 0.237524 16.5166667 0.242095 16.5194444 0.243619 16.5222222 0.246667 16.5280000 0.300000 16.7942222 0.300000 16.7972222 0.250476 16.8000000 0.252000 16.8027778 0.254286 16.8055556 0.255048 16.8083333 0.252762 16.8111111 0.252000 16.8138889 0.251238 16.8166667 0.252000 16.8194444 0.252762 16.8222222 0.255048 16.8250000 0.256571 16.8277778 0.258857 16.8305556 0.261905 16.8333333 0.262667 16.8361111 0.264952 16.8388889 0.266476 16.8416667 0.265714 16.8444444 0.264190 16.8472222 0.264952 16.8500000 0.266476 16.8527778 0.268762 16.8555556 0.271048 16.8583333 0.271048 16.8611111 0.271048 16.8638889 0.268762 16.8666667 0.268762 16.8694444 0.268762 16.8722222 0.268000 16.8750000 0.267238 16.8777778 0.265714 16.8805556 0.264952 16.8833333 0.265714 16.8861111 0.266476 16.8888889 0.266476 16.8916667 0.263429 16.8944444 0.263429 16.8972222 0.264952 16.9000000 0.268762 16.9027778 0.270286 16.9055556 0.270286 16.9083333 0.266476 16.9111111 0.262667 16.9138889 0.258095 16.9166667 0.260381 16.9194444 0.258095 16.9222222 0.256571 16.9250000 0.254286 16.9277778 0.254286 16.9305556 0.252762 16.9333333 0.252762 16.9361111 0.251238 16.9388889 0.251238 16.9416667 0.250476 16.9444444 0.248952 16.9472222 0.247429 16.9500000 0.248952 16.9527778 0.248952 16.9555556 0.249714 16.9583333 0.248952 16.9611111 0.247429 16.9638889 0.245143 16.9666667 0.247429 16.9694444 0.248952 16.9722222 0.247429 16.9750000 0.247429 16.9777778 0.245905 16.9805556 0.245143 16.9833333 0.245905 16.9861111 0.248190 16.9888889 0.248190 16.9916667 0.246667 16.9944444 0.246667 16.9972222 0.245905 17.0000000 0.245905 17.0027778 0.245905 17.0055556 0.243619 17.0083333 0.235238 17.0111111 0.229143 17.0138889 0.226857 17.0166667 0.223810 17.0194444 0.219238 17.0222222 0.218476 17.0250000 0.226095 17.0277778 0.239810 17.0305556 0.261143 17.0333333 0.285524 17.0361111 0.314476 17.0388889 0.353333 17.0416667 0.396000 17.0444444 0.428762 17.0472222 0.445524 17.0500000 0.448571 17.0527778 0.425714 17.0555556 0.373143 17.0583333 0.308381 17.0611111 0.258857 17.0638889 0.230667 17.0666667 0.226095 17.0694444 0.232952 17.0722222 0.238286 17.0750000 0.242857 17.0777778 0.242857 17.0805556 0.240571 17.0833333 0.242095 17.0861111 0.245143 17.0888889 0.245905 17.0916667 0.247429 17.0944444 0.244381 17.0972222 0.242857 17.1000000 0.243619 17.1027778 0.243619 17.1055556 0.245905 17.1083333 0.243619 17.1111111 0.242857 17.1138889 0.242095 17.1166667 0.241333 17.1194444 0.242095 17.1222222 0.242095 17.1250000 0.242095 17.1277778 0.241333 17.1305556 0.239810 17.1333333 0.239810 17.1361111 0.240571 17.1388889 0.241333 17.1416667 0.242095 17.1444444 0.242095 17.1472222 0.239810 17.1500000 0.240571 17.1527778 0.242095 17.1555556 0.243619 17.1583333 0.242857 17.1611111 0.241333 17.1638889 0.242095 17.1666667 0.242857 17.1694444 0.244381 17.1722222 0.245143 17.1750000 0.244381 17.1777778 0.244381 17.1805556 0.241333 17.1833333 0.243619 17.1861111 0.244381 17.1888889 0.245905 17.1916667 0.241333 17.1944444 0.239810 17.1972222 0.239810 17.2000000 0.241333 17.2027778 0.243619 17.2055556 0.242095 17.2083333 0.243619 17.2111111 0.242857 17.2138889 0.240571 17.2166667 0.241333 17.2194444 0.242095 17.2222222 0.243619 17.2250000 0.243619 17.2277778 0.241333 17.2305556 0.241333 17.2333333 0.242095 17.2361111 0.241333 17.2388889 0.243619 17.2416667 0.242857 17.2444444 0.242857 17.2472222 0.242095 17.2500000 0.242095 17.2527778 0.245905 17.2555556 0.245143 17.2583333 0.244381 17.2611111 0.243619 17.2638889 0.242095 17.2666667 0.243619 17.2694444 0.242857 17.2722222 0.245143 17.2750000 0.243619 17.2777778 0.242095 17.2805556 0.241333 17.2833333 0.242857 17.2861111 0.242857 17.2888889 0.243619 17.2916667 0.243619 17.2944444 0.241333 17.2972222 0.239048 17.3000000 0.239810 17.3027778 0.241333 17.3055556 0.239810 17.3083333 0.242095 17.3111111 0.239048 17.3138889 0.239048 17.3166667 0.239048 17.3194444 0.240571 17.3222222 0.240571 17.3250000 0.241333 17.3277778 0.239048 17.3305556 0.239048 17.3333333 0.241333 17.3361111 0.242095 17.3388889 0.242095 17.3416667 0.241333 17.3444444 0.241333 17.3502222 0.300000 17.6636667 0.300000 17.6666667 0.251238 17.6694444 0.253524 17.6722222 0.252762 17.6750000 0.253524 17.6777778 0.255048 17.6805556 0.251238 17.6833333 0.253524 17.6861111 0.255810 17.6888889 0.256571 17.6916667 0.256571 17.6944444 0.256571 17.6972222 0.256571 17.7000000 0.259619 17.7027778 0.261905 17.7055556 0.261905 17.7083333 0.261905 17.7111111 0.261905 17.7138889 0.261905 17.7166667 0.261905 17.7194444 0.264952 17.7222222 0.267238 17.7250000 0.265714 17.7277778 0.265714 17.7305556 0.264952 17.7333333 0.264952 17.7361111 0.265714 17.7388889 0.267238 17.7416667 0.267238 17.7444444 0.264952 17.7472222 0.261905 17.7500000 0.263429 17.7527778 0.264952 17.7555556 0.264952 17.7583333 0.263429 17.7611111 0.261905 17.7638889 0.261143 17.7666667 0.266476 17.7694444 0.269524 17.7722222 0.269524 17.7750000 0.265714 17.7777778 0.259619 17.7805556 0.255810 17.7833333 0.255810 17.7861111 0.254286 17.7888889 0.252762 17.7916667 0.250476 17.7944444 0.248952 17.7972222 0.248190 17.8000000 0.246667 17.8027778 0.248190 17.8055556 0.248190 17.8083333 0.247429 17.8111111 0.249714 17.8138889 0.246667 17.8166667 0.247429 17.8194444 0.247429 17.8222222 0.248190 17.8250000 0.246667 17.8277778 0.245905 17.8305556 0.245905 17.8333333 0.245905 17.8361111 0.247429 17.8388889 0.248190 17.8416667 0.248190 17.8444444 0.245905 17.8472222 0.245143 17.8500000 0.245143 17.8527778 0.245905 17.8555556 0.247429 17.8583333 0.247429 17.8611111 0.245143 17.8638889 0.243619 17.8666667 0.242857 17.8694444 0.243619 17.8722222 0.242095 17.8750000 0.236000 17.8777778 0.229143 17.8805556 0.226095 17.8833333 0.221524 17.8861111 0.216952 17.8888889 0.212381 17.8916667 0.216952 17.8944444 0.231429 17.8972222 0.250476 17.9000000 0.270286 17.9027778 0.293143 17.9055556 0.325143 17.9083333 0.364762 17.9111111 0.399810 17.9138889 0.423429 17.9166667 0.433333 17.9194444 0.424190 17.9222222 0.389905 17.9250000 0.333524 17.9277778 0.277143 17.9305556 0.242095 17.9333333 0.228381 17.9361111 0.229143 17.9388889 0.235238 17.9416667 0.241333 17.9444444 0.242857 17.9472222 0.239810 17.9500000 0.241333 17.9527778 0.242857 17.9555556 0.245905 17.9583333 0.243619 17.9611111 0.245143 17.9638889 0.244381 17.9666667 0.243619 17.9694444 0.243619 17.9722222 0.245143 17.9750000 0.244381 17.9777778 0.242857 17.9805556 0.242095 17.9833333 0.243619 17.9861111 0.243619 17.9888889 0.243619 17.9916667 0.242095 17.9944444 0.241333 17.9972222 0.239810 18.0000000 0.240571 18.0027778 0.242095 18.0055556 0.242857 18.0083333 0.242857 18.0111111 0.239810 18.0138889 0.239048 18.0166667 0.239810 18.0194444 0.243619 18.0222222 0.243619 18.0250000 0.243619 18.0277778 0.244381 18.0305556 0.240571 18.0333333 0.241333 18.0361111 0.242857 18.0388889 0.245143 18.0416667 0.242095 18.0444444 0.240571 18.0472222 0.240571 18.0500000 0.241333 18.0527778 0.242857 18.0555556 0.242857 18.0583333 0.242857 18.0611111 0.242095 18.0638889 0.240571 18.0666667 0.242095 18.0694444 0.244381 18.0722222 0.242095 18.0750000 0.242095 18.0777778 0.241333 18.0805556 0.240571 18.0833333 0.240571 18.0861111 0.242095 18.0888889 0.242095 18.0916667 0.241333 18.0944444 0.239810 18.0972222 0.239048 18.1000000 0.241333 18.1027778 0.242095 18.1055556 0.245143 18.1083333 0.243619 18.1111111 0.242857 18.1138889 0.243619 18.1166667 0.241333 18.1194444 0.243619 18.1222222 0.244381 18.1250000 0.245143 18.1277778 0.244381 18.1305556 0.242857 18.1333333 0.242095 18.1361111 0.244381 18.1388889 0.243619 18.1416667 0.245143 18.1444444 0.243619 18.1472222 0.239810 18.1500000 0.241333 18.1527778 0.241333 18.1555556 0.240571 18.1583333 0.240571 18.1611111 0.240571 18.1638889 0.237524 18.1666667 0.240571 18.1694444 0.242095 18.1722222 0.240571 18.1750000 0.242095 18.1777778 0.239810 18.1805556 0.238286 18.1833333 0.238286 18.1861111 0.239810 18.1888889 0.240571 18.1916667 0.240571 18.1944444 0.237524 18.1972222 0.236762 18.2000000 0.240571 18.2027778 0.242095 18.2055556 0.240571 18.2083333 0.241333 18.2111111 0.240571 18.2138889 0.240571 18.2196667 0.300000 18.4858889 0.300000 18.4888889 0.252000 18.4916667 0.251238 18.4944444 0.250476 18.4972222 0.249714 18.5000000 0.249714 18.5027778 0.252000 18.5055556 0.252762 18.5083333 0.253524 18.5111111 0.252762 18.5138889 0.252762 18.5166667 0.254286 18.5194444 0.256571 18.5222222 0.258095 18.5250000 0.258857 18.5277778 0.258857 18.5305556 0.257333 18.5333333 0.259619 18.5361111 0.261143 18.5388889 0.261905 18.5416667 0.262667 18.5444444 0.261905 18.5472222 0.262667 18.5500000 0.265714 18.5527778 0.267238 18.5555556 0.266476 18.5583333 0.266476 18.5611111 0.264952 18.5638889 0.264190 18.5666667 0.263429 18.5694444 0.263429 18.5722222 0.264952 18.5750000 0.265714 18.5777778 0.263429 18.5805556 0.258857 18.5833333 0.261905 18.5861111 0.261143 18.5888889 0.264190 18.5916667 0.265714 18.5944444 0.267238 18.5972222 0.263429 18.6000000 0.260381 18.6027778 0.258095 18.6055556 0.256571 18.6083333 0.252000 18.6111111 0.251238 18.6138889 0.247429 18.6166667 0.246667 18.6194444 0.246667 18.6222222 0.245143 18.6250000 0.244381 18.6277778 0.245905 18.6305556 0.245143 18.6333333 0.245143 18.6361111 0.245143 18.6388889 0.246667 18.6416667 0.247429 18.6444444 0.245905 18.6472222 0.242857 18.6500000 0.244381 18.6527778 0.246667 18.6555556 0.247429 18.6583333 0.248190 18.6611111 0.248952 18.6638889 0.245905 18.6666667 0.244381 18.6694444 0.246667 18.6722222 0.247429 18.6750000 0.247429 18.6777778 0.245905 18.6805556 0.243619 18.6833333 0.243619 18.6861111 0.244381 18.6888889 0.245143 18.6916667 0.241333 18.6944444 0.236762 18.6972222 0.230667 18.7000000 0.229143 18.7027778 0.229905 18.7055556 0.227619 18.7083333 0.224571 18.7111111 0.215429 18.7138889 0.210857 18.7166667 0.216190 18.7194444 0.229905 18.7222222 0.247429 18.7250000 0.268762 18.7277778 0.293905 18.7305556 0.328952 18.7333333 0.369333 18.7361111 0.403619 18.7388889 0.428000 18.7416667 0.434095 18.7444444 0.410476 18.7472222 0.360952 18.7500000 0.300000 18.7527778 0.257333 18.7555556 0.233714 18.7583333 0.222286 18.7611111 0.226095 18.7638889 0.229905 18.7666667 0.234476 18.7694444 0.238286 18.7722222 0.237524 18.7750000 0.237524 18.7777778 0.236762 18.7805556 0.238286 18.7833333 0.236762 18.7861111 0.239810 18.7888889 0.240571 18.7916667 0.239810 18.7944444 0.238286 18.7972222 0.237524 18.8000000 0.237524 18.8027778 0.239810 18.8055556 0.240571 18.8083333 0.239048 18.8111111 0.239048 18.8138889 0.239810 18.8166667 0.239048 18.8194444 0.241333 18.8222222 0.241333 18.8250000 0.239810 18.8277778 0.237524 18.8305556 0.236000 18.8333333 0.237524 18.8361111 0.239048 18.8388889 0.240571 18.8416667 0.237524 18.8444444 0.236762 18.8472222 0.235238 18.8500000 0.235238 18.8527778 0.238286 18.8555556 0.239048 18.8583333 0.235238 18.8611111 0.236762 18.8638889 0.236762 18.8666667 0.237524 18.8694444 0.238286 18.8722222 0.239048 18.8750000 0.237524 18.8777778 0.238286 18.8805556 0.236762 18.8833333 0.237524 18.8861111 0.239048 18.8888889 0.239810 18.8916667 0.239048 18.8944444 0.238286 18.8972222 0.238286 18.9000000 0.236762 18.9027778 0.238286 18.9055556 0.239048 18.9083333 0.238286 18.9111111 0.237524 18.9138889 0.236000 18.9166667 0.236762 18.9194444 0.239048 18.9222222 0.239810 18.9250000 0.239048 18.9277778 0.236762 18.9305556 0.236000 18.9333333 0.237524 18.9361111 0.239048 18.9388889 0.239810 18.9416667 0.239048 18.9444444 0.236762 18.9472222 0.237524 18.9500000 0.236762 18.9527778 0.236762 18.9555556 0.238286 18.9583333 0.237524 18.9611111 0.236000 18.9638889 0.232952 18.9666667 0.234476 18.9694444 0.234476 18.9722222 0.235238 18.9750000 0.233714 18.9777778 0.233714 18.9805556 0.232952 18.9833333 0.231429 18.9861111 0.231429 18.9888889 0.231429 18.9916667 0.229143 18.9944444 0.228381 18.9972222 0.226095 19.0000000 0.229143 19.0027778 0.230667 19.0055556 0.231429 19.0083333 0.231429 19.0111111 0.228381 19.0138889 0.226095 19.0166667 0.229905 19.0194444 0.232190 19.0222222 0.233714 19.0250000 0.235238 19.0277778 0.234476 19.0305556 0.234476 19.0333333 0.236762 19.0361111 0.241333 19.0418889 0.300000 19.2720000 0.300000 19.2750000 0.248190 19.2777778 0.247429 19.2805556 0.245143 19.2833333 0.246667 19.2861111 0.247429 19.2888889 0.248952 19.2916667 0.247429 19.2944444 0.247429 19.2972222 0.245905 19.3000000 0.247429 19.3027778 0.248952 19.3055556 0.250476 19.3083333 0.251238 19.3111111 0.253524 19.3138889 0.253524 19.3166667 0.254286 19.3194444 0.256571 19.3222222 0.257333 19.3250000 0.259619 19.3277778 0.258095 19.3305556 0.258857 19.3333333 0.262667 19.3361111 0.263429 19.3388889 0.264952 19.3416667 0.264190 19.3444444 0.264952 19.3472222 0.262667 19.3500000 0.262667 19.3527778 0.263429 19.3555556 0.261905 19.3583333 0.261143 19.3611111 0.261143 19.3638889 0.258857 19.3666667 0.259619 19.3694444 0.259619 19.3722222 0.259619 19.3750000 0.261143 19.3777778 0.261905 19.3805556 0.264190 19.3833333 0.264952 19.3861111 0.261905 19.3888889 0.260381 19.3916667 0.257333 19.3944444 0.253524 19.3972222 0.248190 19.4000000 0.249714 19.4027778 0.248952 19.4055556 0.249714 19.4083333 0.247429 19.4111111 0.246667 19.4138889 0.245143 19.4166667 0.245143 19.4194444 0.245143 19.4222222 0.244381 19.4250000 0.244381 19.4277778 0.245905 19.4305556 0.244381 19.4333333 0.245143 19.4361111 0.245143 19.4388889 0.245143 19.4416667 0.245905 19.4444444 0.242857 19.4472222 0.242857 19.4500000 0.244381 19.4527778 0.245143 19.4555556 0.243619 19.4583333 0.245143 19.4611111 0.242095 19.4638889 0.240571 19.4666667 0.241333 19.4694444 0.241333 19.4722222 0.244381 19.4750000 0.242857 19.4777778 0.242857 19.4805556 0.239048 19.4833333 0.239810 19.4861111 0.234476 19.4888889 0.229905 19.4916667 0.226857 19.4944444 0.222286 19.4972222 0.213143 19.5000000 0.210857 19.5027778 0.221524 19.5055556 0.241333 19.5083333 0.263429 19.5111111 0.287048 19.5138889 0.319048 19.5166667 0.361714 19.5194444 0.402857 19.5222222 0.431810 19.5250000 0.442476 19.5277778 0.428000 19.5305556 0.384571 19.5333333 0.321333 19.5361111 0.269524 19.5388889 0.238286 19.5416667 0.226095 19.5444444 0.226095 19.5472222 0.231429 19.5500000 0.241333 19.5527778 0.241333 19.5555556 0.241333 19.5583333 0.240571 19.5611111 0.241333 19.5638889 0.239810 19.5666667 0.240571 19.5694444 0.241333 19.5722222 0.241333 19.5750000 0.240571 19.5777778 0.239810 19.5805556 0.240571 19.5833333 0.240571 19.5861111 0.239810 19.5888889 0.242095 19.5916667 0.241333 19.5944444 0.240571 19.5972222 0.238286 19.6000000 0.239048 19.6027778 0.239810 19.6055556 0.240571 19.6083333 0.240571 19.6111111 0.240571 19.6138889 0.238286 19.6166667 0.242857 19.6194444 0.240571 19.6222222 0.242095 19.6250000 0.240571 19.6277778 0.241333 19.6305556 0.240571 19.6333333 0.241333 19.6361111 0.243619 19.6388889 0.244381 19.6416667 0.244381 19.6444444 0.242095 19.6472222 0.240571 19.6500000 0.240571 19.6527778 0.241333 19.6555556 0.242857 19.6583333 0.242095 19.6611111 0.240571 19.6638889 0.240571 19.6666667 0.239810 19.6694444 0.242857 19.6722222 0.241333 19.6750000 0.241333 19.6777778 0.239048 19.6805556 0.240571 19.6833333 0.241333 19.6861111 0.241333 19.6888889 0.242857 19.6916667 0.242095 19.6944444 0.239810 19.6972222 0.238286 19.7000000 0.241333 19.7027778 0.242095 19.7055556 0.242857 19.7083333 0.242095 19.7111111 0.242095 19.7138889 0.240571 19.7166667 0.240571 19.7194444 0.242095 19.7222222 0.245905 19.7250000 0.245905 19.7277778 0.243619 19.7305556 0.241333 19.7333333 0.242857 19.7361111 0.241333 19.7388889 0.242857 19.7416667 0.240571 19.7444444 0.240571 19.7472222 0.239048 19.7500000 0.239048 19.7527778 0.241333 19.7555556 0.240571 19.7583333 0.240571 19.7611111 0.238286 19.7638889 0.236762 19.7666667 0.238286 19.7694444 0.238286 19.7722222 0.238286 19.7750000 0.237524 19.7777778 0.235238 19.7805556 0.234476 19.7833333 0.236000 19.7861111 0.238286 19.7888889 0.237524 19.7916667 0.237524 19.7944444 0.237524 19.7972222 0.237524 19.8000000 0.239048 19.8027778 0.241333 19.8055556 0.243619 19.8083333 0.242857 19.8111111 0.245143 19.8138889 0.244381 19.8166667 0.245905 19.8194444 0.248952 19.8222222 0.252000 19.8280000 0.300000 20.0636667 0.300000 20.0666667 0.252000 20.0694444 0.252000 20.0722222 0.254286 20.0750000 0.254286 20.0777778 0.252762 20.0805556 0.251238 20.0833333 0.252000 20.0861111 0.253524 20.0888889 0.254286 20.0916667 0.254286 20.0944444 0.254286 20.0972222 0.254286 20.1000000 0.256571 20.1027778 0.260381 20.1055556 0.262667 20.1083333 0.263429 20.1111111 0.262667 20.1138889 0.261905 20.1166667 0.263429 20.1194444 0.262667 20.1222222 0.264952 20.1250000 0.266476 20.1277778 0.264952 20.1305556 0.264190 20.1333333 0.264952 20.1361111 0.268762 20.1388889 0.269524 20.1416667 0.270286 20.1444444 0.268000 20.1472222 0.267238 20.1500000 0.268762 20.1527778 0.268762 20.1555556 0.268762 20.1583333 0.268000 20.1611111 0.265714 20.1638889 0.264952 20.1666667 0.265714 20.1694444 0.266476 20.1722222 0.266476 20.1750000 0.267238 20.1777778 0.269524 20.1805556 0.271048 20.1833333 0.271048 20.1861111 0.268762 20.1888889 0.265714 20.1916667 0.261905 20.1944444 0.258857 20.1972222 0.254286 20.2000000 0.253524 20.2027778 0.251238 20.2055556 0.251238 20.2083333 0.250476 20.2111111 0.248952 20.2138889 0.248190 20.2166667 0.248952 20.2194444 0.247429 20.2222222 0.249714 20.2250000 0.249714 20.2277778 0.247429 20.2305556 0.247429 20.2333333 0.246667 20.2361111 0.248952 20.2388889 0.248952 20.2416667 0.248952 20.2444444 0.248190 20.2472222 0.247429 20.2500000 0.248190 20.2527778 0.251238 20.2555556 0.250476 20.2583333 0.250476 20.2611111 0.248952 20.2638889 0.247429 20.2666667 0.246667 20.2694444 0.239810 20.2722222 0.234476 20.2750000 0.229905 20.2777778 0.223048 20.2805556 0.216952 20.2833333 0.212381 20.2861111 0.214667 20.2888889 0.230667 20.2916667 0.249714 20.2944444 0.264190 20.2972222 0.280190 20.3000000 0.300000 20.3027778 0.324381 20.3055556 0.353333 20.3083333 0.383048 20.3111111 0.406667 20.3138889 0.424190 20.3166667 0.441714 20.3194444 0.457714 20.3222222 0.460000 20.3250000 0.440190 20.3277778 0.386857 20.3305556 0.317524 20.3333333 0.262667 20.3361111 0.236000 20.3388889 0.235238 20.3416667 0.240571 20.3444444 0.245905 20.3472222 0.245143 20.3500000 0.244381 20.3527778 0.245905 20.3555556 0.246667 20.3583333 0.245143 20.3611111 0.244381 20.3638889 0.240571 20.3666667 0.241333 20.3694444 0.242857 20.3722222 0.243619 20.3750000 0.243619 20.3777778 0.242095 20.3805556 0.239810 20.3833333 0.241333 20.3861111 0.242857 20.3888889 0.244381 20.3916667 0.243619 20.3944444 0.241333 20.3972222 0.239048 20.4000000 0.241333 20.4027778 0.241333 20.4055556 0.243619 20.4083333 0.242857 20.4111111 0.241333 20.4138889 0.239810 20.4166667 0.240571 20.4194444 0.243619 20.4222222 0.245143 20.4250000 0.245143 20.4277778 0.244381 20.4305556 0.243619 20.4333333 0.243619 20.4361111 0.244381 20.4388889 0.245905 20.4416667 0.245143 20.4444444 0.243619 20.4472222 0.242095 20.4500000 0.242095 20.4527778 0.244381 20.4555556 0.243619 20.4583333 0.244381 20.4611111 0.242095 20.4638889 0.240571 20.4666667 0.242095 20.4694444 0.242095 20.4722222 0.244381 20.4750000 0.244381 20.4777778 0.242857 20.4805556 0.241333 20.4833333 0.241333 20.4861111 0.242857 20.4888889 0.245143 20.4916667 0.245905 20.4944444 0.243619 20.4972222 0.242857 20.5000000 0.243619 20.5027778 0.243619 20.5055556 0.245905 20.5083333 0.244381 20.5111111 0.245143 20.5138889 0.241333 20.5166667 0.241333 20.5194444 0.242095 20.5222222 0.245143 20.5250000 0.244381 20.5277778 0.242857 20.5305556 0.242095 20.5333333 0.243619 20.5361111 0.243619 20.5388889 0.243619 20.5416667 0.245143 20.5444444 0.241333 20.5472222 0.239810 20.5500000 0.242095 20.5527778 0.242857 20.5555556 0.244381 20.5583333 0.242857 20.5611111 0.241333 20.5638889 0.240571 20.5666667 0.242857 20.5694444 0.243619 20.5722222 0.243619 20.5750000 0.243619 20.5777778 0.243619 20.5805556 0.241333 20.5833333 0.242095 20.5861111 0.241333 20.5888889 0.243619 20.5916667 0.243619 20.5944444 0.243619 20.5972222 0.242095 20.6000000 0.243619 20.6027778 0.247429 20.6055556 0.248190 20.6083333 0.250476 20.6111111 0.248952 20.6138889 0.250476 20.6196667 0.300000 20.8386667 0.300000 20.8416667 0.252000 20.8444444 0.251238 20.8472222 0.252762 20.8500000 0.252762 20.8527778 0.252762 20.8555556 0.253524 20.8583333 0.254286 20.8611111 0.252762 20.8638889 0.252762 20.8666667 0.254286 20.8694444 0.256571 20.8722222 0.255810 20.8750000 0.258095 20.8777778 0.258095 20.8805556 0.258095 20.8833333 0.258857 20.8861111 0.261143 20.8888889 0.263429 20.8916667 0.262667 20.8944444 0.263429 20.8972222 0.262667 20.9000000 0.262667 20.9027778 0.266476 20.9055556 0.268762 20.9083333 0.271048 20.9111111 0.270286 20.9138889 0.271048 20.9166667 0.269524 20.9194444 0.270286 20.9222222 0.269524 20.9250000 0.268000 20.9277778 0.267238 20.9305556 0.266476 20.9333333 0.268000 20.9361111 0.268000 20.9388889 0.269524 20.9416667 0.268000 20.9444444 0.266476 20.9472222 0.267238 20.9500000 0.266476 20.9527778 0.264190 20.9555556 0.265714 20.9583333 0.265714 20.9611111 0.266476 20.9638889 0.269524 20.9666667 0.268762 20.9694444 0.264952 20.9722222 0.261905 20.9750000 0.260381 20.9777778 0.256571 20.9805556 0.254286 20.9833333 0.252000 20.9861111 0.249714 20.9888889 0.250476 20.9916667 0.248952 20.9944444 0.248190 20.9972222 0.247429 21.0000000 0.249714 21.0027778 0.251238 21.0055556 0.251238 21.0083333 0.250476 21.0111111 0.248952 21.0138889 0.248952 21.0166667 0.248952 21.0194444 0.249714 21.0222222 0.249714 21.0250000 0.248952 21.0277778 0.246667 21.0305556 0.245905 21.0333333 0.246667 21.0361111 0.247429 21.0388889 0.248190 21.0416667 0.246667 21.0444444 0.245143 21.0472222 0.240571 21.0500000 0.239048 21.0527778 0.233714 21.0555556 0.229143 21.0583333 0.226857 21.0611111 0.221524 21.0638889 0.213143 21.0666667 0.211619 21.0694444 0.220762 21.0722222 0.239048 21.0750000 0.261905 21.0777778 0.285524 21.0805556 0.315238 21.0833333 0.360190 21.0861111 0.400571 21.0888889 0.426476 21.0916667 0.434095 21.0944444 0.415810 21.0972222 0.370095 21.1000000 0.310667 21.1027778 0.263429 21.1055556 0.235238 21.1083333 0.226095 21.1111111 0.226857 21.1138889 0.234476 21.1166667 0.239048 21.1194444 0.239810 21.1222222 0.239048 21.1250000 0.239048 21.1277778 0.239810 21.1305556 0.240571 21.1333333 0.242857 21.1361111 0.244381 21.1388889 0.243619 21.1416667 0.241333 21.1444444 0.239810 21.1472222 0.238286 21.1500000 0.240571 21.1527778 0.240571 21.1555556 0.241333 21.1583333 0.242095 21.1611111 0.239810 21.1638889 0.239048 21.1666667 0.242095 21.1694444 0.242095 21.1722222 0.242857 21.1750000 0.241333 21.1777778 0.239810 21.1805556 0.238286 21.1833333 0.239048 21.1861111 0.239810 21.1888889 0.239810 21.1916667 0.242095 21.1944444 0.239810 21.1972222 0.240571 21.2000000 0.239810 21.2027778 0.239048 21.2055556 0.240571 21.2083333 0.241333 21.2111111 0.240571 21.2138889 0.239048 21.2166667 0.240571 21.2194444 0.242095 21.2222222 0.242095 21.2250000 0.241333 21.2277778 0.242095 21.2305556 0.241333 21.2333333 0.243619 21.2361111 0.242857 21.2388889 0.243619 21.2416667 0.243619 21.2444444 0.242857 21.2472222 0.241333 21.2500000 0.241333 21.2527778 0.242857 21.2555556 0.241333 21.2583333 0.242095 21.2611111 0.239048 21.2638889 0.238286 21.2666667 0.239048 21.2694444 0.241333 21.2722222 0.242095 21.2750000 0.242857 21.2777778 0.239810 21.2805556 0.238286 21.2833333 0.238286 21.2861111 0.239810 21.2888889 0.240571 21.2916667 0.242095 21.2944444 0.241333 21.2972222 0.239810 21.3000000 0.242857 21.3027778 0.242857 21.3055556 0.242095 21.3083333 0.241333 21.3111111 0.242857 21.3138889 0.241333 21.3166667 0.241333 21.3194444 0.242857 21.3222222 0.242095 21.3250000 0.239048 21.3277778 0.238286 21.3305556 0.236762 21.3333333 0.237524 21.3361111 0.236762 21.3388889 0.239048 21.3416667 0.237524 21.3444444 0.237524 21.3472222 0.236762 21.3500000 0.236762 21.3527778 0.236762 21.3555556 0.236762 21.3583333 0.236762 21.3611111 0.235238 21.3638889 0.232190 21.3666667 0.234476 21.3694444 0.236000 21.3722222 0.236762 21.3750000 0.239048 21.3777778 0.237524 21.3805556 0.238286 21.3833333 0.241333 21.3861111 0.242857 21.3888889 0.246667 21.3946667 0.300000 21.6247778 0.300000 21.6277778 0.249714 21.6305556 0.248952 21.6333333 0.248190 21.6361111 0.251238 21.6388889 0.250476 21.6416667 0.249714 21.6444444 0.246667 21.6472222 0.246667 21.6500000 0.248952 21.6527778 0.251238 21.6555556 0.252762 21.6583333 0.253524 21.6611111 0.255048 21.6638889 0.255048 21.6666667 0.258095 21.6694444 0.258857 21.6722222 0.261143 21.6750000 0.259619 21.6777778 0.261905 21.6805556 0.261905 21.6833333 0.261905 21.6861111 0.265714 21.6888889 0.266476 21.6916667 0.266476 21.6944444 0.264952 21.6972222 0.261905 21.7000000 0.261905 21.7027778 0.261905 21.7055556 0.264190 21.7083333 0.264952 21.7111111 0.262667 21.7138889 0.263429 21.7166667 0.264190 21.7194444 0.264190 21.7222222 0.264952 21.7250000 0.261143 21.7277778 0.260381 21.7305556 0.258095 21.7333333 0.259619 21.7361111 0.261143 21.7388889 0.264952 21.7416667 0.265714 21.7444444 0.263429 21.7472222 0.258857 21.7500000 0.256571 21.7527778 0.255048 21.7555556 0.253524 21.7583333 0.251238 21.7611111 0.245905 21.7638889 0.244381 21.7666667 0.245143 21.7694444 0.244381 21.7722222 0.245905 21.7750000 0.245905 21.7777778 0.245143 21.7805556 0.244381 21.7833333 0.244381 21.7861111 0.245905 21.7888889 0.247429 21.7916667 0.245905 21.7944444 0.243619 21.7972222 0.241333 21.8000000 0.243619 21.8027778 0.246667 21.8055556 0.246667 21.8083333 0.247429 21.8111111 0.245143 21.8138889 0.243619 21.8166667 0.243619 21.8194444 0.245143 21.8222222 0.247429 21.8250000 0.245143 21.8277778 0.244381 21.8305556 0.241333 21.8333333 0.240571 21.8361111 0.238286 21.8388889 0.234476 21.8416667 0.231429 21.8444444 0.228381 21.8472222 0.221524 21.8500000 0.216190 21.8527778 0.213905 21.8555556 0.223048 21.8583333 0.236000 21.8611111 0.255048 21.8638889 0.280190 21.8666667 0.312190 21.8694444 0.354857 21.8722222 0.394476 21.8750000 0.427238 21.8777778 0.440190 21.8805556 0.426476 21.8833333 0.383048 21.8861111 0.324381 21.8888889 0.272571 21.8916667 0.239810 21.8944444 0.225333 21.8972222 0.221524 21.9000000 0.228381 21.9027778 0.235238 21.9055556 0.237524 21.9083333 0.237524 21.9111111 0.236762 21.9138889 0.237524 21.9166667 0.238286 21.9194444 0.239810 21.9222222 0.239810 21.9250000 0.239810 21.9277778 0.238286 21.9305556 0.237524 21.9333333 0.239048 21.9361111 0.238286 21.9388889 0.239810 21.9416667 0.239048 21.9444444 0.237524 21.9472222 0.236000 21.9500000 0.236762 21.9527778 0.236762 21.9555556 0.238286 21.9583333 0.237524 21.9611111 0.234476 21.9638889 0.232190 21.9666667 0.232190 21.9694444 0.235238 21.9722222 0.236762 21.9750000 0.236000 21.9777778 0.236000 21.9805556 0.235238 21.9833333 0.236000 21.9861111 0.235238 21.9888889 0.237524 21.9916667 0.236762 21.9944444 0.233714 21.9972222 0.232952 22.0000000 0.233714 22.0027778 0.236762 22.0055556 0.236762 22.0083333 0.237524 22.0111111 0.237524 22.0138889 0.236000 22.0166667 0.234476 22.0194444 0.233714 22.0222222 0.235238 22.0250000 0.236000 22.0277778 0.236000 22.0305556 0.235238 22.0333333 0.235238 22.0361111 0.235238 22.0388889 0.236000 22.0416667 0.235238 22.0444444 0.235238 22.0472222 0.235238 22.0500000 0.236000 22.0527778 0.236762 22.0555556 0.236762 22.0583333 0.236762 22.0611111 0.236000 22.0638889 0.234476 22.0666667 0.235238 22.0694444 0.236000 22.0722222 0.236762 22.0750000 0.236000 22.0777778 0.236000 22.0805556 0.234476 22.0833333 0.236000 22.0861111 0.236000 22.0888889 0.237524 22.0916667 0.238286 22.0944444 0.235238 22.0972222 0.233714 22.1000000 0.232952 22.1027778 0.236000 22.1055556 0.236762 22.1083333 0.234476 22.1111111 0.232952 22.1138889 0.231429 22.1166667 0.231429 22.1194444 0.232190 22.1222222 0.232190 22.1250000 0.232190 22.1277778 0.229143 22.1305556 0.227619 22.1333333 0.225333 22.1361111 0.226857 22.1388889 0.227619 22.1416667 0.226857 22.1444444 0.226095 22.1472222 0.225333 22.1500000 0.226095 22.1527778 0.227619 22.1555556 0.230667 22.1583333 0.229143 22.1611111 0.229905 22.1638889 0.228381 22.1666667 0.230667 22.1694444 0.231429 22.1722222 0.233714 22.1750000 0.234476 22.1807778 0.300000 22.4358889 0.300000 22.4388889 0.244381 22.4416667 0.244381 22.4444444 0.242095 22.4472222 0.242095 22.4500000 0.243619 22.4527778 0.245143 22.4555556 0.245143 22.4583333 0.246667 22.4611111 0.245143 22.4638889 0.244381 22.4666667 0.246667 22.4694444 0.247429 22.4722222 0.248952 22.4750000 0.250476 22.4777778 0.251238 22.4805556 0.249714 22.4833333 0.251238 22.4861111 0.254286 22.4888889 0.254286 22.4916667 0.255048 22.4944444 0.253524 22.4972222 0.255048 22.5000000 0.256571 22.5027778 0.258857 22.5055556 0.258857 22.5083333 0.261143 22.5111111 0.259619 22.5138889 0.258857 22.5166667 0.258095 22.5194444 0.259619 22.5222222 0.258095 22.5250000 0.258857 22.5277778 0.256571 22.5305556 0.255048 22.5333333 0.255048 22.5361111 0.256571 22.5388889 0.258095 22.5416667 0.257333 22.5444444 0.254286 22.5472222 0.255810 22.5500000 0.256571 22.5527778 0.261143 22.5555556 0.263429 22.5583333 0.258857 22.5611111 0.254286 22.5638889 0.248190 22.5666667 0.248190 22.5694444 0.246667 22.5722222 0.245143 22.5750000 0.242095 22.5777778 0.240571 22.5805556 0.238286 22.5833333 0.239048 22.5861111 0.241333 22.5888889 0.241333 22.5916667 0.241333 22.5944444 0.238286 22.5972222 0.237524 22.6000000 0.238286 22.6027778 0.240571 22.6055556 0.239048 22.6083333 0.239810 22.6111111 0.236762 22.6138889 0.236762 22.6166667 0.238286 22.6194444 0.239810 22.6222222 0.240571 22.6250000 0.240571 22.6277778 0.238286 22.6305556 0.236762 22.6333333 0.236762 22.6361111 0.239048 22.6388889 0.238286 22.6416667 0.234476 22.6444444 0.226857 22.6472222 0.220000 22.6500000 0.216190 22.6527778 0.213143 22.6555556 0.209333 22.6583333 0.201714 22.6611111 0.202476 22.6638889 0.213143 22.6666667 0.232952 22.6694444 0.248952 22.6722222 0.261905 22.6750000 0.277143 22.6777778 0.297714 22.6805556 0.324381 22.6833333 0.362476 22.6861111 0.401333 22.6888889 0.430286 22.6916667 0.445524 22.6944444 0.438667 22.6972222 0.398286 22.7000000 0.332762 22.7027778 0.270286 22.7055556 0.232190 22.7083333 0.217714 22.7111111 0.222286 22.7138889 0.226095 22.7166667 0.233714 22.7194444 0.232190 22.7222222 0.232952 22.7250000 0.232952 22.7277778 0.232952 22.7305556 0.231429 22.7333333 0.230667 22.7361111 0.230667 22.7388889 0.231429 22.7416667 0.230667 22.7444444 0.229905 22.7472222 0.228381 22.7500000 0.229143 22.7527778 0.231429 22.7555556 0.232952 22.7583333 0.231429 22.7611111 0.232190 22.7638889 0.229905 22.7666667 0.229905 22.7694444 0.232952 22.7722222 0.232190 22.7750000 0.232190 22.7777778 0.231429 22.7805556 0.230667 22.7833333 0.231429 22.7861111 0.230667 22.7888889 0.233714 22.7916667 0.230667 22.7944444 0.231429 22.7972222 0.230667 22.8000000 0.230667 22.8027778 0.232190 22.8055556 0.232952 22.8083333 0.233714 22.8111111 0.233714 22.8138889 0.231429 22.8166667 0.232190 22.8194444 0.234476 22.8222222 0.232952 22.8250000 0.231429 22.8277778 0.231429 22.8305556 0.230667 22.8333333 0.229905 22.8361111 0.232952 22.8388889 0.233714 22.8416667 0.232190 22.8444444 0.230667 22.8472222 0.229905 22.8500000 0.230667 22.8527778 0.232952 22.8555556 0.232190 22.8583333 0.232952 22.8611111 0.231429 22.8638889 0.229143 22.8666667 0.231429 22.8694444 0.230667 22.8722222 0.232952 22.8750000 0.232952 22.8777778 0.231429 22.8805556 0.227619 22.8833333 0.230667 22.8861111 0.231429 22.8888889 0.231429 22.8916667 0.232952 22.8944444 0.232952 22.8972222 0.230667 22.9000000 0.232952 22.9027778 0.232952 22.9055556 0.233714 22.9083333 0.232952 22.9111111 0.232190 22.9138889 0.230667 22.9166667 0.231429 22.9194444 0.232952 22.9222222 0.233714 22.9250000 0.231429 22.9277778 0.232190 22.9305556 0.230667 22.9333333 0.231429 22.9361111 0.232190 22.9388889 0.232190 22.9416667 0.230667 22.9444444 0.228381 22.9472222 0.228381 22.9500000 0.226857 22.9527778 0.229143 22.9555556 0.230667 22.9583333 0.230667 22.9611111 0.229143 22.9638889 0.228381 22.9666667 0.228381 22.9694444 0.230667 22.9722222 0.230667 22.9750000 0.229905 22.9777778 0.231429 22.9805556 0.230667 22.9833333 0.232190 22.9861111 0.233714 22.9918889 0.300000 23.2525556 0.300000 23.2555556 0.238286 23.2583333 0.239810 23.2611111 0.238286 23.2638889 0.237524 23.2666667 0.237524 23.2694444 0.239048 23.2722222 0.239810 23.2750000 0.239810 23.2777778 0.239810 23.2805556 0.238286 23.2833333 0.240571 23.2861111 0.243619 23.2888889 0.244381 23.2916667 0.245905 23.2944444 0.245905 23.2972222 0.245905 23.3000000 0.246667 23.3027778 0.248190 23.3055556 0.249714 23.3083333 0.250476 23.3111111 0.248190 23.3138889 0.247429 23.3166667 0.247429 23.3194444 0.250476 23.3222222 0.254286 23.3250000 0.253524 23.3277778 0.253524 23.3305556 0.251238 23.3333333 0.254286 23.3361111 0.252000 23.3388889 0.255048 23.3416667 0.253524 23.3444444 0.251238 23.3472222 0.249714 23.3500000 0.251238 23.3527778 0.254286 23.3555556 0.255048 23.3583333 0.252762 23.3611111 0.250476 23.3638889 0.251238 23.3666667 0.254286 23.3694444 0.257333 23.3722222 0.255048 23.3750000 0.249714 23.3777778 0.244381 23.3805556 0.241333 23.3833333 0.240571 23.3861111 0.239810 23.3888889 0.239810 23.3916667 0.237524 23.3944444 0.236000 23.3972222 0.232952 23.4000000 0.234476 23.4027778 0.236000 23.4055556 0.236762 23.4083333 0.237524 23.4111111 0.234476 23.4138889 0.233714 23.4166667 0.234476 23.4194444 0.234476 23.4222222 0.236000 23.4250000 0.236000 23.4277778 0.232952 23.4305556 0.232190 23.4333333 0.234476 23.4361111 0.234476 23.4388889 0.235238 23.4416667 0.234476 23.4444444 0.234476 23.4472222 0.232190 23.4500000 0.232952 23.4527778 0.230667 23.4555556 0.234476 23.4583333 0.232952 23.4611111 0.230667 23.4638889 0.226857 23.4666667 0.222286 23.4694444 0.216952 23.4722222 0.213905 23.4750000 0.211619 23.4777778 0.203238 23.4805556 0.198667 23.4833333 0.204000 23.4861111 0.222286 23.4888889 0.245905 23.4916667 0.269524 23.4944444 0.296190 23.4972222 0.336571 23.5000000 0.382286 23.5027778 0.415048 23.5055556 0.428762 23.5083333 0.421143 23.5111111 0.383810 23.5138889 0.318286 23.5166667 0.256571 23.5194444 0.220762 23.5222222 0.210857 23.5250000 0.214667 23.5277778 0.220762 23.5305556 0.223810 23.5333333 0.228381 23.5361111 0.227619 23.5388889 0.228381 23.5416667 0.229905 23.5444444 0.226857 23.5472222 0.226095 23.5500000 0.226095 23.5527778 0.228381 23.5555556 0.229143 23.5583333 0.227619 23.5611111 0.226857 23.5638889 0.225333 23.5666667 0.226095 23.5694444 0.227619 23.5722222 0.228381 23.5750000 0.227619 23.5777778 0.225333 23.5805556 0.224571 23.5833333 0.224571 23.5861111 0.224571 23.5888889 0.226857 23.5916667 0.225333 23.5944444 0.226095 23.5972222 0.224571 23.6000000 0.225333 23.6027778 0.226095 23.6055556 0.226857 23.6083333 0.227619 23.6111111 0.226095 23.6138889 0.225333 23.6166667 0.226095 23.6194444 0.226857 23.6222222 0.227619 23.6250000 0.226095 23.6277778 0.226095 23.6305556 0.222286 23.6333333 0.224571 23.6361111 0.225333 23.6388889 0.226095 23.6416667 0.227619 23.6444444 0.227619 23.6472222 0.224571 23.6500000 0.227619 23.6527778 0.227619 23.6555556 0.227619 23.6583333 0.228381 23.6611111 0.224571 23.6638889 0.224571 23.6666667 0.224571 23.6694444 0.225333 23.6722222 0.228381 23.6750000 0.226095 23.6777778 0.224571 23.6805556 0.223048 23.6833333 0.224571 23.6861111 0.225333 23.6888889 0.225333 23.6916667 0.226857 23.6944444 0.225333 23.6972222 0.223810 23.7000000 0.224571 23.7027778 0.225333 23.7055556 0.227619 23.7083333 0.226857 23.7111111 0.225333 23.7138889 0.223810 23.7166667 0.226857 23.7194444 0.226095 23.7222222 0.227619 23.7250000 0.226857 23.7277778 0.226857 23.7305556 0.226857 23.7333333 0.228381 23.7361111 0.229143 23.7388889 0.229905 23.7416667 0.227619 23.7444444 0.227619 23.7472222 0.226857 23.7500000 0.225333 23.7527778 0.226857 23.7555556 0.228381 23.7583333 0.226857 23.7611111 0.224571 23.7638889 0.223048 23.7666667 0.223048 23.7694444 0.226095 23.7722222 0.226095 23.7750000 0.226095 23.7777778 0.224571 23.7805556 0.223048 23.7833333 0.223048 23.7861111 0.225333 23.7888889 0.226095 23.7916667 0.223810 23.7944444 0.225333 23.7972222 0.223810 23.8000000 0.226857 23.8027778 0.228381 23.8085556 0.300000 24.0803333 0.300000 24.0833333 0.235238 24.0861111 0.236000 24.0888889 0.235238 24.0916667 0.236000 24.0944444 0.235238 24.0972222 0.232952 24.1000000 0.232952 24.1027778 0.235238 24.1055556 0.236000 24.1083333 0.236000 24.1111111 0.236762 24.1138889 0.235238 24.1166667 0.239048 24.1194444 0.242095 24.1222222 0.244381 24.1250000 0.243619 24.1277778 0.243619 24.1305556 0.244381 24.1333333 0.245905 24.1361111 0.247429 24.1388889 0.249714 24.1416667 0.251238 24.1444444 0.251238 24.1472222 0.249714 24.1500000 0.250476 24.1527778 0.252000 24.1555556 0.252000 24.1583333 0.252000 24.1611111 0.250476 24.1638889 0.248190 24.1666667 0.247429 24.1694444 0.248952 24.1722222 0.250476 24.1750000 0.248952 24.1777778 0.245905 24.1805556 0.242095 24.1833333 0.245143 24.1861111 0.247429 24.1888889 0.253524 24.1916667 0.255048 24.1944444 0.252000 24.1972222 0.248952 24.2000000 0.244381 24.2027778 0.243619 24.2055556 0.242857 24.2083333 0.241333 24.2111111 0.238286 24.2138889 0.234476 24.2166667 0.234476 24.2194444 0.234476 24.2222222 0.234476 24.2250000 0.233714 24.2277778 0.231429 24.2305556 0.229905 24.2333333 0.229905 24.2361111 0.229905 24.2388889 0.230667 24.2416667 0.231429 24.2444444 0.231429 24.2472222 0.229143 24.2500000 0.228381 24.2527778 0.228381 24.2555556 0.229905 24.2583333 0.227619 24.2611111 0.226857 24.2638889 0.225333 24.2666667 0.226857 24.2694444 0.229143 24.2722222 0.229143 24.2750000 0.226857 24.2777778 0.226095 24.2805556 0.224571 24.2833333 0.224571 24.2861111 0.225333 24.2888889 0.225333 24.2916667 0.220000 24.2944444 0.215429 24.2972222 0.208571 24.3000000 0.207048 24.3027778 0.205524 24.3055556 0.200190 24.3083333 0.196381 24.3111111 0.200190 24.3138889 0.212381 24.3166667 0.232190 24.3194444 0.252762 24.3222222 0.280190 24.3250000 0.319048 24.3277778 0.360190 24.3305556 0.391429 24.3333333 0.410476 24.3361111 0.408952 24.3388889 0.380762 24.3416667 0.328190 24.3444444 0.270286 24.3472222 0.230667 24.3500000 0.210095 24.3527778 0.206286 24.3555556 0.210857 24.3583333 0.216952 24.3611111 0.218476 24.3638889 0.218476 24.3666667 0.218476 24.3694444 0.220000 24.3722222 0.223048 24.3750000 0.221524 24.3777778 0.223048 24.3805556 0.221524 24.3833333 0.221524 24.3861111 0.225333 24.3888889 0.224571 24.3916667 0.223810 24.3944444 0.225333 24.3972222 0.220762 24.4000000 0.222286 24.4027778 0.220762 24.4055556 0.223048 24.4083333 0.223048 24.4111111 0.223048 24.4138889 0.221524 24.4166667 0.221524 24.4194444 0.223810 24.4222222 0.222286 24.4250000 0.221524 24.4277778 0.220000 24.4305556 0.219238 24.4333333 0.220000 24.4361111 0.218476 24.4388889 0.220762 24.4416667 0.220000 24.4444444 0.220762 24.4472222 0.219238 24.4500000 0.220762 24.4527778 0.220762 24.4555556 0.222286 24.4583333 0.221524 24.4611111 0.222286 24.4638889 0.219238 24.4666667 0.219238 24.4694444 0.220762 24.4722222 0.222286 24.4750000 0.223048 24.4777778 0.220000 24.4805556 0.219238 24.4833333 0.220000 24.4861111 0.222286 24.4888889 0.224571 24.4916667 0.223810 24.4944444 0.222286 24.4972222 0.220762 24.5000000 0.220762 24.5027778 0.221524 24.5055556 0.223048 24.5083333 0.223810 24.5111111 0.222286 24.5138889 0.220762 24.5166667 0.223048 24.5194444 0.221524 24.5222222 0.222286 24.5250000 0.220762 24.5277778 0.223048 24.5305556 0.223048 24.5333333 0.221524 24.5361111 0.220000 24.5388889 0.223810 24.5416667 0.224571 24.5444444 0.224571 24.5472222 0.223048 24.5500000 0.224571 24.5527778 0.225333 24.5555556 0.227619 24.5583333 0.225333 24.5611111 0.224571 24.5638889 0.222286 24.5666667 0.223048 24.5694444 0.223810 24.5722222 0.223810 24.5750000 0.223810 24.5777778 0.223048 24.5805556 0.221524 24.5833333 0.223048 24.5861111 0.223048 24.5888889 0.221524 24.5916667 0.222286 24.5944444 0.220000 24.5972222 0.218476 24.6000000 0.218476 24.6027778 0.217714 24.6055556 0.220762 24.6083333 0.217714 24.6111111 0.217714 24.6138889 0.214667 24.6166667 0.216190 24.6194444 0.217714 24.6222222 0.216952 24.6250000 0.217714 24.6277778 0.216952 24.6305556 0.216190 24.6363333 0.300000 24.9247778 0.300000 24.9277778 0.232952 24.9305556 0.232190 24.9333333 0.233714 24.9361111 0.234476 24.9388889 0.234476 24.9416667 0.235238 24.9444444 0.234476 24.9472222 0.235238 24.9500000 0.237524 24.9527778 0.237524 24.9555556 0.242095 24.9583333 0.244381 24.9611111 0.243619 24.9638889 0.239048 24.9666667 0.240571 24.9694444 0.243619 24.9722222 0.245905 24.9750000 0.246667 24.9777778 0.245143 24.9805556 0.242095 24.9833333 0.243619 24.9861111 0.245905 24.9888889 0.249714 24.9916667 0.250476 24.9944444 0.250476 24.9972222 0.249714 25.0000000 0.251238 25.0027778 0.251238 25.0055556 0.252000 25.0083333 0.251238 25.0111111 0.248190 25.0138889 0.245905 25.0166667 0.246667 25.0194444 0.248190 25.0222222 0.248190 25.0250000 0.245143 25.0277778 0.243619 25.0305556 0.241333 25.0333333 0.243619 25.0361111 0.248190 25.0388889 0.250476 25.0416667 0.248952 25.0444444 0.242095 25.0472222 0.240571 25.0500000 0.237524 25.0527778 0.236000 25.0555556 0.236000 25.0583333 0.232952 25.0611111 0.231429 25.0638889 0.229905 25.0666667 0.232190 25.0694444 0.230667 25.0722222 0.233714 25.0750000 0.232190 25.0777778 0.231429 25.0805556 0.229905 25.0833333 0.229143 25.0861111 0.229905 25.0888889 0.230667 25.0916667 0.230667 25.0944444 0.229143 25.0972222 0.226857 25.1000000 0.229143 25.1027778 0.230667 25.1055556 0.230667 25.1083333 0.228381 25.1111111 0.228381 25.1138889 0.227619 25.1166667 0.226095 25.1194444 0.228381 25.1222222 0.226857 25.1250000 0.229905 25.1277778 0.226857 25.1305556 0.226095 25.1333333 0.226095 25.1361111 0.224571 25.1388889 0.220000 25.1416667 0.217714 25.1444444 0.213143 25.1472222 0.209333 25.1500000 0.203238 25.1527778 0.197905 25.1555556 0.204000 25.1583333 0.217714 25.1611111 0.236762 25.1638889 0.257333 25.1666667 0.287810 25.1694444 0.325143 25.1722222 0.366286 25.1750000 0.402857 25.1777778 0.421905 25.1805556 0.426476 25.1833333 0.400571 25.1861111 0.352571 25.1888889 0.293905 25.1916667 0.246667 25.1944444 0.219238 25.1972222 0.207810 25.2000000 0.204762 25.2027778 0.210095 25.2055556 0.216952 25.2083333 0.220762 25.2111111 0.222286 25.2138889 0.219238 25.2166667 0.221524 25.2194444 0.223810 25.2222222 0.224571 25.2250000 0.224571 25.2277778 0.223048 25.2305556 0.223048 25.2333333 0.223048 25.2361111 0.224571 25.2388889 0.223810 25.2416667 0.223810 25.2444444 0.223810 25.2472222 0.220762 25.2500000 0.223048 25.2527778 0.224571 25.2555556 0.224571 25.2583333 0.223810 25.2611111 0.222286 25.2638889 0.221524 25.2666667 0.222286 25.2694444 0.223810 25.2722222 0.226857 25.2750000 0.223810 25.2777778 0.223048 25.2805556 0.220762 25.2833333 0.221524 25.2861111 0.223048 25.2888889 0.225333 25.2916667 0.222286 25.2944444 0.223048 25.2972222 0.223810 25.3000000 0.223048 25.3027778 0.225333 25.3055556 0.226857 25.3083333 0.225333 25.3111111 0.226095 25.3138889 0.223810 25.3166667 0.223810 25.3194444 0.225333 25.3222222 0.226095 25.3250000 0.224571 25.3277778 0.223048 25.3305556 0.223048 25.3333333 0.222286 25.3361111 0.223810 25.3388889 0.225333 25.3416667 0.225333 25.3444444 0.223810 25.3472222 0.222286 25.3500000 0.221524 25.3527778 0.224571 25.3555556 0.224571 25.3583333 0.225333 25.3611111 0.221524 25.3638889 0.222286 25.3666667 0.223048 25.3694444 0.224571 25.3722222 0.224571 25.3750000 0.226095 25.3777778 0.225333 25.3805556 0.222286 25.3833333 0.224571 25.3861111 0.226095 25.3888889 0.226857 25.3916667 0.226857 25.3944444 0.224571 25.3972222 0.222286 25.4000000 0.220762 25.4027778 0.222286 25.4055556 0.223048 25.4083333 0.221524 25.4111111 0.220762 25.4138889 0.217714 25.4166667 0.217714 25.4194444 0.220762 25.4222222 0.219238 25.4250000 0.218476 25.4277778 0.217714 25.4305556 0.215429 25.4333333 0.215429 25.4361111 0.217714 25.4388889 0.217714 25.4416667 0.216952 25.4444444 0.217714 25.4472222 0.216190 25.4500000 0.217714 25.4527778 0.219238 25.4555556 0.219238 25.4583333 0.220000 25.4611111 0.220000 25.4638889 0.220762 25.4666667 0.222286 25.4694444 0.224571 25.4722222 0.226857 25.4750000 0.229143 25.4807778 0.300000 25.7303333 0.300000 25.7333333 0.236000 25.7361111 0.238286 25.7388889 0.239810 25.7416667 0.240571 25.7444444 0.237524 25.7472222 0.236762 25.7500000 0.236762 25.7527778 0.237524 25.7555556 0.240571 25.7583333 0.240571 25.7611111 0.239048 25.7638889 0.239810 25.7666667 0.239810 25.7694444 0.242857 25.7722222 0.243619 25.7750000 0.247429 25.7777778 0.246667 25.7805556 0.248190 25.7833333 0.249714 25.7861111 0.251238 25.7888889 0.254286 25.7916667 0.253524 25.7944444 0.251238 25.7972222 0.251238 25.8000000 0.252762 25.8027778 0.256571 25.8055556 0.258095 25.8083333 0.257333 25.8111111 0.255810 25.8138889 0.255048 25.8166667 0.253524 25.8194444 0.254286 25.8222222 0.254286 25.8250000 0.252762 25.8277778 0.252000 25.8305556 0.250476 25.8333333 0.253524 25.8361111 0.253524 25.8388889 0.252000 25.8416667 0.252000 25.8444444 0.252762 25.8472222 0.253524 25.8500000 0.258095 25.8527778 0.261143 25.8555556 0.260381 25.8583333 0.255048 25.8611111 0.250476 25.8638889 0.248190 25.8666667 0.246667 25.8694444 0.246667 25.8722222 0.245143 25.8750000 0.242857 25.8777778 0.242095 25.8805556 0.238286 25.8833333 0.239048 25.8861111 0.238286 25.8888889 0.240571 25.8916667 0.238286 25.8944444 0.236762 25.8972222 0.235238 25.9000000 0.236000 25.9027778 0.236762 25.9055556 0.236000 25.9083333 0.237524 25.9111111 0.235238 25.9138889 0.235238 25.9166667 0.234476 25.9194444 0.237524 25.9222222 0.237524 25.9250000 0.239048 25.9277778 0.236000 25.9305556 0.234476 25.9333333 0.235238 25.9361111 0.236762 25.9388889 0.234476 25.9416667 0.231429 25.9444444 0.225333 25.9472222 0.217714 25.9500000 0.216190 25.9527778 0.213143 25.9555556 0.209333 25.9583333 0.207810 25.9611111 0.215429 25.9638889 0.235238 25.9666667 0.261143 25.9694444 0.287810 25.9722222 0.324381 25.9750000 0.367810 25.9777778 0.407429 25.9805556 0.434857 25.9833333 0.453143 25.9861111 0.459238 25.9888889 0.448571 25.9916667 0.412762 25.9944444 0.353333 25.9972222 0.289333 26.0000000 0.238286 26.0027778 0.216190 26.0055556 0.214667 26.0083333 0.218476 26.0111111 0.223810 26.0138889 0.230667 26.0166667 0.230667 26.0194444 0.232190 26.0222222 0.232190 26.0250000 0.232952 26.0277778 0.230667 26.0305556 0.229143 26.0333333 0.229143 26.0361111 0.229143 26.0388889 0.229143 26.0416667 0.229143 26.0444444 0.226857 26.0472222 0.226095 26.0500000 0.226857 26.0527778 0.228381 26.0555556 0.228381 26.0583333 0.229905 26.0611111 0.229905 26.0638889 0.227619 26.0666667 0.227619 26.0694444 0.228381 26.0722222 0.230667 26.0750000 0.230667 26.0777778 0.229905 26.0805556 0.229905 26.0833333 0.229905 26.0861111 0.230667 26.0888889 0.231429 26.0916667 0.231429 26.0944444 0.230667 26.0972222 0.227619 26.1000000 0.229143 26.1027778 0.229143 26.1055556 0.231429 26.1083333 0.231429 26.1111111 0.230667 26.1138889 0.226857 26.1166667 0.228381 26.1194444 0.232190 26.1222222 0.233714 26.1250000 0.232952 26.1277778 0.231429 26.1305556 0.229905 26.1333333 0.229905 26.1361111 0.232190 26.1388889 0.234476 26.1416667 0.235238 26.1444444 0.231429 26.1472222 0.229905 26.1500000 0.230667 26.1527778 0.231429 26.1555556 0.232952 26.1583333 0.232190 26.1611111 0.232952 26.1638889 0.231429 26.1666667 0.232190 26.1694444 0.232952 26.1722222 0.233714 26.1750000 0.231429 26.1777778 0.231429 26.1805556 0.230667 26.1833333 0.230667 26.1861111 0.229905 26.1888889 0.231429 26.1916667 0.233714 26.1944444 0.229143 26.1972222 0.229143 26.2000000 0.231429 26.2027778 0.233714 26.2055556 0.234476 26.2083333 0.233714 26.2111111 0.231429 26.2138889 0.229143 26.2166667 0.229143 26.2194444 0.229905 26.2222222 0.230667 26.2250000 0.230667 26.2277778 0.229905 26.2305556 0.228381 26.2333333 0.228381 26.2361111 0.229905 26.2388889 0.231429 26.2416667 0.230667 26.2444444 0.229905 26.2472222 0.227619 26.2500000 0.229905 26.2527778 0.229905 26.2555556 0.231429 26.2583333 0.231429 26.2611111 0.232190 26.2638889 0.232190 26.2666667 0.233714 26.2694444 0.235238 26.2722222 0.236000 26.2750000 0.236762 26.2777778 0.239810 26.2805556 0.238286 26.2863333 0.300000 26.5053333 0.300000 26.5083333 0.242857 26.5111111 0.242095 26.5138889 0.240571 26.5166667 0.242095 26.5194444 0.242857 26.5222222 0.242857 26.5250000 0.244381 26.5277778 0.243619 26.5305556 0.243619 26.5333333 0.245905 26.5361111 0.245143 26.5388889 0.246667 26.5416667 0.248952 26.5444444 0.246667 26.5472222 0.246667 26.5500000 0.248190 26.5527778 0.251238 26.5555556 0.255048 26.5583333 0.255048 26.5611111 0.253524 26.5638889 0.252000 26.5666667 0.254286 26.5694444 0.256571 26.5722222 0.256571 26.5750000 0.256571 26.5777778 0.256571 26.5805556 0.258857 26.5833333 0.258095 26.5861111 0.260381 26.5888889 0.262667 26.5916667 0.261905 26.5944444 0.260381 26.5972222 0.258857 26.6000000 0.257333 26.6027778 0.257333 26.6055556 0.259619 26.6083333 0.259619 26.6111111 0.259619 26.6138889 0.258095 26.6166667 0.258857 26.6194444 0.261143 26.6222222 0.263429 26.6250000 0.264952 26.6277778 0.263429 26.6305556 0.258095 26.6333333 0.252762 26.6361111 0.253524 26.6388889 0.251238 26.6416667 0.249714 26.6444444 0.246667 26.6472222 0.243619 26.6500000 0.242857 26.6527778 0.244381 26.6555556 0.243619 26.6583333 0.243619 26.6611111 0.243619 26.6638889 0.242095 26.6666667 0.241333 26.6694444 0.242095 26.6722222 0.243619 26.6750000 0.245143 26.6777778 0.243619 26.6805556 0.241333 26.6833333 0.242857 26.6861111 0.242857 26.6888889 0.242095 26.6916667 0.242095 26.6944444 0.239810 26.6972222 0.239048 26.7000000 0.239048 26.7027778 0.240571 26.7055556 0.240571 26.7083333 0.240571 26.7111111 0.239810 26.7138889 0.236762 26.7166667 0.235238 26.7194444 0.233714 26.7222222 0.227619 26.7250000 0.223810 26.7277778 0.220000 26.7305556 0.213143 26.7333333 0.207810 26.7361111 0.209333 26.7388889 0.223810 26.7416667 0.245143 26.7444444 0.264952 26.7472222 0.291619 26.7500000 0.330476 26.7527778 0.376190 26.7555556 0.411238 26.7583333 0.430286 26.7611111 0.427238 26.7638889 0.394476 26.7666667 0.334286 26.7694444 0.275619 26.7722222 0.236762 26.7750000 0.220000 26.7777778 0.221524 26.7805556 0.228381 26.7833333 0.233714 26.7861111 0.236762 26.7888889 0.236762 26.7916667 0.237524 26.7944444 0.238286 26.7972222 0.236762 26.8000000 0.236000 26.8027778 0.236762 26.8055556 0.239048 26.8083333 0.236762 26.8111111 0.236000 26.8138889 0.234476 26.8166667 0.236000 26.8194444 0.238286 26.8222222 0.237524 26.8250000 0.239048 26.8277778 0.236762 26.8305556 0.234476 26.8333333 0.236000 26.8361111 0.235238 26.8388889 0.238286 26.8416667 0.237524 26.8444444 0.236000 26.8472222 0.233714 26.8500000 0.234476 26.8527778 0.235238 26.8555556 0.236762 26.8583333 0.236000 26.8611111 0.235238 26.8638889 0.233714 26.8666667 0.235238 26.8694444 0.236000 26.8722222 0.237524 26.8750000 0.237524 26.8777778 0.236000 26.8805556 0.235238 26.8833333 0.236762 26.8861111 0.238286 26.8888889 0.239048 26.8916667 0.238286 26.8944444 0.239048 26.8972222 0.237524 26.9000000 0.236000 26.9027778 0.238286 26.9055556 0.239810 26.9083333 0.236762 26.9111111 0.237524 26.9138889 0.234476 26.9166667 0.235238 26.9194444 0.236762 26.9222222 0.236762 26.9250000 0.237524 26.9277778 0.236000 26.9305556 0.234476 26.9333333 0.235238 26.9361111 0.237524 26.9388889 0.237524 26.9416667 0.239048 26.9444444 0.238286 26.9472222 0.236762 26.9500000 0.236000 26.9527778 0.238286 26.9555556 0.239048 26.9583333 0.240571 26.9611111 0.239048 26.9638889 0.239048 26.9666667 0.238286 26.9694444 0.239810 26.9722222 0.240571 26.9750000 0.238286 26.9777778 0.239048 26.9805556 0.234476 26.9833333 0.234476 26.9861111 0.236000 26.9888889 0.236762 26.9916667 0.238286 26.9944444 0.235238 26.9972222 0.233714 27.0000000 0.234476 27.0027778 0.235238 27.0055556 0.236762 27.0083333 0.235238 27.0111111 0.235238 27.0138889 0.232952 27.0166667 0.233714 27.0194444 0.236762 27.0222222 0.236762 27.0250000 0.235238 27.0277778 0.234476 27.0305556 0.233714 27.0333333 0.237524 27.0361111 0.239810 27.0388889 0.241333 27.0416667 0.242857 27.0444444 0.242095 27.0472222 0.241333 27.0500000 0.242095 27.0527778 0.244381 27.0555556 0.247429 27.0613333 0.300000 27.3053333 0.300000 27.3083333 0.242095 27.3111111 0.240571 27.3138889 0.239810 27.3166667 0.240571 27.3194444 0.245905 27.3222222 0.246667 27.3250000 0.245143 27.3277778 0.242857 27.3305556 0.241333 27.3333333 0.242095 27.3361111 0.242857 27.3388889 0.246667 27.3416667 0.245905 27.3444444 0.245905 27.3472222 0.245905 27.3500000 0.247429 27.3527778 0.249714 27.3555556 0.252000 27.3583333 0.252762 27.3611111 0.250476 27.3638889 0.252000 27.3666667 0.254286 27.3694444 0.256571 27.3722222 0.259619 27.3750000 0.261143 27.3777778 0.258857 27.3805556 0.259619 27.3833333 0.259619 27.3861111 0.261143 27.3888889 0.261143 27.3916667 0.259619 27.3944444 0.258095 27.3972222 0.255810 27.4000000 0.258095 27.4027778 0.258095 27.4055556 0.256571 27.4083333 0.255048 27.4111111 0.254286 27.4138889 0.255810 27.4166667 0.258857 27.4194444 0.258095 27.4222222 0.255048 27.4250000 0.252762 27.4277778 0.247429 27.4305556 0.244381 27.4333333 0.243619 27.4361111 0.240571 27.4388889 0.241333 27.4416667 0.239810 27.4444444 0.237524 27.4472222 0.236762 27.4500000 0.238286 27.4527778 0.239810 27.4555556 0.239048 27.4583333 0.238286 27.4611111 0.239048 27.4638889 0.238286 27.4666667 0.237524 27.4694444 0.240571 27.4722222 0.239810 27.4750000 0.239810 27.4777778 0.236762 27.4805556 0.234476 27.4833333 0.234476 27.4861111 0.236762 27.4888889 0.237524 27.4916667 0.238286 27.4944444 0.237524 27.4972222 0.237524 27.5000000 0.236000 27.5027778 0.237524 27.5055556 0.236762 27.5083333 0.235238 27.5111111 0.230667 27.5138889 0.223810 27.5166667 0.222286 27.5194444 0.220762 27.5222222 0.220762 27.5250000 0.213143 27.5277778 0.206286 27.5305556 0.200190 27.5333333 0.202476 27.5361111 0.213143 27.5388889 0.227619 27.5416667 0.245143 27.5444444 0.264190 27.5472222 0.293905 27.5500000 0.336571 27.5527778 0.378476 27.5555556 0.408190 27.5583333 0.421143 27.5611111 0.409714 27.5638889 0.366286 27.5666667 0.309905 27.5694444 0.261905 27.5722222 0.232190 27.5750000 0.218476 27.5777778 0.216190 27.5805556 0.222286 27.5833333 0.226857 27.5861111 0.231429 27.5888889 0.231429 27.5916667 0.232190 27.5944444 0.232952 27.5972222 0.230667 27.6000000 0.231429 27.6027778 0.231429 27.6055556 0.232952 27.6083333 0.232952 27.6111111 0.232190 27.6138889 0.231429 27.6166667 0.230667 27.6194444 0.232190 27.6222222 0.233714 27.6250000 0.234476 27.6277778 0.232952 27.6305556 0.230667 27.6333333 0.232190 27.6361111 0.232190 27.6388889 0.232952 27.6416667 0.233714 27.6444444 0.229905 27.6472222 0.229905 27.6500000 0.230667 27.6527778 0.229143 27.6555556 0.231429 27.6583333 0.232190 27.6611111 0.228381 27.6638889 0.226095 27.6666667 0.229143 27.6694444 0.229905 27.6722222 0.229905 27.6750000 0.231429 27.6777778 0.231429 27.6805556 0.228381 27.6833333 0.229905 27.6861111 0.230667 27.6888889 0.232952 27.6916667 0.233714 27.6944444 0.232190 27.6972222 0.231429 27.7000000 0.233714 27.7027778 0.232952 27.7055556 0.232190 27.7083333 0.232190 27.7111111 0.231429 27.7138889 0.231429 27.7166667 0.232952 27.7194444 0.233714 27.7222222 0.232952 27.7250000 0.232190 27.7277778 0.230667 27.7305556 0.227619 27.7333333 0.229905 27.7361111 0.231429 27.7388889 0.233714 27.7416667 0.232952 27.7444444 0.232190 27.7472222 0.230667 27.7500000 0.231429 27.7527778 0.233714 27.7555556 0.233714 27.7583333 0.231429 27.7611111 0.231429 27.7638889 0.229905 27.7666667 0.230667 27.7694444 0.232952 27.7722222 0.234476 27.7750000 0.235238 27.7777778 0.233714 27.7805556 0.229905 27.7833333 0.229143 27.7861111 0.232190 27.7888889 0.232952 27.7916667 0.232952 27.7944444 0.228381 27.7972222 0.226857 27.8000000 0.225333 27.8027778 0.226857 27.8055556 0.227619 27.8083333 0.226095 27.8111111 0.225333 27.8138889 0.224571 27.8166667 0.225333 27.8194444 0.225333 27.8222222 0.225333 27.8250000 0.224571 27.8277778 0.224571 27.8305556 0.222286 27.8333333 0.224571 27.8361111 0.224571 27.8388889 0.227619 27.8416667 0.227619 27.8444444 0.229143 27.8472222 0.227619 27.8500000 0.229143 27.8527778 0.234476 27.8555556 0.237524 27.8613333 0.300000 28.0942222 0.300000 28.0972222 0.240571 28.1000000 0.242095 28.1027778 0.242095 28.1055556 0.242857 28.1083333 0.242095 28.1111111 0.240571 28.1138889 0.237524 28.1166667 0.238286 28.1194444 0.239810 28.1222222 0.239810 28.1250000 0.241333 28.1277778 0.238286 28.1305556 0.238286 28.1333333 0.241333 28.1361111 0.243619 28.1388889 0.248952 28.1416667 0.250476 28.1444444 0.250476 28.1472222 0.247429 28.1500000 0.248952 28.1527778 0.250476 28.1555556 0.251238 28.1583333 0.251238 28.1611111 0.252762 28.1638889 0.252762 28.1666667 0.254286 28.1694444 0.255810 28.1722222 0.257333 28.1750000 0.256571 28.1777778 0.255048 28.1805556 0.253524 28.1833333 0.255048 28.1861111 0.255810 28.1888889 0.256571 28.1916667 0.255810 28.1944444 0.254286 28.1972222 0.252000 28.2000000 0.252762 28.2027778 0.252762 28.2055556 0.255810 28.2083333 0.258095 28.2111111 0.257333 28.2138889 0.254286 28.2166667 0.251238 28.2194444 0.248190 28.2222222 0.248190 28.2250000 0.243619 28.2277778 0.239810 28.2305556 0.236000 28.2333333 0.236762 28.2361111 0.235238 28.2388889 0.236762 28.2416667 0.237524 28.2444444 0.236000 28.2472222 0.235238 28.2500000 0.235238 28.2527778 0.234476 28.2555556 0.236762 28.2583333 0.237524 28.2611111 0.235238 28.2638889 0.232952 28.2666667 0.232190 28.2694444 0.233714 28.2722222 0.236000 28.2750000 0.237524 28.2777778 0.236000 28.2805556 0.233714 28.2833333 0.235238 28.2861111 0.235238 28.2888889 0.236762 28.2916667 0.236000 28.2944444 0.234476 28.2972222 0.233714 28.3000000 0.231429 28.3027778 0.228381 28.3055556 0.225333 28.3083333 0.220762 28.3111111 0.218476 28.3138889 0.215429 28.3166667 0.210095 28.3194444 0.206286 28.3222222 0.205524 28.3250000 0.215429 28.3277778 0.232190 28.3305556 0.250476 28.3333333 0.273333 28.3361111 0.303810 28.3388889 0.340381 28.3416667 0.382286 28.3444444 0.412000 28.3472222 0.429524 28.3500000 0.430286 28.3527778 0.403619 28.3555556 0.349524 28.3583333 0.287048 28.3611111 0.240571 28.3638889 0.220762 28.3666667 0.215429 28.3694444 0.219238 28.3722222 0.225333 28.3750000 0.230667 28.3777778 0.230667 28.3805556 0.229143 28.3833333 0.229143 28.3861111 0.231429 28.3888889 0.232952 28.3916667 0.231429 28.3944444 0.232190 28.3972222 0.229143 28.4000000 0.232952 28.4027778 0.231429 28.4055556 0.233714 28.4083333 0.232952 28.4111111 0.231429 28.4138889 0.229905 28.4166667 0.228381 28.4194444 0.230667 28.4222222 0.230667 28.4250000 0.229905 28.4277778 0.227619 28.4305556 0.226095 28.4333333 0.227619 28.4361111 0.229143 28.4388889 0.230667 28.4416667 0.229905 28.4444444 0.229905 28.4472222 0.229905 28.4500000 0.229905 28.4527778 0.229143 28.4555556 0.231429 28.4583333 0.230667 28.4611111 0.229905 28.4638889 0.226857 28.4666667 0.228381 28.4694444 0.229905 28.4722222 0.229143 28.4750000 0.230667 28.4777778 0.229905 28.4805556 0.228381 28.4833333 0.230667 28.4861111 0.231429 28.4888889 0.230667 28.4916667 0.230667 28.4944444 0.230667 28.4972222 0.228381 28.5000000 0.226857 28.5027778 0.228381 28.5055556 0.230667 28.5083333 0.229905 28.5111111 0.228381 28.5138889 0.226857 28.5166667 0.228381 28.5194444 0.229143 28.5222222 0.230667 28.5250000 0.229905 28.5277778 0.229905 28.5305556 0.229143 28.5333333 0.228381 28.5361111 0.230667 28.5388889 0.232190 28.5416667 0.232190 28.5444444 0.231429 28.5472222 0.230667 28.5500000 0.231429 28.5527778 0.232952 28.5555556 0.235238 28.5583333 0.233714 28.5611111 0.232952 28.5638889 0.231429 28.5666667 0.230667 28.5694444 0.230667 28.5722222 0.231429 28.5750000 0.232190 28.5777778 0.229905 28.5805556 0.229905 28.5833333 0.228381 28.5861111 0.229143 28.5888889 0.229905 28.5916667 0.229905 28.5944444 0.227619 28.5972222 0.225333 28.6000000 0.226857 28.6027778 0.226857 28.6055556 0.227619 28.6083333 0.226095 28.6111111 0.225333 28.6138889 0.223810 28.6166667 0.225333 28.6194444 0.226095 28.6222222 0.225333 28.6250000 0.225333 28.6277778 0.226857 28.6305556 0.223810 28.6333333 0.223810 28.6361111 0.222286 28.6388889 0.226857 28.6416667 0.225333 28.6444444 0.225333 28.6502222 0.300000 28.8472222 0.300000)
Vecg1 ecg_l1 0 PWL(0.0000000 0.300000 0.5608889 0.300000 0.5638889 0.267238 0.5666667 0.265714 0.5694444 0.267238 0.5722222 0.267238 0.5750000 0.267238 0.5777778 0.265714 0.5805556 0.265714 0.5833333 0.265714 0.5861111 0.268762 0.5888889 0.270286 0.5916667 0.268000 0.5944444 0.268000 0.5972222 0.267238 0.6000000 0.264190 0.6027778 0.264952 0.6055556 0.266476 0.6083333 0.266476 0.6111111 0.264952 0.6138889 0.265714 0.6166667 0.264952 0.6194444 0.267238 0.6222222 0.270286 0.6250000 0.270286 0.6277778 0.271048 0.6305556 0.269524 0.6333333 0.270286 0.6361111 0.272571 0.6388889 0.274095 0.6416667 0.272571 0.6444444 0.273333 0.6472222 0.270286 0.6500000 0.270286 0.6527778 0.274095 0.6555556 0.273333 0.6583333 0.273333 0.6611111 0.272571 0.6638889 0.271810 0.6666667 0.271810 0.6694444 0.273333 0.6722222 0.273333 0.6750000 0.273333 0.6777778 0.271048 0.6805556 0.268762 0.6833333 0.269524 0.6861111 0.268762 0.6888889 0.268762 0.6916667 0.267238 0.6944444 0.267238 0.6972222 0.265714 0.7000000 0.267238 0.7027778 0.268000 0.7055556 0.269524 0.7083333 0.267238 0.7111111 0.265714 0.7138889 0.262667 0.7166667 0.262667 0.7194444 0.261905 0.7222222 0.265714 0.7250000 0.264952 0.7277778 0.264190 0.7305556 0.263429 0.7333333 0.264190 0.7361111 0.264190 0.7388889 0.266476 0.7416667 0.264952 0.7444444 0.263429 0.7472222 0.263429 0.7500000 0.262667 0.7527778 0.265714 0.7555556 0.265714 0.7583333 0.264190 0.7611111 0.261905 0.7638889 0.258857 0.7666667 0.257333 0.7694444 0.255810 0.7722222 0.254286 0.7750000 0.249714 0.7777778 0.245143 0.7805556 0.245905 0.7833333 0.253524 0.7861111 0.268762 0.7888889 0.287810 0.7916667 0.302286 0.7944444 0.309905 0.7972222 0.317524 0.8000000 0.328952 0.8027778 0.345714 0.8055556 0.362476 0.8083333 0.375429 0.8111111 0.373905 0.8138889 0.354857 0.8166667 0.316000 0.8194444 0.274857 0.8222222 0.246667 0.8250000 0.231429 0.8277778 0.228381 0.8305556 0.231429 0.8333333 0.239810 0.8361111 0.247429 0.8388889 0.252762 0.8416667 0.255048 0.8444444 0.256571 0.8472222 0.255048 0.8500000 0.255048 0.8527778 0.257333 0.8555556 0.256571 0.8583333 0.256571 0.8611111 0.256571 0.8638889 0.255810 0.8666667 0.258095 0.8694444 0.258095 0.8722222 0.258095 0.8750000 0.258857 0.8777778 0.256571 0.8805556 0.255048 0.8833333 0.255810 0.8861111 0.258095 0.8888889 0.259619 0.8916667 0.259619 0.8944444 0.258095 0.8972222 0.255048 0.9000000 0.255810 0.9027778 0.256571 0.9055556 0.258857 0.9083333 0.259619 0.9111111 0.258095 0.9138889 0.257333 0.9166667 0.257333 0.9194444 0.258857 0.9222222 0.259619 0.9250000 0.258857 0.9277778 0.258857 0.9305556 0.257333 0.9333333 0.258857 0.9361111 0.259619 0.9388889 0.259619 0.9416667 0.259619 0.9444444 0.258857 0.9472222 0.256571 0.9500000 0.256571 0.9527778 0.259619 0.9555556 0.259619 0.9583333 0.261143 0.9611111 0.258095 0.9638889 0.258095 0.9666667 0.257333 0.9694444 0.258857 0.9722222 0.259619 0.9750000 0.258095 0.9777778 0.256571 0.9805556 0.257333 0.9833333 0.257333 0.9861111 0.258095 0.9888889 0.258095 0.9916667 0.258095 0.9944444 0.256571 0.9972222 0.255048 1.0000000 0.255048 1.0027778 0.258095 1.0055556 0.258095 1.0083333 0.256571 1.0111111 0.255810 1.0138889 0.252000 1.0166667 0.252000 1.0194444 0.253524 1.0222222 0.255810 1.0250000 0.252762 1.0277778 0.251238 1.0305556 0.251238 1.0333333 0.248952 1.0361111 0.249714 1.0388889 0.250476 1.0416667 0.247429 1.0444444 0.246667 1.0472222 0.244381 1.0500000 0.243619 1.0527778 0.245905 1.0555556 0.245143 1.0583333 0.243619 1.0611111 0.240571 1.0638889 0.239810 1.0666667 0.239048 1.0694444 0.240571 1.0722222 0.241333 1.0750000 0.240571 1.0777778 0.239048 1.0805556 0.237524 1.0833333 0.236000 1.0861111 0.238286 1.0888889 0.237524 1.0916667 0.237524 1.0944444 0.239048 1.0972222 0.238286 1.1000000 0.240571 1.1027778 0.241333 1.1055556 0.244381 1.1083333 0.245905 1.1111111 0.247429 1.1168889 0.300000 1.3720000 0.300000 1.3750000 0.269524 1.3777778 0.264952 1.3805556 0.266476 1.3833333 0.267238 1.3861111 0.268762 1.3888889 0.269524 1.3916667 0.268762 1.3944444 0.266476 1.3972222 0.266476 1.4000000 0.265714 1.4027778 0.268762 1.4055556 0.269524 1.4083333 0.269524 1.4111111 0.268000 1.4138889 0.264952 1.4166667 0.267238 1.4194444 0.269524 1.4222222 0.269524 1.4250000 0.268762 1.4277778 0.268000 1.4305556 0.267238 1.4333333 0.266476 1.4361111 0.268762 1.4388889 0.269524 1.4416667 0.270286 1.4444444 0.268762 1.4472222 0.268762 1.4500000 0.268762 1.4527778 0.272571 1.4555556 0.274095 1.4583333 0.271048 1.4611111 0.271048 1.4638889 0.269524 1.4666667 0.271810 1.4694444 0.274857 1.4722222 0.277905 1.4750000 0.277905 1.4777778 0.274095 1.4805556 0.273333 1.4833333 0.274095 1.4861111 0.274857 1.4888889 0.277143 1.4916667 0.275619 1.4944444 0.273333 1.4972222 0.271048 1.5000000 0.271048 1.5027778 0.271810 1.5055556 0.271810 1.5083333 0.273333 1.5111111 0.270286 1.5138889 0.267238 1.5166667 0.268762 1.5194444 0.269524 1.5222222 0.270286 1.5250000 0.268762 1.5277778 0.268000 1.5305556 0.266476 1.5333333 0.267238 1.5361111 0.268000 1.5388889 0.268762 1.5416667 0.269524 1.5444444 0.268000 1.5472222 0.266476 1.5500000 0.266476 1.5527778 0.266476 1.5555556 0.269524 1.5583333 0.268762 1.5611111 0.267238 1.5638889 0.265714 1.5666667 0.266476 1.5694444 0.267238 1.5722222 0.268762 1.5750000 0.266476 1.5777778 0.265714 1.5805556 0.263429 1.5833333 0.260381 1.5861111 0.257333 1.5888889 0.254286 1.5916667 0.247429 1.5944444 0.242857 1.5972222 0.247429 1.6000000 0.260381 1.6027778 0.280952 1.6055556 0.303810 1.6083333 0.322095 1.6111111 0.339619 1.6138889 0.357143 1.6166667 0.376952 1.6194444 0.396762 1.6222222 0.407429 1.6250000 0.392952 1.6277778 0.348762 1.6305556 0.293143 1.6333333 0.261905 1.6361111 0.258857 1.6388889 0.263429 1.6416667 0.263429 1.6444444 0.261905 1.6472222 0.261143 1.6500000 0.262667 1.6527778 0.262667 1.6555556 0.262667 1.6583333 0.261143 1.6611111 0.260381 1.6638889 0.260381 1.6666667 0.258857 1.6694444 0.262667 1.6722222 0.262667 1.6750000 0.261905 1.6777778 0.259619 1.6805556 0.258857 1.6833333 0.258857 1.6861111 0.259619 1.6888889 0.260381 1.6916667 0.260381 1.6944444 0.258857 1.6972222 0.257333 1.7000000 0.257333 1.7027778 0.258857 1.7055556 0.261143 1.7083333 0.259619 1.7111111 0.257333 1.7138889 0.255810 1.7166667 0.258095 1.7194444 0.259619 1.7222222 0.261143 1.7250000 0.260381 1.7277778 0.260381 1.7305556 0.257333 1.7333333 0.257333 1.7361111 0.259619 1.7388889 0.260381 1.7416667 0.261143 1.7444444 0.260381 1.7472222 0.258095 1.7500000 0.258857 1.7527778 0.258095 1.7555556 0.259619 1.7583333 0.259619 1.7611111 0.258857 1.7638889 0.257333 1.7666667 0.256571 1.7694444 0.257333 1.7722222 0.261143 1.7750000 0.258857 1.7777778 0.257333 1.7805556 0.255810 1.7833333 0.255810 1.7861111 0.258857 1.7888889 0.258857 1.7916667 0.256571 1.7944444 0.254286 1.7972222 0.254286 1.8000000 0.254286 1.8027778 0.255048 1.8055556 0.258095 1.8083333 0.255048 1.8111111 0.254286 1.8138889 0.252762 1.8166667 0.252762 1.8194444 0.252000 1.8222222 0.252762 1.8250000 0.252762 1.8277778 0.248952 1.8305556 0.247429 1.8333333 0.245905 1.8361111 0.246667 1.8388889 0.247429 1.8416667 0.245143 1.8444444 0.243619 1.8472222 0.242857 1.8500000 0.241333 1.8527778 0.243619 1.8555556 0.243619 1.8583333 0.241333 1.8611111 0.239048 1.8638889 0.236762 1.8666667 0.238286 1.8694444 0.237524 1.8722222 0.240571 1.8750000 0.238286 1.8777778 0.237524 1.8805556 0.235238 1.8833333 0.236000 1.8861111 0.237524 1.8888889 0.238286 1.8916667 0.239048 1.8944444 0.239048 1.8972222 0.238286 1.9000000 0.241333 1.9027778 0.244381 1.9055556 0.247429 1.9083333 0.248952 1.9111111 0.250476 1.9138889 0.252762 1.9166667 0.255048 1.9194444 0.258095 1.9222222 0.261143 1.9280000 0.300000 2.1608889 0.300000 2.1638889 0.264190 2.1666667 0.264952 2.1694444 0.265714 2.1722222 0.265714 2.1750000 0.265714 2.1777778 0.265714 2.1805556 0.264952 2.1833333 0.264952 2.1861111 0.267238 2.1888889 0.268000 2.1916667 0.265714 2.1944444 0.263429 2.1972222 0.264190 2.2000000 0.263429 2.2027778 0.265714 2.2055556 0.267238 2.2083333 0.266476 2.2111111 0.266476 2.2138889 0.264952 2.2166667 0.264952 2.2194444 0.268762 2.2222222 0.269524 2.2250000 0.268762 2.2277778 0.270286 2.2305556 0.268000 2.2333333 0.268762 2.2361111 0.271048 2.2388889 0.271810 2.2416667 0.269524 2.2444444 0.270286 2.2472222 0.269524 2.2500000 0.271048 2.2527778 0.274095 2.2555556 0.278667 2.2583333 0.274857 2.2611111 0.274857 2.2638889 0.271810 2.2666667 0.272571 2.2694444 0.274095 2.2722222 0.277143 2.2750000 0.274857 2.2777778 0.272571 2.2805556 0.269524 2.2833333 0.268000 2.2861111 0.268000 2.2888889 0.271810 2.2916667 0.271048 2.2944444 0.269524 2.2972222 0.267238 2.3000000 0.266476 2.3027778 0.268000 2.3055556 0.270286 2.3083333 0.268762 2.3111111 0.266476 2.3138889 0.265714 2.3166667 0.264952 2.3194444 0.266476 2.3222222 0.268000 2.3250000 0.268000 2.3277778 0.264952 2.3305556 0.264190 2.3333333 0.264952 2.3361111 0.265714 2.3388889 0.267238 2.3416667 0.266476 2.3444444 0.266476 2.3472222 0.264952 2.3500000 0.263429 2.3527778 0.266476 2.3555556 0.265714 2.3583333 0.264190 2.3611111 0.261905 2.3638889 0.257333 2.3666667 0.253524 2.3694444 0.250476 2.3722222 0.247429 2.3750000 0.242857 2.3777778 0.236762 2.3805556 0.235238 2.3833333 0.241333 2.3861111 0.255048 2.3888889 0.272571 2.3916667 0.290095 2.3944444 0.305333 2.3972222 0.319810 2.4000000 0.336571 2.4027778 0.356381 2.4055556 0.375429 2.4083333 0.392952 2.4111111 0.399810 2.4138889 0.383048 2.4166667 0.335048 2.4194444 0.284000 2.4222222 0.257333 2.4250000 0.256571 2.4277778 0.261143 2.4305556 0.261143 2.4333333 0.260381 2.4361111 0.264952 2.4388889 0.266476 2.4416667 0.262667 2.4444444 0.261143 2.4472222 0.260381 2.4500000 0.261905 2.4527778 0.264190 2.4555556 0.262667 2.4583333 0.262667 2.4611111 0.260381 2.4638889 0.259619 2.4666667 0.259619 2.4694444 0.260381 2.4722222 0.263429 2.4750000 0.262667 2.4777778 0.260381 2.4805556 0.258857 2.4833333 0.258857 2.4861111 0.261143 2.4888889 0.261143 2.4916667 0.261905 2.4944444 0.259619 2.4972222 0.258857 2.5000000 0.258857 2.5027778 0.259619 2.5055556 0.261905 2.5083333 0.262667 2.5111111 0.259619 2.5138889 0.258857 2.5166667 0.260381 2.5194444 0.261143 2.5222222 0.262667 2.5250000 0.261905 2.5277778 0.260381 2.5305556 0.258857 2.5333333 0.260381 2.5361111 0.261143 2.5388889 0.261905 2.5416667 0.261143 2.5444444 0.261143 2.5472222 0.258095 2.5500000 0.258857 2.5527778 0.259619 2.5555556 0.260381 2.5583333 0.260381 2.5611111 0.258095 2.5638889 0.258857 2.5666667 0.260381 2.5694444 0.262667 2.5722222 0.261143 2.5750000 0.259619 2.5777778 0.259619 2.5805556 0.258857 2.5833333 0.259619 2.5861111 0.260381 2.5888889 0.258857 2.5916667 0.259619 2.5944444 0.258857 2.5972222 0.257333 2.6000000 0.256571 2.6027778 0.257333 2.6055556 0.256571 2.6083333 0.255810 2.6111111 0.252762 2.6138889 0.253524 2.6166667 0.254286 2.6194444 0.254286 2.6222222 0.252762 2.6250000 0.250476 2.6277778 0.248190 2.6305556 0.248190 2.6333333 0.250476 2.6361111 0.251238 2.6388889 0.245905 2.6416667 0.245143 2.6444444 0.242095 2.6472222 0.241333 2.6500000 0.242857 2.6527778 0.244381 2.6555556 0.242857 2.6583333 0.241333 2.6611111 0.240571 2.6638889 0.239810 2.6666667 0.241333 2.6694444 0.242857 2.6722222 0.242857 2.6750000 0.242857 2.6777778 0.242095 2.6805556 0.244381 2.6833333 0.247429 2.6861111 0.248952 2.6888889 0.252000 2.6916667 0.252762 2.6944444 0.253524 2.6972222 0.255810 2.7000000 0.258857 2.7027778 0.261143 2.7055556 0.261905 2.7083333 0.262667 2.7111111 0.264190 2.7168889 0.300000 2.9525556 0.300000 2.9555556 0.264952 2.9583333 0.264190 2.9611111 0.262667 2.9638889 0.261905 2.9666667 0.262667 2.9694444 0.264952 2.9722222 0.264952 2.9750000 0.264190 2.9777778 0.261905 2.9805556 0.261905 2.9833333 0.263429 2.9861111 0.265714 2.9888889 0.264952 2.9916667 0.264190 2.9944444 0.263429 2.9972222 0.262667 3.0000000 0.263429 3.0027778 0.265714 3.0055556 0.265714 3.0083333 0.264952 3.0111111 0.264952 3.0138889 0.265714 3.0166667 0.268762 3.0194444 0.268000 3.0222222 0.266476 3.0250000 0.268762 3.0277778 0.266476 3.0305556 0.266476 3.0333333 0.268000 3.0361111 0.271048 3.0388889 0.272571 3.0416667 0.272571 3.0444444 0.271810 3.0472222 0.271048 3.0500000 0.271048 3.0527778 0.271810 3.0555556 0.268762 3.0583333 0.269524 3.0611111 0.266476 3.0638889 0.266476 3.0666667 0.266476 3.0694444 0.268000 3.0722222 0.265714 3.0750000 0.266476 3.0777778 0.263429 3.0805556 0.262667 3.0833333 0.264190 3.0861111 0.264952 3.0888889 0.262667 3.0916667 0.262667 3.0944444 0.261905 3.0972222 0.261143 3.1000000 0.264952 3.1027778 0.265714 3.1055556 0.264952 3.1083333 0.262667 3.1111111 0.261143 3.1138889 0.259619 3.1166667 0.261143 3.1194444 0.262667 3.1222222 0.260381 3.1250000 0.261905 3.1277778 0.260381 3.1305556 0.258857 3.1333333 0.263429 3.1361111 0.262667 3.1388889 0.261905 3.1416667 0.261905 3.1444444 0.261905 3.1472222 0.259619 3.1500000 0.261143 3.1527778 0.262667 3.1555556 0.261143 3.1583333 0.259619 3.1611111 0.257333 3.1638889 0.253524 3.1666667 0.251238 3.1694444 0.246667 3.1722222 0.242095 3.1750000 0.240571 3.1777778 0.247429 3.1805556 0.263429 3.1833333 0.283238 3.1861111 0.296952 3.1888889 0.306095 3.1916667 0.316762 3.1944444 0.333524 3.1972222 0.353333 3.2000000 0.367048 3.2027778 0.360190 3.2055556 0.323619 3.2083333 0.274095 3.2111111 0.242095 3.2138889 0.237524 3.2166667 0.245905 3.2194444 0.251238 3.2222222 0.253524 3.2250000 0.254286 3.2277778 0.255048 3.2305556 0.255048 3.2333333 0.256571 3.2361111 0.254286 3.2388889 0.252762 3.2416667 0.253524 3.2444444 0.253524 3.2472222 0.255048 3.2500000 0.258857 3.2527778 0.258857 3.2555556 0.256571 3.2583333 0.253524 3.2611111 0.252762 3.2638889 0.254286 3.2666667 0.255810 3.2694444 0.258095 3.2722222 0.256571 3.2750000 0.256571 3.2777778 0.253524 3.2805556 0.255810 3.2833333 0.255810 3.2861111 0.256571 3.2888889 0.256571 3.2916667 0.255810 3.2944444 0.254286 3.2972222 0.255048 3.3000000 0.256571 3.3027778 0.258095 3.3055556 0.255810 3.3083333 0.255048 3.3111111 0.258095 3.3138889 0.256571 3.3166667 0.256571 3.3194444 0.260381 3.3222222 0.258857 3.3250000 0.259619 3.3277778 0.256571 3.3305556 0.255810 3.3333333 0.255048 3.3361111 0.257333 3.3388889 0.255810 3.3416667 0.255048 3.3444444 0.254286 3.3472222 0.252762 3.3500000 0.253524 3.3527778 0.255048 3.3555556 0.254286 3.3583333 0.257333 3.3611111 0.255810 3.3638889 0.253524 3.3666667 0.255810 3.3694444 0.256571 3.3722222 0.253524 3.3750000 0.252762 3.3777778 0.252000 3.3805556 0.253524 3.3833333 0.255048 3.3861111 0.255810 3.3888889 0.255048 3.3916667 0.254286 3.3944444 0.253524 3.3972222 0.250476 3.4000000 0.252762 3.4027778 0.254286 3.4055556 0.252762 3.4083333 0.248952 3.4111111 0.248190 3.4138889 0.246667 3.4166667 0.245905 3.4194444 0.248190 3.4222222 0.246667 3.4250000 0.244381 3.4277778 0.242095 3.4305556 0.239048 3.4333333 0.241333 3.4361111 0.242095 3.4388889 0.240571 3.4416667 0.239048 3.4444444 0.238286 3.4472222 0.238286 3.4500000 0.238286 3.4527778 0.236762 3.4555556 0.236762 3.4583333 0.236000 3.4611111 0.236762 3.4638889 0.235238 3.4666667 0.237524 3.4694444 0.239810 3.4722222 0.241333 3.4750000 0.238286 3.4777778 0.239810 3.4805556 0.239810 3.4833333 0.242857 3.4861111 0.243619 3.4888889 0.242857 3.4916667 0.242857 3.4944444 0.243619 3.4972222 0.245143 3.5000000 0.247429 3.5027778 0.251238 3.5085556 0.300000 3.7414444 0.300000 3.7444444 0.258857 3.7472222 0.259619 3.7500000 0.261143 3.7527778 0.262667 3.7555556 0.261143 3.7583333 0.258095 3.7611111 0.258095 3.7638889 0.258095 3.7666667 0.261143 3.7694444 0.261143 3.7722222 0.260381 3.7750000 0.259619 3.7777778 0.256571 3.7805556 0.257333 3.7833333 0.259619 3.7861111 0.260381 3.7888889 0.261143 3.7916667 0.261905 3.7944444 0.261143 3.7972222 0.261905 3.8000000 0.263429 3.8027778 0.264952 3.8055556 0.264190 3.8083333 0.265714 3.8111111 0.264190 3.8138889 0.263429 3.8166667 0.265714 3.8194444 0.267238 3.8222222 0.264190 3.8250000 0.264952 3.8277778 0.265714 3.8305556 0.267238 3.8333333 0.268762 3.8361111 0.269524 3.8388889 0.268000 3.8416667 0.265714 3.8444444 0.264952 3.8472222 0.265714 3.8500000 0.267238 3.8527778 0.268000 3.8555556 0.264190 3.8583333 0.263429 3.8611111 0.261143 3.8638889 0.262667 3.8666667 0.264190 3.8694444 0.264952 3.8722222 0.264190 3.8750000 0.262667 3.8777778 0.258857 3.8805556 0.260381 3.8833333 0.261905 3.8861111 0.263429 3.8888889 0.263429 3.8916667 0.261143 3.8944444 0.260381 3.8972222 0.259619 3.9000000 0.261143 3.9027778 0.262667 3.9055556 0.262667 3.9083333 0.260381 3.9111111 0.261143 3.9138889 0.260381 3.9166667 0.261143 3.9194444 0.263429 3.9222222 0.263429 3.9250000 0.260381 3.9277778 0.260381 3.9305556 0.261905 3.9333333 0.263429 3.9361111 0.264190 3.9388889 0.263429 3.9416667 0.261143 3.9444444 0.258857 3.9472222 0.256571 3.9500000 0.255810 3.9527778 0.252762 3.9555556 0.249714 3.9583333 0.244381 3.9611111 0.243619 3.9638889 0.246667 3.9666667 0.260381 3.9694444 0.279429 3.9722222 0.296952 3.9750000 0.305333 3.9777778 0.314476 3.9805556 0.328190 3.9833333 0.348000 3.9861111 0.368571 3.9888889 0.378476 3.9916667 0.368571 3.9944444 0.326667 3.9972222 0.272571 4.0000000 0.241333 4.0027778 0.239810 4.0055556 0.247429 4.0083333 0.252762 4.0111111 0.255810 4.0138889 0.258095 4.0166667 0.259619 4.0194444 0.264190 4.0222222 0.261905 4.0250000 0.259619 4.0277778 0.261143 4.0305556 0.262667 4.0333333 0.263429 4.0361111 0.263429 4.0388889 0.261905 4.0416667 0.260381 4.0444444 0.259619 4.0472222 0.258095 4.0500000 0.261143 4.0527778 0.263429 4.0555556 0.262667 4.0583333 0.260381 4.0611111 0.260381 4.0638889 0.259619 4.0666667 0.261905 4.0694444 0.261905 4.0722222 0.262667 4.0750000 0.261905 4.0777778 0.259619 4.0805556 0.261143 4.0833333 0.261905 4.0861111 0.262667 4.0888889 0.262667 4.0916667 0.261143 4.0944444 0.260381 4.0972222 0.261905 4.1000000 0.263429 4.1027778 0.267238 4.1055556 0.264952 4.1083333 0.261905 4.1111111 0.261905 4.1138889 0.261143 4.1166667 0.263429 4.1194444 0.266476 4.1222222 0.264190 4.1250000 0.264190 4.1277778 0.263429 4.1305556 0.261143 4.1333333 0.262667 4.1361111 0.265714 4.1388889 0.264952 4.1416667 0.264190 4.1444444 0.263429 4.1472222 0.263429 4.1500000 0.263429 4.1527778 0.264952 4.1555556 0.262667 4.1583333 0.261143 4.1611111 0.261905 4.1638889 0.261905 4.1666667 0.264190 4.1694444 0.263429 4.1722222 0.264190 4.1750000 0.261143 4.1777778 0.261143 4.1805556 0.261143 4.1833333 0.261905 4.1861111 0.264190 4.1888889 0.260381 4.1916667 0.261143 4.1944444 0.258857 4.1972222 0.256571 4.2000000 0.256571 4.2027778 0.257333 4.2055556 0.256571 4.2083333 0.256571 4.2111111 0.253524 4.2138889 0.255048 4.2166667 0.256571 4.2194444 0.255810 4.2222222 0.253524 4.2250000 0.251238 4.2277778 0.248952 4.2305556 0.248190 4.2333333 0.252000 4.2361111 0.252000 4.2388889 0.249714 4.2416667 0.247429 4.2444444 0.246667 4.2472222 0.245905 4.2500000 0.244381 4.2527778 0.245905 4.2555556 0.244381 4.2583333 0.243619 4.2611111 0.242857 4.2638889 0.242857 4.2666667 0.243619 4.2694444 0.245905 4.2722222 0.245143 4.2750000 0.248190 4.2777778 0.248190 4.2805556 0.249714 4.2833333 0.252000 4.2861111 0.255810 4.2888889 0.258095 4.2916667 0.259619 4.2974444 0.300000 4.5581111 0.300000 4.5611111 0.274857 4.5638889 0.275619 4.5666667 0.275619 4.5694444 0.277905 4.5722222 0.277143 4.5750000 0.277143 4.5777778 0.275619 4.5805556 0.275619 4.5833333 0.277143 4.5861111 0.277143 4.5888889 0.277143 4.5916667 0.276381 4.5944444 0.275619 4.5972222 0.275619 4.6000000 0.277143 4.6027778 0.280190 4.6055556 0.277143 4.6083333 0.276381 4.6111111 0.275619 4.6138889 0.277143 4.6166667 0.280952 4.6194444 0.281714 4.6222222 0.282476 4.6250000 0.280952 4.6277778 0.279429 4.6305556 0.278667 4.6333333 0.280190 4.6361111 0.284000 4.6388889 0.284000 4.6416667 0.284762 4.6444444 0.284000 4.6472222 0.286286 4.6500000 0.287810 4.6527778 0.288571 4.6555556 0.286286 4.6583333 0.286286 4.6611111 0.284762 4.6638889 0.284762 4.6666667 0.285524 4.6694444 0.286286 4.6722222 0.283238 4.6750000 0.280952 4.6777778 0.280190 4.6805556 0.281714 4.6833333 0.281714 4.6861111 0.283238 4.6888889 0.283238 4.6916667 0.281714 4.6944444 0.280190 4.6972222 0.278667 4.7000000 0.277905 4.7027778 0.280952 4.7055556 0.280190 4.7083333 0.277143 4.7111111 0.277905 4.7138889 0.278667 4.7166667 0.278667 4.7194444 0.281714 4.7222222 0.279429 4.7250000 0.277905 4.7277778 0.275619 4.7305556 0.277143 4.7333333 0.279429 4.7361111 0.280952 4.7388889 0.279429 4.7416667 0.277905 4.7444444 0.277143 4.7472222 0.275619 4.7500000 0.277905 4.7527778 0.279429 4.7555556 0.279429 4.7583333 0.280952 4.7611111 0.275619 4.7638889 0.273333 4.7666667 0.270286 4.7694444 0.268000 4.7722222 0.264952 4.7750000 0.258857 4.7777778 0.255810 4.7805556 0.257333 4.7833333 0.270286 4.7861111 0.292381 4.7888889 0.312952 4.7916667 0.329714 4.7944444 0.346476 4.7972222 0.364000 4.8000000 0.386095 4.8027778 0.407429 4.8055556 0.421905 4.8083333 0.421143 4.8111111 0.390667 4.8138889 0.335810 4.8166667 0.288571 4.8194444 0.271048 4.8222222 0.271810 4.8250000 0.276381 4.8277778 0.274095 4.8305556 0.274857 4.8333333 0.276381 4.8361111 0.277905 4.8388889 0.276381 4.8416667 0.271048 4.8444444 0.269524 4.8472222 0.270286 4.8500000 0.273333 4.8527778 0.273333 4.8555556 0.272571 4.8583333 0.271810 4.8611111 0.269524 4.8638889 0.270286 4.8666667 0.269524 4.8694444 0.270286 4.8722222 0.271048 4.8750000 0.270286 4.8777778 0.269524 4.8805556 0.269524 4.8833333 0.271048 4.8861111 0.272571 4.8888889 0.271810 4.8916667 0.270286 4.8944444 0.268000 4.8972222 0.268000 4.9000000 0.273333 4.9027778 0.271048 4.9055556 0.271810 4.9083333 0.271810 4.9111111 0.270286 4.9138889 0.269524 4.9166667 0.270286 4.9194444 0.272571 4.9222222 0.271048 4.9250000 0.270286 4.9277778 0.271048 4.9305556 0.270286 4.9333333 0.273333 4.9361111 0.273333 4.9388889 0.271810 4.9416667 0.271048 4.9444444 0.270286 4.9472222 0.271048 4.9500000 0.271810 4.9527778 0.274095 4.9555556 0.274095 4.9583333 0.271048 4.9611111 0.269524 4.9638889 0.269524 4.9666667 0.272571 4.9694444 0.273333 4.9722222 0.270286 4.9750000 0.273333 4.9777778 0.271048 4.9805556 0.271048 4.9833333 0.271048 4.9861111 0.272571 4.9888889 0.271048 4.9916667 0.268000 4.9944444 0.268762 4.9972222 0.269524 5.0000000 0.268000 5.0027778 0.270286 5.0055556 0.268762 5.0083333 0.267238 5.0111111 0.264952 5.0138889 0.267238 5.0166667 0.265714 5.0194444 0.268762 5.0222222 0.267238 5.0250000 0.264190 5.0277778 0.262667 5.0305556 0.262667 5.0333333 0.263429 5.0361111 0.262667 5.0388889 0.264190 5.0416667 0.260381 5.0444444 0.259619 5.0472222 0.258857 5.0500000 0.259619 5.0527778 0.259619 5.0555556 0.258857 5.0583333 0.256571 5.0611111 0.254286 5.0638889 0.255048 5.0666667 0.255048 5.0694444 0.255048 5.0722222 0.253524 5.0750000 0.252762 5.0777778 0.251238 5.0805556 0.250476 5.0833333 0.251238 5.0861111 0.252762 5.0888889 0.251238 5.0916667 0.251238 5.0944444 0.250476 5.0972222 0.252762 5.1000000 0.257333 5.1027778 0.257333 5.1055556 0.257333 5.1083333 0.259619 5.1141111 0.300000 5.2108889 0.300000 5.2138889 0.281714 5.2166667 0.282476 5.2194444 0.284000 5.2222222 0.283238 5.2250000 0.280952 5.2277778 0.282476 5.2305556 0.280190 5.2333333 0.282476 5.2361111 0.285524 5.2388889 0.284762 5.2416667 0.283238 5.2444444 0.282476 5.2472222 0.282476 5.2500000 0.284000 5.2527778 0.284762 5.2555556 0.283238 5.2583333 0.284762 5.2611111 0.284762 5.2638889 0.284000 5.2666667 0.285524 5.2694444 0.285524 5.2722222 0.285524 5.2750000 0.283238 5.2777778 0.282476 5.2805556 0.283238 5.2833333 0.284000 5.2861111 0.284000 5.2888889 0.282476 5.2916667 0.282476 5.2944444 0.279429 5.2972222 0.280952 5.3000000 0.279429 5.3027778 0.280952 5.3055556 0.280190 5.3083333 0.277143 5.3111111 0.276381 5.3138889 0.274857 5.3166667 0.274857 5.3194444 0.274095 5.3222222 0.273333 5.3250000 0.274095 5.3277778 0.273333 5.3305556 0.274095 5.3333333 0.274857 5.3361111 0.275619 5.3388889 0.275619 5.3416667 0.274095 5.3444444 0.272571 5.3472222 0.274095 5.3500000 0.276381 5.3527778 0.276381 5.3555556 0.275619 5.3583333 0.275619 5.3611111 0.273333 5.3638889 0.274095 5.3666667 0.276381 5.3694444 0.277143 5.3722222 0.275619 5.3750000 0.276381 5.3777778 0.274857 5.3805556 0.275619 5.3833333 0.277143 5.3861111 0.277143 5.3888889 0.277905 5.3916667 0.276381 5.3944444 0.274857 5.3972222 0.276381 5.4000000 0.279429 5.4027778 0.280190 5.4055556 0.277905 5.4083333 0.276381 5.4111111 0.275619 5.4138889 0.275619 5.4166667 0.273333 5.4194444 0.271048 5.4222222 0.264190 5.4250000 0.261905 5.4277778 0.255048 5.4305556 0.252000 5.4333333 0.255048 5.4361111 0.271048 5.4388889 0.287048 5.4416667 0.309143 5.4444444 0.326667 5.4472222 0.340381 5.4500000 0.357905 5.4527778 0.373905 5.4555556 0.389905 5.4583333 0.401333 5.4611111 0.401333 5.4638889 0.376190 5.4666667 0.331238 5.4694444 0.288571 5.4722222 0.267238 5.4750000 0.268762 5.4777778 0.272571 5.4805556 0.273333 5.4833333 0.274857 5.4861111 0.277905 5.4888889 0.277905 5.4916667 0.275619 5.4944444 0.274857 5.4972222 0.274095 5.5000000 0.276381 5.5027778 0.276381 5.5055556 0.276381 5.5083333 0.274095 5.5111111 0.273333 5.5138889 0.274095 5.5166667 0.276381 5.5194444 0.276381 5.5222222 0.275619 5.5250000 0.274857 5.5277778 0.272571 5.5305556 0.273333 5.5333333 0.274095 5.5361111 0.275619 5.5388889 0.275619 5.5416667 0.274095 5.5444444 0.272571 5.5472222 0.272571 5.5500000 0.274095 5.5527778 0.274857 5.5555556 0.274857 5.5583333 0.273333 5.5611111 0.272571 5.5638889 0.271810 5.5666667 0.274095 5.5694444 0.275619 5.5722222 0.274857 5.5750000 0.273333 5.5777778 0.273333 5.5805556 0.273333 5.5833333 0.272571 5.5861111 0.274095 5.5888889 0.275619 5.5916667 0.274095 5.5944444 0.272571 5.5972222 0.271810 5.6000000 0.274095 5.6027778 0.275619 5.6055556 0.272571 5.6083333 0.272571 5.6111111 0.271810 5.6138889 0.271810 5.6166667 0.274857 5.6194444 0.276381 5.6222222 0.274095 5.6250000 0.273333 5.6277778 0.270286 5.6305556 0.270286 5.6333333 0.271048 5.6361111 0.273333 5.6388889 0.273333 5.6416667 0.271048 5.6444444 0.271048 5.6472222 0.271048 5.6500000 0.271810 5.6527778 0.271048 5.6555556 0.267238 5.6583333 0.266476 5.6611111 0.267238 5.6638889 0.265714 5.6666667 0.267238 5.6694444 0.269524 5.6722222 0.264952 5.6750000 0.265714 5.6777778 0.262667 5.6805556 0.263429 5.6833333 0.262667 5.6861111 0.266476 5.6888889 0.262667 5.6916667 0.260381 5.6944444 0.257333 5.6972222 0.257333 5.7000000 0.256571 5.7027778 0.258857 5.7055556 0.256571 5.7083333 0.255048 5.7111111 0.253524 5.7138889 0.253524 5.7166667 0.252000 5.7194444 0.253524 5.7222222 0.252762 5.7250000 0.249714 5.7277778 0.250476 5.7305556 0.249714 5.7333333 0.252000 5.7361111 0.252762 5.7388889 0.252000 5.7416667 0.252762 5.7444444 0.251238 5.7472222 0.253524 5.7500000 0.255810 5.7527778 0.258095 5.7555556 0.258857 5.7583333 0.259619 5.7611111 0.259619 5.7668889 0.300000 6.2053333 0.300000 6.2083333 0.266476 6.2111111 0.265714 6.2138889 0.265714 6.2166667 0.268762 6.2194444 0.269524 6.2222222 0.268762 6.2250000 0.268762 6.2277778 0.268000 6.2305556 0.268000 6.2333333 0.270286 6.2361111 0.270286 6.2388889 0.270286 6.2416667 0.269524 6.2444444 0.265714 6.2472222 0.265714 6.2500000 0.268762 6.2527778 0.271048 6.2555556 0.270286 6.2583333 0.271048 6.2611111 0.269524 6.2638889 0.271810 6.2666667 0.272571 6.2694444 0.274857 6.2722222 0.274095 6.2750000 0.272571 6.2777778 0.273333 6.2805556 0.274095 6.2833333 0.274857 6.2861111 0.277143 6.2888889 0.276381 6.2916667 0.274857 6.2944444 0.274095 6.2972222 0.274857 6.3000000 0.274857 6.3027778 0.276381 6.3055556 0.274095 6.3083333 0.272571 6.3111111 0.274095 6.3138889 0.274857 6.3166667 0.275619 6.3194444 0.275619 6.3222222 0.272571 6.3250000 0.271048 6.3277778 0.268762 6.3305556 0.271048 6.3333333 0.271048 6.3361111 0.274095 6.3388889 0.271810 6.3416667 0.271048 6.3444444 0.270286 6.3472222 0.265714 6.3500000 0.267238 6.3527778 0.269524 6.3555556 0.268762 6.3583333 0.268762 6.3611111 0.268762 6.3638889 0.266476 6.3666667 0.268000 6.3694444 0.268000 6.3722222 0.268000 6.3750000 0.267238 6.3777778 0.265714 6.3805556 0.264190 6.3833333 0.264952 6.3861111 0.268762 6.3888889 0.267238 6.3916667 0.265714 6.3944444 0.265714 6.3972222 0.266476 6.4000000 0.266476 6.4027778 0.267238 6.4055556 0.265714 6.4083333 0.265714 6.4111111 0.261143 6.4138889 0.258095 6.4166667 0.255810 6.4194444 0.255810 6.4222222 0.252000 6.4250000 0.249714 6.4277778 0.253524 6.4305556 0.262667 6.4333333 0.282476 6.4361111 0.296190 6.4388889 0.304571 6.4416667 0.312190 6.4444444 0.323619 6.4472222 0.340381 6.4500000 0.358667 6.4527778 0.376190 6.4555556 0.383048 6.4583333 0.368571 6.4611111 0.332762 6.4638889 0.286286 6.4666667 0.250476 6.4694444 0.240571 6.4722222 0.241333 6.4750000 0.244381 6.4777778 0.248952 6.4805556 0.255048 6.4833333 0.256571 6.4861111 0.258857 6.4888889 0.259619 6.4916667 0.258857 6.4944444 0.258095 6.4972222 0.256571 6.5000000 0.259619 6.5027778 0.261905 6.5055556 0.260381 6.5083333 0.260381 6.5111111 0.259619 6.5138889 0.258857 6.5166667 0.259619 6.5194444 0.262667 6.5222222 0.260381 6.5250000 0.261143 6.5277778 0.257333 6.5305556 0.260381 6.5333333 0.261905 6.5361111 0.261905 6.5388889 0.261143 6.5416667 0.261143 6.5444444 0.260381 6.5472222 0.260381 6.5500000 0.261143 6.5527778 0.265714 6.5555556 0.263429 6.5583333 0.262667 6.5611111 0.259619 6.5638889 0.258095 6.5666667 0.261905 6.5694444 0.262667 6.5722222 0.264952 6.5750000 0.263429 6.5777778 0.261143 6.5805556 0.261905 6.5833333 0.261905 6.5861111 0.262667 6.5888889 0.264190 6.5916667 0.263429 6.5944444 0.261905 6.5972222 0.261905 6.6000000 0.262667 6.6027778 0.266476 6.6055556 0.262667 6.6083333 0.262667 6.6111111 0.263429 6.6138889 0.261143 6.6166667 0.262667 6.6194444 0.265714 6.6222222 0.263429 6.6250000 0.261905 6.6277778 0.260381 6.6305556 0.259619 6.6333333 0.261143 6.6361111 0.263429 6.6388889 0.261905 6.6416667 0.261905 6.6444444 0.259619 6.6472222 0.260381 6.6500000 0.260381 6.6527778 0.259619 6.6555556 0.258095 6.6583333 0.258857 6.6611111 0.258857 6.6638889 0.258857 6.6666667 0.258857 6.6694444 0.262667 6.6722222 0.259619 6.6750000 0.259619 6.6777778 0.258857 6.6805556 0.256571 6.6833333 0.260381 6.6861111 0.262667 6.6888889 0.261143 6.6916667 0.259619 6.6944444 0.256571 6.6972222 0.255048 6.7000000 0.254286 6.7027778 0.255048 6.7055556 0.256571 6.7083333 0.251238 6.7111111 0.250476 6.7138889 0.248952 6.7166667 0.248952 6.7194444 0.249714 6.7222222 0.246667 6.7250000 0.247429 6.7277778 0.244381 6.7305556 0.242095 6.7333333 0.242857 6.7361111 0.242857 6.7388889 0.241333 6.7416667 0.241333 6.7444444 0.239048 6.7472222 0.239048 6.7500000 0.239810 6.7527778 0.240571 6.7555556 0.240571 6.7613333 0.300000 7.0497778 0.300000 7.0527778 0.271810 7.0555556 0.270286 7.0583333 0.269524 7.0611111 0.269524 7.0638889 0.268762 7.0666667 0.270286 7.0694444 0.271810 7.0722222 0.271048 7.0750000 0.270286 7.0777778 0.269524 7.0805556 0.269524 7.0833333 0.269524 7.0861111 0.271048 7.0888889 0.269524 7.0916667 0.271048 7.0944444 0.269524 7.0972222 0.270286 7.1000000 0.272571 7.1027778 0.275619 7.1055556 0.272571 7.1083333 0.272571 7.1111111 0.271810 7.1138889 0.272571 7.1166667 0.275619 7.1194444 0.277905 7.1222222 0.276381 7.1250000 0.274095 7.1277778 0.274095 7.1305556 0.276381 7.1333333 0.277905 7.1361111 0.280190 7.1388889 0.279429 7.1416667 0.278667 7.1444444 0.279429 7.1472222 0.278667 7.1500000 0.278667 7.1527778 0.280952 7.1555556 0.280190 7.1583333 0.277143 7.1611111 0.274857 7.1638889 0.274857 7.1666667 0.274857 7.1694444 0.276381 7.1722222 0.277143 7.1750000 0.274857 7.1777778 0.272571 7.1805556 0.270286 7.1833333 0.273333 7.1861111 0.274095 7.1888889 0.273333 7.1916667 0.271810 7.1944444 0.270286 7.1972222 0.271048 7.2000000 0.273333 7.2027778 0.271810 7.2055556 0.271048 7.2083333 0.268762 7.2111111 0.267238 7.2138889 0.267238 7.2166667 0.270286 7.2194444 0.272571 7.2222222 0.271048 7.2250000 0.269524 7.2277778 0.269524 7.2305556 0.267238 7.2333333 0.269524 7.2361111 0.272571 7.2388889 0.270286 7.2416667 0.269524 7.2444444 0.268762 7.2472222 0.268000 7.2500000 0.269524 7.2527778 0.268762 7.2555556 0.264190 7.2583333 0.260381 7.2611111 0.256571 7.2638889 0.254286 7.2666667 0.250476 7.2694444 0.251238 7.2722222 0.255810 7.2750000 0.271048 7.2777778 0.291619 7.2805556 0.307619 7.2833333 0.322857 7.2861111 0.337333 7.2888889 0.352571 7.2916667 0.367810 7.2944444 0.380762 7.2972222 0.390667 7.3000000 0.379238 7.3027778 0.341905 7.3055556 0.287048 7.3083333 0.254286 7.3111111 0.248952 7.3138889 0.256571 7.3166667 0.261905 7.3194444 0.262667 7.3222222 0.264190 7.3250000 0.267238 7.3277778 0.264952 7.3305556 0.264952 7.3333333 0.263429 7.3361111 0.264190 7.3388889 0.264190 7.3416667 0.262667 7.3444444 0.261143 7.3472222 0.261905 7.3500000 0.263429 7.3527778 0.265714 7.3555556 0.264952 7.3583333 0.261905 7.3611111 0.263429 7.3638889 0.261143 7.3666667 0.264952 7.3694444 0.265714 7.3722222 0.265714 7.3750000 0.265714 7.3777778 0.264952 7.3805556 0.263429 7.3833333 0.265714 7.3861111 0.267238 7.3888889 0.267238 7.3916667 0.265714 7.3944444 0.264190 7.3972222 0.263429 7.4000000 0.265714 7.4027778 0.268762 7.4055556 0.268000 7.4083333 0.265714 7.4111111 0.264952 7.4138889 0.264190 7.4166667 0.265714 7.4194444 0.267238 7.4222222 0.266476 7.4250000 0.264952 7.4277778 0.264190 7.4305556 0.264952 7.4333333 0.267238 7.4361111 0.267238 7.4388889 0.267238 7.4416667 0.265714 7.4444444 0.264190 7.4472222 0.264190 7.4500000 0.264952 7.4527778 0.267238 7.4555556 0.265714 7.4583333 0.265714 7.4611111 0.264190 7.4638889 0.262667 7.4666667 0.263429 7.4694444 0.265714 7.4722222 0.268000 7.4750000 0.264952 7.4777778 0.264952 7.4805556 0.262667 7.4833333 0.266476 7.4861111 0.265714 7.4888889 0.264190 7.4916667 0.262667 7.4944444 0.261905 7.4972222 0.261905 7.5000000 0.263429 7.5027778 0.263429 7.5055556 0.262667 7.5083333 0.261905 7.5111111 0.258857 7.5138889 0.258857 7.5166667 0.259619 7.5194444 0.260381 7.5222222 0.257333 7.5250000 0.255048 7.5277778 0.255048 7.5305556 0.252000 7.5333333 0.252762 7.5361111 0.253524 7.5388889 0.252762 7.5416667 0.250476 7.5444444 0.249714 7.5472222 0.246667 7.5500000 0.248190 7.5527778 0.248952 7.5555556 0.246667 7.5583333 0.246667 7.5611111 0.243619 7.5638889 0.244381 7.5666667 0.245905 7.5694444 0.248952 7.5722222 0.245905 7.5750000 0.244381 7.5777778 0.243619 7.5805556 0.245143 7.5833333 0.248952 7.5861111 0.252000 7.5888889 0.252000 7.5916667 0.253524 7.5944444 0.256571 7.5972222 0.256571 7.6000000 0.258857 7.6057778 0.300000 7.8608889 0.300000 7.8638889 0.268762 7.8666667 0.271810 7.8694444 0.275619 7.8722222 0.274095 7.8750000 0.271048 7.8777778 0.271048 7.8805556 0.271048 7.8833333 0.272571 7.8861111 0.274095 7.8888889 0.275619 7.8916667 0.274095 7.8944444 0.271810 7.8972222 0.270286 7.9000000 0.272571 7.9027778 0.273333 7.9055556 0.274095 7.9083333 0.274095 7.9111111 0.270286 7.9138889 0.269524 7.9166667 0.272571 7.9194444 0.274095 7.9222222 0.273333 7.9250000 0.272571 7.9277778 0.272571 7.9305556 0.274095 7.9333333 0.276381 7.9361111 0.279429 7.9388889 0.277905 7.9416667 0.275619 7.9444444 0.275619 7.9472222 0.275619 7.9500000 0.278667 7.9527778 0.281714 7.9555556 0.281714 7.9583333 0.280190 7.9611111 0.280190 7.9638889 0.280952 7.9666667 0.280952 7.9694444 0.282476 7.9722222 0.283238 7.9750000 0.280190 7.9777778 0.277905 7.9805556 0.276381 7.9833333 0.278667 7.9861111 0.278667 7.9888889 0.277905 7.9916667 0.277143 7.9944444 0.275619 7.9972222 0.274857 8.0000000 0.275619 8.0027778 0.277143 8.0055556 0.274857 8.0083333 0.271810 8.0111111 0.272571 8.0138889 0.271810 8.0166667 0.274095 8.0194444 0.276381 8.0222222 0.273333 8.0250000 0.271048 8.0277778 0.270286 8.0305556 0.270286 8.0333333 0.272571 8.0361111 0.273333 8.0388889 0.272571 8.0416667 0.272571 8.0444444 0.271048 8.0472222 0.274095 8.0500000 0.272571 8.0527778 0.273333 8.0555556 0.272571 8.0583333 0.271810 8.0611111 0.269524 8.0638889 0.270286 8.0666667 0.269524 8.0694444 0.265714 8.0722222 0.261143 8.0750000 0.255048 8.0777778 0.249714 8.0805556 0.248190 8.0833333 0.253524 8.0861111 0.270286 8.0888889 0.290095 8.0916667 0.310667 8.0944444 0.327429 8.0972222 0.343429 8.1000000 0.363238 8.1027778 0.384571 8.1055556 0.402095 8.1083333 0.406667 8.1111111 0.384571 8.1138889 0.332000 8.1166667 0.280952 8.1194444 0.259619 8.1222222 0.263429 8.1250000 0.267238 8.1277778 0.267238 8.1305556 0.264952 8.1333333 0.266476 8.1361111 0.268000 8.1388889 0.264190 8.1416667 0.264190 8.1444444 0.264190 8.1472222 0.264952 8.1500000 0.265714 8.1527778 0.268000 8.1555556 0.267238 8.1583333 0.265714 8.1611111 0.263429 8.1638889 0.261905 8.1666667 0.264952 8.1694444 0.264952 8.1722222 0.265714 8.1750000 0.264952 8.1777778 0.263429 8.1805556 0.264190 8.1833333 0.264952 8.1861111 0.265714 8.1888889 0.264952 8.1916667 0.262667 8.1944444 0.264190 8.1972222 0.264190 8.2000000 0.266476 8.2027778 0.266476 8.2055556 0.265714 8.2083333 0.264952 8.2111111 0.262667 8.2138889 0.265714 8.2166667 0.266476 8.2194444 0.268000 8.2222222 0.268000 8.2250000 0.266476 8.2277778 0.263429 8.2305556 0.264190 8.2333333 0.265714 8.2361111 0.268000 8.2388889 0.269524 8.2416667 0.265714 8.2444444 0.265714 8.2472222 0.265714 8.2500000 0.265714 8.2527778 0.267238 8.2555556 0.267238 8.2583333 0.264190 8.2611111 0.263429 8.2638889 0.263429 8.2666667 0.264190 8.2694444 0.266476 8.2722222 0.265714 8.2750000 0.264190 8.2777778 0.262667 8.2805556 0.262667 8.2833333 0.264952 8.2861111 0.265714 8.2888889 0.266476 8.2916667 0.262667 8.2944444 0.261905 8.2972222 0.261143 8.3000000 0.261143 8.3027778 0.263429 8.3055556 0.261905 8.3083333 0.260381 8.3111111 0.258095 8.3138889 0.256571 8.3166667 0.258095 8.3194444 0.257333 8.3222222 0.255810 8.3250000 0.254286 8.3277778 0.253524 8.3305556 0.252000 8.3333333 0.252762 8.3361111 0.252000 8.3388889 0.250476 8.3416667 0.248952 8.3444444 0.246667 8.3472222 0.247429 8.3500000 0.248190 8.3527778 0.248952 8.3555556 0.246667 8.3583333 0.245143 8.3611111 0.243619 8.3638889 0.244381 8.3666667 0.245143 8.3694444 0.247429 8.3722222 0.248190 8.3750000 0.246667 8.3777778 0.245905 8.3805556 0.247429 8.3833333 0.250476 8.3861111 0.253524 8.3888889 0.254286 8.3916667 0.256571 8.3944444 0.256571 8.3972222 0.257333 8.4000000 0.259619 8.4027778 0.264952 8.4055556 0.264190 8.4083333 0.263429 8.4111111 0.262667 8.4168889 0.300000 8.6497778 0.300000 8.6527778 0.277143 8.6555556 0.275619 8.6583333 0.274857 8.6611111 0.272571 8.6638889 0.272571 8.6666667 0.274857 8.6694444 0.277143 8.6722222 0.276381 8.6750000 0.276381 8.6777778 0.274095 8.6805556 0.273333 8.6833333 0.274857 8.6861111 0.276381 8.6888889 0.277143 8.6916667 0.276381 8.6944444 0.274857 8.6972222 0.274857 8.7000000 0.275619 8.7027778 0.275619 8.7055556 0.274857 8.7083333 0.274095 8.7111111 0.273333 8.7138889 0.275619 8.7166667 0.279429 8.7194444 0.278667 8.7222222 0.277905 8.7250000 0.278667 8.7277778 0.277905 8.7305556 0.279429 8.7333333 0.280952 8.7361111 0.282476 8.7388889 0.282476 8.7416667 0.280952 8.7444444 0.280190 8.7472222 0.284000 8.7500000 0.285524 8.7527778 0.285524 8.7555556 0.285524 8.7583333 0.285524 8.7611111 0.285524 8.7638889 0.282476 8.7666667 0.281714 8.7694444 0.281714 8.7722222 0.280190 8.7750000 0.279429 8.7777778 0.280952 8.7805556 0.278667 8.7833333 0.279429 8.7861111 0.281714 8.7888889 0.277143 8.7916667 0.277143 8.7944444 0.276381 8.7972222 0.275619 8.8000000 0.277905 8.8027778 0.278667 8.8055556 0.277905 8.8083333 0.277905 8.8111111 0.275619 8.8138889 0.274857 8.8166667 0.276381 8.8194444 0.277905 8.8222222 0.276381 8.8250000 0.276381 8.8277778 0.274095 8.8305556 0.274857 8.8333333 0.275619 8.8361111 0.276381 8.8388889 0.275619 8.8416667 0.274095 8.8444444 0.274095 8.8472222 0.274857 8.8500000 0.274857 8.8527778 0.277905 8.8555556 0.274095 8.8583333 0.271048 8.8611111 0.265714 8.8638889 0.261905 8.8666667 0.258857 8.8694444 0.257333 8.8722222 0.253524 8.8750000 0.255810 8.8777778 0.269524 8.8805556 0.288571 8.8833333 0.306095 8.8861111 0.320571 8.8888889 0.332762 8.8916667 0.348762 8.8944444 0.366286 8.8972222 0.382286 8.9000000 0.388381 8.9027778 0.370857 8.9055556 0.322095 8.9083333 0.276381 8.9111111 0.256571 8.9138889 0.261905 8.9166667 0.269524 8.9194444 0.272571 8.9222222 0.271048 8.9250000 0.271048 8.9277778 0.271810 8.9305556 0.270286 8.9333333 0.271810 8.9361111 0.273333 8.9388889 0.271048 8.9416667 0.270286 8.9444444 0.268762 8.9472222 0.268762 8.9500000 0.271810 8.9527778 0.274857 8.9555556 0.271810 8.9583333 0.271048 8.9611111 0.268000 8.9638889 0.268000 8.9666667 0.269524 8.9694444 0.271048 8.9722222 0.271810 8.9750000 0.270286 8.9777778 0.268000 8.9805556 0.268000 8.9833333 0.271048 8.9861111 0.272571 8.9888889 0.271048 8.9916667 0.270286 8.9944444 0.267238 8.9972222 0.267238 9.0000000 0.270286 9.0027778 0.271810 9.0055556 0.272571 9.0083333 0.271810 9.0111111 0.269524 9.0138889 0.268762 9.0166667 0.271048 9.0194444 0.272571 9.0222222 0.271810 9.0250000 0.270286 9.0277778 0.270286 9.0305556 0.270286 9.0333333 0.271048 9.0361111 0.271810 9.0388889 0.270286 9.0416667 0.270286 9.0444444 0.268762 9.0472222 0.269524 9.0500000 0.271048 9.0527778 0.271810 9.0555556 0.270286 9.0583333 0.268000 9.0611111 0.267238 9.0638889 0.267238 9.0666667 0.268762 9.0694444 0.271048 9.0722222 0.271048 9.0750000 0.268762 9.0777778 0.266476 9.0805556 0.267238 9.0833333 0.268762 9.0861111 0.268000 9.0888889 0.266476 9.0916667 0.264952 9.0944444 0.263429 9.0972222 0.261143 9.1000000 0.263429 9.1027778 0.265714 9.1055556 0.264952 9.1083333 0.261905 9.1111111 0.261905 9.1138889 0.260381 9.1166667 0.260381 9.1194444 0.261143 9.1222222 0.260381 9.1250000 0.256571 9.1277778 0.255048 9.1305556 0.254286 9.1333333 0.256571 9.1361111 0.257333 9.1388889 0.255810 9.1416667 0.253524 9.1444444 0.252000 9.1472222 0.251238 9.1500000 0.252762 9.1527778 0.253524 9.1555556 0.252762 9.1583333 0.251238 9.1611111 0.250476 9.1638889 0.248952 9.1666667 0.251238 9.1694444 0.254286 9.1722222 0.254286 9.1750000 0.254286 9.1777778 0.256571 9.1805556 0.257333 9.1833333 0.260381 9.1861111 0.263429 9.1888889 0.264190 9.1916667 0.265714 9.1944444 0.264952 9.1972222 0.265714 9.2000000 0.271048 9.2057778 0.300000 9.4220000 0.300000 9.4250000 0.268762 9.4277778 0.268000 9.4305556 0.267238 9.4333333 0.266476 9.4361111 0.268762 9.4388889 0.266476 9.4416667 0.264952 9.4444444 0.265714 9.4472222 0.265714 9.4500000 0.270286 9.4527778 0.270286 9.4555556 0.266476 9.4583333 0.264952 9.4611111 0.261905 9.4638889 0.263429 9.4666667 0.265714 9.4694444 0.268000 9.4722222 0.268000 9.4750000 0.264952 9.4777778 0.264190 9.4805556 0.263429 9.4833333 0.268000 9.4861111 0.270286 9.4888889 0.270286 9.4916667 0.271048 9.4944444 0.269524 9.4972222 0.270286 9.5000000 0.272571 9.5027778 0.272571 9.5055556 0.271048 9.5083333 0.271048 9.5111111 0.272571 9.5138889 0.271810 9.5166667 0.274857 9.5194444 0.274857 9.5222222 0.273333 9.5250000 0.271810 9.5277778 0.269524 9.5305556 0.270286 9.5333333 0.271810 9.5361111 0.272571 9.5388889 0.270286 9.5416667 0.270286 9.5444444 0.267238 9.5472222 0.269524 9.5500000 0.268000 9.5527778 0.270286 9.5555556 0.265714 9.5583333 0.264190 9.5611111 0.262667 9.5638889 0.262667 9.5666667 0.266476 9.5694444 0.264952 9.5722222 0.266476 9.5750000 0.265714 9.5777778 0.263429 9.5805556 0.265714 9.5833333 0.268000 9.5861111 0.266476 9.5888889 0.264952 9.5916667 0.264952 9.5944444 0.263429 9.5972222 0.262667 9.6000000 0.262667 9.6027778 0.263429 9.6055556 0.264190 9.6083333 0.263429 9.6111111 0.261143 9.6138889 0.261143 9.6166667 0.261905 9.6194444 0.264952 9.6222222 0.263429 9.6250000 0.261905 9.6277778 0.259619 9.6305556 0.255810 9.6333333 0.252762 9.6361111 0.253524 9.6388889 0.248952 9.6416667 0.245905 9.6444444 0.248952 9.6472222 0.258857 9.6500000 0.275619 9.6527778 0.292381 9.6555556 0.301524 9.6583333 0.309905 9.6611111 0.320571 9.6638889 0.336571 9.6666667 0.354095 9.6694444 0.360190 9.6722222 0.338857 9.6750000 0.297714 9.6777778 0.255048 9.6805556 0.238286 9.6833333 0.240571 9.6861111 0.248190 9.6888889 0.253524 9.6916667 0.252762 9.6944444 0.255048 9.6972222 0.255048 9.7000000 0.257333 9.7027778 0.258857 9.7055556 0.259619 9.7083333 0.256571 9.7111111 0.255810 9.7138889 0.255810 9.7166667 0.255810 9.7194444 0.256571 9.7222222 0.255810 9.7250000 0.255810 9.7277778 0.256571 9.7305556 0.256571 9.7333333 0.256571 9.7361111 0.259619 9.7388889 0.259619 9.7416667 0.258095 9.7444444 0.256571 9.7472222 0.257333 9.7500000 0.258857 9.7527778 0.258857 9.7555556 0.258095 9.7583333 0.258857 9.7611111 0.256571 9.7638889 0.254286 9.7666667 0.257333 9.7694444 0.258095 9.7722222 0.256571 9.7750000 0.256571 9.7777778 0.255048 9.7805556 0.255810 9.7833333 0.256571 9.7861111 0.258095 9.7888889 0.259619 9.7916667 0.256571 9.7944444 0.254286 9.7972222 0.253524 9.8000000 0.256571 9.8027778 0.258857 9.8055556 0.257333 9.8083333 0.258095 9.8111111 0.255810 9.8138889 0.257333 9.8166667 0.255810 9.8194444 0.257333 9.8222222 0.257333 9.8250000 0.256571 9.8277778 0.256571 9.8305556 0.256571 9.8333333 0.255048 9.8361111 0.258095 9.8388889 0.257333 9.8416667 0.255810 9.8444444 0.255048 9.8472222 0.255048 9.8500000 0.256571 9.8527778 0.258095 9.8555556 0.255048 9.8583333 0.253524 9.8611111 0.253524 9.8638889 0.251238 9.8666667 0.253524 9.8694444 0.255048 9.8722222 0.254286 9.8750000 0.254286 9.8777778 0.251238 9.8805556 0.251238 9.8833333 0.252762 9.8861111 0.253524 9.8888889 0.252000 9.8916667 0.249714 9.8944444 0.247429 9.8972222 0.245905 9.9000000 0.248190 9.9027778 0.248952 9.9055556 0.246667 9.9083333 0.243619 9.9111111 0.242095 9.9138889 0.242095 9.9166667 0.242857 9.9194444 0.241333 9.9222222 0.238286 9.9250000 0.238286 9.9277778 0.236000 9.9305556 0.234476 9.9333333 0.236762 9.9361111 0.237524 9.9388889 0.236762 9.9416667 0.235238 9.9444444 0.235238 9.9472222 0.235238 9.9500000 0.238286 9.9527778 0.241333 9.9555556 0.240571 9.9583333 0.241333 9.9611111 0.241333 9.9638889 0.242095 9.9666667 0.246667 9.9694444 0.251238 9.9722222 0.252000 9.9780000 0.300000 10.2608889 0.300000 10.2638889 0.263429 10.2666667 0.265714 10.2694444 0.268762 10.2722222 0.267238 10.2750000 0.267238 10.2777778 0.266476 10.2805556 0.264952 10.2833333 0.265714 10.2861111 0.267238 10.2888889 0.265714 10.2916667 0.266476 10.2944444 0.266476 10.2972222 0.265714 10.3000000 0.270286 10.3027778 0.270286 10.3055556 0.268762 10.3083333 0.269524 10.3111111 0.269524 10.3138889 0.270286 10.3166667 0.271048 10.3194444 0.274095 10.3222222 0.274095 10.3250000 0.272571 10.3277778 0.272571 10.3305556 0.271810 10.3333333 0.274095 10.3361111 0.274857 10.3388889 0.272571 10.3416667 0.273333 10.3444444 0.271810 10.3472222 0.273333 10.3500000 0.274095 10.3527778 0.277143 10.3555556 0.277143 10.3583333 0.276381 10.3611111 0.272571 10.3638889 0.272571 10.3666667 0.274095 10.3694444 0.273333 10.3722222 0.272571 10.3750000 0.271048 10.3777778 0.270286 10.3805556 0.269524 10.3833333 0.271048 10.3861111 0.271810 10.3888889 0.269524 10.3916667 0.270286 10.3944444 0.267238 10.3972222 0.268000 10.4000000 0.269524 10.4027778 0.270286 10.4055556 0.268762 10.4083333 0.266476 10.4111111 0.267238 10.4138889 0.265714 10.4166667 0.265714 10.4194444 0.268000 10.4222222 0.268762 10.4250000 0.268000 10.4277778 0.265714 10.4305556 0.264952 10.4333333 0.267238 10.4361111 0.269524 10.4388889 0.267238 10.4416667 0.266476 10.4444444 0.265714 10.4472222 0.268000 10.4500000 0.268000 10.4527778 0.269524 10.4555556 0.268000 10.4583333 0.267238 10.4611111 0.265714 10.4638889 0.264190 10.4666667 0.263429 10.4694444 0.261143 10.4722222 0.255810 10.4750000 0.252762 10.4777778 0.248952 10.4805556 0.245143 10.4833333 0.246667 10.4861111 0.256571 10.4888889 0.273333 10.4916667 0.292381 10.4944444 0.311429 10.4972222 0.328952 10.5000000 0.348000 10.5027778 0.365524 10.5055556 0.383048 10.5083333 0.399810 10.5111111 0.399810 10.5138889 0.376952 10.5166667 0.332000 10.5194444 0.286286 10.5222222 0.258095 10.5250000 0.255810 10.5277778 0.259619 10.5305556 0.261905 10.5333333 0.261143 10.5361111 0.264952 10.5388889 0.264952 10.5416667 0.261905 10.5444444 0.261143 10.5472222 0.261143 10.5500000 0.261905 10.5527778 0.264190 10.5555556 0.261905 10.5583333 0.261905 10.5611111 0.259619 10.5638889 0.261143 10.5666667 0.261905 10.5694444 0.263429 10.5722222 0.262667 10.5750000 0.261143 10.5777778 0.261143 10.5805556 0.259619 10.5833333 0.263429 10.5861111 0.263429 10.5888889 0.261143 10.5916667 0.261143 10.5944444 0.259619 10.5972222 0.260381 10.6000000 0.261905 10.6027778 0.261143 10.6055556 0.261143 10.6083333 0.261143 10.6111111 0.261143 10.6138889 0.261905 10.6166667 0.262667 10.6194444 0.265714 10.6222222 0.264952 10.6250000 0.262667 10.6277778 0.261143 10.6305556 0.260381 10.6333333 0.262667 10.6361111 0.262667 10.6388889 0.262667 10.6416667 0.263429 10.6444444 0.261905 10.6472222 0.262667 10.6500000 0.262667 10.6527778 0.263429 10.6555556 0.263429 10.6583333 0.261905 10.6611111 0.259619 10.6638889 0.261143 10.6666667 0.263429 10.6694444 0.263429 10.6722222 0.263429 10.6750000 0.261143 10.6777778 0.260381 10.6805556 0.260381 10.6833333 0.261143 10.6861111 0.261143 10.6888889 0.261905 10.6916667 0.260381 10.6944444 0.258095 10.6972222 0.257333 10.7000000 0.257333 10.7027778 0.258857 10.7055556 0.259619 10.7083333 0.256571 10.7111111 0.255810 10.7138889 0.257333 10.7166667 0.257333 10.7194444 0.258095 10.7222222 0.255048 10.7250000 0.253524 10.7277778 0.252762 10.7305556 0.252762 10.7333333 0.251238 10.7361111 0.253524 10.7388889 0.251238 10.7416667 0.247429 10.7444444 0.246667 10.7472222 0.245905 10.7500000 0.245905 10.7527778 0.246667 10.7555556 0.246667 10.7583333 0.245143 10.7611111 0.242095 10.7638889 0.241333 10.7666667 0.242095 10.7694444 0.242095 10.7722222 0.242857 10.7750000 0.241333 10.7777778 0.239810 10.7805556 0.242095 10.7833333 0.240571 10.7861111 0.242095 10.7888889 0.241333 10.7916667 0.242095 10.7944444 0.242857 10.7972222 0.243619 10.8000000 0.248952 10.8027778 0.252000 10.8055556 0.252762 10.8083333 0.254286 10.8111111 0.252762 10.8168889 0.300000 11.1164444 0.300000 11.1194444 0.268000 11.1222222 0.268762 11.1250000 0.268000 11.1277778 0.264952 11.1305556 0.265714 11.1333333 0.267238 11.1361111 0.268000 11.1388889 0.268000 11.1416667 0.265714 11.1444444 0.265714 11.1472222 0.265714 11.1500000 0.268762 11.1527778 0.269524 11.1555556 0.268000 11.1583333 0.266476 11.1611111 0.268000 11.1638889 0.267238 11.1666667 0.271048 11.1694444 0.271048 11.1722222 0.271810 11.1750000 0.271810 11.1777778 0.271810 11.1805556 0.269524 11.1833333 0.271810 11.1861111 0.274095 11.1888889 0.274095 11.1916667 0.276381 11.1944444 0.275619 11.1972222 0.275619 11.2000000 0.273333 11.2027778 0.274857 11.2055556 0.275619 11.2083333 0.275619 11.2111111 0.274857 11.2138889 0.274095 11.2166667 0.274857 11.2194444 0.275619 11.2222222 0.273333 11.2250000 0.270286 11.2277778 0.269524 11.2305556 0.268762 11.2333333 0.270286 11.2361111 0.270286 11.2388889 0.268762 11.2416667 0.269524 11.2444444 0.266476 11.2472222 0.265714 11.2500000 0.266476 11.2527778 0.268000 11.2555556 0.267238 11.2583333 0.266476 11.2611111 0.264952 11.2638889 0.263429 11.2666667 0.267238 11.2694444 0.267238 11.2722222 0.265714 11.2750000 0.264190 11.2777778 0.263429 11.2805556 0.261905 11.2833333 0.264952 11.2861111 0.268762 11.2888889 0.265714 11.2916667 0.264952 11.2944444 0.263429 11.2972222 0.261905 11.3000000 0.264952 11.3027778 0.267238 11.3055556 0.264952 11.3083333 0.261143 11.3111111 0.257333 11.3138889 0.253524 11.3166667 0.252000 11.3194444 0.250476 11.3222222 0.249714 11.3250000 0.246667 11.3277778 0.242857 11.3305556 0.236762 11.3333333 0.236762 11.3361111 0.242857 11.3388889 0.251238 11.3416667 0.264190 11.3444444 0.280952 11.3472222 0.300000 11.3500000 0.317524 11.3527778 0.331238 11.3555556 0.348000 11.3583333 0.364000 11.3611111 0.380000 11.3638889 0.392952 11.3666667 0.393714 11.3694444 0.371619 11.3722222 0.320571 11.3750000 0.274857 11.3777778 0.250476 11.3805556 0.253524 11.3833333 0.258857 11.3861111 0.260381 11.3888889 0.260381 11.3916667 0.261905 11.3944444 0.258857 11.3972222 0.258095 11.4000000 0.260381 11.4027778 0.260381 11.4055556 0.258095 11.4083333 0.258857 11.4111111 0.258857 11.4138889 0.258857 11.4166667 0.259619 11.4194444 0.260381 11.4222222 0.258857 11.4250000 0.258857 11.4277778 0.257333 11.4305556 0.256571 11.4333333 0.259619 11.4361111 0.261143 11.4388889 0.260381 11.4416667 0.258857 11.4444444 0.258095 11.4472222 0.256571 11.4500000 0.258857 11.4527778 0.259619 11.4555556 0.259619 11.4583333 0.260381 11.4611111 0.258095 11.4638889 0.258857 11.4666667 0.259619 11.4694444 0.261143 11.4722222 0.260381 11.4750000 0.261143 11.4777778 0.258095 11.4805556 0.259619 11.4833333 0.260381 11.4861111 0.261143 11.4888889 0.261143 11.4916667 0.260381 11.4944444 0.259619 11.4972222 0.257333 11.5000000 0.260381 11.5027778 0.263429 11.5055556 0.261905 11.5083333 0.259619 11.5111111 0.258857 11.5138889 0.257333 11.5166667 0.259619 11.5194444 0.261905 11.5222222 0.261143 11.5250000 0.260381 11.5277778 0.258857 11.5305556 0.257333 11.5333333 0.258095 11.5361111 0.260381 11.5388889 0.258857 11.5416667 0.256571 11.5444444 0.257333 11.5472222 0.257333 11.5500000 0.258095 11.5527778 0.257333 11.5555556 0.258095 11.5583333 0.258857 11.5611111 0.255048 11.5638889 0.253524 11.5666667 0.255048 11.5694444 0.257333 11.5722222 0.254286 11.5750000 0.252762 11.5777778 0.252762 11.5805556 0.252000 11.5833333 0.252000 11.5861111 0.252762 11.5888889 0.252000 11.5916667 0.249714 11.5944444 0.246667 11.5972222 0.246667 11.6000000 0.245905 11.6027778 0.248952 11.6055556 0.247429 11.6083333 0.245905 11.6111111 0.243619 11.6138889 0.242857 11.6166667 0.241333 11.6194444 0.242095 11.6222222 0.240571 11.6250000 0.240571 11.6277778 0.238286 11.6305556 0.237524 11.6333333 0.239810 11.6361111 0.239810 11.6388889 0.239810 11.6416667 0.239048 11.6444444 0.237524 11.6472222 0.238286 11.6500000 0.241333 11.6527778 0.242857 11.6555556 0.244381 11.6583333 0.244381 11.6611111 0.244381 11.6638889 0.245905 11.6666667 0.250476 11.6724444 0.300000 11.9386667 0.300000 11.9416667 0.262667 11.9444444 0.263429 11.9472222 0.263429 11.9500000 0.262667 11.9527778 0.264190 11.9555556 0.264190 11.9583333 0.262667 11.9611111 0.258857 11.9638889 0.260381 11.9666667 0.261905 11.9694444 0.261905 11.9722222 0.261143 11.9750000 0.261905 11.9777778 0.258857 11.9805556 0.258857 11.9833333 0.261905 11.9861111 0.264952 11.9888889 0.264190 11.9916667 0.263429 11.9944444 0.264190 11.9972222 0.264190 12.0000000 0.264952 12.0027778 0.265714 12.0055556 0.267238 12.0083333 0.264190 12.0111111 0.265714 12.0138889 0.266476 12.0166667 0.268762 12.0194444 0.268762 12.0222222 0.268762 12.0250000 0.268762 12.0277778 0.268000 12.0305556 0.265714 12.0333333 0.268000 12.0361111 0.270286 12.0388889 0.269524 12.0416667 0.267238 12.0444444 0.264190 12.0472222 0.264952 12.0500000 0.265714 12.0527778 0.265714 12.0555556 0.262667 12.0583333 0.261905 12.0611111 0.260381 12.0638889 0.259619 12.0666667 0.264952 12.0694444 0.264190 12.0722222 0.263429 12.0750000 0.261905 12.0777778 0.257333 12.0805556 0.258857 12.0833333 0.259619 12.0861111 0.261143 12.0888889 0.259619 12.0916667 0.258095 12.0944444 0.257333 12.0972222 0.255810 12.1000000 0.258095 12.1027778 0.259619 12.1055556 0.258857 12.1083333 0.258857 12.1111111 0.257333 12.1138889 0.257333 12.1166667 0.258857 12.1194444 0.259619 12.1222222 0.257333 12.1250000 0.256571 12.1277778 0.255048 12.1305556 0.255048 12.1333333 0.257333 12.1361111 0.259619 12.1388889 0.257333 12.1416667 0.254286 12.1444444 0.250476 12.1472222 0.245905 12.1500000 0.245143 12.1527778 0.245905 12.1555556 0.241333 12.1583333 0.239048 12.1611111 0.245905 12.1638889 0.258857 12.1666667 0.274095 12.1694444 0.288571 12.1722222 0.298476 12.1750000 0.307619 12.1777778 0.320571 12.1805556 0.338857 12.1833333 0.354857 12.1861111 0.359429 12.1888889 0.341905 12.1916667 0.306095 12.1944444 0.265714 12.1972222 0.239048 12.2000000 0.237524 12.2027778 0.245143 12.2055556 0.247429 12.2083333 0.248190 12.2111111 0.247429 12.2138889 0.247429 12.2166667 0.249714 12.2194444 0.253524 12.2222222 0.252000 12.2250000 0.252000 12.2277778 0.250476 12.2305556 0.248952 12.2333333 0.249714 12.2361111 0.252762 12.2388889 0.252000 12.2416667 0.251238 12.2444444 0.251238 12.2472222 0.251238 12.2500000 0.251238 12.2527778 0.252762 12.2555556 0.250476 12.2583333 0.249714 12.2611111 0.247429 12.2638889 0.248190 12.2666667 0.251238 12.2694444 0.252762 12.2722222 0.252762 12.2750000 0.251238 12.2777778 0.250476 12.2805556 0.250476 12.2833333 0.252000 12.2861111 0.252762 12.2888889 0.252762 12.2916667 0.252000 12.2944444 0.249714 12.2972222 0.251238 12.3000000 0.252000 12.3027778 0.255810 12.3055556 0.253524 12.3083333 0.253524 12.3111111 0.251238 12.3138889 0.251238 12.3166667 0.250476 12.3194444 0.251238 12.3222222 0.252000 12.3250000 0.251238 12.3277778 0.250476 12.3305556 0.249714 12.3333333 0.252000 12.3361111 0.252762 12.3388889 0.252000 12.3416667 0.249714 12.3444444 0.248190 12.3472222 0.248952 12.3500000 0.252000 12.3527778 0.253524 12.3555556 0.251238 12.3583333 0.250476 12.3611111 0.251238 12.3638889 0.250476 12.3666667 0.249714 12.3694444 0.251238 12.3722222 0.252762 12.3750000 0.250476 12.3777778 0.250476 12.3805556 0.249714 12.3833333 0.250476 12.3861111 0.249714 12.3888889 0.249714 12.3916667 0.248952 12.3944444 0.248952 12.3972222 0.247429 12.4000000 0.248952 12.4027778 0.248190 12.4055556 0.247429 12.4083333 0.246667 12.4111111 0.245143 12.4138889 0.242095 12.4166667 0.244381 12.4194444 0.245143 12.4222222 0.243619 12.4250000 0.242095 12.4277778 0.238286 12.4305556 0.235238 12.4333333 0.236000 12.4361111 0.238286 12.4388889 0.237524 12.4416667 0.235238 12.4444444 0.232952 12.4472222 0.232190 12.4500000 0.232952 12.4527778 0.234476 12.4555556 0.234476 12.4583333 0.232952 12.4611111 0.231429 12.4638889 0.229143 12.4666667 0.232952 12.4694444 0.233714 12.4722222 0.232190 12.4750000 0.229143 12.4777778 0.231429 12.4805556 0.232190 12.4833333 0.236000 12.4861111 0.239048 12.4888889 0.241333 12.4946667 0.300000 12.7664444 0.300000 12.7694444 0.251238 12.7722222 0.250476 12.7750000 0.247429 12.7777778 0.246667 12.7805556 0.246667 12.7833333 0.247429 12.7861111 0.249714 12.7888889 0.252000 12.7916667 0.249714 12.7944444 0.248190 12.7972222 0.247429 12.8000000 0.248190 12.8027778 0.251238 12.8055556 0.249714 12.8083333 0.248190 12.8111111 0.246667 12.8138889 0.248952 12.8166667 0.250476 12.8194444 0.252762 12.8222222 0.253524 12.8250000 0.251238 12.8277778 0.252000 12.8305556 0.251238 12.8333333 0.252762 12.8361111 0.255810 12.8388889 0.255048 12.8416667 0.253524 12.8444444 0.253524 12.8472222 0.252762 12.8500000 0.255048 12.8527778 0.257333 12.8555556 0.257333 12.8583333 0.256571 12.8611111 0.255810 12.8638889 0.255048 12.8666667 0.255810 12.8694444 0.256571 12.8722222 0.255048 12.8750000 0.254286 12.8777778 0.252000 12.8805556 0.252000 12.8833333 0.253524 12.8861111 0.255048 12.8888889 0.253524 12.8916667 0.252762 12.8944444 0.247429 12.8972222 0.248952 12.9000000 0.248190 12.9027778 0.248952 12.9055556 0.249714 12.9083333 0.249714 12.9111111 0.247429 12.9138889 0.247429 12.9166667 0.248190 12.9194444 0.248952 12.9222222 0.249714 12.9250000 0.248952 12.9277778 0.248952 12.9305556 0.249714 12.9333333 0.250476 12.9361111 0.252762 12.9388889 0.250476 12.9416667 0.250476 12.9444444 0.249714 12.9472222 0.248952 12.9500000 0.248952 12.9527778 0.252000 12.9555556 0.251238 12.9583333 0.249714 12.9611111 0.250476 12.9638889 0.248952 12.9666667 0.250476 12.9694444 0.249714 12.9722222 0.246667 12.9750000 0.242857 12.9777778 0.239810 12.9805556 0.235238 12.9833333 0.235238 12.9861111 0.234476 12.9888889 0.235238 12.9916667 0.244381 12.9944444 0.258857 12.9972222 0.274857 13.0000000 0.290095 13.0027778 0.302286 13.0055556 0.312190 13.0083333 0.327429 13.0111111 0.344952 13.0138889 0.359429 13.0166667 0.361714 13.0194444 0.348000 13.0222222 0.303810 13.0250000 0.260381 13.0277778 0.232952 13.0305556 0.229143 13.0333333 0.236762 13.0361111 0.242857 13.0388889 0.245143 13.0416667 0.246667 13.0444444 0.246667 13.0472222 0.246667 13.0500000 0.248952 13.0527778 0.250476 13.0555556 0.250476 13.0583333 0.248190 13.0611111 0.249714 13.0638889 0.248952 13.0666667 0.250476 13.0694444 0.250476 13.0722222 0.248952 13.0750000 0.250476 13.0777778 0.246667 13.0805556 0.248190 13.0833333 0.248190 13.0861111 0.252762 13.0888889 0.251238 13.0916667 0.250476 13.0944444 0.247429 13.0972222 0.248190 13.1000000 0.249714 13.1027778 0.252000 13.1055556 0.252762 13.1083333 0.251238 13.1111111 0.248952 13.1138889 0.248952 13.1166667 0.250476 13.1194444 0.252000 13.1222222 0.250476 13.1250000 0.249714 13.1277778 0.250476 13.1305556 0.249714 13.1333333 0.252000 13.1361111 0.251238 13.1388889 0.252762 13.1416667 0.251238 13.1444444 0.248952 13.1472222 0.249714 13.1500000 0.252000 13.1527778 0.252000 13.1555556 0.252000 13.1583333 0.251238 13.1611111 0.249714 13.1638889 0.249714 13.1666667 0.252000 13.1694444 0.252762 13.1722222 0.253524 13.1750000 0.251238 13.1777778 0.248952 13.1805556 0.248952 13.1833333 0.247429 13.1861111 0.250476 13.1888889 0.249714 13.1916667 0.249714 13.1944444 0.248952 13.1972222 0.248952 13.2000000 0.249714 13.2027778 0.250476 13.2055556 0.249714 13.2083333 0.248952 13.2111111 0.245905 13.2138889 0.245905 13.2166667 0.246667 13.2194444 0.249714 13.2222222 0.248190 13.2250000 0.245143 13.2277778 0.244381 13.2305556 0.244381 13.2333333 0.243619 13.2361111 0.246667 13.2388889 0.245905 13.2416667 0.243619 13.2444444 0.242095 13.2472222 0.240571 13.2500000 0.241333 13.2527778 0.242095 13.2555556 0.240571 13.2583333 0.239810 13.2611111 0.236000 13.2638889 0.234476 13.2666667 0.236000 13.2694444 0.237524 13.2722222 0.235238 13.2750000 0.234476 13.2777778 0.231429 13.2805556 0.229905 13.2833333 0.232190 13.2861111 0.230667 13.2888889 0.231429 13.2916667 0.231429 13.2944444 0.228381 13.2972222 0.229143 13.3000000 0.229905 13.3027778 0.232952 13.3055556 0.232190 13.3083333 0.233714 13.3111111 0.236000 13.3138889 0.239048 13.3166667 0.242095 13.3224444 0.300000 13.5886667 0.300000 13.5916667 0.258857 13.5944444 0.258857 13.5972222 0.258095 13.6000000 0.259619 13.6027778 0.261905 13.6055556 0.261905 13.6083333 0.260381 13.6111111 0.259619 13.6138889 0.258095 13.6166667 0.259619 13.6194444 0.261143 13.6222222 0.261905 13.6250000 0.259619 13.6277778 0.260381 13.6305556 0.259619 13.6333333 0.261905 13.6361111 0.264190 13.6388889 0.260381 13.6416667 0.260381 13.6444444 0.261905 13.6472222 0.261905 13.6500000 0.263429 13.6527778 0.266476 13.6555556 0.267238 13.6583333 0.264952 13.6611111 0.263429 13.6638889 0.265714 13.6666667 0.266476 13.6694444 0.270286 13.6722222 0.269524 13.6750000 0.268000 13.6777778 0.269524 13.6805556 0.267238 13.6833333 0.271048 13.6861111 0.270286 13.6888889 0.270286 13.6916667 0.271048 13.6944444 0.268000 13.6972222 0.268000 13.7000000 0.269524 13.7027778 0.268000 13.7055556 0.265714 13.7083333 0.266476 13.7111111 0.264952 13.7138889 0.264190 13.7166667 0.265714 13.7194444 0.266476 13.7222222 0.264190 13.7250000 0.263429 13.7277778 0.264952 13.7305556 0.261905 13.7333333 0.261143 13.7361111 0.262667 13.7388889 0.263429 13.7416667 0.262667 13.7444444 0.261905 13.7472222 0.261143 13.7500000 0.263429 13.7527778 0.264190 13.7555556 0.263429 13.7583333 0.262667 13.7611111 0.261143 13.7638889 0.260381 13.7666667 0.261143 13.7694444 0.264952 13.7722222 0.263429 13.7750000 0.262667 13.7777778 0.261143 13.7805556 0.259619 13.7833333 0.259619 13.7861111 0.261905 13.7888889 0.262667 13.7916667 0.261905 13.7944444 0.258857 13.7972222 0.254286 13.8000000 0.251238 13.8027778 0.249714 13.8055556 0.245905 13.8083333 0.241333 13.8111111 0.243619 13.8138889 0.251238 13.8166667 0.271048 13.8194444 0.292381 13.8222222 0.311429 13.8250000 0.328952 13.8277778 0.346476 13.8305556 0.366286 13.8333333 0.386857 13.8361111 0.400571 13.8388889 0.398286 13.8416667 0.369333 13.8444444 0.318286 13.8472222 0.273333 13.8500000 0.255048 13.8527778 0.260381 13.8555556 0.261143 13.8583333 0.258095 13.8611111 0.257333 13.8638889 0.257333 13.8666667 0.258095 13.8694444 0.257333 13.8722222 0.257333 13.8750000 0.256571 13.8777778 0.255048 13.8805556 0.254286 13.8833333 0.255810 13.8861111 0.256571 13.8888889 0.255048 13.8916667 0.254286 13.8944444 0.252762 13.8972222 0.255048 13.9000000 0.253524 13.9027778 0.255810 13.9055556 0.256571 13.9083333 0.254286 13.9111111 0.253524 13.9138889 0.254286 13.9166667 0.255810 13.9194444 0.256571 13.9222222 0.255810 13.9250000 0.255810 13.9277778 0.255048 13.9305556 0.255810 13.9333333 0.255810 13.9361111 0.256571 13.9388889 0.256571 13.9416667 0.255810 13.9444444 0.252762 13.9472222 0.253524 13.9500000 0.256571 13.9527778 0.257333 13.9555556 0.257333 13.9583333 0.256571 13.9611111 0.255048 13.9638889 0.253524 13.9666667 0.255810 13.9694444 0.258857 13.9722222 0.257333 13.9750000 0.257333 13.9777778 0.255048 13.9805556 0.253524 13.9833333 0.255048 13.9861111 0.257333 13.9888889 0.257333 13.9916667 0.256571 13.9944444 0.255048 13.9972222 0.255048 14.0000000 0.255048 14.0027778 0.255810 14.0055556 0.255048 14.0083333 0.254286 14.0111111 0.252762 14.0138889 0.254286 14.0166667 0.254286 14.0194444 0.255048 14.0222222 0.253524 14.0250000 0.252000 14.0277778 0.249714 14.0305556 0.250476 14.0333333 0.250476 14.0361111 0.252000 14.0388889 0.250476 14.0416667 0.249714 14.0444444 0.247429 14.0472222 0.246667 14.0500000 0.247429 14.0527778 0.248952 14.0555556 0.245905 14.0583333 0.242095 14.0611111 0.242857 14.0638889 0.241333 14.0666667 0.242857 14.0694444 0.243619 14.0722222 0.242095 14.0750000 0.239810 14.0777778 0.237524 14.0805556 0.237524 14.0833333 0.238286 14.0861111 0.239048 14.0888889 0.238286 14.0916667 0.236000 14.0944444 0.234476 14.0972222 0.234476 14.1000000 0.236000 14.1027778 0.237524 14.1055556 0.238286 14.1083333 0.238286 14.1111111 0.237524 14.1138889 0.238286 14.1166667 0.241333 14.1194444 0.243619 14.1222222 0.245905 14.1250000 0.247429 14.1277778 0.248952 14.1305556 0.251238 14.1333333 0.254286 14.1361111 0.257333 14.1388889 0.258857 14.1446667 0.300000 14.3831111 0.300000 14.3861111 0.264952 14.3888889 0.264190 14.3916667 0.262667 14.3944444 0.263429 14.3972222 0.264952 14.4000000 0.265714 14.4027778 0.264190 14.4055556 0.264952 14.4083333 0.264952 14.4111111 0.263429 14.4138889 0.262667 14.4166667 0.264952 14.4194444 0.265714 14.4222222 0.265714 14.4250000 0.264952 14.4277778 0.262667 14.4305556 0.263429 14.4333333 0.264952 14.4361111 0.267238 14.4388889 0.268000 14.4416667 0.265714 14.4444444 0.265714 14.4472222 0.264952 14.4500000 0.267238 14.4527778 0.269524 14.4555556 0.268762 14.4583333 0.268000 14.4611111 0.268000 14.4638889 0.269524 14.4666667 0.271048 14.4694444 0.272571 14.4722222 0.271810 14.4750000 0.270286 14.4777778 0.269524 14.4805556 0.270286 14.4833333 0.271810 14.4861111 0.276381 14.4888889 0.274857 14.4916667 0.274095 14.4944444 0.272571 14.4972222 0.273333 14.5000000 0.272571 14.5027778 0.275619 14.5055556 0.271810 14.5083333 0.271048 14.5111111 0.268762 14.5138889 0.268762 14.5166667 0.270286 14.5194444 0.271048 14.5222222 0.269524 14.5250000 0.268762 14.5277778 0.265714 14.5305556 0.264952 14.5333333 0.265714 14.5361111 0.269524 14.5388889 0.267238 14.5416667 0.265714 14.5444444 0.264952 14.5472222 0.262667 14.5500000 0.264190 14.5527778 0.267238 14.5555556 0.265714 14.5583333 0.264190 14.5611111 0.264952 14.5638889 0.264190 14.5666667 0.266476 14.5694444 0.266476 14.5722222 0.265714 14.5750000 0.265714 14.5777778 0.265714 14.5805556 0.264952 14.5833333 0.265714 14.5861111 0.265714 14.5888889 0.262667 14.5916667 0.257333 14.5944444 0.253524 14.5972222 0.248952 14.6000000 0.246667 14.6027778 0.245143 14.6055556 0.245143 14.6083333 0.252000 14.6111111 0.266476 14.6138889 0.285524 14.6166667 0.303810 14.6194444 0.321333 14.6222222 0.337333 14.6250000 0.355619 14.6277778 0.370857 14.6305556 0.386095 14.6333333 0.388381 14.6361111 0.363238 14.6388889 0.311429 14.6416667 0.268000 14.6444444 0.249714 14.6472222 0.254286 14.6500000 0.258857 14.6527778 0.260381 14.6555556 0.260381 14.6583333 0.261143 14.6611111 0.259619 14.6638889 0.259619 14.6666667 0.261143 14.6694444 0.261905 14.6722222 0.260381 14.6750000 0.259619 14.6777778 0.260381 14.6805556 0.258095 14.6833333 0.261143 14.6861111 0.261143 14.6888889 0.260381 14.6916667 0.258095 14.6944444 0.258095 14.6972222 0.258095 14.7000000 0.260381 14.7027778 0.260381 14.7055556 0.261143 14.7083333 0.258095 14.7111111 0.256571 14.7138889 0.257333 14.7166667 0.259619 14.7194444 0.261905 14.7222222 0.261905 14.7250000 0.260381 14.7277778 0.258095 14.7305556 0.256571 14.7333333 0.258095 14.7361111 0.261905 14.7388889 0.261143 14.7416667 0.261143 14.7444444 0.258857 14.7472222 0.258857 14.7500000 0.261143 14.7527778 0.261905 14.7555556 0.261905 14.7583333 0.261143 14.7611111 0.261143 14.7638889 0.261905 14.7666667 0.261143 14.7694444 0.264190 14.7722222 0.263429 14.7750000 0.261143 14.7777778 0.261143 14.7805556 0.259619 14.7833333 0.260381 14.7861111 0.261905 14.7888889 0.261905 14.7916667 0.260381 14.7944444 0.258095 14.7972222 0.257333 14.8000000 0.258095 14.8027778 0.261143 14.8055556 0.259619 14.8083333 0.256571 14.8111111 0.257333 14.8138889 0.255048 14.8166667 0.255048 14.8194444 0.258095 14.8222222 0.256571 14.8250000 0.255048 14.8277778 0.253524 14.8305556 0.253524 14.8333333 0.253524 14.8361111 0.253524 14.8388889 0.252762 14.8416667 0.252000 14.8444444 0.249714 14.8472222 0.249714 14.8500000 0.252000 14.8527778 0.252000 14.8555556 0.251238 14.8583333 0.248190 14.8611111 0.244381 14.8638889 0.245143 14.8666667 0.245143 14.8694444 0.247429 14.8722222 0.244381 14.8750000 0.244381 14.8777778 0.241333 14.8805556 0.241333 14.8833333 0.240571 14.8861111 0.242857 14.8888889 0.244381 14.8916667 0.241333 14.8944444 0.239048 14.8972222 0.239810 14.9000000 0.240571 14.9027778 0.242095 14.9055556 0.241333 14.9083333 0.239048 14.9111111 0.238286 14.9138889 0.239048 14.9166667 0.239810 14.9194444 0.243619 14.9222222 0.243619 14.9250000 0.244381 14.9277778 0.243619 14.9305556 0.246667 14.9333333 0.248952 14.9391111 0.300000 15.1803333 0.300000 15.1833333 0.256571 15.1861111 0.256571 15.1888889 0.256571 15.1916667 0.255810 15.1944444 0.254286 15.1972222 0.255048 15.2000000 0.255048 15.2027778 0.258095 15.2055556 0.257333 15.2083333 0.257333 15.2111111 0.254286 15.2138889 0.254286 15.2166667 0.256571 15.2194444 0.258095 15.2222222 0.258857 15.2250000 0.255048 15.2277778 0.255048 15.2305556 0.253524 15.2333333 0.255810 15.2361111 0.258857 15.2388889 0.257333 15.2416667 0.255810 15.2444444 0.255810 15.2472222 0.258095 15.2500000 0.261143 15.2527778 0.261905 15.2555556 0.260381 15.2583333 0.258857 15.2611111 0.257333 15.2638889 0.258857 15.2666667 0.259619 15.2694444 0.262667 15.2722222 0.262667 15.2750000 0.261143 15.2777778 0.261905 15.2805556 0.263429 15.2833333 0.264190 15.2861111 0.264952 15.2888889 0.264952 15.2916667 0.261905 15.2944444 0.259619 15.2972222 0.258095 15.3000000 0.258095 15.3027778 0.260381 15.3055556 0.261143 15.3083333 0.259619 15.3111111 0.255810 15.3138889 0.255048 15.3166667 0.255048 15.3194444 0.257333 15.3222222 0.258857 15.3250000 0.255810 15.3277778 0.254286 15.3305556 0.255048 15.3333333 0.254286 15.3361111 0.254286 15.3388889 0.254286 15.3416667 0.253524 15.3444444 0.255048 15.3472222 0.255048 15.3500000 0.255048 15.3527778 0.254286 15.3555556 0.254286 15.3583333 0.254286 15.3611111 0.254286 15.3638889 0.252000 15.3666667 0.253524 15.3694444 0.257333 15.3722222 0.255810 15.3750000 0.255048 15.3777778 0.250476 15.3805556 0.248190 15.3833333 0.245143 15.3861111 0.244381 15.3888889 0.242095 15.3916667 0.236762 15.3944444 0.231429 15.3972222 0.236000 15.4000000 0.247429 15.4027778 0.262667 15.4055556 0.275619 15.4083333 0.286286 15.4111111 0.290857 15.4138889 0.299238 15.4166667 0.307619 15.4194444 0.325143 15.4222222 0.340381 15.4250000 0.357905 15.4277778 0.370095 15.4305556 0.375429 15.4333333 0.373905 15.4361111 0.351048 15.4388889 0.306857 15.4416667 0.262667 15.4444444 0.234476 15.4472222 0.226857 15.4500000 0.234476 15.4527778 0.239048 15.4555556 0.242095 15.4583333 0.244381 15.4611111 0.245905 15.4638889 0.244381 15.4666667 0.247429 15.4694444 0.247429 15.4722222 0.248190 15.4750000 0.247429 15.4777778 0.244381 15.4805556 0.245143 15.4833333 0.245143 15.4861111 0.248190 15.4888889 0.246667 15.4916667 0.247429 15.4944444 0.244381 15.4972222 0.245143 15.5000000 0.245143 15.5027778 0.247429 15.5055556 0.247429 15.5083333 0.245143 15.5111111 0.245143 15.5138889 0.243619 15.5166667 0.245905 15.5194444 0.247429 15.5222222 0.247429 15.5250000 0.245905 15.5277778 0.245143 15.5305556 0.245143 15.5333333 0.245905 15.5361111 0.246667 15.5388889 0.248190 15.5416667 0.247429 15.5444444 0.245143 15.5472222 0.247429 15.5500000 0.245905 15.5527778 0.248952 15.5555556 0.246667 15.5583333 0.244381 15.5611111 0.245143 15.5638889 0.243619 15.5666667 0.245143 15.5694444 0.247429 15.5722222 0.248190 15.5750000 0.245905 15.5777778 0.242857 15.5805556 0.242095 15.5833333 0.244381 15.5861111 0.245143 15.5888889 0.245905 15.5916667 0.245905 15.5944444 0.246667 15.5972222 0.244381 15.6000000 0.245905 15.6027778 0.245143 15.6055556 0.244381 15.6083333 0.241333 15.6111111 0.240571 15.6138889 0.242095 15.6166667 0.243619 15.6194444 0.244381 15.6222222 0.241333 15.6250000 0.241333 15.6277778 0.236000 15.6305556 0.238286 15.6333333 0.240571 15.6361111 0.240571 15.6388889 0.241333 15.6416667 0.239810 15.6444444 0.238286 15.6472222 0.239048 15.6500000 0.239810 15.6527778 0.239810 15.6555556 0.238286 15.6583333 0.235238 15.6611111 0.232952 15.6638889 0.230667 15.6666667 0.230667 15.6694444 0.232190 15.6722222 0.229143 15.6750000 0.229143 15.6777778 0.226857 15.6805556 0.226095 15.6833333 0.226095 15.6861111 0.226095 15.6888889 0.225333 15.6916667 0.223810 15.6944444 0.222286 15.6972222 0.220000 15.7000000 0.222286 15.7027778 0.224571 15.7055556 0.223810 15.7083333 0.221524 15.7111111 0.222286 15.7138889 0.225333 15.7166667 0.227619 15.7194444 0.231429 15.7222222 0.231429 15.7250000 0.231429 15.7277778 0.232952 15.7305556 0.234476 15.7363333 0.300000 15.9720000 0.300000 15.9750000 0.248190 15.9777778 0.246667 15.9805556 0.245143 15.9833333 0.248190 15.9861111 0.248190 15.9888889 0.248952 15.9916667 0.248190 15.9944444 0.246667 15.9972222 0.246667 16.0000000 0.248190 16.0027778 0.249714 16.0055556 0.249714 16.0083333 0.248190 16.0111111 0.247429 16.0138889 0.247429 16.0166667 0.247429 16.0194444 0.248952 16.0222222 0.251238 16.0250000 0.248952 16.0277778 0.248190 16.0305556 0.247429 16.0333333 0.250476 16.0361111 0.254286 16.0388889 0.252000 16.0416667 0.252000 16.0444444 0.253524 16.0472222 0.254286 16.0500000 0.257333 16.0527778 0.258857 16.0555556 0.255810 16.0583333 0.255810 16.0611111 0.255048 16.0638889 0.255810 16.0666667 0.258095 16.0694444 0.261143 16.0722222 0.259619 16.0750000 0.258095 16.0777778 0.257333 16.0805556 0.256571 16.0833333 0.257333 16.0861111 0.258857 16.0888889 0.256571 16.0916667 0.253524 16.0944444 0.253524 16.0972222 0.253524 16.1000000 0.255048 16.1027778 0.255048 16.1055556 0.255048 16.1083333 0.252000 16.1111111 0.250476 16.1138889 0.250476 16.1166667 0.252762 16.1194444 0.253524 16.1222222 0.254286 16.1250000 0.252762 16.1277778 0.250476 16.1305556 0.250476 16.1333333 0.250476 16.1361111 0.253524 16.1388889 0.253524 16.1416667 0.250476 16.1444444 0.251238 16.1472222 0.250476 16.1500000 0.252762 16.1527778 0.252762 16.1555556 0.252000 16.1583333 0.251238 16.1611111 0.250476 16.1638889 0.251238 16.1666667 0.252000 16.1694444 0.253524 16.1722222 0.254286 16.1750000 0.250476 16.1777778 0.248952 16.1805556 0.246667 16.1833333 0.245905 16.1861111 0.242095 16.1888889 0.236762 16.1916667 0.234476 16.1944444 0.230667 16.1972222 0.237524 16.2000000 0.253524 16.2027778 0.275619 16.2055556 0.293143 16.2083333 0.305333 16.2111111 0.318286 16.2138889 0.337333 16.2166667 0.358667 16.2194444 0.375429 16.2222222 0.372381 16.2250000 0.344952 16.2277778 0.293905 16.2305556 0.246667 16.2333333 0.232952 16.2361111 0.236762 16.2388889 0.242095 16.2416667 0.245143 16.2444444 0.244381 16.2472222 0.245905 16.2500000 0.248190 16.2527778 0.248190 16.2555556 0.248952 16.2583333 0.246667 16.2611111 0.243619 16.2638889 0.245143 16.2666667 0.245905 16.2694444 0.245905 16.2722222 0.246667 16.2750000 0.246667 16.2777778 0.245905 16.2805556 0.246667 16.2833333 0.246667 16.2861111 0.248190 16.2888889 0.247429 16.2916667 0.247429 16.2944444 0.246667 16.2972222 0.247429 16.3000000 0.248952 16.3027778 0.248952 16.3055556 0.249714 16.3083333 0.247429 16.3111111 0.247429 16.3138889 0.248190 16.3166667 0.248952 16.3194444 0.251238 16.3222222 0.248952 16.3250000 0.249714 16.3277778 0.248190 16.3305556 0.248190 16.3333333 0.248952 16.3361111 0.250476 16.3388889 0.250476 16.3416667 0.248190 16.3444444 0.247429 16.3472222 0.247429 16.3500000 0.251238 16.3527778 0.251238 16.3555556 0.249714 16.3583333 0.247429 16.3611111 0.248952 16.3638889 0.248190 16.3666667 0.249714 16.3694444 0.250476 16.3722222 0.249714 16.3750000 0.248190 16.3777778 0.247429 16.3805556 0.246667 16.3833333 0.248952 16.3861111 0.250476 16.3888889 0.248190 16.3916667 0.248952 16.3944444 0.245905 16.3972222 0.245143 16.4000000 0.245905 16.4027778 0.246667 16.4055556 0.247429 16.4083333 0.245905 16.4111111 0.242857 16.4138889 0.244381 16.4166667 0.242857 16.4194444 0.242857 16.4222222 0.244381 16.4250000 0.242857 16.4277778 0.241333 16.4305556 0.240571 16.4333333 0.242095 16.4361111 0.243619 16.4388889 0.242095 16.4416667 0.240571 16.4444444 0.238286 16.4472222 0.235238 16.4500000 0.236000 16.4527778 0.235238 16.4555556 0.235238 16.4583333 0.233714 16.4611111 0.232190 16.4638889 0.231429 16.4666667 0.229905 16.4694444 0.230667 16.4722222 0.228381 16.4750000 0.227619 16.4777778 0.225333 16.4805556 0.225333 16.4833333 0.227619 16.4861111 0.229143 16.4888889 0.228381 16.4916667 0.226857 16.4944444 0.226095 16.4972222 0.228381 16.5000000 0.229143 16.5027778 0.234476 16.5055556 0.234476 16.5083333 0.236000 16.5111111 0.236000 16.5138889 0.240571 16.5166667 0.242857 16.5194444 0.244381 16.5222222 0.246667 16.5280000 0.300000 16.7942222 0.300000 16.7972222 0.256571 16.8000000 0.257333 16.8027778 0.258857 16.8055556 0.261905 16.8083333 0.258857 16.8111111 0.259619 16.8138889 0.257333 16.8166667 0.258095 16.8194444 0.259619 16.8222222 0.258857 16.8250000 0.257333 16.8277778 0.257333 16.8305556 0.257333 16.8333333 0.261143 16.8361111 0.260381 16.8388889 0.261905 16.8416667 0.261143 16.8444444 0.260381 16.8472222 0.261143 16.8500000 0.264190 16.8527778 0.267238 16.8555556 0.265714 16.8583333 0.264190 16.8611111 0.264190 16.8638889 0.263429 16.8666667 0.264952 16.8694444 0.268000 16.8722222 0.268762 16.8750000 0.268762 16.8777778 0.269524 16.8805556 0.269524 16.8833333 0.269524 16.8861111 0.271048 16.8888889 0.271048 16.8916667 0.268762 16.8944444 0.268000 16.8972222 0.268762 16.9000000 0.268762 16.9027778 0.269524 16.9055556 0.268000 16.9083333 0.265714 16.9111111 0.264190 16.9138889 0.264190 16.9166667 0.264952 16.9194444 0.267238 16.9222222 0.265714 16.9250000 0.264190 16.9277778 0.264190 16.9305556 0.262667 16.9333333 0.263429 16.9361111 0.264952 16.9388889 0.263429 16.9416667 0.262667 16.9444444 0.261143 16.9472222 0.260381 16.9500000 0.261143 16.9527778 0.264952 16.9555556 0.262667 16.9583333 0.261143 16.9611111 0.261143 16.9638889 0.261143 16.9666667 0.262667 16.9694444 0.264190 16.9722222 0.262667 16.9750000 0.261905 16.9777778 0.260381 16.9805556 0.260381 16.9833333 0.261905 16.9861111 0.263429 16.9888889 0.261905 16.9916667 0.259619 16.9944444 0.258095 16.9972222 0.258095 17.0000000 0.255048 17.0027778 0.252762 17.0055556 0.248190 17.0083333 0.242857 17.0111111 0.237524 17.0138889 0.236000 17.0166667 0.244381 17.0194444 0.264190 17.0222222 0.282476 17.0250000 0.302286 17.0277778 0.317524 17.0305556 0.335810 17.0333333 0.356381 17.0361111 0.376190 17.0388889 0.393714 17.0416667 0.407429 17.0444444 0.408190 17.0472222 0.377714 17.0500000 0.324381 17.0527778 0.280952 17.0555556 0.256571 17.0583333 0.255048 17.0611111 0.255048 17.0638889 0.253524 17.0666667 0.255810 17.0694444 0.257333 17.0722222 0.258095 17.0750000 0.258857 17.0777778 0.255810 17.0805556 0.255810 17.0833333 0.255810 17.0861111 0.257333 17.0888889 0.256571 17.0916667 0.255048 17.0944444 0.255048 17.0972222 0.253524 17.1000000 0.254286 17.1027778 0.254286 17.1055556 0.255810 17.1083333 0.255048 17.1111111 0.253524 17.1138889 0.252762 17.1166667 0.254286 17.1194444 0.255810 17.1222222 0.255810 17.1250000 0.255048 17.1277778 0.252762 17.1305556 0.254286 17.1333333 0.255048 17.1361111 0.257333 17.1388889 0.256571 17.1416667 0.255048 17.1444444 0.253524 17.1472222 0.252762 17.1500000 0.255810 17.1527778 0.256571 17.1555556 0.255810 17.1583333 0.255810 17.1611111 0.255048 17.1638889 0.254286 17.1666667 0.255810 17.1694444 0.257333 17.1722222 0.256571 17.1750000 0.255810 17.1777778 0.254286 17.1805556 0.253524 17.1833333 0.255048 17.1861111 0.257333 17.1888889 0.254286 17.1916667 0.255048 17.1944444 0.253524 17.1972222 0.253524 17.2000000 0.255810 17.2027778 0.258095 17.2055556 0.255810 17.2083333 0.254286 17.2111111 0.253524 17.2138889 0.252762 17.2166667 0.255048 17.2194444 0.255048 17.2222222 0.254286 17.2250000 0.253524 17.2277778 0.252000 17.2305556 0.252000 17.2333333 0.251238 17.2361111 0.252000 17.2388889 0.249714 17.2416667 0.251238 17.2444444 0.248952 17.2472222 0.248190 17.2500000 0.249714 17.2527778 0.252762 17.2555556 0.250476 17.2583333 0.249714 17.2611111 0.247429 17.2638889 0.246667 17.2666667 0.245905 17.2694444 0.247429 17.2722222 0.245905 17.2750000 0.245143 17.2777778 0.242857 17.2805556 0.240571 17.2833333 0.243619 17.2861111 0.242095 17.2888889 0.240571 17.2916667 0.239048 17.2944444 0.237524 17.2972222 0.237524 17.3000000 0.238286 17.3027778 0.238286 17.3055556 0.234476 17.3083333 0.232952 17.3111111 0.232190 17.3138889 0.229143 17.3166667 0.230667 17.3194444 0.232190 17.3222222 0.230667 17.3250000 0.230667 17.3277778 0.229143 17.3305556 0.228381 17.3333333 0.229905 17.3361111 0.231429 17.3388889 0.232952 17.3416667 0.232190 17.3444444 0.232952 17.3502222 0.300000 17.6636667 0.300000 17.6666667 0.261143 17.6694444 0.263429 17.6722222 0.262667 17.6750000 0.261143 17.6777778 0.262667 17.6805556 0.259619 17.6833333 0.262667 17.6861111 0.263429 17.6888889 0.262667 17.6916667 0.261905 17.6944444 0.259619 17.6972222 0.259619 17.7000000 0.263429 17.7027778 0.265714 17.7055556 0.264190 17.7083333 0.261905 17.7111111 0.262667 17.7138889 0.261905 17.7166667 0.264190 17.7194444 0.266476 17.7222222 0.267238 17.7250000 0.268000 17.7277778 0.268000 17.7305556 0.265714 17.7333333 0.268762 17.7361111 0.269524 17.7388889 0.270286 17.7416667 0.268762 17.7444444 0.269524 17.7472222 0.270286 17.7500000 0.273333 17.7527778 0.273333 17.7555556 0.271810 17.7583333 0.271810 17.7611111 0.271048 17.7638889 0.268762 17.7666667 0.271048 17.7694444 0.270286 17.7722222 0.268000 17.7750000 0.268000 17.7777778 0.266476 17.7805556 0.265714 17.7833333 0.267238 17.7861111 0.267238 17.7888889 0.265714 17.7916667 0.266476 17.7944444 0.264190 17.7972222 0.264190 17.8000000 0.264952 17.8027778 0.266476 17.8055556 0.266476 17.8083333 0.263429 17.8111111 0.263429 17.8138889 0.262667 17.8166667 0.264952 17.8194444 0.264952 17.8222222 0.264952 17.8250000 0.262667 17.8277778 0.261143 17.8305556 0.261905 17.8333333 0.261905 17.8361111 0.263429 17.8388889 0.262667 17.8416667 0.261905 17.8444444 0.262667 17.8472222 0.261905 17.8500000 0.264190 17.8527778 0.266476 17.8555556 0.264952 17.8583333 0.262667 17.8611111 0.258857 17.8638889 0.258095 17.8666667 0.257333 17.8694444 0.256571 17.8722222 0.251238 17.8750000 0.247429 17.8777778 0.240571 17.8805556 0.239810 17.8833333 0.242857 17.8861111 0.255810 17.8888889 0.274095 17.8916667 0.292381 17.8944444 0.306095 17.8972222 0.319048 17.9000000 0.337333 17.9027778 0.355619 17.9055556 0.370095 17.9083333 0.385333 17.9111111 0.391429 17.9138889 0.378476 17.9166667 0.341905 17.9194444 0.295429 17.9222222 0.260381 17.9250000 0.248190 17.9277778 0.253524 17.9305556 0.258095 17.9333333 0.256571 17.9361111 0.259619 17.9388889 0.261905 17.9416667 0.260381 17.9444444 0.258857 17.9472222 0.258857 17.9500000 0.258857 17.9527778 0.259619 17.9555556 0.258857 17.9583333 0.258857 17.9611111 0.257333 17.9638889 0.255810 17.9666667 0.258095 17.9694444 0.259619 17.9722222 0.258857 17.9750000 0.258095 17.9777778 0.257333 17.9805556 0.257333 17.9833333 0.258857 17.9861111 0.258857 17.9888889 0.258857 17.9916667 0.260381 17.9944444 0.257333 17.9972222 0.255810 18.0000000 0.258857 18.0027778 0.261143 18.0055556 0.259619 18.0083333 0.258857 18.0111111 0.256571 18.0138889 0.256571 18.0166667 0.261905 18.0194444 0.261905 18.0222222 0.258857 18.0250000 0.259619 18.0277778 0.258095 18.0305556 0.258857 18.0333333 0.259619 18.0361111 0.261143 18.0388889 0.261143 18.0416667 0.259619 18.0444444 0.258095 18.0472222 0.258095 18.0500000 0.259619 18.0527778 0.261905 18.0555556 0.260381 18.0583333 0.258857 18.0611111 0.257333 18.0638889 0.257333 18.0666667 0.258095 18.0694444 0.260381 18.0722222 0.259619 18.0750000 0.257333 18.0777778 0.256571 18.0805556 0.256571 18.0833333 0.259619 18.0861111 0.259619 18.0888889 0.258095 18.0916667 0.255048 18.0944444 0.254286 18.0972222 0.254286 18.1000000 0.256571 18.1027778 0.258095 18.1055556 0.255048 18.1083333 0.252762 18.1111111 0.253524 18.1138889 0.251238 18.1166667 0.253524 18.1194444 0.253524 18.1222222 0.252762 18.1250000 0.252000 18.1277778 0.248952 18.1305556 0.248952 18.1333333 0.248952 18.1361111 0.250476 18.1388889 0.248952 18.1416667 0.246667 18.1444444 0.243619 18.1472222 0.242095 18.1500000 0.243619 18.1527778 0.245143 18.1555556 0.242095 18.1583333 0.241333 18.1611111 0.239048 18.1638889 0.237524 18.1666667 0.238286 18.1694444 0.239810 18.1722222 0.239048 18.1750000 0.236000 18.1777778 0.234476 18.1805556 0.234476 18.1833333 0.234476 18.1861111 0.238286 18.1888889 0.236762 18.1916667 0.236000 18.1944444 0.235238 18.1972222 0.236762 18.2000000 0.237524 18.2027778 0.242095 18.2055556 0.242095 18.2083333 0.242857 18.2111111 0.242095 18.2138889 0.243619 18.2196667 0.300000 18.4858889 0.300000 18.4888889 0.256571 18.4916667 0.255810 18.4944444 0.253524 18.4972222 0.255048 18.5000000 0.256571 18.5027778 0.257333 18.5055556 0.256571 18.5083333 0.252762 18.5111111 0.252000 18.5138889 0.252762 18.5166667 0.254286 18.5194444 0.255048 18.5222222 0.255048 18.5250000 0.255048 18.5277778 0.254286 18.5305556 0.252762 18.5333333 0.255810 18.5361111 0.257333 18.5388889 0.258857 18.5416667 0.258857 18.5444444 0.258857 18.5472222 0.259619 18.5500000 0.261905 18.5527778 0.261905 18.5555556 0.261143 18.5583333 0.259619 18.5611111 0.260381 18.5638889 0.262667 18.5666667 0.264190 18.5694444 0.265714 18.5722222 0.261905 18.5750000 0.261905 18.5777778 0.259619 18.5805556 0.259619 18.5833333 0.262667 18.5861111 0.263429 18.5888889 0.263429 18.5916667 0.261905 18.5944444 0.258095 18.5972222 0.256571 18.6000000 0.257333 18.6027778 0.259619 18.6055556 0.258857 18.6083333 0.258095 18.6111111 0.255810 18.6138889 0.254286 18.6166667 0.256571 18.6194444 0.256571 18.6222222 0.255048 18.6250000 0.255048 18.6277778 0.254286 18.6305556 0.253524 18.6333333 0.256571 18.6361111 0.259619 18.6388889 0.255048 18.6416667 0.252762 18.6444444 0.251238 18.6472222 0.250476 18.6500000 0.252000 18.6527778 0.254286 18.6555556 0.255810 18.6583333 0.254286 18.6611111 0.252000 18.6638889 0.254286 18.6666667 0.253524 18.6694444 0.255810 18.6722222 0.256571 18.6750000 0.254286 18.6777778 0.254286 18.6805556 0.255048 18.6833333 0.257333 18.6861111 0.255048 18.6888889 0.251238 18.6916667 0.245143 18.6944444 0.239810 18.6972222 0.241333 18.7000000 0.239810 18.7027778 0.236000 18.7055556 0.232190 18.7083333 0.235238 18.7111111 0.243619 18.7138889 0.260381 18.7166667 0.278667 18.7194444 0.289333 18.7222222 0.298476 18.7250000 0.309905 18.7277778 0.322857 18.7305556 0.343429 18.7333333 0.361714 18.7361111 0.364762 18.7388889 0.338857 18.7416667 0.290095 18.7444444 0.246667 18.7472222 0.228381 18.7500000 0.232952 18.7527778 0.240571 18.7555556 0.245143 18.7583333 0.246667 18.7611111 0.246667 18.7638889 0.245143 18.7666667 0.246667 18.7694444 0.248190 18.7722222 0.248952 18.7750000 0.248952 18.7777778 0.248952 18.7805556 0.248952 18.7833333 0.252762 18.7861111 0.249714 18.7888889 0.248190 18.7916667 0.247429 18.7944444 0.245905 18.7972222 0.248952 18.8000000 0.249714 18.8027778 0.252000 18.8055556 0.248952 18.8083333 0.248952 18.8111111 0.248952 18.8138889 0.248190 18.8166667 0.252000 18.8194444 0.253524 18.8222222 0.253524 18.8250000 0.252762 18.8277778 0.252000 18.8305556 0.251238 18.8333333 0.251238 18.8361111 0.253524 18.8388889 0.250476 18.8416667 0.249714 18.8444444 0.249714 18.8472222 0.250476 18.8500000 0.250476 18.8527778 0.251238 18.8555556 0.248952 18.8583333 0.249714 18.8611111 0.247429 18.8638889 0.249714 18.8666667 0.249714 18.8694444 0.251238 18.8722222 0.249714 18.8750000 0.248952 18.8777778 0.248952 18.8805556 0.249714 18.8833333 0.252000 18.8861111 0.252000 18.8888889 0.251238 18.8916667 0.251238 18.8944444 0.248952 18.8972222 0.247429 18.9000000 0.248190 18.9027778 0.248190 18.9055556 0.249714 18.9083333 0.248952 18.9111111 0.246667 18.9138889 0.245905 18.9166667 0.248952 18.9194444 0.250476 18.9222222 0.246667 18.9250000 0.245905 18.9277778 0.245143 18.9305556 0.244381 18.9333333 0.245905 18.9361111 0.245905 18.9388889 0.245905 18.9416667 0.243619 18.9444444 0.243619 18.9472222 0.242857 18.9500000 0.241333 18.9527778 0.243619 18.9555556 0.239810 18.9583333 0.239048 18.9611111 0.238286 18.9638889 0.237524 18.9666667 0.234476 18.9694444 0.236000 18.9722222 0.232952 18.9750000 0.231429 18.9777778 0.231429 18.9805556 0.229905 18.9833333 0.229905 18.9861111 0.229143 18.9888889 0.227619 18.9916667 0.227619 18.9944444 0.225333 18.9972222 0.223810 19.0000000 0.227619 19.0027778 0.228381 19.0055556 0.228381 19.0083333 0.229905 19.0111111 0.228381 19.0138889 0.228381 19.0166667 0.231429 19.0194444 0.235238 19.0222222 0.236762 19.0250000 0.241333 19.0277778 0.239810 19.0305556 0.242857 19.0333333 0.245143 19.0361111 0.245905 19.0418889 0.300000 19.2720000 0.300000 19.2750000 0.259619 19.2777778 0.257333 19.2805556 0.257333 19.2833333 0.257333 19.2861111 0.258857 19.2888889 0.261143 19.2916667 0.259619 19.2944444 0.257333 19.2972222 0.257333 19.3000000 0.258857 19.3027778 0.259619 19.3055556 0.259619 19.3083333 0.258095 19.3111111 0.258095 19.3138889 0.259619 19.3166667 0.261905 19.3194444 0.264952 19.3222222 0.262667 19.3250000 0.261905 19.3277778 0.261143 19.3305556 0.261905 19.3333333 0.264952 19.3361111 0.268000 19.3388889 0.268762 19.3416667 0.267238 19.3444444 0.264952 19.3472222 0.266476 19.3500000 0.266476 19.3527778 0.270286 19.3555556 0.271048 19.3583333 0.269524 19.3611111 0.269524 19.3638889 0.270286 19.3666667 0.269524 19.3694444 0.272571 19.3722222 0.268000 19.3750000 0.268762 19.3777778 0.268000 19.3805556 0.266476 19.3833333 0.268000 19.3861111 0.267238 19.3888889 0.265714 19.3916667 0.266476 19.3944444 0.265714 19.3972222 0.263429 19.4000000 0.265714 19.4027778 0.266476 19.4055556 0.265714 19.4083333 0.265714 19.4111111 0.262667 19.4138889 0.262667 19.4166667 0.264190 19.4194444 0.264190 19.4222222 0.262667 19.4250000 0.261905 19.4277778 0.261905 19.4305556 0.262667 19.4333333 0.264190 19.4361111 0.264952 19.4388889 0.264952 19.4416667 0.263429 19.4444444 0.261905 19.4472222 0.262667 19.4500000 0.262667 19.4527778 0.264952 19.4555556 0.263429 19.4583333 0.262667 19.4611111 0.262667 19.4638889 0.261143 19.4666667 0.264190 19.4694444 0.264952 19.4722222 0.263429 19.4750000 0.261905 19.4777778 0.258857 19.4805556 0.255810 19.4833333 0.252762 19.4861111 0.250476 19.4888889 0.244381 19.4916667 0.242095 19.4944444 0.245143 19.4972222 0.260381 19.5000000 0.282476 19.5027778 0.301524 19.5055556 0.315238 19.5083333 0.329714 19.5111111 0.344190 19.5138889 0.364000 19.5166667 0.383048 19.5194444 0.393714 19.5222222 0.376952 19.5250000 0.333524 19.5277778 0.280190 19.5305556 0.246667 19.5333333 0.244381 19.5361111 0.253524 19.5388889 0.256571 19.5416667 0.257333 19.5444444 0.258095 19.5472222 0.259619 19.5500000 0.259619 19.5527778 0.261143 19.5555556 0.260381 19.5583333 0.258857 19.5611111 0.258857 19.5638889 0.258095 19.5666667 0.260381 19.5694444 0.262667 19.5722222 0.261905 19.5750000 0.259619 19.5777778 0.258095 19.5805556 0.258095 19.5833333 0.260381 19.5861111 0.261905 19.5888889 0.262667 19.5916667 0.261905 19.5944444 0.259619 19.5972222 0.260381 19.6000000 0.260381 19.6027778 0.261905 19.6055556 0.261143 19.6083333 0.260381 19.6111111 0.261143 19.6138889 0.261143 19.6166667 0.262667 19.6194444 0.263429 19.6222222 0.262667 19.6250000 0.261143 19.6277778 0.259619 19.6305556 0.261143 19.6333333 0.263429 19.6361111 0.264952 19.6388889 0.264952 19.6416667 0.264952 19.6444444 0.261905 19.6472222 0.261905 19.6500000 0.264190 19.6527778 0.262667 19.6555556 0.264190 19.6583333 0.264190 19.6611111 0.259619 19.6638889 0.262667 19.6666667 0.263429 19.6694444 0.265714 19.6722222 0.262667 19.6750000 0.264190 19.6777778 0.261905 19.6805556 0.260381 19.6833333 0.261905 19.6861111 0.264952 19.6888889 0.263429 19.6916667 0.263429 19.6944444 0.261905 19.6972222 0.260381 19.7000000 0.261143 19.7027778 0.261905 19.7055556 0.259619 19.7083333 0.260381 19.7111111 0.257333 19.7138889 0.257333 19.7166667 0.258857 19.7194444 0.258857 19.7222222 0.258095 19.7250000 0.256571 19.7277778 0.253524 19.7305556 0.254286 19.7333333 0.253524 19.7361111 0.255810 19.7388889 0.253524 19.7416667 0.251238 19.7444444 0.248190 19.7472222 0.246667 19.7500000 0.248952 19.7527778 0.249714 19.7555556 0.247429 19.7583333 0.244381 19.7611111 0.242095 19.7638889 0.241333 19.7666667 0.241333 19.7694444 0.243619 19.7722222 0.241333 19.7750000 0.239048 19.7777778 0.239048 19.7805556 0.236000 19.7833333 0.239048 19.7861111 0.240571 19.7888889 0.239810 19.7916667 0.240571 19.7944444 0.239810 19.7972222 0.242857 19.8000000 0.245905 19.8027778 0.249714 19.8055556 0.250476 19.8083333 0.251238 19.8111111 0.253524 19.8138889 0.257333 19.8166667 0.259619 19.8194444 0.262667 19.8222222 0.264190 19.8280000 0.300000 20.0636667 0.300000 20.0666667 0.269524 20.0694444 0.271048 20.0722222 0.269524 20.0750000 0.268000 20.0777778 0.268000 20.0805556 0.268762 20.0833333 0.270286 20.0861111 0.273333 20.0888889 0.271810 20.0916667 0.268000 20.0944444 0.268000 20.0972222 0.267238 20.1000000 0.268000 20.1027778 0.270286 20.1055556 0.269524 20.1083333 0.268762 20.1111111 0.268000 20.1138889 0.268762 20.1166667 0.270286 20.1194444 0.272571 20.1222222 0.272571 20.1250000 0.271810 20.1277778 0.270286 20.1305556 0.270286 20.1333333 0.274857 20.1361111 0.276381 20.1388889 0.278667 20.1416667 0.274095 20.1444444 0.273333 20.1472222 0.274857 20.1500000 0.274857 20.1527778 0.277143 20.1555556 0.278667 20.1583333 0.280190 20.1611111 0.278667 20.1638889 0.276381 20.1666667 0.277905 20.1694444 0.279429 20.1722222 0.277905 20.1750000 0.278667 20.1777778 0.275619 20.1805556 0.275619 20.1833333 0.273333 20.1861111 0.275619 20.1888889 0.274857 20.1916667 0.273333 20.1944444 0.271810 20.1972222 0.270286 20.2000000 0.273333 20.2027778 0.272571 20.2055556 0.271810 20.2083333 0.269524 20.2111111 0.268000 20.2138889 0.268762 20.2166667 0.268000 20.2194444 0.272571 20.2222222 0.271048 20.2250000 0.268762 20.2277778 0.267238 20.2305556 0.268000 20.2333333 0.267238 20.2361111 0.271048 20.2388889 0.271810 20.2416667 0.269524 20.2444444 0.268762 20.2472222 0.268000 20.2500000 0.269524 20.2527778 0.269524 20.2555556 0.269524 20.2583333 0.265714 20.2611111 0.264952 20.2638889 0.261143 20.2666667 0.258095 20.2694444 0.254286 20.2722222 0.248190 20.2750000 0.243619 20.2777778 0.242857 20.2805556 0.254286 20.2833333 0.275619 20.2861111 0.296952 20.2888889 0.312952 20.2916667 0.324381 20.2944444 0.330476 20.2972222 0.339619 20.3000000 0.351810 20.3027778 0.366286 20.3055556 0.376190 20.3083333 0.386857 20.3111111 0.399810 20.3138889 0.415048 20.3166667 0.420381 20.3194444 0.398286 20.3222222 0.348762 20.3250000 0.290095 20.3277778 0.261143 20.3305556 0.260381 20.3333333 0.264952 20.3361111 0.266476 20.3388889 0.264952 20.3416667 0.265714 20.3444444 0.263429 20.3472222 0.261143 20.3500000 0.261905 20.3527778 0.262667 20.3555556 0.262667 20.3583333 0.258857 20.3611111 0.260381 20.3638889 0.258857 20.3666667 0.261905 20.3694444 0.261905 20.3722222 0.261143 20.3750000 0.260381 20.3777778 0.258857 20.3805556 0.258857 20.3833333 0.261905 20.3861111 0.260381 20.3888889 0.261143 20.3916667 0.261143 20.3944444 0.258095 20.3972222 0.258095 20.4000000 0.258095 20.4027778 0.262667 20.4055556 0.262667 20.4083333 0.261905 20.4111111 0.259619 20.4138889 0.258857 20.4166667 0.260381 20.4194444 0.261143 20.4222222 0.260381 20.4250000 0.258857 20.4277778 0.258857 20.4305556 0.259619 20.4333333 0.261143 20.4361111 0.260381 20.4388889 0.261905 20.4416667 0.261905 20.4444444 0.258857 20.4472222 0.258095 20.4500000 0.260381 20.4527778 0.261143 20.4555556 0.258857 20.4583333 0.261143 20.4611111 0.258857 20.4638889 0.258857 20.4666667 0.258095 20.4694444 0.259619 20.4722222 0.260381 20.4750000 0.257333 20.4777778 0.258857 20.4805556 0.258095 20.4833333 0.258857 20.4861111 0.258857 20.4888889 0.257333 20.4916667 0.255048 20.4944444 0.254286 20.4972222 0.254286 20.5000000 0.255048 20.5027778 0.255048 20.5055556 0.255810 20.5083333 0.252000 20.5111111 0.248952 20.5138889 0.250476 20.5166667 0.250476 20.5194444 0.252762 20.5222222 0.251238 20.5250000 0.247429 20.5277778 0.245143 20.5305556 0.244381 20.5333333 0.244381 20.5361111 0.246667 20.5388889 0.243619 20.5416667 0.242857 20.5444444 0.240571 20.5472222 0.238286 20.5500000 0.238286 20.5527778 0.239048 20.5555556 0.236762 20.5583333 0.236000 20.5611111 0.235238 20.5638889 0.234476 20.5666667 0.235238 20.5694444 0.236762 20.5722222 0.235238 20.5750000 0.234476 20.5777778 0.235238 20.5805556 0.234476 20.5833333 0.239810 20.5861111 0.242095 20.5888889 0.242857 20.5916667 0.243619 20.5944444 0.242857 20.5972222 0.246667 20.6000000 0.250476 20.6027778 0.254286 20.6055556 0.255048 20.6083333 0.257333 20.6111111 0.257333 20.6138889 0.258095 20.6196667 0.300000 20.8386667 0.300000 20.8416667 0.267238 20.8444444 0.265714 20.8472222 0.265714 20.8500000 0.268000 20.8527778 0.268000 20.8555556 0.267238 20.8583333 0.266476 20.8611111 0.266476 20.8638889 0.265714 20.8666667 0.267238 20.8694444 0.269524 20.8722222 0.266476 20.8750000 0.264952 20.8777778 0.264952 20.8805556 0.265714 20.8833333 0.268000 20.8861111 0.268762 20.8888889 0.268000 20.8916667 0.268762 20.8944444 0.267238 20.8972222 0.268000 20.9000000 0.270286 20.9027778 0.273333 20.9055556 0.274857 20.9083333 0.271048 20.9111111 0.271048 20.9138889 0.271810 20.9166667 0.272571 20.9194444 0.272571 20.9222222 0.273333 20.9250000 0.271810 20.9277778 0.271048 20.9305556 0.270286 20.9333333 0.273333 20.9361111 0.276381 20.9388889 0.277143 20.9416667 0.276381 20.9444444 0.274095 20.9472222 0.273333 20.9500000 0.274857 20.9527778 0.276381 20.9555556 0.275619 20.9583333 0.274095 20.9611111 0.272571 20.9638889 0.271048 20.9666667 0.271810 20.9694444 0.274095 20.9722222 0.271048 20.9750000 0.268762 20.9777778 0.268000 20.9805556 0.266476 20.9833333 0.267238 20.9861111 0.268000 20.9888889 0.267238 20.9916667 0.265714 20.9944444 0.264190 20.9972222 0.265714 21.0000000 0.265714 21.0027778 0.267238 21.0055556 0.268000 21.0083333 0.266476 21.0111111 0.265714 21.0138889 0.265714 21.0166667 0.264190 21.0194444 0.265714 21.0222222 0.264190 21.0250000 0.265714 21.0277778 0.264190 21.0305556 0.263429 21.0333333 0.264190 21.0361111 0.265714 21.0388889 0.263429 21.0416667 0.260381 21.0444444 0.256571 21.0472222 0.252762 21.0500000 0.250476 21.0527778 0.245905 21.0555556 0.240571 21.0583333 0.238286 21.0611111 0.245143 21.0638889 0.259619 21.0666667 0.278667 21.0694444 0.296952 21.0722222 0.308381 21.0750000 0.319810 21.0777778 0.337333 21.0805556 0.355619 21.0833333 0.372381 21.0861111 0.380762 21.0888889 0.361714 21.0916667 0.316000 21.0944444 0.268000 21.0972222 0.245905 21.1000000 0.245905 21.1027778 0.255810 21.1055556 0.256571 21.1083333 0.257333 21.1111111 0.257333 21.1138889 0.255810 21.1166667 0.255810 21.1194444 0.258095 21.1222222 0.258095 21.1250000 0.257333 21.1277778 0.255810 21.1305556 0.256571 21.1333333 0.255810 21.1361111 0.255810 21.1388889 0.256571 21.1416667 0.255810 21.1444444 0.253524 21.1472222 0.253524 21.1500000 0.254286 21.1527778 0.257333 21.1555556 0.254286 21.1583333 0.255048 21.1611111 0.255048 21.1638889 0.256571 21.1666667 0.258095 21.1694444 0.259619 21.1722222 0.257333 21.1750000 0.254286 21.1777778 0.254286 21.1805556 0.254286 21.1833333 0.255048 21.1861111 0.258857 21.1888889 0.256571 21.1916667 0.256571 21.1944444 0.255810 21.1972222 0.255048 21.2000000 0.255810 21.2027778 0.256571 21.2055556 0.258095 21.2083333 0.255048 21.2111111 0.255810 21.2138889 0.254286 21.2166667 0.255048 21.2194444 0.255048 21.2222222 0.256571 21.2250000 0.255810 21.2277778 0.256571 21.2305556 0.255048 21.2333333 0.256571 21.2361111 0.258095 21.2388889 0.255810 21.2416667 0.257333 21.2444444 0.255810 21.2472222 0.253524 21.2500000 0.255810 21.2527778 0.258095 21.2555556 0.255810 21.2583333 0.255810 21.2611111 0.255048 21.2638889 0.253524 21.2666667 0.255048 21.2694444 0.255048 21.2722222 0.254286 21.2750000 0.251238 21.2777778 0.250476 21.2805556 0.251238 21.2833333 0.252762 21.2861111 0.254286 21.2888889 0.251238 21.2916667 0.248952 21.2944444 0.246667 21.2972222 0.246667 21.3000000 0.250476 21.3027778 0.249714 21.3055556 0.248190 21.3083333 0.247429 21.3111111 0.245143 21.3138889 0.242095 21.3166667 0.242095 21.3194444 0.243619 21.3222222 0.242857 21.3250000 0.242095 21.3277778 0.239048 21.3305556 0.238286 21.3333333 0.239048 21.3361111 0.239048 21.3388889 0.236762 21.3416667 0.235238 21.3444444 0.234476 21.3472222 0.232190 21.3500000 0.233714 21.3527778 0.236000 21.3555556 0.232952 21.3583333 0.232952 21.3611111 0.230667 21.3638889 0.229143 21.3666667 0.234476 21.3694444 0.238286 21.3722222 0.238286 21.3750000 0.239810 21.3777778 0.237524 21.3805556 0.239810 21.3833333 0.245905 21.3861111 0.249714 21.3888889 0.251238 21.3946667 0.300000 21.6247778 0.300000 21.6277778 0.254286 21.6305556 0.252762 21.6333333 0.254286 21.6361111 0.256571 21.6388889 0.256571 21.6416667 0.255810 21.6444444 0.255048 21.6472222 0.254286 21.6500000 0.255810 21.6527778 0.256571 21.6555556 0.256571 21.6583333 0.255810 21.6611111 0.255048 21.6638889 0.255048 21.6666667 0.255810 21.6694444 0.257333 21.6722222 0.255810 21.6750000 0.258857 21.6777778 0.255810 21.6805556 0.258095 21.6833333 0.260381 21.6861111 0.261143 21.6888889 0.260381 21.6916667 0.257333 21.6944444 0.257333 21.6972222 0.256571 21.7000000 0.258857 21.7027778 0.263429 21.7055556 0.264952 21.7083333 0.264190 21.7111111 0.262667 21.7138889 0.263429 21.7166667 0.264952 21.7194444 0.264952 21.7222222 0.264952 21.7250000 0.263429 21.7277778 0.259619 21.7305556 0.260381 21.7333333 0.262667 21.7361111 0.261905 21.7388889 0.259619 21.7416667 0.255048 21.7444444 0.255810 21.7472222 0.255048 21.7500000 0.257333 21.7527778 0.256571 21.7555556 0.257333 21.7583333 0.255810 21.7611111 0.251238 21.7638889 0.252762 21.7666667 0.253524 21.7694444 0.255048 21.7722222 0.255048 21.7750000 0.255048 21.7777778 0.255048 21.7805556 0.254286 21.7833333 0.254286 21.7861111 0.255810 21.7888889 0.253524 21.7916667 0.253524 21.7944444 0.251238 21.7972222 0.253524 21.8000000 0.255048 21.8027778 0.255810 21.8055556 0.256571 21.8083333 0.255810 21.8111111 0.253524 21.8138889 0.253524 21.8166667 0.254286 21.8194444 0.255810 21.8222222 0.252000 21.8250000 0.252000 21.8277778 0.249714 21.8305556 0.247429 21.8333333 0.245905 21.8361111 0.242857 21.8388889 0.239048 21.8416667 0.234476 21.8444444 0.232952 21.8472222 0.238286 21.8500000 0.251238 21.8527778 0.267238 21.8555556 0.282476 21.8583333 0.291619 21.8611111 0.300000 21.8638889 0.312952 21.8666667 0.334286 21.8694444 0.354095 21.8722222 0.365524 21.8750000 0.354095 21.8777778 0.309143 21.8805556 0.258095 21.8833333 0.229143 21.8861111 0.229143 21.8888889 0.234476 21.8916667 0.241333 21.8944444 0.242857 21.8972222 0.245143 21.9000000 0.246667 21.9027778 0.245905 21.9055556 0.246667 21.9083333 0.245905 21.9111111 0.246667 21.9138889 0.245905 21.9166667 0.247429 21.9194444 0.249714 21.9222222 0.249714 21.9250000 0.247429 21.9277778 0.247429 21.9305556 0.246667 21.9333333 0.248952 21.9361111 0.252000 21.9388889 0.250476 21.9416667 0.250476 21.9444444 0.248952 21.9472222 0.247429 21.9500000 0.251238 21.9527778 0.250476 21.9555556 0.249714 21.9583333 0.251238 21.9611111 0.247429 21.9638889 0.248190 21.9666667 0.249714 21.9694444 0.252000 21.9722222 0.250476 21.9750000 0.248952 21.9777778 0.248190 21.9805556 0.248190 21.9833333 0.252000 21.9861111 0.252762 21.9888889 0.250476 21.9916667 0.248190 21.9944444 0.248190 21.9972222 0.248190 22.0000000 0.249714 22.0027778 0.251238 22.0055556 0.252000 22.0083333 0.252762 22.0111111 0.250476 22.0138889 0.249714 22.0166667 0.252000 22.0194444 0.252762 22.0222222 0.252762 22.0250000 0.248190 22.0277778 0.247429 22.0305556 0.247429 22.0333333 0.248952 22.0361111 0.251238 22.0388889 0.251238 22.0416667 0.252762 22.0444444 0.250476 22.0472222 0.249714 22.0500000 0.249714 22.0527778 0.250476 22.0555556 0.249714 22.0583333 0.248190 22.0611111 0.248952 22.0638889 0.248190 22.0666667 0.248952 22.0694444 0.251238 22.0722222 0.250476 22.0750000 0.248190 22.0777778 0.245905 22.0805556 0.245143 22.0833333 0.246667 22.0861111 0.247429 22.0888889 0.245905 22.0916667 0.243619 22.0944444 0.244381 22.0972222 0.240571 22.1000000 0.242857 22.1027778 0.243619 22.1055556 0.242857 22.1083333 0.240571 22.1111111 0.236762 22.1138889 0.236762 22.1166667 0.237524 22.1194444 0.237524 22.1222222 0.235238 22.1250000 0.232952 22.1277778 0.231429 22.1305556 0.230667 22.1333333 0.232952 22.1361111 0.232190 22.1388889 0.231429 22.1416667 0.229143 22.1444444 0.227619 22.1472222 0.228381 22.1500000 0.229905 22.1527778 0.232952 22.1555556 0.232190 22.1583333 0.232952 22.1611111 0.232190 22.1638889 0.234476 22.1666667 0.239048 22.1694444 0.240571 22.1722222 0.243619 22.1750000 0.244381 22.1807778 0.300000 22.4358889 0.300000 22.4388889 0.264952 22.4416667 0.264190 22.4444444 0.262667 22.4472222 0.262667 22.4500000 0.264190 22.4527778 0.267238 22.4555556 0.266476 22.4583333 0.263429 22.4611111 0.263429 22.4638889 0.264190 22.4666667 0.263429 22.4694444 0.264190 22.4722222 0.264952 22.4750000 0.264952 22.4777778 0.263429 22.4805556 0.262667 22.4833333 0.263429 22.4861111 0.266476 22.4888889 0.265714 22.4916667 0.264952 22.4944444 0.264190 22.4972222 0.266476 22.5000000 0.268762 22.5027778 0.271048 22.5055556 0.270286 22.5083333 0.271810 22.5111111 0.269524 22.5138889 0.270286 22.5166667 0.268762 22.5194444 0.271048 22.5222222 0.269524 22.5250000 0.271048 22.5277778 0.271810 22.5305556 0.272571 22.5333333 0.275619 22.5361111 0.274857 22.5388889 0.274857 22.5416667 0.274095 22.5444444 0.272571 22.5472222 0.273333 22.5500000 0.274095 22.5527778 0.274095 22.5555556 0.273333 22.5583333 0.271048 22.5611111 0.268000 22.5638889 0.268000 22.5666667 0.269524 22.5694444 0.269524 22.5722222 0.269524 22.5750000 0.267238 22.5777778 0.266476 22.5805556 0.265714 22.5833333 0.266476 22.5861111 0.268762 22.5888889 0.266476 22.5916667 0.266476 22.5944444 0.264952 22.5972222 0.265714 22.6000000 0.267238 22.6027778 0.268000 22.6055556 0.265714 22.6083333 0.264952 22.6111111 0.262667 22.6138889 0.265714 22.6166667 0.267238 22.6194444 0.268000 22.6222222 0.267238 22.6250000 0.268000 22.6277778 0.265714 22.6305556 0.264952 22.6333333 0.264190 22.6361111 0.264190 22.6388889 0.259619 22.6416667 0.255048 22.6444444 0.248952 22.6472222 0.241333 22.6500000 0.241333 22.6527778 0.243619 22.6555556 0.251238 22.6583333 0.267238 22.6611111 0.284762 22.6638889 0.300000 22.6666667 0.313714 22.6694444 0.325905 22.6722222 0.335810 22.6750000 0.346476 22.6777778 0.364000 22.6805556 0.380762 22.6833333 0.401333 22.6861111 0.414286 22.6888889 0.406667 22.6916667 0.367048 22.6944444 0.310667 22.6972222 0.266476 22.7000000 0.256571 22.7027778 0.261143 22.7055556 0.264190 22.7083333 0.262667 22.7111111 0.261143 22.7138889 0.261143 22.7166667 0.262667 22.7194444 0.262667 22.7222222 0.261905 22.7250000 0.260381 22.7277778 0.259619 22.7305556 0.258857 22.7333333 0.260381 22.7361111 0.261905 22.7388889 0.261905 22.7416667 0.260381 22.7444444 0.259619 22.7472222 0.258857 22.7500000 0.258857 22.7527778 0.261905 22.7555556 0.260381 22.7583333 0.260381 22.7611111 0.260381 22.7638889 0.259619 22.7666667 0.261143 22.7694444 0.260381 22.7722222 0.261905 22.7750000 0.260381 22.7777778 0.259619 22.7805556 0.259619 22.7833333 0.260381 22.7861111 0.259619 22.7888889 0.261143 22.7916667 0.260381 22.7944444 0.258095 22.7972222 0.259619 22.8000000 0.261143 22.8027778 0.263429 22.8055556 0.262667 22.8083333 0.262667 22.8111111 0.260381 22.8138889 0.260381 22.8166667 0.259619 22.8194444 0.261905 22.8222222 0.261905 22.8250000 0.258857 22.8277778 0.259619 22.8305556 0.260381 22.8333333 0.261143 22.8361111 0.261905 22.8388889 0.260381 22.8416667 0.259619 22.8444444 0.258095 22.8472222 0.258095 22.8500000 0.259619 22.8527778 0.260381 22.8555556 0.261143 22.8583333 0.258095 22.8611111 0.258095 22.8638889 0.258095 22.8666667 0.258857 22.8694444 0.258095 22.8722222 0.258857 22.8750000 0.258095 22.8777778 0.254286 22.8805556 0.255048 22.8833333 0.255810 22.8861111 0.256571 22.8888889 0.255810 22.8916667 0.254286 22.8944444 0.249714 22.8972222 0.250476 22.9000000 0.252762 22.9027778 0.253524 22.9055556 0.250476 22.9083333 0.248952 22.9111111 0.245143 22.9138889 0.245905 22.9166667 0.246667 22.9194444 0.246667 22.9222222 0.245143 22.9250000 0.245143 22.9277778 0.241333 22.9305556 0.239810 22.9333333 0.240571 22.9361111 0.240571 22.9388889 0.239048 22.9416667 0.239048 22.9444444 0.235238 22.9472222 0.237524 22.9500000 0.236000 22.9527778 0.238286 22.9555556 0.238286 22.9583333 0.237524 22.9611111 0.236000 22.9638889 0.237524 22.9666667 0.238286 22.9694444 0.242095 22.9722222 0.242095 22.9750000 0.242857 22.9777778 0.242095 22.9805556 0.245143 22.9833333 0.247429 22.9861111 0.249714 22.9918889 0.300000 23.2525556 0.300000 23.2555556 0.268000 23.2583333 0.267238 23.2611111 0.266476 23.2638889 0.265714 23.2666667 0.265714 23.2694444 0.268000 23.2722222 0.267238 23.2750000 0.265714 23.2777778 0.265714 23.2805556 0.266476 23.2833333 0.267238 23.2861111 0.268762 23.2888889 0.267238 23.2916667 0.266476 23.2944444 0.263429 23.2972222 0.264190 23.3000000 0.264952 23.3027778 0.268000 23.3055556 0.268000 23.3083333 0.268000 23.3111111 0.267238 23.3138889 0.268000 23.3166667 0.271048 23.3194444 0.270286 23.3222222 0.271810 23.3250000 0.271810 23.3277778 0.271048 23.3305556 0.271048 23.3333333 0.272571 23.3361111 0.273333 23.3388889 0.273333 23.3416667 0.273333 23.3444444 0.273333 23.3472222 0.275619 23.3500000 0.276381 23.3527778 0.277143 23.3555556 0.277905 23.3583333 0.274857 23.3611111 0.275619 23.3638889 0.271810 23.3666667 0.272571 23.3694444 0.274095 23.3722222 0.273333 23.3750000 0.273333 23.3777778 0.271048 23.3805556 0.271810 23.3833333 0.269524 23.3861111 0.271048 23.3888889 0.270286 23.3916667 0.271048 23.3944444 0.267238 23.3972222 0.266476 23.4000000 0.268762 23.4027778 0.268762 23.4055556 0.268000 23.4083333 0.267238 23.4111111 0.267238 23.4138889 0.266476 23.4166667 0.266476 23.4194444 0.267238 23.4222222 0.268000 23.4250000 0.267238 23.4277778 0.264952 23.4305556 0.267238 23.4333333 0.268762 23.4361111 0.268762 23.4388889 0.269524 23.4416667 0.266476 23.4444444 0.264952 23.4472222 0.264952 23.4500000 0.267238 23.4527778 0.267238 23.4555556 0.266476 23.4583333 0.261905 23.4611111 0.257333 23.4638889 0.253524 23.4666667 0.250476 23.4694444 0.248190 23.4722222 0.243619 23.4750000 0.245143 23.4777778 0.258095 23.4805556 0.276381 23.4833333 0.300000 23.4861111 0.317524 23.4888889 0.333524 23.4916667 0.351810 23.4944444 0.369333 23.4972222 0.388381 23.5000000 0.402857 23.5027778 0.396762 23.5055556 0.357905 23.5083333 0.300762 23.5111111 0.261143 23.5138889 0.253524 23.5166667 0.260381 23.5194444 0.261143 23.5222222 0.261905 23.5250000 0.260381 23.5277778 0.261143 23.5305556 0.260381 23.5333333 0.260381 23.5361111 0.261905 23.5388889 0.262667 23.5416667 0.259619 23.5444444 0.258095 23.5472222 0.256571 23.5500000 0.260381 23.5527778 0.262667 23.5555556 0.261143 23.5583333 0.261143 23.5611111 0.260381 23.5638889 0.258095 23.5666667 0.260381 23.5694444 0.261905 23.5722222 0.260381 23.5750000 0.261143 23.5777778 0.259619 23.5805556 0.259619 23.5833333 0.259619 23.5861111 0.261143 23.5888889 0.261905 23.5916667 0.260381 23.5944444 0.257333 23.5972222 0.259619 23.6000000 0.261143 23.6027778 0.263429 23.6055556 0.261905 23.6083333 0.260381 23.6111111 0.259619 23.6138889 0.259619 23.6166667 0.259619 23.6194444 0.261143 23.6222222 0.260381 23.6250000 0.261905 23.6277778 0.258857 23.6305556 0.260381 23.6333333 0.261143 23.6361111 0.262667 23.6388889 0.262667 23.6416667 0.261905 23.6444444 0.258857 23.6472222 0.260381 23.6500000 0.261905 23.6527778 0.264190 23.6555556 0.261143 23.6583333 0.261905 23.6611111 0.258095 23.6638889 0.258857 23.6666667 0.259619 23.6694444 0.261143 23.6722222 0.261143 23.6750000 0.259619 23.6777778 0.258857 23.6805556 0.256571 23.6833333 0.256571 23.6861111 0.260381 23.6888889 0.258095 23.6916667 0.256571 23.6944444 0.255810 23.6972222 0.256571 23.7000000 0.257333 23.7027778 0.258857 23.7055556 0.256571 23.7083333 0.255810 23.7111111 0.254286 23.7138889 0.251238 23.7166667 0.252000 23.7194444 0.252762 23.7222222 0.252000 23.7250000 0.250476 23.7277778 0.249714 23.7305556 0.247429 23.7333333 0.247429 23.7361111 0.248190 23.7388889 0.247429 23.7416667 0.245143 23.7444444 0.244381 23.7472222 0.243619 23.7500000 0.242857 23.7527778 0.243619 23.7555556 0.242857 23.7583333 0.239810 23.7611111 0.238286 23.7638889 0.239048 23.7666667 0.239048 23.7694444 0.239810 23.7722222 0.238286 23.7750000 0.238286 23.7777778 0.236762 23.7805556 0.236000 23.7833333 0.239048 23.7861111 0.243619 23.7888889 0.242857 23.7916667 0.243619 23.7944444 0.244381 23.7972222 0.248952 23.8000000 0.250476 23.8027778 0.252762 23.8085556 0.300000 24.0803333 0.300000 24.0833333 0.264190 24.0861111 0.268000 24.0888889 0.266476 24.0916667 0.264952 24.0944444 0.264952 24.0972222 0.264190 24.1000000 0.264952 24.1027778 0.266476 24.1055556 0.264952 24.1083333 0.264952 24.1111111 0.261905 24.1138889 0.262667 24.1166667 0.263429 24.1194444 0.265714 24.1222222 0.266476 24.1250000 0.266476 24.1277778 0.267238 24.1305556 0.265714 24.1333333 0.268762 24.1361111 0.269524 24.1388889 0.269524 24.1416667 0.268000 24.1444444 0.268000 24.1472222 0.268000 24.1500000 0.271048 24.1527778 0.273333 24.1555556 0.273333 24.1583333 0.270286 24.1611111 0.271048 24.1638889 0.271048 24.1666667 0.274095 24.1694444 0.274095 24.1722222 0.275619 24.1750000 0.274095 24.1777778 0.271810 24.1805556 0.271810 24.1833333 0.272571 24.1861111 0.272571 24.1888889 0.273333 24.1916667 0.271810 24.1944444 0.268000 24.1972222 0.267238 24.2000000 0.268000 24.2027778 0.269524 24.2055556 0.269524 24.2083333 0.268762 24.2111111 0.267238 24.2138889 0.264190 24.2166667 0.264952 24.2194444 0.265714 24.2222222 0.264190 24.2250000 0.263429 24.2277778 0.261905 24.2305556 0.261143 24.2333333 0.261905 24.2361111 0.262667 24.2388889 0.262667 24.2416667 0.261905 24.2444444 0.260381 24.2472222 0.258857 24.2500000 0.260381 24.2527778 0.263429 24.2555556 0.262667 24.2583333 0.261143 24.2611111 0.260381 24.2638889 0.260381 24.2666667 0.260381 24.2694444 0.261905 24.2722222 0.262667 24.2750000 0.261143 24.2777778 0.258857 24.2805556 0.259619 24.2833333 0.256571 24.2861111 0.255810 24.2888889 0.252000 24.2916667 0.247429 24.2944444 0.243619 24.2972222 0.238286 24.3000000 0.236762 24.3027778 0.241333 24.3055556 0.252762 24.3083333 0.266476 24.3111111 0.283238 24.3138889 0.294667 24.3166667 0.306857 24.3194444 0.322095 24.3222222 0.336571 24.3250000 0.356381 24.3277778 0.367048 24.3305556 0.361714 24.3333333 0.332762 24.3361111 0.287810 24.3388889 0.249714 24.3416667 0.237524 24.3444444 0.240571 24.3472222 0.248190 24.3500000 0.252000 24.3527778 0.253524 24.3555556 0.252000 24.3583333 0.252762 24.3611111 0.252000 24.3638889 0.251238 24.3666667 0.252000 24.3694444 0.254286 24.3722222 0.254286 24.3750000 0.251238 24.3777778 0.251238 24.3805556 0.252000 24.3833333 0.252762 24.3861111 0.255810 24.3888889 0.255048 24.3916667 0.255810 24.3944444 0.252000 24.3972222 0.253524 24.4000000 0.252762 24.4027778 0.254286 24.4055556 0.255048 24.4083333 0.252762 24.4111111 0.251238 24.4138889 0.251238 24.4166667 0.252000 24.4194444 0.254286 24.4222222 0.254286 24.4250000 0.252762 24.4277778 0.250476 24.4305556 0.252000 24.4333333 0.251238 24.4361111 0.255048 24.4388889 0.252762 24.4416667 0.255810 24.4444444 0.253524 24.4472222 0.252762 24.4500000 0.253524 24.4527778 0.256571 24.4555556 0.253524 24.4583333 0.253524 24.4611111 0.250476 24.4638889 0.252000 24.4666667 0.254286 24.4694444 0.255810 24.4722222 0.254286 24.4750000 0.252000 24.4777778 0.250476 24.4805556 0.248952 24.4833333 0.251238 24.4861111 0.255048 24.4888889 0.252762 24.4916667 0.252762 24.4944444 0.253524 24.4972222 0.251238 24.5000000 0.251238 24.5027778 0.252762 24.5055556 0.252762 24.5083333 0.253524 24.5111111 0.251238 24.5138889 0.251238 24.5166667 0.251238 24.5194444 0.252762 24.5222222 0.252000 24.5250000 0.251238 24.5277778 0.249714 24.5305556 0.250476 24.5333333 0.252000 24.5361111 0.252000 24.5388889 0.250476 24.5416667 0.250476 24.5444444 0.250476 24.5472222 0.248190 24.5500000 0.248190 24.5527778 0.247429 24.5555556 0.247429 24.5583333 0.245905 24.5611111 0.243619 24.5638889 0.244381 24.5666667 0.242857 24.5694444 0.244381 24.5722222 0.244381 24.5750000 0.242095 24.5777778 0.239810 24.5805556 0.238286 24.5833333 0.236762 24.5861111 0.240571 24.5888889 0.239048 24.5916667 0.237524 24.5944444 0.232952 24.5972222 0.232952 24.6000000 0.232190 24.6027778 0.233714 24.6055556 0.232190 24.6083333 0.232952 24.6111111 0.231429 24.6138889 0.231429 24.6166667 0.232952 24.6194444 0.234476 24.6222222 0.232952 24.6250000 0.232190 24.6277778 0.230667 24.6305556 0.231429 24.6363333 0.300000 24.9247778 0.300000 24.9277778 0.252000 24.9305556 0.252000 24.9333333 0.253524 24.9361111 0.253524 24.9388889 0.254286 24.9416667 0.254286 24.9444444 0.251238 24.9472222 0.252000 24.9500000 0.252762 24.9527778 0.253524 24.9555556 0.254286 24.9583333 0.255048 24.9611111 0.255048 24.9638889 0.252762 24.9666667 0.255048 24.9694444 0.256571 24.9722222 0.255810 24.9750000 0.253524 24.9777778 0.253524 24.9805556 0.255048 24.9833333 0.256571 24.9861111 0.258095 24.9888889 0.258095 24.9916667 0.257333 24.9944444 0.256571 24.9972222 0.255048 25.0000000 0.258095 25.0027778 0.258095 25.0055556 0.259619 25.0083333 0.262667 25.0111111 0.261143 25.0138889 0.259619 25.0166667 0.260381 25.0194444 0.261905 25.0222222 0.261143 25.0250000 0.259619 25.0277778 0.260381 25.0305556 0.259619 25.0333333 0.259619 25.0361111 0.258857 25.0388889 0.255048 25.0416667 0.255048 25.0444444 0.252000 25.0472222 0.253524 25.0500000 0.255048 25.0527778 0.256571 25.0555556 0.255048 25.0583333 0.251238 25.0611111 0.252762 25.0638889 0.250476 25.0666667 0.252762 25.0694444 0.252762 25.0722222 0.253524 25.0750000 0.252762 25.0777778 0.252000 25.0805556 0.251238 25.0833333 0.252000 25.0861111 0.252762 25.0888889 0.252000 25.0916667 0.252000 25.0944444 0.250476 25.0972222 0.251238 25.1000000 0.251238 25.1027778 0.253524 25.1055556 0.252762 25.1083333 0.252762 25.1111111 0.250476 25.1138889 0.249714 25.1166667 0.252000 25.1194444 0.252000 25.1222222 0.253524 25.1250000 0.252762 25.1277778 0.250476 25.1305556 0.248952 25.1333333 0.245905 25.1361111 0.243619 25.1388889 0.239810 25.1416667 0.235238 25.1444444 0.232190 25.1472222 0.235238 25.1500000 0.248190 25.1527778 0.264190 25.1555556 0.278667 25.1583333 0.292381 25.1611111 0.298476 25.1638889 0.309143 25.1666667 0.327429 25.1694444 0.348000 25.1722222 0.364000 25.1750000 0.365524 25.1777778 0.341143 25.1805556 0.293905 25.1833333 0.249714 25.1861111 0.226857 25.1888889 0.226095 25.1916667 0.230667 25.1944444 0.236000 25.1972222 0.241333 25.2000000 0.245905 25.2027778 0.251238 25.2055556 0.248952 25.2083333 0.248190 25.2111111 0.248952 25.2138889 0.246667 25.2166667 0.247429 25.2194444 0.248190 25.2222222 0.247429 25.2250000 0.248952 25.2277778 0.248190 25.2305556 0.247429 25.2333333 0.248952 25.2361111 0.248190 25.2388889 0.249714 25.2416667 0.247429 25.2444444 0.247429 25.2472222 0.246667 25.2500000 0.248952 25.2527778 0.251238 25.2555556 0.248952 25.2583333 0.249714 25.2611111 0.248190 25.2638889 0.249714 25.2666667 0.251238 25.2694444 0.252000 25.2722222 0.252000 25.2750000 0.251238 25.2777778 0.248952 25.2805556 0.248952 25.2833333 0.251238 25.2861111 0.252000 25.2888889 0.252762 25.2916667 0.251238 25.2944444 0.251238 25.2972222 0.251238 25.3000000 0.251238 25.3027778 0.252762 25.3055556 0.253524 25.3083333 0.252000 25.3111111 0.252762 25.3138889 0.251238 25.3166667 0.252762 25.3194444 0.253524 25.3222222 0.252762 25.3250000 0.251238 25.3277778 0.252000 25.3305556 0.252000 25.3333333 0.252762 25.3361111 0.252762 25.3388889 0.253524 25.3416667 0.252762 25.3444444 0.249714 25.3472222 0.251238 25.3500000 0.252000 25.3527778 0.253524 25.3555556 0.254286 25.3583333 0.249714 25.3611111 0.248952 25.3638889 0.248190 25.3666667 0.249714 25.3694444 0.252762 25.3722222 0.252000 25.3750000 0.251238 25.3777778 0.248190 25.3805556 0.248190 25.3833333 0.248952 25.3861111 0.251238 25.3888889 0.248190 25.3916667 0.245143 25.3944444 0.242857 25.3972222 0.242857 25.4000000 0.242857 25.4027778 0.243619 25.4055556 0.242857 25.4083333 0.239810 25.4111111 0.238286 25.4138889 0.235238 25.4166667 0.235238 25.4194444 0.236762 25.4222222 0.236762 25.4250000 0.236000 25.4277778 0.232190 25.4305556 0.229905 25.4333333 0.231429 25.4361111 0.232952 25.4388889 0.234476 25.4416667 0.233714 25.4444444 0.232190 25.4472222 0.233714 25.4500000 0.236000 25.4527778 0.237524 25.4555556 0.238286 25.4583333 0.239048 25.4611111 0.239048 25.4638889 0.242857 25.4666667 0.245905 25.4694444 0.248190 25.4722222 0.251238 25.4750000 0.252000 25.4807778 0.300000 25.7303333 0.300000 25.7333333 0.265714 25.7361111 0.267238 25.7388889 0.267238 25.7416667 0.264952 25.7444444 0.264190 25.7472222 0.263429 25.7500000 0.264952 25.7527778 0.268000 25.7555556 0.268000 25.7583333 0.265714 25.7611111 0.264952 25.7638889 0.266476 25.7666667 0.264952 25.7694444 0.265714 25.7722222 0.265714 25.7750000 0.264190 25.7777778 0.265714 25.7805556 0.264952 25.7833333 0.268000 25.7861111 0.268762 25.7888889 0.271048 25.7916667 0.268000 25.7944444 0.267238 25.7972222 0.268762 25.8000000 0.269524 25.8027778 0.274095 25.8055556 0.274095 25.8083333 0.272571 25.8111111 0.271810 25.8138889 0.270286 25.8166667 0.274095 25.8194444 0.274095 25.8222222 0.276381 25.8250000 0.276381 25.8277778 0.274857 25.8305556 0.274857 25.8333333 0.275619 25.8361111 0.275619 25.8388889 0.277143 25.8416667 0.275619 25.8444444 0.274857 25.8472222 0.272571 25.8500000 0.275619 25.8527778 0.274857 25.8555556 0.272571 25.8583333 0.272571 25.8611111 0.271048 25.8638889 0.270286 25.8666667 0.269524 25.8694444 0.272571 25.8722222 0.269524 25.8750000 0.269524 25.8777778 0.267238 25.8805556 0.267238 25.8833333 0.269524 25.8861111 0.268000 25.8888889 0.268000 25.8916667 0.265714 25.8944444 0.268000 25.8972222 0.267238 25.9000000 0.268762 25.9027778 0.269524 25.9055556 0.269524 25.9083333 0.269524 25.9111111 0.264952 25.9138889 0.264952 25.9166667 0.266476 25.9194444 0.268000 25.9222222 0.267238 25.9250000 0.267238 25.9277778 0.265714 25.9305556 0.263429 25.9333333 0.262667 25.9361111 0.261905 25.9388889 0.258857 25.9416667 0.252000 25.9444444 0.247429 25.9472222 0.242857 25.9500000 0.243619 25.9527778 0.250476 25.9555556 0.268000 25.9583333 0.289333 25.9611111 0.309905 25.9638889 0.326667 25.9666667 0.348762 25.9694444 0.367048 25.9722222 0.387619 25.9750000 0.402857 25.9777778 0.415810 25.9805556 0.424190 25.9833333 0.415048 25.9861111 0.380762 25.9888889 0.323619 25.9916667 0.275619 25.9944444 0.251238 25.9972222 0.250476 26.0000000 0.256571 26.0027778 0.258857 26.0055556 0.258857 26.0083333 0.260381 26.0111111 0.259619 26.0138889 0.257333 26.0166667 0.258095 26.0194444 0.258857 26.0222222 0.259619 26.0250000 0.256571 26.0277778 0.255810 26.0305556 0.253524 26.0333333 0.255810 26.0361111 0.257333 26.0388889 0.257333 26.0416667 0.257333 26.0444444 0.255048 26.0472222 0.254286 26.0500000 0.255048 26.0527778 0.256571 26.0555556 0.256571 26.0583333 0.257333 26.0611111 0.257333 26.0638889 0.255048 26.0666667 0.255810 26.0694444 0.257333 26.0722222 0.257333 26.0750000 0.256571 26.0777778 0.257333 26.0805556 0.256571 26.0833333 0.258857 26.0861111 0.257333 26.0888889 0.258095 26.0916667 0.256571 26.0944444 0.255810 26.0972222 0.256571 26.1000000 0.256571 26.1027778 0.260381 26.1055556 0.258857 26.1083333 0.258095 26.1111111 0.256571 26.1138889 0.255810 26.1166667 0.258095 26.1194444 0.259619 26.1222222 0.258095 26.1250000 0.258095 26.1277778 0.256571 26.1305556 0.256571 26.1333333 0.256571 26.1361111 0.257333 26.1388889 0.257333 26.1416667 0.256571 26.1444444 0.256571 26.1472222 0.254286 26.1500000 0.257333 26.1527778 0.256571 26.1555556 0.255048 26.1583333 0.252762 26.1611111 0.252000 26.1638889 0.253524 26.1666667 0.254286 26.1694444 0.255810 26.1722222 0.255810 26.1750000 0.252762 26.1777778 0.251238 26.1805556 0.252762 26.1833333 0.250476 26.1861111 0.252000 26.1888889 0.249714 26.1916667 0.247429 26.1944444 0.247429 26.1972222 0.246667 26.2000000 0.245905 26.2027778 0.246667 26.2055556 0.244381 26.2083333 0.242857 26.2111111 0.241333 26.2138889 0.238286 26.2166667 0.239810 26.2194444 0.241333 26.2222222 0.239048 26.2250000 0.237524 26.2277778 0.234476 26.2305556 0.235238 26.2333333 0.237524 26.2361111 0.237524 26.2388889 0.236762 26.2416667 0.235238 26.2444444 0.234476 26.2472222 0.235238 26.2500000 0.236000 26.2527778 0.238286 26.2555556 0.240571 26.2583333 0.240571 26.2611111 0.242095 26.2638889 0.244381 26.2666667 0.246667 26.2694444 0.252000 26.2722222 0.252762 26.2750000 0.255048 26.2777778 0.257333 26.2805556 0.257333 26.2863333 0.300000 26.5053333 0.300000 26.5083333 0.264190 26.5111111 0.263429 26.5138889 0.262667 26.5166667 0.265714 26.5194444 0.265714 26.5222222 0.265714 26.5250000 0.264952 26.5277778 0.264190 26.5305556 0.263429 26.5333333 0.265714 26.5361111 0.267238 26.5388889 0.268000 26.5416667 0.265714 26.5444444 0.264190 26.5472222 0.263429 26.5500000 0.264952 26.5527778 0.264952 26.5555556 0.267238 26.5583333 0.265714 26.5611111 0.263429 26.5638889 0.264952 26.5666667 0.266476 26.5694444 0.268000 26.5722222 0.268762 26.5750000 0.268000 26.5777778 0.268762 26.5805556 0.268000 26.5833333 0.271810 26.5861111 0.274095 26.5888889 0.272571 26.5916667 0.271048 26.5944444 0.268000 26.5972222 0.271810 26.6000000 0.274857 26.6027778 0.275619 26.6055556 0.277143 26.6083333 0.274857 26.6111111 0.274095 26.6138889 0.273333 26.6166667 0.273333 26.6194444 0.275619 26.6222222 0.274857 26.6250000 0.271048 26.6277778 0.268762 26.6305556 0.267238 26.6333333 0.268762 26.6361111 0.269524 26.6388889 0.269524 26.6416667 0.267238 26.6444444 0.266476 26.6472222 0.266476 26.6500000 0.268762 26.6527778 0.268762 26.6555556 0.268000 26.6583333 0.264952 26.6611111 0.264190 26.6638889 0.262667 26.6666667 0.264190 26.6694444 0.266476 26.6722222 0.264952 26.6750000 0.264190 26.6777778 0.263429 26.6805556 0.263429 26.6833333 0.264952 26.6861111 0.264952 26.6888889 0.264952 26.6916667 0.264190 26.6944444 0.263429 26.6972222 0.262667 26.7000000 0.262667 26.7027778 0.265714 26.7055556 0.263429 26.7083333 0.263429 26.7111111 0.258857 26.7138889 0.254286 26.7166667 0.252762 26.7194444 0.249714 26.7222222 0.246667 26.7250000 0.237524 26.7277778 0.238286 26.7305556 0.247429 26.7333333 0.266476 26.7361111 0.289333 26.7388889 0.308381 26.7416667 0.322095 26.7444444 0.337333 26.7472222 0.357143 26.7500000 0.376190 26.7527778 0.392190 26.7555556 0.391429 26.7583333 0.357905 26.7611111 0.302286 26.7638889 0.259619 26.7666667 0.248952 26.7694444 0.257333 26.7722222 0.261143 26.7750000 0.259619 26.7777778 0.258857 26.7805556 0.260381 26.7833333 0.262667 26.7861111 0.261905 26.7888889 0.258857 26.7916667 0.258857 26.7944444 0.258095 26.7972222 0.258857 26.8000000 0.259619 26.8027778 0.261143 26.8055556 0.260381 26.8083333 0.259619 26.8111111 0.258857 26.8138889 0.256571 26.8166667 0.260381 26.8194444 0.261905 26.8222222 0.260381 26.8250000 0.258857 26.8277778 0.258095 26.8305556 0.256571 26.8333333 0.260381 26.8361111 0.261143 26.8388889 0.260381 26.8416667 0.260381 26.8444444 0.256571 26.8472222 0.257333 26.8500000 0.259619 26.8527778 0.261905 26.8555556 0.260381 26.8583333 0.259619 26.8611111 0.258857 26.8638889 0.258095 26.8666667 0.259619 26.8694444 0.261143 26.8722222 0.260381 26.8750000 0.260381 26.8777778 0.259619 26.8805556 0.259619 26.8833333 0.261143 26.8861111 0.263429 26.8888889 0.261143 26.8916667 0.260381 26.8944444 0.258857 26.8972222 0.258857 26.9000000 0.259619 26.9027778 0.261905 26.9055556 0.261143 26.9083333 0.259619 26.9111111 0.257333 26.9138889 0.258095 26.9166667 0.260381 26.9194444 0.261143 26.9222222 0.261143 26.9250000 0.258857 26.9277778 0.258857 26.9305556 0.256571 26.9333333 0.257333 26.9361111 0.258095 26.9388889 0.258857 26.9416667 0.255810 26.9444444 0.255810 26.9472222 0.255048 26.9500000 0.254286 26.9527778 0.255048 26.9555556 0.253524 26.9583333 0.252762 26.9611111 0.251238 26.9638889 0.249714 26.9666667 0.250476 26.9694444 0.251238 26.9722222 0.248952 26.9750000 0.248190 26.9777778 0.243619 26.9805556 0.242857 26.9833333 0.244381 26.9861111 0.245905 26.9888889 0.244381 26.9916667 0.241333 26.9944444 0.239048 26.9972222 0.237524 27.0000000 0.240571 27.0027778 0.241333 27.0055556 0.239048 27.0083333 0.239048 27.0111111 0.236762 27.0138889 0.235238 27.0166667 0.237524 27.0194444 0.239810 27.0222222 0.239810 27.0250000 0.241333 27.0277778 0.238286 27.0305556 0.242095 27.0333333 0.245905 27.0361111 0.249714 27.0388889 0.251238 27.0416667 0.251238 27.0444444 0.253524 27.0472222 0.252762 27.0500000 0.257333 27.0527778 0.260381 27.0555556 0.261143 27.0613333 0.300000 27.3053333 0.300000 27.3083333 0.261143 27.3111111 0.260381 27.3138889 0.259619 27.3166667 0.261905 27.3194444 0.264190 27.3222222 0.263429 27.3250000 0.261905 27.3277778 0.260381 27.3305556 0.258095 27.3333333 0.259619 27.3361111 0.261143 27.3388889 0.261905 27.3416667 0.260381 27.3444444 0.261143 27.3472222 0.260381 27.3500000 0.262667 27.3527778 0.262667 27.3555556 0.261905 27.3583333 0.261905 27.3611111 0.261143 27.3638889 0.262667 27.3666667 0.265714 27.3694444 0.268000 27.3722222 0.268000 27.3750000 0.266476 27.3777778 0.265714 27.3805556 0.264952 27.3833333 0.268000 27.3861111 0.268000 27.3888889 0.268000 27.3916667 0.269524 27.3944444 0.267238 27.3972222 0.266476 27.4000000 0.270286 27.4027778 0.268762 27.4055556 0.269524 27.4083333 0.269524 27.4111111 0.265714 27.4138889 0.264190 27.4166667 0.264190 27.4194444 0.264952 27.4222222 0.264952 27.4250000 0.262667 27.4277778 0.261905 27.4305556 0.262667 27.4333333 0.260381 27.4361111 0.263429 27.4388889 0.261905 27.4416667 0.260381 27.4444444 0.258095 27.4472222 0.257333 27.4500000 0.259619 27.4527778 0.259619 27.4555556 0.259619 27.4583333 0.258857 27.4611111 0.255810 27.4638889 0.256571 27.4666667 0.257333 27.4694444 0.259619 27.4722222 0.258095 27.4750000 0.260381 27.4777778 0.259619 27.4805556 0.258095 27.4833333 0.259619 27.4861111 0.259619 27.4888889 0.258857 27.4916667 0.257333 27.4944444 0.256571 27.4972222 0.257333 27.5000000 0.258095 27.5027778 0.257333 27.5055556 0.255810 27.5083333 0.252762 27.5111111 0.248190 27.5138889 0.244381 27.5166667 0.241333 27.5194444 0.237524 27.5222222 0.233714 27.5250000 0.236000 27.5277778 0.240571 27.5305556 0.253524 27.5333333 0.268762 27.5361111 0.282476 27.5388889 0.296190 27.5416667 0.303048 27.5444444 0.316000 27.5472222 0.334286 27.5500000 0.354857 27.5527778 0.362476 27.5555556 0.348762 27.5583333 0.306857 27.5611111 0.260381 27.5638889 0.233714 27.5666667 0.233714 27.5694444 0.243619 27.5722222 0.250476 27.5750000 0.250476 27.5777778 0.252762 27.5805556 0.251238 27.5833333 0.251238 27.5861111 0.252000 27.5888889 0.252000 27.5916667 0.252000 27.5944444 0.252000 27.5972222 0.251238 27.6000000 0.252762 27.6027778 0.253524 27.6055556 0.252000 27.6083333 0.251238 27.6111111 0.249714 27.6138889 0.249714 27.6166667 0.252762 27.6194444 0.255810 27.6222222 0.255048 27.6250000 0.253524 27.6277778 0.252000 27.6305556 0.251238 27.6333333 0.252000 27.6361111 0.255048 27.6388889 0.253524 27.6416667 0.252762 27.6444444 0.252762 27.6472222 0.252000 27.6500000 0.254286 27.6527778 0.254286 27.6555556 0.252000 27.6583333 0.252762 27.6611111 0.251238 27.6638889 0.250476 27.6666667 0.251238 27.6694444 0.253524 27.6722222 0.252762 27.6750000 0.251238 27.6777778 0.250476 27.6805556 0.251238 27.6833333 0.254286 27.6861111 0.255810 27.6888889 0.255048 27.6916667 0.253524 27.6944444 0.252762 27.6972222 0.253524 27.7000000 0.252762 27.7027778 0.255810 27.7055556 0.255810 27.7083333 0.255810 27.7111111 0.252762 27.7138889 0.252762 27.7166667 0.251238 27.7194444 0.252762 27.7222222 0.250476 27.7250000 0.252000 27.7277778 0.248952 27.7305556 0.249714 27.7333333 0.250476 27.7361111 0.252762 27.7388889 0.252000 27.7416667 0.252000 27.7444444 0.250476 27.7472222 0.248952 27.7500000 0.249714 27.7527778 0.250476 27.7555556 0.248190 27.7583333 0.247429 27.7611111 0.246667 27.7638889 0.247429 27.7666667 0.248190 27.7694444 0.248952 27.7722222 0.245143 27.7750000 0.242857 27.7777778 0.242095 27.7805556 0.240571 27.7833333 0.242095 27.7861111 0.244381 27.7888889 0.242857 27.7916667 0.239048 27.7944444 0.237524 27.7972222 0.238286 27.8000000 0.236000 27.8027778 0.237524 27.8055556 0.236762 27.8083333 0.235238 27.8111111 0.232952 27.8138889 0.231429 27.8166667 0.232190 27.8194444 0.234476 27.8222222 0.232952 27.8250000 0.232190 27.8277778 0.231429 27.8305556 0.231429 27.8333333 0.234476 27.8361111 0.237524 27.8388889 0.238286 27.8416667 0.237524 27.8444444 0.239048 27.8472222 0.242095 27.8500000 0.244381 27.8527778 0.248190 27.8555556 0.249714 27.8613333 0.300000 28.0942222 0.300000 28.0972222 0.251238 28.1000000 0.253524 28.1027778 0.253524 28.1055556 0.252000 28.1083333 0.251238 28.1111111 0.250476 28.1138889 0.248952 28.1166667 0.250476 28.1194444 0.252762 28.1222222 0.252762 28.1250000 0.251238 28.1277778 0.251238 28.1305556 0.248952 28.1333333 0.252762 28.1361111 0.252000 28.1388889 0.253524 28.1416667 0.249714 28.1444444 0.250476 28.1472222 0.250476 28.1500000 0.252762 28.1527778 0.255048 28.1555556 0.254286 28.1583333 0.255048 28.1611111 0.253524 28.1638889 0.252000 28.1666667 0.255048 28.1694444 0.255810 28.1722222 0.256571 28.1750000 0.257333 28.1777778 0.255810 28.1805556 0.258095 28.1833333 0.261905 28.1861111 0.263429 28.1888889 0.261143 28.1916667 0.258857 28.1944444 0.256571 28.1972222 0.256571 28.2000000 0.256571 28.2027778 0.258857 28.2055556 0.259619 28.2083333 0.258857 28.2111111 0.254286 28.2138889 0.254286 28.2166667 0.255048 28.2194444 0.254286 28.2222222 0.253524 28.2250000 0.252762 28.2277778 0.252762 28.2305556 0.251238 28.2333333 0.252762 28.2361111 0.253524 28.2388889 0.252762 28.2416667 0.252762 28.2444444 0.249714 28.2472222 0.250476 28.2500000 0.251238 28.2527778 0.252762 28.2555556 0.252000 28.2583333 0.248952 28.2611111 0.247429 28.2638889 0.250476 28.2666667 0.252000 28.2694444 0.252762 28.2722222 0.251238 28.2750000 0.249714 28.2777778 0.248952 28.2805556 0.248952 28.2833333 0.250476 28.2861111 0.251238 28.2888889 0.249714 28.2916667 0.250476 28.2944444 0.247429 28.2972222 0.245143 28.3000000 0.245143 28.3027778 0.244381 28.3055556 0.241333 28.3083333 0.235238 28.3111111 0.230667 28.3138889 0.229143 28.3166667 0.236762 28.3194444 0.252762 28.3222222 0.267238 28.3250000 0.284000 28.3277778 0.293905 28.3305556 0.301524 28.3333333 0.315238 28.3361111 0.332762 28.3388889 0.351048 28.3416667 0.364000 28.3444444 0.359429 28.3472222 0.328190 28.3500000 0.280190 28.3527778 0.242095 28.3555556 0.226857 28.3583333 0.232190 28.3611111 0.237524 28.3638889 0.240571 28.3666667 0.246667 28.3694444 0.248952 28.3722222 0.248190 28.3750000 0.248190 28.3777778 0.246667 28.3805556 0.247429 28.3833333 0.248952 28.3861111 0.248190 28.3888889 0.249714 28.3916667 0.248952 28.3944444 0.249714 28.3972222 0.248952 28.4000000 0.249714 28.4027778 0.251238 28.4055556 0.250476 28.4083333 0.248190 28.4111111 0.248190 28.4138889 0.248190 28.4166667 0.248952 28.4194444 0.251238 28.4222222 0.252000 28.4250000 0.250476 28.4277778 0.249714 28.4305556 0.248190 28.4333333 0.249714 28.4361111 0.252762 28.4388889 0.251238 28.4416667 0.250476 28.4444444 0.249714 28.4472222 0.249714 28.4500000 0.251238 28.4527778 0.251238 28.4555556 0.252000 28.4583333 0.251238 28.4611111 0.249714 28.4638889 0.250476 28.4666667 0.250476 28.4694444 0.253524 28.4722222 0.253524 28.4750000 0.252762 28.4777778 0.251238 28.4805556 0.249714 28.4833333 0.252000 28.4861111 0.253524 28.4888889 0.254286 28.4916667 0.255048 28.4944444 0.252762 28.4972222 0.252000 28.5000000 0.252762 28.5027778 0.253524 28.5055556 0.254286 28.5083333 0.253524 28.5111111 0.252000 28.5138889 0.252762 28.5166667 0.254286 28.5194444 0.255048 28.5222222 0.253524 28.5250000 0.252000 28.5277778 0.252762 28.5305556 0.251238 28.5333333 0.253524 28.5361111 0.252762 28.5388889 0.255810 28.5416667 0.252762 28.5444444 0.251238 28.5472222 0.250476 28.5500000 0.252000 28.5527778 0.251238 28.5555556 0.252000 28.5583333 0.248952 28.5611111 0.247429 28.5638889 0.249714 28.5666667 0.248952 28.5694444 0.250476 28.5722222 0.247429 28.5750000 0.245905 28.5777778 0.243619 28.5805556 0.241333 28.5833333 0.244381 28.5861111 0.242857 28.5888889 0.242857 28.5916667 0.240571 28.5944444 0.237524 28.5972222 0.235238 28.6000000 0.235238 28.6027778 0.237524 28.6055556 0.235238 28.6083333 0.235238 28.6111111 0.233714 28.6138889 0.232190 28.6166667 0.232190 28.6194444 0.233714 28.6222222 0.232952 28.6250000 0.232190 28.6277778 0.232952 28.6305556 0.233714 28.6333333 0.234476 28.6361111 0.237524 28.6388889 0.239048 28.6416667 0.238286 28.6444444 0.238286 28.6502222 0.300000 28.8472222 0.300000)

.include "C:/Users/kadhi/OneDrive/Desktop/amux/verilogLearning/Leaky-Integrate-Fire---SNN-model-on-FPGA/experiments/frontend_optimization/complete_frontend_v9b/inverter.spice"
.include "C:/Users/kadhi/OneDrive/Desktop/amux/verilogLearning/Leaky-Integrate-Fire---SNN-model-on-FPGA/experiments/frontend_optimization/complete_frontend_v9b/bias_gen.spice"
.include "C:/Users/kadhi/OneDrive/Desktop/amux/verilogLearning/Leaky-Integrate-Fire---SNN-model-on-FPGA/experiments/frontend_optimization/complete_frontend_v9b/rpeak_detector.spice"
.include "C:/Users/kadhi/OneDrive/Desktop/amux/verilogLearning/Leaky-Integrate-Fire---SNN-model-on-FPGA/experiments/frontend_optimization/complete_frontend_v9b/rpeak_hold.spice"
.include "C:/Users/kadhi/OneDrive/Desktop/amux/verilogLearning/Leaky-Integrate-Fire---SNN-model-on-FPGA/experiments/frontend_optimization/complete_frontend_v9b/pulse_gen.spice"
.include "C:/Users/kadhi/OneDrive/Desktop/amux/verilogLearning/Leaky-Integrate-Fire---SNN-model-on-FPGA/experiments/frontend_optimization/complete_frontend_v9b/long_pulse_gen.spice"
.include "C:/Users/kadhi/OneDrive/Desktop/amux/verilogLearning/Leaky-Integrate-Fire---SNN-model-on-FPGA/experiments/frontend_optimization/complete_frontend_v9b/delay_timer.spice"
.include "C:/Users/kadhi/OneDrive/Desktop/amux/verilogLearning/Leaky-Integrate-Fire---SNN-model-on-FPGA/experiments/frontend_optimization/complete_frontend_v9b/edge_buffer.spice"
.include "C:/Users/kadhi/OneDrive/Desktop/amux/verilogLearning/Leaky-Integrate-Fire---SNN-model-on-FPGA/experiments/frontend_optimization/complete_frontend_v9b/pwave_predictor.spice"
.include "C:/Users/kadhi/OneDrive/Desktop/amux/verilogLearning/Leaky-Integrate-Fire---SNN-model-on-FPGA/experiments/frontend_optimization/complete_frontend_v9b/rr_timing.spice"
.include "C:/Users/kadhi/OneDrive/Desktop/amux/verilogLearning/Leaky-Integrate-Fire---SNN-model-on-FPGA/experiments/frontend_optimization/complete_frontend_v9b/beat_instability.spice"
.include "C:/Users/kadhi/OneDrive/Desktop/amux/verilogLearning/Leaky-Integrate-Fire---SNN-model-on-FPGA/experiments/frontend_optimization/complete_frontend_v9b/pwave_diff.spice"
.include "C:/Users/kadhi/OneDrive/Desktop/amux/verilogLearning/Leaky-Integrate-Fire---SNN-model-on-FPGA/experiments/frontend_optimization/complete_frontend_v9b/qrs_width.spice"
.include "C:/Users/kadhi/OneDrive/Desktop/amux/verilogLearning/Leaky-Integrate-Fire---SNN-model-on-FPGA/experiments/frontend_optimization/complete_frontend_v9b/qrs_slope.spice"
.include "C:/Users/kadhi/OneDrive/Desktop/amux/verilogLearning/Leaky-Integrate-Fire---SNN-model-on-FPGA/experiments/frontend_optimization/complete_frontend_v9b/qrs_symmetry.spice"

* === BIAS GENERATOR ===
Xbias vbias vref vdd vss bias_gen
.ic V(xbias.iref)=0.3

* === R-PEAK DETECTOR (matches integration_test.py exactly) ===
Vthresh rpeak_threshold 0 0.367429
Xrpk ecg_l0 rpeak_threshold rpeak_level vdd vss vbias rpeak_detector
Xhold rpeak_level rpeak_level_held vdd vss vbias rpeak_hold
.ic V(xhold.hold_cap)=0
Xeb_rpk_in rpeak_level_held rpeak_level_sharp vdd vss edge_buffer
Xpg_rpk rpeak_level_sharp rpeak_pulse_raw vdd vss vbias pulse_gen
Xeb_rpk rpeak_pulse_raw rpeak_pulse vdd vss edge_buffer

* === DELAY TIMER ===
Vth14 vth_14_node 0 0.274000
Vth69 vth_69_node 0 0.446645
Vth28 vth_28_node 0 0.468112
Vth300 vth_300_node 0 0.329200
Vth10 vth_10_node 0 0.309477
Vth_rpk_del vth_rpk_del_node 0 0.437470

Xdt rpeak_pulse trig_s14_level trig_s69_level trig_wid_level trig_bi_level trig_rr_level trig_rpk_del_level dt_sf_out vdd vss vbias vth_14_node vth_69_node vth_28_node vth_300_node vth_10_node vth_rpk_del_node delay_timer

* Delay timer signal chain: level -> pulse_gen -> edge_buffer (NOT eb->pg!)
* s14 uses pulse_gen; s69/wid/bi use long_pulse_gen (longer hold time)
Xpg_s14 trig_s14_level pg_s14_raw vdd vss vbias pulse_gen
Xpg_s69 trig_s69_level pg_s69_raw vdd vss vbias long_pulse_gen
Xpg_wid trig_wid_level pg_wid_raw vdd vss vbias long_pulse_gen
Xpg_bi  trig_bi_level  pg_bi_raw  vdd vss vbias long_pulse_gen
Xpg_rr  trig_rr_level  pg_rr_raw  vdd vss vbias pulse_gen
Xpg_rpk_del trig_rpk_del_level pg_rpk_del_raw vdd vss vbias pulse_gen

Xeb_s14 pg_s14_raw trig_s14 vdd vss edge_buffer
Xeb_s69 pg_s69_raw trig_s69 vdd vss edge_buffer
Xeb_wid pg_wid_raw trig_wid vdd vss edge_buffer
Xeb_bi  pg_bi_raw  trig_bi_copy vdd vss edge_buffer
Xeb_rr  pg_rr_raw  trig_rr_copy vdd vss edge_buffer
Xeb_rpk_del pg_rpk_del_raw rpeak_pulse_delayed vdd vss edge_buffer

* === ISOLATED DUPLICATE TIMER for pwave base/peak ===
* Prevents esamp loading transients from corrupting pwave comparisons
Xinv_rpk_pre rpeak_pulse rpk_bar_pre vdd vss inverter_sub
XMpre2n vdd rpeak_pulse net_timer2 vss sky130_fd_pr__nfet_01v8 L=0.5 W=2 nf=1
XMpre2p vdd rpk_bar_pre net_timer2 vdd sky130_fd_pr__pfet_01v8 L=0.5 W=2 nf=1
XMdis2 net_timer2 vbias vss vss sky130_fd_pr__nfet_01v8 L=8 W=0.42 nf=1
XCtimer2 net_timer2 vss sky130_fd_pr__cap_mim_m3_1 W=400 L=400
XMsf2 vdd net_timer2 sf2_out vss sky130_fd_pr__nfet_01v8 L=8 W=0.42 nf=1
XMsf2_bias sf2_out vbias vss vss sky130_fd_pr__nfet_01v8 L=8 W=0.42 nf=1

* === PWAVE PREDICTOR ===
* Thresholds track rr_ewma with fixed offsets (Vsource coupling, matches integration_test.py)
Vrrc_off rrc_threshold rr_ewma 0.02
Vpwb_off vth_pw_base_node rr_ewma 0.023352
Vpwp_off vth_pw_peak_node rr_ewma 0.014952

* rr_cap comparator on ORIGINAL timer (esamp dip helps fast comparator reset)
Xpwpred_rrc rr_timer rr_ewma rrc_pwb_unused rrc_pwp_unused rr_cap_level vth_pw_base_node vth_pw_peak_node rrc_threshold vdd vss vbias pwave_predictor
* pw_base/pw_peak comparators on ISOLATED timer (no esamp transient)
Xpwpred_pw sf2_out rr_ewma pw_base_cmp pw_peak_cmp pw_rrc_unused vth_pw_base_node vth_pw_peak_node rrc_threshold vdd vss vbias pwave_predictor

* rr_cap AND gate: trig_rr_cap = rr_cap_level AND NOT(rpeak_level)
Xinv_rpk rpeak_level rpeak_level_bar vdd vss inverter_sub
XMnand_p1 nand_rrc rr_cap_level vdd vdd sky130_fd_pr__pfet_01v8 L=0.15 W=2 nf=1
XMnand_p2 nand_rrc rpeak_level_bar vdd vdd sky130_fd_pr__pfet_01v8 L=0.15 W=2 nf=1
XMnand_n1 nand_rrc rr_cap_level nand_mid_rrc vss sky130_fd_pr__nfet_01v8 L=0.15 W=1 nf=1
XMnand_n2 nand_mid_rrc rpeak_level_bar vss vss sky130_fd_pr__nfet_01v8 L=0.15 W=1 nf=1
Xinv_nand_rrc nand_rrc trig_rr_cap vdd vss inverter_sub

* pw_base/pw_peak: comparator -> edge_buffer -> pulse_gen
Xeb_pwb pw_base_cmp pwb_level vdd vss edge_buffer
Xpg_pwb pwb_level trig_pw_base vdd vss vbias pulse_gen
Xeb_pwp pw_peak_cmp pwp_level vdd vss edge_buffer
Xpg_pwp pwp_level trig_pw_peak vdd vss vbias pulse_gen

* === FEATURE CIRCUITS ===
Xrr ecg_l0 trig_rr_cap rpeak_pulse trig_rr_copy f1 f2 rr_timer rr_ewma vdd vss vbias rr_timing
Xbi0 ecg_l0 rpeak_pulse_delayed trig_bi_copy f3 vdd vss vbias beat_instability
Xbi1 ecg_l1 rpeak_pulse_delayed trig_bi_copy f4 vdd vss vbias beat_instability
Xpw ecg_l0 trig_pw_base trig_pw_peak f5 vdd vss vbias pwave_diff
Xwid ecg_l0 trig_wid f6 vdd vss qrs_width
Xslp ecg_l0 trig_s14 trig_s69 f7 vdd vss vbias qrs_slope
Xsym ecg_l0 rpeak_pulse_delayed f8 vdd vss qrs_symmetry

* === INITIAL CONDITIONS ===
.ic V(xrr.net_timer)=0.9
.ic V(xrr.ewma_node)=0.391389
.ic V(xrr.esamp_node)=0.391389
.ic V(xrr.prev_node)=0.391389
.ic V(net_timer2)=0.9
.ic V(xbi0.prev_node)=0.3
.ic V(xbi0.esamp_node)=0.3
.ic V(xbi1.prev_node)=0.3
.ic V(xbi1.esamp_node)=0.3
.ic V(xdt.timer_node)=0
.ic V(xdt.timer2)=0
.ic V(rpeak_pulse_raw)=0
.ic V(rpeak_level_held)=0

.tran 0.5m 28.8472 UIC
.meas tran f1_5 FIND V(f1) AT=4.7561111
.meas tran f2_5 FIND V(f2) AT=5.1138889
.meas tran f3_5 FIND V(f3) AT=4.9111111
.meas tran f4_5 FIND V(f4) AT=4.9111111
.meas tran f5_5 FIND V(f5) AT=4.9111111
.meas tran f6_5 FIND V(f6) AT=4.9111111
.meas tran f7_5 FIND V(f7) AT=4.9111111
.meas tran f8_5 FIND V(f8) AT=4.9111111
.meas tran f1_6 FIND V(f1) AT=5.4088889
.meas tran f2_6 FIND V(f2) AT=6.1083333
.meas tran f3_6 FIND V(f3) AT=5.5638889
.meas tran f4_6 FIND V(f4) AT=5.5638889
.meas tran f5_6 FIND V(f5) AT=5.5638889
.meas tran f6_6 FIND V(f6) AT=5.5638889
.meas tran f7_6 FIND V(f7) AT=5.5638889
.meas tran f8_6 FIND V(f8) AT=5.5638889
.meas tran f1_7 FIND V(f1) AT=6.4033333
.meas tran f2_7 FIND V(f2) AT=6.9527778
.meas tran f3_7 FIND V(f3) AT=6.5583333
.meas tran f4_7 FIND V(f4) AT=6.5583333
.meas tran f5_7 FIND V(f5) AT=6.5583333
.meas tran f6_7 FIND V(f6) AT=6.5583333
.meas tran f7_7 FIND V(f7) AT=6.5583333
.meas tran f8_7 FIND V(f8) AT=6.5583333
.meas tran f1_8 FIND V(f1) AT=7.2477778
.meas tran f2_8 FIND V(f2) AT=7.7638889
.meas tran f3_8 FIND V(f3) AT=7.4027778
.meas tran f4_8 FIND V(f4) AT=7.4027778
.meas tran f5_8 FIND V(f5) AT=7.4027778
.meas tran f6_8 FIND V(f6) AT=7.4027778
.meas tran f7_8 FIND V(f7) AT=7.4027778
.meas tran f8_8 FIND V(f8) AT=7.4027778
.meas tran f1_9 FIND V(f1) AT=8.0588889
.meas tran f2_9 FIND V(f2) AT=8.5527778
.meas tran f3_9 FIND V(f3) AT=8.2138889
.meas tran f4_9 FIND V(f4) AT=8.2138889
.meas tran f5_9 FIND V(f5) AT=8.2138889
.meas tran f6_9 FIND V(f6) AT=8.2138889
.meas tran f7_9 FIND V(f7) AT=8.2138889
.meas tran f8_9 FIND V(f8) AT=8.2138889
.meas tran f1_10 FIND V(f1) AT=8.8477778
.meas tran f2_10 FIND V(f2) AT=9.3250000
.meas tran f3_10 FIND V(f3) AT=9.0027778
.meas tran f4_10 FIND V(f4) AT=9.0027778
.meas tran f5_10 FIND V(f5) AT=9.0027778
.meas tran f6_10 FIND V(f6) AT=9.0027778
.meas tran f7_10 FIND V(f7) AT=9.0027778
.meas tran f8_10 FIND V(f8) AT=9.0027778
.meas tran f1_11 FIND V(f1) AT=9.6200000
.meas tran f2_11 FIND V(f2) AT=10.1638889
.meas tran f3_11 FIND V(f3) AT=9.7750000
.meas tran f4_11 FIND V(f4) AT=9.7750000
.meas tran f5_11 FIND V(f5) AT=9.7750000
.meas tran f6_11 FIND V(f6) AT=9.7750000
.meas tran f7_11 FIND V(f7) AT=9.7750000
.meas tran f8_11 FIND V(f8) AT=9.7750000
.meas tran f1_12 FIND V(f1) AT=10.4588889
.meas tran f2_12 FIND V(f2) AT=11.0194444
.meas tran f3_12 FIND V(f3) AT=10.6138889
.meas tran f4_12 FIND V(f4) AT=10.6138889
.meas tran f5_12 FIND V(f5) AT=10.6138889
.meas tran f6_12 FIND V(f6) AT=10.6138889
.meas tran f7_12 FIND V(f7) AT=10.6138889
.meas tran f8_12 FIND V(f8) AT=10.6138889
.meas tran f1_13 FIND V(f1) AT=11.3144444
.meas tran f2_13 FIND V(f2) AT=11.8416667
.meas tran f3_13 FIND V(f3) AT=11.4694444
.meas tran f4_13 FIND V(f4) AT=11.4694444
.meas tran f5_13 FIND V(f5) AT=11.4694444
.meas tran f6_13 FIND V(f6) AT=11.4694444
.meas tran f7_13 FIND V(f7) AT=11.4694444
.meas tran f8_13 FIND V(f8) AT=11.4694444
.meas tran f1_14 FIND V(f1) AT=12.1366667
.meas tran f2_14 FIND V(f2) AT=12.6694444
.meas tran f3_14 FIND V(f3) AT=12.2916667
.meas tran f4_14 FIND V(f4) AT=12.2916667
.meas tran f5_14 FIND V(f5) AT=12.2916667
.meas tran f6_14 FIND V(f6) AT=12.2916667
.meas tran f7_14 FIND V(f7) AT=12.2916667
.meas tran f8_14 FIND V(f8) AT=12.2916667
.meas tran f1_15 FIND V(f1) AT=12.9644444
.meas tran f2_15 FIND V(f2) AT=13.4916667
.meas tran f3_15 FIND V(f3) AT=13.1194444
.meas tran f4_15 FIND V(f4) AT=13.1194444
.meas tran f5_15 FIND V(f5) AT=13.1194444
.meas tran f6_15 FIND V(f6) AT=13.1194444
.meas tran f7_15 FIND V(f7) AT=13.1194444
.meas tran f8_15 FIND V(f8) AT=13.1194444
.meas tran f1_16 FIND V(f1) AT=13.7866667
.meas tran f2_16 FIND V(f2) AT=14.2861111
.meas tran f3_16 FIND V(f3) AT=13.9416667
.meas tran f4_16 FIND V(f4) AT=13.9416667
.meas tran f5_16 FIND V(f5) AT=13.9416667
.meas tran f6_16 FIND V(f6) AT=13.9416667
.meas tran f7_16 FIND V(f7) AT=13.9416667
.meas tran f8_16 FIND V(f8) AT=13.9416667
.meas tran f1_17 FIND V(f1) AT=14.5811111
.meas tran f2_17 FIND V(f2) AT=15.0833333
.meas tran f3_17 FIND V(f3) AT=14.7361111
.meas tran f4_17 FIND V(f4) AT=14.7361111
.meas tran f5_17 FIND V(f5) AT=14.7361111
.meas tran f6_17 FIND V(f6) AT=14.7361111
.meas tran f7_17 FIND V(f7) AT=14.7361111
.meas tran f8_17 FIND V(f8) AT=14.7361111
.meas tran f1_18 FIND V(f1) AT=15.3783333
.meas tran f2_18 FIND V(f2) AT=15.8750000
.meas tran f3_18 FIND V(f3) AT=15.5333333
.meas tran f4_18 FIND V(f4) AT=15.5333333
.meas tran f5_18 FIND V(f5) AT=15.5333333
.meas tran f6_18 FIND V(f6) AT=15.5333333
.meas tran f7_18 FIND V(f7) AT=15.5333333
.meas tran f8_18 FIND V(f8) AT=15.5333333
.meas tran f1_19 FIND V(f1) AT=16.1700000
.meas tran f2_19 FIND V(f2) AT=16.6972222
.meas tran f3_19 FIND V(f3) AT=16.3250000
.meas tran f4_19 FIND V(f4) AT=16.3250000
.meas tran f5_19 FIND V(f5) AT=16.3250000
.meas tran f6_19 FIND V(f6) AT=16.3250000
.meas tran f7_19 FIND V(f7) AT=16.3250000
.meas tran f8_19 FIND V(f8) AT=16.3250000
.meas tran f1_20 FIND V(f1) AT=16.9922222
.meas tran f2_20 FIND V(f2) AT=17.5666667
.meas tran f3_20 FIND V(f3) AT=17.1472222
.meas tran f4_20 FIND V(f4) AT=17.1472222
.meas tran f5_20 FIND V(f5) AT=17.1472222
.meas tran f6_20 FIND V(f6) AT=17.1472222
.meas tran f7_20 FIND V(f7) AT=17.1472222
.meas tran f8_20 FIND V(f8) AT=17.1472222
.meas tran f1_21 FIND V(f1) AT=17.8616667
.meas tran f2_21 FIND V(f2) AT=18.3888889
.meas tran f3_21 FIND V(f3) AT=18.0166667
.meas tran f4_21 FIND V(f4) AT=18.0166667
.meas tran f5_21 FIND V(f5) AT=18.0166667
.meas tran f6_21 FIND V(f6) AT=18.0166667
.meas tran f7_21 FIND V(f7) AT=18.0166667
.meas tran f8_21 FIND V(f8) AT=18.0166667
.meas tran f1_22 FIND V(f1) AT=18.6838889
.meas tran f2_22 FIND V(f2) AT=19.1750000
.meas tran f3_22 FIND V(f3) AT=18.8388889
.meas tran f4_22 FIND V(f4) AT=18.8388889
.meas tran f5_22 FIND V(f5) AT=18.8388889
.meas tran f6_22 FIND V(f6) AT=18.8388889
.meas tran f7_22 FIND V(f7) AT=18.8388889
.meas tran f8_22 FIND V(f8) AT=18.8388889
.meas tran f1_23 FIND V(f1) AT=19.4700000
.meas tran f2_23 FIND V(f2) AT=19.9666667
.meas tran f3_23 FIND V(f3) AT=19.6250000
.meas tran f4_23 FIND V(f4) AT=19.6250000
.meas tran f5_23 FIND V(f5) AT=19.6250000
.meas tran f6_23 FIND V(f6) AT=19.6250000
.meas tran f7_23 FIND V(f7) AT=19.6250000
.meas tran f8_23 FIND V(f8) AT=19.6250000
.meas tran f1_24 FIND V(f1) AT=20.2616667
.meas tran f2_24 FIND V(f2) AT=20.7416667
.meas tran f3_24 FIND V(f3) AT=20.4166667
.meas tran f4_24 FIND V(f4) AT=20.4166667
.meas tran f5_24 FIND V(f5) AT=20.4166667
.meas tran f6_24 FIND V(f6) AT=20.4166667
.meas tran f7_24 FIND V(f7) AT=20.4166667
.meas tran f8_24 FIND V(f8) AT=20.4166667
.meas tran f1_25 FIND V(f1) AT=21.0366667
.meas tran f2_25 FIND V(f2) AT=21.5277778
.meas tran f3_25 FIND V(f3) AT=21.1916667
.meas tran f4_25 FIND V(f4) AT=21.1916667
.meas tran f5_25 FIND V(f5) AT=21.1916667
.meas tran f6_25 FIND V(f6) AT=21.1916667
.meas tran f7_25 FIND V(f7) AT=21.1916667
.meas tran f8_25 FIND V(f8) AT=21.1916667
.meas tran f1_26 FIND V(f1) AT=21.8227778
.meas tran f2_26 FIND V(f2) AT=22.3388889
.meas tran f3_26 FIND V(f3) AT=21.9777778
.meas tran f4_26 FIND V(f4) AT=21.9777778
.meas tran f5_26 FIND V(f5) AT=21.9777778
.meas tran f6_26 FIND V(f6) AT=21.9777778
.meas tran f7_26 FIND V(f7) AT=21.9777778
.meas tran f8_26 FIND V(f8) AT=21.9777778
.meas tran f1_27 FIND V(f1) AT=22.6338889
.meas tran f2_27 FIND V(f2) AT=23.1555556
.meas tran f3_27 FIND V(f3) AT=22.7888889
.meas tran f4_27 FIND V(f4) AT=22.7888889
.meas tran f5_27 FIND V(f5) AT=22.7888889
.meas tran f6_27 FIND V(f6) AT=22.7888889
.meas tran f7_27 FIND V(f7) AT=22.7888889
.meas tran f8_27 FIND V(f8) AT=22.7888889
.meas tran f1_28 FIND V(f1) AT=23.4505556
.meas tran f2_28 FIND V(f2) AT=23.9833333
.meas tran f3_28 FIND V(f3) AT=23.6055556
.meas tran f4_28 FIND V(f4) AT=23.6055556
.meas tran f5_28 FIND V(f5) AT=23.6055556
.meas tran f6_28 FIND V(f6) AT=23.6055556
.meas tran f7_28 FIND V(f7) AT=23.6055556
.meas tran f8_28 FIND V(f8) AT=23.6055556
.meas tran f1_29 FIND V(f1) AT=24.2783333
.meas tran f2_29 FIND V(f2) AT=24.8277778
.meas tran f3_29 FIND V(f3) AT=24.4333333
.meas tran f4_29 FIND V(f4) AT=24.4333333
.meas tran f5_29 FIND V(f5) AT=24.4333333
.meas tran f6_29 FIND V(f6) AT=24.4333333
.meas tran f7_29 FIND V(f7) AT=24.4333333
.meas tran f8_29 FIND V(f8) AT=24.4333333
.meas tran f1_30 FIND V(f1) AT=25.1227778
.meas tran f2_30 FIND V(f2) AT=25.6333333
.meas tran f3_30 FIND V(f3) AT=25.2777778
.meas tran f4_30 FIND V(f4) AT=25.2777778
.meas tran f5_30 FIND V(f5) AT=25.2777778
.meas tran f6_30 FIND V(f6) AT=25.2777778
.meas tran f7_30 FIND V(f7) AT=25.2777778
.meas tran f8_30 FIND V(f8) AT=25.2777778
.meas tran f1_31 FIND V(f1) AT=25.9283333
.meas tran f2_31 FIND V(f2) AT=26.4083333
.meas tran f3_31 FIND V(f3) AT=26.0833333
.meas tran f4_31 FIND V(f4) AT=26.0833333
.meas tran f5_31 FIND V(f5) AT=26.0833333
.meas tran f6_31 FIND V(f6) AT=26.0833333
.meas tran f7_31 FIND V(f7) AT=26.0833333
.meas tran f8_31 FIND V(f8) AT=26.0833333
.meas tran f1_32 FIND V(f1) AT=26.7033333
.meas tran f2_32 FIND V(f2) AT=27.2083333
.meas tran f3_32 FIND V(f3) AT=26.8583333
.meas tran f4_32 FIND V(f4) AT=26.8583333
.meas tran f5_32 FIND V(f5) AT=26.8583333
.meas tran f6_32 FIND V(f6) AT=26.8583333
.meas tran f7_32 FIND V(f7) AT=26.8583333
.meas tran f8_32 FIND V(f8) AT=26.8583333
.meas tran f1_33 FIND V(f1) AT=27.5033333
.meas tran f2_33 FIND V(f2) AT=27.9972222
.meas tran f3_33 FIND V(f3) AT=27.6583333
.meas tran f4_33 FIND V(f4) AT=27.6583333
.meas tran f5_33 FIND V(f5) AT=27.6583333
.meas tran f6_33 FIND V(f6) AT=27.6583333
.meas tran f7_33 FIND V(f7) AT=27.6583333
.meas tran f8_33 FIND V(f8) AT=27.6583333
.meas tran f1_34 FIND V(f1) AT=28.2922222
.meas tran f3_34 FIND V(f3) AT=28.4472222
.meas tran f4_34 FIND V(f4) AT=28.4472222
.meas tran f5_34 FIND V(f5) AT=28.4472222
.meas tran f6_34 FIND V(f6) AT=28.4472222
.meas tran f7_34 FIND V(f7) AT=28.4472222
.meas tran f8_34 FIND V(f8) AT=28.4472222
.meas tran trpk_0 WHEN V(rpeak_pulse)=0.45 RISE=1 TD=0.7638889
.meas tran trpk_1 WHEN V(rpeak_pulse)=0.45 RISE=1 TD=1.5750000
.meas tran trpk_2 WHEN V(rpeak_pulse)=0.45 RISE=1 TD=2.3638889
.meas tran trpk_3 WHEN V(rpeak_pulse)=0.45 RISE=1 TD=3.1555556
.meas tran trpk_4 WHEN V(rpeak_pulse)=0.45 RISE=1 TD=3.9444444
.meas tran trpk_5 WHEN V(rpeak_pulse)=0.45 RISE=1 TD=4.7611111
.meas tran trpk_6 WHEN V(rpeak_pulse)=0.45 RISE=1 TD=5.4138889
.meas tran trpk_7 WHEN V(rpeak_pulse)=0.45 RISE=1 TD=6.4083333
.meas tran trpk_8 WHEN V(rpeak_pulse)=0.45 RISE=1 TD=7.2527778
.meas tran trpk_9 WHEN V(rpeak_pulse)=0.45 RISE=1 TD=8.0638889
.meas tran trpk_10 WHEN V(rpeak_pulse)=0.45 RISE=1 TD=8.8527778
.meas tran trpk_11 WHEN V(rpeak_pulse)=0.45 RISE=1 TD=9.6250000
.meas tran trpk_12 WHEN V(rpeak_pulse)=0.45 RISE=1 TD=10.4638889
.meas tran trpk_13 WHEN V(rpeak_pulse)=0.45 RISE=1 TD=11.3194444
.meas tran trpk_14 WHEN V(rpeak_pulse)=0.45 RISE=1 TD=12.1416667
.meas tran trpk_15 WHEN V(rpeak_pulse)=0.45 RISE=1 TD=12.9694444
.meas tran trpk_16 WHEN V(rpeak_pulse)=0.45 RISE=1 TD=13.7916667
.meas tran trpk_17 WHEN V(rpeak_pulse)=0.45 RISE=1 TD=14.5861111
.meas tran trpk_18 WHEN V(rpeak_pulse)=0.45 RISE=1 TD=15.3833333
.meas tran trpk_19 WHEN V(rpeak_pulse)=0.45 RISE=1 TD=16.1750000
.meas tran trpk_20 WHEN V(rpeak_pulse)=0.45 RISE=1 TD=16.9972222
.meas tran trpk_21 WHEN V(rpeak_pulse)=0.45 RISE=1 TD=17.8666667
.meas tran trpk_22 WHEN V(rpeak_pulse)=0.45 RISE=1 TD=18.6888889
.meas tran trpk_23 WHEN V(rpeak_pulse)=0.45 RISE=1 TD=19.4750000
.meas tran trpk_24 WHEN V(rpeak_pulse)=0.45 RISE=1 TD=20.2666667
.meas tran trpk_25 WHEN V(rpeak_pulse)=0.45 RISE=1 TD=21.0416667
.meas tran trpk_26 WHEN V(rpeak_pulse)=0.45 RISE=1 TD=21.8277778
.meas tran trpk_27 WHEN V(rpeak_pulse)=0.45 RISE=1 TD=22.6388889
.meas tran trpk_28 WHEN V(rpeak_pulse)=0.45 RISE=1 TD=23.4555556
.meas tran trpk_29 WHEN V(rpeak_pulse)=0.45 RISE=1 TD=24.2833333
.meas tran trpk_30 WHEN V(rpeak_pulse)=0.45 RISE=1 TD=25.1277778
.meas tran trpk_31 WHEN V(rpeak_pulse)=0.45 RISE=1 TD=25.9333333
.meas tran trpk_32 WHEN V(rpeak_pulse)=0.45 RISE=1 TD=26.7083333
.meas tran trpk_33 WHEN V(rpeak_pulse)=0.45 RISE=1 TD=27.5083333
.meas tran trpk_34 WHEN V(rpeak_pulse)=0.45 RISE=1 TD=28.2972222

.end
