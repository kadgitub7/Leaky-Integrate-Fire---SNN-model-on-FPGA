.title ewma_convergence_ic0.37
.lib "sky130_minimal.lib.spice" tt
.option scale=1.0u method=gear reltol=0.01 gmin=1e-15
.temp 27
Vdd vdd 0 0.9
Vss vss 0 0
Vbias vbias 0 0.300
Vrpk rpk 0 PWL(0.0000000 0.000000 0.4996000 0.000000 0.5000000 0.900000 0.5050000 0.900000 0.5054000 0.000000 1.2996000 0.000000 1.3000000 0.900000 1.3050000 0.900000 1.3054000 0.000000 2.0996000 0.000000 2.1000000 0.900000 2.1050000 0.900000 2.1054000 0.000000 2.8996000 0.000000 2.9000000 0.900000 2.9050000 0.900000 2.9054000 0.000000 3.6996000 0.000000 3.7000000 0.900000 3.7050000 0.900000 3.7054000 0.000000 4.4996000 0.000000 4.5000000 0.900000 4.5050000 0.900000 4.5054000 0.000000 5.2996000 0.000000 5.3000000 0.900000 5.3050000 0.900000 5.3054000 0.000000 6.0996000 0.000000 6.1000000 0.900000 6.1050000 0.900000 6.1054000 0.000000 6.8996000 0.000000 6.9000000 0.900000 6.9050000 0.900000 6.9054000 0.000000 7.6996000 0.000000 7.7000000 0.900000 7.7050000 0.900000 7.7054000 0.000000 8.4996000 0.000000 8.5000000 0.900000 8.5050000 0.900000 8.5054000 0.000000 9.2996000 0.000000 9.3000000 0.900000 9.3050000 0.900000 9.3054000 0.000000 10.0996000 0.000000 10.1000000 0.900000 10.1050000 0.900000 10.1054000 0.000000 10.8996000 0.000000 10.9000000 0.900000 10.9050000 0.900000 10.9054000 0.000000 11.6996000 0.000000 11.7000000 0.900000 11.7050000 0.900000 11.7054000 0.000000 12.2000000 0.000000)
Vcap cap_trig 0 PWL(0.0000000 0.000000 0.4946000 0.000000 0.4950000 0.900000 0.4970000 0.900000 0.4974000 0.000000 1.2946000 0.000000 1.2950000 0.900000 1.2970000 0.900000 1.2974000 0.000000 2.0946000 0.000000 2.0950000 0.900000 2.0970000 0.900000 2.0974000 0.000000 2.8946000 0.000000 2.8950000 0.900000 2.8970000 0.900000 2.8974000 0.000000 3.6946000 0.000000 3.6950000 0.900000 3.6970000 0.900000 3.6974000 0.000000 4.4946000 0.000000 4.4950000 0.900000 4.4970000 0.900000 4.4974000 0.000000 5.2946000 0.000000 5.2950000 0.900000 5.2970000 0.900000 5.2974000 0.000000 6.0946000 0.000000 6.0950000 0.900000 6.0970000 0.900000 6.0974000 0.000000 6.8946000 0.000000 6.8950000 0.900000 6.8970000 0.900000 6.8974000 0.000000 7.6946000 0.000000 7.6950000 0.900000 7.6970000 0.900000 7.6974000 0.000000 8.4946000 0.000000 8.4950000 0.900000 8.4970000 0.900000 8.4974000 0.000000 9.2946000 0.000000 9.2950000 0.900000 9.2970000 0.900000 9.2974000 0.000000 10.0946000 0.000000 10.0950000 0.900000 10.0970000 0.900000 10.0974000 0.000000 10.8946000 0.000000 10.8950000 0.900000 10.8970000 0.900000 10.8974000 0.000000 11.6946000 0.000000 11.6950000 0.900000 11.6970000 0.900000 11.6974000 0.000000 12.2000000 0.000000)
Vcopy copy_trig 0 PWL(0.0000000 0.000000 0.5096000 0.000000 0.5100000 0.900000 0.5120000 0.900000 0.5124000 0.000000 1.3096000 0.000000 1.3100000 0.900000 1.3120000 0.900000 1.3124000 0.000000 2.1096000 0.000000 2.1100000 0.900000 2.1120000 0.900000 2.1124000 0.000000 2.9096000 0.000000 2.9100000 0.900000 2.9120000 0.900000 2.9124000 0.000000 3.7096000 0.000000 3.7100000 0.900000 3.7120000 0.900000 3.7124000 0.000000 4.5096000 0.000000 4.5100000 0.900000 4.5120000 0.900000 4.5124000 0.000000 5.3096000 0.000000 5.3100000 0.900000 5.3120000 0.900000 5.3124000 0.000000 6.1096000 0.000000 6.1100000 0.900000 6.1120000 0.900000 6.1124000 0.000000 6.9096000 0.000000 6.9100000 0.900000 6.9120000 0.900000 6.9124000 0.000000 7.7096000 0.000000 7.7100000 0.900000 7.7120000 0.900000 7.7124000 0.000000 8.5096000 0.000000 8.5100000 0.900000 8.5120000 0.900000 8.5124000 0.000000 9.3096000 0.000000 9.3100000 0.900000 9.3120000 0.900000 9.3124000 0.000000 10.1096000 0.000000 10.1100000 0.900000 10.1120000 0.900000 10.1124000 0.000000 10.9096000 0.000000 10.9100000 0.900000 10.9120000 0.900000 10.9124000 0.000000 11.7096000 0.000000 11.7100000 0.900000 11.7120000 0.900000 11.7124000 0.000000 12.2000000 0.000000)
.include "C:/Users/kadhi/OneDrive/Desktop/amux/verilogLearning/Leaky-Integrate-Fire---SNN-model-on-FPGA/experiments/frontend_optimization/complete_frontend_v9b/inverter.spice"
.include "C:/Users/kadhi/OneDrive/Desktop/amux/verilogLearning/Leaky-Integrate-Fire---SNN-model-on-FPGA/experiments/frontend_optimization/complete_frontend_v9b/rr_timing.spice"
Xrr 0 cap_trig rpk copy_trig f1 f2 tout eout vdd vss vbias rr_timing
.ic V(xrr.ewma_node)=0.37
.tran 0.1m 12.2000
.meas tran ewma_3 FIND V(xrr.ewma_node) AT=2.8850000
.meas tran esamp_3 FIND V(xrr.esamp_node) AT=2.8960000
.meas tran ewma_7 FIND V(xrr.ewma_node) AT=6.0850000
.meas tran esamp_7 FIND V(xrr.esamp_node) AT=6.0960000
.meas tran ewma_14 FIND V(xrr.ewma_node) AT=11.6850000
.meas tran esamp_14 FIND V(xrr.esamp_node) AT=11.6960000

.end
