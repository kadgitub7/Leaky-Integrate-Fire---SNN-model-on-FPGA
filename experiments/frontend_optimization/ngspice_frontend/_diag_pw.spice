.title diagnose_pwave_drift
.lib "sky130_minimal.lib.spice" tt
.option scale=1.0u method=gear reltol=0.01 gmin=1e-15
.temp 27
Vdd vdd 0 0.9
Vss vss 0 0
Vbias vbias 0 0.300
Vrpk rpk 0 PWL(0.0000000 0.000000 0.4996000 0.000000 0.5000000 0.900000 0.5050000 0.900000 0.5054000 0.000000 1.2996000 0.000000 1.3000000 0.900000 1.3050000 0.900000 1.3054000 0.000000 2.0996000 0.000000 2.1000000 0.900000 2.1050000 0.900000 2.1054000 0.000000 2.8996000 0.000000 2.9000000 0.900000 2.9050000 0.900000 2.9054000 0.000000 3.6996000 0.000000 3.7000000 0.900000 3.7050000 0.900000 3.7054000 0.000000 4.4996000 0.000000 4.5000000 0.900000 4.5050000 0.900000 4.5054000 0.000000 5.2996000 0.000000 5.3000000 0.900000 5.3050000 0.900000 5.3054000 0.000000 6.0996000 0.000000 6.1000000 0.900000 6.1050000 0.900000 6.1054000 0.000000 6.8996000 0.000000 6.9000000 0.900000 6.9050000 0.900000 6.9054000 0.000000 7.6996000 0.000000 7.7000000 0.900000 7.7050000 0.900000 7.7054000 0.000000 8.4996000 0.000000 8.5000000 0.900000 8.5050000 0.900000 8.5054000 0.000000 9.2996000 0.000000 9.3000000 0.900000 9.3050000 0.900000 9.3054000 0.000000 10.0996000 0.000000 10.1000000 0.900000 10.1050000 0.900000 10.1054000 0.000000 10.8996000 0.000000 10.9000000 0.900000 10.9050000 0.900000 10.9054000 0.000000 11.6996000 0.000000 11.7000000 0.900000 11.7050000 0.900000 11.7054000 0.000000 12.2000000 0.000000)
Vcap capture_trig 0 PWL(0.0000000 0.000000 0.4946000 0.000000 0.4950000 0.900000 0.4970000 0.900000 0.4974000 0.000000 1.2946000 0.000000 1.2950000 0.900000 1.2970000 0.900000 1.2974000 0.000000 2.0946000 0.000000 2.0950000 0.900000 2.0970000 0.900000 2.0974000 0.000000 2.8946000 0.000000 2.8950000 0.900000 2.8970000 0.900000 2.8974000 0.000000 3.6946000 0.000000 3.6950000 0.900000 3.6970000 0.900000 3.6974000 0.000000 4.4946000 0.000000 4.4950000 0.900000 4.4970000 0.900000 4.4974000 0.000000 5.2946000 0.000000 5.2950000 0.900000 5.2970000 0.900000 5.2974000 0.000000 6.0946000 0.000000 6.0950000 0.900000 6.0970000 0.900000 6.0974000 0.000000 6.8946000 0.000000 6.8950000 0.900000 6.8970000 0.900000 6.8974000 0.000000 7.6946000 0.000000 7.6950000 0.900000 7.6970000 0.900000 7.6974000 0.000000 8.4946000 0.000000 8.4950000 0.900000 8.4970000 0.900000 8.4974000 0.000000 9.2946000 0.000000 9.2950000 0.900000 9.2970000 0.900000 9.2974000 0.000000 10.0946000 0.000000 10.0950000 0.900000 10.0970000 0.900000 10.0974000 0.000000 10.8946000 0.000000 10.8950000 0.900000 10.8970000 0.900000 10.8974000 0.000000 11.6946000 0.000000 11.6950000 0.900000 11.6970000 0.900000 11.6974000 0.000000 12.2000000 0.000000)
Vcopy copy_trig 0 PWL(0.0000000 0.000000 0.5096000 0.000000 0.5100000 0.900000 0.5120000 0.900000 0.5124000 0.000000 1.3096000 0.000000 1.3100000 0.900000 1.3120000 0.900000 1.3124000 0.000000 2.1096000 0.000000 2.1100000 0.900000 2.1120000 0.900000 2.1124000 0.000000 2.9096000 0.000000 2.9100000 0.900000 2.9120000 0.900000 2.9124000 0.000000 3.7096000 0.000000 3.7100000 0.900000 3.7120000 0.900000 3.7124000 0.000000 4.5096000 0.000000 4.5100000 0.900000 4.5120000 0.900000 4.5124000 0.000000 5.3096000 0.000000 5.3100000 0.900000 5.3120000 0.900000 5.3124000 0.000000 6.1096000 0.000000 6.1100000 0.900000 6.1120000 0.900000 6.1124000 0.000000 6.9096000 0.000000 6.9100000 0.900000 6.9120000 0.900000 6.9124000 0.000000 7.7096000 0.000000 7.7100000 0.900000 7.7120000 0.900000 7.7124000 0.000000 8.5096000 0.000000 8.5100000 0.900000 8.5120000 0.900000 8.5124000 0.000000 9.3096000 0.000000 9.3100000 0.900000 9.3120000 0.900000 9.3124000 0.000000 10.1096000 0.000000 10.1100000 0.900000 10.1120000 0.900000 10.1124000 0.000000 10.9096000 0.000000 10.9100000 0.900000 10.9120000 0.900000 10.9124000 0.000000 11.7096000 0.000000 11.7100000 0.900000 11.7120000 0.900000 11.7124000 0.000000 12.2000000 0.000000)

.include "C:/Users/kadhi/OneDrive/Desktop/amux/verilogLearning/Leaky-Integrate-Fire---SNN-model-on-FPGA/experiments/frontend_optimization/complete_frontend_v9b/inverter.spice"
.include "C:/Users/kadhi/OneDrive/Desktop/amux/verilogLearning/Leaky-Integrate-Fire---SNN-model-on-FPGA/experiments/frontend_optimization/complete_frontend_v9b/rr_timing.spice"

Xrr 0 capture_trig rpk copy_trig f1 f2 timer_out ewma_out vdd vss vbias rr_timing
.ic V(xrr.ewma_node)=0.35

.tran 0.1m 12.2000

.meas tran ewma_pre_2 FIND V(xrr.ewma_node) AT=2.0850000
.meas tran sf_pre_2 FIND V(xrr.sf_out) AT=2.0850000
.meas tran timer_pre_2 FIND V(xrr.net_timer) AT=2.0850000
.meas tran sf_cap_2 FIND V(xrr.sf_out) AT=2.0960000
.meas tran esamp_cap_2 FIND V(xrr.esamp_node) AT=2.0960000
.meas tran ewma_post_2 FIND V(xrr.ewma_node) AT=2.1150000
.meas tran tmr_pwb_2 FIND V(timer_out) AT=2.6940000
.meas tran tmr_pwp_2 FIND V(timer_out) AT=2.7690000
.meas tran tmr_rrc_2 FIND V(timer_out) AT=2.8950000
.meas tran ewma_pre_3 FIND V(xrr.ewma_node) AT=2.8850000
.meas tran sf_pre_3 FIND V(xrr.sf_out) AT=2.8850000
.meas tran timer_pre_3 FIND V(xrr.net_timer) AT=2.8850000
.meas tran sf_cap_3 FIND V(xrr.sf_out) AT=2.8960000
.meas tran esamp_cap_3 FIND V(xrr.esamp_node) AT=2.8960000
.meas tran ewma_post_3 FIND V(xrr.ewma_node) AT=2.9150000
.meas tran tmr_pwb_3 FIND V(timer_out) AT=3.4940000
.meas tran tmr_pwp_3 FIND V(timer_out) AT=3.5690000
.meas tran tmr_rrc_3 FIND V(timer_out) AT=3.6950000
.meas tran ewma_pre_4 FIND V(xrr.ewma_node) AT=3.6850000
.meas tran sf_pre_4 FIND V(xrr.sf_out) AT=3.6850000
.meas tran timer_pre_4 FIND V(xrr.net_timer) AT=3.6850000
.meas tran sf_cap_4 FIND V(xrr.sf_out) AT=3.6960000
.meas tran esamp_cap_4 FIND V(xrr.esamp_node) AT=3.6960000
.meas tran ewma_post_4 FIND V(xrr.ewma_node) AT=3.7150000
.meas tran tmr_pwb_4 FIND V(timer_out) AT=4.2940000
.meas tran tmr_pwp_4 FIND V(timer_out) AT=4.3690000
.meas tran tmr_rrc_4 FIND V(timer_out) AT=4.4950000
.meas tran ewma_pre_5 FIND V(xrr.ewma_node) AT=4.4850000
.meas tran sf_pre_5 FIND V(xrr.sf_out) AT=4.4850000
.meas tran timer_pre_5 FIND V(xrr.net_timer) AT=4.4850000
.meas tran sf_cap_5 FIND V(xrr.sf_out) AT=4.4960000
.meas tran esamp_cap_5 FIND V(xrr.esamp_node) AT=4.4960000
.meas tran ewma_post_5 FIND V(xrr.ewma_node) AT=4.5150000
.meas tran tmr_pwb_5 FIND V(timer_out) AT=5.0940000
.meas tran tmr_pwp_5 FIND V(timer_out) AT=5.1690000
.meas tran tmr_rrc_5 FIND V(timer_out) AT=5.2950000
.meas tran ewma_pre_6 FIND V(xrr.ewma_node) AT=5.2850000
.meas tran sf_pre_6 FIND V(xrr.sf_out) AT=5.2850000
.meas tran timer_pre_6 FIND V(xrr.net_timer) AT=5.2850000
.meas tran sf_cap_6 FIND V(xrr.sf_out) AT=5.2960000
.meas tran esamp_cap_6 FIND V(xrr.esamp_node) AT=5.2960000
.meas tran ewma_post_6 FIND V(xrr.ewma_node) AT=5.3150000
.meas tran tmr_pwb_6 FIND V(timer_out) AT=5.8940000
.meas tran tmr_pwp_6 FIND V(timer_out) AT=5.9690000
.meas tran tmr_rrc_6 FIND V(timer_out) AT=6.0950000
.meas tran ewma_pre_7 FIND V(xrr.ewma_node) AT=6.0850000
.meas tran sf_pre_7 FIND V(xrr.sf_out) AT=6.0850000
.meas tran timer_pre_7 FIND V(xrr.net_timer) AT=6.0850000
.meas tran sf_cap_7 FIND V(xrr.sf_out) AT=6.0960000
.meas tran esamp_cap_7 FIND V(xrr.esamp_node) AT=6.0960000
.meas tran ewma_post_7 FIND V(xrr.ewma_node) AT=6.1150000
.meas tran tmr_pwb_7 FIND V(timer_out) AT=6.6940000
.meas tran tmr_pwp_7 FIND V(timer_out) AT=6.7690000
.meas tran tmr_rrc_7 FIND V(timer_out) AT=6.8950000
.meas tran ewma_pre_8 FIND V(xrr.ewma_node) AT=6.8850000
.meas tran sf_pre_8 FIND V(xrr.sf_out) AT=6.8850000
.meas tran timer_pre_8 FIND V(xrr.net_timer) AT=6.8850000
.meas tran sf_cap_8 FIND V(xrr.sf_out) AT=6.8960000
.meas tran esamp_cap_8 FIND V(xrr.esamp_node) AT=6.8960000
.meas tran ewma_post_8 FIND V(xrr.ewma_node) AT=6.9150000
.meas tran tmr_pwb_8 FIND V(timer_out) AT=7.4940000
.meas tran tmr_pwp_8 FIND V(timer_out) AT=7.5690000
.meas tran tmr_rrc_8 FIND V(timer_out) AT=7.6950000
.meas tran ewma_pre_9 FIND V(xrr.ewma_node) AT=7.6850000
.meas tran sf_pre_9 FIND V(xrr.sf_out) AT=7.6850000
.meas tran timer_pre_9 FIND V(xrr.net_timer) AT=7.6850000
.meas tran sf_cap_9 FIND V(xrr.sf_out) AT=7.6960000
.meas tran esamp_cap_9 FIND V(xrr.esamp_node) AT=7.6960000
.meas tran ewma_post_9 FIND V(xrr.ewma_node) AT=7.7150000
.meas tran tmr_pwb_9 FIND V(timer_out) AT=8.2940000
.meas tran tmr_pwp_9 FIND V(timer_out) AT=8.3690000
.meas tran tmr_rrc_9 FIND V(timer_out) AT=8.4950000
.meas tran ewma_pre_10 FIND V(xrr.ewma_node) AT=8.4850000
.meas tran sf_pre_10 FIND V(xrr.sf_out) AT=8.4850000
.meas tran timer_pre_10 FIND V(xrr.net_timer) AT=8.4850000
.meas tran sf_cap_10 FIND V(xrr.sf_out) AT=8.4960000
.meas tran esamp_cap_10 FIND V(xrr.esamp_node) AT=8.4960000
.meas tran ewma_post_10 FIND V(xrr.ewma_node) AT=8.5150000
.meas tran tmr_pwb_10 FIND V(timer_out) AT=9.0940000
.meas tran tmr_pwp_10 FIND V(timer_out) AT=9.1690000
.meas tran tmr_rrc_10 FIND V(timer_out) AT=9.2950000
.meas tran ewma_pre_11 FIND V(xrr.ewma_node) AT=9.2850000
.meas tran sf_pre_11 FIND V(xrr.sf_out) AT=9.2850000
.meas tran timer_pre_11 FIND V(xrr.net_timer) AT=9.2850000
.meas tran sf_cap_11 FIND V(xrr.sf_out) AT=9.2960000
.meas tran esamp_cap_11 FIND V(xrr.esamp_node) AT=9.2960000
.meas tran ewma_post_11 FIND V(xrr.ewma_node) AT=9.3150000
.meas tran tmr_pwb_11 FIND V(timer_out) AT=9.8940000
.meas tran tmr_pwp_11 FIND V(timer_out) AT=9.9690000
.meas tran tmr_rrc_11 FIND V(timer_out) AT=10.0950000
.meas tran ewma_pre_12 FIND V(xrr.ewma_node) AT=10.0850000
.meas tran sf_pre_12 FIND V(xrr.sf_out) AT=10.0850000
.meas tran timer_pre_12 FIND V(xrr.net_timer) AT=10.0850000
.meas tran sf_cap_12 FIND V(xrr.sf_out) AT=10.0960000
.meas tran esamp_cap_12 FIND V(xrr.esamp_node) AT=10.0960000
.meas tran ewma_post_12 FIND V(xrr.ewma_node) AT=10.1150000
.meas tran tmr_pwb_12 FIND V(timer_out) AT=10.6940000
.meas tran tmr_pwp_12 FIND V(timer_out) AT=10.7690000
.meas tran tmr_rrc_12 FIND V(timer_out) AT=10.8950000
.meas tran ewma_pre_13 FIND V(xrr.ewma_node) AT=10.8850000
.meas tran sf_pre_13 FIND V(xrr.sf_out) AT=10.8850000
.meas tran timer_pre_13 FIND V(xrr.net_timer) AT=10.8850000
.meas tran sf_cap_13 FIND V(xrr.sf_out) AT=10.8960000
.meas tran esamp_cap_13 FIND V(xrr.esamp_node) AT=10.8960000
.meas tran ewma_post_13 FIND V(xrr.ewma_node) AT=10.9150000
.meas tran tmr_pwb_13 FIND V(timer_out) AT=11.4940000
.meas tran tmr_pwp_13 FIND V(timer_out) AT=11.5690000
.meas tran tmr_rrc_13 FIND V(timer_out) AT=11.6950000
.meas tran ewma_pre_14 FIND V(xrr.ewma_node) AT=11.6850000
.meas tran sf_pre_14 FIND V(xrr.sf_out) AT=11.6850000
.meas tran timer_pre_14 FIND V(xrr.net_timer) AT=11.6850000
.meas tran sf_cap_14 FIND V(xrr.sf_out) AT=11.6960000
.meas tran esamp_cap_14 FIND V(xrr.esamp_node) AT=11.6960000
.meas tran ewma_post_14 FIND V(xrr.ewma_node) AT=11.7150000

.end
