* QRS Width Debug Testbench

.title qrs_width_debug

.lib "sky130_minimal.lib.spice" tt
.option scale=1.0u
.option method=gear
.option gmin=1e-15
.option abstol=1e-15
.option reltol=0.005
.temp 27

.include "ota_5t_subthreshold.spice"
.include "inverter.spice"

* --- Power supply ---
Vdd vdd 0 0.9
Vss vss 0 0
Vbias vbias 0 0.35
Vpeak peak_voltage 0 0.45

* --- ECG: triangular QRS at t=0.5s, amplitude 0.5V above 0.15V baseline ---
Vecg ecg_in 0 PWL(0 0.15 0.459 0.15 0.480 0.35 0.500 0.65 0.520 0.15 0.540 0.15 1.0 0.15)

* --- QRS gate: HIGH from 0.46s to 0.54s ---
Vqrs qrs_gate 0 PWL(0 0 0.459 0 0.460 0.9 0.540 0.9 0.541 0 1.0 0)

* --- R-peak trigger: 1ms pulse at 0.5s ---
Vrpeak rpeak_trigger 0 PWL(0 0 0.499 0 0.500 0.9 0.501 0.9 0.502 0 1.0 0)

* ========== INLINED QRS_WIDTH (so we can probe internals) ==========

* --- 30% threshold generator ---
XMthr_top peak_voltage peak_voltage thresh_30 vdd sky130_fd_pr__pfet_01v8_hvt L=4 W=3 nf=1
XMthr_bot thresh_30 thresh_30 vss vss sky130_fd_pr__nfet_01v8 L=4 W=1.3 nf=1

* --- Comparator: ecg > threshold? ---
Xota_wcmp ecg_in thresh_30 width_cmp_out vdd vss vbias ota_5t

* AND with qrs_gate
Xinv_qgate qrs_gate qrs_gate_bar vdd vss inverter_sub
XMand_n width_cmp_out qrs_gate width_gate_gated vss sky130_fd_pr__nfet_01v8 L=0.5 W=1 nf=1
XMand_p width_cmp_out qrs_gate_bar width_gate_gated vdd sky130_fd_pr__pfet_01v8 L=0.5 W=2 nf=1
XMand_pull width_gate_gated qrs_gate_bar vss vss sky130_fd_pr__nfet_01v8 L=0.5 W=2 nf=1

* --- Width timer ---
XMw_bias net_w_bias vbias net_w_sw vss sky130_fd_pr__nfet_01v8 L=8 W=1 nf=1
XMw_gate net_w_sw width_gate_gated vss vss sky130_fd_pr__nfet_01v8 L=0.5 W=2 nf=1
XMw_charge width_out net_w_bias vdd vdd sky130_fd_pr__pfet_01v8_hvt L=8 W=1 nf=1
XMw_disable net_w_bias qrs_gate vdd vdd sky130_fd_pr__pfet_01v8 L=0.5 W=2 nf=1
XCwidth width_out vss sky130_fd_pr__cap_mim_m3_1 W=35 L=35
XMw_reset width_out rpeak_trigger vss vss sky130_fd_pr__nfet_01v8 L=0.5 W=2 nf=1

* ====================================================================

.tran 0.1m 0.7

* Measure thresh_30 at steady state (before QRS)
.meas tran thresh_30_val FIND V(thresh_30) AT=0.40
.meas tran ecg_at_base FIND V(ecg_in) AT=0.40

* Measure during QRS rise
.meas tran thresh_at_rise FIND V(thresh_30) AT=0.47
.meas tran ecg_at_rise FIND V(ecg_in) AT=0.47
.meas tran cmp_at_rise FIND V(width_cmp_out) AT=0.47
.meas tran gate_gated_rise FIND V(width_gate_gated) AT=0.47
.meas tran bias_at_rise FIND V(net_w_bias) AT=0.47
.meas tran width_at_rise FIND V(width_out) AT=0.47

* At peak
.meas tran ecg_at_peak FIND V(ecg_in) AT=0.50
.meas tran cmp_at_peak FIND V(width_cmp_out) AT=0.50
.meas tran gate_gated_peak FIND V(width_gate_gated) AT=0.50
.meas tran bias_at_peak FIND V(net_w_bias) AT=0.50
.meas tran width_at_peak FIND V(width_out) AT=0.50

* Before rpeak (5ms before)
.meas tran width_pre_rpeak FIND V(width_out) AT=0.495

* Just after rpeak (should be reset)
.meas tran width_post_rpeak FIND V(width_out) AT=0.503

* During QRS tail (after rpeak, still in gate window)
.meas tran ecg_at_tail FIND V(ecg_in) AT=0.52
.meas tran cmp_at_tail FIND V(width_cmp_out) AT=0.52
.meas tran gate_gated_tail FIND V(width_gate_gated) AT=0.52
.meas tran width_at_tail FIND V(width_out) AT=0.52

* After QRS gate closes
.meas tran width_final FIND V(width_out) AT=0.55
.meas tran bias_final FIND V(net_w_bias) AT=0.55

.end
