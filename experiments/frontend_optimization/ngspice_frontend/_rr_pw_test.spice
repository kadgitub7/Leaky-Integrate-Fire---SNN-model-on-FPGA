.title rr_pwave_trigger_test
.lib "sky130_minimal.lib.spice" tt
.option scale=1.0u method=gear reltol=0.01 gmin=1e-15
.temp 27

Vdd vdd 0 0.9
Vss vss 0 0
Vbias vbias 0 0.300

Vecg ecg_l0 0 PWL(0.0000000 0.300000 0.5608889 0.300000 0.5638889 0.249167 0.5666667 0.248333 0.5694444 0.250000 0.5722222 0.249167 0.5750000 0.251667 0.5777778 0.250000 0.5805556 0.250000 0.5833333 0.249167 0.5861111 0.249167 0.5888889 0.251667 0.5916667 0.253333 0.5944444 0.250833 0.5972222 0.249167 0.6000000 0.247500 0.6027778 0.249167 0.6055556 0.250833 0.6083333 0.251667 0.6111111 0.253333 0.6138889 0.255000 0.6166667 0.254167 0.6194444 0.254167 0.6222222 0.255000 0.6250000 0.258333 0.6277778 0.258333 0.6305556 0.257500 0.6333333 0.262500 0.6361111 0.263333 0.6388889 0.265833 0.6416667 0.266667 0.6444444 0.265833 0.6472222 0.264167 0.6500000 0.261667 0.6527778 0.263333 0.6555556 0.262500 0.6583333 0.262500 0.6611111 0.262500 0.6638889 0.261667 0.6666667 0.260833 0.6694444 0.260000 0.6722222 0.260833 0.6750000 0.263333 0.6777778 0.265000 0.6805556 0.265833 0.6833333 0.259167 0.6861111 0.252500 0.6888889 0.252500 0.6916667 0.250000 0.6944444 0.248333 0.6972222 0.245000 0.7000000 0.245000 0.7027778 0.245833 0.7055556 0.247500 0.7083333 0.246667 0.7111111 0.247500 0.7138889 0.245833 0.7166667 0.243333 0.7194444 0.242500 0.7222222 0.243333 0.7250000 0.243333 0.7277778 0.241667 0.7305556 0.242500 0.7333333 0.240833 0.7361111 0.245000 0.7388889 0.244167 0.7416667 0.245000 0.7444444 0.246667 0.7472222 0.242500 0.7500000 0.240833 0.7527778 0.243333 0.7555556 0.245000 0.7583333 0.245833 0.7611111 0.245000 0.7638889 0.241667 0.7666667 0.239167 0.7694444 0.240000 0.7722222 0.236667 0.7750000 0.229167 0.7777778 0.225833 0.7805556 0.220833 0.7833333 0.215000 0.7861111 0.210833 0.7888889 0.215833 0.7916667 0.230833 0.7944444 0.250000 0.7972222 0.273333 0.8000000 0.297500 0.8027778 0.339167 0.8055556 0.381667 0.8083333 0.420000 0.8111111 0.445833 0.8138889 0.456667 0.8166667 0.450833 0.8194444 0.425833 0.8222222 0.381667 0.8250000 0.327500 0.8277778 0.281667 0.8305556 0.255000 0.8333333 0.235000 0.8361111 0.225000 0.8388889 0.220833 0.8416667 0.224167 0.8444444 0.229167 0.8472222 0.235000 0.8500000 0.235000 0.8527778 0.235833 0.8555556 0.235000 0.8583333 0.236667 0.8611111 0.236667 0.8638889 0.236667 0.8666667 0.234167 0.8694444 0.235833 0.8722222 0.235833 0.8750000 0.235833 0.8777778 0.237500 0.8805556 0.234167 0.8833333 0.231667 0.8861111 0.231667 0.8888889 0.233333 0.8916667 0.234167 0.8944444 0.235000 0.8972222 0.232500 0.9000000 0.234167 0.9027778 0.235833 0.9055556 0.237500 0.9083333 0.235000 0.9111111 0.235000 0.9138889 0.232500 0.9166667 0.231667 0.9194444 0.231667 0.9222222 0.235000 0.9250000 0.235000 0.9277778 0.234167 0.9305556 0.232500 0.9333333 0.230833 0.9361111 0.233333 0.9388889 0.231667 0.9416667 0.232500 0.9444444 0.231667 0.9472222 0.230833 0.9500000 0.231667 0.9527778 0.233333 0.9555556 0.233333 0.9583333 0.234167 0.9611111 0.235000 0.9638889 0.232500 0.9666667 0.231667 0.9694444 0.235000 0.9722222 0.235000 0.9750000 0.235833 0.9777778 0.235833 0.9805556 0.231667 0.9833333 0.232500 0.9861111 0.234167 0.9888889 0.235000 0.9916667 0.237500 0.9944444 0.235000 0.9972222 0.234167 1.0000000 0.231667 1.0027778 0.233333 1.0055556 0.235000 1.0083333 0.235000 1.0111111 0.235833 1.0138889 0.232500 1.0166667 0.230833 1.0194444 0.230833 1.0222222 0.233333 1.0250000 0.234167 1.0277778 0.232500 1.0305556 0.230833 1.0333333 0.230000 1.0361111 0.230000 1.0388889 0.231667 1.0416667 0.230833 1.0444444 0.229167 1.0472222 0.230000 1.0500000 0.227500 1.0527778 0.228333 1.0555556 0.228333 1.0583333 0.230000 1.0611111 0.228333 1.0638889 0.225000 1.0666667 0.224167 1.0694444 0.225000 1.0722222 0.227500 1.0750000 0.225833 1.0777778 0.225000 1.0805556 0.224167 1.0833333 0.221667 1.0861111 0.223333 1.0888889 0.224167 1.0916667 0.225000 1.0944444 0.224167 1.0972222 0.221667 1.1000000 0.220833 1.1027778 0.223333 1.1055556 0.225000 1.1083333 0.225833 1.1111111 0.226667 1.1168889 0.300000 1.3720000 0.300000 1.3750000 0.245000 1.3777778 0.242500 1.3805556 0.242500 1.3833333 0.240833 1.3861111 0.241667 1.3888889 0.243333 1.3916667 0.245000 1.3944444 0.243333 1.3972222 0.243333 1.4000000 0.243333 1.4027778 0.245000 1.4055556 0.244167 1.4083333 0.245000 1.4111111 0.244167 1.4138889 0.242500 1.4166667 0.242500 1.4194444 0.243333 1.4222222 0.245000 1.4250000 0.247500 1.4277778 0.250833 1.4305556 0.250000 1.4333333 0.250833 1.4361111 0.252500 1.4388889 0.254167 1.4416667 0.255833 1.4444444 0.255833 1.4472222 0.255833 1.4500000 0.257500 1.4527778 0.258333 1.4555556 0.260000 1.4583333 0.262500 1.4611111 0.264167 1.4638889 0.260000 1.4666667 0.259167 1.4694444 0.260000 1.4722222 0.259167 1.4750000 0.260833 1.4777778 0.259167 1.4805556 0.258333 1.4833333 0.254167 1.4861111 0.254167 1.4888889 0.255833 1.4916667 0.258333 1.4944444 0.262500 1.4972222 0.263333 1.5000000 0.261667 1.5027778 0.255833 1.5055556 0.255000 1.5083333 0.253333 1.5111111 0.252500 1.5138889 0.249167 1.5166667 0.246667 1.5194444 0.243333 1.5222222 0.245000 1.5250000 0.244167 1.5277778 0.244167 1.5305556 0.240833 1.5333333 0.238333 1.5361111 0.240000 1.5388889 0.242500 1.5416667 0.241667 1.5444444 0.240833 1.5472222 0.239167 1.5500000 0.237500 1.5527778 0.236667 1.5555556 0.238333 1.5583333 0.239167 1.5611111 0.239167 1.5638889 0.236667 1.5666667 0.235833 1.5694444 0.236667 1.5722222 0.237500 1.5750000 0.240833 1.5777778 0.238333 1.5805556 0.235000 1.5833333 0.232500 1.5861111 0.231667 1.5888889 0.227500 1.5916667 0.222500 1.5944444 0.218333 1.5972222 0.213333 1.6000000 0.207500 1.6027778 0.205000 1.6055556 0.212500 1.6083333 0.232500 1.6111111 0.258333 1.6138889 0.285000 1.6166667 0.320000 1.6194444 0.368333 1.6222222 0.415000 1.6250000 0.447500 1.6277778 0.460000 1.6305556 0.441667 1.6333333 0.386667 1.6361111 0.308333 1.6388889 0.246667 1.6416667 0.216667 1.6444444 0.215833 1.6472222 0.225833 1.6500000 0.230833 1.6527778 0.234167 1.6555556 0.235000 1.6583333 0.234167 1.6611111 0.235000 1.6638889 0.234167 1.6666667 0.232500 1.6694444 0.234167 1.6722222 0.232500 1.6750000 0.235000 1.6777778 0.234167 1.6805556 0.234167 1.6833333 0.231667 1.6861111 0.232500 1.6888889 0.233333 1.6916667 0.233333 1.6944444 0.230833 1.6972222 0.232500 1.7000000 0.230000 1.7027778 0.230833 1.7055556 0.232500 1.7083333 0.232500 1.7111111 0.230000 1.7138889 0.230000 1.7166667 0.227500 1.7194444 0.230000 1.7222222 0.231667 1.7250000 0.231667 1.7277778 0.232500 1.7305556 0.229167 1.7333333 0.228333 1.7361111 0.230000 1.7388889 0.230833 1.7416667 0.231667 1.7444444 0.231667 1.7472222 0.229167 1.7500000 0.230000 1.7527778 0.233333 1.7555556 0.234167 1.7583333 0.233333 1.7611111 0.233333 1.7638889 0.234167 1.7666667 0.230833 1.7694444 0.232500 1.7722222 0.235000 1.7750000 0.233333 1.7777778 0.233333 1.7805556 0.230833 1.7833333 0.229167 1.7861111 0.229167 1.7888889 0.230833 1.7916667 0.230833 1.7944444 0.231667 1.7972222 0.229167 1.8000000 0.229167 1.8027778 0.230000 1.8055556 0.230833 1.8083333 0.233333 1.8111111 0.233333 1.8138889 0.231667 1.8166667 0.229167 1.8194444 0.231667 1.8222222 0.232500 1.8250000 0.234167 1.8277778 0.233333 1.8305556 0.233333 1.8333333 0.232500 1.8361111 0.235833 1.8388889 0.233333 1.8416667 0.235000 1.8444444 0.235000 1.8472222 0.233333 1.8500000 0.230833 1.8527778 0.232500 1.8555556 0.232500 1.8583333 0.231667 1.8611111 0.230833 1.8638889 0.230000 1.8666667 0.230000 1.8694444 0.229167 1.8722222 0.230833 1.8750000 0.230833 1.8777778 0.231667 1.8805556 0.227500 1.8833333 0.228333 1.8861111 0.227500 1.8888889 0.230000 1.8916667 0.230000 1.8944444 0.230000 1.8972222 0.230000 1.9000000 0.229167 1.9027778 0.229167 1.9055556 0.230833 1.9083333 0.234167 1.9111111 0.234167 1.9138889 0.235000 1.9166667 0.237500 1.9194444 0.240000 1.9222222 0.243333 1.9280000 0.300000 2.1608889 0.300000 2.1638889 0.237500 2.1666667 0.235833 2.1694444 0.240833 2.1722222 0.240000 2.1750000 0.240833 2.1777778 0.240000 2.1805556 0.240000 2.1833333 0.238333 2.1861111 0.240000 2.1888889 0.242500 2.1916667 0.240833 2.1944444 0.242500 2.1972222 0.242500 2.2000000 0.242500 2.2027778 0.243333 2.2055556 0.248333 2.2083333 0.249167 2.2111111 0.249167 2.2138889 0.248333 2.2166667 0.249167 2.2194444 0.251667 2.2222222 0.252500 2.2250000 0.254167 2.2277778 0.253333 2.2305556 0.253333 2.2333333 0.254167 2.2361111 0.255833 2.2388889 0.257500 2.2416667 0.259167 2.2444444 0.256667 2.2472222 0.255833 2.2500000 0.254167 2.2527778 0.253333 2.2555556 0.255833 2.2583333 0.255000 2.2611111 0.254167 2.2638889 0.253333 2.2666667 0.254167 2.2694444 0.253333 2.2722222 0.254167 2.2750000 0.255833 2.2777778 0.257500 2.2805556 0.260000 2.2833333 0.256667 2.2861111 0.253333 2.2888889 0.248333 2.2916667 0.248333 2.2944444 0.242500 2.2972222 0.240000 2.3000000 0.236667 2.3027778 0.235833 2.3055556 0.236667 2.3083333 0.238333 2.3111111 0.237500 2.3138889 0.235833 2.3166667 0.235000 2.3194444 0.234167 2.3222222 0.235833 2.3250000 0.235833 2.3277778 0.235833 2.3305556 0.234167 2.3333333 0.232500 2.3361111 0.233333 2.3388889 0.237500 2.3416667 0.237500 2.3444444 0.235000 2.3472222 0.234167 2.3500000 0.230833 2.3527778 0.232500 2.3555556 0.233333 2.3583333 0.235000 2.3611111 0.232500 2.3638889 0.229167 2.3666667 0.223333 2.3694444 0.220833 2.3722222 0.215833 2.3750000 0.215000 2.3777778 0.212500 2.3805556 0.210000 2.3833333 0.200000 2.3861111 0.192500 2.3888889 0.195000 2.3916667 0.204167 2.3944444 0.217500 2.3972222 0.235833 2.4000000 0.255000 2.4027778 0.280833 2.4055556 0.315000 2.4083333 0.361667 2.4111111 0.405833 2.4138889 0.435000 2.4166667 0.443333 2.4194444 0.428333 2.4222222 0.379167 2.4250000 0.310833 2.4277778 0.249167 2.4305556 0.216667 2.4333333 0.213333 2.4361111 0.220833 2.4388889 0.231667 2.4416667 0.235000 2.4444444 0.235000 2.4472222 0.233333 2.4500000 0.231667 2.4527778 0.232500 2.4555556 0.235833 2.4583333 0.235000 2.4611111 0.234167 2.4638889 0.232500 2.4666667 0.231667 2.4694444 0.232500 2.4722222 0.233333 2.4750000 0.235000 2.4777778 0.234167 2.4805556 0.231667 2.4833333 0.230833 2.4861111 0.231667 2.4888889 0.234167 2.4916667 0.232500 2.4944444 0.231667 2.4972222 0.232500 2.5000000 0.232500 2.5027778 0.231667 2.5055556 0.235000 2.5083333 0.235833 2.5111111 0.235000 2.5138889 0.234167 2.5166667 0.233333 2.5194444 0.233333 2.5222222 0.233333 2.5250000 0.234167 2.5277778 0.234167 2.5305556 0.232500 2.5333333 0.232500 2.5361111 0.233333 2.5388889 0.234167 2.5416667 0.235833 2.5444444 0.237500 2.5472222 0.235833 2.5500000 0.234167 2.5527778 0.235000 2.5555556 0.235833 2.5583333 0.237500 2.5611111 0.235833 2.5638889 0.234167 2.5666667 0.234167 2.5694444 0.235833 2.5722222 0.237500 2.5750000 0.237500 2.5777778 0.235833 2.5805556 0.234167 2.5833333 0.235000 2.5861111 0.235000 2.5888889 0.239167 2.5916667 0.237500 2.5944444 0.235833 2.5972222 0.234167 2.6000000 0.236667 2.6027778 0.235833 2.6055556 0.237500 2.6083333 0.236667 2.6111111 0.235000 2.6138889 0.236667 2.6166667 0.237500 2.6194444 0.237500 2.6222222 0.237500 2.6250000 0.237500 2.6277778 0.236667 2.6305556 0.235000 2.6333333 0.235000 2.6361111 0.239167 2.6388889 0.238333 2.6416667 0.237500 2.6444444 0.235833 2.6472222 0.235000 2.6500000 0.235000 2.6527778 0.237500 2.6555556 0.239167 2.6583333 0.235833 2.6611111 0.236667 2.6638889 0.235000 2.6666667 0.237500 2.6694444 0.237500 2.6722222 0.239167 2.6750000 0.238333 2.6777778 0.235833 2.6805556 0.234167 2.6833333 0.235833 2.6861111 0.235833 2.6888889 0.238333 2.6916667 0.239167 2.6944444 0.238333 2.6972222 0.237500 2.7000000 0.241667 2.7027778 0.244167 2.7055556 0.246667 2.7083333 0.247500 2.7111111 0.246667 2.7168889 0.300000 2.9525556 0.300000 2.9555556 0.242500 2.9583333 0.242500 2.9611111 0.241667 2.9638889 0.240833 2.9666667 0.242500 2.9694444 0.245000 2.9722222 0.245000 2.9750000 0.244167 2.9777778 0.244167 2.9805556 0.243333 2.9833333 0.245000 2.9861111 0.246667 2.9888889 0.251667 2.9916667 0.251667 2.9944444 0.250000 2.9972222 0.249167 3.0000000 0.252500 3.0027778 0.253333 3.0055556 0.254167 3.0083333 0.253333 3.0111111 0.254167 3.0138889 0.255000 3.0166667 0.255833 3.0194444 0.258333 3.0222222 0.261667 3.0250000 0.259167 3.0277778 0.260000 3.0305556 0.257500 3.0333333 0.257500 3.0361111 0.259167 3.0388889 0.260833 3.0416667 0.257500 3.0444444 0.255833 3.0472222 0.256667 3.0500000 0.257500 3.0527778 0.255000 3.0555556 0.255833 3.0583333 0.253333 3.0611111 0.257500 3.0638889 0.258333 3.0666667 0.259167 3.0694444 0.255833 3.0722222 0.253333 3.0750000 0.250000 3.0777778 0.247500 3.0805556 0.245833 3.0833333 0.244167 3.0861111 0.242500 3.0888889 0.245000 3.0916667 0.244167 3.0944444 0.242500 3.0972222 0.240000 3.1000000 0.241667 3.1027778 0.243333 3.1055556 0.244167 3.1083333 0.242500 3.1111111 0.240000 3.1138889 0.239167 3.1166667 0.237500 3.1194444 0.238333 3.1222222 0.239167 3.1250000 0.239167 3.1277778 0.236667 3.1305556 0.237500 3.1333333 0.237500 3.1361111 0.239167 3.1388889 0.238333 3.1416667 0.240000 3.1444444 0.238333 3.1472222 0.236667 3.1500000 0.239167 3.1527778 0.240000 3.1555556 0.241667 3.1583333 0.240833 3.1611111 0.238333 3.1638889 0.235833 3.1666667 0.234167 3.1694444 0.228333 3.1722222 0.225833 3.1750000 0.219167 3.1777778 0.214167 3.1805556 0.205833 3.1833333 0.207500 3.1861111 0.220833 3.1888889 0.240833 3.1916667 0.263333 3.1944444 0.290833 3.1972222 0.330833 3.2000000 0.379167 3.2027778 0.417500 3.2055556 0.436667 3.2083333 0.430000 3.2111111 0.389167 3.2138889 0.324167 3.2166667 0.266667 3.2194444 0.230000 3.2222222 0.216667 3.2250000 0.220000 3.2277778 0.225000 3.2305556 0.231667 3.2333333 0.233333 3.2361111 0.235000 3.2388889 0.235000 3.2416667 0.233333 3.2444444 0.232500 3.2472222 0.229167 3.2500000 0.229167 3.2527778 0.232500 3.2555556 0.234167 3.2583333 0.232500 3.2611111 0.232500 3.2638889 0.230833 3.2666667 0.232500 3.2694444 0.235833 3.2722222 0.235000 3.2750000 0.234167 3.2777778 0.234167 3.2805556 0.234167 3.2833333 0.234167 3.2861111 0.235833 3.2888889 0.235000 3.2916667 0.235000 3.2944444 0.233333 3.2972222 0.229167 3.3000000 0.231667 3.3027778 0.233333 3.3055556 0.234167 3.3083333 0.233333 3.3111111 0.232500 3.3138889 0.229167 3.3166667 0.230833 3.3194444 0.232500 3.3222222 0.232500 3.3250000 0.232500 3.3277778 0.231667 3.3305556 0.230833 3.3333333 0.232500 3.3361111 0.230000 3.3388889 0.232500 3.3416667 0.231667 3.3444444 0.231667 3.3472222 0.230000 3.3500000 0.230833 3.3527778 0.232500 3.3555556 0.234167 3.3583333 0.234167 3.3611111 0.234167 3.3638889 0.233333 3.3666667 0.234167 3.3694444 0.234167 3.3722222 0.232500 3.3750000 0.232500 3.3777778 0.230000 3.3805556 0.227500 3.3833333 0.230833 3.3861111 0.232500 3.3888889 0.234167 3.3916667 0.235000 3.3944444 0.230833 3.3972222 0.232500 3.4000000 0.232500 3.4027778 0.233333 3.4055556 0.234167 3.4083333 0.234167 3.4111111 0.232500 3.4138889 0.230000 3.4166667 0.230833 3.4194444 0.233333 3.4222222 0.234167 3.4250000 0.233333 3.4277778 0.232500 3.4305556 0.229167 3.4333333 0.229167 3.4361111 0.229167 3.4388889 0.230000 3.4416667 0.229167 3.4444444 0.225000 3.4472222 0.225833 3.4500000 0.225000 3.4527778 0.227500 3.4555556 0.225833 3.4583333 0.221667 3.4611111 0.224167 3.4638889 0.223333 3.4666667 0.226667 3.4694444 0.227500 3.4722222 0.229167 3.4750000 0.228333 3.4777778 0.225833 3.4805556 0.225000 3.4833333 0.225833 3.4861111 0.228333 3.4888889 0.230000 3.4916667 0.231667 3.4944444 0.229167 3.4972222 0.230000 3.5000000 0.232500 3.5027778 0.236667 3.5085556 0.300000 3.7414444 0.300000 3.7444444 0.243333 3.7472222 0.243333 3.7500000 0.243333 3.7527778 0.245833 3.7555556 0.245833 3.7583333 0.245833 3.7611111 0.242500 3.7638889 0.241667 3.7666667 0.243333 3.7694444 0.245000 3.7722222 0.246667 3.7750000 0.248333 3.7777778 0.249167 3.7805556 0.249167 3.7833333 0.254167 3.7861111 0.255000 3.7888889 0.257500 3.7916667 0.256667 3.7944444 0.255833 3.7972222 0.256667 3.8000000 0.258333 3.8027778 0.260833 3.8055556 0.260833 3.8083333 0.263333 3.8111111 0.260833 3.8138889 0.260833 3.8166667 0.263333 3.8194444 0.261667 3.8222222 0.262500 3.8250000 0.260833 3.8277778 0.259167 3.8305556 0.257500 3.8333333 0.260000 3.8361111 0.261667 3.8388889 0.261667 3.8416667 0.258333 3.8444444 0.257500 3.8472222 0.258333 3.8500000 0.261667 3.8527778 0.265833 3.8555556 0.267500 3.8583333 0.265000 3.8611111 0.261667 3.8638889 0.255000 3.8666667 0.255000 3.8694444 0.252500 3.8722222 0.252500 3.8750000 0.248333 3.8777778 0.245000 3.8805556 0.243333 3.8833333 0.243333 3.8861111 0.242500 3.8888889 0.241667 3.8916667 0.241667 3.8944444 0.243333 3.8972222 0.240833 3.9000000 0.242500 3.9027778 0.243333 3.9055556 0.243333 3.9083333 0.242500 3.9111111 0.240833 3.9138889 0.238333 3.9166667 0.240833 3.9194444 0.238333 3.9222222 0.242500 3.9250000 0.243333 3.9277778 0.240000 3.9305556 0.236667 3.9333333 0.240000 3.9361111 0.242500 3.9388889 0.241667 3.9416667 0.241667 3.9444444 0.240833 3.9472222 0.236667 3.9500000 0.235000 3.9527778 0.234167 3.9555556 0.229167 3.9583333 0.224167 3.9611111 0.220833 3.9638889 0.215000 3.9666667 0.209167 3.9694444 0.210000 3.9722222 0.217500 3.9750000 0.232500 3.9777778 0.250833 3.9805556 0.273333 3.9833333 0.306667 3.9861111 0.352500 3.9888889 0.399167 3.9916667 0.433333 3.9944444 0.447500 3.9972222 0.432500 4.0000000 0.386667 4.0027778 0.321667 4.0055556 0.264167 4.0083333 0.229167 4.0111111 0.216667 4.0138889 0.218333 4.0166667 0.225000 4.0194444 0.233333 4.0222222 0.235000 4.0250000 0.234167 4.0277778 0.234167 4.0305556 0.233333 4.0333333 0.235000 4.0361111 0.236667 4.0388889 0.235833 4.0416667 0.235833 4.0444444 0.233333 4.0472222 0.231667 4.0500000 0.231667 4.0527778 0.235000 4.0555556 0.235000 4.0583333 0.232500 4.0611111 0.232500 4.0638889 0.230833 4.0666667 0.231667 4.0694444 0.234167 4.0722222 0.234167 4.0750000 0.233333 4.0777778 0.230833 4.0805556 0.230833 4.0833333 0.230833 4.0861111 0.233333 4.0888889 0.235000 4.0916667 0.235000 4.0944444 0.231667 4.0972222 0.230833 4.1000000 0.232500 4.1027778 0.234167 4.1055556 0.234167 4.1083333 0.234167 4.1111111 0.232500 4.1138889 0.231667 4.1166667 0.231667 4.1194444 0.233333 4.1222222 0.235000 4.1250000 0.234167 4.1277778 0.231667 4.1305556 0.229167 4.1333333 0.230833 4.1361111 0.232500 4.1388889 0.231667 4.1416667 0.232500 4.1444444 0.230833 4.1472222 0.229167 4.1500000 0.229167 4.1527778 0.231667 4.1555556 0.234167 4.1583333 0.235000 4.1611111 0.233333 4.1638889 0.231667 4.1666667 0.231667 4.1694444 0.233333 4.1722222 0.235000 4.1750000 0.231667 4.1777778 0.230000 4.1805556 0.230000 4.1833333 0.230833 4.1861111 0.230833 4.1888889 0.232500 4.1916667 0.230000 4.1944444 0.230833 4.1972222 0.229167 4.2000000 0.231667 4.2027778 0.233333 4.2055556 0.232500 4.2083333 0.233333 4.2111111 0.233333 4.2138889 0.231667 4.2166667 0.233333 4.2194444 0.234167 4.2222222 0.234167 4.2250000 0.232500 4.2277778 0.231667 4.2305556 0.229167 4.2333333 0.229167 4.2361111 0.231667 4.2388889 0.231667 4.2416667 0.230000 4.2444444 0.228333 4.2472222 0.225833 4.2500000 0.226667 4.2527778 0.227500 4.2555556 0.228333 4.2583333 0.228333 4.2611111 0.225000 4.2638889 0.225833 4.2666667 0.225833 4.2694444 0.227500 4.2722222 0.227500 4.2750000 0.225833 4.2777778 0.226667 4.2805556 0.225000 4.2833333 0.228333 4.2861111 0.228333 4.2888889 0.230833 4.2916667 0.233333 4.2974444 0.300000 4.5581111 0.300000 4.5611111 0.245000 4.5638889 0.245000 4.5666667 0.245833 4.5694444 0.247500 4.5722222 0.247500 4.5750000 0.247500 4.5777778 0.245000 4.5805556 0.245000 4.5833333 0.246667 4.5861111 0.247500 4.5888889 0.249167 4.5916667 0.249167 4.5944444 0.250833 4.5972222 0.247500 4.6000000 0.250000 4.6027778 0.254167 4.6055556 0.257500 4.6083333 0.257500 4.6111111 0.256667 4.6138889 0.255833 4.6166667 0.257500 4.6194444 0.260833 4.6222222 0.261667 4.6250000 0.262500 4.6277778 0.263333 4.6305556 0.263333 4.6333333 0.264167 4.6361111 0.266667 4.6388889 0.265833 4.6416667 0.265833 4.6444444 0.262500 4.6472222 0.260833 4.6500000 0.260000 4.6527778 0.261667 4.6555556 0.264167 4.6583333 0.260000 4.6611111 0.260000 4.6638889 0.258333 4.6666667 0.260833 4.6694444 0.265000 4.6722222 0.266667 4.6750000 0.263333 4.6777778 0.257500 4.6805556 0.254167 4.6833333 0.252500 4.6861111 0.250000 4.6888889 0.249167 4.6916667 0.246667 4.6944444 0.245000 4.6972222 0.245833 4.7000000 0.246667 4.7027778 0.245000 4.7055556 0.245000 4.7083333 0.244167 4.7111111 0.243333 4.7138889 0.242500 4.7166667 0.243333 4.7194444 0.244167 4.7222222 0.246667 4.7250000 0.245833 4.7277778 0.244167 4.7305556 0.242500 4.7333333 0.242500 4.7361111 0.242500 4.7388889 0.244167 4.7416667 0.243333 4.7444444 0.242500 4.7472222 0.240833 4.7500000 0.243333 4.7527778 0.243333 4.7555556 0.243333 4.7583333 0.243333 4.7611111 0.242500 4.7638889 0.240833 4.7666667 0.239167 4.7694444 0.238333 4.7722222 0.232500 4.7750000 0.225833 4.7777778 0.220000 4.7805556 0.217500 4.7833333 0.213333 4.7861111 0.210833 4.7888889 0.215833 4.7916667 0.230833 4.7944444 0.253333 4.7972222 0.277500 4.8000000 0.310833 4.8027778 0.350000 4.8055556 0.396667 4.8083333 0.435000 4.8111111 0.457500 4.8138889 0.453333 4.8166667 0.429167 4.8194444 0.374167 4.8222222 0.303333 4.8250000 0.250833 4.8277778 0.225833 4.8305556 0.221667 4.8333333 0.229167 4.8361111 0.236667 4.8388889 0.240000 4.8416667 0.240000 4.8444444 0.238333 4.8472222 0.236667 4.8500000 0.236667 4.8527778 0.237500 4.8555556 0.238333 4.8583333 0.239167 4.8611111 0.238333 4.8638889 0.235833 4.8666667 0.235833 4.8694444 0.237500 4.8722222 0.238333 4.8750000 0.238333 4.8777778 0.235833 4.8805556 0.234167 4.8833333 0.235833 4.8861111 0.235833 4.8888889 0.235000 4.8916667 0.235833 4.8944444 0.234167 4.8972222 0.231667 4.9000000 0.233333 4.9027778 0.234167 4.9055556 0.236667 4.9083333 0.234167 4.9111111 0.234167 4.9138889 0.233333 4.9166667 0.233333 4.9194444 0.234167 4.9222222 0.235000 4.9250000 0.235000 4.9277778 0.234167 4.9305556 0.232500 4.9333333 0.235000 4.9361111 0.235833 4.9388889 0.237500 4.9416667 0.237500 4.9444444 0.236667 4.9472222 0.235000 4.9500000 0.235833 4.9527778 0.238333 4.9555556 0.238333 4.9583333 0.238333 4.9611111 0.237500 4.9638889 0.235833 4.9666667 0.238333 4.9694444 0.235000 4.9722222 0.237500 4.9750000 0.238333 4.9777778 0.236667 4.9805556 0.235000 4.9833333 0.235000 4.9861111 0.235833 4.9888889 0.237500 4.9916667 0.237500 4.9944444 0.235833 4.9972222 0.234167 5.0000000 0.235000 5.0027778 0.235833 5.0055556 0.237500 5.0083333 0.236667 5.0111111 0.235833 5.0138889 0.235000 5.0166667 0.236667 5.0194444 0.236667 5.0222222 0.238333 5.0250000 0.238333 5.0277778 0.239167 5.0305556 0.235000 5.0333333 0.239167 5.0361111 0.239167 5.0388889 0.240000 5.0416667 0.237500 5.0444444 0.236667 5.0472222 0.233333 5.0500000 0.235000 5.0527778 0.237500 5.0555556 0.237500 5.0583333 0.238333 5.0611111 0.235833 5.0638889 0.235000 5.0666667 0.235000 5.0694444 0.235000 5.0722222 0.235000 5.0750000 0.237500 5.0777778 0.235833 5.0805556 0.234167 5.0833333 0.236667 5.0861111 0.238333 5.0888889 0.237500 5.0916667 0.237500 5.0944444 0.235000 5.0972222 0.232500 5.1000000 0.237500 5.1027778 0.238333 5.1055556 0.240000 5.1083333 0.237500 5.1141111 0.300000 5.2108889 0.300000 5.2138889 0.250833 5.2166667 0.252500 5.2194444 0.253333 5.2222222 0.254167 5.2250000 0.253333 5.2277778 0.251667 5.2305556 0.248333 5.2333333 0.249167 5.2361111 0.252500 5.2388889 0.255000 5.2416667 0.255000 5.2444444 0.254167 5.2472222 0.252500 5.2500000 0.252500 5.2527778 0.255000 5.2555556 0.255833 5.2583333 0.255833 5.2611111 0.255833 5.2638889 0.253333 5.2666667 0.255833 5.2694444 0.259167 5.2722222 0.260833 5.2750000 0.260833 5.2777778 0.258333 5.2805556 0.258333 5.2833333 0.259167 5.2861111 0.264167 5.2888889 0.263333 5.2916667 0.259167 5.2944444 0.257500 5.2972222 0.261667 5.3000000 0.265833 5.3027778 0.265000 5.3055556 0.263333 5.3083333 0.261667 5.3111111 0.260000 5.3138889 0.260000 5.3166667 0.259167 5.3194444 0.258333 5.3222222 0.255000 5.3250000 0.252500 5.3277778 0.247500 5.3305556 0.246667 5.3333333 0.246667 5.3361111 0.248333 5.3388889 0.245000 5.3416667 0.243333 5.3444444 0.242500 5.3472222 0.240000 5.3500000 0.239167 5.3527778 0.240000 5.3555556 0.241667 5.3583333 0.240833 5.3611111 0.237500 5.3638889 0.235833 5.3666667 0.237500 5.3694444 0.238333 5.3722222 0.239167 5.3750000 0.239167 5.3777778 0.238333 5.3805556 0.236667 5.3833333 0.240000 5.3861111 0.241667 5.3888889 0.240833 5.3916667 0.240833 5.3944444 0.241667 5.3972222 0.239167 5.4000000 0.241667 5.4027778 0.241667 5.4055556 0.243333 5.4083333 0.240833 5.4111111 0.241667 5.4138889 0.237500 5.4166667 0.239167 5.4194444 0.237500 5.4222222 0.233333 5.4250000 0.228333 5.4277778 0.220833 5.4305556 0.213333 5.4333333 0.213333 5.4361111 0.208333 5.4388889 0.205000 5.4416667 0.210000 5.4444444 0.225833 5.4472222 0.249167 5.4500000 0.276667 5.4527778 0.304167 5.4555556 0.343333 5.4583333 0.385000 5.4611111 0.422500 5.4638889 0.440833 5.4666667 0.445833 5.4694444 0.422500 5.4722222 0.366667 5.4750000 0.295833 5.4777778 0.244167 5.4805556 0.220000 5.4833333 0.221667 5.4861111 0.230833 5.4888889 0.237500 5.4916667 0.239167 5.4944444 0.235833 5.4972222 0.233333 5.5000000 0.236667 5.5027778 0.235000 5.5055556 0.237500 5.5083333 0.235833 5.5111111 0.234167 5.5138889 0.232500 5.5166667 0.235000 5.5194444 0.236667 5.5222222 0.235833 5.5250000 0.235833 5.5277778 0.234167 5.5305556 0.233333 5.5333333 0.232500 5.5361111 0.233333 5.5388889 0.235000 5.5416667 0.235000 5.5444444 0.234167 5.5472222 0.233333 5.5500000 0.235000 5.5527778 0.235833 5.5555556 0.235000 5.5583333 0.235833 5.5611111 0.231667 5.5638889 0.230000 5.5666667 0.232500 5.5694444 0.231667 5.5722222 0.235000 5.5750000 0.235000 5.5777778 0.235000 5.5805556 0.233333 5.5833333 0.233333 5.5861111 0.235000 5.5888889 0.237500 5.5916667 0.236667 5.5944444 0.234167 5.5972222 0.233333 5.6000000 0.235000 5.6027778 0.233333 5.6055556 0.235000 5.6083333 0.234167 5.6111111 0.231667 5.6138889 0.230833 5.6166667 0.232500 5.6194444 0.235833 5.6222222 0.235833 5.6250000 0.236667 5.6277778 0.233333 5.6305556 0.233333 5.6333333 0.234167 5.6361111 0.235000 5.6388889 0.236667 5.6416667 0.237500 5.6444444 0.234167 5.6472222 0.234167 5.6500000 0.235833 5.6527778 0.236667 5.6555556 0.237500 5.6583333 0.235833 5.6611111 0.235000 5.6638889 0.233333 5.6666667 0.233333 5.6694444 0.235833 5.6722222 0.236667 5.6750000 0.234167 5.6777778 0.235000 5.6805556 0.233333 5.6833333 0.234167 5.6861111 0.235833 5.6888889 0.236667 5.6916667 0.235833 5.6944444 0.234167 5.6972222 0.232500 5.7000000 0.233333 5.7027778 0.235000 5.7055556 0.236667 5.7083333 0.236667 5.7111111 0.235833 5.7138889 0.232500 5.7166667 0.234167 5.7194444 0.233333 5.7222222 0.235000 5.7250000 0.233333 5.7277778 0.232500 5.7305556 0.229167 5.7333333 0.230000 5.7361111 0.232500 5.7388889 0.233333 5.7416667 0.232500 5.7444444 0.232500 5.7472222 0.230833 5.7500000 0.233333 5.7527778 0.235000 5.7555556 0.236667 5.7583333 0.235833 5.7611111 0.234167 5.7668889 0.300000 6.2053333 0.300000 6.2083333 0.242500 6.2111111 0.240833 6.2138889 0.240000 6.2166667 0.240000 6.2194444 0.239167 6.2222222 0.242500 6.2250000 0.240833 6.2277778 0.241667 6.2305556 0.240000 6.2333333 0.240833 6.2361111 0.240000 6.2388889 0.242500 6.2416667 0.244167 6.2444444 0.245000 6.2472222 0.245000 6.2500000 0.248333 6.2527778 0.249167 6.2555556 0.250000 6.2583333 0.249167 6.2611111 0.250833 6.2638889 0.249167 6.2666667 0.252500 6.2694444 0.254167 6.2722222 0.255833 6.2750000 0.257500 6.2777778 0.257500 6.2805556 0.256667 6.2833333 0.255833 6.2861111 0.257500 6.2888889 0.257500 6.2916667 0.256667 6.2944444 0.253333 6.2972222 0.251667 6.3000000 0.253333 6.3027778 0.255000 6.3055556 0.257500 6.3083333 0.254167 6.3111111 0.251667 6.3138889 0.246667 6.3166667 0.250000 6.3194444 0.250833 6.3222222 0.255000 6.3250000 0.255833 6.3277778 0.255000 6.3305556 0.252500 6.3333333 0.250000 6.3361111 0.248333 6.3388889 0.247500 6.3416667 0.246667 6.3444444 0.241667 6.3472222 0.238333 6.3500000 0.239167 6.3527778 0.239167 6.3555556 0.239167 6.3583333 0.238333 6.3611111 0.238333 6.3638889 0.238333 6.3666667 0.236667 6.3694444 0.240000 6.3722222 0.237500 6.3750000 0.237500 6.3777778 0.233333 6.3805556 0.230000 6.3833333 0.232500 6.3861111 0.233333 6.3888889 0.235833 6.3916667 0.236667 6.3944444 0.233333 6.3972222 0.230833 6.4000000 0.232500 6.4027778 0.234167 6.4055556 0.234167 6.4083333 0.234167 6.4111111 0.231667 6.4138889 0.228333 6.4166667 0.226667 6.4194444 0.224167 6.4222222 0.218333 6.4250000 0.219167 6.4277778 0.213333 6.4305556 0.205000 6.4333333 0.204167 6.4361111 0.212500 6.4388889 0.230000 6.4416667 0.249167 6.4444444 0.268333 6.4472222 0.296667 6.4500000 0.336667 6.4527778 0.380833 6.4555556 0.419167 6.4583333 0.440833 6.4611111 0.447500 6.4638889 0.431667 6.4666667 0.393333 6.4694444 0.337500 6.4722222 0.288333 6.4750000 0.252500 6.4777778 0.229167 6.4805556 0.216667 6.4833333 0.208333 6.4861111 0.210833 6.4888889 0.216667 6.4916667 0.222500 6.4944444 0.225000 6.4972222 0.225000 6.5000000 0.227500 6.5027778 0.230000 6.5055556 0.231667 6.5083333 0.231667 6.5111111 0.230833 6.5138889 0.230000 6.5166667 0.229167 6.5194444 0.230000 6.5222222 0.228333 6.5250000 0.228333 6.5277778 0.226667 6.5305556 0.225000 6.5333333 0.225000 6.5361111 0.228333 6.5388889 0.228333 6.5416667 0.228333 6.5444444 0.225833 6.5472222 0.225833 6.5500000 0.226667 6.5527778 0.229167 6.5555556 0.228333 6.5583333 0.228333 6.5611111 0.229167 6.5638889 0.225833 6.5666667 0.225833 6.5694444 0.228333 6.5722222 0.227500 6.5750000 0.227500 6.5777778 0.225833 6.5805556 0.225833 6.5833333 0.227500 6.5861111 0.228333 6.5888889 0.229167 6.5916667 0.228333 6.5944444 0.228333 6.5972222 0.226667 6.6000000 0.230000 6.6027778 0.228333 6.6055556 0.229167 6.6083333 0.228333 6.6111111 0.226667 6.6138889 0.226667 6.6166667 0.228333 6.6194444 0.228333 6.6222222 0.230833 6.6250000 0.229167 6.6277778 0.228333 6.6305556 0.224167 6.6333333 0.225833 6.6361111 0.225833 6.6388889 0.228333 6.6416667 0.228333 6.6444444 0.226667 6.6472222 0.226667 6.6500000 0.227500 6.6527778 0.228333 6.6555556 0.230833 6.6583333 0.230833 6.6611111 0.229167 6.6638889 0.229167 6.6666667 0.230000 6.6694444 0.232500 6.6722222 0.232500 6.6750000 0.230833 6.6777778 0.230833 6.6805556 0.229167 6.6833333 0.228333 6.6861111 0.232500 6.6888889 0.232500 6.6916667 0.232500 6.6944444 0.232500 6.6972222 0.228333 6.7000000 0.230833 6.7027778 0.231667 6.7055556 0.230833 6.7083333 0.228333 6.7111111 0.225833 6.7138889 0.222500 6.7166667 0.223333 6.7194444 0.225000 6.7222222 0.224167 6.7250000 0.223333 6.7277778 0.222500 6.7305556 0.219167 6.7333333 0.217500 6.7361111 0.220833 6.7388889 0.218333 6.7416667 0.216667 6.7444444 0.217500 6.7472222 0.214167 6.7500000 0.216667 6.7527778 0.219167 6.7555556 0.218333 6.7613333 0.300000 7.0497778 0.300000 7.0527778 0.240833 7.0555556 0.243333 7.0583333 0.242500 7.0611111 0.240833 7.0638889 0.240833 7.0666667 0.240833 7.0694444 0.243333 7.0722222 0.243333 7.0750000 0.242500 7.0777778 0.239167 7.0805556 0.238333 7.0833333 0.241667 7.0861111 0.245000 7.0888889 0.246667 7.0916667 0.247500 7.0944444 0.250833 7.0972222 0.249167 7.1000000 0.250833 7.1027778 0.250000 7.1055556 0.252500 7.1083333 0.254167 7.1111111 0.256667 7.1138889 0.254167 7.1166667 0.255833 7.1194444 0.256667 7.1222222 0.258333 7.1250000 0.259167 7.1277778 0.257500 7.1305556 0.255833 7.1333333 0.256667 7.1361111 0.256667 7.1388889 0.258333 7.1416667 0.256667 7.1444444 0.253333 7.1472222 0.253333 7.1500000 0.254167 7.1527778 0.252500 7.1555556 0.253333 7.1583333 0.257500 7.1611111 0.259167 7.1638889 0.259167 7.1666667 0.256667 7.1694444 0.252500 7.1722222 0.251667 7.1750000 0.250000 7.1777778 0.246667 7.1805556 0.244167 7.1833333 0.240833 7.1861111 0.241667 7.1888889 0.240833 7.1916667 0.240833 7.1944444 0.237500 7.1972222 0.235833 7.2000000 0.236667 7.2027778 0.240000 7.2055556 0.241667 7.2083333 0.240000 7.2111111 0.239167 7.2138889 0.238333 7.2166667 0.238333 7.2194444 0.239167 7.2222222 0.240000 7.2250000 0.239167 7.2277778 0.238333 7.2305556 0.235833 7.2333333 0.235833 7.2361111 0.239167 7.2388889 0.240000 7.2416667 0.236667 7.2444444 0.235833 7.2472222 0.234167 7.2500000 0.234167 7.2527778 0.235833 7.2555556 0.236667 7.2583333 0.234167 7.2611111 0.229167 7.2638889 0.222500 7.2666667 0.216667 7.2694444 0.214167 7.2722222 0.211667 7.2750000 0.206667 7.2777778 0.202500 7.2805556 0.211667 7.2833333 0.231667 7.2861111 0.257500 7.2888889 0.282500 7.2916667 0.317500 7.2944444 0.359167 7.2972222 0.400000 7.3000000 0.435000 7.3027778 0.448333 7.3055556 0.438333 7.3083333 0.396667 7.3111111 0.330833 7.3138889 0.265833 7.3166667 0.225000 7.3194444 0.212500 7.3222222 0.217500 7.3250000 0.222500 7.3277778 0.227500 7.3305556 0.230833 7.3333333 0.230833 7.3361111 0.230833 7.3388889 0.233333 7.3416667 0.234167 7.3444444 0.232500 7.3472222 0.229167 7.3500000 0.227500 7.3527778 0.230833 7.3555556 0.230833 7.3583333 0.230833 7.3611111 0.230833 7.3638889 0.228333 7.3666667 0.230000 7.3694444 0.231667 7.3722222 0.232500 7.3750000 0.230000 7.3777778 0.231667 7.3805556 0.230000 7.3833333 0.233333 7.3861111 0.234167 7.3888889 0.235833 7.3916667 0.233333 7.3944444 0.233333 7.3972222 0.233333 7.4000000 0.233333 7.4027778 0.234167 7.4055556 0.233333 7.4083333 0.233333 7.4111111 0.233333 7.4138889 0.231667 7.4166667 0.234167 7.4194444 0.231667 7.4222222 0.233333 7.4250000 0.234167 7.4277778 0.232500 7.4305556 0.231667 7.4333333 0.230833 7.4361111 0.232500 7.4388889 0.233333 7.4416667 0.234167 7.4444444 0.232500 7.4472222 0.230833 7.4500000 0.232500 7.4527778 0.230833 7.4555556 0.231667 7.4583333 0.232500 7.4611111 0.232500 7.4638889 0.231667 7.4666667 0.232500 7.4694444 0.233333 7.4722222 0.234167 7.4750000 0.232500 7.4777778 0.232500 7.4805556 0.233333 7.4833333 0.234167 7.4861111 0.235000 7.4888889 0.234167 7.4916667 0.235000 7.4944444 0.234167 7.4972222 0.230000 7.5000000 0.230833 7.5027778 0.232500 7.5055556 0.233333 7.5083333 0.233333 7.5111111 0.230833 7.5138889 0.230000 7.5166667 0.231667 7.5194444 0.234167 7.5222222 0.233333 7.5250000 0.232500 7.5277778 0.230833 7.5305556 0.227500 7.5333333 0.230833 7.5361111 0.230833 7.5388889 0.233333 7.5416667 0.232500 7.5444444 0.230000 7.5472222 0.228333 7.5500000 0.229167 7.5527778 0.231667 7.5555556 0.231667 7.5583333 0.232500 7.5611111 0.230833 7.5638889 0.229167 7.5666667 0.229167 7.5694444 0.230000 7.5722222 0.231667 7.5750000 0.231667 7.5777778 0.230000 7.5805556 0.228333 7.5833333 0.229167 7.5861111 0.230000 7.5888889 0.232500 7.5916667 0.230833 7.5944444 0.231667 7.5972222 0.231667 7.6000000 0.235833 7.6057778 0.300000 7.8608889 0.300000 7.8638889 0.244167 7.8666667 0.246667 7.8694444 0.245833 7.8722222 0.247500 7.8750000 0.246667 7.8777778 0.246667 7.8805556 0.242500 7.8833333 0.244167 7.8861111 0.246667 7.8888889 0.248333 7.8916667 0.246667 7.8944444 0.246667 7.8972222 0.243333 7.9000000 0.245000 7.9027778 0.246667 7.9055556 0.248333 7.9083333 0.248333 7.9111111 0.248333 7.9138889 0.250833 7.9166667 0.253333 7.9194444 0.257500 7.9222222 0.258333 7.9250000 0.258333 7.9277778 0.257500 7.9305556 0.256667 7.9333333 0.260000 7.9361111 0.263333 7.9388889 0.261667 7.9416667 0.261667 7.9444444 0.264167 7.9472222 0.263333 7.9500000 0.262500 7.9527778 0.261667 7.9555556 0.261667 7.9583333 0.260833 7.9611111 0.259167 7.9638889 0.257500 7.9666667 0.260000 7.9694444 0.260833 7.9722222 0.259167 7.9750000 0.260833 7.9777778 0.261667 7.9805556 0.263333 7.9833333 0.267500 7.9861111 0.263333 7.9888889 0.259167 7.9916667 0.256667 7.9944444 0.255000 7.9972222 0.251667 8.0000000 0.250000 8.0027778 0.249167 8.0055556 0.249167 8.0083333 0.246667 8.0111111 0.245000 8.0138889 0.241667 8.0166667 0.241667 8.0194444 0.244167 8.0222222 0.244167 8.0250000 0.244167 8.0277778 0.243333 8.0305556 0.241667 8.0333333 0.241667 8.0361111 0.242500 8.0388889 0.244167 8.0416667 0.242500 8.0444444 0.240833 8.0472222 0.238333 8.0500000 0.241667 8.0527778 0.242500 8.0555556 0.244167 8.0583333 0.244167 8.0611111 0.244167 8.0638889 0.240833 8.0666667 0.240833 8.0694444 0.242500 8.0722222 0.240833 8.0750000 0.234167 8.0777778 0.225000 8.0805556 0.220000 8.0833333 0.215833 8.0861111 0.212500 8.0888889 0.209167 8.0916667 0.216667 8.0944444 0.234167 8.0972222 0.257500 8.1000000 0.288333 8.1027778 0.324167 8.1055556 0.370833 8.1083333 0.414167 8.1111111 0.445833 8.1138889 0.454167 8.1166667 0.432500 8.1194444 0.378333 8.1222222 0.303333 8.1250000 0.245833 8.1277778 0.221667 8.1305556 0.219167 8.1333333 0.231667 8.1361111 0.239167 8.1388889 0.240833 8.1416667 0.239167 8.1444444 0.236667 8.1472222 0.235833 8.1500000 0.236667 8.1527778 0.238333 8.1555556 0.238333 8.1583333 0.237500 8.1611111 0.235833 8.1638889 0.234167 8.1666667 0.235833 8.1694444 0.236667 8.1722222 0.235833 8.1750000 0.237500 8.1777778 0.235000 8.1805556 0.232500 8.1833333 0.232500 8.1861111 0.235000 8.1888889 0.235833 8.1916667 0.235833 8.1944444 0.235000 8.1972222 0.231667 8.2000000 0.233333 8.2027778 0.235000 8.2055556 0.235833 8.2083333 0.235833 8.2111111 0.234167 8.2138889 0.235000 8.2166667 0.234167 8.2194444 0.236667 8.2222222 0.237500 8.2250000 0.236667 8.2277778 0.235833 8.2305556 0.233333 8.2333333 0.235833 8.2361111 0.236667 8.2388889 0.237500 8.2416667 0.236667 8.2444444 0.234167 8.2472222 0.234167 8.2500000 0.235833 8.2527778 0.237500 8.2555556 0.238333 8.2583333 0.239167 8.2611111 0.235833 8.2638889 0.234167 8.2666667 0.235833 8.2694444 0.235833 8.2722222 0.238333 8.2750000 0.237500 8.2777778 0.238333 8.2805556 0.237500 8.2833333 0.237500 8.2861111 0.238333 8.2888889 0.240833 8.2916667 0.239167 8.2944444 0.236667 8.2972222 0.237500 8.3000000 0.238333 8.3027778 0.236667 8.3055556 0.239167 8.3083333 0.238333 8.3111111 0.237500 8.3138889 0.235000 8.3166667 0.236667 8.3194444 0.237500 8.3222222 0.236667 8.3250000 0.238333 8.3277778 0.237500 8.3305556 0.236667 8.3333333 0.235833 8.3361111 0.235833 8.3388889 0.238333 8.3416667 0.237500 8.3444444 0.237500 8.3472222 0.236667 8.3500000 0.236667 8.3527778 0.236667 8.3555556 0.236667 8.3583333 0.237500 8.3611111 0.235000 8.3638889 0.234167 8.3666667 0.235833 8.3694444 0.235833 8.3722222 0.237500 8.3750000 0.237500 8.3777778 0.235833 8.3805556 0.235833 8.3833333 0.235000 8.3861111 0.238333 8.3888889 0.239167 8.3916667 0.239167 8.3944444 0.237500 8.3972222 0.235833 8.4000000 0.241667 8.4027778 0.242500 8.4055556 0.245833 8.4083333 0.245833 8.4111111 0.245000 8.4168889 0.300000 8.6497778 0.300000 8.6527778 0.249167 8.6555556 0.251667 8.6583333 0.252500 8.6611111 0.251667 8.6638889 0.249167 8.6666667 0.248333 8.6694444 0.250000 8.6722222 0.250000 8.6750000 0.248333 8.6777778 0.247500 8.6805556 0.247500 8.6833333 0.248333 8.6861111 0.250833 8.6888889 0.250000 8.6916667 0.250833 8.6944444 0.247500 8.6972222 0.248333 8.7000000 0.251667 8.7027778 0.255833 8.7055556 0.260000 8.7083333 0.257500 8.7111111 0.260000 8.7138889 0.258333 8.7166667 0.262500 8.7194444 0.262500 8.7222222 0.264167 8.7250000 0.265000 8.7277778 0.266667 8.7305556 0.267500 8.7333333 0.267500 8.7361111 0.270000 8.7388889 0.270833 8.7416667 0.270000 8.7444444 0.265833 8.7472222 0.264167 8.7500000 0.265000 8.7527778 0.265000 8.7555556 0.265000 8.7583333 0.265000 8.7611111 0.264167 8.7638889 0.262500 8.7666667 0.265000 8.7694444 0.270000 8.7722222 0.271667 8.7750000 0.269167 8.7777778 0.260000 8.7805556 0.257500 8.7833333 0.257500 8.7861111 0.255000 8.7888889 0.254167 8.7916667 0.252500 8.7944444 0.250000 8.7972222 0.250000 8.8000000 0.247500 8.8027778 0.249167 8.8055556 0.250000 8.8083333 0.250833 8.8111111 0.250000 8.8138889 0.247500 8.8166667 0.248333 8.8194444 0.248333 8.8222222 0.250000 8.8250000 0.250000 8.8277778 0.249167 8.8305556 0.247500 8.8333333 0.245833 8.8361111 0.246667 8.8388889 0.246667 8.8416667 0.246667 8.8444444 0.245833 8.8472222 0.243333 8.8500000 0.244167 8.8527778 0.245833 8.8555556 0.247500 8.8583333 0.246667 8.8611111 0.242500 8.8638889 0.238333 8.8666667 0.234167 8.8694444 0.229167 8.8722222 0.225833 8.8750000 0.222500 8.8777778 0.215000 8.8805556 0.211667 8.8833333 0.219167 8.8861111 0.238333 8.8888889 0.260833 8.8916667 0.285000 8.8944444 0.317500 8.8972222 0.362500 8.9000000 0.409167 8.9027778 0.436667 8.9055556 0.444167 8.9083333 0.422500 8.9111111 0.375000 8.9138889 0.310000 8.9166667 0.255000 8.9194444 0.228333 8.9222222 0.223333 8.9250000 0.230833 8.9277778 0.235833 8.9305556 0.239167 8.9333333 0.240833 8.9361111 0.240833 8.9388889 0.242500 8.9416667 0.241667 8.9444444 0.241667 8.9472222 0.240000 8.9500000 0.242500 8.9527778 0.243333 8.9555556 0.243333 8.9583333 0.244167 8.9611111 0.244167 8.9638889 0.240833 8.9666667 0.242500 8.9694444 0.243333 8.9722222 0.244167 8.9750000 0.243333 8.9777778 0.241667 8.9805556 0.239167 8.9833333 0.240000 8.9861111 0.239167 8.9888889 0.241667 8.9916667 0.242500 8.9944444 0.239167 8.9972222 0.240000 9.0000000 0.241667 9.0027778 0.240833 9.0055556 0.241667 9.0083333 0.240833 9.0111111 0.241667 9.0138889 0.240000 9.0166667 0.244167 9.0194444 0.244167 9.0222222 0.245000 9.0250000 0.243333 9.0277778 0.241667 9.0305556 0.241667 9.0333333 0.242500 9.0361111 0.244167 9.0388889 0.242500 9.0416667 0.240833 9.0444444 0.240833 9.0472222 0.238333 9.0500000 0.240833 9.0527778 0.241667 9.0555556 0.242500 9.0583333 0.239167 9.0611111 0.239167 9.0638889 0.238333 9.0666667 0.239167 9.0694444 0.240833 9.0722222 0.242500 9.0750000 0.242500 9.0777778 0.242500 9.0805556 0.243333 9.0833333 0.244167 9.0861111 0.245833 9.0888889 0.244167 9.0916667 0.242500 9.0944444 0.241667 9.0972222 0.241667 9.1000000 0.240833 9.1027778 0.240833 9.1055556 0.240000 9.1083333 0.241667 9.1111111 0.240000 9.1138889 0.239167 9.1166667 0.242500 9.1194444 0.242500 9.1222222 0.245000 9.1250000 0.241667 9.1277778 0.242500 9.1305556 0.240833 9.1333333 0.241667 9.1361111 0.243333 9.1388889 0.244167 9.1416667 0.241667 9.1444444 0.239167 9.1472222 0.236667 9.1500000 0.235833 9.1527778 0.240833 9.1555556 0.240000 9.1583333 0.240833 9.1611111 0.238333 9.1638889 0.235833 9.1666667 0.238333 9.1694444 0.238333 9.1722222 0.241667 9.1750000 0.242500 9.1777778 0.239167 9.1805556 0.239167 9.1833333 0.240000 9.1861111 0.242500 9.1888889 0.245000 9.1916667 0.245000 9.1944444 0.245000 9.1972222 0.244167 9.2000000 0.247500 9.2057778 0.300000 9.4220000 0.300000 9.4250000 0.249167 9.4277778 0.248333 9.4305556 0.246667 9.4333333 0.248333 9.4361111 0.250000 9.4388889 0.250833 9.4416667 0.250000 9.4444444 0.247500 9.4472222 0.245833 9.4500000 0.245833 9.4527778 0.249167 9.4555556 0.248333 9.4583333 0.251667 9.4611111 0.247500 9.4638889 0.245833 9.4666667 0.246667 9.4694444 0.251667 9.4722222 0.253333 9.4750000 0.256667 9.4777778 0.256667 9.4805556 0.255833 9.4833333 0.256667 9.4861111 0.258333 9.4888889 0.261667 9.4916667 0.263333 9.4944444 0.263333 9.4972222 0.260833 9.5000000 0.263333 9.5027778 0.265833 9.5055556 0.265833 9.5083333 0.265000 9.5111111 0.265000 9.5138889 0.261667 9.5166667 0.260000 9.5194444 0.261667 9.5222222 0.262500 9.5250000 0.260833 9.5277778 0.258333 9.5305556 0.255833 9.5333333 0.256667 9.5361111 0.259167 9.5388889 0.264167 9.5416667 0.264167 9.5444444 0.259167 9.5472222 0.253333 9.5500000 0.254167 9.5527778 0.254167 9.5555556 0.250833 9.5583333 0.248333 9.5611111 0.245833 9.5638889 0.243333 9.5666667 0.243333 9.5694444 0.245833 9.5722222 0.247500 9.5750000 0.248333 9.5777778 0.247500 9.5805556 0.245000 9.5833333 0.245000 9.5861111 0.245833 9.5888889 0.245833 9.5916667 0.244167 9.5944444 0.242500 9.5972222 0.241667 9.6000000 0.241667 9.6027778 0.241667 9.6055556 0.242500 9.6083333 0.241667 9.6111111 0.239167 9.6138889 0.240000 9.6166667 0.241667 9.6194444 0.240833 9.6222222 0.242500 9.6250000 0.242500 9.6277778 0.241667 9.6305556 0.239167 9.6333333 0.236667 9.6361111 0.232500 9.6388889 0.229167 9.6416667 0.226667 9.6444444 0.221667 9.6472222 0.213333 9.6500000 0.210000 9.6527778 0.218333 9.6555556 0.235000 9.6583333 0.256667 9.6611111 0.280833 9.6638889 0.314167 9.6666667 0.360000 9.6694444 0.402500 9.6722222 0.430000 9.6750000 0.439167 9.6777778 0.420000 9.6805556 0.368333 9.6833333 0.305000 9.6861111 0.257500 9.6888889 0.230833 9.6916667 0.221667 9.6944444 0.222500 9.6972222 0.227500 9.7000000 0.234167 9.7027778 0.237500 9.7055556 0.238333 9.7083333 0.237500 9.7111111 0.237500 9.7138889 0.235000 9.7166667 0.233333 9.7194444 0.236667 9.7222222 0.235833 9.7250000 0.235833 9.7277778 0.235833 9.7305556 0.235833 9.7333333 0.238333 9.7361111 0.238333 9.7388889 0.240000 9.7416667 0.236667 9.7444444 0.236667 9.7472222 0.235833 9.7500000 0.238333 9.7527778 0.238333 9.7555556 0.239167 9.7583333 0.237500 9.7611111 0.235833 9.7638889 0.235000 9.7666667 0.235000 9.7694444 0.235833 9.7722222 0.235833 9.7750000 0.234167 9.7777778 0.235000 9.7805556 0.233333 9.7833333 0.232500 9.7861111 0.235000 9.7888889 0.234167 9.7916667 0.235000 9.7944444 0.232500 9.7972222 0.232500 9.8000000 0.233333 9.8027778 0.237500 9.8055556 0.236667 9.8083333 0.235000 9.8111111 0.234167 9.8138889 0.234167 9.8166667 0.235000 9.8194444 0.235000 9.8222222 0.235833 9.8250000 0.232500 9.8277778 0.233333 9.8305556 0.232500 9.8333333 0.234167 9.8361111 0.235000 9.8388889 0.234167 9.8416667 0.235000 9.8444444 0.233333 9.8472222 0.232500 9.8500000 0.232500 9.8527778 0.235000 9.8555556 0.235000 9.8583333 0.234167 9.8611111 0.233333 9.8638889 0.233333 9.8666667 0.234167 9.8694444 0.236667 9.8722222 0.238333 9.8750000 0.236667 9.8777778 0.235833 9.8805556 0.234167 9.8833333 0.235000 9.8861111 0.236667 9.8888889 0.236667 9.8916667 0.235833 9.8944444 0.235000 9.8972222 0.235000 9.9000000 0.233333 9.9027778 0.233333 9.9055556 0.232500 9.9083333 0.230833 9.9111111 0.230000 9.9138889 0.228333 9.9166667 0.228333 9.9194444 0.229167 9.9222222 0.230000 9.9250000 0.228333 9.9277778 0.225833 9.9305556 0.222500 9.9333333 0.224167 9.9361111 0.226667 9.9388889 0.229167 9.9416667 0.227500 9.9444444 0.225000 9.9472222 0.226667 9.9500000 0.225833 9.9527778 0.229167 9.9555556 0.229167 9.9583333 0.229167 9.9611111 0.228333 9.9638889 0.228333 9.9666667 0.230833 9.9694444 0.230833 9.9722222 0.235833 9.9780000 0.300000 10.2608889 0.300000 10.2638889 0.246667 10.2666667 0.247500 10.2694444 0.248333 10.2722222 0.250833 10.2750000 0.250833 10.2777778 0.249167 10.2805556 0.248333 10.2833333 0.250000 10.2861111 0.253333 10.2888889 0.254167 10.2916667 0.255833 10.2944444 0.254167 10.2972222 0.254167 10.3000000 0.256667 10.3027778 0.260000 10.3055556 0.260000 10.3083333 0.260833 10.3111111 0.260000 10.3138889 0.260833 10.3166667 0.262500 10.3194444 0.264167 10.3222222 0.265833 10.3250000 0.265833 10.3277778 0.265000 10.3305556 0.264167 10.3333333 0.263333 10.3361111 0.263333 10.3388889 0.264167 10.3416667 0.263333 10.3444444 0.263333 10.3472222 0.261667 10.3500000 0.261667 10.3527778 0.260000 10.3555556 0.265000 10.3583333 0.263333 10.3611111 0.261667 10.3638889 0.257500 10.3666667 0.260833 10.3694444 0.265000 10.3722222 0.268333 10.3750000 0.265833 10.3777778 0.262500 10.3805556 0.256667 10.3833333 0.254167 10.3861111 0.253333 10.3888889 0.252500 10.3916667 0.249167 10.3944444 0.246667 10.3972222 0.247500 10.4000000 0.244167 10.4027778 0.245833 10.4055556 0.244167 10.4083333 0.246667 10.4111111 0.245833 10.4138889 0.246667 10.4166667 0.245833 10.4194444 0.245833 10.4222222 0.248333 10.4250000 0.249167 10.4277778 0.246667 10.4305556 0.246667 10.4333333 0.245000 10.4361111 0.246667 10.4388889 0.246667 10.4416667 0.245000 10.4444444 0.245000 10.4472222 0.240000 10.4500000 0.240833 10.4527778 0.245000 10.4555556 0.245833 10.4583333 0.245833 10.4611111 0.244167 10.4638889 0.241667 10.4666667 0.243333 10.4694444 0.242500 10.4722222 0.240833 10.4750000 0.235833 10.4777778 0.229167 10.4805556 0.225000 10.4833333 0.221667 10.4861111 0.219167 10.4888889 0.215000 10.4916667 0.214167 10.4944444 0.224167 10.4972222 0.245833 10.5000000 0.272500 10.5027778 0.301667 10.5055556 0.341667 10.5083333 0.385833 10.5111111 0.423333 10.5138889 0.447500 10.5166667 0.455833 10.5194444 0.439167 10.5222222 0.387500 10.5250000 0.320000 10.5277778 0.261667 10.5305556 0.229167 10.5333333 0.224167 10.5361111 0.230000 10.5388889 0.236667 10.5416667 0.240000 10.5444444 0.239167 10.5472222 0.237500 10.5500000 0.236667 10.5527778 0.240833 10.5555556 0.240833 10.5583333 0.238333 10.5611111 0.237500 10.5638889 0.235833 10.5666667 0.236667 10.5694444 0.239167 10.5722222 0.238333 10.5750000 0.238333 10.5777778 0.239167 10.5805556 0.236667 10.5833333 0.238333 10.5861111 0.237500 10.5888889 0.239167 10.5916667 0.238333 10.5944444 0.236667 10.5972222 0.237500 10.6000000 0.239167 10.6027778 0.240000 10.6055556 0.240000 10.6083333 0.240833 10.6111111 0.240833 10.6138889 0.238333 10.6166667 0.239167 10.6194444 0.240833 10.6222222 0.241667 10.6250000 0.241667 10.6277778 0.241667 10.6305556 0.240000 10.6333333 0.240000 10.6361111 0.240000 10.6388889 0.241667 10.6416667 0.240833 10.6444444 0.239167 10.6472222 0.238333 10.6500000 0.240000 10.6527778 0.241667 10.6555556 0.240833 10.6583333 0.241667 10.6611111 0.240833 10.6638889 0.238333 10.6666667 0.237500 10.6694444 0.240000 10.6722222 0.241667 10.6750000 0.242500 10.6777778 0.241667 10.6805556 0.238333 10.6833333 0.238333 10.6861111 0.240833 10.6888889 0.241667 10.6916667 0.242500 10.6944444 0.240000 10.6972222 0.238333 10.7000000 0.239167 10.7027778 0.240000 10.7055556 0.241667 10.7083333 0.240833 10.7111111 0.239167 10.7138889 0.239167 10.7166667 0.238333 10.7194444 0.239167 10.7222222 0.241667 10.7250000 0.241667 10.7277778 0.240000 10.7305556 0.240000 10.7333333 0.240833 10.7361111 0.242500 10.7388889 0.241667 10.7416667 0.242500 10.7444444 0.240833 10.7472222 0.238333 10.7500000 0.239167 10.7527778 0.240833 10.7555556 0.240000 10.7583333 0.239167 10.7611111 0.239167 10.7638889 0.236667 10.7666667 0.235833 10.7694444 0.237500 10.7722222 0.238333 10.7750000 0.237500 10.7777778 0.235833 10.7805556 0.234167 10.7833333 0.237500 10.7861111 0.235833 10.7888889 0.236667 10.7916667 0.238333 10.7944444 0.235833 10.7972222 0.235833 10.8000000 0.236667 10.8027778 0.238333 10.8055556 0.240000 10.8083333 0.241667 10.8111111 0.244167 10.8168889 0.300000 11.1164444 0.300000 11.1194444 0.250833 11.1222222 0.252500 11.1250000 0.250833 11.1277778 0.250833 11.1305556 0.248333 11.1333333 0.250000 11.1361111 0.252500 11.1388889 0.253333 11.1416667 0.254167 11.1444444 0.253333 11.1472222 0.255833 11.1500000 0.259167 11.1527778 0.261667 11.1555556 0.260000 11.1583333 0.260000 11.1611111 0.260000 11.1638889 0.259167 11.1666667 0.263333 11.1694444 0.263333 11.1722222 0.264167 11.1750000 0.266667 11.1777778 0.266667 11.1805556 0.265000 11.1833333 0.265833 11.1861111 0.267500 11.1888889 0.265833 11.1916667 0.265000 11.1944444 0.264167 11.1972222 0.262500 11.2000000 0.262500 11.2027778 0.266667 11.2055556 0.266667 11.2083333 0.265000 11.2111111 0.262500 11.2138889 0.263333 11.2166667 0.267500 11.2194444 0.270000 11.2222222 0.270833 11.2250000 0.265833 11.2277778 0.259167 11.2305556 0.255833 11.2333333 0.254167 11.2361111 0.253333 11.2388889 0.252500 11.2416667 0.250000 11.2444444 0.248333 11.2472222 0.245833 11.2500000 0.246667 11.2527778 0.245833 11.2555556 0.248333 11.2583333 0.245833 11.2611111 0.245000 11.2638889 0.243333 11.2666667 0.244167 11.2694444 0.245000 11.2722222 0.245833 11.2750000 0.246667 11.2777778 0.243333 11.2805556 0.242500 11.2833333 0.243333 11.2861111 0.245000 11.2888889 0.244167 11.2916667 0.245000 11.2944444 0.243333 11.2972222 0.243333 11.3000000 0.244167 11.3027778 0.244167 11.3055556 0.245000 11.3083333 0.244167 11.3111111 0.242500 11.3138889 0.237500 11.3166667 0.234167 11.3194444 0.228333 11.3222222 0.226667 11.3250000 0.225000 11.3277778 0.225000 11.3305556 0.220833 11.3333333 0.220000 11.3361111 0.215000 11.3388889 0.208333 11.3416667 0.204167 11.3444444 0.209167 11.3472222 0.218333 11.3500000 0.237500 11.3527778 0.258333 11.3555556 0.280000 11.3583333 0.310000 11.3611111 0.347500 11.3638889 0.387500 11.3666667 0.423333 11.3694444 0.443333 11.3722222 0.448333 11.3750000 0.421667 11.3777778 0.370833 11.3805556 0.302500 11.3833333 0.252500 11.3861111 0.227500 11.3888889 0.225000 11.3916667 0.227500 11.3944444 0.235833 11.3972222 0.236667 11.4000000 0.238333 11.4027778 0.238333 11.4055556 0.238333 11.4083333 0.240000 11.4111111 0.240000 11.4138889 0.238333 11.4166667 0.235833 11.4194444 0.239167 11.4222222 0.240000 11.4250000 0.239167 11.4277778 0.239167 11.4305556 0.237500 11.4333333 0.235833 11.4361111 0.240000 11.4388889 0.239167 11.4416667 0.240833 11.4444444 0.237500 11.4472222 0.236667 11.4500000 0.237500 11.4527778 0.240833 11.4555556 0.240833 11.4583333 0.240000 11.4611111 0.239167 11.4638889 0.236667 11.4666667 0.238333 11.4694444 0.240833 11.4722222 0.241667 11.4750000 0.240833 11.4777778 0.239167 11.4805556 0.236667 11.4833333 0.239167 11.4861111 0.240833 11.4888889 0.240833 11.4916667 0.239167 11.4944444 0.235833 11.4972222 0.235000 11.5000000 0.237500 11.5027778 0.240833 11.5055556 0.239167 11.5083333 0.240000 11.5111111 0.240833 11.5138889 0.239167 11.5166667 0.239167 11.5194444 0.240833 11.5222222 0.242500 11.5250000 0.242500 11.5277778 0.239167 11.5305556 0.240000 11.5333333 0.237500 11.5361111 0.240833 11.5388889 0.240000 11.5416667 0.239167 11.5444444 0.239167 11.5472222 0.238333 11.5500000 0.240000 11.5527778 0.240833 11.5555556 0.240000 11.5583333 0.239167 11.5611111 0.235833 11.5638889 0.236667 11.5666667 0.239167 11.5694444 0.240833 11.5722222 0.244167 11.5750000 0.240000 11.5777778 0.240000 11.5805556 0.235833 11.5833333 0.236667 11.5861111 0.237500 11.5888889 0.240000 11.5916667 0.240000 11.5944444 0.239167 11.5972222 0.237500 11.6000000 0.239167 11.6027778 0.240833 11.6055556 0.240000 11.6083333 0.241667 11.6111111 0.240000 11.6138889 0.238333 11.6166667 0.238333 11.6194444 0.239167 11.6222222 0.238333 11.6250000 0.236667 11.6277778 0.235000 11.6305556 0.235833 11.6333333 0.236667 11.6361111 0.238333 11.6388889 0.238333 11.6416667 0.239167 11.6444444 0.239167 11.6472222 0.235000 11.6500000 0.237500 11.6527778 0.238333 11.6555556 0.240833 11.6583333 0.239167 11.6611111 0.240000 11.6638889 0.238333 11.6666667 0.241667 11.6724444 0.300000 11.9386667 0.300000 11.9416667 0.247500 11.9444444 0.244167 11.9472222 0.244167 11.9500000 0.245000 11.9527778 0.248333 11.9555556 0.248333 11.9583333 0.247500 11.9611111 0.245000 11.9638889 0.246667 11.9666667 0.247500 11.9694444 0.250000 11.9722222 0.252500 11.9750000 0.253333 11.9777778 0.255833 11.9805556 0.256667 11.9833333 0.255833 11.9861111 0.256667 11.9888889 0.257500 11.9916667 0.256667 11.9944444 0.258333 11.9972222 0.257500 12.0000000 0.260000 12.0027778 0.261667 12.0055556 0.265833 12.0083333 0.265000 12.0111111 0.262500 12.0138889 0.260833 12.0166667 0.262500 12.0194444 0.262500 12.0222222 0.261667 12.0250000 0.262500 12.0277778 0.260000 12.0305556 0.260000 12.0333333 0.261667 12.0361111 0.260833 12.0388889 0.258333 12.0416667 0.258333 12.0444444 0.257500 12.0472222 0.260833 12.0500000 0.263333 12.0527778 0.265833 12.0555556 0.264167 12.0583333 0.260000 12.0611111 0.255833 12.0638889 0.253333 12.0666667 0.253333 12.0694444 0.255000 12.0722222 0.255000 12.0750000 0.251667 12.0777778 0.246667 12.0805556 0.244167 12.0833333 0.243333 12.0861111 0.245000 12.0888889 0.245000 12.0916667 0.244167 12.0944444 0.241667 12.0972222 0.240000 12.1000000 0.241667 12.1027778 0.241667 12.1055556 0.242500 12.1083333 0.241667 12.1111111 0.240833 12.1138889 0.239167 12.1166667 0.240000 12.1194444 0.240833 12.1222222 0.241667 12.1250000 0.243333 12.1277778 0.240000 12.1305556 0.238333 12.1333333 0.238333 12.1361111 0.240833 12.1388889 0.242500 12.1416667 0.241667 12.1444444 0.238333 12.1472222 0.235833 12.1500000 0.231667 12.1527778 0.226667 12.1555556 0.223333 12.1583333 0.218333 12.1611111 0.210000 12.1638889 0.205833 12.1666667 0.208333 12.1694444 0.219167 12.1722222 0.239167 12.1750000 0.257500 12.1777778 0.279167 12.1805556 0.315000 12.1833333 0.360000 12.1861111 0.400000 12.1888889 0.425000 12.1916667 0.432500 12.1944444 0.416667 12.1972222 0.373333 12.2000000 0.315833 12.2027778 0.269167 12.2055556 0.238333 12.2083333 0.221667 12.2111111 0.218333 12.2138889 0.221667 12.2166667 0.226667 12.2194444 0.229167 12.2222222 0.231667 12.2250000 0.231667 12.2277778 0.231667 12.2305556 0.230000 12.2333333 0.233333 12.2361111 0.234167 12.2388889 0.232500 12.2416667 0.231667 12.2444444 0.232500 12.2472222 0.230000 12.2500000 0.234167 12.2527778 0.234167 12.2555556 0.235000 12.2583333 0.234167 12.2611111 0.234167 12.2638889 0.231667 12.2666667 0.233333 12.2694444 0.233333 12.2722222 0.231667 12.2750000 0.233333 12.2777778 0.232500 12.2805556 0.231667 12.2833333 0.231667 12.2861111 0.233333 12.2888889 0.235000 12.2916667 0.235000 12.2944444 0.233333 12.2972222 0.233333 12.3000000 0.234167 12.3027778 0.235000 12.3055556 0.235833 12.3083333 0.235000 12.3111111 0.231667 12.3138889 0.231667 12.3166667 0.231667 12.3194444 0.230833 12.3222222 0.231667 12.3250000 0.232500 12.3277778 0.230000 12.3305556 0.230000 12.3333333 0.230000 12.3361111 0.230833 12.3388889 0.231667 12.3416667 0.230833 12.3444444 0.229167 12.3472222 0.229167 12.3500000 0.230000 12.3527778 0.229167 12.3555556 0.230000 12.3583333 0.231667 12.3611111 0.231667 12.3638889 0.230833 12.3666667 0.231667 12.3694444 0.231667 12.3722222 0.233333 12.3750000 0.232500 12.3777778 0.232500 12.3805556 0.229167 12.3833333 0.230000 12.3861111 0.231667 12.3888889 0.233333 12.3916667 0.232500 12.3944444 0.230833 12.3972222 0.230000 12.4000000 0.231667 12.4027778 0.231667 12.4055556 0.233333 12.4083333 0.231667 12.4111111 0.230833 12.4138889 0.230000 12.4166667 0.231667 12.4194444 0.233333 12.4222222 0.235000 12.4250000 0.233333 12.4277778 0.230833 12.4305556 0.230000 12.4333333 0.230833 12.4361111 0.230833 12.4388889 0.233333 12.4416667 0.230833 12.4444444 0.228333 12.4472222 0.225000 12.4500000 0.226667 12.4527778 0.226667 12.4555556 0.227500 12.4583333 0.227500 12.4611111 0.226667 12.4638889 0.225000 12.4666667 0.227500 12.4694444 0.226667 12.4722222 0.228333 12.4750000 0.226667 12.4777778 0.225833 12.4805556 0.225833 12.4833333 0.226667 12.4861111 0.227500 12.4888889 0.230000 12.4946667 0.300000 12.7664444 0.300000 12.7694444 0.241667 12.7722222 0.244167 12.7750000 0.242500 12.7777778 0.241667 12.7805556 0.241667 12.7833333 0.240833 12.7861111 0.243333 12.7888889 0.244167 12.7916667 0.245000 12.7944444 0.243333 12.7972222 0.240833 12.8000000 0.240833 12.8027778 0.245000 12.8055556 0.247500 12.8083333 0.247500 12.8111111 0.247500 12.8138889 0.246667 12.8166667 0.250000 12.8194444 0.250000 12.8222222 0.253333 12.8250000 0.255833 12.8277778 0.253333 12.8305556 0.252500 12.8333333 0.255833 12.8361111 0.260833 12.8388889 0.261667 12.8416667 0.261667 12.8444444 0.259167 12.8472222 0.257500 12.8500000 0.258333 12.8527778 0.259167 12.8555556 0.258333 12.8583333 0.257500 12.8611111 0.255833 12.8638889 0.255000 12.8666667 0.251667 12.8694444 0.253333 12.8722222 0.254167 12.8750000 0.256667 12.8777778 0.257500 12.8805556 0.256667 12.8833333 0.254167 12.8861111 0.250833 12.8888889 0.250000 12.8916667 0.249167 12.8944444 0.244167 12.8972222 0.240833 12.9000000 0.241667 12.9027778 0.241667 12.9055556 0.241667 12.9083333 0.240833 12.9111111 0.238333 12.9138889 0.238333 12.9166667 0.240000 12.9194444 0.239167 12.9222222 0.240833 12.9250000 0.239167 12.9277778 0.237500 12.9305556 0.235833 12.9333333 0.236667 12.9361111 0.237500 12.9388889 0.240833 12.9416667 0.238333 12.9444444 0.235833 12.9472222 0.235000 12.9500000 0.235000 12.9527778 0.238333 12.9555556 0.240000 12.9583333 0.238333 12.9611111 0.236667 12.9638889 0.235833 12.9666667 0.236667 12.9694444 0.237500 12.9722222 0.238333 12.9750000 0.236667 12.9777778 0.232500 12.9805556 0.225833 12.9833333 0.222500 12.9861111 0.220000 12.9888889 0.219167 12.9916667 0.212500 12.9944444 0.207500 12.9972222 0.210833 13.0000000 0.225000 13.0027778 0.245833 13.0055556 0.269167 13.0083333 0.295833 13.0111111 0.330833 13.0138889 0.371667 13.0166667 0.410000 13.0194444 0.435833 13.0222222 0.441667 13.0250000 0.425000 13.0277778 0.380833 13.0305556 0.318333 13.0333333 0.265000 13.0361111 0.235000 13.0388889 0.223333 13.0416667 0.219167 13.0444444 0.221667 13.0472222 0.225000 13.0500000 0.229167 13.0527778 0.230833 13.0555556 0.232500 13.0583333 0.230833 13.0611111 0.230833 13.0638889 0.230000 13.0666667 0.233333 13.0694444 0.234167 13.0722222 0.235833 13.0750000 0.234167 13.0777778 0.233333 13.0805556 0.230000 13.0833333 0.231667 13.0861111 0.233333 13.0888889 0.233333 13.0916667 0.232500 13.0944444 0.232500 13.0972222 0.227500 13.1000000 0.230000 13.1027778 0.231667 13.1055556 0.232500 13.1083333 0.230833 13.1111111 0.228333 13.1138889 0.226667 13.1166667 0.227500 13.1194444 0.230833 13.1222222 0.230000 13.1250000 0.228333 13.1277778 0.230833 13.1305556 0.228333 13.1333333 0.229167 13.1361111 0.230000 13.1388889 0.230000 13.1416667 0.230833 13.1444444 0.229167 13.1472222 0.229167 13.1500000 0.230000 13.1527778 0.231667 13.1555556 0.231667 13.1583333 0.231667 13.1611111 0.230000 13.1638889 0.228333 13.1666667 0.230000 13.1694444 0.230833 13.1722222 0.234167 13.1750000 0.232500 13.1777778 0.230833 13.1805556 0.228333 13.1833333 0.230000 13.1861111 0.230000 13.1888889 0.230833 13.1916667 0.230000 13.1944444 0.229167 13.1972222 0.226667 13.2000000 0.228333 13.2027778 0.229167 13.2055556 0.230833 13.2083333 0.230000 13.2111111 0.229167 13.2138889 0.226667 13.2166667 0.228333 13.2194444 0.228333 13.2222222 0.229167 13.2250000 0.230000 13.2277778 0.230833 13.2305556 0.229167 13.2333333 0.228333 13.2361111 0.229167 13.2388889 0.230833 13.2416667 0.232500 13.2444444 0.232500 13.2472222 0.229167 13.2500000 0.230833 13.2527778 0.230000 13.2555556 0.230000 13.2583333 0.230000 13.2611111 0.227500 13.2638889 0.227500 13.2666667 0.226667 13.2694444 0.230000 13.2722222 0.228333 13.2750000 0.225000 13.2777778 0.224167 13.2805556 0.222500 13.2833333 0.222500 13.2861111 0.222500 13.2888889 0.222500 13.2916667 0.222500 13.2944444 0.221667 13.2972222 0.218333 13.3000000 0.219167 13.3027778 0.223333 13.3055556 0.224167 13.3083333 0.223333 13.3111111 0.224167 13.3138889 0.224167 13.3166667 0.226667 13.3224444 0.300000 13.5886667 0.300000 13.5916667 0.244167 13.5944444 0.240833 13.5972222 0.242500 13.6000000 0.243333 13.6027778 0.245000 13.6055556 0.243333 13.6083333 0.242500 13.6111111 0.241667 13.6138889 0.240833 13.6166667 0.241667 13.6194444 0.244167 13.6222222 0.245000 13.6250000 0.245000 13.6277778 0.245000 13.6305556 0.245000 13.6333333 0.249167 13.6361111 0.252500 13.6388889 0.254167 13.6416667 0.253333 13.6444444 0.252500 13.6472222 0.251667 13.6500000 0.254167 13.6527778 0.256667 13.6555556 0.259167 13.6583333 0.260000 13.6611111 0.260000 13.6638889 0.260000 13.6666667 0.260833 13.6694444 0.262500 13.6722222 0.263333 13.6750000 0.261667 13.6777778 0.260000 13.6805556 0.257500 13.6833333 0.257500 13.6861111 0.260000 13.6888889 0.260000 13.6916667 0.258333 13.6944444 0.255000 13.6972222 0.255000 13.7000000 0.260000 13.7027778 0.261667 13.7055556 0.262500 13.7083333 0.255833 13.7111111 0.250833 13.7138889 0.249167 13.7166667 0.245833 13.7194444 0.247500 13.7222222 0.245833 13.7250000 0.245000 13.7277778 0.242500 13.7305556 0.240000 13.7333333 0.239167 13.7361111 0.240833 13.7388889 0.242500 13.7416667 0.243333 13.7444444 0.244167 13.7472222 0.240000 13.7500000 0.240833 13.7527778 0.242500 13.7555556 0.244167 13.7583333 0.240833 13.7611111 0.241667 13.7638889 0.237500 13.7666667 0.237500 13.7694444 0.239167 13.7722222 0.239167 13.7750000 0.241667 13.7777778 0.238333 13.7805556 0.236667 13.7833333 0.239167 13.7861111 0.238333 13.7888889 0.240833 13.7916667 0.238333 13.7944444 0.236667 13.7972222 0.235833 13.8000000 0.235833 13.8027778 0.233333 13.8055556 0.228333 13.8083333 0.222500 13.8111111 0.219167 13.8138889 0.213333 13.8166667 0.207500 13.8194444 0.212500 13.8222222 0.227500 13.8250000 0.249167 13.8277778 0.274167 13.8305556 0.301667 13.8333333 0.343333 13.8361111 0.389167 13.8388889 0.426667 13.8416667 0.448333 13.8444444 0.450833 13.8472222 0.417500 13.8500000 0.360000 13.8527778 0.295000 13.8555556 0.246667 13.8583333 0.224167 13.8611111 0.220833 13.8638889 0.226667 13.8666667 0.234167 13.8694444 0.236667 13.8722222 0.236667 13.8750000 0.235833 13.8777778 0.234167 13.8805556 0.233333 13.8833333 0.232500 13.8861111 0.234167 13.8888889 0.231667 13.8916667 0.235000 13.8944444 0.234167 13.8972222 0.232500 13.9000000 0.232500 13.9027778 0.234167 13.9055556 0.235833 13.9083333 0.235833 13.9111111 0.232500 13.9138889 0.232500 13.9166667 0.233333 13.9194444 0.235833 13.9222222 0.236667 13.9250000 0.235833 13.9277778 0.232500 13.9305556 0.231667 13.9333333 0.233333 13.9361111 0.234167 13.9388889 0.235833 13.9416667 0.234167 13.9444444 0.231667 13.9472222 0.232500 13.9500000 0.232500 13.9527778 0.234167 13.9555556 0.235000 13.9583333 0.234167 13.9611111 0.234167 13.9638889 0.232500 13.9666667 0.231667 13.9694444 0.233333 13.9722222 0.235833 13.9750000 0.234167 13.9777778 0.233333 13.9805556 0.234167 13.9833333 0.235833 13.9861111 0.235833 13.9888889 0.237500 13.9916667 0.237500 13.9944444 0.236667 13.9972222 0.234167 14.0000000 0.235833 14.0027778 0.235000 14.0055556 0.235833 14.0083333 0.236667 14.0111111 0.235000 14.0138889 0.233333 14.0166667 0.233333 14.0194444 0.235000 14.0222222 0.239167 14.0250000 0.237500 14.0277778 0.235833 14.0305556 0.233333 14.0333333 0.233333 14.0361111 0.235000 14.0388889 0.236667 14.0416667 0.237500 14.0444444 0.235833 14.0472222 0.234167 14.0500000 0.236667 14.0527778 0.238333 14.0555556 0.239167 14.0583333 0.239167 14.0611111 0.237500 14.0638889 0.235833 14.0666667 0.237500 14.0694444 0.237500 14.0722222 0.239167 14.0750000 0.238333 14.0777778 0.237500 14.0805556 0.233333 14.0833333 0.234167 14.0861111 0.232500 14.0888889 0.238333 14.0916667 0.235833 14.0944444 0.233333 14.0972222 0.231667 14.1000000 0.233333 14.1027778 0.234167 14.1055556 0.237500 14.1083333 0.236667 14.1111111 0.235833 14.1138889 0.232500 14.1166667 0.235833 14.1194444 0.237500 14.1222222 0.238333 14.1250000 0.239167 14.1277778 0.239167 14.1305556 0.241667 14.1333333 0.240833 14.1361111 0.246667 14.1388889 0.248333 14.1446667 0.300000 14.3416667 0.300000)
Vrpk rpk 0 PWL(0.0000000 0.000000 0.8134889 0.000000 0.8138889 0.900000 0.8143889 0.900000 0.8147889 0.000000 1.6246000 0.000000 1.6250000 0.900000 1.6255000 0.900000 1.6259000 0.000000 2.4134889 0.000000 2.4138889 0.900000 2.4143889 0.900000 2.4147889 0.000000 3.2051556 0.000000 3.2055556 0.900000 3.2060556 0.900000 3.2064556 0.000000 3.9940444 0.000000 3.9944444 0.900000 3.9949444 0.900000 3.9953444 0.000000 4.8107111 0.000000 4.8111111 0.900000 4.8116111 0.900000 4.8120111 0.000000 5.4634889 0.000000 5.4638889 0.900000 5.4643889 0.900000 5.4647889 0.000000 6.4579333 0.000000 6.4583333 0.900000 6.4588333 0.900000 6.4592333 0.000000 7.3023778 0.000000 7.3027778 0.900000 7.3032778 0.900000 7.3036778 0.000000 8.1134889 0.000000 8.1138889 0.900000 8.1143889 0.900000 8.1147889 0.000000 8.9023778 0.000000 8.9027778 0.900000 8.9032778 0.900000 8.9036778 0.000000 9.6746000 0.000000 9.6750000 0.900000 9.6755000 0.900000 9.6759000 0.000000 10.5134889 0.000000 10.5138889 0.900000 10.5143889 0.900000 10.5147889 0.000000 11.3690444 0.000000 11.3694444 0.900000 11.3699444 0.900000 11.3703444 0.000000 12.1912667 0.000000 12.1916667 0.900000 12.1921667 0.900000 12.1925667 0.000000 13.0190444 0.000000 13.0194444 0.900000 13.0199444 0.900000 13.0203444 0.000000 13.8412667 0.000000 13.8416667 0.900000 13.8421667 0.900000 13.8425667 0.000000 14.3416667 0.000000)

.include "C:/Users/kadhi/OneDrive/Desktop/amux/verilogLearning/Leaky-Integrate-Fire---SNN-model-on-FPGA/experiments/frontend_optimization/complete_frontend_v9b/inverter.spice"
.include "C:/Users/kadhi/OneDrive/Desktop/amux/verilogLearning/Leaky-Integrate-Fire---SNN-model-on-FPGA/experiments/frontend_optimization/complete_frontend_v9b/delay_timer.spice"
.include "C:/Users/kadhi/OneDrive/Desktop/amux/verilogLearning/Leaky-Integrate-Fire---SNN-model-on-FPGA/experiments/frontend_optimization/complete_frontend_v9b/edge_buffer.spice"
.include "C:/Users/kadhi/OneDrive/Desktop/amux/verilogLearning/Leaky-Integrate-Fire---SNN-model-on-FPGA/experiments/frontend_optimization/complete_frontend_v9b/pulse_gen.spice"
.include "C:/Users/kadhi/OneDrive/Desktop/amux/verilogLearning/Leaky-Integrate-Fire---SNN-model-on-FPGA/experiments/frontend_optimization/complete_frontend_v9b/rr_timing.spice"
.include "C:/Users/kadhi/OneDrive/Desktop/amux/verilogLearning/Leaky-Integrate-Fire---SNN-model-on-FPGA/experiments/frontend_optimization/complete_frontend_v9b/pwave_predictor.spice"

* === RR TIMING ===
* Ports: ecg_unused capture_trig rpeak_trigger copy_trig
*        rr_ratio_out rr_asym_out timer_out ewma_out vdd vss vbias
Xrr ecg_l0 rr_cap_pulse rpk rr_copy_pulse f1_out f2_out rr_timer rr_ewma vdd vss vbias rr_timing

* === PWAVE PREDICTOR ===
* Ports: timer_node ewma_node pw_base_trig pw_peak_trig rr_cap_trig
*        vth_base vth_peak vdd vss vbias
* Dynamic thresholds from EWMA
Bvth_base vth_base 0 V = V(rr_ewma) + 0.095
Bvth_peak vth_peak 0 V = V(rr_ewma) + 0.061

Xpw rr_timer rr_ewma pw_base_level pw_peak_level rr_cap_level vth_base vth_peak vdd vss vbias pwave_predictor

* Edge buffers + pulse generators for pwave triggers
Xeb_base pw_base_level pw_base_sharp vdd vss edge_buffer
Xpg_base pw_base_sharp pw_base_pulse vdd vss vbias pulse_gen
Xeb_peak pw_peak_level pw_peak_sharp vdd vss edge_buffer
Xpg_peak pw_peak_sharp pw_peak_pulse vdd vss vbias pulse_gen
Xeb_cap  rr_cap_level  rr_cap_sharp  vdd vss edge_buffer
Xpg_cap  rr_cap_sharp  rr_cap_pulse  vdd vss vbias pulse_gen

* === DELAY TIMER (for rr_copy trigger) ===
* Minimal — we just need the rr_copy trigger at R+10ms
Vth14  vth14  0 0.1
Vth69  vth69  0 0.1
Vth83  vth83  0 0.1
Vth300 vth300 0 0.1
Vth10  vth10  0 0.347980
Vth_rpk vth_rpk 0 0.1

Xdt rpk dt_s14 dt_s69 dt_wid dt_bi dt_rr dt_rpk sf_dt vdd vss vbias vth14 vth69 vth83 vth300 vth10 vth_rpk delay_timer

* RR copy pulse generator
Xeb_rr dt_rr rr_sharp vdd vss edge_buffer
Xpg_rr rr_sharp rr_copy_pulse vdd vss vbias pulse_gen

.tran 0.5m 14.3417

.meas tran tpwb_3 WHEN V(pw_base_pulse)=0.45 RISE=1 TD=2.8055556
.meas tran tpwp_3 WHEN V(pw_peak_pulse)=0.45 RISE=1 TD=2.8055556
.meas tran tcap_3 WHEN V(rr_cap_pulse)=0.45 RISE=1 TD=2.8055556
.meas tran ewma_3 FIND V(rr_ewma) AT=3.2055556
.meas tran timer_3 FIND V(rr_timer) AT=3.2055556
.meas tran tpwb_4 WHEN V(pw_base_pulse)=0.45 RISE=1 TD=3.5944444
.meas tran tpwp_4 WHEN V(pw_peak_pulse)=0.45 RISE=1 TD=3.5944444
.meas tran tcap_4 WHEN V(rr_cap_pulse)=0.45 RISE=1 TD=3.5944444
.meas tran ewma_4 FIND V(rr_ewma) AT=3.9944444
.meas tran timer_4 FIND V(rr_timer) AT=3.9944444
.meas tran tpwb_5 WHEN V(pw_base_pulse)=0.45 RISE=1 TD=4.4111111
.meas tran tpwp_5 WHEN V(pw_peak_pulse)=0.45 RISE=1 TD=4.4111111
.meas tran tcap_5 WHEN V(rr_cap_pulse)=0.45 RISE=1 TD=4.4111111
.meas tran ewma_5 FIND V(rr_ewma) AT=4.8111111
.meas tran timer_5 FIND V(rr_timer) AT=4.8111111
.meas tran tpwb_6 WHEN V(pw_base_pulse)=0.45 RISE=1 TD=5.0638889
.meas tran tpwp_6 WHEN V(pw_peak_pulse)=0.45 RISE=1 TD=5.0638889
.meas tran tcap_6 WHEN V(rr_cap_pulse)=0.45 RISE=1 TD=5.0638889
.meas tran ewma_6 FIND V(rr_ewma) AT=5.4638889
.meas tran timer_6 FIND V(rr_timer) AT=5.4638889
.meas tran tpwb_7 WHEN V(pw_base_pulse)=0.45 RISE=1 TD=6.0583333
.meas tran tpwp_7 WHEN V(pw_peak_pulse)=0.45 RISE=1 TD=6.0583333
.meas tran tcap_7 WHEN V(rr_cap_pulse)=0.45 RISE=1 TD=6.0583333
.meas tran ewma_7 FIND V(rr_ewma) AT=6.4583333
.meas tran timer_7 FIND V(rr_timer) AT=6.4583333
.meas tran tpwb_8 WHEN V(pw_base_pulse)=0.45 RISE=1 TD=6.9027778
.meas tran tpwp_8 WHEN V(pw_peak_pulse)=0.45 RISE=1 TD=6.9027778
.meas tran tcap_8 WHEN V(rr_cap_pulse)=0.45 RISE=1 TD=6.9027778
.meas tran ewma_8 FIND V(rr_ewma) AT=7.3027778
.meas tran timer_8 FIND V(rr_timer) AT=7.3027778
.meas tran tpwb_9 WHEN V(pw_base_pulse)=0.45 RISE=1 TD=7.7138889
.meas tran tpwp_9 WHEN V(pw_peak_pulse)=0.45 RISE=1 TD=7.7138889
.meas tran tcap_9 WHEN V(rr_cap_pulse)=0.45 RISE=1 TD=7.7138889
.meas tran ewma_9 FIND V(rr_ewma) AT=8.1138889
.meas tran timer_9 FIND V(rr_timer) AT=8.1138889
.meas tran tpwb_10 WHEN V(pw_base_pulse)=0.45 RISE=1 TD=8.5027778
.meas tran tpwp_10 WHEN V(pw_peak_pulse)=0.45 RISE=1 TD=8.5027778
.meas tran tcap_10 WHEN V(rr_cap_pulse)=0.45 RISE=1 TD=8.5027778
.meas tran ewma_10 FIND V(rr_ewma) AT=8.9027778
.meas tran timer_10 FIND V(rr_timer) AT=8.9027778
.meas tran tpwb_11 WHEN V(pw_base_pulse)=0.45 RISE=1 TD=9.2750000
.meas tran tpwp_11 WHEN V(pw_peak_pulse)=0.45 RISE=1 TD=9.2750000
.meas tran tcap_11 WHEN V(rr_cap_pulse)=0.45 RISE=1 TD=9.2750000
.meas tran ewma_11 FIND V(rr_ewma) AT=9.6750000
.meas tran timer_11 FIND V(rr_timer) AT=9.6750000
.meas tran tpwb_12 WHEN V(pw_base_pulse)=0.45 RISE=1 TD=10.1138889
.meas tran tpwp_12 WHEN V(pw_peak_pulse)=0.45 RISE=1 TD=10.1138889
.meas tran tcap_12 WHEN V(rr_cap_pulse)=0.45 RISE=1 TD=10.1138889
.meas tran ewma_12 FIND V(rr_ewma) AT=10.5138889
.meas tran timer_12 FIND V(rr_timer) AT=10.5138889
.meas tran tpwb_13 WHEN V(pw_base_pulse)=0.45 RISE=1 TD=10.9694444
.meas tran tpwp_13 WHEN V(pw_peak_pulse)=0.45 RISE=1 TD=10.9694444
.meas tran tcap_13 WHEN V(rr_cap_pulse)=0.45 RISE=1 TD=10.9694444
.meas tran ewma_13 FIND V(rr_ewma) AT=11.3694444
.meas tran timer_13 FIND V(rr_timer) AT=11.3694444
.meas tran tpwb_14 WHEN V(pw_base_pulse)=0.45 RISE=1 TD=11.7916667
.meas tran tpwp_14 WHEN V(pw_peak_pulse)=0.45 RISE=1 TD=11.7916667
.meas tran tcap_14 WHEN V(rr_cap_pulse)=0.45 RISE=1 TD=11.7916667
.meas tran ewma_14 FIND V(rr_ewma) AT=12.1916667
.meas tran timer_14 FIND V(rr_timer) AT=12.1916667
.meas tran tpwb_15 WHEN V(pw_base_pulse)=0.45 RISE=1 TD=12.6194444
.meas tran tpwp_15 WHEN V(pw_peak_pulse)=0.45 RISE=1 TD=12.6194444
.meas tran tcap_15 WHEN V(rr_cap_pulse)=0.45 RISE=1 TD=12.6194444
.meas tran ewma_15 FIND V(rr_ewma) AT=13.0194444
.meas tran timer_15 FIND V(rr_timer) AT=13.0194444
.meas tran tpwb_16 WHEN V(pw_base_pulse)=0.45 RISE=1 TD=13.4416667
.meas tran tpwp_16 WHEN V(pw_peak_pulse)=0.45 RISE=1 TD=13.4416667
.meas tran tcap_16 WHEN V(rr_cap_pulse)=0.45 RISE=1 TD=13.4416667
.meas tran ewma_16 FIND V(rr_ewma) AT=13.8416667
.meas tran timer_16 FIND V(rr_timer) AT=13.8416667

.end
