* DIAGNOSTIC: Feature node waveforms
.title diag_features
.lib "sky130_minimal.lib.spice" tt
.option scale=1.0u method=gear gmin=1e-15 abstol=1e-15 reltol=0.005
.temp 27

.include "ota_5t_subthreshold.spice"
.include "inverter.spice"
.include "resistor_div.spice"
.include "otac_lpf.spice"
.include "otac_hpf.spice"
.include "otac_bpf.spice"
.include "rectifier.spice"
.include "comparator.spice"
.include "rr_timing.spice"
.include "beat_instability.spice"
.include "pwave_energy.spice"
.include "qrs_width.spice"
.include "slope_ratio.spice"
.include "qrs_symmetry.spice"
.include "sh_channel.spice"
.include "sh_bank.spice"

Vdd vdd 0 0.9
Vss vss 0 0
Xvref_gen vdd vss vref resistor_div
Vbias_src vbias 0 0.35

Vecg0 ecg_raw_L0 0 PWL(
+ 0.000000e+00 1.877690e-01
+ 1.111111e-02 1.977658e-01
+ 2.222222e-02 1.852698e-01
+ 3.333333e-02 1.852698e-01
+ 4.444444e-02 1.902682e-01
+ 5.555556e-02 1.877690e-01
+ 6.666667e-02 1.852698e-01
+ 7.777778e-02 1.977658e-01
+ 8.888889e-02 2.002650e-01
+ 1.000000e-01 2.202586e-01
+ 1.111111e-01 2.352539e-01
+ 1.222222e-01 2.427515e-01
+ 1.333333e-01 2.377531e-01
+ 1.444444e-01 2.427515e-01
+ 1.555556e-01 2.327547e-01
+ 1.666667e-01 2.227579e-01
+ 1.777778e-01 1.977658e-01
+ 1.888889e-01 1.902682e-01
+ 2.000000e-01 1.802713e-01
+ 2.111111e-01 1.902682e-01
+ 2.222222e-01 1.777721e-01
+ 2.333333e-01 1.777721e-01
+ 2.444444e-01 1.802713e-01
+ 2.555556e-01 1.677753e-01
+ 2.666667e-01 1.102936e-01
+ 2.777778e-01 9.779752e-02
+ 2.888889e-01 3.827071e-01
+ 3.000000e-01 8.225674e-01
+ 3.111111e-01 3.602142e-01
+ 3.222222e-01 1.377848e-01
+ 3.333333e-01 1.652761e-01
+ 3.444444e-01 1.652761e-01
+ 3.555556e-01 1.577785e-01
+ 3.666667e-01 1.577785e-01
+ 3.777778e-01 1.552793e-01
+ 3.888889e-01 1.502809e-01
+ 4.000000e-01 1.527801e-01
+ 4.111111e-01 1.552793e-01
+ 4.222222e-01 1.552793e-01
+ 4.333333e-01 1.602777e-01
+ 4.444444e-01 1.652761e-01
+ 4.555556e-01 1.652761e-01
+ 4.666667e-01 1.602777e-01
+ 4.777778e-01 1.627769e-01
+ 4.888889e-01 1.552793e-01
+ 5.000000e-01 1.577785e-01
+ 5.111111e-01 1.652761e-01
+ 5.222222e-01 1.677753e-01
+ 5.333333e-01 1.602777e-01
+ 5.444444e-01 1.627769e-01
+ 5.555556e-01 1.552793e-01
+ 5.666667e-01 1.577785e-01
+ 5.777778e-01 1.627769e-01
+ 5.888889e-01 1.627769e-01
+ 6.000000e-01 1.577785e-01
+ 6.111111e-01 1.777721e-01
+ 6.222222e-01 1.927674e-01
+ 6.333333e-01 2.077626e-01
+ 6.444444e-01 2.102618e-01
+ 6.555556e-01 2.052634e-01
+ 6.666667e-01 2.077626e-01
+ 6.777778e-01 2.102618e-01
+ 6.888889e-01 2.027642e-01
+ 7.000000e-01 2.077626e-01
+ 7.111111e-01 2.127610e-01
+ 7.222222e-01 1.977658e-01
+ 7.333333e-01 2.127610e-01
+ 7.444444e-01 2.177594e-01
+ 7.555556e-01 2.177594e-01
+ 7.666667e-01 2.252571e-01
+ 7.777778e-01 2.402523e-01
+ 7.888889e-01 2.477499e-01
+ 8.000000e-01 2.302555e-01
+ 8.111111e-01 2.152602e-01
+ 8.222222e-01 1.902682e-01
+ 8.333333e-01 1.777721e-01
+ 8.444444e-01 1.752729e-01
+ 8.555556e-01 1.627769e-01
+ 8.666667e-01 1.652761e-01
+ 8.777778e-01 1.727737e-01
+ 8.888889e-01 1.752729e-01
+ 9.000000e-01 1.752729e-01
+ 9.111111e-01 1.502809e-01
+ 9.222222e-01 9.029990e-02
+ 9.333333e-01 1.277880e-01
+ 9.444444e-01 4.801761e-01
+ 9.555556e-01 7.875785e-01
+ 9.666667e-01 1.827705e-01
+ 9.777778e-01 1.627769e-01
+ 9.888889e-01 1.602777e-01
+ 1.000000e+00 1.527801e-01
+ 1.011111e+00 1.577785e-01
+ 1.022222e+00 1.477817e-01
+ 1.033333e+00 1.527801e-01
+ 1.044444e+00 1.552793e-01
+ 1.055556e+00 1.477817e-01
+ 1.066667e+00 1.552793e-01
+ 1.077778e+00 1.627769e-01
+ 1.088889e+00 1.552793e-01
+ 1.100000e+00 1.452825e-01
+ 1.111111e+00 1.577785e-01
+ 1.122222e+00 1.527801e-01
+ 1.133333e+00 1.527801e-01
+ 1.144444e+00 1.627769e-01
+ 1.155556e+00 1.502809e-01
+ 1.166667e+00 1.552793e-01
+ 1.177778e+00 1.602777e-01
+ 1.188889e+00 1.502809e-01
+ 1.200000e+00 1.577785e-01
+ 1.211111e+00 1.552793e-01
+ 1.222222e+00 1.402840e-01
+ 1.233333e+00 1.477817e-01
+ 1.244444e+00 1.602777e-01
+ 1.255556e+00 1.552793e-01
+ 1.266667e+00 1.577785e-01
+ 1.277778e+00 1.802713e-01
+ 1.288889e+00 1.827705e-01
+ 1.300000e+00 1.977658e-01
+ 1.311111e+00 1.977658e-01
+ 1.322222e+00 1.777721e-01
+ 1.333333e+00 1.977658e-01
+ 1.344444e+00 1.977658e-01
+ 1.355556e+00 1.877690e-01
+ 1.366667e+00 1.877690e-01
+ 1.377778e+00 1.927674e-01
+ 1.388889e+00 1.827705e-01
+ 1.400000e+00 1.677753e-01
+ 1.411111e+00 1.802713e-01
+ 1.422222e+00 1.702745e-01
+ 1.433333e+00 1.677753e-01
+ 1.444444e+00 1.802713e-01
+ 1.455556e+00 1.752729e-01
+ 1.466667e+00 1.752729e-01
+ 1.477778e+00 1.727737e-01
+ 1.488889e+00 1.727737e-01
+ 1.500000e+00 1.702745e-01
+ 1.511111e+00 1.702745e-01
+ 1.522222e+00 1.627769e-01
+ 1.533333e+00 1.777721e-01
+ 1.544444e+00 1.752729e-01
+ 1.555556e+00 1.677753e-01
+ 1.566667e+00 1.627769e-01
+ 1.577778e+00 1.652761e-01
+ 1.588889e+00 1.677753e-01
+ 1.600000e+00 1.677753e-01
+ 1.611111e+00 1.802713e-01
+ 1.622222e+00 1.777721e-01
+ 1.633333e+00 1.702745e-01
+ 1.644444e+00 1.727737e-01
+ 1.655556e+00 1.652761e-01
+ 1.666667e+00 1.677753e-01
+ 1.677778e+00 1.702745e-01
+ 1.688889e+00 1.752729e-01
+ 1.700000e+00 1.727737e-01
+ 1.711111e+00 1.777721e-01
+ 1.722222e+00 1.727737e-01
+ 1.733333e+00 1.852698e-01
+ 1.744444e+00 2.002650e-01
+ 1.755556e+00 2.077626e-01
+ 1.766667e+00 2.227579e-01
+ 1.777778e+00 2.227579e-01
+ 1.788889e+00 2.102618e-01
+ 1.800000e+00 2.052634e-01
+ 1.811111e+00 2.152602e-01
+ 1.822222e+00 2.002650e-01
+ 1.833333e+00 1.752729e-01
+ 1.844444e+00 1.677753e-01
+ 1.855556e+00 1.602777e-01
+ 1.866667e+00 1.502809e-01
+ 1.877778e+00 1.577785e-01
+ 1.888889e+00 1.477817e-01
+ 1.900000e+00 1.452825e-01
+ 1.911111e+00 1.052951e-01
+ 1.922222e+00 6.280863e-02
+ 1.933333e+00 2.552475e-01
+ 1.944444e+00 7.076039e-01
+ 1.955556e+00 6.301285e-01
+ 1.966667e+00 1.377848e-01
+ 1.977778e+00 1.002967e-01
+ 1.988889e+00 1.327864e-01
+ 2.000000e+00 1.427832e-01
+ 2.011111e+00 1.352856e-01
+ 2.022222e+00 1.252888e-01
+ 2.033333e+00 1.277880e-01
+ 2.044444e+00 1.352856e-01
+ 2.055556e+00 1.277880e-01
+ 2.066667e+00 1.277880e-01
+ 2.077778e+00 1.377848e-01
+ 2.088889e+00 1.402840e-01
+ 2.100000e+00 1.302872e-01
+ 2.111111e+00 1.427832e-01
+ 2.122222e+00 1.277880e-01
+ 2.133333e+00 1.302872e-01
+ 2.144444e+00 1.427832e-01
+ 2.155556e+00 1.402840e-01
+ 2.166667e+00 1.427832e-01
+ 2.177778e+00 1.477817e-01
+ 2.188889e+00 1.427832e-01
+ 2.200000e+00 1.277880e-01
+ 2.211111e+00 1.227896e-01
+ 2.222222e+00 1.027959e-01
+ 2.233333e+00 1.027959e-01
+ 2.244444e+00 1.052951e-01
+ 2.255556e+00 1.052951e-01
+ 2.266667e+00 1.152920e-01
+ 2.277778e+00 1.377848e-01
+ 2.288889e+00 1.552793e-01
+ 2.300000e+00 1.727737e-01
+ 2.311111e+00 1.877690e-01
+ 2.322222e+00 1.977658e-01
+ 2.333333e+00 1.952666e-01
+ 2.344444e+00 1.927674e-01
+ 2.355556e+00 1.877690e-01
+ 2.366667e+00 1.877690e-01
+ 2.377778e+00 1.927674e-01
+ 2.388889e+00 1.852698e-01
+ 2.400000e+00 1.827705e-01
+ 2.411111e+00 1.902682e-01
+ 2.422222e+00 1.777721e-01
+ 2.433333e+00 1.727737e-01
+ 2.444444e+00 1.827705e-01
+ 2.455556e+00 1.802713e-01
+ 2.466667e+00 1.777721e-01
+ 2.477778e+00 1.827705e-01
+ 2.488889e+00 1.777721e-01
+ 2.500000e+00 1.702745e-01
+ 2.511111e+00 1.777721e-01
+ 2.522222e+00 1.702745e-01
+ 2.533333e+00 1.702745e-01
+ 2.544444e+00 1.802713e-01
+ 2.555556e+00 1.727737e-01
+ 2.566667e+00 1.677753e-01
+ 2.577778e+00 1.902682e-01
+ 2.588889e+00 2.027642e-01
+ 2.600000e+00 2.202586e-01
+ 2.611111e+00 2.252571e-01
+ 2.622222e+00 2.202586e-01
+ 2.633333e+00 2.102618e-01
+ 2.644444e+00 2.102618e-01
+ 2.655556e+00 2.202586e-01
+ 2.666667e+00 1.902682e-01
+ 2.677778e+00 1.727737e-01
+ 2.688889e+00 1.602777e-01
+ 2.700000e+00 1.677753e-01
+ 2.711111e+00 1.702745e-01
+ 2.722222e+00 1.577785e-01
+ 2.733333e+00 1.577785e-01
+ 2.744444e+00 1.602777e-01
+ 2.755556e+00 1.002967e-01
+ 2.766667e+00 5.781022e-02
+ 2.777778e+00 2.977341e-01
+ 2.788889e+00 7.550889e-01
+ 2.800000e+00 4.426880e-01
+ 2.811111e+00 1.027959e-01
+ 2.822222e+00 1.427832e-01
+ 2.833333e+00 1.477817e-01
+ 2.844444e+00 1.427832e-01
+ 2.855556e+00 1.402840e-01
+ 2.866667e+00 1.452825e-01
+ 2.877778e+00 1.577785e-01
+ 2.888889e+00 1.502809e-01
+ 2.900000e+00 1.502809e-01
+ 2.911111e+00 1.502809e-01
+ 2.922222e+00 1.427832e-01
+ 2.933333e+00 1.477817e-01
+ 2.944444e+00 1.452825e-01
+ 2.955556e+00 1.477817e-01
+ 2.966667e+00 1.477817e-01
+ 2.977778e+00 1.527801e-01
+ 2.988889e+00 1.427832e-01
+ 3.000000e+00 1.427832e-01
+ 3.011111e+00 1.502809e-01
+ 3.022222e+00 1.427832e-01
+ 3.033333e+00 1.402840e-01
+ 3.044444e+00 1.452825e-01
+ 3.055556e+00 1.377848e-01
+ 3.066667e+00 1.402840e-01
+ 3.077778e+00 1.477817e-01
+ 3.088889e+00 1.577785e-01
+ 3.100000e+00 1.752729e-01
+ 3.111111e+00 1.977658e-01
+ 3.122222e+00 1.977658e-01
+ 3.133333e+00 2.027642e-01
+ 3.144444e+00 2.152602e-01
+ 3.155556e+00 2.102618e-01
+ 3.166667e+00 2.027642e-01
+ 3.177778e+00 2.077626e-01
+ 3.188889e+00 2.027642e-01
+ 3.200000e+00 1.977658e-01
+ 3.211111e+00 1.977658e-01
+ 3.222222e+00 1.902682e-01
+ 3.233333e+00 1.902682e-01
+ 3.244444e+00 1.927674e-01
+ 3.255556e+00 1.852698e-01
+ 3.266667e+00 1.827705e-01
+ 3.277778e+00 1.927674e-01
+ 3.288889e+00 1.752729e-01
+ 3.300000e+00 1.752729e-01
+ 3.311111e+00 1.827705e-01
+ 3.322222e+00 1.827705e-01
+ 3.333333e+00 1.827705e-01
+ 3.344444e+00 1.927674e-01
+ 3.355556e+00 1.902682e-01
+ 3.366667e+00 1.902682e-01
+ 3.377778e+00 1.952666e-01
+ 3.388889e+00 1.852698e-01
+ 3.400000e+00 1.952666e-01
+ 3.411111e+00 2.252571e-01
+ 3.422222e+00 2.302555e-01
+ 3.433333e+00 2.427515e-01
+ 3.444444e+00 2.352539e-01
+ 3.455556e+00 2.302555e-01
+ 3.466667e+00 2.352539e-01
+ 3.477778e+00 2.277563e-01
+ 3.488889e+00 2.002650e-01
+ 3.500000e+00 1.852698e-01
+ 3.511111e+00 1.827705e-01
+ 3.522222e+00 1.752729e-01
+ 3.533333e+00 1.727737e-01
+ 3.544444e+00 1.827705e-01
+ 3.555556e+00 1.727737e-01
+ 3.566667e+00 1.252888e-01
+ 3.577778e+00 7.780387e-02
+ 3.588889e+00 3.152285e-01
+ 3.600000e+00 7.875785e-01
+ 3.611111e+00 3.602142e-01
+ 3.622222e+00 1.452825e-01
+ 3.633333e+00 1.602777e-01
+ 3.644444e+00 1.652761e-01
+ 3.655556e+00 1.577785e-01
+ 3.666667e+00 1.552793e-01
+ 3.677778e+00 1.577785e-01
+ 3.688889e+00 1.502809e-01
+ 3.700000e+00 1.527801e-01
+ 3.711111e+00 1.627769e-01
+ 3.722222e+00 1.577785e-01
+ 3.733333e+00 1.527801e-01
+ 3.744444e+00 1.652761e-01
+ 3.755556e+00 1.577785e-01
+ 3.766667e+00 1.652761e-01
+ 3.777778e+00 1.727737e-01
+ 3.788889e+00 1.652761e-01
+ 3.800000e+00 1.627769e-01
+ 3.811111e+00 1.602777e-01
+ 3.822222e+00 1.577785e-01
+ 3.833333e+00 1.627769e-01
+ 3.844444e+00 1.602777e-01
+ 3.855556e+00 1.577785e-01
+ 3.866667e+00 1.577785e-01
+ 3.877778e+00 1.677753e-01
+ 3.888889e+00 1.752729e-01
+ 3.900000e+00 1.852698e-01
+ 3.911111e+00 1.927674e-01
+ 3.922222e+00 2.077626e-01
+ 3.933333e+00 2.127610e-01
+ 3.944444e+00 2.252571e-01
+ 3.955556e+00 2.077626e-01
+ 3.966667e+00 2.152602e-01
+ 3.977778e+00 2.152602e-01
+ 3.988889e+00 2.077626e-01
+ 4.000000e+00 2.102618e-01
+ 4.011111e+00 2.152602e-01
+ 4.022222e+00 2.027642e-01
+ 4.033333e+00 2.052634e-01
+ 4.044444e+00 2.027642e-01
+ 4.055556e+00 1.927674e-01
+ 4.066667e+00 1.927674e-01
+ 4.077778e+00 1.927674e-01
+ 4.088889e+00 1.952666e-01
+ 4.100000e+00 1.952666e-01
+ 4.111111e+00 1.977658e-01
+ 4.122222e+00 1.902682e-01
+ 4.133333e+00 1.902682e-01
+ 4.144444e+00 2.052634e-01
+ 4.155556e+00 1.952666e-01
+ 4.166667e+00 1.927674e-01
+ 4.177778e+00 2.002650e-01
+ 4.188889e+00 2.052634e-01
+ 4.200000e+00 2.302555e-01
+ 4.211111e+00 2.427515e-01
+ 4.222222e+00 2.527483e-01
+ 4.233333e+00 2.477499e-01
+ 4.244444e+00 2.452507e-01
+ 4.255556e+00 2.452507e-01
+ 4.266667e+00 2.302555e-01
+ 4.277778e+00 2.127610e-01
+ 4.288889e+00 1.927674e-01
+ 4.300000e+00 2.002650e-01
+ 4.311111e+00 2.002650e-01
+ 4.322222e+00 1.877690e-01
+ 4.333333e+00 1.877690e-01
+ 4.344444e+00 1.927674e-01
+ 4.355556e+00 1.527801e-01
+ 4.366667e+00 9.529832e-02
+ 4.377778e+00 2.327547e-01
+ 4.388889e+00 6.776135e-01
+ 4.400000e+00 5.751460e-01
+ 4.411111e+00 1.202904e-01
+ 4.422222e+00 1.727737e-01
+ 4.433333e+00 1.752729e-01
+ 4.444444e+00 1.802713e-01
+ 4.455556e+00 1.777721e-01
+ 4.466667e+00 1.752729e-01
+ 4.477778e+00 1.752729e-01
+ 4.488889e+00 1.752729e-01
+ 4.500000e+00 1.752729e-01
+ 4.511111e+00 1.852698e-01
+ 4.522222e+00 1.777721e-01
+ 4.533333e+00 1.727737e-01
+ 4.544444e+00 1.777721e-01
+ 4.555556e+00 1.677753e-01
+ 4.566667e+00 1.777721e-01
+ 4.577778e+00 1.827705e-01
+ 4.588889e+00 1.727737e-01
+ 4.600000e+00 1.702745e-01
+ 4.611111e+00 1.852698e-01
+ 4.622222e+00 1.752729e-01
+ 4.633333e+00 1.677753e-01
+ 4.644444e+00 1.702745e-01
+ 4.655556e+00 1.652761e-01
+ 4.666667e+00 1.677753e-01
+ 4.677778e+00 1.852698e-01
+ 4.688889e+00 1.927674e-01)
Vecg1 ecg_raw_L1 0 PWL(
+ 0.000000e+00 2.349170e-01
+ 1.111111e-02 2.419861e-01
+ 2.222222e-02 2.349170e-01
+ 3.333333e-02 2.278478e-01
+ 4.444444e-02 2.490552e-01
+ 5.555556e-02 2.384515e-01
+ 6.666667e-02 2.384515e-01
+ 7.777778e-02 2.455206e-01
+ 8.888889e-02 2.455206e-01
+ 1.000000e-01 2.384515e-01
+ 1.111111e-01 2.702626e-01
+ 1.222222e-01 2.596589e-01
+ 1.333333e-01 2.773317e-01
+ 1.444444e-01 2.879354e-01
+ 1.555556e-01 2.844008e-01
+ 1.666667e-01 2.596589e-01
+ 1.777778e-01 2.737971e-01
+ 1.888889e-01 2.490552e-01
+ 2.000000e-01 2.490552e-01
+ 2.111111e-01 2.561243e-01
+ 2.222222e-01 2.561243e-01
+ 2.333333e-01 2.455206e-01
+ 2.444444e-01 2.561243e-01
+ 2.555556e-01 2.137096e-01
+ 2.666667e-01 1.465530e-01
+ 2.777778e-01 4.116450e-01
+ 2.888889e-01 7.509627e-01
+ 3.000000e-01 7.721701e-01
+ 3.111111e-01 2.207787e-01
+ 3.222222e-01 2.419861e-01
+ 3.333333e-01 2.101750e-01
+ 3.444444e-01 2.243133e-01
+ 3.555556e-01 2.101750e-01
+ 3.666667e-01 2.101750e-01
+ 3.777778e-01 2.207787e-01
+ 3.888889e-01 2.278478e-01
+ 4.000000e-01 2.137096e-01
+ 4.111111e-01 2.172442e-01
+ 4.222222e-01 2.278478e-01
+ 4.333333e-01 2.137096e-01
+ 4.444444e-01 2.313824e-01
+ 4.555556e-01 2.243133e-01
+ 4.666667e-01 2.172442e-01
+ 4.777778e-01 2.172442e-01
+ 4.888889e-01 2.031059e-01
+ 5.000000e-01 1.889677e-01
+ 5.111111e-01 1.995714e-01
+ 5.222222e-01 1.818986e-01
+ 5.333333e-01 1.642258e-01
+ 5.444444e-01 1.606912e-01
+ 5.555556e-01 1.430184e-01
+ 5.666667e-01 1.253456e-01
+ 5.777778e-01 1.253456e-01
+ 5.888889e-01 1.536221e-01
+ 6.000000e-01 1.642258e-01
+ 6.111111e-01 2.137096e-01
+ 6.222222e-01 2.455206e-01
+ 6.333333e-01 2.596589e-01
+ 6.444444e-01 2.808662e-01
+ 6.555556e-01 2.773317e-01
+ 6.666667e-01 2.667280e-01
+ 6.777778e-01 2.808662e-01
+ 6.888889e-01 2.702626e-01
+ 7.000000e-01 2.773317e-01
+ 7.111111e-01 2.737971e-01
+ 7.222222e-01 2.702626e-01
+ 7.333333e-01 2.702626e-01
+ 7.444444e-01 2.737971e-01
+ 7.555556e-01 2.844008e-01
+ 7.666667e-01 2.702626e-01
+ 7.777778e-01 2.702626e-01
+ 7.888889e-01 2.561243e-01
+ 8.000000e-01 2.419861e-01
+ 8.111111e-01 2.278478e-01
+ 8.222222e-01 2.349170e-01
+ 8.333333e-01 2.243133e-01
+ 8.444444e-01 2.384515e-01
+ 8.555556e-01 2.419861e-01
+ 8.666667e-01 2.349170e-01
+ 8.777778e-01 2.490552e-01
+ 8.888889e-01 2.561243e-01
+ 9.000000e-01 2.384515e-01
+ 9.111111e-01 1.854331e-01
+ 9.222222e-01 1.430184e-01
+ 9.333333e-01 4.752671e-01
+ 9.444444e-01 7.686355e-01
+ 9.555556e-01 4.964744e-01
+ 9.666667e-01 2.243133e-01
+ 9.777778e-01 2.490552e-01
+ 9.888889e-01 2.419861e-01
+ 1.000000e+00 2.278478e-01
+ 1.011111e+00 2.384515e-01
+ 1.022222e+00 2.313824e-01
+ 1.033333e+00 2.243133e-01
+ 1.044444e+00 2.349170e-01
+ 1.055556e+00 2.313824e-01
+ 1.066667e+00 2.278478e-01
+ 1.077778e+00 2.384515e-01
+ 1.088889e+00 2.313824e-01
+ 1.100000e+00 2.207787e-01
+ 1.111111e+00 2.313824e-01
+ 1.122222e+00 2.172442e-01
+ 1.133333e+00 2.172442e-01
+ 1.144444e+00 1.995714e-01
+ 1.155556e+00 1.995714e-01
+ 1.166667e+00 1.783640e-01
+ 1.177778e+00 1.783640e-01
+ 1.188889e+00 1.500875e-01
+ 1.200000e+00 1.359493e-01
+ 1.211111e+00 1.324147e-01
+ 1.222222e+00 1.288802e-01
+ 1.233333e+00 1.253456e-01
+ 1.244444e+00 1.606912e-01
+ 1.255556e+00 1.783640e-01
+ 1.266667e+00 1.995714e-01
+ 1.277778e+00 2.243133e-01
+ 1.288889e+00 2.419861e-01
+ 1.300000e+00 2.384515e-01
+ 1.311111e+00 2.525898e-01
+ 1.322222e+00 2.419861e-01
+ 1.333333e+00 2.455206e-01
+ 1.344444e+00 2.525898e-01
+ 1.355556e+00 2.490552e-01
+ 1.366667e+00 2.384515e-01
+ 1.377778e+00 2.455206e-01
+ 1.388889e+00 2.278478e-01
+ 1.400000e+00 2.313824e-01
+ 1.411111e+00 2.349170e-01
+ 1.422222e+00 2.243133e-01
+ 1.433333e+00 2.243133e-01
+ 1.444444e+00 2.278478e-01
+ 1.455556e+00 2.419861e-01
+ 1.466667e+00 2.101750e-01
+ 1.477778e+00 2.384515e-01
+ 1.488889e+00 2.243133e-01
+ 1.500000e+00 2.243133e-01
+ 1.511111e+00 2.243133e-01
+ 1.522222e+00 2.419861e-01
+ 1.533333e+00 2.207787e-01
+ 1.544444e+00 2.384515e-01
+ 1.555556e+00 2.243133e-01
+ 1.566667e+00 2.137096e-01
+ 1.577778e+00 2.207787e-01
+ 1.588889e+00 2.172442e-01
+ 1.600000e+00 2.137096e-01
+ 1.611111e+00 2.137096e-01
+ 1.622222e+00 2.172442e-01
+ 1.633333e+00 2.031059e-01
+ 1.644444e+00 2.243133e-01
+ 1.655556e+00 2.066405e-01
+ 1.666667e+00 1.995714e-01
+ 1.677778e+00 2.031059e-01
+ 1.688889e+00 2.066405e-01
+ 1.700000e+00 1.925022e-01
+ 1.711111e+00 2.066405e-01
+ 1.722222e+00 2.137096e-01
+ 1.733333e+00 1.925022e-01
+ 1.744444e+00 2.137096e-01
+ 1.755556e+00 2.243133e-01
+ 1.766667e+00 2.278478e-01
+ 1.777778e+00 2.419861e-01
+ 1.788889e+00 2.349170e-01
+ 1.800000e+00 2.313824e-01
+ 1.811111e+00 2.243133e-01
+ 1.822222e+00 2.172442e-01
+ 1.833333e+00 2.137096e-01
+ 1.844444e+00 2.066405e-01
+ 1.855556e+00 2.031059e-01
+ 1.866667e+00 1.925022e-01
+ 1.877778e+00 1.995714e-01
+ 1.888889e+00 1.960368e-01
+ 1.900000e+00 1.712949e-01
+ 1.911111e+00 1.288802e-01
+ 1.922222e+00 2.702626e-01
+ 1.933333e+00 4.611288e-01
+ 1.944444e+00 7.368245e-01
+ 1.955556e+00 1.218110e-01
+ 1.966667e+00 1.147419e-01
+ 1.977778e+00 1.642258e-01
+ 1.988889e+00 1.642258e-01
+ 2.000000e+00 1.642258e-01
+ 2.011111e+00 1.677603e-01
+ 2.022222e+00 1.748294e-01
+ 2.033333e+00 1.677603e-01
+ 2.044444e+00 1.818986e-01
+ 2.055556e+00 1.748294e-01
+ 2.066667e+00 1.712949e-01
+ 2.077778e+00 1.854331e-01
+ 2.088889e+00 1.783640e-01
+ 2.100000e+00 1.818986e-01
+ 2.111111e+00 1.818986e-01
+ 2.122222e+00 1.712949e-01
+ 2.133333e+00 1.642258e-01
+ 2.144444e+00 1.571566e-01
+ 2.155556e+00 1.606912e-01
+ 2.166667e+00 1.606912e-01
+ 2.177778e+00 1.712949e-01
+ 2.188889e+00 1.394838e-01
+ 2.200000e+00 1.218110e-01
+ 2.211111e+00 1.041382e-01
+ 2.222222e+00 8.646544e-02
+ 2.233333e+00 6.879264e-02
+ 2.244444e+00 7.586176e-02
+ 2.255556e+00 8.293088e-02
+ 2.266667e+00 1.076728e-01
+ 2.277778e+00 1.536221e-01
+ 2.288889e+00 1.854331e-01
+ 2.300000e+00 1.960368e-01
+ 2.311111e+00 2.243133e-01
+ 2.322222e+00 2.172442e-01
+ 2.333333e+00 2.207787e-01
+ 2.344444e+00 2.172442e-01
+ 2.355556e+00 2.313824e-01
+ 2.366667e+00 2.137096e-01
+ 2.377778e+00 2.243133e-01
+ 2.388889e+00 2.137096e-01
+ 2.400000e+00 2.066405e-01
+ 2.411111e+00 2.137096e-01
+ 2.422222e+00 2.031059e-01
+ 2.433333e+00 2.031059e-01
+ 2.444444e+00 2.101750e-01
+ 2.455556e+00 2.137096e-01
+ 2.466667e+00 1.960368e-01
+ 2.477778e+00 1.995714e-01
+ 2.488889e+00 1.995714e-01
+ 2.500000e+00 1.995714e-01
+ 2.511111e+00 2.101750e-01
+ 2.522222e+00 2.137096e-01
+ 2.533333e+00 1.960368e-01
+ 2.544444e+00 2.137096e-01
+ 2.555556e+00 2.137096e-01
+ 2.566667e+00 2.101750e-01
+ 2.577778e+00 2.101750e-01
+ 2.588889e+00 2.243133e-01
+ 2.600000e+00 2.207787e-01
+ 2.611111e+00 2.419861e-01
+ 2.622222e+00 2.490552e-01
+ 2.633333e+00 2.561243e-01
+ 2.644444e+00 2.596589e-01
+ 2.655556e+00 2.349170e-01
+ 2.666667e+00 2.243133e-01
+ 2.677778e+00 2.278478e-01
+ 2.688889e+00 2.278478e-01
+ 2.700000e+00 1.995714e-01
+ 2.711111e+00 2.172442e-01
+ 2.722222e+00 2.101750e-01
+ 2.733333e+00 2.066405e-01
+ 2.744444e+00 1.854331e-01
+ 2.755556e+00 1.218110e-01
+ 2.766667e+00 3.126773e-01
+ 2.777778e+00 5.954421e-01
+ 2.788889e+00 7.191517e-01
+ 2.800000e+00 1.147419e-01
+ 2.811111e+00 1.854331e-01
+ 2.822222e+00 1.818986e-01
+ 2.833333e+00 1.712949e-01
+ 2.844444e+00 1.889677e-01
+ 2.855556e+00 1.889677e-01
+ 2.866667e+00 1.889677e-01
+ 2.877778e+00 1.995714e-01
+ 2.888889e+00 1.925022e-01
+ 2.900000e+00 1.889677e-01
+ 2.911111e+00 1.960368e-01
+ 2.922222e+00 1.995714e-01
+ 2.933333e+00 1.854331e-01
+ 2.944444e+00 1.925022e-01
+ 2.955556e+00 1.818986e-01
+ 2.966667e+00 1.889677e-01
+ 2.977778e+00 1.854331e-01
+ 2.988889e+00 1.818986e-01
+ 3.000000e+00 1.606912e-01
+ 3.011111e+00 1.536221e-01
+ 3.022222e+00 1.324147e-01
+ 3.033333e+00 1.182765e-01
+ 3.044444e+00 1.041382e-01
+ 3.055556e+00 1.006037e-01
+ 3.066667e+00 9.000000e-02
+ 3.077778e+00 1.288802e-01
+ 3.088889e+00 1.606912e-01
+ 3.100000e+00 1.960368e-01
+ 3.111111e+00 2.243133e-01
+ 3.122222e+00 2.243133e-01
+ 3.133333e+00 2.278478e-01
+ 3.144444e+00 2.384515e-01
+ 3.155556e+00 2.384515e-01
+ 3.166667e+00 2.349170e-01
+ 3.177778e+00 2.419861e-01
+ 3.188889e+00 2.313824e-01
+ 3.200000e+00 2.278478e-01
+ 3.211111e+00 2.313824e-01
+ 3.222222e+00 2.278478e-01
+ 3.233333e+00 2.101750e-01
+ 3.244444e+00 2.243133e-01
+ 3.255556e+00 2.172442e-01
+ 3.266667e+00 2.066405e-01
+ 3.277778e+00 2.207787e-01
+ 3.288889e+00 2.066405e-01
+ 3.300000e+00 2.066405e-01
+ 3.311111e+00 2.207787e-01
+ 3.322222e+00 2.243133e-01
+ 3.333333e+00 2.101750e-01
+ 3.344444e+00 2.207787e-01
+ 3.355556e+00 2.207787e-01
+ 3.366667e+00 2.172442e-01
+ 3.377778e+00 2.384515e-01
+ 3.388889e+00 2.243133e-01
+ 3.400000e+00 2.137096e-01
+ 3.411111e+00 2.278478e-01
+ 3.422222e+00 2.419861e-01
+ 3.433333e+00 2.384515e-01
+ 3.444444e+00 2.667280e-01
+ 3.455556e+00 2.631934e-01
+ 3.466667e+00 2.490552e-01
+ 3.477778e+00 2.490552e-01
+ 3.488889e+00 2.384515e-01
+ 3.500000e+00 2.243133e-01
+ 3.511111e+00 2.278478e-01
+ 3.522222e+00 2.243133e-01
+ 3.533333e+00 2.172442e-01
+ 3.544444e+00 2.243133e-01
+ 3.555556e+00 2.101750e-01
+ 3.566667e+00 1.182765e-01
+ 3.577778e+00 3.056082e-01
+ 3.588889e+00 6.449259e-01
+ 3.600000e+00 7.438936e-01
+ 3.611111e+00 1.818986e-01
+ 3.622222e+00 1.960368e-01
+ 3.633333e+00 1.854331e-01
+ 3.644444e+00 1.995714e-01
+ 3.655556e+00 1.889677e-01
+ 3.666667e+00 1.818986e-01
+ 3.677778e+00 1.889677e-01
+ 3.688889e+00 1.960368e-01
+ 3.700000e+00 1.783640e-01
+ 3.711111e+00 2.031059e-01
+ 3.722222e+00 1.925022e-01
+ 3.733333e+00 1.925022e-01
+ 3.744444e+00 1.995714e-01
+ 3.755556e+00 1.854331e-01
+ 3.766667e+00 1.783640e-01
+ 3.777778e+00 1.960368e-01
+ 3.788889e+00 1.712949e-01
+ 3.800000e+00 1.571566e-01
+ 3.811111e+00 1.465530e-01
+ 3.822222e+00 1.324147e-01
+ 3.833333e+00 1.041382e-01
+ 3.844444e+00 1.041382e-01
+ 3.855556e+00 9.706912e-02
+ 3.866667e+00 1.006037e-01
+ 3.877778e+00 1.394838e-01
+ 3.888889e+00 1.642258e-01
+ 3.900000e+00 1.783640e-01
+ 3.911111e+00 2.243133e-01
+ 3.922222e+00 2.349170e-01
+ 3.933333e+00 2.384515e-01
+ 3.944444e+00 2.455206e-01
+ 3.955556e+00 2.490552e-01
+ 3.966667e+00 2.313824e-01
+ 3.977778e+00 2.490552e-01
+ 3.988889e+00 2.349170e-01
+ 4.000000e+00 2.313824e-01
+ 4.011111e+00 2.349170e-01
+ 4.022222e+00 2.349170e-01
+ 4.033333e+00 2.137096e-01
+ 4.044444e+00 2.278478e-01
+ 4.055556e+00 2.207787e-01
+ 4.066667e+00 2.172442e-01
+ 4.077778e+00 2.207787e-01
+ 4.088889e+00 2.137096e-01
+ 4.100000e+00 2.172442e-01
+ 4.111111e+00 2.278478e-01
+ 4.122222e+00 2.243133e-01
+ 4.133333e+00 2.243133e-01
+ 4.144444e+00 2.384515e-01
+ 4.155556e+00 2.349170e-01
+ 4.166667e+00 2.313824e-01
+ 4.177778e+00 2.455206e-01
+ 4.188889e+00 2.384515e-01
+ 4.200000e+00 2.278478e-01
+ 4.211111e+00 2.490552e-01
+ 4.222222e+00 2.631934e-01
+ 4.233333e+00 2.596589e-01
+ 4.244444e+00 2.844008e-01
+ 4.255556e+00 2.667280e-01
+ 4.266667e+00 2.631934e-01
+ 4.277778e+00 2.455206e-01
+ 4.288889e+00 2.490552e-01
+ 4.300000e+00 2.384515e-01
+ 4.311111e+00 2.419861e-01
+ 4.322222e+00 2.384515e-01
+ 4.333333e+00 2.313824e-01
+ 4.344444e+00 2.313824e-01
+ 4.355556e+00 1.606912e-01
+ 4.366667e+00 2.101750e-01
+ 4.377778e+00 5.035435e-01
+ 4.388889e+00 7.615664e-01
+ 4.400000e+00 1.500875e-01
+ 4.411111e+00 2.172442e-01
+ 4.422222e+00 2.207787e-01
+ 4.433333e+00 2.066405e-01
+ 4.444444e+00 2.207787e-01
+ 4.455556e+00 2.101750e-01
+ 4.466667e+00 2.031059e-01
+ 4.477778e+00 2.172442e-01
+ 4.488889e+00 2.137096e-01
+ 4.500000e+00 2.101750e-01
+ 4.511111e+00 2.207787e-01
+ 4.522222e+00 2.172442e-01
+ 4.533333e+00 2.066405e-01
+ 4.544444e+00 2.137096e-01
+ 4.555556e+00 2.066405e-01
+ 4.566667e+00 1.960368e-01
+ 4.577778e+00 1.960368e-01
+ 4.588889e+00 1.818986e-01
+ 4.600000e+00 1.748294e-01
+ 4.611111e+00 1.677603e-01
+ 4.622222e+00 1.500875e-01
+ 4.633333e+00 1.288802e-01
+ 4.644444e+00 1.324147e-01
+ 4.655556e+00 1.253456e-01
+ 4.666667e+00 1.500875e-01
+ 4.677778e+00 1.854331e-01
+ 4.688889e+00 2.172442e-01)

Xbuf0 ecg_raw_L0 ecg_buf_L0 ecg_buf_L0 vdd vss vbias ota_5t
Xhpf0 ecg_buf_L0 ecg_hp_L0 vdd vss vbias otac_hpf cap_w=100 cap_l=100
Xlpf0 ecg_hp_L0 ecg_cond_L0 vdd vss vbias otac_lpf cap_w=17 cap_l=17

Xbuf1 ecg_raw_L1 ecg_buf_L1 ecg_buf_L1 vdd vss vbias ota_5t
Xhpf1 ecg_buf_L1 ecg_hp_L1 vdd vss vbias otac_hpf cap_w=100 cap_l=100
Xlpf1 ecg_hp_L1 ecg_cond_L1 vdd vss vbias otac_lpf cap_w=17 cap_l=17

Xbpf ecg_cond_L0 bpf_out vdd vss vbias otac_bpf cl_hpf=39 cw_hpf=39 cl_lpf=24 cw_lpf=24
Xrect bpf_out rect_out vref vdd vss vbias rectifier
Xenv rect_out env_out vdd vss vbias otac_lpf cap_w=77 cap_l=77
Xthresh env_out thresh_out vdd vss vbias otac_lpf cap_w=50 cap_l=50
Xcmp env_out thresh_out rpeak_internal vdd vss vbias comparator

Vrpeak rpeak_trigger 0 PWL(
+ 0.0000000e+00 0.000000e+00
+ 2.9990000e-01 0.000000e+00
+ 3.0000000e-01 9.000000e-01
+ 3.0500000e-01 9.000000e-01
+ 3.0510000e-01 0.000000e+00
+ 9.5267778e-01 0.000000e+00
+ 9.5277778e-01 9.000000e-01
+ 9.5777778e-01 9.000000e-01
+ 9.5787778e-01 0.000000e+00
+ 1.9471222e+00 0.000000e+00
+ 1.9472222e+00 9.000000e-01
+ 1.9522222e+00 9.000000e-01
+ 1.9523222e+00 0.000000e+00
+ 2.7915667e+00 0.000000e+00
+ 2.7916667e+00 9.000000e-01
+ 2.7966667e+00 9.000000e-01
+ 2.7967667e+00 0.000000e+00
+ 3.6026778e+00 0.000000e+00
+ 3.6027778e+00 9.000000e-01
+ 3.6077778e+00 9.000000e-01
+ 3.6078778e+00 0.000000e+00
+ 4.3915667e+00 0.000000e+00
+ 4.3916667e+00 9.000000e-01
+ 4.3966667e+00 9.000000e-01
+ 4.3967667e+00 0.000000e+00
+ 4.6888889e+00 0.000000e+00)
Vqrs_gate qrs_gate 0 PWL(
+ 0.0000000e+00 0.000000e+00
+ 2.4990000e-01 0.000000e+00
+ 2.5000000e-01 9.000000e-01
+ 4.0000000e-01 9.000000e-01
+ 4.0010000e-01 0.000000e+00
+ 9.0267778e-01 0.000000e+00
+ 9.0277778e-01 9.000000e-01
+ 1.0527778e+00 9.000000e-01
+ 1.0528778e+00 0.000000e+00
+ 1.8971222e+00 0.000000e+00
+ 1.8972222e+00 9.000000e-01
+ 2.0472222e+00 9.000000e-01
+ 2.0473222e+00 0.000000e+00
+ 2.7415667e+00 0.000000e+00
+ 2.7416667e+00 9.000000e-01
+ 2.8916667e+00 9.000000e-01
+ 2.8917667e+00 0.000000e+00
+ 3.5526778e+00 0.000000e+00
+ 3.5527778e+00 9.000000e-01
+ 3.7027778e+00 9.000000e-01
+ 3.7028778e+00 0.000000e+00
+ 4.3415667e+00 0.000000e+00
+ 4.3416667e+00 9.000000e-01
+ 4.4916667e+00 9.000000e-01
+ 4.4917667e+00 0.000000e+00
+ 4.6888889e+00 0.000000e+00)
Vpwave_gate pwave_gate 0 PWL(
+ 0.0000000e+00 0.000000e+00
+ 1.7990000e-01 0.000000e+00
+ 1.8000000e-01 9.000000e-01
+ 2.8000000e-01 9.000000e-01
+ 2.8010000e-01 0.000000e+00
+ 8.3267778e-01 0.000000e+00
+ 8.3277778e-01 9.000000e-01
+ 9.3277778e-01 9.000000e-01
+ 9.3287778e-01 0.000000e+00
+ 1.8271222e+00 0.000000e+00
+ 1.8272222e+00 9.000000e-01
+ 1.9272222e+00 9.000000e-01
+ 1.9273222e+00 0.000000e+00
+ 2.6715667e+00 0.000000e+00
+ 2.6716667e+00 9.000000e-01
+ 2.7716667e+00 9.000000e-01
+ 2.7717667e+00 0.000000e+00
+ 3.4826778e+00 0.000000e+00
+ 3.4827778e+00 9.000000e-01
+ 3.5827778e+00 9.000000e-01
+ 3.5828778e+00 0.000000e+00
+ 4.2715667e+00 0.000000e+00
+ 4.2716667e+00 9.000000e-01
+ 4.3716667e+00 9.000000e-01
+ 4.3717667e+00 0.000000e+00
+ 4.6888889e+00 0.000000e+00)
Vsample_clk sample_clk 0 PWL(
+ 0.0000000e+00 0.000000e+00
+ 4.9990000e-01 0.000000e+00
+ 5.0000000e-01 9.000000e-01
+ 5.0200000e-01 9.000000e-01
+ 5.0210000e-01 0.000000e+00
+ 1.1526778e+00 0.000000e+00
+ 1.1527778e+00 9.000000e-01
+ 1.1547778e+00 9.000000e-01
+ 1.1548778e+00 0.000000e+00
+ 2.1471222e+00 0.000000e+00
+ 2.1472222e+00 9.000000e-01
+ 2.1492222e+00 9.000000e-01
+ 2.1493222e+00 0.000000e+00
+ 2.9915667e+00 0.000000e+00
+ 2.9916667e+00 9.000000e-01
+ 2.9936667e+00 9.000000e-01
+ 2.9937667e+00 0.000000e+00
+ 3.8026778e+00 0.000000e+00
+ 3.8027778e+00 9.000000e-01
+ 3.8047778e+00 9.000000e-01
+ 3.8048778e+00 0.000000e+00
+ 4.5915667e+00 0.000000e+00
+ 4.5916667e+00 9.000000e-01
+ 4.5936667e+00 9.000000e-01
+ 4.5937667e+00 0.000000e+00
+ 4.6888889e+00 0.000000e+00)
Vsample_clkb sample_clk_bar 0 PWL(
+ 0.0000000e+00 9.000000e-01
+ 4.9990000e-01 9.000000e-01
+ 5.0000000e-01 0.000000e+00
+ 5.0200000e-01 0.000000e+00
+ 5.0210000e-01 9.000000e-01
+ 1.1526778e+00 9.000000e-01
+ 1.1527778e+00 0.000000e+00
+ 1.1547778e+00 0.000000e+00
+ 1.1548778e+00 9.000000e-01
+ 2.1471222e+00 9.000000e-01
+ 2.1472222e+00 0.000000e+00
+ 2.1492222e+00 0.000000e+00
+ 2.1493222e+00 9.000000e-01
+ 2.9915667e+00 9.000000e-01
+ 2.9916667e+00 0.000000e+00
+ 2.9936667e+00 0.000000e+00
+ 2.9937667e+00 9.000000e-01
+ 3.8026778e+00 9.000000e-01
+ 3.8027778e+00 0.000000e+00
+ 3.8047778e+00 0.000000e+00
+ 3.8048778e+00 9.000000e-01
+ 4.5915667e+00 9.000000e-01
+ 4.5916667e+00 0.000000e+00
+ 4.5936667e+00 0.000000e+00
+ 4.5937667e+00 9.000000e-01
+ 4.6888889e+00 9.000000e-01)

Xrr rpeak_trigger f_rr_ratio f_rr_asym vdd vss vbias rr_timing
Xinstab0 ecg_cond_L0 qrs_gate rpeak_trigger f_instab_L0 vdd vss vbias vref beat_instability
Xinstab1 ecg_cond_L1 qrs_gate rpeak_trigger f_instab_L1 vdd vss vbias vref beat_instability
Xpwave ecg_cond_L0 pwave_gate rpeak_trigger f_pwave vdd vss vbias vref pwave_energy
Xwidth vref ecg_cond_L0 qrs_gate rpeak_trigger f_width vdd vss vbias qrs_width
Xslope ecg_cond_L0 qrs_gate rpeak_trigger f_slope vdd vss vbias vref slope_ratio
Xsym qrs_gate rpeak_trigger f_width f_sym rpeak_trigger vdd vss vbias qrs_symmetry

Xsh f_rr_ratio f_rr_asym f_instab_L0 f_instab_L1 f_pwave f_width f_slope f_sym
+ o_rr_ratio o_rr_asym o_instab_L0 o_instab_L1 o_pwave o_width o_slope o_sym
+ sample_clk sample_clk_bar vdd vss sh_bank

.tran 200u 4.688888888888889 uic

.meas tran f_rr_ratio_t0 FIND v(f_rr_ratio) AT=1.997222e+00
.meas tran f_rr_asym_t0 FIND v(f_rr_asym) AT=1.997222e+00
.meas tran f_instab_l0_t0 FIND v(f_instab_l0) AT=1.997222e+00
.meas tran f_instab_l1_t0 FIND v(f_instab_l1) AT=1.997222e+00
.meas tran f_pwave_t0 FIND v(f_pwave) AT=1.997222e+00
.meas tran f_width_t0 FIND v(f_width) AT=1.997222e+00
.meas tran f_slope_t0 FIND v(f_slope) AT=1.997222e+00
.meas tran f_sym_t0 FIND v(f_sym) AT=1.997222e+00
.meas tran ecg_cond_l0_t0 FIND v(ecg_cond_l0) AT=1.997222e+00
.meas tran bpf_out_t0 FIND v(bpf_out) AT=1.997222e+00
.meas tran env_out_t0 FIND v(env_out) AT=1.997222e+00
.meas tran f_rr_ratio_t1 FIND v(f_rr_ratio) AT=2.017222e+00
.meas tran f_rr_asym_t1 FIND v(f_rr_asym) AT=2.017222e+00
.meas tran f_instab_l0_t1 FIND v(f_instab_l0) AT=2.017222e+00
.meas tran f_instab_l1_t1 FIND v(f_instab_l1) AT=2.017222e+00
.meas tran f_pwave_t1 FIND v(f_pwave) AT=2.017222e+00
.meas tran f_width_t1 FIND v(f_width) AT=2.017222e+00
.meas tran f_slope_t1 FIND v(f_slope) AT=2.017222e+00
.meas tran f_sym_t1 FIND v(f_sym) AT=2.017222e+00
.meas tran ecg_cond_l0_t1 FIND v(ecg_cond_l0) AT=2.017222e+00
.meas tran bpf_out_t1 FIND v(bpf_out) AT=2.017222e+00
.meas tran env_out_t1 FIND v(env_out) AT=2.017222e+00
.meas tran f_rr_ratio_t2 FIND v(f_rr_ratio) AT=2.037222e+00
.meas tran f_rr_asym_t2 FIND v(f_rr_asym) AT=2.037222e+00
.meas tran f_instab_l0_t2 FIND v(f_instab_l0) AT=2.037222e+00
.meas tran f_instab_l1_t2 FIND v(f_instab_l1) AT=2.037222e+00
.meas tran f_pwave_t2 FIND v(f_pwave) AT=2.037222e+00
.meas tran f_width_t2 FIND v(f_width) AT=2.037222e+00
.meas tran f_slope_t2 FIND v(f_slope) AT=2.037222e+00
.meas tran f_sym_t2 FIND v(f_sym) AT=2.037222e+00
.meas tran ecg_cond_l0_t2 FIND v(ecg_cond_l0) AT=2.037222e+00
.meas tran bpf_out_t2 FIND v(bpf_out) AT=2.037222e+00
.meas tran env_out_t2 FIND v(env_out) AT=2.037222e+00
.meas tran f_rr_ratio_t3 FIND v(f_rr_ratio) AT=2.057222e+00
.meas tran f_rr_asym_t3 FIND v(f_rr_asym) AT=2.057222e+00
.meas tran f_instab_l0_t3 FIND v(f_instab_l0) AT=2.057222e+00
.meas tran f_instab_l1_t3 FIND v(f_instab_l1) AT=2.057222e+00
.meas tran f_pwave_t3 FIND v(f_pwave) AT=2.057222e+00
.meas tran f_width_t3 FIND v(f_width) AT=2.057222e+00
.meas tran f_slope_t3 FIND v(f_slope) AT=2.057222e+00
.meas tran f_sym_t3 FIND v(f_sym) AT=2.057222e+00
.meas tran ecg_cond_l0_t3 FIND v(ecg_cond_l0) AT=2.057222e+00
.meas tran bpf_out_t3 FIND v(bpf_out) AT=2.057222e+00
.meas tran env_out_t3 FIND v(env_out) AT=2.057222e+00
.meas tran f_rr_ratio_t4 FIND v(f_rr_ratio) AT=2.077222e+00
.meas tran f_rr_asym_t4 FIND v(f_rr_asym) AT=2.077222e+00
.meas tran f_instab_l0_t4 FIND v(f_instab_l0) AT=2.077222e+00
.meas tran f_instab_l1_t4 FIND v(f_instab_l1) AT=2.077222e+00
.meas tran f_pwave_t4 FIND v(f_pwave) AT=2.077222e+00
.meas tran f_width_t4 FIND v(f_width) AT=2.077222e+00
.meas tran f_slope_t4 FIND v(f_slope) AT=2.077222e+00
.meas tran f_sym_t4 FIND v(f_sym) AT=2.077222e+00
.meas tran ecg_cond_l0_t4 FIND v(ecg_cond_l0) AT=2.077222e+00
.meas tran bpf_out_t4 FIND v(bpf_out) AT=2.077222e+00
.meas tran env_out_t4 FIND v(env_out) AT=2.077222e+00
.meas tran f_rr_ratio_t5 FIND v(f_rr_ratio) AT=2.097222e+00
.meas tran f_rr_asym_t5 FIND v(f_rr_asym) AT=2.097222e+00
.meas tran f_instab_l0_t5 FIND v(f_instab_l0) AT=2.097222e+00
.meas tran f_instab_l1_t5 FIND v(f_instab_l1) AT=2.097222e+00
.meas tran f_pwave_t5 FIND v(f_pwave) AT=2.097222e+00
.meas tran f_width_t5 FIND v(f_width) AT=2.097222e+00
.meas tran f_slope_t5 FIND v(f_slope) AT=2.097222e+00
.meas tran f_sym_t5 FIND v(f_sym) AT=2.097222e+00
.meas tran ecg_cond_l0_t5 FIND v(ecg_cond_l0) AT=2.097222e+00
.meas tran bpf_out_t5 FIND v(bpf_out) AT=2.097222e+00
.meas tran env_out_t5 FIND v(env_out) AT=2.097222e+00
.meas tran f_rr_ratio_t6 FIND v(f_rr_ratio) AT=2.117222e+00
.meas tran f_rr_asym_t6 FIND v(f_rr_asym) AT=2.117222e+00
.meas tran f_instab_l0_t6 FIND v(f_instab_l0) AT=2.117222e+00
.meas tran f_instab_l1_t6 FIND v(f_instab_l1) AT=2.117222e+00
.meas tran f_pwave_t6 FIND v(f_pwave) AT=2.117222e+00
.meas tran f_width_t6 FIND v(f_width) AT=2.117222e+00
.meas tran f_slope_t6 FIND v(f_slope) AT=2.117222e+00
.meas tran f_sym_t6 FIND v(f_sym) AT=2.117222e+00
.meas tran ecg_cond_l0_t6 FIND v(ecg_cond_l0) AT=2.117222e+00
.meas tran bpf_out_t6 FIND v(bpf_out) AT=2.117222e+00
.meas tran env_out_t6 FIND v(env_out) AT=2.117222e+00
.meas tran f_rr_ratio_t7 FIND v(f_rr_ratio) AT=2.137222e+00
.meas tran f_rr_asym_t7 FIND v(f_rr_asym) AT=2.137222e+00
.meas tran f_instab_l0_t7 FIND v(f_instab_l0) AT=2.137222e+00
.meas tran f_instab_l1_t7 FIND v(f_instab_l1) AT=2.137222e+00
.meas tran f_pwave_t7 FIND v(f_pwave) AT=2.137222e+00
.meas tran f_width_t7 FIND v(f_width) AT=2.137222e+00
.meas tran f_slope_t7 FIND v(f_slope) AT=2.137222e+00
.meas tran f_sym_t7 FIND v(f_sym) AT=2.137222e+00
.meas tran ecg_cond_l0_t7 FIND v(ecg_cond_l0) AT=2.137222e+00
.meas tran bpf_out_t7 FIND v(bpf_out) AT=2.137222e+00
.meas tran env_out_t7 FIND v(env_out) AT=2.137222e+00
.meas tran f_rr_ratio_t8 FIND v(f_rr_ratio) AT=2.157222e+00
.meas tran f_rr_asym_t8 FIND v(f_rr_asym) AT=2.157222e+00
.meas tran f_instab_l0_t8 FIND v(f_instab_l0) AT=2.157222e+00
.meas tran f_instab_l1_t8 FIND v(f_instab_l1) AT=2.157222e+00
.meas tran f_pwave_t8 FIND v(f_pwave) AT=2.157222e+00
.meas tran f_width_t8 FIND v(f_width) AT=2.157222e+00
.meas tran f_slope_t8 FIND v(f_slope) AT=2.157222e+00
.meas tran f_sym_t8 FIND v(f_sym) AT=2.157222e+00
.meas tran ecg_cond_l0_t8 FIND v(ecg_cond_l0) AT=2.157222e+00
.meas tran bpf_out_t8 FIND v(bpf_out) AT=2.157222e+00
.meas tran env_out_t8 FIND v(env_out) AT=2.157222e+00
.meas tran f_rr_ratio_t9 FIND v(f_rr_ratio) AT=2.177222e+00
.meas tran f_rr_asym_t9 FIND v(f_rr_asym) AT=2.177222e+00
.meas tran f_instab_l0_t9 FIND v(f_instab_l0) AT=2.177222e+00
.meas tran f_instab_l1_t9 FIND v(f_instab_l1) AT=2.177222e+00
.meas tran f_pwave_t9 FIND v(f_pwave) AT=2.177222e+00
.meas tran f_width_t9 FIND v(f_width) AT=2.177222e+00
.meas tran f_slope_t9 FIND v(f_slope) AT=2.177222e+00
.meas tran f_sym_t9 FIND v(f_sym) AT=2.177222e+00
.meas tran ecg_cond_l0_t9 FIND v(ecg_cond_l0) AT=2.177222e+00
.meas tran bpf_out_t9 FIND v(bpf_out) AT=2.177222e+00
.meas tran env_out_t9 FIND v(env_out) AT=2.177222e+00
.meas tran f_rr_ratio_t10 FIND v(f_rr_ratio) AT=2.197222e+00
.meas tran f_rr_asym_t10 FIND v(f_rr_asym) AT=2.197222e+00
.meas tran f_instab_l0_t10 FIND v(f_instab_l0) AT=2.197222e+00
.meas tran f_instab_l1_t10 FIND v(f_instab_l1) AT=2.197222e+00
.meas tran f_pwave_t10 FIND v(f_pwave) AT=2.197222e+00
.meas tran f_width_t10 FIND v(f_width) AT=2.197222e+00
.meas tran f_slope_t10 FIND v(f_slope) AT=2.197222e+00
.meas tran f_sym_t10 FIND v(f_sym) AT=2.197222e+00
.meas tran ecg_cond_l0_t10 FIND v(ecg_cond_l0) AT=2.197222e+00
.meas tran bpf_out_t10 FIND v(bpf_out) AT=2.197222e+00
.meas tran env_out_t10 FIND v(env_out) AT=2.197222e+00
.meas tran f_rr_ratio_t11 FIND v(f_rr_ratio) AT=2.217222e+00
.meas tran f_rr_asym_t11 FIND v(f_rr_asym) AT=2.217222e+00
.meas tran f_instab_l0_t11 FIND v(f_instab_l0) AT=2.217222e+00
.meas tran f_instab_l1_t11 FIND v(f_instab_l1) AT=2.217222e+00
.meas tran f_pwave_t11 FIND v(f_pwave) AT=2.217222e+00
.meas tran f_width_t11 FIND v(f_width) AT=2.217222e+00
.meas tran f_slope_t11 FIND v(f_slope) AT=2.217222e+00
.meas tran f_sym_t11 FIND v(f_sym) AT=2.217222e+00
.meas tran ecg_cond_l0_t11 FIND v(ecg_cond_l0) AT=2.217222e+00
.meas tran bpf_out_t11 FIND v(bpf_out) AT=2.217222e+00
.meas tran env_out_t11 FIND v(env_out) AT=2.217222e+00
.meas tran f_rr_ratio_t12 FIND v(f_rr_ratio) AT=2.237222e+00
.meas tran f_rr_asym_t12 FIND v(f_rr_asym) AT=2.237222e+00
.meas tran f_instab_l0_t12 FIND v(f_instab_l0) AT=2.237222e+00
.meas tran f_instab_l1_t12 FIND v(f_instab_l1) AT=2.237222e+00
.meas tran f_pwave_t12 FIND v(f_pwave) AT=2.237222e+00
.meas tran f_width_t12 FIND v(f_width) AT=2.237222e+00
.meas tran f_slope_t12 FIND v(f_slope) AT=2.237222e+00
.meas tran f_sym_t12 FIND v(f_sym) AT=2.237222e+00
.meas tran ecg_cond_l0_t12 FIND v(ecg_cond_l0) AT=2.237222e+00
.meas tran bpf_out_t12 FIND v(bpf_out) AT=2.237222e+00
.meas tran env_out_t12 FIND v(env_out) AT=2.237222e+00
.meas tran f_rr_ratio_t13 FIND v(f_rr_ratio) AT=2.257222e+00
.meas tran f_rr_asym_t13 FIND v(f_rr_asym) AT=2.257222e+00
.meas tran f_instab_l0_t13 FIND v(f_instab_l0) AT=2.257222e+00
.meas tran f_instab_l1_t13 FIND v(f_instab_l1) AT=2.257222e+00
.meas tran f_pwave_t13 FIND v(f_pwave) AT=2.257222e+00
.meas tran f_width_t13 FIND v(f_width) AT=2.257222e+00
.meas tran f_slope_t13 FIND v(f_slope) AT=2.257222e+00
.meas tran f_sym_t13 FIND v(f_sym) AT=2.257222e+00
.meas tran ecg_cond_l0_t13 FIND v(ecg_cond_l0) AT=2.257222e+00
.meas tran bpf_out_t13 FIND v(bpf_out) AT=2.257222e+00
.meas tran env_out_t13 FIND v(env_out) AT=2.257222e+00
.meas tran f_rr_ratio_t14 FIND v(f_rr_ratio) AT=2.277222e+00
.meas tran f_rr_asym_t14 FIND v(f_rr_asym) AT=2.277222e+00
.meas tran f_instab_l0_t14 FIND v(f_instab_l0) AT=2.277222e+00
.meas tran f_instab_l1_t14 FIND v(f_instab_l1) AT=2.277222e+00
.meas tran f_pwave_t14 FIND v(f_pwave) AT=2.277222e+00
.meas tran f_width_t14 FIND v(f_width) AT=2.277222e+00
.meas tran f_slope_t14 FIND v(f_slope) AT=2.277222e+00
.meas tran f_sym_t14 FIND v(f_sym) AT=2.277222e+00
.meas tran ecg_cond_l0_t14 FIND v(ecg_cond_l0) AT=2.277222e+00
.meas tran bpf_out_t14 FIND v(bpf_out) AT=2.277222e+00
.meas tran env_out_t14 FIND v(env_out) AT=2.277222e+00
.meas tran f_rr_ratio_t15 FIND v(f_rr_ratio) AT=2.297222e+00
.meas tran f_rr_asym_t15 FIND v(f_rr_asym) AT=2.297222e+00
.meas tran f_instab_l0_t15 FIND v(f_instab_l0) AT=2.297222e+00
.meas tran f_instab_l1_t15 FIND v(f_instab_l1) AT=2.297222e+00
.meas tran f_pwave_t15 FIND v(f_pwave) AT=2.297222e+00
.meas tran f_width_t15 FIND v(f_width) AT=2.297222e+00
.meas tran f_slope_t15 FIND v(f_slope) AT=2.297222e+00
.meas tran f_sym_t15 FIND v(f_sym) AT=2.297222e+00
.meas tran ecg_cond_l0_t15 FIND v(ecg_cond_l0) AT=2.297222e+00
.meas tran bpf_out_t15 FIND v(bpf_out) AT=2.297222e+00
.meas tran env_out_t15 FIND v(env_out) AT=2.297222e+00
.meas tran f_rr_ratio_t16 FIND v(f_rr_ratio) AT=2.317222e+00
.meas tran f_rr_asym_t16 FIND v(f_rr_asym) AT=2.317222e+00
.meas tran f_instab_l0_t16 FIND v(f_instab_l0) AT=2.317222e+00
.meas tran f_instab_l1_t16 FIND v(f_instab_l1) AT=2.317222e+00
.meas tran f_pwave_t16 FIND v(f_pwave) AT=2.317222e+00
.meas tran f_width_t16 FIND v(f_width) AT=2.317222e+00
.meas tran f_slope_t16 FIND v(f_slope) AT=2.317222e+00
.meas tran f_sym_t16 FIND v(f_sym) AT=2.317222e+00
.meas tran ecg_cond_l0_t16 FIND v(ecg_cond_l0) AT=2.317222e+00
.meas tran bpf_out_t16 FIND v(bpf_out) AT=2.317222e+00
.meas tran env_out_t16 FIND v(env_out) AT=2.317222e+00
.meas tran f_rr_ratio_t17 FIND v(f_rr_ratio) AT=2.337222e+00
.meas tran f_rr_asym_t17 FIND v(f_rr_asym) AT=2.337222e+00
.meas tran f_instab_l0_t17 FIND v(f_instab_l0) AT=2.337222e+00
.meas tran f_instab_l1_t17 FIND v(f_instab_l1) AT=2.337222e+00
.meas tran f_pwave_t17 FIND v(f_pwave) AT=2.337222e+00
.meas tran f_width_t17 FIND v(f_width) AT=2.337222e+00
.meas tran f_slope_t17 FIND v(f_slope) AT=2.337222e+00
.meas tran f_sym_t17 FIND v(f_sym) AT=2.337222e+00
.meas tran ecg_cond_l0_t17 FIND v(ecg_cond_l0) AT=2.337222e+00
.meas tran bpf_out_t17 FIND v(bpf_out) AT=2.337222e+00
.meas tran env_out_t17 FIND v(env_out) AT=2.337222e+00
.meas tran f_rr_ratio_t18 FIND v(f_rr_ratio) AT=2.357222e+00
.meas tran f_rr_asym_t18 FIND v(f_rr_asym) AT=2.357222e+00
.meas tran f_instab_l0_t18 FIND v(f_instab_l0) AT=2.357222e+00
.meas tran f_instab_l1_t18 FIND v(f_instab_l1) AT=2.357222e+00
.meas tran f_pwave_t18 FIND v(f_pwave) AT=2.357222e+00
.meas tran f_width_t18 FIND v(f_width) AT=2.357222e+00
.meas tran f_slope_t18 FIND v(f_slope) AT=2.357222e+00
.meas tran f_sym_t18 FIND v(f_sym) AT=2.357222e+00
.meas tran ecg_cond_l0_t18 FIND v(ecg_cond_l0) AT=2.357222e+00
.meas tran bpf_out_t18 FIND v(bpf_out) AT=2.357222e+00
.meas tran env_out_t18 FIND v(env_out) AT=2.357222e+00
.meas tran f_rr_ratio_t19 FIND v(f_rr_ratio) AT=2.377222e+00
.meas tran f_rr_asym_t19 FIND v(f_rr_asym) AT=2.377222e+00
.meas tran f_instab_l0_t19 FIND v(f_instab_l0) AT=2.377222e+00
.meas tran f_instab_l1_t19 FIND v(f_instab_l1) AT=2.377222e+00
.meas tran f_pwave_t19 FIND v(f_pwave) AT=2.377222e+00
.meas tran f_width_t19 FIND v(f_width) AT=2.377222e+00
.meas tran f_slope_t19 FIND v(f_slope) AT=2.377222e+00
.meas tran f_sym_t19 FIND v(f_sym) AT=2.377222e+00
.meas tran ecg_cond_l0_t19 FIND v(ecg_cond_l0) AT=2.377222e+00
.meas tran bpf_out_t19 FIND v(bpf_out) AT=2.377222e+00
.meas tran env_out_t19 FIND v(env_out) AT=2.377222e+00
.meas tran f_rr_ratio_t20 FIND v(f_rr_ratio) AT=2.397222e+00
.meas tran f_rr_asym_t20 FIND v(f_rr_asym) AT=2.397222e+00
.meas tran f_instab_l0_t20 FIND v(f_instab_l0) AT=2.397222e+00
.meas tran f_instab_l1_t20 FIND v(f_instab_l1) AT=2.397222e+00
.meas tran f_pwave_t20 FIND v(f_pwave) AT=2.397222e+00
.meas tran f_width_t20 FIND v(f_width) AT=2.397222e+00
.meas tran f_slope_t20 FIND v(f_slope) AT=2.397222e+00
.meas tran f_sym_t20 FIND v(f_sym) AT=2.397222e+00
.meas tran ecg_cond_l0_t20 FIND v(ecg_cond_l0) AT=2.397222e+00
.meas tran bpf_out_t20 FIND v(bpf_out) AT=2.397222e+00
.meas tran env_out_t20 FIND v(env_out) AT=2.397222e+00
.meas tran f_rr_ratio_t21 FIND v(f_rr_ratio) AT=2.417222e+00
.meas tran f_rr_asym_t21 FIND v(f_rr_asym) AT=2.417222e+00
.meas tran f_instab_l0_t21 FIND v(f_instab_l0) AT=2.417222e+00
.meas tran f_instab_l1_t21 FIND v(f_instab_l1) AT=2.417222e+00
.meas tran f_pwave_t21 FIND v(f_pwave) AT=2.417222e+00
.meas tran f_width_t21 FIND v(f_width) AT=2.417222e+00
.meas tran f_slope_t21 FIND v(f_slope) AT=2.417222e+00
.meas tran f_sym_t21 FIND v(f_sym) AT=2.417222e+00
.meas tran ecg_cond_l0_t21 FIND v(ecg_cond_l0) AT=2.417222e+00
.meas tran bpf_out_t21 FIND v(bpf_out) AT=2.417222e+00
.meas tran env_out_t21 FIND v(env_out) AT=2.417222e+00
.meas tran f_rr_ratio_t22 FIND v(f_rr_ratio) AT=2.437222e+00
.meas tran f_rr_asym_t22 FIND v(f_rr_asym) AT=2.437222e+00
.meas tran f_instab_l0_t22 FIND v(f_instab_l0) AT=2.437222e+00
.meas tran f_instab_l1_t22 FIND v(f_instab_l1) AT=2.437222e+00
.meas tran f_pwave_t22 FIND v(f_pwave) AT=2.437222e+00
.meas tran f_width_t22 FIND v(f_width) AT=2.437222e+00
.meas tran f_slope_t22 FIND v(f_slope) AT=2.437222e+00
.meas tran f_sym_t22 FIND v(f_sym) AT=2.437222e+00
.meas tran ecg_cond_l0_t22 FIND v(ecg_cond_l0) AT=2.437222e+00
.meas tran bpf_out_t22 FIND v(bpf_out) AT=2.437222e+00
.meas tran env_out_t22 FIND v(env_out) AT=2.437222e+00
.meas tran f_rr_ratio_t23 FIND v(f_rr_ratio) AT=2.457222e+00
.meas tran f_rr_asym_t23 FIND v(f_rr_asym) AT=2.457222e+00
.meas tran f_instab_l0_t23 FIND v(f_instab_l0) AT=2.457222e+00
.meas tran f_instab_l1_t23 FIND v(f_instab_l1) AT=2.457222e+00
.meas tran f_pwave_t23 FIND v(f_pwave) AT=2.457222e+00
.meas tran f_width_t23 FIND v(f_width) AT=2.457222e+00
.meas tran f_slope_t23 FIND v(f_slope) AT=2.457222e+00
.meas tran f_sym_t23 FIND v(f_sym) AT=2.457222e+00
.meas tran ecg_cond_l0_t23 FIND v(ecg_cond_l0) AT=2.457222e+00
.meas tran bpf_out_t23 FIND v(bpf_out) AT=2.457222e+00
.meas tran env_out_t23 FIND v(env_out) AT=2.457222e+00
.meas tran f_rr_ratio_t24 FIND v(f_rr_ratio) AT=2.477222e+00
.meas tran f_rr_asym_t24 FIND v(f_rr_asym) AT=2.477222e+00
.meas tran f_instab_l0_t24 FIND v(f_instab_l0) AT=2.477222e+00
.meas tran f_instab_l1_t24 FIND v(f_instab_l1) AT=2.477222e+00
.meas tran f_pwave_t24 FIND v(f_pwave) AT=2.477222e+00
.meas tran f_width_t24 FIND v(f_width) AT=2.477222e+00
.meas tran f_slope_t24 FIND v(f_slope) AT=2.477222e+00
.meas tran f_sym_t24 FIND v(f_sym) AT=2.477222e+00
.meas tran ecg_cond_l0_t24 FIND v(ecg_cond_l0) AT=2.477222e+00
.meas tran bpf_out_t24 FIND v(bpf_out) AT=2.477222e+00
.meas tran env_out_t24 FIND v(env_out) AT=2.477222e+00
.meas tran f_rr_ratio_t25 FIND v(f_rr_ratio) AT=2.497222e+00
.meas tran f_rr_asym_t25 FIND v(f_rr_asym) AT=2.497222e+00
.meas tran f_instab_l0_t25 FIND v(f_instab_l0) AT=2.497222e+00
.meas tran f_instab_l1_t25 FIND v(f_instab_l1) AT=2.497222e+00
.meas tran f_pwave_t25 FIND v(f_pwave) AT=2.497222e+00
.meas tran f_width_t25 FIND v(f_width) AT=2.497222e+00
.meas tran f_slope_t25 FIND v(f_slope) AT=2.497222e+00
.meas tran f_sym_t25 FIND v(f_sym) AT=2.497222e+00
.meas tran ecg_cond_l0_t25 FIND v(ecg_cond_l0) AT=2.497222e+00
.meas tran bpf_out_t25 FIND v(bpf_out) AT=2.497222e+00
.meas tran env_out_t25 FIND v(env_out) AT=2.497222e+00
.meas tran f_rr_ratio_t26 FIND v(f_rr_ratio) AT=2.517222e+00
.meas tran f_rr_asym_t26 FIND v(f_rr_asym) AT=2.517222e+00
.meas tran f_instab_l0_t26 FIND v(f_instab_l0) AT=2.517222e+00
.meas tran f_instab_l1_t26 FIND v(f_instab_l1) AT=2.517222e+00
.meas tran f_pwave_t26 FIND v(f_pwave) AT=2.517222e+00
.meas tran f_width_t26 FIND v(f_width) AT=2.517222e+00
.meas tran f_slope_t26 FIND v(f_slope) AT=2.517222e+00
.meas tran f_sym_t26 FIND v(f_sym) AT=2.517222e+00
.meas tran ecg_cond_l0_t26 FIND v(ecg_cond_l0) AT=2.517222e+00
.meas tran bpf_out_t26 FIND v(bpf_out) AT=2.517222e+00
.meas tran env_out_t26 FIND v(env_out) AT=2.517222e+00
.meas tran f_rr_ratio_t27 FIND v(f_rr_ratio) AT=2.537222e+00
.meas tran f_rr_asym_t27 FIND v(f_rr_asym) AT=2.537222e+00
.meas tran f_instab_l0_t27 FIND v(f_instab_l0) AT=2.537222e+00
.meas tran f_instab_l1_t27 FIND v(f_instab_l1) AT=2.537222e+00
.meas tran f_pwave_t27 FIND v(f_pwave) AT=2.537222e+00
.meas tran f_width_t27 FIND v(f_width) AT=2.537222e+00
.meas tran f_slope_t27 FIND v(f_slope) AT=2.537222e+00
.meas tran f_sym_t27 FIND v(f_sym) AT=2.537222e+00
.meas tran ecg_cond_l0_t27 FIND v(ecg_cond_l0) AT=2.537222e+00
.meas tran bpf_out_t27 FIND v(bpf_out) AT=2.537222e+00
.meas tran env_out_t27 FIND v(env_out) AT=2.537222e+00
.meas tran f_rr_ratio_t28 FIND v(f_rr_ratio) AT=2.557222e+00
.meas tran f_rr_asym_t28 FIND v(f_rr_asym) AT=2.557222e+00
.meas tran f_instab_l0_t28 FIND v(f_instab_l0) AT=2.557222e+00
.meas tran f_instab_l1_t28 FIND v(f_instab_l1) AT=2.557222e+00
.meas tran f_pwave_t28 FIND v(f_pwave) AT=2.557222e+00
.meas tran f_width_t28 FIND v(f_width) AT=2.557222e+00
.meas tran f_slope_t28 FIND v(f_slope) AT=2.557222e+00
.meas tran f_sym_t28 FIND v(f_sym) AT=2.557222e+00
.meas tran ecg_cond_l0_t28 FIND v(ecg_cond_l0) AT=2.557222e+00
.meas tran bpf_out_t28 FIND v(bpf_out) AT=2.557222e+00
.meas tran env_out_t28 FIND v(env_out) AT=2.557222e+00
.meas tran f_rr_ratio_t29 FIND v(f_rr_ratio) AT=2.577222e+00
.meas tran f_rr_asym_t29 FIND v(f_rr_asym) AT=2.577222e+00
.meas tran f_instab_l0_t29 FIND v(f_instab_l0) AT=2.577222e+00
.meas tran f_instab_l1_t29 FIND v(f_instab_l1) AT=2.577222e+00
.meas tran f_pwave_t29 FIND v(f_pwave) AT=2.577222e+00
.meas tran f_width_t29 FIND v(f_width) AT=2.577222e+00
.meas tran f_slope_t29 FIND v(f_slope) AT=2.577222e+00
.meas tran f_sym_t29 FIND v(f_sym) AT=2.577222e+00
.meas tran ecg_cond_l0_t29 FIND v(ecg_cond_l0) AT=2.577222e+00
.meas tran bpf_out_t29 FIND v(bpf_out) AT=2.577222e+00
.meas tran env_out_t29 FIND v(env_out) AT=2.577222e+00
.meas tran f_rr_ratio_t30 FIND v(f_rr_ratio) AT=2.597222e+00
.meas tran f_rr_asym_t30 FIND v(f_rr_asym) AT=2.597222e+00
.meas tran f_instab_l0_t30 FIND v(f_instab_l0) AT=2.597222e+00
.meas tran f_instab_l1_t30 FIND v(f_instab_l1) AT=2.597222e+00
.meas tran f_pwave_t30 FIND v(f_pwave) AT=2.597222e+00
.meas tran f_width_t30 FIND v(f_width) AT=2.597222e+00
.meas tran f_slope_t30 FIND v(f_slope) AT=2.597222e+00
.meas tran f_sym_t30 FIND v(f_sym) AT=2.597222e+00
.meas tran ecg_cond_l0_t30 FIND v(ecg_cond_l0) AT=2.597222e+00
.meas tran bpf_out_t30 FIND v(bpf_out) AT=2.597222e+00
.meas tran env_out_t30 FIND v(env_out) AT=2.597222e+00
.meas tran f_rr_ratio_t31 FIND v(f_rr_ratio) AT=2.617222e+00
.meas tran f_rr_asym_t31 FIND v(f_rr_asym) AT=2.617222e+00
.meas tran f_instab_l0_t31 FIND v(f_instab_l0) AT=2.617222e+00
.meas tran f_instab_l1_t31 FIND v(f_instab_l1) AT=2.617222e+00
.meas tran f_pwave_t31 FIND v(f_pwave) AT=2.617222e+00
.meas tran f_width_t31 FIND v(f_width) AT=2.617222e+00
.meas tran f_slope_t31 FIND v(f_slope) AT=2.617222e+00
.meas tran f_sym_t31 FIND v(f_sym) AT=2.617222e+00
.meas tran ecg_cond_l0_t31 FIND v(ecg_cond_l0) AT=2.617222e+00
.meas tran bpf_out_t31 FIND v(bpf_out) AT=2.617222e+00
.meas tran env_out_t31 FIND v(env_out) AT=2.617222e+00
.meas tran f_rr_ratio_t32 FIND v(f_rr_ratio) AT=2.637222e+00
.meas tran f_rr_asym_t32 FIND v(f_rr_asym) AT=2.637222e+00
.meas tran f_instab_l0_t32 FIND v(f_instab_l0) AT=2.637222e+00
.meas tran f_instab_l1_t32 FIND v(f_instab_l1) AT=2.637222e+00
.meas tran f_pwave_t32 FIND v(f_pwave) AT=2.637222e+00
.meas tran f_width_t32 FIND v(f_width) AT=2.637222e+00
.meas tran f_slope_t32 FIND v(f_slope) AT=2.637222e+00
.meas tran f_sym_t32 FIND v(f_sym) AT=2.637222e+00
.meas tran ecg_cond_l0_t32 FIND v(ecg_cond_l0) AT=2.637222e+00
.meas tran bpf_out_t32 FIND v(bpf_out) AT=2.637222e+00
.meas tran env_out_t32 FIND v(env_out) AT=2.637222e+00
.meas tran f_rr_ratio_t33 FIND v(f_rr_ratio) AT=2.657222e+00
.meas tran f_rr_asym_t33 FIND v(f_rr_asym) AT=2.657222e+00
.meas tran f_instab_l0_t33 FIND v(f_instab_l0) AT=2.657222e+00
.meas tran f_instab_l1_t33 FIND v(f_instab_l1) AT=2.657222e+00
.meas tran f_pwave_t33 FIND v(f_pwave) AT=2.657222e+00
.meas tran f_width_t33 FIND v(f_width) AT=2.657222e+00
.meas tran f_slope_t33 FIND v(f_slope) AT=2.657222e+00
.meas tran f_sym_t33 FIND v(f_sym) AT=2.657222e+00
.meas tran ecg_cond_l0_t33 FIND v(ecg_cond_l0) AT=2.657222e+00
.meas tran bpf_out_t33 FIND v(bpf_out) AT=2.657222e+00
.meas tran env_out_t33 FIND v(env_out) AT=2.657222e+00
.meas tran f_rr_ratio_t34 FIND v(f_rr_ratio) AT=2.677222e+00
.meas tran f_rr_asym_t34 FIND v(f_rr_asym) AT=2.677222e+00
.meas tran f_instab_l0_t34 FIND v(f_instab_l0) AT=2.677222e+00
.meas tran f_instab_l1_t34 FIND v(f_instab_l1) AT=2.677222e+00
.meas tran f_pwave_t34 FIND v(f_pwave) AT=2.677222e+00
.meas tran f_width_t34 FIND v(f_width) AT=2.677222e+00
.meas tran f_slope_t34 FIND v(f_slope) AT=2.677222e+00
.meas tran f_sym_t34 FIND v(f_sym) AT=2.677222e+00
.meas tran ecg_cond_l0_t34 FIND v(ecg_cond_l0) AT=2.677222e+00
.meas tran bpf_out_t34 FIND v(bpf_out) AT=2.677222e+00
.meas tran env_out_t34 FIND v(env_out) AT=2.677222e+00
.meas tran f_rr_ratio_t35 FIND v(f_rr_ratio) AT=2.697222e+00
.meas tran f_rr_asym_t35 FIND v(f_rr_asym) AT=2.697222e+00
.meas tran f_instab_l0_t35 FIND v(f_instab_l0) AT=2.697222e+00
.meas tran f_instab_l1_t35 FIND v(f_instab_l1) AT=2.697222e+00
.meas tran f_pwave_t35 FIND v(f_pwave) AT=2.697222e+00
.meas tran f_width_t35 FIND v(f_width) AT=2.697222e+00
.meas tran f_slope_t35 FIND v(f_slope) AT=2.697222e+00
.meas tran f_sym_t35 FIND v(f_sym) AT=2.697222e+00
.meas tran ecg_cond_l0_t35 FIND v(ecg_cond_l0) AT=2.697222e+00
.meas tran bpf_out_t35 FIND v(bpf_out) AT=2.697222e+00
.meas tran env_out_t35 FIND v(env_out) AT=2.697222e+00
.meas tran f_rr_ratio_t36 FIND v(f_rr_ratio) AT=2.717222e+00
.meas tran f_rr_asym_t36 FIND v(f_rr_asym) AT=2.717222e+00
.meas tran f_instab_l0_t36 FIND v(f_instab_l0) AT=2.717222e+00
.meas tran f_instab_l1_t36 FIND v(f_instab_l1) AT=2.717222e+00
.meas tran f_pwave_t36 FIND v(f_pwave) AT=2.717222e+00
.meas tran f_width_t36 FIND v(f_width) AT=2.717222e+00
.meas tran f_slope_t36 FIND v(f_slope) AT=2.717222e+00
.meas tran f_sym_t36 FIND v(f_sym) AT=2.717222e+00
.meas tran ecg_cond_l0_t36 FIND v(ecg_cond_l0) AT=2.717222e+00
.meas tran bpf_out_t36 FIND v(bpf_out) AT=2.717222e+00
.meas tran env_out_t36 FIND v(env_out) AT=2.717222e+00
.meas tran f_rr_ratio_t37 FIND v(f_rr_ratio) AT=2.737222e+00
.meas tran f_rr_asym_t37 FIND v(f_rr_asym) AT=2.737222e+00
.meas tran f_instab_l0_t37 FIND v(f_instab_l0) AT=2.737222e+00
.meas tran f_instab_l1_t37 FIND v(f_instab_l1) AT=2.737222e+00
.meas tran f_pwave_t37 FIND v(f_pwave) AT=2.737222e+00
.meas tran f_width_t37 FIND v(f_width) AT=2.737222e+00
.meas tran f_slope_t37 FIND v(f_slope) AT=2.737222e+00
.meas tran f_sym_t37 FIND v(f_sym) AT=2.737222e+00
.meas tran ecg_cond_l0_t37 FIND v(ecg_cond_l0) AT=2.737222e+00
.meas tran bpf_out_t37 FIND v(bpf_out) AT=2.737222e+00
.meas tran env_out_t37 FIND v(env_out) AT=2.737222e+00
.meas tran f_rr_ratio_t38 FIND v(f_rr_ratio) AT=2.757222e+00
.meas tran f_rr_asym_t38 FIND v(f_rr_asym) AT=2.757222e+00
.meas tran f_instab_l0_t38 FIND v(f_instab_l0) AT=2.757222e+00
.meas tran f_instab_l1_t38 FIND v(f_instab_l1) AT=2.757222e+00
.meas tran f_pwave_t38 FIND v(f_pwave) AT=2.757222e+00
.meas tran f_width_t38 FIND v(f_width) AT=2.757222e+00
.meas tran f_slope_t38 FIND v(f_slope) AT=2.757222e+00
.meas tran f_sym_t38 FIND v(f_sym) AT=2.757222e+00
.meas tran ecg_cond_l0_t38 FIND v(ecg_cond_l0) AT=2.757222e+00
.meas tran bpf_out_t38 FIND v(bpf_out) AT=2.757222e+00
.meas tran env_out_t38 FIND v(env_out) AT=2.757222e+00
.meas tran f_rr_ratio_t39 FIND v(f_rr_ratio) AT=2.777222e+00
.meas tran f_rr_asym_t39 FIND v(f_rr_asym) AT=2.777222e+00
.meas tran f_instab_l0_t39 FIND v(f_instab_l0) AT=2.777222e+00
.meas tran f_instab_l1_t39 FIND v(f_instab_l1) AT=2.777222e+00
.meas tran f_pwave_t39 FIND v(f_pwave) AT=2.777222e+00
.meas tran f_width_t39 FIND v(f_width) AT=2.777222e+00
.meas tran f_slope_t39 FIND v(f_slope) AT=2.777222e+00
.meas tran f_sym_t39 FIND v(f_sym) AT=2.777222e+00
.meas tran ecg_cond_l0_t39 FIND v(ecg_cond_l0) AT=2.777222e+00
.meas tran bpf_out_t39 FIND v(bpf_out) AT=2.777222e+00
.meas tran env_out_t39 FIND v(env_out) AT=2.777222e+00
.meas tran f_rr_ratio_t40 FIND v(f_rr_ratio) AT=2.797222e+00
.meas tran f_rr_asym_t40 FIND v(f_rr_asym) AT=2.797222e+00
.meas tran f_instab_l0_t40 FIND v(f_instab_l0) AT=2.797222e+00
.meas tran f_instab_l1_t40 FIND v(f_instab_l1) AT=2.797222e+00
.meas tran f_pwave_t40 FIND v(f_pwave) AT=2.797222e+00
.meas tran f_width_t40 FIND v(f_width) AT=2.797222e+00
.meas tran f_slope_t40 FIND v(f_slope) AT=2.797222e+00
.meas tran f_sym_t40 FIND v(f_sym) AT=2.797222e+00
.meas tran ecg_cond_l0_t40 FIND v(ecg_cond_l0) AT=2.797222e+00
.meas tran bpf_out_t40 FIND v(bpf_out) AT=2.797222e+00
.meas tran env_out_t40 FIND v(env_out) AT=2.797222e+00
.meas tran f_rr_ratio_t41 FIND v(f_rr_ratio) AT=2.817222e+00
.meas tran f_rr_asym_t41 FIND v(f_rr_asym) AT=2.817222e+00
.meas tran f_instab_l0_t41 FIND v(f_instab_l0) AT=2.817222e+00
.meas tran f_instab_l1_t41 FIND v(f_instab_l1) AT=2.817222e+00
.meas tran f_pwave_t41 FIND v(f_pwave) AT=2.817222e+00
.meas tran f_width_t41 FIND v(f_width) AT=2.817222e+00
.meas tran f_slope_t41 FIND v(f_slope) AT=2.817222e+00
.meas tran f_sym_t41 FIND v(f_sym) AT=2.817222e+00
.meas tran ecg_cond_l0_t41 FIND v(ecg_cond_l0) AT=2.817222e+00
.meas tran bpf_out_t41 FIND v(bpf_out) AT=2.817222e+00
.meas tran env_out_t41 FIND v(env_out) AT=2.817222e+00
.meas tran f_rr_ratio_t42 FIND v(f_rr_ratio) AT=2.837222e+00
.meas tran f_rr_asym_t42 FIND v(f_rr_asym) AT=2.837222e+00
.meas tran f_instab_l0_t42 FIND v(f_instab_l0) AT=2.837222e+00
.meas tran f_instab_l1_t42 FIND v(f_instab_l1) AT=2.837222e+00
.meas tran f_pwave_t42 FIND v(f_pwave) AT=2.837222e+00
.meas tran f_width_t42 FIND v(f_width) AT=2.837222e+00
.meas tran f_slope_t42 FIND v(f_slope) AT=2.837222e+00
.meas tran f_sym_t42 FIND v(f_sym) AT=2.837222e+00
.meas tran ecg_cond_l0_t42 FIND v(ecg_cond_l0) AT=2.837222e+00
.meas tran bpf_out_t42 FIND v(bpf_out) AT=2.837222e+00
.meas tran env_out_t42 FIND v(env_out) AT=2.837222e+00
.meas tran f_rr_ratio_pre120 FIND v(f_rr_ratio) AT=2.671667e+00
.meas tran f_rr_asym_pre120 FIND v(f_rr_asym) AT=2.671667e+00
.meas tran f_instab_l0_pre120 FIND v(f_instab_l0) AT=2.671667e+00
.meas tran f_instab_l1_pre120 FIND v(f_instab_l1) AT=2.671667e+00
.meas tran f_pwave_pre120 FIND v(f_pwave) AT=2.671667e+00
.meas tran f_width_pre120 FIND v(f_width) AT=2.671667e+00
.meas tran f_slope_pre120 FIND v(f_slope) AT=2.671667e+00
.meas tran f_sym_pre120 FIND v(f_sym) AT=2.671667e+00
.meas tran ecg_cond_l0_pre120 FIND v(ecg_cond_l0) AT=2.671667e+00
.meas tran bpf_out_pre120 FIND v(bpf_out) AT=2.671667e+00
.meas tran env_out_pre120 FIND v(env_out) AT=2.671667e+00
.meas tran f_rr_ratio_pre50 FIND v(f_rr_ratio) AT=2.741667e+00
.meas tran f_rr_asym_pre50 FIND v(f_rr_asym) AT=2.741667e+00
.meas tran f_instab_l0_pre50 FIND v(f_instab_l0) AT=2.741667e+00
.meas tran f_instab_l1_pre50 FIND v(f_instab_l1) AT=2.741667e+00
.meas tran f_pwave_pre50 FIND v(f_pwave) AT=2.741667e+00
.meas tran f_width_pre50 FIND v(f_width) AT=2.741667e+00
.meas tran f_slope_pre50 FIND v(f_slope) AT=2.741667e+00
.meas tran f_sym_pre50 FIND v(f_sym) AT=2.741667e+00
.meas tran ecg_cond_l0_pre50 FIND v(ecg_cond_l0) AT=2.741667e+00
.meas tran bpf_out_pre50 FIND v(bpf_out) AT=2.741667e+00
.meas tran env_out_pre50 FIND v(env_out) AT=2.741667e+00
.meas tran f_rr_ratio_pre20 FIND v(f_rr_ratio) AT=2.771667e+00
.meas tran f_rr_asym_pre20 FIND v(f_rr_asym) AT=2.771667e+00
.meas tran f_instab_l0_pre20 FIND v(f_instab_l0) AT=2.771667e+00
.meas tran f_instab_l1_pre20 FIND v(f_instab_l1) AT=2.771667e+00
.meas tran f_pwave_pre20 FIND v(f_pwave) AT=2.771667e+00
.meas tran f_width_pre20 FIND v(f_width) AT=2.771667e+00
.meas tran f_slope_pre20 FIND v(f_slope) AT=2.771667e+00
.meas tran f_sym_pre20 FIND v(f_sym) AT=2.771667e+00
.meas tran ecg_cond_l0_pre20 FIND v(ecg_cond_l0) AT=2.771667e+00
.meas tran bpf_out_pre20 FIND v(bpf_out) AT=2.771667e+00
.meas tran env_out_pre20 FIND v(env_out) AT=2.771667e+00
.meas tran f_rr_ratio_pre5 FIND v(f_rr_ratio) AT=2.786667e+00
.meas tran f_rr_asym_pre5 FIND v(f_rr_asym) AT=2.786667e+00
.meas tran f_instab_l0_pre5 FIND v(f_instab_l0) AT=2.786667e+00
.meas tran f_instab_l1_pre5 FIND v(f_instab_l1) AT=2.786667e+00
.meas tran f_pwave_pre5 FIND v(f_pwave) AT=2.786667e+00
.meas tran f_width_pre5 FIND v(f_width) AT=2.786667e+00
.meas tran f_slope_pre5 FIND v(f_slope) AT=2.786667e+00
.meas tran f_sym_pre5 FIND v(f_sym) AT=2.786667e+00
.meas tran ecg_cond_l0_pre5 FIND v(ecg_cond_l0) AT=2.786667e+00
.meas tran bpf_out_pre5 FIND v(bpf_out) AT=2.786667e+00
.meas tran env_out_pre5 FIND v(env_out) AT=2.786667e+00
.meas tran f_rr_ratio_pre1 FIND v(f_rr_ratio) AT=2.790667e+00
.meas tran f_rr_asym_pre1 FIND v(f_rr_asym) AT=2.790667e+00
.meas tran f_instab_l0_pre1 FIND v(f_instab_l0) AT=2.790667e+00
.meas tran f_instab_l1_pre1 FIND v(f_instab_l1) AT=2.790667e+00
.meas tran f_pwave_pre1 FIND v(f_pwave) AT=2.790667e+00
.meas tran f_width_pre1 FIND v(f_width) AT=2.790667e+00
.meas tran f_slope_pre1 FIND v(f_slope) AT=2.790667e+00
.meas tran f_sym_pre1 FIND v(f_sym) AT=2.790667e+00
.meas tran ecg_cond_l0_pre1 FIND v(ecg_cond_l0) AT=2.790667e+00
.meas tran bpf_out_pre1 FIND v(bpf_out) AT=2.790667e+00
.meas tran env_out_pre1 FIND v(env_out) AT=2.790667e+00
.meas tran f_rr_ratio_at_rp FIND v(f_rr_ratio) AT=2.791667e+00
.meas tran f_rr_asym_at_rp FIND v(f_rr_asym) AT=2.791667e+00
.meas tran f_instab_l0_at_rp FIND v(f_instab_l0) AT=2.791667e+00
.meas tran f_instab_l1_at_rp FIND v(f_instab_l1) AT=2.791667e+00
.meas tran f_pwave_at_rp FIND v(f_pwave) AT=2.791667e+00
.meas tran f_width_at_rp FIND v(f_width) AT=2.791667e+00
.meas tran f_slope_at_rp FIND v(f_slope) AT=2.791667e+00
.meas tran f_sym_at_rp FIND v(f_sym) AT=2.791667e+00
.meas tran ecg_cond_l0_at_rp FIND v(ecg_cond_l0) AT=2.791667e+00
.meas tran bpf_out_at_rp FIND v(bpf_out) AT=2.791667e+00
.meas tran env_out_at_rp FIND v(env_out) AT=2.791667e+00
.meas tran f_rr_ratio_post1 FIND v(f_rr_ratio) AT=2.792667e+00
.meas tran f_rr_asym_post1 FIND v(f_rr_asym) AT=2.792667e+00
.meas tran f_instab_l0_post1 FIND v(f_instab_l0) AT=2.792667e+00
.meas tran f_instab_l1_post1 FIND v(f_instab_l1) AT=2.792667e+00
.meas tran f_pwave_post1 FIND v(f_pwave) AT=2.792667e+00
.meas tran f_width_post1 FIND v(f_width) AT=2.792667e+00
.meas tran f_slope_post1 FIND v(f_slope) AT=2.792667e+00
.meas tran f_sym_post1 FIND v(f_sym) AT=2.792667e+00
.meas tran ecg_cond_l0_post1 FIND v(ecg_cond_l0) AT=2.792667e+00
.meas tran bpf_out_post1 FIND v(bpf_out) AT=2.792667e+00
.meas tran env_out_post1 FIND v(env_out) AT=2.792667e+00
.meas tran f_rr_ratio_post5 FIND v(f_rr_ratio) AT=2.796667e+00
.meas tran f_rr_asym_post5 FIND v(f_rr_asym) AT=2.796667e+00
.meas tran f_instab_l0_post5 FIND v(f_instab_l0) AT=2.796667e+00
.meas tran f_instab_l1_post5 FIND v(f_instab_l1) AT=2.796667e+00
.meas tran f_pwave_post5 FIND v(f_pwave) AT=2.796667e+00
.meas tran f_width_post5 FIND v(f_width) AT=2.796667e+00
.meas tran f_slope_post5 FIND v(f_slope) AT=2.796667e+00
.meas tran f_sym_post5 FIND v(f_sym) AT=2.796667e+00
.meas tran ecg_cond_l0_post5 FIND v(ecg_cond_l0) AT=2.796667e+00
.meas tran bpf_out_post5 FIND v(bpf_out) AT=2.796667e+00
.meas tran env_out_post5 FIND v(env_out) AT=2.796667e+00
.meas tran f_rr_ratio_post10 FIND v(f_rr_ratio) AT=2.801667e+00
.meas tran f_rr_asym_post10 FIND v(f_rr_asym) AT=2.801667e+00
.meas tran f_instab_l0_post10 FIND v(f_instab_l0) AT=2.801667e+00
.meas tran f_instab_l1_post10 FIND v(f_instab_l1) AT=2.801667e+00
.meas tran f_pwave_post10 FIND v(f_pwave) AT=2.801667e+00
.meas tran f_width_post10 FIND v(f_width) AT=2.801667e+00
.meas tran f_slope_post10 FIND v(f_slope) AT=2.801667e+00
.meas tran f_sym_post10 FIND v(f_sym) AT=2.801667e+00
.meas tran ecg_cond_l0_post10 FIND v(ecg_cond_l0) AT=2.801667e+00
.meas tran bpf_out_post10 FIND v(bpf_out) AT=2.801667e+00
.meas tran env_out_post10 FIND v(env_out) AT=2.801667e+00
.meas tran f_rr_ratio_post50 FIND v(f_rr_ratio) AT=2.841667e+00
.meas tran f_rr_asym_post50 FIND v(f_rr_asym) AT=2.841667e+00
.meas tran f_instab_l0_post50 FIND v(f_instab_l0) AT=2.841667e+00
.meas tran f_instab_l1_post50 FIND v(f_instab_l1) AT=2.841667e+00
.meas tran f_pwave_post50 FIND v(f_pwave) AT=2.841667e+00
.meas tran f_width_post50 FIND v(f_width) AT=2.841667e+00
.meas tran f_slope_post50 FIND v(f_slope) AT=2.841667e+00
.meas tran f_sym_post50 FIND v(f_sym) AT=2.841667e+00
.meas tran ecg_cond_l0_post50 FIND v(ecg_cond_l0) AT=2.841667e+00
.meas tran bpf_out_post50 FIND v(bpf_out) AT=2.841667e+00
.meas tran env_out_post50 FIND v(env_out) AT=2.841667e+00
.meas tran f_rr_ratio_post100 FIND v(f_rr_ratio) AT=2.891667e+00
.meas tran f_rr_asym_post100 FIND v(f_rr_asym) AT=2.891667e+00
.meas tran f_instab_l0_post100 FIND v(f_instab_l0) AT=2.891667e+00
.meas tran f_instab_l1_post100 FIND v(f_instab_l1) AT=2.891667e+00
.meas tran f_pwave_post100 FIND v(f_pwave) AT=2.891667e+00
.meas tran f_width_post100 FIND v(f_width) AT=2.891667e+00
.meas tran f_slope_post100 FIND v(f_slope) AT=2.891667e+00
.meas tran f_sym_post100 FIND v(f_sym) AT=2.891667e+00
.meas tran ecg_cond_l0_post100 FIND v(ecg_cond_l0) AT=2.891667e+00
.meas tran bpf_out_post100 FIND v(bpf_out) AT=2.891667e+00
.meas tran env_out_post100 FIND v(env_out) AT=2.891667e+00
.meas tran f_rr_ratio_post150 FIND v(f_rr_ratio) AT=2.941667e+00
.meas tran f_rr_asym_post150 FIND v(f_rr_asym) AT=2.941667e+00
.meas tran f_instab_l0_post150 FIND v(f_instab_l0) AT=2.941667e+00
.meas tran f_instab_l1_post150 FIND v(f_instab_l1) AT=2.941667e+00
.meas tran f_pwave_post150 FIND v(f_pwave) AT=2.941667e+00
.meas tran f_width_post150 FIND v(f_width) AT=2.941667e+00
.meas tran f_slope_post150 FIND v(f_slope) AT=2.941667e+00
.meas tran f_sym_post150 FIND v(f_sym) AT=2.941667e+00
.meas tran ecg_cond_l0_post150 FIND v(ecg_cond_l0) AT=2.941667e+00
.meas tran bpf_out_post150 FIND v(bpf_out) AT=2.941667e+00
.meas tran env_out_post150 FIND v(env_out) AT=2.941667e+00
.meas tran f_rr_ratio_post200 FIND v(f_rr_ratio) AT=2.991667e+00
.meas tran f_rr_asym_post200 FIND v(f_rr_asym) AT=2.991667e+00
.meas tran f_instab_l0_post200 FIND v(f_instab_l0) AT=2.991667e+00
.meas tran f_instab_l1_post200 FIND v(f_instab_l1) AT=2.991667e+00
.meas tran f_pwave_post200 FIND v(f_pwave) AT=2.991667e+00
.meas tran f_width_post200 FIND v(f_width) AT=2.991667e+00
.meas tran f_slope_post200 FIND v(f_slope) AT=2.991667e+00
.meas tran f_sym_post200 FIND v(f_sym) AT=2.991667e+00
.meas tran ecg_cond_l0_post200 FIND v(ecg_cond_l0) AT=2.991667e+00
.meas tran bpf_out_post200 FIND v(bpf_out) AT=2.991667e+00
.meas tran env_out_post200 FIND v(env_out) AT=2.991667e+00

.control
  run
  quit
.endc
.end
