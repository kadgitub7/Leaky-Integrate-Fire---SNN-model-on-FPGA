.title rr_timing_v5_test
.lib "sky130_minimal.lib.spice" tt
.option scale=1.0u method=gear reltol=0.01 gmin=1e-15
.temp 27
.include "rr_timing_v5.spice"

Vdd vdd 0 0.9
Vss vss 0 0
Vbias vbias 0 0.35
Vcapt capture_trig 0 PWL(0.0000000 0.000000 0.9915000 0.000000 0.9920000 0.900000 0.9970000 0.900000 0.9975000 0.000000 1.6470556 0.000000 1.6475556 0.900000 1.6525556 0.900000 1.6530556 0.000000 2.3192778 0.000000 2.3197778 0.900000 2.3247778 0.900000 2.3252778 0.000000 2.9553889 0.000000 2.9558889 0.900000 2.9608889 0.900000 2.9613889 0.000000 3.5803889 0.000000 3.5808889 0.900000 3.5858889 0.900000 3.5863889 0.000000 4.1803889 0.000000 4.1808889 0.900000 4.1858889 0.900000 4.1863889 0.000000 4.8081667 0.000000 4.8086667 0.900000 4.8136667 0.900000 4.8141667 0.000000 5.4248333 0.000000 5.4253333 0.900000 5.4303333 0.900000 5.4308333 0.000000 6.0720556 0.000000 6.0725556 0.900000 6.0775556 0.900000 6.0780556 0.000000 6.7276111 0.000000 6.7281111 0.900000 6.7331111 0.900000 6.7336111 0.000000 7.3776111 0.000000 7.3781111 0.900000 7.3831111 0.900000 7.3836111 0.000000 8.0081667 0.000000 8.0086667 0.900000 8.0136667 0.900000 8.0141667 0.000000 8.6415000 0.000000 8.6420000 0.900000 8.6470000 0.900000 8.6475000 0.000000 9.2609444 0.000000 9.2614444 0.900000 9.2664444 0.900000 9.2669444 0.000000 9.8609444 0.000000 9.8614444 0.900000 9.8664444 0.900000 9.8669444 0.000000 10.4442778 0.000000 10.4447778 0.900000 10.4497778 0.900000 10.4502778 0.000000 11.0498333 0.000000 11.0503333 0.900000 11.0553333 0.900000 11.0558333 0.000000 11.6609444 0.000000 11.6614444 0.900000 11.6664444 0.900000 11.6669444 0.000000 12.2998333 0.000000 12.3003333 0.900000 12.3053333 0.900000 12.3058333 0.000000 12.9498333 0.000000 12.9503333 0.900000 12.9553333 0.900000 12.9558333 0.000000 13.5831667 0.000000 13.5836667 0.900000 13.5886667 0.900000 13.5891667 0.000000 14.2137222 0.000000 14.2142222 0.900000 14.2192222 0.900000 14.2197222 0.000000 14.8026111 0.000000 14.8031111 0.900000 14.8081111 0.900000 14.8086111 0.000000 15.4220556 0.000000 15.4225556 0.900000 15.4275556 0.900000 15.4280556 0.000000 16.0165000 0.000000 16.0170000 0.900000 16.0220000 0.900000 16.0225000 0.000000 16.6331667 0.000000 16.6336667 0.900000 16.6386667 0.900000 16.6391667 0.000000 17.2331667 0.000000 17.2336667 0.900000 17.2386667 0.900000 17.2391667 0.000000 17.8526111 0.000000 17.8531111 0.900000 17.8581111 0.900000 17.8586111 0.000000 18.4831667 0.000000 18.4836667 0.900000 18.4886667 0.900000 18.4891667 0.000000 19.1498333 0.000000 19.1503333 0.900000 19.1553333 0.900000 19.1558333 0.000000 19.8248333 0.000000 19.8253333 0.900000 19.8303333 0.900000 19.8308333 0.000000 20.4498333 0.000000 20.4503333 0.900000 20.4553333 0.900000 20.4558333 0.000000 21.0609444 0.000000 21.0614444 0.900000 21.0664444 0.900000 21.0669444 0.000000 21.6859444 0.000000 21.6864444 0.900000 21.6914444 0.900000 21.6919444 0.000000 22.3359444 0.000000 22.3364444 0.900000 22.3414444 0.900000 22.3419444 0.000000 22.9637222 0.000000 22.9642222 0.900000 22.9692222 0.900000 22.9697222 0.000000 23.5915000 0.000000 23.5920000 0.900000 23.5970000 0.900000 23.5975000 0.000000 24.2498333 0.000000 24.2503333 0.900000 24.2553333 0.900000 24.2558333 0.000000 24.9220556 0.000000 24.9225556 0.900000 24.9275556 0.900000 24.9280556 0.000000 25.6053889 0.000000 25.6058889 0.900000 25.6108889 0.900000 25.6113889 0.000000 26.2803889 0.000000 26.2808889 0.900000 26.2858889 0.900000 26.2863889 0.000000 26.9165000 0.000000 26.9170000 0.900000 26.9220000 0.900000 26.9225000 0.000000 27.5415000 0.000000 27.5420000 0.900000 27.5470000 0.900000 27.5475000 0.000000 28.1803889 0.000000 28.1808889 0.900000 28.1858889 0.900000 28.1863889 0.000000 28.8331667 0.000000 28.8336667 0.900000 28.8386667 0.900000 28.8391667 0.000000 29.4970556 0.000000 29.4975556 0.900000 29.5025556 0.900000 29.5030556 0.000000 30.1498333 0.000000 30.1503333 0.900000 30.1553333 0.900000 30.1558333 0.000000 30.8331667 0.000000 30.8336667 0.900000 30.8386667 0.900000 30.8391667 0.000000 31.5192778 0.000000 31.5197778 0.900000 31.5247778 0.900000 31.5252778 0.000000 32.2026111 0.000000 32.2031111 0.900000 32.2081111 0.900000 32.2086111 0.000000 33.2111111 0.000000)
Vrpeak rpeak_trigger 0 PWL(0.0000000 0.000000 0.9990000 0.000000 1.0000000 0.900000 1.0050000 0.900000 1.0060000 0.000000 1.6545556 0.000000 1.6555556 0.900000 1.6605556 0.900000 1.6615556 0.000000 2.3267778 0.000000 2.3277778 0.900000 2.3327778 0.900000 2.3337778 0.000000 2.9628889 0.000000 2.9638889 0.900000 2.9688889 0.900000 2.9698889 0.000000 3.5878889 0.000000 3.5888889 0.900000 3.5938889 0.900000 3.5948889 0.000000 4.1878889 0.000000 4.1888889 0.900000 4.1938889 0.900000 4.1948889 0.000000 4.8156667 0.000000 4.8166667 0.900000 4.8216667 0.900000 4.8226667 0.000000 5.4323333 0.000000 5.4333333 0.900000 5.4383333 0.900000 5.4393333 0.000000 6.0795556 0.000000 6.0805556 0.900000 6.0855556 0.900000 6.0865556 0.000000 6.7351111 0.000000 6.7361111 0.900000 6.7411111 0.900000 6.7421111 0.000000 7.3851111 0.000000 7.3861111 0.900000 7.3911111 0.900000 7.3921111 0.000000 8.0156667 0.000000 8.0166667 0.900000 8.0216667 0.900000 8.0226667 0.000000 8.6490000 0.000000 8.6500000 0.900000 8.6550000 0.900000 8.6560000 0.000000 9.2684444 0.000000 9.2694444 0.900000 9.2744444 0.900000 9.2754444 0.000000 9.8684444 0.000000 9.8694444 0.900000 9.8744444 0.900000 9.8754444 0.000000 10.4517778 0.000000 10.4527778 0.900000 10.4577778 0.900000 10.4587778 0.000000 11.0573333 0.000000 11.0583333 0.900000 11.0633333 0.900000 11.0643333 0.000000 11.6684444 0.000000 11.6694444 0.900000 11.6744444 0.900000 11.6754444 0.000000 12.3073333 0.000000 12.3083333 0.900000 12.3133333 0.900000 12.3143333 0.000000 12.9573333 0.000000 12.9583333 0.900000 12.9633333 0.900000 12.9643333 0.000000 13.5906667 0.000000 13.5916667 0.900000 13.5966667 0.900000 13.5976667 0.000000 14.2212222 0.000000 14.2222222 0.900000 14.2272222 0.900000 14.2282222 0.000000 14.8101111 0.000000 14.8111111 0.900000 14.8161111 0.900000 14.8171111 0.000000 15.4295556 0.000000 15.4305556 0.900000 15.4355556 0.900000 15.4365556 0.000000 16.0240000 0.000000 16.0250000 0.900000 16.0300000 0.900000 16.0310000 0.000000 16.6406667 0.000000 16.6416667 0.900000 16.6466667 0.900000 16.6476667 0.000000 17.2406667 0.000000 17.2416667 0.900000 17.2466667 0.900000 17.2476667 0.000000 17.8601111 0.000000 17.8611111 0.900000 17.8661111 0.900000 17.8671111 0.000000 18.4906667 0.000000 18.4916667 0.900000 18.4966667 0.900000 18.4976667 0.000000 19.1573333 0.000000 19.1583333 0.900000 19.1633333 0.900000 19.1643333 0.000000 19.8323333 0.000000 19.8333333 0.900000 19.8383333 0.900000 19.8393333 0.000000 20.4573333 0.000000 20.4583333 0.900000 20.4633333 0.900000 20.4643333 0.000000 21.0684444 0.000000 21.0694444 0.900000 21.0744444 0.900000 21.0754444 0.000000 21.6934444 0.000000 21.6944444 0.900000 21.6994444 0.900000 21.7004444 0.000000 22.3434444 0.000000 22.3444444 0.900000 22.3494444 0.900000 22.3504444 0.000000 22.9712222 0.000000 22.9722222 0.900000 22.9772222 0.900000 22.9782222 0.000000 23.5990000 0.000000 23.6000000 0.900000 23.6050000 0.900000 23.6060000 0.000000 24.2573333 0.000000 24.2583333 0.900000 24.2633333 0.900000 24.2643333 0.000000 24.9295556 0.000000 24.9305556 0.900000 24.9355556 0.900000 24.9365556 0.000000 25.6128889 0.000000 25.6138889 0.900000 25.6188889 0.900000 25.6198889 0.000000 26.2878889 0.000000 26.2888889 0.900000 26.2938889 0.900000 26.2948889 0.000000 26.9240000 0.000000 26.9250000 0.900000 26.9300000 0.900000 26.9310000 0.000000 27.5490000 0.000000 27.5500000 0.900000 27.5550000 0.900000 27.5560000 0.000000 28.1878889 0.000000 28.1888889 0.900000 28.1938889 0.900000 28.1948889 0.000000 28.8406667 0.000000 28.8416667 0.900000 28.8466667 0.900000 28.8476667 0.000000 29.5045556 0.000000 29.5055556 0.900000 29.5105556 0.900000 29.5115556 0.000000 30.1573333 0.000000 30.1583333 0.900000 30.1633333 0.900000 30.1643333 0.000000 30.8406667 0.000000 30.8416667 0.900000 30.8466667 0.900000 30.8476667 0.000000 31.5267778 0.000000 31.5277778 0.900000 31.5327778 0.900000 31.5337778 0.000000 32.2101111 0.000000 32.2111111 0.900000 32.2161111 0.900000 32.2171111 0.000000 33.2111111 0.000000)
Vcopy copy_trig 0 PWL(0.0000000 0.000000 1.0095000 0.000000 1.0100000 0.900000 1.0120000 0.900000 1.0125000 0.000000 1.6650556 0.000000 1.6655556 0.900000 1.6675556 0.900000 1.6680556 0.000000 2.3372778 0.000000 2.3377778 0.900000 2.3397778 0.900000 2.3402778 0.000000 2.9733889 0.000000 2.9738889 0.900000 2.9758889 0.900000 2.9763889 0.000000 3.5983889 0.000000 3.5988889 0.900000 3.6008889 0.900000 3.6013889 0.000000 4.1983889 0.000000 4.1988889 0.900000 4.2008889 0.900000 4.2013889 0.000000 4.8261667 0.000000 4.8266667 0.900000 4.8286667 0.900000 4.8291667 0.000000 5.4428333 0.000000 5.4433333 0.900000 5.4453333 0.900000 5.4458333 0.000000 6.0900556 0.000000 6.0905556 0.900000 6.0925556 0.900000 6.0930556 0.000000 6.7456111 0.000000 6.7461111 0.900000 6.7481111 0.900000 6.7486111 0.000000 7.3956111 0.000000 7.3961111 0.900000 7.3981111 0.900000 7.3986111 0.000000 8.0261667 0.000000 8.0266667 0.900000 8.0286667 0.900000 8.0291667 0.000000 8.6595000 0.000000 8.6600000 0.900000 8.6620000 0.900000 8.6625000 0.000000 9.2789444 0.000000 9.2794444 0.900000 9.2814444 0.900000 9.2819444 0.000000 9.8789444 0.000000 9.8794444 0.900000 9.8814444 0.900000 9.8819444 0.000000 10.4622778 0.000000 10.4627778 0.900000 10.4647778 0.900000 10.4652778 0.000000 11.0678333 0.000000 11.0683333 0.900000 11.0703333 0.900000 11.0708333 0.000000 11.6789444 0.000000 11.6794444 0.900000 11.6814444 0.900000 11.6819444 0.000000 12.3178333 0.000000 12.3183333 0.900000 12.3203333 0.900000 12.3208333 0.000000 12.9678333 0.000000 12.9683333 0.900000 12.9703333 0.900000 12.9708333 0.000000 13.6011667 0.000000 13.6016667 0.900000 13.6036667 0.900000 13.6041667 0.000000 14.2317222 0.000000 14.2322222 0.900000 14.2342222 0.900000 14.2347222 0.000000 14.8206111 0.000000 14.8211111 0.900000 14.8231111 0.900000 14.8236111 0.000000 15.4400556 0.000000 15.4405556 0.900000 15.4425556 0.900000 15.4430556 0.000000 16.0345000 0.000000 16.0350000 0.900000 16.0370000 0.900000 16.0375000 0.000000 16.6511667 0.000000 16.6516667 0.900000 16.6536667 0.900000 16.6541667 0.000000 17.2511667 0.000000 17.2516667 0.900000 17.2536667 0.900000 17.2541667 0.000000 17.8706111 0.000000 17.8711111 0.900000 17.8731111 0.900000 17.8736111 0.000000 18.5011667 0.000000 18.5016667 0.900000 18.5036667 0.900000 18.5041667 0.000000 19.1678333 0.000000 19.1683333 0.900000 19.1703333 0.900000 19.1708333 0.000000 19.8428333 0.000000 19.8433333 0.900000 19.8453333 0.900000 19.8458333 0.000000 20.4678333 0.000000 20.4683333 0.900000 20.4703333 0.900000 20.4708333 0.000000 21.0789444 0.000000 21.0794444 0.900000 21.0814444 0.900000 21.0819444 0.000000 21.7039444 0.000000 21.7044444 0.900000 21.7064444 0.900000 21.7069444 0.000000 22.3539444 0.000000 22.3544444 0.900000 22.3564444 0.900000 22.3569444 0.000000 22.9817222 0.000000 22.9822222 0.900000 22.9842222 0.900000 22.9847222 0.000000 23.6095000 0.000000 23.6100000 0.900000 23.6120000 0.900000 23.6125000 0.000000 24.2678333 0.000000 24.2683333 0.900000 24.2703333 0.900000 24.2708333 0.000000 24.9400556 0.000000 24.9405556 0.900000 24.9425556 0.900000 24.9430556 0.000000 25.6233889 0.000000 25.6238889 0.900000 25.6258889 0.900000 25.6263889 0.000000 26.2983889 0.000000 26.2988889 0.900000 26.3008889 0.900000 26.3013889 0.000000 26.9345000 0.000000 26.9350000 0.900000 26.9370000 0.900000 26.9375000 0.000000 27.5595000 0.000000 27.5600000 0.900000 27.5620000 0.900000 27.5625000 0.000000 28.1983889 0.000000 28.1988889 0.900000 28.2008889 0.900000 28.2013889 0.000000 28.8511667 0.000000 28.8516667 0.900000 28.8536667 0.900000 28.8541667 0.000000 29.5150556 0.000000 29.5155556 0.900000 29.5175556 0.900000 29.5180556 0.000000 30.1678333 0.000000 30.1683333 0.900000 30.1703333 0.900000 30.1708333 0.000000 30.8511667 0.000000 30.8516667 0.900000 30.8536667 0.900000 30.8541667 0.000000 31.5372778 0.000000 31.5377778 0.900000 31.5397778 0.900000 31.5402778 0.000000 32.2206111 0.000000 32.2211111 0.900000 32.2231111 0.900000 32.2236111 0.000000 33.2111111 0.000000)

Xrr capture_trig rpeak_trigger copy_trig rr_ratio_out rr_asym_out vdd vss vbias rr_timing_v5

.tran 0.5m 33.2111

.meas tran timer_b0 FIND V(Xrr.net_timer) AT=0.9900000
.meas tran sf_b0 FIND V(Xrr.sf_out) AT=0.9900000
.meas tran prev_b0 FIND V(Xrr.prev_node) AT=0.9900000
.meas tran ewma_b0 FIND V(Xrr.ewma_node) AT=0.9900000
.meas tran ratio_b0 FIND V(rr_ratio_out) AT=0.9900000
.meas tran asym_b0 FIND V(rr_asym_out) AT=0.9900000
.meas tran prev_capt_b0 FIND V(Xrr.prev_node) AT=0.9980000
.meas tran sf_capt_b0 FIND V(Xrr.sf_out) AT=0.9980000
.meas tran timer_b1 FIND V(Xrr.net_timer) AT=1.6455556
.meas tran sf_b1 FIND V(Xrr.sf_out) AT=1.6455556
.meas tran prev_b1 FIND V(Xrr.prev_node) AT=1.6455556
.meas tran ewma_b1 FIND V(Xrr.ewma_node) AT=1.6455556
.meas tran ratio_b1 FIND V(rr_ratio_out) AT=1.6455556
.meas tran asym_b1 FIND V(rr_asym_out) AT=1.6455556
.meas tran prev_capt_b1 FIND V(Xrr.prev_node) AT=1.6535556
.meas tran sf_capt_b1 FIND V(Xrr.sf_out) AT=1.6535556
.meas tran timer_b2 FIND V(Xrr.net_timer) AT=2.3177778
.meas tran sf_b2 FIND V(Xrr.sf_out) AT=2.3177778
.meas tran prev_b2 FIND V(Xrr.prev_node) AT=2.3177778
.meas tran ewma_b2 FIND V(Xrr.ewma_node) AT=2.3177778
.meas tran ratio_b2 FIND V(rr_ratio_out) AT=2.3177778
.meas tran asym_b2 FIND V(rr_asym_out) AT=2.3177778
.meas tran prev_capt_b2 FIND V(Xrr.prev_node) AT=2.3257778
.meas tran sf_capt_b2 FIND V(Xrr.sf_out) AT=2.3257778
.meas tran timer_b3 FIND V(Xrr.net_timer) AT=2.9538889
.meas tran sf_b3 FIND V(Xrr.sf_out) AT=2.9538889
.meas tran prev_b3 FIND V(Xrr.prev_node) AT=2.9538889
.meas tran ewma_b3 FIND V(Xrr.ewma_node) AT=2.9538889
.meas tran ratio_b3 FIND V(rr_ratio_out) AT=2.9538889
.meas tran asym_b3 FIND V(rr_asym_out) AT=2.9538889
.meas tran prev_capt_b3 FIND V(Xrr.prev_node) AT=2.9618889
.meas tran sf_capt_b3 FIND V(Xrr.sf_out) AT=2.9618889
.meas tran timer_b4 FIND V(Xrr.net_timer) AT=3.5788889
.meas tran sf_b4 FIND V(Xrr.sf_out) AT=3.5788889
.meas tran prev_b4 FIND V(Xrr.prev_node) AT=3.5788889
.meas tran ewma_b4 FIND V(Xrr.ewma_node) AT=3.5788889
.meas tran ratio_b4 FIND V(rr_ratio_out) AT=3.5788889
.meas tran asym_b4 FIND V(rr_asym_out) AT=3.5788889
.meas tran prev_capt_b4 FIND V(Xrr.prev_node) AT=3.5868889
.meas tran sf_capt_b4 FIND V(Xrr.sf_out) AT=3.5868889
.meas tran timer_b5 FIND V(Xrr.net_timer) AT=4.1788889
.meas tran sf_b5 FIND V(Xrr.sf_out) AT=4.1788889
.meas tran prev_b5 FIND V(Xrr.prev_node) AT=4.1788889
.meas tran ewma_b5 FIND V(Xrr.ewma_node) AT=4.1788889
.meas tran ratio_b5 FIND V(rr_ratio_out) AT=4.1788889
.meas tran asym_b5 FIND V(rr_asym_out) AT=4.1788889
.meas tran prev_capt_b5 FIND V(Xrr.prev_node) AT=4.1868889
.meas tran sf_capt_b5 FIND V(Xrr.sf_out) AT=4.1868889
.meas tran timer_b6 FIND V(Xrr.net_timer) AT=4.8066667
.meas tran sf_b6 FIND V(Xrr.sf_out) AT=4.8066667
.meas tran prev_b6 FIND V(Xrr.prev_node) AT=4.8066667
.meas tran ewma_b6 FIND V(Xrr.ewma_node) AT=4.8066667
.meas tran ratio_b6 FIND V(rr_ratio_out) AT=4.8066667
.meas tran asym_b6 FIND V(rr_asym_out) AT=4.8066667
.meas tran prev_capt_b6 FIND V(Xrr.prev_node) AT=4.8146667
.meas tran sf_capt_b6 FIND V(Xrr.sf_out) AT=4.8146667
.meas tran timer_b7 FIND V(Xrr.net_timer) AT=5.4233333
.meas tran sf_b7 FIND V(Xrr.sf_out) AT=5.4233333
.meas tran prev_b7 FIND V(Xrr.prev_node) AT=5.4233333
.meas tran ewma_b7 FIND V(Xrr.ewma_node) AT=5.4233333
.meas tran ratio_b7 FIND V(rr_ratio_out) AT=5.4233333
.meas tran asym_b7 FIND V(rr_asym_out) AT=5.4233333
.meas tran prev_capt_b7 FIND V(Xrr.prev_node) AT=5.4313333
.meas tran sf_capt_b7 FIND V(Xrr.sf_out) AT=5.4313333
.meas tran timer_b8 FIND V(Xrr.net_timer) AT=6.0705556
.meas tran sf_b8 FIND V(Xrr.sf_out) AT=6.0705556
.meas tran prev_b8 FIND V(Xrr.prev_node) AT=6.0705556
.meas tran ewma_b8 FIND V(Xrr.ewma_node) AT=6.0705556
.meas tran ratio_b8 FIND V(rr_ratio_out) AT=6.0705556
.meas tran asym_b8 FIND V(rr_asym_out) AT=6.0705556
.meas tran prev_capt_b8 FIND V(Xrr.prev_node) AT=6.0785556
.meas tran sf_capt_b8 FIND V(Xrr.sf_out) AT=6.0785556
.meas tran timer_b9 FIND V(Xrr.net_timer) AT=6.7261111
.meas tran sf_b9 FIND V(Xrr.sf_out) AT=6.7261111
.meas tran prev_b9 FIND V(Xrr.prev_node) AT=6.7261111
.meas tran ewma_b9 FIND V(Xrr.ewma_node) AT=6.7261111
.meas tran ratio_b9 FIND V(rr_ratio_out) AT=6.7261111
.meas tran asym_b9 FIND V(rr_asym_out) AT=6.7261111
.meas tran prev_capt_b9 FIND V(Xrr.prev_node) AT=6.7341111
.meas tran sf_capt_b9 FIND V(Xrr.sf_out) AT=6.7341111
.meas tran timer_b10 FIND V(Xrr.net_timer) AT=7.3761111
.meas tran sf_b10 FIND V(Xrr.sf_out) AT=7.3761111
.meas tran prev_b10 FIND V(Xrr.prev_node) AT=7.3761111
.meas tran ewma_b10 FIND V(Xrr.ewma_node) AT=7.3761111
.meas tran ratio_b10 FIND V(rr_ratio_out) AT=7.3761111
.meas tran asym_b10 FIND V(rr_asym_out) AT=7.3761111
.meas tran prev_capt_b10 FIND V(Xrr.prev_node) AT=7.3841111
.meas tran sf_capt_b10 FIND V(Xrr.sf_out) AT=7.3841111
.meas tran timer_b11 FIND V(Xrr.net_timer) AT=8.0066667
.meas tran sf_b11 FIND V(Xrr.sf_out) AT=8.0066667
.meas tran prev_b11 FIND V(Xrr.prev_node) AT=8.0066667
.meas tran ewma_b11 FIND V(Xrr.ewma_node) AT=8.0066667
.meas tran ratio_b11 FIND V(rr_ratio_out) AT=8.0066667
.meas tran asym_b11 FIND V(rr_asym_out) AT=8.0066667
.meas tran prev_capt_b11 FIND V(Xrr.prev_node) AT=8.0146667
.meas tran sf_capt_b11 FIND V(Xrr.sf_out) AT=8.0146667
.meas tran timer_b12 FIND V(Xrr.net_timer) AT=8.6400000
.meas tran sf_b12 FIND V(Xrr.sf_out) AT=8.6400000
.meas tran prev_b12 FIND V(Xrr.prev_node) AT=8.6400000
.meas tran ewma_b12 FIND V(Xrr.ewma_node) AT=8.6400000
.meas tran ratio_b12 FIND V(rr_ratio_out) AT=8.6400000
.meas tran asym_b12 FIND V(rr_asym_out) AT=8.6400000
.meas tran prev_capt_b12 FIND V(Xrr.prev_node) AT=8.6480000
.meas tran sf_capt_b12 FIND V(Xrr.sf_out) AT=8.6480000
.meas tran timer_b13 FIND V(Xrr.net_timer) AT=9.2594444
.meas tran sf_b13 FIND V(Xrr.sf_out) AT=9.2594444
.meas tran prev_b13 FIND V(Xrr.prev_node) AT=9.2594444
.meas tran ewma_b13 FIND V(Xrr.ewma_node) AT=9.2594444
.meas tran ratio_b13 FIND V(rr_ratio_out) AT=9.2594444
.meas tran asym_b13 FIND V(rr_asym_out) AT=9.2594444
.meas tran prev_capt_b13 FIND V(Xrr.prev_node) AT=9.2674444
.meas tran sf_capt_b13 FIND V(Xrr.sf_out) AT=9.2674444
.meas tran timer_b14 FIND V(Xrr.net_timer) AT=9.8594444
.meas tran sf_b14 FIND V(Xrr.sf_out) AT=9.8594444
.meas tran prev_b14 FIND V(Xrr.prev_node) AT=9.8594444
.meas tran ewma_b14 FIND V(Xrr.ewma_node) AT=9.8594444
.meas tran ratio_b14 FIND V(rr_ratio_out) AT=9.8594444
.meas tran asym_b14 FIND V(rr_asym_out) AT=9.8594444
.meas tran prev_capt_b14 FIND V(Xrr.prev_node) AT=9.8674444
.meas tran sf_capt_b14 FIND V(Xrr.sf_out) AT=9.8674444
.meas tran timer_b15 FIND V(Xrr.net_timer) AT=10.4427778
.meas tran sf_b15 FIND V(Xrr.sf_out) AT=10.4427778
.meas tran prev_b15 FIND V(Xrr.prev_node) AT=10.4427778
.meas tran ewma_b15 FIND V(Xrr.ewma_node) AT=10.4427778
.meas tran ratio_b15 FIND V(rr_ratio_out) AT=10.4427778
.meas tran asym_b15 FIND V(rr_asym_out) AT=10.4427778
.meas tran prev_capt_b15 FIND V(Xrr.prev_node) AT=10.4507778
.meas tran sf_capt_b15 FIND V(Xrr.sf_out) AT=10.4507778
.meas tran timer_b16 FIND V(Xrr.net_timer) AT=11.0483333
.meas tran sf_b16 FIND V(Xrr.sf_out) AT=11.0483333
.meas tran prev_b16 FIND V(Xrr.prev_node) AT=11.0483333
.meas tran ewma_b16 FIND V(Xrr.ewma_node) AT=11.0483333
.meas tran ratio_b16 FIND V(rr_ratio_out) AT=11.0483333
.meas tran asym_b16 FIND V(rr_asym_out) AT=11.0483333
.meas tran prev_capt_b16 FIND V(Xrr.prev_node) AT=11.0563333
.meas tran sf_capt_b16 FIND V(Xrr.sf_out) AT=11.0563333
.meas tran timer_b17 FIND V(Xrr.net_timer) AT=11.6594444
.meas tran sf_b17 FIND V(Xrr.sf_out) AT=11.6594444
.meas tran prev_b17 FIND V(Xrr.prev_node) AT=11.6594444
.meas tran ewma_b17 FIND V(Xrr.ewma_node) AT=11.6594444
.meas tran ratio_b17 FIND V(rr_ratio_out) AT=11.6594444
.meas tran asym_b17 FIND V(rr_asym_out) AT=11.6594444
.meas tran prev_capt_b17 FIND V(Xrr.prev_node) AT=11.6674444
.meas tran sf_capt_b17 FIND V(Xrr.sf_out) AT=11.6674444
.meas tran timer_b18 FIND V(Xrr.net_timer) AT=12.2983333
.meas tran sf_b18 FIND V(Xrr.sf_out) AT=12.2983333
.meas tran prev_b18 FIND V(Xrr.prev_node) AT=12.2983333
.meas tran ewma_b18 FIND V(Xrr.ewma_node) AT=12.2983333
.meas tran ratio_b18 FIND V(rr_ratio_out) AT=12.2983333
.meas tran asym_b18 FIND V(rr_asym_out) AT=12.2983333
.meas tran prev_capt_b18 FIND V(Xrr.prev_node) AT=12.3063333
.meas tran sf_capt_b18 FIND V(Xrr.sf_out) AT=12.3063333
.meas tran timer_b19 FIND V(Xrr.net_timer) AT=12.9483333
.meas tran sf_b19 FIND V(Xrr.sf_out) AT=12.9483333
.meas tran prev_b19 FIND V(Xrr.prev_node) AT=12.9483333
.meas tran ewma_b19 FIND V(Xrr.ewma_node) AT=12.9483333
.meas tran ratio_b19 FIND V(rr_ratio_out) AT=12.9483333
.meas tran asym_b19 FIND V(rr_asym_out) AT=12.9483333
.meas tran prev_capt_b19 FIND V(Xrr.prev_node) AT=12.9563333
.meas tran sf_capt_b19 FIND V(Xrr.sf_out) AT=12.9563333
.meas tran timer_b20 FIND V(Xrr.net_timer) AT=13.5816667
.meas tran sf_b20 FIND V(Xrr.sf_out) AT=13.5816667
.meas tran prev_b20 FIND V(Xrr.prev_node) AT=13.5816667
.meas tran ewma_b20 FIND V(Xrr.ewma_node) AT=13.5816667
.meas tran ratio_b20 FIND V(rr_ratio_out) AT=13.5816667
.meas tran asym_b20 FIND V(rr_asym_out) AT=13.5816667
.meas tran prev_capt_b20 FIND V(Xrr.prev_node) AT=13.5896667
.meas tran sf_capt_b20 FIND V(Xrr.sf_out) AT=13.5896667
.meas tran timer_b21 FIND V(Xrr.net_timer) AT=14.2122222
.meas tran sf_b21 FIND V(Xrr.sf_out) AT=14.2122222
.meas tran prev_b21 FIND V(Xrr.prev_node) AT=14.2122222
.meas tran ewma_b21 FIND V(Xrr.ewma_node) AT=14.2122222
.meas tran ratio_b21 FIND V(rr_ratio_out) AT=14.2122222
.meas tran asym_b21 FIND V(rr_asym_out) AT=14.2122222
.meas tran prev_capt_b21 FIND V(Xrr.prev_node) AT=14.2202222
.meas tran sf_capt_b21 FIND V(Xrr.sf_out) AT=14.2202222
.meas tran timer_b22 FIND V(Xrr.net_timer) AT=14.8011111
.meas tran sf_b22 FIND V(Xrr.sf_out) AT=14.8011111
.meas tran prev_b22 FIND V(Xrr.prev_node) AT=14.8011111
.meas tran ewma_b22 FIND V(Xrr.ewma_node) AT=14.8011111
.meas tran ratio_b22 FIND V(rr_ratio_out) AT=14.8011111
.meas tran asym_b22 FIND V(rr_asym_out) AT=14.8011111
.meas tran prev_capt_b22 FIND V(Xrr.prev_node) AT=14.8091111
.meas tran sf_capt_b22 FIND V(Xrr.sf_out) AT=14.8091111
.meas tran timer_b23 FIND V(Xrr.net_timer) AT=15.4205556
.meas tran sf_b23 FIND V(Xrr.sf_out) AT=15.4205556
.meas tran prev_b23 FIND V(Xrr.prev_node) AT=15.4205556
.meas tran ewma_b23 FIND V(Xrr.ewma_node) AT=15.4205556
.meas tran ratio_b23 FIND V(rr_ratio_out) AT=15.4205556
.meas tran asym_b23 FIND V(rr_asym_out) AT=15.4205556
.meas tran prev_capt_b23 FIND V(Xrr.prev_node) AT=15.4285556
.meas tran sf_capt_b23 FIND V(Xrr.sf_out) AT=15.4285556
.meas tran timer_b24 FIND V(Xrr.net_timer) AT=16.0150000
.meas tran sf_b24 FIND V(Xrr.sf_out) AT=16.0150000
.meas tran prev_b24 FIND V(Xrr.prev_node) AT=16.0150000
.meas tran ewma_b24 FIND V(Xrr.ewma_node) AT=16.0150000
.meas tran ratio_b24 FIND V(rr_ratio_out) AT=16.0150000
.meas tran asym_b24 FIND V(rr_asym_out) AT=16.0150000
.meas tran prev_capt_b24 FIND V(Xrr.prev_node) AT=16.0230000
.meas tran sf_capt_b24 FIND V(Xrr.sf_out) AT=16.0230000
.meas tran timer_b25 FIND V(Xrr.net_timer) AT=16.6316667
.meas tran sf_b25 FIND V(Xrr.sf_out) AT=16.6316667
.meas tran prev_b25 FIND V(Xrr.prev_node) AT=16.6316667
.meas tran ewma_b25 FIND V(Xrr.ewma_node) AT=16.6316667
.meas tran ratio_b25 FIND V(rr_ratio_out) AT=16.6316667
.meas tran asym_b25 FIND V(rr_asym_out) AT=16.6316667
.meas tran prev_capt_b25 FIND V(Xrr.prev_node) AT=16.6396667
.meas tran sf_capt_b25 FIND V(Xrr.sf_out) AT=16.6396667
.meas tran timer_b26 FIND V(Xrr.net_timer) AT=17.2316667
.meas tran sf_b26 FIND V(Xrr.sf_out) AT=17.2316667
.meas tran prev_b26 FIND V(Xrr.prev_node) AT=17.2316667
.meas tran ewma_b26 FIND V(Xrr.ewma_node) AT=17.2316667
.meas tran ratio_b26 FIND V(rr_ratio_out) AT=17.2316667
.meas tran asym_b26 FIND V(rr_asym_out) AT=17.2316667
.meas tran prev_capt_b26 FIND V(Xrr.prev_node) AT=17.2396667
.meas tran sf_capt_b26 FIND V(Xrr.sf_out) AT=17.2396667
.meas tran timer_b27 FIND V(Xrr.net_timer) AT=17.8511111
.meas tran sf_b27 FIND V(Xrr.sf_out) AT=17.8511111
.meas tran prev_b27 FIND V(Xrr.prev_node) AT=17.8511111
.meas tran ewma_b27 FIND V(Xrr.ewma_node) AT=17.8511111
.meas tran ratio_b27 FIND V(rr_ratio_out) AT=17.8511111
.meas tran asym_b27 FIND V(rr_asym_out) AT=17.8511111
.meas tran prev_capt_b27 FIND V(Xrr.prev_node) AT=17.8591111
.meas tran sf_capt_b27 FIND V(Xrr.sf_out) AT=17.8591111
.meas tran timer_b28 FIND V(Xrr.net_timer) AT=18.4816667
.meas tran sf_b28 FIND V(Xrr.sf_out) AT=18.4816667
.meas tran prev_b28 FIND V(Xrr.prev_node) AT=18.4816667
.meas tran ewma_b28 FIND V(Xrr.ewma_node) AT=18.4816667
.meas tran ratio_b28 FIND V(rr_ratio_out) AT=18.4816667
.meas tran asym_b28 FIND V(rr_asym_out) AT=18.4816667
.meas tran prev_capt_b28 FIND V(Xrr.prev_node) AT=18.4896667
.meas tran sf_capt_b28 FIND V(Xrr.sf_out) AT=18.4896667
.meas tran timer_b29 FIND V(Xrr.net_timer) AT=19.1483333
.meas tran sf_b29 FIND V(Xrr.sf_out) AT=19.1483333
.meas tran prev_b29 FIND V(Xrr.prev_node) AT=19.1483333
.meas tran ewma_b29 FIND V(Xrr.ewma_node) AT=19.1483333
.meas tran ratio_b29 FIND V(rr_ratio_out) AT=19.1483333
.meas tran asym_b29 FIND V(rr_asym_out) AT=19.1483333
.meas tran prev_capt_b29 FIND V(Xrr.prev_node) AT=19.1563333
.meas tran sf_capt_b29 FIND V(Xrr.sf_out) AT=19.1563333
.meas tran timer_b30 FIND V(Xrr.net_timer) AT=19.8233333
.meas tran sf_b30 FIND V(Xrr.sf_out) AT=19.8233333
.meas tran prev_b30 FIND V(Xrr.prev_node) AT=19.8233333
.meas tran ewma_b30 FIND V(Xrr.ewma_node) AT=19.8233333
.meas tran ratio_b30 FIND V(rr_ratio_out) AT=19.8233333
.meas tran asym_b30 FIND V(rr_asym_out) AT=19.8233333
.meas tran prev_capt_b30 FIND V(Xrr.prev_node) AT=19.8313333
.meas tran sf_capt_b30 FIND V(Xrr.sf_out) AT=19.8313333
.meas tran timer_b31 FIND V(Xrr.net_timer) AT=20.4483333
.meas tran sf_b31 FIND V(Xrr.sf_out) AT=20.4483333
.meas tran prev_b31 FIND V(Xrr.prev_node) AT=20.4483333
.meas tran ewma_b31 FIND V(Xrr.ewma_node) AT=20.4483333
.meas tran ratio_b31 FIND V(rr_ratio_out) AT=20.4483333
.meas tran asym_b31 FIND V(rr_asym_out) AT=20.4483333
.meas tran prev_capt_b31 FIND V(Xrr.prev_node) AT=20.4563333
.meas tran sf_capt_b31 FIND V(Xrr.sf_out) AT=20.4563333
.meas tran timer_b32 FIND V(Xrr.net_timer) AT=21.0594444
.meas tran sf_b32 FIND V(Xrr.sf_out) AT=21.0594444
.meas tran prev_b32 FIND V(Xrr.prev_node) AT=21.0594444
.meas tran ewma_b32 FIND V(Xrr.ewma_node) AT=21.0594444
.meas tran ratio_b32 FIND V(rr_ratio_out) AT=21.0594444
.meas tran asym_b32 FIND V(rr_asym_out) AT=21.0594444
.meas tran prev_capt_b32 FIND V(Xrr.prev_node) AT=21.0674444
.meas tran sf_capt_b32 FIND V(Xrr.sf_out) AT=21.0674444
.meas tran timer_b33 FIND V(Xrr.net_timer) AT=21.6844444
.meas tran sf_b33 FIND V(Xrr.sf_out) AT=21.6844444
.meas tran prev_b33 FIND V(Xrr.prev_node) AT=21.6844444
.meas tran ewma_b33 FIND V(Xrr.ewma_node) AT=21.6844444
.meas tran ratio_b33 FIND V(rr_ratio_out) AT=21.6844444
.meas tran asym_b33 FIND V(rr_asym_out) AT=21.6844444
.meas tran prev_capt_b33 FIND V(Xrr.prev_node) AT=21.6924444
.meas tran sf_capt_b33 FIND V(Xrr.sf_out) AT=21.6924444
.meas tran timer_b34 FIND V(Xrr.net_timer) AT=22.3344444
.meas tran sf_b34 FIND V(Xrr.sf_out) AT=22.3344444
.meas tran prev_b34 FIND V(Xrr.prev_node) AT=22.3344444
.meas tran ewma_b34 FIND V(Xrr.ewma_node) AT=22.3344444
.meas tran ratio_b34 FIND V(rr_ratio_out) AT=22.3344444
.meas tran asym_b34 FIND V(rr_asym_out) AT=22.3344444
.meas tran prev_capt_b34 FIND V(Xrr.prev_node) AT=22.3424444
.meas tran sf_capt_b34 FIND V(Xrr.sf_out) AT=22.3424444
.meas tran timer_b35 FIND V(Xrr.net_timer) AT=22.9622222
.meas tran sf_b35 FIND V(Xrr.sf_out) AT=22.9622222
.meas tran prev_b35 FIND V(Xrr.prev_node) AT=22.9622222
.meas tran ewma_b35 FIND V(Xrr.ewma_node) AT=22.9622222
.meas tran ratio_b35 FIND V(rr_ratio_out) AT=22.9622222
.meas tran asym_b35 FIND V(rr_asym_out) AT=22.9622222
.meas tran prev_capt_b35 FIND V(Xrr.prev_node) AT=22.9702222
.meas tran sf_capt_b35 FIND V(Xrr.sf_out) AT=22.9702222
.meas tran timer_b36 FIND V(Xrr.net_timer) AT=23.5900000
.meas tran sf_b36 FIND V(Xrr.sf_out) AT=23.5900000
.meas tran prev_b36 FIND V(Xrr.prev_node) AT=23.5900000
.meas tran ewma_b36 FIND V(Xrr.ewma_node) AT=23.5900000
.meas tran ratio_b36 FIND V(rr_ratio_out) AT=23.5900000
.meas tran asym_b36 FIND V(rr_asym_out) AT=23.5900000
.meas tran prev_capt_b36 FIND V(Xrr.prev_node) AT=23.5980000
.meas tran sf_capt_b36 FIND V(Xrr.sf_out) AT=23.5980000
.meas tran timer_b37 FIND V(Xrr.net_timer) AT=24.2483333
.meas tran sf_b37 FIND V(Xrr.sf_out) AT=24.2483333
.meas tran prev_b37 FIND V(Xrr.prev_node) AT=24.2483333
.meas tran ewma_b37 FIND V(Xrr.ewma_node) AT=24.2483333
.meas tran ratio_b37 FIND V(rr_ratio_out) AT=24.2483333
.meas tran asym_b37 FIND V(rr_asym_out) AT=24.2483333
.meas tran prev_capt_b37 FIND V(Xrr.prev_node) AT=24.2563333
.meas tran sf_capt_b37 FIND V(Xrr.sf_out) AT=24.2563333
.meas tran timer_b38 FIND V(Xrr.net_timer) AT=24.9205556
.meas tran sf_b38 FIND V(Xrr.sf_out) AT=24.9205556
.meas tran prev_b38 FIND V(Xrr.prev_node) AT=24.9205556
.meas tran ewma_b38 FIND V(Xrr.ewma_node) AT=24.9205556
.meas tran ratio_b38 FIND V(rr_ratio_out) AT=24.9205556
.meas tran asym_b38 FIND V(rr_asym_out) AT=24.9205556
.meas tran prev_capt_b38 FIND V(Xrr.prev_node) AT=24.9285556
.meas tran sf_capt_b38 FIND V(Xrr.sf_out) AT=24.9285556
.meas tran timer_b39 FIND V(Xrr.net_timer) AT=25.6038889
.meas tran sf_b39 FIND V(Xrr.sf_out) AT=25.6038889
.meas tran prev_b39 FIND V(Xrr.prev_node) AT=25.6038889
.meas tran ewma_b39 FIND V(Xrr.ewma_node) AT=25.6038889
.meas tran ratio_b39 FIND V(rr_ratio_out) AT=25.6038889
.meas tran asym_b39 FIND V(rr_asym_out) AT=25.6038889
.meas tran prev_capt_b39 FIND V(Xrr.prev_node) AT=25.6118889
.meas tran sf_capt_b39 FIND V(Xrr.sf_out) AT=25.6118889
.meas tran timer_b40 FIND V(Xrr.net_timer) AT=26.2788889
.meas tran sf_b40 FIND V(Xrr.sf_out) AT=26.2788889
.meas tran prev_b40 FIND V(Xrr.prev_node) AT=26.2788889
.meas tran ewma_b40 FIND V(Xrr.ewma_node) AT=26.2788889
.meas tran ratio_b40 FIND V(rr_ratio_out) AT=26.2788889
.meas tran asym_b40 FIND V(rr_asym_out) AT=26.2788889
.meas tran prev_capt_b40 FIND V(Xrr.prev_node) AT=26.2868889
.meas tran sf_capt_b40 FIND V(Xrr.sf_out) AT=26.2868889
.meas tran timer_b41 FIND V(Xrr.net_timer) AT=26.9150000
.meas tran sf_b41 FIND V(Xrr.sf_out) AT=26.9150000
.meas tran prev_b41 FIND V(Xrr.prev_node) AT=26.9150000
.meas tran ewma_b41 FIND V(Xrr.ewma_node) AT=26.9150000
.meas tran ratio_b41 FIND V(rr_ratio_out) AT=26.9150000
.meas tran asym_b41 FIND V(rr_asym_out) AT=26.9150000
.meas tran prev_capt_b41 FIND V(Xrr.prev_node) AT=26.9230000
.meas tran sf_capt_b41 FIND V(Xrr.sf_out) AT=26.9230000
.meas tran timer_b42 FIND V(Xrr.net_timer) AT=27.5400000
.meas tran sf_b42 FIND V(Xrr.sf_out) AT=27.5400000
.meas tran prev_b42 FIND V(Xrr.prev_node) AT=27.5400000
.meas tran ewma_b42 FIND V(Xrr.ewma_node) AT=27.5400000
.meas tran ratio_b42 FIND V(rr_ratio_out) AT=27.5400000
.meas tran asym_b42 FIND V(rr_asym_out) AT=27.5400000
.meas tran prev_capt_b42 FIND V(Xrr.prev_node) AT=27.5480000
.meas tran sf_capt_b42 FIND V(Xrr.sf_out) AT=27.5480000
.meas tran timer_b43 FIND V(Xrr.net_timer) AT=28.1788889
.meas tran sf_b43 FIND V(Xrr.sf_out) AT=28.1788889
.meas tran prev_b43 FIND V(Xrr.prev_node) AT=28.1788889
.meas tran ewma_b43 FIND V(Xrr.ewma_node) AT=28.1788889
.meas tran ratio_b43 FIND V(rr_ratio_out) AT=28.1788889
.meas tran asym_b43 FIND V(rr_asym_out) AT=28.1788889
.meas tran prev_capt_b43 FIND V(Xrr.prev_node) AT=28.1868889
.meas tran sf_capt_b43 FIND V(Xrr.sf_out) AT=28.1868889
.meas tran timer_b44 FIND V(Xrr.net_timer) AT=28.8316667
.meas tran sf_b44 FIND V(Xrr.sf_out) AT=28.8316667
.meas tran prev_b44 FIND V(Xrr.prev_node) AT=28.8316667
.meas tran ewma_b44 FIND V(Xrr.ewma_node) AT=28.8316667
.meas tran ratio_b44 FIND V(rr_ratio_out) AT=28.8316667
.meas tran asym_b44 FIND V(rr_asym_out) AT=28.8316667
.meas tran prev_capt_b44 FIND V(Xrr.prev_node) AT=28.8396667
.meas tran sf_capt_b44 FIND V(Xrr.sf_out) AT=28.8396667
.meas tran timer_b45 FIND V(Xrr.net_timer) AT=29.4955556
.meas tran sf_b45 FIND V(Xrr.sf_out) AT=29.4955556
.meas tran prev_b45 FIND V(Xrr.prev_node) AT=29.4955556
.meas tran ewma_b45 FIND V(Xrr.ewma_node) AT=29.4955556
.meas tran ratio_b45 FIND V(rr_ratio_out) AT=29.4955556
.meas tran asym_b45 FIND V(rr_asym_out) AT=29.4955556
.meas tran prev_capt_b45 FIND V(Xrr.prev_node) AT=29.5035556
.meas tran sf_capt_b45 FIND V(Xrr.sf_out) AT=29.5035556
.meas tran timer_b46 FIND V(Xrr.net_timer) AT=30.1483333
.meas tran sf_b46 FIND V(Xrr.sf_out) AT=30.1483333
.meas tran prev_b46 FIND V(Xrr.prev_node) AT=30.1483333
.meas tran ewma_b46 FIND V(Xrr.ewma_node) AT=30.1483333
.meas tran ratio_b46 FIND V(rr_ratio_out) AT=30.1483333
.meas tran asym_b46 FIND V(rr_asym_out) AT=30.1483333
.meas tran prev_capt_b46 FIND V(Xrr.prev_node) AT=30.1563333
.meas tran sf_capt_b46 FIND V(Xrr.sf_out) AT=30.1563333
.meas tran timer_b47 FIND V(Xrr.net_timer) AT=30.8316667
.meas tran sf_b47 FIND V(Xrr.sf_out) AT=30.8316667
.meas tran prev_b47 FIND V(Xrr.prev_node) AT=30.8316667
.meas tran ewma_b47 FIND V(Xrr.ewma_node) AT=30.8316667
.meas tran ratio_b47 FIND V(rr_ratio_out) AT=30.8316667
.meas tran asym_b47 FIND V(rr_asym_out) AT=30.8316667
.meas tran prev_capt_b47 FIND V(Xrr.prev_node) AT=30.8396667
.meas tran sf_capt_b47 FIND V(Xrr.sf_out) AT=30.8396667
.meas tran timer_b48 FIND V(Xrr.net_timer) AT=31.5177778
.meas tran sf_b48 FIND V(Xrr.sf_out) AT=31.5177778
.meas tran prev_b48 FIND V(Xrr.prev_node) AT=31.5177778
.meas tran ewma_b48 FIND V(Xrr.ewma_node) AT=31.5177778
.meas tran ratio_b48 FIND V(rr_ratio_out) AT=31.5177778
.meas tran asym_b48 FIND V(rr_asym_out) AT=31.5177778
.meas tran prev_capt_b48 FIND V(Xrr.prev_node) AT=31.5257778
.meas tran sf_capt_b48 FIND V(Xrr.sf_out) AT=31.5257778
.meas tran timer_b49 FIND V(Xrr.net_timer) AT=32.2011111
.meas tran sf_b49 FIND V(Xrr.sf_out) AT=32.2011111
.meas tran prev_b49 FIND V(Xrr.prev_node) AT=32.2011111
.meas tran ewma_b49 FIND V(Xrr.ewma_node) AT=32.2011111
.meas tran ratio_b49 FIND V(rr_ratio_out) AT=32.2011111
.meas tran asym_b49 FIND V(rr_asym_out) AT=32.2011111
.meas tran prev_capt_b49 FIND V(Xrr.prev_node) AT=32.2091111
.meas tran sf_capt_b49 FIND V(Xrr.sf_out) AT=32.2091111

.end
