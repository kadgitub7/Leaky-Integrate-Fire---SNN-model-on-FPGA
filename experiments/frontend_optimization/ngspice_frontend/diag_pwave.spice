* P-wave Energy Debug — inlined for internal node probing
.title diag_pwave_debug

.lib "sky130_minimal.lib.spice" tt
.option scale=1.0u
.option method=gear
.option gmin=1e-15
.option abstol=1e-15
.option reltol=0.005
.temp 27

.include "ota_5t_subthreshold.spice"
.include "inverter.spice"

Vdd vdd 0 0.9
Vss vss 0 0
Vbias vbias 0 0.35
Vref vref 0 0.45

* ECG with big P-wave difference
Vecg ecg_in 0 PWL(
+ 0 0.25
+ 0.28 0.25
+ 0.32 0.3
+ 0.36 0.25
+ 0.459 0.25
+ 0.5 0.75
+ 0.54 0.25
+ 1.08 0.25
+ 1.12 0.45
+ 1.16 0.25
+ 1.259 0.25
+ 1.3 0.65
+ 1.34 0.25
+ 1.8 0.25
+ )

* P-wave gate: 150ms to 20ms before QRS onset
* Beat 1: QRS onset=0.46, pgate=0.31 to 0.44
* Beat 2: QRS onset=1.26, pgate=1.11 to 1.24
Vpgate pwave_gate 0 PWL(
+ 0 0
+ 0.309 0
+ 0.310 0.9
+ 0.440 0.9
+ 0.441 0
+ 1.109 0
+ 1.110 0.9
+ 1.240 0.9
+ 1.241 0
+ 1.8 0
+ )

* rpeak trigger
Vrpeak rpeak_trigger 0 PWL(
+ 0 0
+ 0.499 0
+ 0.500 0.9
+ 0.502 0
+ 1.299 0
+ 1.300 0.9
+ 1.302 0
+ 1.8 0
+ )

* ========== INLINED PWAVE_ENERGY ==========

* BPF (always on)
Xota_hpf_lp ecg_in hpf_vlp hpf_vlp vdd vss vbias ota_5t
XChpf_lp hpf_vlp vss sky130_fd_pr__cap_mim_m3_1 W=63 L=63

Xota_hpf_sub hpf_vlp ecg_in bpf_mid vdd vss vbias ota_5t

Xota_lpf bpf_mid bpf_pw bpf_pw vdd vss vbias ota_5t
XClpf bpf_pw vss sky130_fd_pr__cap_mim_m3_1 W=39 L=39

* Peak detector
Xinv_pg pwave_gate pwave_gate_bar vdd vss inverter_sub

XMpk_bias vbias_pk vbias net_pk_bsw vss sky130_fd_pr__nfet_01v8 L=8 W=1 nf=1
XMpk_bsw net_pk_bsw pwave_gate vss vss sky130_fd_pr__nfet_01v8 L=0.5 W=2 nf=1
XMpk_bdis vbias_pk pwave_gate_bar vss vss sky130_fd_pr__nfet_01v8 L=0.5 W=2 nf=1

Xota_pk bpf_pw pw_energy_out net_pk_cmp vdd vss vbias_pk ota_5t

XMpk_pull net_pk_cmp pwave_gate_bar vss vss sky130_fd_pr__nfet_01v8 L=0.5 W=2 nf=1

Xinv_cmp net_pk_cmp net_pk_cmp_bar vdd vss inverter_sub

XMtg_n bpf_pw net_pk_cmp pw_energy_out vss sky130_fd_pr__nfet_01v8 L=0.5 W=1 nf=1
XMtg_p bpf_pw net_pk_cmp_bar pw_energy_out vdd sky130_fd_pr__pfet_01v8 L=0.5 W=2 nf=1

XCpk pw_energy_out vss sky130_fd_pr__cap_mim_m3_1 W=16 L=16

XMpk_reset pw_energy_out rpeak_trigger vss vss sky130_fd_pr__nfet_01v8 L=0.5 W=2 nf=1

* ==========================================

.tran 0.1m 1.6

* During P-wave window for beat 1
.meas tran ecg_b1_pw FIND V(ecg_in) AT=0.32
.meas tran hpf_vlp_b1 FIND V(hpf_vlp) AT=0.32
.meas tran bpf_mid_b1 FIND V(bpf_mid) AT=0.32
.meas tran bpf_pw_b1 FIND V(bpf_pw) AT=0.32
.meas tran pgate_b1 FIND V(pwave_gate) AT=0.32
.meas tran vbias_pk_b1 FIND V(vbias_pk) AT=0.32
.meas tran cmp_b1 FIND V(net_pk_cmp) AT=0.32
.meas tran pw_out_b1 FIND V(pw_energy_out) AT=0.32

* Before P-wave (baseline)
.meas tran bpf_pw_base FIND V(bpf_pw) AT=0.28
.meas tran hpf_vlp_base FIND V(hpf_vlp) AT=0.28
.meas tran bpf_mid_base FIND V(bpf_mid) AT=0.28

* After P-wave gate closes for beat 1 (should hold peak)
.meas tran pw_out_b1_hold FIND V(pw_energy_out) AT=0.45

* During P-wave window for beat 2
.meas tran ecg_b2_pw FIND V(ecg_in) AT=1.12
.meas tran hpf_vlp_b2 FIND V(hpf_vlp) AT=1.12
.meas tran bpf_mid_b2 FIND V(bpf_mid) AT=1.12
.meas tran bpf_pw_b2 FIND V(bpf_pw) AT=1.12
.meas tran cmp_b2 FIND V(net_pk_cmp) AT=1.12
.meas tran pw_out_b2 FIND V(pw_energy_out) AT=1.12

* After P-wave gate closes for beat 2
.meas tran pw_out_b2_hold FIND V(pw_energy_out) AT=1.25

* BPF peak during P-wave windows
.meas tran bpf_pw_max_b1 MAX V(bpf_pw) FROM=0.31 TO=0.44
.meas tran bpf_pw_min_b1 MIN V(bpf_pw) FROM=0.31 TO=0.44
.meas tran bpf_pw_max_b2 MAX V(bpf_pw) FROM=1.11 TO=1.24
.meas tran bpf_pw_min_b2 MIN V(bpf_pw) FROM=1.11 TO=1.24

.end
