* PWL inline test
.title pwl_test2
V1 n1 0 PWL(0 0.1 0.01 0.2 0.02 0.15)
R1 n1 0 1k
.tran 1m 0.05
.control
run
print v(n1)
quit
.endc
.end
