.title width_timer_test
.lib "sky130_minimal.lib.spice" tt
.option scale=1.0u method=gear gmin=1e-15 abstol=1e-15 reltol=0.005
.temp 27
.include "qrs_width.spice"

Vdd vdd 0 0.9
Vss vss 0 0
Vbias vbias 0 0.35

Vthr threshold_in 0 PWL(0.0000000 0.200000 8.5000000 0.200000)
Vecg ecg_in 0 PWL(0.0000000 0.250000 0.5040000 0.250000 0.5050000 0.600000 0.5250000 0.600000 0.5260000 0.250000 1.3040000 0.250000 1.3050000 0.600000 1.3450000 0.600000 1.3460000 0.250000 2.1040000 0.250000 2.1050000 0.600000 2.1650000 0.600000 2.1660000 0.250000 2.9040000 0.250000 2.9050000 0.600000 2.9850000 0.600000 2.9860000 0.250000 3.7040000 0.250000 3.7050000 0.600000 3.8050000 0.600000 3.8060000 0.250000 4.5040000 0.250000 4.5050000 0.600000 4.6250000 0.600000 4.6260000 0.250000 5.3040000 0.250000 5.3050000 0.600000 5.4450000 0.600000 5.4460000 0.250000 6.1040000 0.250000 6.1050000 0.600000 6.2650000 0.600000 6.2660000 0.250000 6.9040000 0.250000 6.9050000 0.600000 6.9350000 0.600000 6.9360000 0.250000 7.7040000 0.250000 7.7050000 0.600000 7.7550000 0.600000 7.7560000 0.250000 8.5000000 0.250000)
Vqrs qrs_gate 0 PWL(0.0000000 0.000000 0.5040000 0.000000 0.5050000 0.900000 0.5250000 0.900000 0.5260000 0.000000 1.3040000 0.000000 1.3050000 0.900000 1.3450000 0.900000 1.3460000 0.000000 2.1040000 0.000000 2.1050000 0.900000 2.1650000 0.900000 2.1660000 0.000000 2.9040000 0.000000 2.9050000 0.900000 2.9850000 0.900000 2.9860000 0.000000 3.7040000 0.000000 3.7050000 0.900000 3.8050000 0.900000 3.8060000 0.000000 4.5040000 0.000000 4.5050000 0.900000 4.6250000 0.900000 4.6260000 0.000000 5.3040000 0.000000 5.3050000 0.900000 5.4450000 0.900000 5.4460000 0.000000 6.1040000 0.000000 6.1050000 0.900000 6.2650000 0.900000 6.2660000 0.000000 6.9040000 0.000000 6.9050000 0.900000 6.9350000 0.900000 6.9360000 0.000000 7.7040000 0.000000 7.7050000 0.900000 7.7550000 0.900000 7.7560000 0.000000 8.5000000 0.000000)
Vrpeak rpeak_trigger 0 PWL(0.0000000 0.000000 0.4990000 0.000000 0.5000000 0.900000 0.5020000 0.900000 0.5030000 0.000000 1.2990000 0.000000 1.3000000 0.900000 1.3020000 0.900000 1.3030000 0.000000 2.0990000 0.000000 2.1000000 0.900000 2.1020000 0.900000 2.1030000 0.000000 2.8990000 0.000000 2.9000000 0.900000 2.9020000 0.900000 2.9030000 0.000000 3.6990000 0.000000 3.7000000 0.900000 3.7020000 0.900000 3.7030000 0.000000 4.4990000 0.000000 4.5000000 0.900000 4.5020000 0.900000 4.5030000 0.000000 5.2990000 0.000000 5.3000000 0.900000 5.3020000 0.900000 5.3030000 0.000000 6.0990000 0.000000 6.1000000 0.900000 6.1020000 0.900000 6.1030000 0.000000 6.8990000 0.000000 6.9000000 0.900000 6.9020000 0.900000 6.9030000 0.000000 7.6990000 0.000000 7.7000000 0.900000 7.7020000 0.900000 7.7030000 0.000000 8.5000000 0.000000)

Xwidth threshold_in ecg_in qrs_gate rpeak_trigger width_out vdd vss vbias qrs_width

.tran 0.1m 8.5000

.meas tran width_b0 FIND V(width_out) AT=0.5350000
.meas tran width_mid_b0 FIND V(width_out) AT=0.5150000
.meas tran width_b1 FIND V(width_out) AT=1.3550000
.meas tran width_mid_b1 FIND V(width_out) AT=1.3250000
.meas tran width_b2 FIND V(width_out) AT=2.1750000
.meas tran width_mid_b2 FIND V(width_out) AT=2.1350000
.meas tran width_b3 FIND V(width_out) AT=2.9950000
.meas tran width_mid_b3 FIND V(width_out) AT=2.9450000
.meas tran width_b4 FIND V(width_out) AT=3.8150000
.meas tran width_mid_b4 FIND V(width_out) AT=3.7550000
.meas tran width_b5 FIND V(width_out) AT=4.6350000
.meas tran width_mid_b5 FIND V(width_out) AT=4.5650000
.meas tran width_b6 FIND V(width_out) AT=5.4550000
.meas tran width_mid_b6 FIND V(width_out) AT=5.3750000
.meas tran width_b7 FIND V(width_out) AT=6.2750000
.meas tran width_mid_b7 FIND V(width_out) AT=6.1850000
.meas tran width_b8 FIND V(width_out) AT=6.9450000
.meas tran width_mid_b8 FIND V(width_out) AT=6.9200000
.meas tran width_b9 FIND V(width_out) AT=7.7650000
.meas tran width_mid_b9 FIND V(width_out) AT=7.7300000

.end
