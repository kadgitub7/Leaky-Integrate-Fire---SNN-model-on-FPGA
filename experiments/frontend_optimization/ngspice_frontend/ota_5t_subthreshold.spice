* ============================================================
* 5-Transistor OTA -- Subthreshold, nA-range bias
* SKY130 sky130_fd_pr devices, manufacturing-ready
*
* Pin order: vinn vinp vout vdd vss vbias
* All transistors long-channel for matching and high rout
* ============================================================

.subckt ota_5t vinn vinp vout vdd vss vbias

* --- Active load: PMOS current mirror ---
* HVT PMOS for lowest leakage in current mirror
* L=4u for matching in subthreshold, W=2u for gm
XM3 net1 net1 vdd vdd sky130_fd_pr__pfet_01v8_hvt L=4 W=2 nf=1
XM4 vout net1 vdd vdd sky130_fd_pr__pfet_01v8_hvt L=4 W=2 nf=1

* --- Differential input pair: NMOS ---
* Standard Vt for subthreshold gm, long channel for matching
XM1 net1 vinn net_tail vss sky130_fd_pr__nfet_01v8 L=4 W=2 nf=1
XM2 vout vinp net_tail vss sky130_fd_pr__nfet_01v8 L=4 W=2 nf=1

* --- Tail current source: NMOS ---
* Extra-long channel (L=8u) for high output impedance
* Gate voltage (vbias) from bias generator controls Id
XM5 net_tail vbias vss vss sky130_fd_pr__nfet_01v8 L=8 W=1 nf=1

.ends ota_5t
