* Diagnostic Round 2: Redesigned Symmetry/Slope
* 3 beats: amplitude=[0.5, 0.3, 0.6], rise_frac=[0.5, 0.3, 0.7]

.title diag_round2

.lib "sky130_minimal.lib.spice" tt
.option scale=1.0u
.option method=gear
.option gmin=1e-15
.option abstol=1e-15
.option reltol=0.005
.temp 27

.include "ota_5t_subthreshold.spice"
.include "inverter.spice"
.include "resistor_div.spice"
.include "rr_timing.spice"
.include "beat_instability.spice"
.include "pwave_energy.spice"
.include "qrs_width.spice"
.include "slope_ratio.spice"
.include "qrs_symmetry.spice"

Vdd vdd 0 0.9
Vss vss 0 0
Vbias vbias 0 0.35
Vref vref 0 0.45

Vecg ecg_in 0 PWL(0.000000 0.150000 0.359000 0.150000 0.410000 0.200000 0.450000 0.150000 0.459000 0.150000 0.500000 0.650000 0.540000 0.150000 0.975000 0.150000 1.026000 0.180000 1.066000 0.150000 1.075000 0.150000 1.100000 0.450000 1.156000 0.150000 1.843000 0.150000 1.894000 0.210000 1.934000 0.150000 1.943000 0.150000 2.000000 0.750000 2.024000 0.150000 2.500000 0.150000)
Vecg2 ecg_in_l1 0 PWL(0.000000 0.150000 0.359000 0.150000 0.410000 0.200000 0.450000 0.150000 0.459000 0.150000 0.500000 0.650000 0.540000 0.150000 0.975000 0.150000 1.026000 0.180000 1.066000 0.150000 1.075000 0.150000 1.100000 0.450000 1.156000 0.150000 1.843000 0.150000 1.894000 0.210000 1.934000 0.150000 1.943000 0.150000 2.000000 0.750000 2.024000 0.150000 2.500000 0.150000)
Vrpeak rpeak_trigger 0 PWL(0.000000 0.000000 0.499000 0.000000 0.500000 0.900000 0.501000 0.900000 0.502000 0.000000 1.099000 0.000000 1.100000 0.900000 1.101000 0.900000 1.102000 0.000000 1.999000 0.000000 2.000000 0.900000 2.001000 0.900000 2.002000 0.000000 2.500000 0.000000)
Vqrs qrs_gate 0 PWL(0.000000 0.000000 0.454000 0.000000 0.455000 0.900000 0.545000 0.900000 0.546000 0.000000 1.070000 0.000000 1.071000 0.900000 1.161000 0.900000 1.162000 0.000000 1.938000 0.000000 1.939000 0.900000 2.029000 0.900000 2.030000 0.000000 2.500000 0.000000)
Vpwave pwave_gate 0 PWL(0.000000 0.000000 0.309000 0.000000 0.310000 0.900000 0.440000 0.900000 0.441000 0.000000 0.925000 0.000000 0.926000 0.900000 1.056000 0.900000 1.057000 0.000000 1.793000 0.000000 1.794000 0.900000 1.924000 0.900000 1.925000 0.000000 2.500000 0.000000)

* --- Feature extraction ---

* rr_timing: rpeak_trigger rr_ratio_out rr_asym_out vdd vss vbias
Xrr rpeak_trigger f_rr_ratio f_rr_asym vdd vss vbias rr_timing

* beat_instability: ecg_in qrs_gate rpeak_trigger instab_out peak_out vdd vss vbias vref
Xinstab0 ecg_in qrs_gate rpeak_trigger f_instab_l0 peak_out_l0 vdd vss vbias vref beat_instability
Xinstab1 ecg_in_l1 qrs_gate rpeak_trigger f_instab_l1 peak_out_l1 vdd vss vbias vref beat_instability

* pwave_energy: ecg_in pwave_gate rpeak_trigger pw_energy_out vdd vss vbias vref
Xpwave ecg_in_l1 pwave_gate rpeak_trigger f_pwave vdd vss vbias vref pwave_energy

* qrs_width: peak_voltage ecg_in qrs_gate rpeak_trigger width_out vdd vss vbias
Xwidth vref ecg_in qrs_gate rpeak_trigger f_width vdd vss vbias qrs_width

* qrs_symmetry: qrs_onset rpeak_trigger sym_out rise_timer_out fall_timer_out vdd vss vbias
Xsym qrs_gate rpeak_trigger f_sym rise_timer_out fall_timer_out vdd vss vbias qrs_symmetry

* slope_ratio: rise_timer_voltage fall_timer_voltage slope_out vdd vss
Xslope rise_timer_out fall_timer_out f_slope vdd vss slope_ratio

.tran 0.1m 2.3

* === Measurements at bt-5ms (before rpeak reset) ===
.meas tran f_rr_ratio_pre_b1 FIND V(f_rr_ratio) AT=0.495000
.meas tran f_rr_asym_pre_b1 FIND V(f_rr_asym) AT=0.495000
.meas tran f_instab_l0_pre_b1 FIND V(f_instab_l0) AT=0.495000
.meas tran f_instab_l1_pre_b1 FIND V(f_instab_l1) AT=0.495000
.meas tran f_pwave_pre_b1 FIND V(f_pwave) AT=0.495000
.meas tran f_width_pre_b1 FIND V(f_width) AT=0.495000
.meas tran peak_out_l0_pre_b1 FIND V(peak_out_l0) AT=0.495000
.meas tran ecg_in_pre_b1 FIND V(ecg_in) AT=0.495000
.meas tran f_rr_ratio_pre_b2 FIND V(f_rr_ratio) AT=1.095000
.meas tran f_rr_asym_pre_b2 FIND V(f_rr_asym) AT=1.095000
.meas tran f_instab_l0_pre_b2 FIND V(f_instab_l0) AT=1.095000
.meas tran f_instab_l1_pre_b2 FIND V(f_instab_l1) AT=1.095000
.meas tran f_pwave_pre_b2 FIND V(f_pwave) AT=1.095000
.meas tran f_width_pre_b2 FIND V(f_width) AT=1.095000
.meas tran peak_out_l0_pre_b2 FIND V(peak_out_l0) AT=1.095000
.meas tran ecg_in_pre_b2 FIND V(ecg_in) AT=1.095000
.meas tran f_rr_ratio_pre_b3 FIND V(f_rr_ratio) AT=1.995000
.meas tran f_rr_asym_pre_b3 FIND V(f_rr_asym) AT=1.995000
.meas tran f_instab_l0_pre_b3 FIND V(f_instab_l0) AT=1.995000
.meas tran f_instab_l1_pre_b3 FIND V(f_instab_l1) AT=1.995000
.meas tran f_pwave_pre_b3 FIND V(f_pwave) AT=1.995000
.meas tran f_width_pre_b3 FIND V(f_width) AT=1.995000
.meas tran peak_out_l0_pre_b3 FIND V(peak_out_l0) AT=1.995000
.meas tran ecg_in_pre_b3 FIND V(ecg_in) AT=1.995000
.meas tran rise_timer_out_late_b1 FIND V(rise_timer_out) AT=0.540000
.meas tran fall_timer_out_late_b1 FIND V(fall_timer_out) AT=0.540000
.meas tran f_sym_late_b1 FIND V(f_sym) AT=0.540000
.meas tran f_slope_late_b1 FIND V(f_slope) AT=0.540000
.meas tran rise_timer_out_late_b2 FIND V(rise_timer_out) AT=1.156000
.meas tran fall_timer_out_late_b2 FIND V(fall_timer_out) AT=1.156000
.meas tran f_sym_late_b2 FIND V(f_sym) AT=1.156000
.meas tran f_slope_late_b2 FIND V(f_slope) AT=1.156000
.meas tran rise_timer_out_late_b3 FIND V(rise_timer_out) AT=2.024000
.meas tran fall_timer_out_late_b3 FIND V(fall_timer_out) AT=2.024000
.meas tran f_sym_late_b3 FIND V(f_sym) AT=2.024000
.meas tran f_slope_late_b3 FIND V(f_slope) AT=2.024000
.meas tran f_rr_ratio_post_b1 FIND V(f_rr_ratio) AT=0.520000
.meas tran f_rr_asym_post_b1 FIND V(f_rr_asym) AT=0.520000
.meas tran f_instab_l0_post_b1 FIND V(f_instab_l0) AT=0.520000
.meas tran f_instab_l1_post_b1 FIND V(f_instab_l1) AT=0.520000
.meas tran f_pwave_post_b1 FIND V(f_pwave) AT=0.520000
.meas tran f_width_post_b1 FIND V(f_width) AT=0.520000
.meas tran f_slope_post_b1 FIND V(f_slope) AT=0.520000
.meas tran f_sym_post_b1 FIND V(f_sym) AT=0.520000
.meas tran rise_timer_out_post_b1 FIND V(rise_timer_out) AT=0.520000
.meas tran fall_timer_out_post_b1 FIND V(fall_timer_out) AT=0.520000
.meas tran f_rr_ratio_post_b2 FIND V(f_rr_ratio) AT=1.120000
.meas tran f_rr_asym_post_b2 FIND V(f_rr_asym) AT=1.120000
.meas tran f_instab_l0_post_b2 FIND V(f_instab_l0) AT=1.120000
.meas tran f_instab_l1_post_b2 FIND V(f_instab_l1) AT=1.120000
.meas tran f_pwave_post_b2 FIND V(f_pwave) AT=1.120000
.meas tran f_width_post_b2 FIND V(f_width) AT=1.120000
.meas tran f_slope_post_b2 FIND V(f_slope) AT=1.120000
.meas tran f_sym_post_b2 FIND V(f_sym) AT=1.120000
.meas tran rise_timer_out_post_b2 FIND V(rise_timer_out) AT=1.120000
.meas tran fall_timer_out_post_b2 FIND V(fall_timer_out) AT=1.120000
.meas tran f_rr_ratio_post_b3 FIND V(f_rr_ratio) AT=2.020000
.meas tran f_rr_asym_post_b3 FIND V(f_rr_asym) AT=2.020000
.meas tran f_instab_l0_post_b3 FIND V(f_instab_l0) AT=2.020000
.meas tran f_instab_l1_post_b3 FIND V(f_instab_l1) AT=2.020000
.meas tran f_pwave_post_b3 FIND V(f_pwave) AT=2.020000
.meas tran f_width_post_b3 FIND V(f_width) AT=2.020000
.meas tran f_slope_post_b3 FIND V(f_slope) AT=2.020000
.meas tran f_sym_post_b3 FIND V(f_sym) AT=2.020000
.meas tran rise_timer_out_post_b3 FIND V(rise_timer_out) AT=2.020000
.meas tran fall_timer_out_post_b3 FIND V(fall_timer_out) AT=2.020000

.end
