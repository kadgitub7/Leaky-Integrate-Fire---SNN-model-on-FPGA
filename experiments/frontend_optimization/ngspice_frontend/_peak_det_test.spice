.title peak_detector_v3_test
.lib "sky130_minimal.lib.spice" tt
.option scale=1.0u method=gear gmin=1e-15 abstol=1e-15 reltol=0.005
.temp 27

Vdd vdd 0 0.9
Vss vss 0 0
Vbias vbias 0 0.35
Vecg ecg_in 0 PWL(0.0000000 0.250000 0.2450000 0.250000 0.2500000 0.250000 0.3000000 0.400000 0.3500000 0.250000 0.3550000 0.250000 0.7450000 0.250000 0.7500000 0.250000 0.8000000 0.500000 0.8500000 0.250000 0.8550000 0.250000 1.2450000 0.250000 1.2500000 0.250000 1.3000000 0.600000 1.3500000 0.250000 1.3550000 0.250000 1.7450000 0.250000 1.7500000 0.250000 1.8000000 0.700000 1.8500000 0.250000 1.8550000 0.250000 2.2450000 0.250000 2.2500000 0.250000 2.3000000 0.550000 2.3500000 0.250000 2.3550000 0.250000 3.0000000 0.250000)
Vqrs qrs_gate 0 PWL(0.0000000 0.000000 0.2490000 0.000000 0.2500000 0.900000 0.3500000 0.900000 0.3510000 0.000000 0.7490000 0.000000 0.7500000 0.900000 0.8500000 0.900000 0.8510000 0.000000 1.2490000 0.000000 1.2500000 0.900000 1.3500000 0.900000 1.3510000 0.000000 1.7490000 0.000000 1.7500000 0.900000 1.8500000 0.900000 1.8510000 0.000000 2.2490000 0.000000 2.2500000 0.900000 2.3500000 0.900000 2.3510000 0.000000 3.0000000 0.000000)
Vreset reset_trig 0 PWL(0.0000000 0.000000 0.2390000 0.000000 0.2400000 0.900000 0.2450000 0.900000 0.2460000 0.000000 0.7390000 0.000000 0.7400000 0.900000 0.7450000 0.900000 0.7460000 0.000000 1.2390000 0.000000 1.2400000 0.900000 1.2450000 0.900000 1.2460000 0.000000 1.7390000 0.000000 1.7400000 0.900000 1.7450000 0.900000 1.7460000 0.000000 2.2390000 0.000000 2.2400000 0.900000 2.2450000 0.900000 2.2460000 0.000000 3.0000000 0.000000)

* === OTA PEAK DETECTOR with gated tail ===
* PMOS current mirror (active load)
XM3 net1 net1 vdd vdd sky130_fd_pr__pfet_01v8_hvt L=4 W=2 nf=1
XM4 ota_out net1 vdd vdd sky130_fd_pr__pfet_01v8_hvt L=4 W=2 nf=1

* Diff pair: vinn=peak_node (+), vinp=ecg_in (-)
XM1 net1 peak_node net_tail vss sky130_fd_pr__nfet_01v8 L=4 W=2 nf=1
XM2 ota_out ecg_in net_tail vss sky130_fd_pr__nfet_01v8 L=4 W=2 nf=1

* Tail current: series NFETs for gating
* Bias NFET sets max current, gate NFET enables/disables
XMtail_bias net_tail qrs_gate net_tail_sw vss sky130_fd_pr__nfet_01v8 L=8 W=1 nf=1
XMtail_gate net_tail_sw vbias vss vss sky130_fd_pr__nfet_01v8 L=8 W=1 nf=1

* Pullup on OTA output: when QRS gate OFF, OTA output floats -> pull to VDD
* This keeps PMOS charger OFF when OTA is disabled
XMpull ota_out qrs_gate vdd vdd sky130_fd_pr__pfet_01v8 L=0.5 W=2 nf=1

* PMOS charger: HVT L=80 W=0.42 (very weak, ~5nA max, OTA-controlled)
XMpk vdd ota_out peak_node vdd sky130_fd_pr__pfet_01v8_hvt L=80 W=0.42 nf=1

* Peak cap: 1pF
XCpk peak_node vss sky130_fd_pr__cap_mim_m3_1 W=22 L=22

* Reset NFET
XMrst peak_node reset_trig vss vss sky130_fd_pr__nfet_01v8 L=0.5 W=2 nf=1

.tran 0.05m 3.0000

.meas tran ecg_pk_b0 FIND V(ecg_in) AT=0.3000000
.meas tran pk_hold_b0 FIND V(peak_node) AT=0.3600000
.meas tran pk_reset_b0 FIND V(peak_node) AT=0.2510000
.meas tran pk_rpk_b0 FIND V(peak_node) AT=0.3000000
.meas tran ota_rpk_b0 FIND V(ota_out) AT=0.3000000
.meas tran pk_late_b0 FIND V(peak_node) AT=0.3100000
.meas tran ecg_pk_b1 FIND V(ecg_in) AT=0.8000000
.meas tran pk_hold_b1 FIND V(peak_node) AT=0.8600000
.meas tran pk_reset_b1 FIND V(peak_node) AT=0.7510000
.meas tran pk_rpk_b1 FIND V(peak_node) AT=0.8000000
.meas tran ota_rpk_b1 FIND V(ota_out) AT=0.8000000
.meas tran pk_late_b1 FIND V(peak_node) AT=0.8100000
.meas tran ecg_pk_b2 FIND V(ecg_in) AT=1.3000000
.meas tran pk_hold_b2 FIND V(peak_node) AT=1.3600000
.meas tran pk_reset_b2 FIND V(peak_node) AT=1.2510000
.meas tran pk_rpk_b2 FIND V(peak_node) AT=1.3000000
.meas tran ota_rpk_b2 FIND V(ota_out) AT=1.3000000
.meas tran pk_late_b2 FIND V(peak_node) AT=1.3100000
.meas tran ecg_pk_b3 FIND V(ecg_in) AT=1.8000000
.meas tran pk_hold_b3 FIND V(peak_node) AT=1.8600000
.meas tran pk_reset_b3 FIND V(peak_node) AT=1.7510000
.meas tran pk_rpk_b3 FIND V(peak_node) AT=1.8000000
.meas tran ota_rpk_b3 FIND V(ota_out) AT=1.8000000
.meas tran pk_late_b3 FIND V(peak_node) AT=1.8100000
.meas tran ecg_pk_b4 FIND V(ecg_in) AT=2.3000000
.meas tran pk_hold_b4 FIND V(peak_node) AT=2.3600000
.meas tran pk_reset_b4 FIND V(peak_node) AT=2.2510000
.meas tran pk_rpk_b4 FIND V(peak_node) AT=2.3000000
.meas tran ota_rpk_b4 FIND V(ota_out) AT=2.3000000
.meas tran pk_late_b4 FIND V(peak_node) AT=2.3100000

.end
