* ============================================================
* FEATURES 3 & 4: Beat-to-beat Amplitude Instability v4
*
* Same as v3 but with DIODE-CONNECTED loads for proportional
* (linear) output instead of binary comparator.
*
* Python: (peak - prev_peak) / prev_peak [signed, no abs]
* Analog: S&H + diff pair with diode loads
*
* Pin: ecg_in capture_trig copy_trig instab_out vdd vss vbias
* ============================================================

.subckt beat_instability_v4 ecg_in capture_trig copy_trig instab_out vdd vss vbias

* === CURRENT PEAK CAPTURE ===
XMcurr ecg_in capture_trig curr_node vss sky130_fd_pr__nfet_01v8 L=0.5 W=2 nf=1
XCcurr curr_node vss sky130_fd_pr__cap_mim_m3_1 W=50 L=50

* === EWMA SAMPLE (for prev update) ===
XMesamp ecg_in capture_trig esamp_node vss sky130_fd_pr__nfet_01v8 L=0.5 W=2 nf=1
XCesamp esamp_node vss sky130_fd_pr__cap_mim_m3_1 W=150 L=150

* === PREV UPDATE at copy_trig ===
* alpha = 45/(45+5) = 0.9 -> prev ~ 0.9*curr + 0.1*prev_old
XMcopy esamp_node copy_trig prev_node vss sky130_fd_pr__nfet_01v8 L=0.5 W=2 nf=1
XCprev prev_node vss sky130_fd_pr__cap_mim_m3_1 W=50 L=50

* === DIFF PAIR: instability output ===
* Diode-connected loads for linear (proportional) gain
XMi_tail tail_i vbias vss vss sky130_fd_pr__nfet_01v8 L=8 W=0.42 nf=1
XMi1 net_i1 curr_node tail_i vss sky130_fd_pr__nfet_01v8 L=4 W=2 nf=1
XMi2 instab_out prev_node tail_i vss sky130_fd_pr__nfet_01v8 L=4 W=2 nf=1
XMi3 net_i1 net_i1 vdd vdd sky130_fd_pr__pfet_01v8 L=4 W=2 nf=1
XMi4 instab_out instab_out vdd vdd sky130_fd_pr__pfet_01v8 L=4 W=2 nf=1

.ends beat_instability_v4
