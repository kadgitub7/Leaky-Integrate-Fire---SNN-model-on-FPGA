.title find_converged_ewma
.lib "sky130_minimal.lib.spice" tt
.option scale=1.0u method=gear reltol=0.01 gmin=1e-15
.temp 27
Vdd vdd 0 0.9
Vss vss 0 0
Vbias vbias 0 0.300
Vrpk rpk 0 PWL(0.0000000 0.000000 0.4996000 0.000000 0.5000000 0.900000 0.5050000 0.900000 0.5054000 0.000000 1.2996000 0.000000 1.3000000 0.900000 1.3050000 0.900000 1.3054000 0.000000 2.0996000 0.000000 2.1000000 0.900000 2.1050000 0.900000 2.1054000 0.000000 2.8996000 0.000000 2.9000000 0.900000 2.9050000 0.900000 2.9054000 0.000000 3.6996000 0.000000 3.7000000 0.900000 3.7050000 0.900000 3.7054000 0.000000 4.4996000 0.000000 4.5000000 0.900000 4.5050000 0.900000 4.5054000 0.000000 5.2996000 0.000000 5.3000000 0.900000 5.3050000 0.900000 5.3054000 0.000000 6.0996000 0.000000 6.1000000 0.900000 6.1050000 0.900000 6.1054000 0.000000 6.8996000 0.000000 6.9000000 0.900000 6.9050000 0.900000 6.9054000 0.000000 7.6996000 0.000000 7.7000000 0.900000 7.7050000 0.900000 7.7054000 0.000000 8.4996000 0.000000 8.5000000 0.900000 8.5050000 0.900000 8.5054000 0.000000 9.2996000 0.000000 9.3000000 0.900000 9.3050000 0.900000 9.3054000 0.000000 10.0996000 0.000000 10.1000000 0.900000 10.1050000 0.900000 10.1054000 0.000000 10.8996000 0.000000 10.9000000 0.900000 10.9050000 0.900000 10.9054000 0.000000 11.6996000 0.000000 11.7000000 0.900000 11.7050000 0.900000 11.7054000 0.000000 12.4996000 0.000000 12.5000000 0.900000 12.5050000 0.900000 12.5054000 0.000000 13.2996000 0.000000 13.3000000 0.900000 13.3050000 0.900000 13.3054000 0.000000 14.0996000 0.000000 14.1000000 0.900000 14.1050000 0.900000 14.1054000 0.000000 14.8996000 0.000000 14.9000000 0.900000 14.9050000 0.900000 14.9054000 0.000000 15.6996000 0.000000 15.7000000 0.900000 15.7050000 0.900000 15.7054000 0.000000 16.2000000 0.000000)
Vc cap_t 0 PWL(0.0000000 0.000000 0.4946000 0.000000 0.4950000 0.900000 0.4970000 0.900000 0.4974000 0.000000 1.2946000 0.000000 1.2950000 0.900000 1.2970000 0.900000 1.2974000 0.000000 2.0946000 0.000000 2.0950000 0.900000 2.0970000 0.900000 2.0974000 0.000000 2.8946000 0.000000 2.8950000 0.900000 2.8970000 0.900000 2.8974000 0.000000 3.6946000 0.000000 3.6950000 0.900000 3.6970000 0.900000 3.6974000 0.000000 4.4946000 0.000000 4.4950000 0.900000 4.4970000 0.900000 4.4974000 0.000000 5.2946000 0.000000 5.2950000 0.900000 5.2970000 0.900000 5.2974000 0.000000 6.0946000 0.000000 6.0950000 0.900000 6.0970000 0.900000 6.0974000 0.000000 6.8946000 0.000000 6.8950000 0.900000 6.8970000 0.900000 6.8974000 0.000000 7.6946000 0.000000 7.6950000 0.900000 7.6970000 0.900000 7.6974000 0.000000 8.4946000 0.000000 8.4950000 0.900000 8.4970000 0.900000 8.4974000 0.000000 9.2946000 0.000000 9.2950000 0.900000 9.2970000 0.900000 9.2974000 0.000000 10.0946000 0.000000 10.0950000 0.900000 10.0970000 0.900000 10.0974000 0.000000 10.8946000 0.000000 10.8950000 0.900000 10.8970000 0.900000 10.8974000 0.000000 11.6946000 0.000000 11.6950000 0.900000 11.6970000 0.900000 11.6974000 0.000000 12.4946000 0.000000 12.4950000 0.900000 12.4970000 0.900000 12.4974000 0.000000 13.2946000 0.000000 13.2950000 0.900000 13.2970000 0.900000 13.2974000 0.000000 14.0946000 0.000000 14.0950000 0.900000 14.0970000 0.900000 14.0974000 0.000000 14.8946000 0.000000 14.8950000 0.900000 14.8970000 0.900000 14.8974000 0.000000 15.6946000 0.000000 15.6950000 0.900000 15.6970000 0.900000 15.6974000 0.000000 16.2000000 0.000000)
Vcp copy_t 0 PWL(0.0000000 0.000000 0.5096000 0.000000 0.5100000 0.900000 0.5120000 0.900000 0.5124000 0.000000 1.3096000 0.000000 1.3100000 0.900000 1.3120000 0.900000 1.3124000 0.000000 2.1096000 0.000000 2.1100000 0.900000 2.1120000 0.900000 2.1124000 0.000000 2.9096000 0.000000 2.9100000 0.900000 2.9120000 0.900000 2.9124000 0.000000 3.7096000 0.000000 3.7100000 0.900000 3.7120000 0.900000 3.7124000 0.000000 4.5096000 0.000000 4.5100000 0.900000 4.5120000 0.900000 4.5124000 0.000000 5.3096000 0.000000 5.3100000 0.900000 5.3120000 0.900000 5.3124000 0.000000 6.1096000 0.000000 6.1100000 0.900000 6.1120000 0.900000 6.1124000 0.000000 6.9096000 0.000000 6.9100000 0.900000 6.9120000 0.900000 6.9124000 0.000000 7.7096000 0.000000 7.7100000 0.900000 7.7120000 0.900000 7.7124000 0.000000 8.5096000 0.000000 8.5100000 0.900000 8.5120000 0.900000 8.5124000 0.000000 9.3096000 0.000000 9.3100000 0.900000 9.3120000 0.900000 9.3124000 0.000000 10.1096000 0.000000 10.1100000 0.900000 10.1120000 0.900000 10.1124000 0.000000 10.9096000 0.000000 10.9100000 0.900000 10.9120000 0.900000 10.9124000 0.000000 11.7096000 0.000000 11.7100000 0.900000 11.7120000 0.900000 11.7124000 0.000000 12.5096000 0.000000 12.5100000 0.900000 12.5120000 0.900000 12.5124000 0.000000 13.3096000 0.000000 13.3100000 0.900000 13.3120000 0.900000 13.3124000 0.000000 14.1096000 0.000000 14.1100000 0.900000 14.1120000 0.900000 14.1124000 0.000000 14.9096000 0.000000 14.9100000 0.900000 14.9120000 0.900000 14.9124000 0.000000 15.7096000 0.000000 15.7100000 0.900000 15.7120000 0.900000 15.7124000 0.000000 16.2000000 0.000000)
.include "C:/Users/kadhi/OneDrive/Desktop/amux/verilogLearning/Leaky-Integrate-Fire---SNN-model-on-FPGA/experiments/frontend_optimization/complete_frontend_v9b/inverter.spice"
.include "C:/Users/kadhi/OneDrive/Desktop/amux/verilogLearning/Leaky-Integrate-Fire---SNN-model-on-FPGA/experiments/frontend_optimization/complete_frontend_v9b/rr_timing.spice"
Xrr 0 cap_t rpk copy_t f1 f2 tout eout vdd vss vbias rr_timing
.ic V(xrr.ewma_node)=0.369
.tran 0.1m 16.2000
.meas tran e_2 FIND V(xrr.ewma_node) AT=2.0850000
.meas tran s_2 FIND V(xrr.esamp_node) AT=2.0960000
.meas tran tb_2 FIND V(tout) AT=2.6940000
.meas tran tp_2 FIND V(tout) AT=2.7690000
.meas tran tc_2 FIND V(tout) AT=2.8950000
.meas tran e_3 FIND V(xrr.ewma_node) AT=2.8850000
.meas tran s_3 FIND V(xrr.esamp_node) AT=2.8960000
.meas tran tb_3 FIND V(tout) AT=3.4940000
.meas tran tp_3 FIND V(tout) AT=3.5690000
.meas tran tc_3 FIND V(tout) AT=3.6950000
.meas tran e_4 FIND V(xrr.ewma_node) AT=3.6850000
.meas tran s_4 FIND V(xrr.esamp_node) AT=3.6960000
.meas tran tb_4 FIND V(tout) AT=4.2940000
.meas tran tp_4 FIND V(tout) AT=4.3690000
.meas tran tc_4 FIND V(tout) AT=4.4950000
.meas tran e_5 FIND V(xrr.ewma_node) AT=4.4850000
.meas tran s_5 FIND V(xrr.esamp_node) AT=4.4960000
.meas tran tb_5 FIND V(tout) AT=5.0940000
.meas tran tp_5 FIND V(tout) AT=5.1690000
.meas tran tc_5 FIND V(tout) AT=5.2950000
.meas tran e_6 FIND V(xrr.ewma_node) AT=5.2850000
.meas tran s_6 FIND V(xrr.esamp_node) AT=5.2960000
.meas tran tb_6 FIND V(tout) AT=5.8940000
.meas tran tp_6 FIND V(tout) AT=5.9690000
.meas tran tc_6 FIND V(tout) AT=6.0950000
.meas tran e_7 FIND V(xrr.ewma_node) AT=6.0850000
.meas tran s_7 FIND V(xrr.esamp_node) AT=6.0960000
.meas tran tb_7 FIND V(tout) AT=6.6940000
.meas tran tp_7 FIND V(tout) AT=6.7690000
.meas tran tc_7 FIND V(tout) AT=6.8950000
.meas tran e_8 FIND V(xrr.ewma_node) AT=6.8850000
.meas tran s_8 FIND V(xrr.esamp_node) AT=6.8960000
.meas tran tb_8 FIND V(tout) AT=7.4940000
.meas tran tp_8 FIND V(tout) AT=7.5690000
.meas tran tc_8 FIND V(tout) AT=7.6950000
.meas tran e_9 FIND V(xrr.ewma_node) AT=7.6850000
.meas tran s_9 FIND V(xrr.esamp_node) AT=7.6960000
.meas tran tb_9 FIND V(tout) AT=8.2940000
.meas tran tp_9 FIND V(tout) AT=8.3690000
.meas tran tc_9 FIND V(tout) AT=8.4950000
.meas tran e_10 FIND V(xrr.ewma_node) AT=8.4850000
.meas tran s_10 FIND V(xrr.esamp_node) AT=8.4960000
.meas tran tb_10 FIND V(tout) AT=9.0940000
.meas tran tp_10 FIND V(tout) AT=9.1690000
.meas tran tc_10 FIND V(tout) AT=9.2950000
.meas tran e_11 FIND V(xrr.ewma_node) AT=9.2850000
.meas tran s_11 FIND V(xrr.esamp_node) AT=9.2960000
.meas tran tb_11 FIND V(tout) AT=9.8940000
.meas tran tp_11 FIND V(tout) AT=9.9690000
.meas tran tc_11 FIND V(tout) AT=10.0950000
.meas tran e_12 FIND V(xrr.ewma_node) AT=10.0850000
.meas tran s_12 FIND V(xrr.esamp_node) AT=10.0960000
.meas tran tb_12 FIND V(tout) AT=10.6940000
.meas tran tp_12 FIND V(tout) AT=10.7690000
.meas tran tc_12 FIND V(tout) AT=10.8950000
.meas tran e_13 FIND V(xrr.ewma_node) AT=10.8850000
.meas tran s_13 FIND V(xrr.esamp_node) AT=10.8960000
.meas tran tb_13 FIND V(tout) AT=11.4940000
.meas tran tp_13 FIND V(tout) AT=11.5690000
.meas tran tc_13 FIND V(tout) AT=11.6950000
.meas tran e_14 FIND V(xrr.ewma_node) AT=11.6850000
.meas tran s_14 FIND V(xrr.esamp_node) AT=11.6960000
.meas tran tb_14 FIND V(tout) AT=12.2940000
.meas tran tp_14 FIND V(tout) AT=12.3690000
.meas tran tc_14 FIND V(tout) AT=12.4950000
.meas tran e_15 FIND V(xrr.ewma_node) AT=12.4850000
.meas tran s_15 FIND V(xrr.esamp_node) AT=12.4960000
.meas tran tb_15 FIND V(tout) AT=13.0940000
.meas tran tp_15 FIND V(tout) AT=13.1690000
.meas tran tc_15 FIND V(tout) AT=13.2950000
.meas tran e_16 FIND V(xrr.ewma_node) AT=13.2850000
.meas tran s_16 FIND V(xrr.esamp_node) AT=13.2960000
.meas tran tb_16 FIND V(tout) AT=13.8940000
.meas tran tp_16 FIND V(tout) AT=13.9690000
.meas tran tc_16 FIND V(tout) AT=14.0950000
.meas tran e_17 FIND V(xrr.ewma_node) AT=14.0850000
.meas tran s_17 FIND V(xrr.esamp_node) AT=14.0960000
.meas tran tb_17 FIND V(tout) AT=14.6940000
.meas tran tp_17 FIND V(tout) AT=14.7690000
.meas tran tc_17 FIND V(tout) AT=14.8950000
.meas tran e_18 FIND V(xrr.ewma_node) AT=14.8850000
.meas tran s_18 FIND V(xrr.esamp_node) AT=14.8960000
.meas tran tb_18 FIND V(tout) AT=15.4940000
.meas tran tp_18 FIND V(tout) AT=15.5690000
.meas tran tc_18 FIND V(tout) AT=15.6950000
.meas tran e_19 FIND V(xrr.ewma_node) AT=15.6850000
.meas tran s_19 FIND V(xrr.esamp_node) AT=15.6960000

.end
