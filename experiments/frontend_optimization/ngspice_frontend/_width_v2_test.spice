.title qrs_width_v2_test
.lib "sky130_minimal.lib.spice" tt
.option scale=1.0u method=gear reltol=0.01 gmin=1e-15
.temp 27
.include "qrs_width_v2.spice"

Vdd vdd 0 0.9
Vss vss 0 0
Vbias vbias 0 0.35
Vbase vbase 0 0.3
Vecg ecg_in 0 PWL(0.0000000 0.300000 1.9344444 0.300000 1.9444444 0.284779 1.9472222 0.285133 1.9500000 0.285487 1.9527778 0.286195 1.9555556 0.285841 1.9583333 0.284779 1.9611111 0.283363 1.9638889 0.283363 1.9666667 0.284071 1.9694444 0.287965 1.9722222 0.293982 1.9750000 0.301062 1.9777778 0.308142 1.9805556 0.314513 1.9833333 0.320885 1.9861111 0.328673 1.9888889 0.337876 1.9916667 0.348496 1.9944444 0.358407 1.9972222 0.367257 2.0000000 0.374336 2.0027778 0.378938 2.0055556 0.378584 2.0083333 0.370442 2.0111111 0.353451 2.0138889 0.323009 2.0166667 0.290442 2.0194444 0.270265 2.0222222 0.261770 2.0250000 0.261416 2.0277778 0.263186 2.0305556 0.267434 2.0333333 0.270973 2.0361111 0.273805 2.0388889 0.274159 2.0416667 0.275929 2.0444444 0.275221 2.0472222 0.275221 2.0500000 0.273451 2.0527778 0.273097 2.0555556 0.273097 2.0583333 0.274867 2.0611111 0.276637 2.0638889 0.275929 2.0666667 0.275575 2.0694444 0.276991 2.0722222 0.278761 2.0750000 0.280531 2.0777778 0.280177 2.0805556 0.279469 2.0833333 0.278053 2.0861111 0.278053 2.0888889 0.278761 2.0916667 0.279115 2.0944444 0.278761 2.0972222 0.277699 2.1000000 0.275929 2.1027778 0.276283 2.1055556 0.278407 2.1083333 0.279823 2.1211111 0.300000 2.4261111 0.300000 2.4361111 0.302124 2.4388889 0.304248 2.4416667 0.305310 2.4444444 0.306018 2.4472222 0.305310 2.4500000 0.306372 2.4527778 0.309558 2.4555556 0.310973 2.4583333 0.310265 2.4611111 0.306372 2.4638889 0.298230 2.4666667 0.283009 2.4694444 0.258938 2.4722222 0.231681 2.4750000 0.205133 2.4777778 0.180000 2.4805556 0.159823 2.4833333 0.149558 2.4861111 0.148850 2.4888889 0.149558 2.4916667 0.152035 2.4944444 0.153097 2.4972222 0.157345 2.5000000 0.161947 2.5027778 0.169027 2.5055556 0.177168 2.5083333 0.183540 2.5111111 0.190265 2.5138889 0.199115 2.5166667 0.208673 2.5194444 0.216106 2.5222222 0.221770 2.5250000 0.226726 2.5277778 0.231681 2.5305556 0.236283 2.5333333 0.241239 2.5361111 0.245841 2.5388889 0.250088 2.5416667 0.253274 2.5444444 0.255044 2.5472222 0.259292 2.5500000 0.263186 2.5527778 0.267434 2.5555556 0.271327 2.5583333 0.275221 2.5611111 0.279469 2.5638889 0.284779 2.5666667 0.288673 2.5694444 0.293274 2.5722222 0.298230 2.5750000 0.301416 2.5777778 0.305310 2.5805556 0.308496 2.5833333 0.309558 2.5861111 0.312743 2.5888889 0.314159 2.5916667 0.315575 2.5944444 0.317699 2.5972222 0.319115 2.6000000 0.319823 2.6127778 0.300000 3.1816667 0.300000 3.1916667 0.286903 3.1944444 0.286549 3.1972222 0.285487 3.2000000 0.285133 3.2027778 0.284779 3.2055556 0.284425 3.2083333 0.282301 3.2111111 0.281593 3.2138889 0.283363 3.2166667 0.286195 3.2194444 0.290442 3.2222222 0.297876 3.2250000 0.306726 3.2277778 0.313805 3.2305556 0.320177 3.2333333 0.325487 3.2361111 0.332566 3.2388889 0.341062 3.2416667 0.349204 3.2444444 0.357345 3.2472222 0.363363 3.2500000 0.366903 3.2527778 0.366549 3.2555556 0.359823 3.2583333 0.351327 3.2611111 0.338584 3.2638889 0.320177 3.2666667 0.298230 3.2694444 0.280885 3.2722222 0.271327 3.2750000 0.266726 3.2777778 0.265310 3.2805556 0.267080 3.2833333 0.269912 3.2861111 0.272743 3.2888889 0.275221 3.2916667 0.275929 3.2944444 0.277699 3.2972222 0.277699 3.3000000 0.276637 3.3027778 0.275221 3.3055556 0.274513 3.3083333 0.273451 3.3111111 0.273097 3.3138889 0.273097 3.3166667 0.273097 3.3194444 0.274513 3.3222222 0.275575 3.3250000 0.277345 3.3277778 0.278053 3.3305556 0.277345 3.3333333 0.276283 3.3361111 0.276283 3.3388889 0.276637 3.3416667 0.276637 3.3444444 0.276991 3.3472222 0.275575 3.3500000 0.276283 3.3527778 0.276283 3.3555556 0.275929 3.3683333 0.300000 3.7094444 0.300000 3.7194444 0.286549 3.7222222 0.287611 3.7250000 0.289027 3.7277778 0.294336 3.7305556 0.301062 3.7333333 0.306018 3.7361111 0.308496 3.7388889 0.308142 3.7416667 0.307080 3.7444444 0.306372 3.7472222 0.301416 3.7500000 0.292212 3.7527778 0.272035 3.7555556 0.244071 3.7583333 0.216814 3.7611111 0.197345 3.7638889 0.183540 3.7666667 0.174690 3.7694444 0.169381 3.7722222 0.165133 3.7750000 0.164425 3.7777778 0.166195 3.7805556 0.167257 3.7833333 0.168319 3.7861111 0.174336 3.7888889 0.186018 3.7916667 0.197699 3.7944444 0.207611 3.7972222 0.214336 3.8000000 0.218584 3.8027778 0.225664 3.8055556 0.232035 3.8083333 0.235575 3.8111111 0.237345 3.8138889 0.239115 3.8166667 0.241593 3.8194444 0.244071 3.8222222 0.248673 3.8250000 0.252566 3.8277778 0.258230 3.8305556 0.259292 3.8333333 0.261770 3.8361111 0.264956 3.8388889 0.269204 3.8416667 0.274513 3.8444444 0.280177 3.8472222 0.284425 3.8500000 0.288673 3.8527778 0.292920 3.8555556 0.296814 3.8583333 0.300000 3.8611111 0.302478 3.8638889 0.303894 3.8666667 0.304248 3.8694444 0.305664 3.8722222 0.306726 3.8750000 0.307434 3.8777778 0.307434 3.8805556 0.308142 3.8833333 0.311681 3.8961111 0.300000 4.4288889 0.300000 4.4388889 0.288319 4.4416667 0.286903 4.4444444 0.285133 4.4472222 0.283009 4.4500000 0.282655 4.4527778 0.282655 4.4555556 0.283009 4.4583333 0.284779 4.4611111 0.286903 4.4638889 0.291150 4.4666667 0.296460 4.4694444 0.302478 4.4722222 0.310265 4.4750000 0.316637 4.4777778 0.323009 4.4805556 0.331150 4.4833333 0.339292 4.4861111 0.349204 4.4888889 0.358761 4.4916667 0.368319 4.4944444 0.377522 4.4972222 0.381770 4.5000000 0.381062 4.5027778 0.375398 4.5055556 0.365133 4.5083333 0.346726 4.5111111 0.315221 4.5138889 0.286903 4.5166667 0.271327 4.5194444 0.266018 4.5222222 0.265310 4.5250000 0.267434 4.5277778 0.270265 4.5305556 0.273805 4.5333333 0.275221 4.5361111 0.275929 4.5388889 0.275929 4.5416667 0.275929 4.5444444 0.274867 4.5472222 0.272743 4.5500000 0.272389 4.5527778 0.273451 4.5555556 0.274159 4.5583333 0.273805 4.5611111 0.274513 4.5638889 0.274867 4.5666667 0.273805 4.5694444 0.276283 4.5722222 0.277699 4.5750000 0.278407 4.5777778 0.279115 4.5805556 0.278053 4.5833333 0.277345 4.5861111 0.278407 4.5888889 0.279469 4.5916667 0.280531 4.5944444 0.280531 4.5972222 0.281239 4.6000000 0.280531 4.6027778 0.279823 4.6155556 0.300000 4.9150000 0.300000 4.9250000 0.295398 4.9277778 0.296814 4.9305556 0.296106 4.9333333 0.296814 4.9361111 0.297876 4.9388889 0.298230 4.9416667 0.300000 4.9444444 0.301416 4.9472222 0.300708 4.9500000 0.297876 4.9527778 0.293982 4.9555556 0.286195 4.9583333 0.268496 4.9611111 0.240885 4.9638889 0.210796 4.9666667 0.184248 4.9694444 0.162301 4.9722222 0.149204 4.9750000 0.146018 4.9777778 0.146018 4.9805556 0.147434 4.9833333 0.149204 4.9861111 0.153451 4.9888889 0.159469 4.9916667 0.166903 4.9944444 0.174690 4.9972222 0.182478 5.0000000 0.190619 5.0027778 0.201239 5.0055556 0.214336 5.0083333 0.223186 5.0111111 0.228850 5.0138889 0.232743 5.0166667 0.236283 5.0194444 0.240177 5.0222222 0.245133 5.0250000 0.249735 5.0277778 0.252566 5.0305556 0.255044 5.0333333 0.258230 5.0361111 0.263186 5.0388889 0.267788 5.0416667 0.271681 5.0444444 0.275575 5.0472222 0.282301 5.0500000 0.288319 5.0527778 0.293628 5.0555556 0.297876 5.0583333 0.302832 5.0611111 0.306726 5.0638889 0.309912 5.0666667 0.311327 5.0694444 0.312389 5.0722222 0.315221 5.0750000 0.316991 5.0777778 0.319469 5.0805556 0.319469 5.0833333 0.320177 5.0861111 0.322301 5.0888889 0.322655 5.1016667 0.300000 5.6872222 0.300000 5.6972222 0.283009 5.7000000 0.281593 5.7027778 0.280885 5.7055556 0.280177 5.7083333 0.279823 5.7111111 0.279469 5.7138889 0.279115 5.7166667 0.279469 5.7194444 0.281947 5.7222222 0.285841 5.7250000 0.291504 5.7277778 0.296460 5.7305556 0.301062 5.7333333 0.306372 5.7361111 0.312743 5.7388889 0.318761 5.7416667 0.326195 5.7444444 0.333982 5.7472222 0.342124 5.7500000 0.349912 5.7527778 0.355929 5.7555556 0.360177 5.7583333 0.360531 5.7611111 0.356283 5.7638889 0.348496 5.7666667 0.336460 5.7694444 0.319823 5.7722222 0.301062 5.7750000 0.284779 5.7777778 0.272389 5.7805556 0.264956 5.7833333 0.260708 5.7861111 0.261770 5.7888889 0.265664 5.7916667 0.268142 5.7944444 0.268850 5.7972222 0.269558 5.8000000 0.268496 5.8027778 0.269558 5.8055556 0.270619 5.8083333 0.271681 5.8111111 0.271681 5.8138889 0.271327 5.8166667 0.270265 5.8194444 0.271327 5.8222222 0.272035 5.8250000 0.272743 5.8277778 0.273451 5.8305556 0.272035 5.8333333 0.270973 5.8361111 0.271327 5.8388889 0.274159 5.8416667 0.276283 5.8444444 0.277345 5.8472222 0.276283 5.8500000 0.275929 5.8527778 0.275929 5.8555556 0.276283 5.8583333 0.275929 5.8611111 0.276283 5.8738889 0.300000 6.2566667 0.300000 6.2666667 0.297522 6.2694444 0.302124 6.2722222 0.308142 6.2750000 0.311327 6.2777778 0.311327 6.2805556 0.308496 6.2833333 0.307788 6.2861111 0.307080 6.2888889 0.305310 6.2916667 0.299646 6.2944444 0.288673 6.2972222 0.269558 6.3000000 0.241947 6.3027778 0.215044 6.3055556 0.192035 6.3083333 0.176460 6.3111111 0.167965 6.3138889 0.164779 6.3166667 0.161593 6.3194444 0.160885 6.3222222 0.162655 6.3250000 0.164779 6.3277778 0.165487 6.3305556 0.166195 6.3333333 0.167611 6.3361111 0.173628 6.3388889 0.181770 6.3416667 0.192035 6.3444444 0.196991 6.3472222 0.199469 6.3500000 0.203009 6.3527778 0.207965 6.3555556 0.215752 6.3583333 0.223894 6.3611111 0.229912 6.3638889 0.233097 6.3666667 0.236991 6.3694444 0.241593 6.3722222 0.244779 6.3750000 0.247965 6.3777778 0.250442 6.3805556 0.253982 6.3833333 0.257168 6.3861111 0.261062 6.3888889 0.262832 6.3916667 0.263894 6.3944444 0.263894 6.3972222 0.264602 6.4000000 0.265310 6.4027778 0.268142 6.4055556 0.270619 6.4083333 0.272389 6.4111111 0.276283 6.4138889 0.279469 6.4166667 0.283717 6.4194444 0.288673 6.4222222 0.293274 6.4250000 0.297876 6.4277778 0.300708 6.4305556 0.302124 6.4433333 0.300000 7.1205556 0.300000 7.1305556 0.287257 7.1333333 0.286903 7.1361111 0.287257 7.1388889 0.285841 7.1416667 0.286195 7.1444444 0.286549 7.1472222 0.285133 7.1500000 0.283717 7.1527778 0.285487 7.1555556 0.289027 7.1583333 0.294690 7.1611111 0.300708 7.1638889 0.306726 7.1666667 0.312743 7.1694444 0.319115 7.1722222 0.325133 7.1750000 0.332212 7.1777778 0.339646 7.1805556 0.347788 7.1833333 0.355575 7.1861111 0.364071 7.1888889 0.371150 7.1916667 0.372920 7.1944444 0.370442 7.1972222 0.361947 7.2000000 0.344248 7.2027778 0.315575 7.2055556 0.287965 7.2083333 0.272389 7.2111111 0.268496 7.2138889 0.266372 7.2166667 0.266372 7.2194444 0.270265 7.2222222 0.273805 7.2250000 0.275575 7.2277778 0.276283 7.2305556 0.275929 7.2333333 0.274159 7.2361111 0.273097 7.2388889 0.272389 7.2416667 0.271681 7.2444444 0.272035 7.2472222 0.273097 7.2500000 0.272743 7.2527778 0.272743 7.2555556 0.272035 7.2583333 0.273451 7.2611111 0.276637 7.2638889 0.278761 7.2666667 0.279115 7.2694444 0.276991 7.2722222 0.275575 7.2750000 0.275221 7.2777778 0.275929 7.2805556 0.277345 7.2833333 0.279823 7.2861111 0.280885 7.2888889 0.281239 7.2916667 0.280885 7.2944444 0.281593 7.3072222 0.300000 7.6316667 0.300000 7.6416667 0.299646 7.6444444 0.300708 7.6472222 0.300000 7.6500000 0.298584 7.6527778 0.299292 7.6555556 0.302124 7.6583333 0.304248 7.6611111 0.303894 7.6638889 0.298938 7.6666667 0.291150 7.6694444 0.281239 7.6722222 0.262478 7.6750000 0.235929 7.6777778 0.207257 7.6805556 0.180708 7.6833333 0.159115 7.6861111 0.145310 7.6888889 0.140000 7.6916667 0.140000 7.6944444 0.140708 7.6972222 0.141062 7.7000000 0.143894 7.7027778 0.148496 7.7055556 0.152743 7.7083333 0.158053 7.7111111 0.165133 7.7138889 0.171504 7.7166667 0.178230 7.7194444 0.183894 7.7222222 0.193805 7.7250000 0.205841 7.7277778 0.215044 7.7305556 0.223894 7.7333333 0.228142 7.7361111 0.233097 7.7388889 0.235929 7.7416667 0.240531 7.7444444 0.245487 7.7472222 0.248673 7.7500000 0.251150 7.7527778 0.253982 7.7555556 0.256814 7.7583333 0.261770 7.7611111 0.266018 7.7638889 0.268496 7.7666667 0.272035 7.7694444 0.275929 7.7722222 0.281947 7.7750000 0.288673 7.7777778 0.293274 7.7805556 0.296814 7.7833333 0.299646 7.7861111 0.303540 7.7888889 0.307080 7.7916667 0.310265 7.7944444 0.311681 7.7972222 0.312035 7.8000000 0.313805 7.8027778 0.315575 7.8055556 0.316637 7.8183333 0.300000 8.3372222 0.300000 8.3472222 0.277345 8.3500000 0.276637 8.3527778 0.276283 8.3555556 0.276283 8.3583333 0.276283 8.3611111 0.276637 8.3638889 0.273805 8.3666667 0.272389 8.3694444 0.272035 8.3722222 0.273451 8.3750000 0.276991 8.3777778 0.282301 8.3805556 0.287257 8.3833333 0.293628 8.3861111 0.300000 8.3888889 0.309558 8.3916667 0.316283 8.3944444 0.323717 8.3972222 0.330088 8.4000000 0.336460 8.4027778 0.342832 8.4055556 0.344248 8.4083333 0.340000 8.4111111 0.332566 8.4138889 0.323363 8.4166667 0.307788 8.4194444 0.287611 8.4222222 0.270973 8.4250000 0.261416 8.4277778 0.255398 8.4305556 0.253982 8.4333333 0.255398 8.4361111 0.259646 8.4388889 0.263186 8.4416667 0.266018 8.4444444 0.265664 8.4472222 0.266018 8.4500000 0.267434 8.4527778 0.268850 8.4555556 0.268850 8.4583333 0.268142 8.4611111 0.267080 8.4638889 0.266018 8.4666667 0.265310 8.4694444 0.266726 8.4722222 0.268496 8.4750000 0.270265 8.4777778 0.271327 8.4805556 0.270619 8.4833333 0.270619 8.4861111 0.270619 8.4888889 0.270973 8.4916667 0.271681 8.4944444 0.273451 8.4972222 0.271681 8.5000000 0.271681 8.5027778 0.271327 8.5055556 0.273097 8.5083333 0.273451 8.5111111 0.275221 8.5238889 0.300000 8.9955556 0.300000 9.0055556 0.278761 9.0083333 0.279115 9.0111111 0.279823 9.0138889 0.279469 9.0166667 0.278407 9.0194444 0.279115 9.0222222 0.278053 9.0250000 0.276637 9.0277778 0.275221 9.0305556 0.275221 9.0333333 0.277699 9.0361111 0.282301 9.0388889 0.289381 9.0416667 0.297168 9.0444444 0.305664 9.0472222 0.313805 9.0500000 0.320177 9.0527778 0.327257 9.0555556 0.335044 9.0583333 0.344248 9.0611111 0.351327 9.0638889 0.355929 9.0666667 0.352389 9.0694444 0.344602 9.0722222 0.337168 9.0750000 0.323717 9.0777778 0.301770 9.0805556 0.279469 9.0833333 0.263894 9.0861111 0.257876 9.0888889 0.257168 9.0916667 0.259646 9.0944444 0.264248 9.0972222 0.267434 9.1000000 0.267080 9.1027778 0.268850 9.1055556 0.270619 9.1083333 0.271681 9.1111111 0.272035 9.1138889 0.270973 9.1166667 0.269204 9.1194444 0.268496 9.1222222 0.268496 9.1250000 0.268850 9.1277778 0.268142 9.1305556 0.268496 9.1333333 0.268496 9.1361111 0.270973 9.1388889 0.273451 9.1416667 0.274159 9.1444444 0.272743 9.1472222 0.271681 9.1500000 0.269558 9.1527778 0.270619 9.1555556 0.271681 9.1583333 0.272389 9.1611111 0.272035 9.1638889 0.271681 9.1666667 0.271327 9.1694444 0.272389 9.1822222 0.300000 9.6233333 0.300000 9.6333333 0.274159 9.6361111 0.274513 9.6388889 0.274513 9.6416667 0.273451 9.6444444 0.272743 9.6472222 0.271327 9.6500000 0.270619 9.6527778 0.270265 9.6555556 0.273097 9.6583333 0.276991 9.6611111 0.281947 9.6638889 0.285487 9.6666667 0.291150 9.6694444 0.298938 9.6722222 0.306372 9.6750000 0.313805 9.6777778 0.320531 9.6805556 0.327611 9.6833333 0.335398 9.6861111 0.343540 9.6888889 0.347080 9.6916667 0.345664 9.6944444 0.338230 9.6972222 0.330088 9.7000000 0.322655 9.7027778 0.312389 9.7055556 0.296106 9.7083333 0.279115 9.7111111 0.267080 9.7138889 0.258584 9.7166667 0.254690 9.7194444 0.256106 9.7222222 0.258938 9.7250000 0.263186 9.7277778 0.265310 9.7305556 0.265664 9.7333333 0.266372 9.7361111 0.268496 9.7388889 0.269912 9.7416667 0.270619 9.7444444 0.269204 9.7472222 0.267788 9.7500000 0.267434 9.7527778 0.266726 9.7555556 0.265310 9.7583333 0.266726 9.7611111 0.267788 9.7638889 0.268496 9.7666667 0.269558 9.7694444 0.269558 9.7722222 0.268850 9.7750000 0.269912 9.7777778 0.269912 9.7805556 0.269912 9.7833333 0.269912 9.7861111 0.270619 9.7888889 0.270619 9.7916667 0.270973 9.7944444 0.271681 9.7972222 0.270973 9.8100000 0.300000 10.2205556 0.300000 10.2305556 0.281947 10.2333333 0.281239 10.2361111 0.281239 10.2388889 0.281593 10.2416667 0.281239 10.2444444 0.281593 10.2472222 0.280531 10.2500000 0.279469 10.2527778 0.279823 10.2555556 0.283363 10.2583333 0.289027 10.2611111 0.295398 10.2638889 0.301062 10.2666667 0.306726 10.2694444 0.313805 10.2722222 0.320885 10.2750000 0.328673 10.2777778 0.336460 10.2805556 0.344602 10.2833333 0.352743 10.2861111 0.358407 10.2888889 0.361593 10.2916667 0.359823 10.2944444 0.352743 10.2972222 0.343540 10.3000000 0.329027 10.3027778 0.305664 10.3055556 0.283717 10.3083333 0.269912 10.3111111 0.262124 10.3138889 0.258584 10.3166667 0.256460 10.3194444 0.260354 10.3222222 0.265310 10.3250000 0.269912 10.3277778 0.271327 10.3305556 0.271327 10.3333333 0.271327 10.3361111 0.273097 10.3388889 0.274513 10.3416667 0.275929 10.3444444 0.274867 10.3472222 0.272389 10.3500000 0.271327 10.3527778 0.271327 10.3555556 0.271681 10.3583333 0.272389 10.3611111 0.272743 10.3638889 0.273451 10.3666667 0.274159 10.3694444 0.275929 10.3722222 0.276637 10.3750000 0.275929 10.3777778 0.275575 10.3805556 0.275929 10.3833333 0.275575 10.3861111 0.276283 10.3888889 0.277345 10.3916667 0.278053 10.3944444 0.278053 10.4072222 0.300000 10.8594444 0.300000 10.8694444 0.289027 10.8722222 0.289381 10.8750000 0.290088 10.8777778 0.289735 10.8805556 0.287965 10.8833333 0.286549 10.8861111 0.285841 10.8888889 0.287611 10.8916667 0.290796 10.8944444 0.296814 10.8972222 0.302124 10.9000000 0.306018 10.9027778 0.313805 10.9055556 0.321947 10.9083333 0.329027 10.9111111 0.335752 10.9138889 0.342124 10.9166667 0.350619 10.9194444 0.359469 10.9222222 0.368319 10.9250000 0.376106 10.9277778 0.379646 10.9305556 0.376814 10.9333333 0.369381 10.9361111 0.359115 10.9388889 0.342832 10.9416667 0.316991 10.9444444 0.294336 10.9472222 0.279115 10.9500000 0.272743 10.9527778 0.271681 10.9555556 0.272389 10.9583333 0.274867 10.9611111 0.277345 10.9638889 0.280177 10.9666667 0.281947 10.9694444 0.284779 10.9722222 0.285133 10.9750000 0.285487 10.9777778 0.285133 10.9805556 0.283363 10.9833333 0.281947 10.9861111 0.281593 10.9888889 0.280531 10.9916667 0.280531 10.9944444 0.281239 10.9972222 0.282655 11.0000000 0.283363 11.0027778 0.283717 11.0055556 0.286549 11.0083333 0.286903 11.0111111 0.286903 11.0138889 0.285841 11.0166667 0.285133 11.0194444 0.286195 11.0222222 0.285133 11.0250000 0.286195 11.0277778 0.286195 11.0305556 0.286195 11.0333333 0.285133 11.0461111 0.300000 11.5094444 0.300000 11.5194444 0.289381 11.5222222 0.290796 11.5250000 0.290442 11.5277778 0.288319 11.5305556 0.285841 11.5333333 0.283717 11.5361111 0.284425 11.5388889 0.287611 11.5416667 0.293274 11.5444444 0.298584 11.5472222 0.302832 11.5500000 0.306726 11.5527778 0.313097 11.5555556 0.319469 11.5583333 0.326195 11.5611111 0.332212 11.5638889 0.338584 11.5666667 0.346372 11.5694444 0.354513 11.5722222 0.361947 11.5750000 0.367965 11.5777778 0.367611 11.5805556 0.363717 11.5833333 0.357345 11.5861111 0.351327 11.5888889 0.343894 11.5916667 0.332920 11.5944444 0.315575 11.5972222 0.298584 11.6000000 0.286195 11.6027778 0.277345 11.6055556 0.273097 11.6083333 0.271681 11.6111111 0.271327 11.6138889 0.272389 11.6166667 0.274867 11.6194444 0.277699 11.6222222 0.280531 11.6250000 0.281947 11.6277778 0.282301 11.6305556 0.282301 11.6333333 0.282301 11.6361111 0.282655 11.6388889 0.281593 11.6416667 0.281239 11.6444444 0.278761 11.6472222 0.278407 11.6500000 0.277345 11.6527778 0.278407 11.6555556 0.279469 11.6583333 0.280885 11.6611111 0.281593 11.6638889 0.280885 11.6666667 0.279469 11.6694444 0.280531 11.6722222 0.281593 11.6750000 0.281947 11.6777778 0.282301 11.6805556 0.282655 11.6833333 0.280531 11.6961111 0.300000 12.2150000 0.300000 12.2250000 0.292566 12.2277778 0.292920 12.2305556 0.292566 12.2333333 0.290442 12.2361111 0.289027 12.2388889 0.287965 12.2416667 0.288319 12.2444444 0.289027 12.2472222 0.291504 12.2500000 0.293982 12.2527778 0.298230 12.2555556 0.303894 12.2583333 0.311327 12.2611111 0.318761 12.2638889 0.325133 12.2666667 0.328673 12.2694444 0.333628 12.2722222 0.342124 12.2750000 0.350973 12.2777778 0.359823 12.2805556 0.366903 12.2833333 0.371150 12.2861111 0.369381 12.2888889 0.365487 12.2916667 0.358053 12.2944444 0.348496 12.2972222 0.332566 12.3000000 0.309912 12.3027778 0.289735 12.3055556 0.277345 12.3083333 0.270619 12.3111111 0.269558 12.3138889 0.269912 12.3166667 0.272389 12.3194444 0.275221 12.3222222 0.279115 12.3250000 0.280885 12.3277778 0.281947 12.3305556 0.282655 12.3333333 0.284071 12.3361111 0.285133 12.3388889 0.284779 12.3416667 0.284425 12.3444444 0.283717 12.3472222 0.283009 12.3500000 0.281239 12.3527778 0.280177 12.3555556 0.280531 12.3583333 0.280885 12.3611111 0.284425 12.3638889 0.285487 12.3666667 0.284779 12.3694444 0.284779 12.3722222 0.285487 12.3750000 0.286195 12.3777778 0.285841 12.3805556 0.285841 12.3833333 0.285487 12.3861111 0.285487 12.3888889 0.285487 12.4016667 0.300000 12.9011111 0.300000 12.9111111 0.298584 12.9138889 0.297876 12.9166667 0.296106 12.9194444 0.295044 12.9222222 0.297522 12.9250000 0.297522 12.9277778 0.296814 12.9305556 0.294690 12.9333333 0.293982 12.9361111 0.296106 12.9388889 0.301062 12.9416667 0.306726 12.9444444 0.312389 12.9472222 0.319115 12.9500000 0.326195 12.9527778 0.333628 12.9555556 0.342478 12.9583333 0.354513 12.9611111 0.365487 12.9638889 0.375398 12.9666667 0.384248 12.9694444 0.391327 12.9722222 0.392035 12.9750000 0.387788 12.9777778 0.377876 12.9805556 0.358053 12.9833333 0.326549 12.9861111 0.298584 12.9888889 0.283717 12.9916667 0.278407 12.9944444 0.277345 12.9972222 0.276637 13.0000000 0.276991 13.0027778 0.281593 13.0055556 0.287257 13.0083333 0.291150 13.0111111 0.290796 13.0138889 0.291150 13.0166667 0.290442 13.0194444 0.289027 13.0222222 0.288319 13.0250000 0.287611 13.0277778 0.286903 13.0305556 0.285841 13.0333333 0.284071 13.0361111 0.284425 13.0388889 0.286903 13.0416667 0.290088 13.0444444 0.290088 13.0472222 0.291858 13.0500000 0.291150 13.0527778 0.289381 13.0555556 0.287965 13.0583333 0.286195 13.0611111 0.286549 13.0638889 0.287611 13.0666667 0.287965 13.0694444 0.289027 13.0722222 0.290088 13.0750000 0.291150 13.0877778 0.300000 13.5233333 0.300000 13.5333333 0.295044 13.5361111 0.295752 13.5388889 0.297168 13.5416667 0.298230 13.5444444 0.299292 13.5472222 0.297876 13.5500000 0.295044 13.5527778 0.293628 13.5555556 0.295044 13.5583333 0.300000 13.5611111 0.305310 13.5638889 0.311681 13.5666667 0.316637 13.5694444 0.323009 13.5722222 0.329381 13.5750000 0.337876 13.5777778 0.346018 13.5805556 0.354513 13.5833333 0.365133 13.5861111 0.373274 13.5888889 0.382124 13.5916667 0.388142 13.5944444 0.389558 13.5972222 0.386372 13.6000000 0.376460 13.6027778 0.361593 13.6055556 0.336814 13.6083333 0.312035 13.6111111 0.296106 13.6138889 0.288319 13.6166667 0.284071 13.6194444 0.281593 13.6222222 0.281947 13.6250000 0.285841 13.6277778 0.289735 13.6305556 0.294336 13.6333333 0.296460 13.6361111 0.295044 13.6388889 0.294336 13.6416667 0.292920 13.6444444 0.291504 13.6472222 0.289735 13.6500000 0.289381 13.6527778 0.289381 13.6555556 0.288673 13.6583333 0.288319 13.6611111 0.288673 13.6638889 0.290088 13.6666667 0.291150 13.6694444 0.292566 13.6722222 0.293274 13.6750000 0.293982 13.6777778 0.293982 13.6805556 0.293628 13.6833333 0.293982 13.6861111 0.294336 13.6888889 0.293628 13.6916667 0.293982 13.6944444 0.292920 13.6972222 0.291504 13.7100000 0.300000 14.1233333 0.300000 14.1333333 0.292212 14.1361111 0.292212 14.1388889 0.292920 14.1416667 0.291858 14.1444444 0.290796 14.1472222 0.289735 14.1500000 0.290088 14.1527778 0.292566 14.1555556 0.294336 14.1583333 0.296460 14.1611111 0.298938 14.1638889 0.301416 14.1666667 0.305664 14.1694444 0.314513 14.1722222 0.324425 14.1750000 0.332920 14.1777778 0.340708 14.1805556 0.347788 14.1833333 0.357345 14.1861111 0.365841 14.1888889 0.372920 14.1916667 0.376106 14.1944444 0.373274 14.1972222 0.366195 14.2000000 0.357699 14.2027778 0.345664 14.2055556 0.328319 14.2083333 0.307434 14.2111111 0.292212 14.2138889 0.282655 14.2166667 0.276637 14.2194444 0.275221 14.2222222 0.276283 14.2250000 0.279469 14.2277778 0.281947 14.2305556 0.282301 14.2333333 0.282655 14.2361111 0.284425 14.2388889 0.286549 14.2416667 0.285487 14.2444444 0.283009 14.2472222 0.278407 14.2500000 0.277345 14.2527778 0.278053 14.2555556 0.280177 14.2583333 0.280531 14.2611111 0.279823 14.2638889 0.279823 14.2666667 0.279115 14.2694444 0.281593 14.2722222 0.282655 14.2750000 0.283009 14.2777778 0.283009 14.2805556 0.282301 14.2833333 0.282301 14.2861111 0.282655 14.2888889 0.284425 14.2916667 0.285487 14.2944444 0.285487 14.2972222 0.285487 14.3100000 0.300000 14.8622222 0.300000 14.8722222 0.284071 14.8750000 0.285841 14.8777778 0.286195 14.8805556 0.284779 14.8833333 0.283717 14.8861111 0.283009 14.8888889 0.282301 14.8916667 0.283009 14.8944444 0.283363 14.8972222 0.286549 14.9000000 0.290796 14.9027778 0.296460 14.9055556 0.302832 14.9083333 0.309204 14.9111111 0.314513 14.9138889 0.321239 14.9166667 0.327611 14.9194444 0.336106 14.9222222 0.344956 14.9250000 0.353451 14.9277778 0.359823 14.9305556 0.364779 14.9333333 0.365133 14.9361111 0.359469 14.9388889 0.349912 14.9416667 0.336814 14.9444444 0.317699 14.9472222 0.295398 14.9500000 0.278761 14.9527778 0.269558 14.9555556 0.264956 14.9583333 0.263186 14.9611111 0.264956 14.9638889 0.268142 14.9666667 0.270973 14.9694444 0.272743 14.9722222 0.274513 14.9750000 0.276637 14.9777778 0.278761 14.9805556 0.280177 14.9833333 0.278761 14.9861111 0.276637 14.9888889 0.276283 14.9916667 0.275929 14.9944444 0.275221 14.9972222 0.275929 15.0000000 0.275575 15.0027778 0.275575 15.0055556 0.276283 15.0083333 0.276991 15.0111111 0.277699 15.0138889 0.278053 15.0166667 0.276991 15.0194444 0.276991 15.0222222 0.278407 15.0250000 0.279469 15.0277778 0.278761 15.0305556 0.278053 15.0333333 0.278053 15.0361111 0.279469 15.0488889 0.300000 15.4122222 0.300000 15.4222222 0.300708 15.4250000 0.304956 15.4277778 0.308496 15.4305556 0.310973 15.4333333 0.311327 15.4361111 0.314513 15.4388889 0.318761 15.4416667 0.320531 15.4444444 0.319823 15.4472222 0.318407 15.4500000 0.315221 15.4527778 0.304956 15.4555556 0.285841 15.4583333 0.257522 15.4611111 0.224248 15.4638889 0.197345 15.4666667 0.178230 15.4694444 0.167965 15.4722222 0.161593 15.4750000 0.158407 15.4777778 0.156637 15.4805556 0.157345 15.4833333 0.159823 15.4861111 0.166195 15.4888889 0.176106 15.4916667 0.185664 15.4944444 0.190619 15.4972222 0.195221 15.5000000 0.200531 15.5027778 0.206195 15.5055556 0.211504 15.5083333 0.217168 15.5111111 0.225310 15.5138889 0.231327 15.5166667 0.236637 15.5194444 0.240885 15.5222222 0.244071 15.5250000 0.248673 15.5277778 0.251504 15.5305556 0.254690 15.5333333 0.256460 15.5361111 0.258584 15.5388889 0.261770 15.5416667 0.265310 15.5444444 0.267080 15.5472222 0.268142 15.5500000 0.269912 15.5527778 0.273805 15.5555556 0.279115 15.5583333 0.284779 15.5611111 0.289381 15.5638889 0.292920 15.5666667 0.295044 15.5694444 0.298230 15.5722222 0.301062 15.5750000 0.304602 15.5777778 0.307434 15.5805556 0.308850 15.5833333 0.309912 15.5861111 0.310619 15.5988889 0.300000 16.1400000 0.300000 16.1500000 0.284425 16.1527778 0.284425 16.1555556 0.284425 16.1583333 0.285487 16.1611111 0.285487 16.1638889 0.283717 16.1666667 0.282301 16.1694444 0.280885 16.1722222 0.281947 16.1750000 0.284071 16.1777778 0.288673 16.1805556 0.293628 16.1833333 0.298938 16.1861111 0.306372 16.1888889 0.314159 16.1916667 0.323009 16.1944444 0.330442 16.1972222 0.338938 16.2000000 0.347788 16.2027778 0.358407 16.2055556 0.369027 16.2083333 0.375752 16.2111111 0.376814 16.2138889 0.371858 16.2166667 0.361239 16.2194444 0.342832 16.2222222 0.314513 16.2250000 0.287611 16.2277778 0.273097 16.2305556 0.268850 16.2333333 0.268496 16.2361111 0.272389 16.2388889 0.277345 16.2416667 0.280531 16.2444444 0.281593 16.2472222 0.280177 16.2500000 0.278761 16.2527778 0.278407 16.2555556 0.278407 16.2583333 0.278053 16.2611111 0.275575 16.2638889 0.275575 16.2666667 0.275221 16.2694444 0.273805 16.2722222 0.274513 16.2750000 0.276283 16.2777778 0.278407 16.2805556 0.278407 16.2833333 0.278407 16.2861111 0.278407 16.2888889 0.278053 16.2916667 0.278761 16.2944444 0.278053 16.2972222 0.277699 16.3000000 0.277345 16.3027778 0.278053 16.3055556 0.278761 16.3083333 0.278761 16.3111111 0.278407 16.3138889 0.278053 16.3266667 0.300000 16.6150000 0.300000 16.6250000 0.296460 16.6277778 0.296814 16.6305556 0.295752 16.6333333 0.295398 16.6361111 0.292920 16.6388889 0.291150 16.6416667 0.291504 16.6444444 0.294690 16.6472222 0.294336 16.6500000 0.289735 16.6527778 0.284425 16.6555556 0.276283 16.6583333 0.261770 16.6611111 0.238761 16.6638889 0.212566 16.6666667 0.187788 16.6694444 0.166195 16.6722222 0.152389 16.6750000 0.147434 16.6777778 0.145310 16.6805556 0.144248 16.6833333 0.144248 16.6861111 0.148496 16.6888889 0.155929 16.6916667 0.164071 16.6944444 0.173628 16.6972222 0.180708 16.7000000 0.186726 16.7027778 0.192743 16.7055556 0.201593 16.7083333 0.210796 16.7111111 0.219646 16.7138889 0.226372 16.7166667 0.230973 16.7194444 0.234513 16.7222222 0.236991 16.7250000 0.241593 16.7277778 0.245133 16.7305556 0.247257 16.7333333 0.250442 16.7361111 0.252920 16.7388889 0.256460 16.7416667 0.261062 16.7444444 0.264248 16.7472222 0.267434 16.7500000 0.272743 16.7527778 0.277345 16.7555556 0.282301 16.7583333 0.286195 16.7611111 0.292566 16.7638889 0.296460 16.7666667 0.300000 16.7694444 0.303894 16.7722222 0.307434 16.7750000 0.308850 16.7777778 0.309912 16.7805556 0.312389 16.7833333 0.313097 16.7861111 0.313451 16.7888889 0.314159 16.8016667 0.300000 17.6094444 0.300000 17.6194444 0.279469 17.6222222 0.279823 17.6250000 0.279823 17.6277778 0.278761 17.6305556 0.278053 17.6333333 0.278053 17.6361111 0.277699 17.6388889 0.279469 17.6416667 0.283717 17.6444444 0.287611 17.6472222 0.290796 17.6500000 0.296460 17.6527778 0.301770 17.6555556 0.308850 17.6583333 0.316991 17.6611111 0.323009 17.6638889 0.329027 17.6666667 0.335044 17.6694444 0.341770 17.6722222 0.350265 17.6750000 0.358407 17.6777778 0.361947 17.6805556 0.359469 17.6833333 0.353451 17.6861111 0.344248 17.6888889 0.332212 17.6916667 0.315929 17.6944444 0.295044 17.6972222 0.276283 17.7000000 0.263540 17.7027778 0.256814 17.7055556 0.253628 17.7083333 0.253628 17.7111111 0.256460 17.7138889 0.259292 17.7166667 0.262124 17.7194444 0.263894 17.7222222 0.265664 17.7250000 0.267434 17.7277778 0.268850 17.7305556 0.270619 17.7333333 0.270973 17.7361111 0.269204 17.7388889 0.268496 17.7416667 0.269204 17.7444444 0.268850 17.7472222 0.269558 17.7500000 0.268850 17.7527778 0.268142 17.7555556 0.269204 17.7583333 0.270265 17.7611111 0.272035 17.7638889 0.273805 17.7666667 0.274513 17.7694444 0.273451 17.7722222 0.272035 17.7750000 0.272389 17.7777778 0.273805 17.7805556 0.275221 17.7833333 0.275221 17.7961111 0.300000 18.1205556 0.300000 18.1305556 0.299292 18.1333333 0.299292 18.1361111 0.299292 18.1388889 0.299292 18.1416667 0.301062 18.1444444 0.302832 18.1472222 0.306018 18.1500000 0.307434 18.1527778 0.304602 18.1555556 0.302478 18.1583333 0.294690 18.1611111 0.277699 18.1638889 0.250796 18.1666667 0.222478 18.1694444 0.196637 18.1722222 0.175398 18.1750000 0.160531 18.1777778 0.152743 18.1805556 0.150619 18.1833333 0.150265 18.1861111 0.150265 18.1888889 0.152389 18.1916667 0.157699 18.1944444 0.163717 18.1972222 0.170442 18.2000000 0.178230 18.2027778 0.185664 18.2055556 0.193097 18.2083333 0.201947 18.2111111 0.211858 18.2138889 0.219646 18.2166667 0.224956 18.2194444 0.229558 18.2222222 0.235929 18.2250000 0.242301 18.2277778 0.246549 18.2305556 0.251150 18.2333333 0.253628 18.2361111 0.256460 18.2388889 0.260354 18.2416667 0.263540 18.2444444 0.267434 18.2472222 0.270973 18.2500000 0.274159 18.2527778 0.277345 18.2555556 0.282301 18.2583333 0.288673 18.2611111 0.293274 18.2638889 0.298230 18.2666667 0.300354 18.2694444 0.303894 18.2722222 0.306018 18.2750000 0.309204 18.2777778 0.310973 18.2805556 0.313097 18.2833333 0.315221 18.2861111 0.315929 18.2888889 0.318761 18.2916667 0.319823 18.2944444 0.322301 18.3072222 0.300000 18.6622222 0.300000 18.6722222 0.355221 18.6750000 0.361593 18.6777778 0.365841 18.6805556 0.369027 18.6833333 0.372920 18.6861111 0.375044 18.6888889 0.377876 18.6916667 0.382124 18.6944444 0.388142 18.6972222 0.397699 18.7000000 0.406195 18.7027778 0.412566 18.7055556 0.418584 18.7083333 0.420708 18.7111111 0.422478 18.7138889 0.424602 18.7166667 0.426018 18.7194444 0.430265 18.7222222 0.434867 18.7250000 0.439823 18.7277778 0.444071 18.7305556 0.447965 18.7333333 0.447611 18.7361111 0.444779 18.7388889 0.436991 18.7416667 0.423894 18.7444444 0.407965 18.7472222 0.394159 18.7500000 0.379292 18.7527778 0.362301 18.7555556 0.342832 18.7583333 0.323717 18.7611111 0.306372 18.7638889 0.291150 18.7666667 0.278761 18.7694444 0.269558 18.7722222 0.265664 18.7750000 0.264248 18.7777778 0.262832 18.7805556 0.260000 18.7833333 0.259292 18.7861111 0.258584 18.7888889 0.257522 18.7916667 0.257522 18.7944444 0.255752 18.7972222 0.254690 18.8000000 0.253628 18.8027778 0.251858 18.8055556 0.250796 18.8083333 0.250442 18.8111111 0.250088 18.8138889 0.248319 18.8166667 0.246903 18.8194444 0.245133 18.8222222 0.245133 18.8250000 0.245133 18.8277778 0.244425 18.8305556 0.243717 18.8333333 0.242655 18.8361111 0.241239 18.8488889 0.300000 19.8955556 0.300000 19.9055556 0.292920 19.9083333 0.293982 19.9111111 0.294690 19.9138889 0.294690 19.9166667 0.294690 19.9194444 0.292920 19.9222222 0.293628 19.9250000 0.293274 19.9277778 0.296460 19.9305556 0.301770 19.9333333 0.306726 19.9361111 0.311327 19.9388889 0.316283 19.9416667 0.324071 19.9444444 0.330442 19.9472222 0.337522 19.9500000 0.344248 19.9527778 0.353097 19.9555556 0.361947 19.9583333 0.369735 19.9611111 0.375398 19.9638889 0.376460 19.9666667 0.372920 19.9694444 0.364425 19.9722222 0.352743 19.9750000 0.336460 19.9777778 0.312743 19.9805556 0.289735 19.9833333 0.273805 19.9861111 0.267788 19.9888889 0.267434 19.9916667 0.270619 19.9944444 0.274159 19.9972222 0.276991 20.0000000 0.277699 20.0027778 0.278407 20.0055556 0.279469 20.0083333 0.282301 20.0111111 0.284071 20.0138889 0.284425 20.0166667 0.283009 20.0194444 0.281593 20.0222222 0.280885 20.0250000 0.280531 20.0277778 0.281239 20.0305556 0.280531 20.0333333 0.280885 20.0361111 0.281593 20.0388889 0.283363 20.0416667 0.286195 20.0444444 0.286903 20.0472222 0.286549 20.0500000 0.285841 20.0527778 0.285487 20.0555556 0.286549 20.0583333 0.288673 20.0611111 0.290088 20.0638889 0.289735 20.0666667 0.288673 20.0694444 0.287965 20.0822222 0.300000 20.3816667 0.300000 20.3916667 0.306372 20.3944444 0.308142 20.3972222 0.308496 20.4000000 0.306372 20.4027778 0.304602 20.4055556 0.303540 20.4083333 0.303186 20.4111111 0.302832 20.4138889 0.304956 20.4166667 0.302832 20.4194444 0.297522 20.4222222 0.285841 20.4250000 0.266726 20.4277778 0.239115 20.4305556 0.209027 20.4333333 0.180708 20.4361111 0.160885 20.4388889 0.152389 20.4416667 0.152389 20.4444444 0.151327 20.4472222 0.151681 20.4500000 0.154159 20.4527778 0.160531 20.4555556 0.170442 20.4583333 0.180354 20.4611111 0.188142 20.4638889 0.194867 20.4666667 0.201239 20.4694444 0.208319 20.4722222 0.218938 20.4750000 0.229204 20.4777778 0.238053 20.4805556 0.245487 20.4833333 0.249735 20.4861111 0.252212 20.4888889 0.256106 20.4916667 0.257522 20.4944444 0.257522 20.4972222 0.256460 20.5000000 0.256814 20.5027778 0.260708 20.5055556 0.266372 20.5083333 0.273805 20.5111111 0.278407 20.5138889 0.284425 20.5166667 0.289381 20.5194444 0.293982 20.5222222 0.297876 20.5250000 0.300354 20.5277778 0.304248 20.5305556 0.308142 20.5333333 0.310619 20.5361111 0.312743 20.5388889 0.315221 20.5416667 0.318407 20.5444444 0.321593 20.5472222 0.324071 20.5500000 0.325841 20.5527778 0.325487 20.5555556 0.326903 20.5683333 0.300000 21.2705556 0.300000 21.2805556 0.293274 21.2833333 0.292920 21.2861111 0.293274 21.2888889 0.294336 21.2916667 0.293982 21.2944444 0.293274 21.2972222 0.290796 21.3000000 0.289381 21.3027778 0.290088 21.3055556 0.292920 21.3083333 0.298230 21.3111111 0.303894 21.3138889 0.312389 21.3166667 0.319469 21.3194444 0.326903 21.3222222 0.334690 21.3250000 0.343540 21.3277778 0.353451 21.3305556 0.363717 21.3333333 0.373982 21.3361111 0.381416 21.3388889 0.384248 21.3416667 0.380708 21.3444444 0.371858 21.3472222 0.355575 21.3500000 0.329027 21.3527778 0.302124 21.3555556 0.284779 21.3583333 0.277345 21.3611111 0.275575 21.3638889 0.277699 21.3666667 0.281947 21.3694444 0.284071 21.3722222 0.286549 21.3750000 0.286195 21.3777778 0.284779 21.3805556 0.283363 21.3833333 0.283363 21.3861111 0.281593 21.3888889 0.280885 21.3916667 0.280885 21.3944444 0.280885 21.3972222 0.281239 21.4000000 0.280531 21.4027778 0.281239 21.4055556 0.283009 21.4083333 0.284425 21.4111111 0.284425 21.4138889 0.283363 21.4166667 0.282655 21.4194444 0.283717 21.4222222 0.285133 21.4250000 0.285841 21.4277778 0.285487 21.4305556 0.285487 21.4333333 0.284779 21.4361111 0.284779 21.4388889 0.285841 21.4416667 0.287257 21.4444444 0.287257 21.4572222 0.300000 23.3361111 0.300000)
Vpp prev_peak_in 0 PWL(0.0000000 0.300000 0.5000000 0.378938 2.0190000 0.378938 2.0200000 0.378938 2.5106667 0.378938 2.5116667 0.451150 3.2662222 0.451150 3.2672222 0.366903 3.7940000 0.366903 3.7950000 0.435575 4.5134444 0.435575 4.5144444 0.381770 4.9995556 0.381770 5.0005556 0.453982 5.7717778 0.453982 5.7727778 0.360531 6.3412222 0.360531 6.3422222 0.439115 7.2051111 0.439115 7.2061111 0.372920 7.7162222 0.372920 7.7172222 0.460000 8.4217778 0.460000 8.4227778 0.346018 9.0801111 0.346018 9.0811111 0.355929 9.7078889 0.355929 9.7088889 0.347080 10.3051111 0.347080 10.3061111 0.361593 10.9440000 0.361593 10.9450000 0.379646 11.5940000 0.379646 11.5950000 0.367965 12.2995556 0.367965 12.3005556 0.371150 12.9856667 0.371150 12.9866667 0.392035 13.6078889 0.392035 13.6088889 0.389558 14.2078889 0.389558 14.2088889 0.376106 14.9467778 0.376106 14.9477778 0.365133 15.4967778 0.365133 15.4977778 0.443363 16.2245556 0.443363 16.2255556 0.376814 16.6995556 0.376814 16.7005556 0.455752 17.6940000 0.455752 17.6950000 0.361947 18.2051111 0.361947 18.2061111 0.449735 18.7467778 0.449735 18.7477778 0.447965 19.9801111 0.447965 19.9811111 0.376460 20.4662222 0.376460 20.4672222 0.448673 23.3361111 0.448673)
Vtl thresh_load 0 PWL(0.0000000 0.000000 1.4995000 0.000000 1.5000000 0.900000 1.5050000 0.900000 1.5055000 0.000000 1.9911667 0.000000 1.9916667 0.900000 1.9966667 0.900000 1.9971667 0.000000 2.7467222 0.000000 2.7472222 0.900000 2.7522222 0.900000 2.7527222 0.000000 3.2745000 0.000000 3.2750000 0.900000 3.2800000 0.900000 3.2805000 0.000000 3.9939444 0.000000 3.9944444 0.900000 3.9994444 0.900000 3.9999444 0.000000 4.4800556 0.000000 4.4805556 0.900000 4.4855556 0.900000 4.4860556 0.000000 5.2522778 0.000000 5.2527778 0.900000 5.2577778 0.900000 5.2582778 0.000000 5.8217222 0.000000 5.8222222 0.900000 5.8272222 0.900000 5.8277222 0.000000 6.6856111 0.000000 6.6861111 0.900000 6.6911111 0.900000 6.6916111 0.000000 7.1967222 0.000000 7.1972222 0.900000 7.2022222 0.900000 7.2027222 0.000000 7.9022778 0.000000 7.9027778 0.900000 7.9077778 0.900000 7.9082778 0.000000 8.5606111 0.000000 8.5611111 0.900000 8.5661111 0.900000 8.5666111 0.000000 9.1883889 0.000000 9.1888889 0.900000 9.1938889 0.900000 9.1943889 0.000000 9.7856111 0.000000 9.7861111 0.900000 9.7911111 0.900000 9.7916111 0.000000 10.4245000 0.000000 10.4250000 0.900000 10.4300000 0.900000 10.4305000 0.000000 11.0745000 0.000000 11.0750000 0.900000 11.0800000 0.900000 11.0805000 0.000000 11.7800556 0.000000 11.7805556 0.900000 11.7855556 0.900000 11.7860556 0.000000 12.4661667 0.000000 12.4666667 0.900000 12.4716667 0.900000 12.4721667 0.000000 13.0883889 0.000000 13.0888889 0.900000 13.0938889 0.900000 13.0943889 0.000000 13.6883889 0.000000 13.6888889 0.900000 13.6938889 0.900000 13.6943889 0.000000 14.4272778 0.000000 14.4277778 0.900000 14.4327778 0.900000 14.4332778 0.000000 14.9772778 0.000000 14.9777778 0.900000 14.9827778 0.900000 14.9832778 0.000000 15.7050556 0.000000 15.7055556 0.900000 15.7105556 0.900000 15.7110556 0.000000 16.1800556 0.000000 16.1805556 0.900000 16.1855556 0.900000 16.1860556 0.000000 17.1745000 0.000000 17.1750000 0.900000 17.1800000 0.900000 17.1805000 0.000000 17.6856111 0.000000 17.6861111 0.900000 17.6911111 0.900000 17.6916111 0.000000 18.2272778 0.000000 18.2277778 0.900000 18.2327778 0.900000 18.2332778 0.000000 19.4606111 0.000000 19.4611111 0.900000 19.4661111 0.900000 19.4666111 0.000000 19.9467222 0.000000 19.9472222 0.900000 19.9522222 0.900000 19.9527222 0.000000 20.8356111 0.000000 20.8361111 0.900000 20.8411111 0.900000 20.8416111 0.000000 23.3361111 0.000000)
Vts thresh_share 0 PWL(0.0000000 0.000000 1.5095000 0.000000 1.5100000 0.900000 1.5200000 0.900000 1.5205000 0.000000 2.0011667 0.000000 2.0016667 0.900000 2.0116667 0.900000 2.0121667 0.000000 2.7567222 0.000000 2.7572222 0.900000 2.7672222 0.900000 2.7677222 0.000000 3.2845000 0.000000 3.2850000 0.900000 3.2950000 0.900000 3.2955000 0.000000 4.0039444 0.000000 4.0044444 0.900000 4.0144444 0.900000 4.0149444 0.000000 4.4900556 0.000000 4.4905556 0.900000 4.5005556 0.900000 4.5010556 0.000000 5.2622778 0.000000 5.2627778 0.900000 5.2727778 0.900000 5.2732778 0.000000 5.8317222 0.000000 5.8322222 0.900000 5.8422222 0.900000 5.8427222 0.000000 6.6956111 0.000000 6.6961111 0.900000 6.7061111 0.900000 6.7066111 0.000000 7.2067222 0.000000 7.2072222 0.900000 7.2172222 0.900000 7.2177222 0.000000 7.9122778 0.000000 7.9127778 0.900000 7.9227778 0.900000 7.9232778 0.000000 8.5706111 0.000000 8.5711111 0.900000 8.5811111 0.900000 8.5816111 0.000000 9.1983889 0.000000 9.1988889 0.900000 9.2088889 0.900000 9.2093889 0.000000 9.7956111 0.000000 9.7961111 0.900000 9.8061111 0.900000 9.8066111 0.000000 10.4345000 0.000000 10.4350000 0.900000 10.4450000 0.900000 10.4455000 0.000000 11.0845000 0.000000 11.0850000 0.900000 11.0950000 0.900000 11.0955000 0.000000 11.7900556 0.000000 11.7905556 0.900000 11.8005556 0.900000 11.8010556 0.000000 12.4761667 0.000000 12.4766667 0.900000 12.4866667 0.900000 12.4871667 0.000000 13.0983889 0.000000 13.0988889 0.900000 13.1088889 0.900000 13.1093889 0.000000 13.6983889 0.000000 13.6988889 0.900000 13.7088889 0.900000 13.7093889 0.000000 14.4372778 0.000000 14.4377778 0.900000 14.4477778 0.900000 14.4482778 0.000000 14.9872778 0.000000 14.9877778 0.900000 14.9977778 0.900000 14.9982778 0.000000 15.7150556 0.000000 15.7155556 0.900000 15.7255556 0.900000 15.7260556 0.000000 16.1900556 0.000000 16.1905556 0.900000 16.2005556 0.900000 16.2010556 0.000000 17.1845000 0.000000 17.1850000 0.900000 17.1950000 0.900000 17.1955000 0.000000 17.6956111 0.000000 17.6961111 0.900000 17.7061111 0.900000 17.7066111 0.000000 18.2372778 0.000000 18.2377778 0.900000 18.2477778 0.900000 18.2482778 0.000000 19.4706111 0.000000 19.4711111 0.900000 19.4811111 0.900000 19.4816111 0.000000 19.9567222 0.000000 19.9572222 0.900000 19.9672222 0.900000 19.9677222 0.000000 20.8456111 0.000000 20.8461111 0.900000 20.8561111 0.900000 20.8566111 0.000000 23.3361111 0.000000)
Vwh width_hold 0 PWL(0.0000000 0.900000 1.8990000 0.000000 1.9000000 0.900000 2.2000000 0.900000 2.2010000 0.000000 2.3906667 0.000000 2.3916667 0.900000 2.6916667 0.900000 2.6926667 0.000000 3.1462222 0.000000 3.1472222 0.900000 3.4472222 0.900000 3.4482222 0.000000 3.6740000 0.000000 3.6750000 0.900000 3.9750000 0.900000 3.9760000 0.000000 4.3934444 0.000000 4.3944444 0.900000 4.6944444 0.900000 4.6954444 0.000000 4.8795556 0.000000 4.8805556 0.900000 5.1805556 0.900000 5.1815556 0.000000 5.6517778 0.000000 5.6527778 0.900000 5.9527778 0.900000 5.9537778 0.000000 6.2212222 0.000000 6.2222222 0.900000 6.5222222 0.900000 6.5232222 0.000000 7.0851111 0.000000 7.0861111 0.900000 7.3861111 0.900000 7.3871111 0.000000 7.5962222 0.000000 7.5972222 0.900000 7.8972222 0.900000 7.8982222 0.000000 8.3017778 0.000000 8.3027778 0.900000 8.6027778 0.900000 8.6037778 0.000000 8.9601111 0.000000 8.9611111 0.900000 9.2611111 0.900000 9.2621111 0.000000 9.5878889 0.000000 9.5888889 0.900000 9.8888889 0.900000 9.8898889 0.000000 10.1851111 0.000000 10.1861111 0.900000 10.4861111 0.900000 10.4871111 0.000000 10.8240000 0.000000 10.8250000 0.900000 11.1250000 0.900000 11.1260000 0.000000 11.4740000 0.000000 11.4750000 0.900000 11.7750000 0.900000 11.7760000 0.000000 12.1795556 0.000000 12.1805556 0.900000 12.4805556 0.900000 12.4815556 0.000000 12.8656667 0.000000 12.8666667 0.900000 13.1666667 0.900000 13.1676667 0.000000 13.4878889 0.000000 13.4888889 0.900000 13.7888889 0.900000 13.7898889 0.000000 14.0878889 0.000000 14.0888889 0.900000 14.3888889 0.900000 14.3898889 0.000000 14.8267778 0.000000 14.8277778 0.900000 15.1277778 0.900000 15.1287778 0.000000 15.3767778 0.000000 15.3777778 0.900000 15.6777778 0.900000 15.6787778 0.000000 16.1045556 0.000000 16.1055556 0.900000 16.4055556 0.900000 16.4065556 0.000000 16.5795556 0.000000 16.5805556 0.900000 16.8805556 0.900000 16.8815556 0.000000 17.5740000 0.000000 17.5750000 0.900000 17.8750000 0.900000 17.8760000 0.000000 18.0851111 0.000000 18.0861111 0.900000 18.3861111 0.900000 18.3871111 0.000000 18.6267778 0.000000 18.6277778 0.900000 18.9277778 0.900000 18.9287778 0.000000 19.8601111 0.000000 19.8611111 0.900000 20.1611111 0.900000 20.1621111 0.000000 20.3462222 0.000000 20.3472222 0.900000 20.6472222 0.900000 20.6482222 0.000000 21.2351111 0.000000 21.2361111 0.900000 21.5361111 0.900000 21.5371111 0.000000 23.3361111 0.000000)

Xwidth ecg_in prev_peak_in vbase thresh_load thresh_share width_hold width_out vdd vss vbias qrs_width_v2

.tran 0.1m 23.3361

.meas tran width_b0 FIND V(width_out) AT=2.1500000
.meas tran thresh_b0 FIND V(Xwidth.thresh_node) AT=1.9500000
.meas tran comp_b0 FIND V(Xwidth.comp_out) AT=2.0000000
.meas tran ecg_b0 FIND V(ecg_in) AT=2.0000000
.meas tran width_b1 FIND V(width_out) AT=2.6416667
.meas tran thresh_b1 FIND V(Xwidth.thresh_node) AT=2.4416667
.meas tran comp_b1 FIND V(Xwidth.comp_out) AT=2.4916667
.meas tran ecg_b1 FIND V(ecg_in) AT=2.4916667
.meas tran width_b2 FIND V(width_out) AT=3.3972222
.meas tran thresh_b2 FIND V(Xwidth.thresh_node) AT=3.1972222
.meas tran comp_b2 FIND V(Xwidth.comp_out) AT=3.2472222
.meas tran ecg_b2 FIND V(ecg_in) AT=3.2472222
.meas tran width_b3 FIND V(width_out) AT=3.9250000
.meas tran thresh_b3 FIND V(Xwidth.thresh_node) AT=3.7250000
.meas tran comp_b3 FIND V(Xwidth.comp_out) AT=3.7750000
.meas tran ecg_b3 FIND V(ecg_in) AT=3.7750000
.meas tran width_b4 FIND V(width_out) AT=4.6444444
.meas tran thresh_b4 FIND V(Xwidth.thresh_node) AT=4.4444444
.meas tran comp_b4 FIND V(Xwidth.comp_out) AT=4.4944444
.meas tran ecg_b4 FIND V(ecg_in) AT=4.4944444
.meas tran width_b5 FIND V(width_out) AT=5.1305556
.meas tran thresh_b5 FIND V(Xwidth.thresh_node) AT=4.9305556
.meas tran comp_b5 FIND V(Xwidth.comp_out) AT=4.9805556
.meas tran ecg_b5 FIND V(ecg_in) AT=4.9805556
.meas tran width_b6 FIND V(width_out) AT=5.9027778
.meas tran thresh_b6 FIND V(Xwidth.thresh_node) AT=5.7027778
.meas tran comp_b6 FIND V(Xwidth.comp_out) AT=5.7527778
.meas tran ecg_b6 FIND V(ecg_in) AT=5.7527778
.meas tran width_b7 FIND V(width_out) AT=6.4722222
.meas tran thresh_b7 FIND V(Xwidth.thresh_node) AT=6.2722222
.meas tran comp_b7 FIND V(Xwidth.comp_out) AT=6.3222222
.meas tran ecg_b7 FIND V(ecg_in) AT=6.3222222
.meas tran width_b8 FIND V(width_out) AT=7.3361111
.meas tran thresh_b8 FIND V(Xwidth.thresh_node) AT=7.1361111
.meas tran comp_b8 FIND V(Xwidth.comp_out) AT=7.1861111
.meas tran ecg_b8 FIND V(ecg_in) AT=7.1861111
.meas tran width_b9 FIND V(width_out) AT=7.8472222
.meas tran thresh_b9 FIND V(Xwidth.thresh_node) AT=7.6472222
.meas tran comp_b9 FIND V(Xwidth.comp_out) AT=7.6972222
.meas tran ecg_b9 FIND V(ecg_in) AT=7.6972222
.meas tran width_b10 FIND V(width_out) AT=8.5527778
.meas tran thresh_b10 FIND V(Xwidth.thresh_node) AT=8.3527778
.meas tran comp_b10 FIND V(Xwidth.comp_out) AT=8.4027778
.meas tran ecg_b10 FIND V(ecg_in) AT=8.4027778
.meas tran width_b11 FIND V(width_out) AT=9.2111111
.meas tran thresh_b11 FIND V(Xwidth.thresh_node) AT=9.0111111
.meas tran comp_b11 FIND V(Xwidth.comp_out) AT=9.0611111
.meas tran ecg_b11 FIND V(ecg_in) AT=9.0611111
.meas tran width_b12 FIND V(width_out) AT=9.8388889
.meas tran thresh_b12 FIND V(Xwidth.thresh_node) AT=9.6388889
.meas tran comp_b12 FIND V(Xwidth.comp_out) AT=9.6888889
.meas tran ecg_b12 FIND V(ecg_in) AT=9.6888889
.meas tran width_b13 FIND V(width_out) AT=10.4361111
.meas tran thresh_b13 FIND V(Xwidth.thresh_node) AT=10.2361111
.meas tran comp_b13 FIND V(Xwidth.comp_out) AT=10.2861111
.meas tran ecg_b13 FIND V(ecg_in) AT=10.2861111
.meas tran width_b14 FIND V(width_out) AT=11.0750000
.meas tran thresh_b14 FIND V(Xwidth.thresh_node) AT=10.8750000
.meas tran comp_b14 FIND V(Xwidth.comp_out) AT=10.9250000
.meas tran ecg_b14 FIND V(ecg_in) AT=10.9250000
.meas tran width_b15 FIND V(width_out) AT=11.7250000
.meas tran thresh_b15 FIND V(Xwidth.thresh_node) AT=11.5250000
.meas tran comp_b15 FIND V(Xwidth.comp_out) AT=11.5750000
.meas tran ecg_b15 FIND V(ecg_in) AT=11.5750000
.meas tran width_b16 FIND V(width_out) AT=12.4305556
.meas tran thresh_b16 FIND V(Xwidth.thresh_node) AT=12.2305556
.meas tran comp_b16 FIND V(Xwidth.comp_out) AT=12.2805556
.meas tran ecg_b16 FIND V(ecg_in) AT=12.2805556
.meas tran width_b17 FIND V(width_out) AT=13.1166667
.meas tran thresh_b17 FIND V(Xwidth.thresh_node) AT=12.9166667
.meas tran comp_b17 FIND V(Xwidth.comp_out) AT=12.9666667
.meas tran ecg_b17 FIND V(ecg_in) AT=12.9666667
.meas tran width_b18 FIND V(width_out) AT=13.7388889
.meas tran thresh_b18 FIND V(Xwidth.thresh_node) AT=13.5388889
.meas tran comp_b18 FIND V(Xwidth.comp_out) AT=13.5888889
.meas tran ecg_b18 FIND V(ecg_in) AT=13.5888889
.meas tran width_b19 FIND V(width_out) AT=14.3388889
.meas tran thresh_b19 FIND V(Xwidth.thresh_node) AT=14.1388889
.meas tran comp_b19 FIND V(Xwidth.comp_out) AT=14.1888889
.meas tran ecg_b19 FIND V(ecg_in) AT=14.1888889
.meas tran width_b20 FIND V(width_out) AT=15.0777778
.meas tran thresh_b20 FIND V(Xwidth.thresh_node) AT=14.8777778
.meas tran comp_b20 FIND V(Xwidth.comp_out) AT=14.9277778
.meas tran ecg_b20 FIND V(ecg_in) AT=14.9277778
.meas tran width_b21 FIND V(width_out) AT=15.6277778
.meas tran thresh_b21 FIND V(Xwidth.thresh_node) AT=15.4277778
.meas tran comp_b21 FIND V(Xwidth.comp_out) AT=15.4777778
.meas tran ecg_b21 FIND V(ecg_in) AT=15.4777778
.meas tran width_b22 FIND V(width_out) AT=16.3555556
.meas tran thresh_b22 FIND V(Xwidth.thresh_node) AT=16.1555556
.meas tran comp_b22 FIND V(Xwidth.comp_out) AT=16.2055556
.meas tran ecg_b22 FIND V(ecg_in) AT=16.2055556
.meas tran width_b23 FIND V(width_out) AT=16.8305556
.meas tran thresh_b23 FIND V(Xwidth.thresh_node) AT=16.6305556
.meas tran comp_b23 FIND V(Xwidth.comp_out) AT=16.6805556
.meas tran ecg_b23 FIND V(ecg_in) AT=16.6805556
.meas tran width_b24 FIND V(width_out) AT=17.8250000
.meas tran thresh_b24 FIND V(Xwidth.thresh_node) AT=17.6250000
.meas tran comp_b24 FIND V(Xwidth.comp_out) AT=17.6750000
.meas tran ecg_b24 FIND V(ecg_in) AT=17.6750000
.meas tran width_b25 FIND V(width_out) AT=18.3361111
.meas tran thresh_b25 FIND V(Xwidth.thresh_node) AT=18.1361111
.meas tran comp_b25 FIND V(Xwidth.comp_out) AT=18.1861111
.meas tran ecg_b25 FIND V(ecg_in) AT=18.1861111
.meas tran width_b26 FIND V(width_out) AT=18.8777778
.meas tran thresh_b26 FIND V(Xwidth.thresh_node) AT=18.6777778
.meas tran comp_b26 FIND V(Xwidth.comp_out) AT=18.7277778
.meas tran ecg_b26 FIND V(ecg_in) AT=18.7277778
.meas tran width_b27 FIND V(width_out) AT=20.1111111
.meas tran thresh_b27 FIND V(Xwidth.thresh_node) AT=19.9111111
.meas tran comp_b27 FIND V(Xwidth.comp_out) AT=19.9611111
.meas tran ecg_b27 FIND V(ecg_in) AT=19.9611111
.meas tran width_b28 FIND V(width_out) AT=20.5972222
.meas tran thresh_b28 FIND V(Xwidth.thresh_node) AT=20.3972222
.meas tran comp_b28 FIND V(Xwidth.comp_out) AT=20.4472222
.meas tran ecg_b28 FIND V(ecg_in) AT=20.4472222
.meas tran width_b29 FIND V(width_out) AT=21.4861111
.meas tran thresh_b29 FIND V(Xwidth.thresh_node) AT=21.2861111
.meas tran comp_b29 FIND V(Xwidth.comp_out) AT=21.3361111
.meas tran ecg_b29 FIND V(ecg_in) AT=21.3361111

.end
