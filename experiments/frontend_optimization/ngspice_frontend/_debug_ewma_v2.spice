.title debug_ewma_v2_bootstrapped
.lib "sky130_minimal.lib.spice" tt
.option scale=1.0u method=gear reltol=0.01 gmin=1e-15
.temp 27

Vdd vdd 0 0.9
Vss vss 0 0
Vbias vbias 0 0.300

Vrpk rpk 0 PWL(0.0000000 0.000000 0.4996000 0.000000 0.5000000 0.900000 0.5050000 0.900000 0.5054000 0.000000 1.2996000 0.000000 1.3000000 0.900000 1.3050000 0.900000 1.3054000 0.000000 2.0996000 0.000000 2.1000000 0.900000 2.1050000 0.900000 2.1054000 0.000000 2.8996000 0.000000 2.9000000 0.900000 2.9050000 0.900000 2.9054000 0.000000 3.6996000 0.000000 3.7000000 0.900000 3.7050000 0.900000 3.7054000 0.000000 4.4996000 0.000000 4.5000000 0.900000 4.5050000 0.900000 4.5054000 0.000000 5.2996000 0.000000 5.3000000 0.900000 5.3050000 0.900000 5.3054000 0.000000 6.0996000 0.000000 6.1000000 0.900000 6.1050000 0.900000 6.1054000 0.000000 6.8996000 0.000000 6.9000000 0.900000 6.9050000 0.900000 6.9054000 0.000000 7.6996000 0.000000 7.7000000 0.900000 7.7050000 0.900000 7.7054000 0.000000 8.2000000 0.000000)
Vcap capture_trig 0 PWL(0.0000000 0.000000 0.4946000 0.000000 0.4950000 0.900000 0.4970000 0.900000 0.4974000 0.000000 1.2946000 0.000000 1.2950000 0.900000 1.2970000 0.900000 1.2974000 0.000000 2.0946000 0.000000 2.0950000 0.900000 2.0970000 0.900000 2.0974000 0.000000 2.8946000 0.000000 2.8950000 0.900000 2.8970000 0.900000 2.8974000 0.000000 3.6946000 0.000000 3.6950000 0.900000 3.6970000 0.900000 3.6974000 0.000000 4.4946000 0.000000 4.4950000 0.900000 4.4970000 0.900000 4.4974000 0.000000 5.2946000 0.000000 5.2950000 0.900000 5.2970000 0.900000 5.2974000 0.000000 6.0946000 0.000000 6.0950000 0.900000 6.0970000 0.900000 6.0974000 0.000000 6.8946000 0.000000 6.8950000 0.900000 6.8970000 0.900000 6.8974000 0.000000 7.6946000 0.000000 7.6950000 0.900000 7.6970000 0.900000 7.6974000 0.000000 8.2000000 0.000000)
Vcopy copy_trig 0 PWL(0.0000000 0.000000 0.5096000 0.000000 0.5100000 0.900000 0.5120000 0.900000 0.5124000 0.000000 1.3096000 0.000000 1.3100000 0.900000 1.3120000 0.900000 1.3124000 0.000000 2.1096000 0.000000 2.1100000 0.900000 2.1120000 0.900000 2.1124000 0.000000 2.9096000 0.000000 2.9100000 0.900000 2.9120000 0.900000 2.9124000 0.000000 3.7096000 0.000000 3.7100000 0.900000 3.7120000 0.900000 3.7124000 0.000000 4.5096000 0.000000 4.5100000 0.900000 4.5120000 0.900000 4.5124000 0.000000 5.3096000 0.000000 5.3100000 0.900000 5.3120000 0.900000 5.3124000 0.000000 6.1096000 0.000000 6.1100000 0.900000 6.1120000 0.900000 6.1124000 0.000000 6.9096000 0.000000 6.9100000 0.900000 6.9120000 0.900000 6.9124000 0.000000 7.7096000 0.000000 7.7100000 0.900000 7.7120000 0.900000 7.7124000 0.000000 8.2000000 0.000000)

.include "C:/Users/kadhi/OneDrive/Desktop/amux/verilogLearning/Leaky-Integrate-Fire---SNN-model-on-FPGA/experiments/frontend_optimization/complete_frontend_v9b/inverter.spice"
.include "C:/Users/kadhi/OneDrive/Desktop/amux/verilogLearning/Leaky-Integrate-Fire---SNN-model-on-FPGA/experiments/frontend_optimization/complete_frontend_v9b/rr_timing.spice"
.include "C:/Users/kadhi/OneDrive/Desktop/amux/verilogLearning/Leaky-Integrate-Fire---SNN-model-on-FPGA/experiments/frontend_optimization/complete_frontend_v9b/pwave_predictor.spice"
.include "C:/Users/kadhi/OneDrive/Desktop/amux/verilogLearning/Leaky-Integrate-Fire---SNN-model-on-FPGA/experiments/frontend_optimization/complete_frontend_v9b/edge_buffer.spice"
.include "C:/Users/kadhi/OneDrive/Desktop/amux/verilogLearning/Leaky-Integrate-Fire---SNN-model-on-FPGA/experiments/frontend_optimization/complete_frontend_v9b/pulse_gen.spice"

Xrr 0 capture_trig rpk copy_trig f1_out f2_out timer_out ewma_out vdd vss vbias rr_timing

* Bootstrap EWMA
.ic V(xrr.ewma_node)=0.35

* Pwave predictor with dynamic thresholds
Bvth_base vth_base 0 V = V(ewma_out) + 0.095
Bvth_peak vth_peak 0 V = V(ewma_out) + 0.061

Xpw timer_out ewma_out pw_base_level pw_peak_level rr_cap_level vth_base vth_peak vdd vss vbias pwave_predictor

* Edge buffers + pulse generators
Xeb_base pw_base_level pw_base_sharp vdd vss edge_buffer
Xpg_base pw_base_sharp pw_base_pulse vdd vss vbias pulse_gen
Xeb_peak pw_peak_level pw_peak_sharp vdd vss edge_buffer
Xpg_peak pw_peak_sharp pw_peak_pulse vdd vss vbias pulse_gen
Xeb_cap  rr_cap_level  rr_cap_sharp  vdd vss edge_buffer
Xpg_cap  rr_cap_sharp  rr_cap_pulse  vdd vss vbias pulse_gen

.tran 0.1m 8.2000

.meas tran ewma_0 FIND V(ewma_out) AT=0.5000000
.meas tran timer_0 FIND V(timer_out) AT=0.5000000
.meas tran vth_b_0 FIND V(vth_base) AT=0.5000000
.meas tran vth_p_0 FIND V(vth_peak) AT=0.5000000
.meas tran esamp_0 FIND V(xrr.esamp_node) AT=0.5050000
.meas tran ewma_1 FIND V(ewma_out) AT=1.3000000
.meas tran timer_1 FIND V(timer_out) AT=1.3000000
.meas tran vth_b_1 FIND V(vth_base) AT=1.3000000
.meas tran vth_p_1 FIND V(vth_peak) AT=1.3000000
.meas tran esamp_1 FIND V(xrr.esamp_node) AT=1.3050000
.meas tran tpwb_1 WHEN V(pw_base_pulse)=0.45 RISE=1 TD=0.9000000
.meas tran tpwp_1 WHEN V(pw_peak_pulse)=0.45 RISE=1 TD=0.9000000
.meas tran tcap_1 WHEN V(rr_cap_pulse)=0.45 RISE=1 TD=0.9000000
.meas tran ewma_2 FIND V(ewma_out) AT=2.1000000
.meas tran timer_2 FIND V(timer_out) AT=2.1000000
.meas tran vth_b_2 FIND V(vth_base) AT=2.1000000
.meas tran vth_p_2 FIND V(vth_peak) AT=2.1000000
.meas tran esamp_2 FIND V(xrr.esamp_node) AT=2.1050000
.meas tran tpwb_2 WHEN V(pw_base_pulse)=0.45 RISE=1 TD=1.7000000
.meas tran tpwp_2 WHEN V(pw_peak_pulse)=0.45 RISE=1 TD=1.7000000
.meas tran tcap_2 WHEN V(rr_cap_pulse)=0.45 RISE=1 TD=1.7000000
.meas tran ewma_3 FIND V(ewma_out) AT=2.9000000
.meas tran timer_3 FIND V(timer_out) AT=2.9000000
.meas tran vth_b_3 FIND V(vth_base) AT=2.9000000
.meas tran vth_p_3 FIND V(vth_peak) AT=2.9000000
.meas tran esamp_3 FIND V(xrr.esamp_node) AT=2.9050000
.meas tran tpwb_3 WHEN V(pw_base_pulse)=0.45 RISE=1 TD=2.5000000
.meas tran tpwp_3 WHEN V(pw_peak_pulse)=0.45 RISE=1 TD=2.5000000
.meas tran tcap_3 WHEN V(rr_cap_pulse)=0.45 RISE=1 TD=2.5000000
.meas tran ewma_4 FIND V(ewma_out) AT=3.7000000
.meas tran timer_4 FIND V(timer_out) AT=3.7000000
.meas tran vth_b_4 FIND V(vth_base) AT=3.7000000
.meas tran vth_p_4 FIND V(vth_peak) AT=3.7000000
.meas tran esamp_4 FIND V(xrr.esamp_node) AT=3.7050000
.meas tran tpwb_4 WHEN V(pw_base_pulse)=0.45 RISE=1 TD=3.3000000
.meas tran tpwp_4 WHEN V(pw_peak_pulse)=0.45 RISE=1 TD=3.3000000
.meas tran tcap_4 WHEN V(rr_cap_pulse)=0.45 RISE=1 TD=3.3000000
.meas tran ewma_5 FIND V(ewma_out) AT=4.5000000
.meas tran timer_5 FIND V(timer_out) AT=4.5000000
.meas tran vth_b_5 FIND V(vth_base) AT=4.5000000
.meas tran vth_p_5 FIND V(vth_peak) AT=4.5000000
.meas tran esamp_5 FIND V(xrr.esamp_node) AT=4.5050000
.meas tran tpwb_5 WHEN V(pw_base_pulse)=0.45 RISE=1 TD=4.1000000
.meas tran tpwp_5 WHEN V(pw_peak_pulse)=0.45 RISE=1 TD=4.1000000
.meas tran tcap_5 WHEN V(rr_cap_pulse)=0.45 RISE=1 TD=4.1000000
.meas tran ewma_6 FIND V(ewma_out) AT=5.3000000
.meas tran timer_6 FIND V(timer_out) AT=5.3000000
.meas tran vth_b_6 FIND V(vth_base) AT=5.3000000
.meas tran vth_p_6 FIND V(vth_peak) AT=5.3000000
.meas tran esamp_6 FIND V(xrr.esamp_node) AT=5.3050000
.meas tran tpwb_6 WHEN V(pw_base_pulse)=0.45 RISE=1 TD=4.9000000
.meas tran tpwp_6 WHEN V(pw_peak_pulse)=0.45 RISE=1 TD=4.9000000
.meas tran tcap_6 WHEN V(rr_cap_pulse)=0.45 RISE=1 TD=4.9000000
.meas tran ewma_7 FIND V(ewma_out) AT=6.1000000
.meas tran timer_7 FIND V(timer_out) AT=6.1000000
.meas tran vth_b_7 FIND V(vth_base) AT=6.1000000
.meas tran vth_p_7 FIND V(vth_peak) AT=6.1000000
.meas tran esamp_7 FIND V(xrr.esamp_node) AT=6.1050000
.meas tran tpwb_7 WHEN V(pw_base_pulse)=0.45 RISE=1 TD=5.7000000
.meas tran tpwp_7 WHEN V(pw_peak_pulse)=0.45 RISE=1 TD=5.7000000
.meas tran tcap_7 WHEN V(rr_cap_pulse)=0.45 RISE=1 TD=5.7000000
.meas tran ewma_8 FIND V(ewma_out) AT=6.9000000
.meas tran timer_8 FIND V(timer_out) AT=6.9000000
.meas tran vth_b_8 FIND V(vth_base) AT=6.9000000
.meas tran vth_p_8 FIND V(vth_peak) AT=6.9000000
.meas tran esamp_8 FIND V(xrr.esamp_node) AT=6.9050000
.meas tran tpwb_8 WHEN V(pw_base_pulse)=0.45 RISE=1 TD=6.5000000
.meas tran tpwp_8 WHEN V(pw_peak_pulse)=0.45 RISE=1 TD=6.5000000
.meas tran tcap_8 WHEN V(rr_cap_pulse)=0.45 RISE=1 TD=6.5000000
.meas tran ewma_9 FIND V(ewma_out) AT=7.7000000
.meas tran timer_9 FIND V(timer_out) AT=7.7000000
.meas tran vth_b_9 FIND V(vth_base) AT=7.7000000
.meas tran vth_p_9 FIND V(vth_peak) AT=7.7000000
.meas tran esamp_9 FIND V(xrr.esamp_node) AT=7.7050000
.meas tran tpwb_9 WHEN V(pw_base_pulse)=0.45 RISE=1 TD=7.3000000
.meas tran tpwp_9 WHEN V(pw_peak_pulse)=0.45 RISE=1 TD=7.3000000
.meas tran tcap_9 WHEN V(rr_cap_pulse)=0.45 RISE=1 TD=7.3000000

.end
