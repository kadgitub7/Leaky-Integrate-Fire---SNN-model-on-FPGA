* ============================================================
* FULL FRONTEND ENERGY TEST - All Components, Real MIT-BIH ECG
* SKY130 transistor-level, tt corner, T=27C
* ============================================================

.title full_frontend_energy_tt_27C

.lib "sky130_minimal.lib.spice" tt
.option scale=1.0u
.option method=gear
.option gmin=1e-15
.option abstol=1e-15
.option reltol=0.005
.temp 27

.include "ota_5t_subthreshold.spice"
* bias_gen.spice not included - using external Vbias source
.include "inverter.spice"
.include "resistor_div.spice"
.include "otac_lpf.spice"
.include "otac_hpf.spice"
.include "otac_bpf.spice"
.include "rectifier.spice"
.include "comparator.spice"
.include "rr_timing.spice"
.include "beat_instability.spice"
.include "pwave_energy.spice"
.include "qrs_width.spice"
.include "slope_ratio.spice"
.include "qrs_symmetry.spice"
.include "sh_channel.spice"
.include "sh_bank.spice"

* === SUPPLIES ===
Vdd vdd 0 0.9
Vss vss 0 0

Xvref_gen vdd vss vref resistor_div

* External bias at 0.35V (self-biased generator needs redesign for VDD=0.9V
* due to HVT PMOS Vth~0.7V leaving insufficient mirror headroom;
* in a real chip: dedicated low-VDD bias circuit or off-chip reference)
Vbias_src vbias 0 0.35

* === ECG INPUTS - MIT-BIH record (inline PWL) ===
Vecg0 ecg_raw_L0 0 PWL(
+ 0.000000e+00 1.599857e-01
+ 1.111111e-02 1.676878e-01
+ 2.222222e-02 1.702551e-01
+ 3.333333e-02 1.676878e-01
+ 4.444444e-02 1.779571e-01
+ 5.555556e-02 1.753898e-01
+ 6.666667e-02 1.651204e-01
+ 7.777778e-02 1.779571e-01
+ 8.888889e-02 1.779571e-01
+ 1.000000e-01 1.907938e-01
+ 1.111111e-01 2.138999e-01
+ 1.222222e-01 2.293040e-01
+ 1.333333e-01 2.293040e-01
+ 1.444444e-01 2.216019e-01
+ 1.555556e-01 2.216019e-01
+ 1.666667e-01 2.293040e-01
+ 1.777778e-01 2.087652e-01
+ 1.888889e-01 1.856592e-01
+ 2.000000e-01 1.625531e-01
+ 2.111111e-01 1.702551e-01
+ 2.222222e-01 1.651204e-01
+ 2.333333e-01 1.522837e-01
+ 2.444444e-01 1.702551e-01
+ 2.555556e-01 1.651204e-01
+ 2.666667e-01 9.580219e-02
+ 2.777778e-01 8.553283e-02
+ 2.888889e-01 4.167199e-01
+ 3.000000e-01 8.172252e-01
+ 3.111111e-01 1.753898e-01
+ 3.222222e-01 1.548511e-01
+ 3.333333e-01 1.445817e-01
+ 3.444444e-01 1.497164e-01
+ 3.555556e-01 1.471490e-01
+ 3.666667e-01 1.343123e-01
+ 3.777778e-01 1.445817e-01
+ 3.888889e-01 1.420143e-01
+ 4.000000e-01 1.420143e-01
+ 4.111111e-01 1.471490e-01
+ 4.222222e-01 1.471490e-01
+ 4.333333e-01 1.394470e-01
+ 4.444444e-01 1.548511e-01
+ 4.555556e-01 1.445817e-01
+ 4.666667e-01 1.497164e-01
+ 4.777778e-01 1.548511e-01
+ 4.888889e-01 1.471490e-01
+ 5.000000e-01 1.420143e-01
+ 5.111111e-01 1.522837e-01
+ 5.222222e-01 1.445817e-01
+ 5.333333e-01 1.471490e-01
+ 5.444444e-01 1.497164e-01
+ 5.555556e-01 1.445817e-01
+ 5.666667e-01 1.445817e-01
+ 5.777778e-01 1.548511e-01
+ 5.888889e-01 1.651204e-01
+ 6.000000e-01 1.753898e-01
+ 6.111111e-01 1.805245e-01
+ 6.222222e-01 2.036305e-01
+ 6.333333e-01 1.959285e-01
+ 6.444444e-01 2.036305e-01
+ 6.555556e-01 1.984959e-01
+ 6.666667e-01 1.959285e-01
+ 6.777778e-01 2.061979e-01
+ 6.888889e-01 1.959285e-01
+ 7.000000e-01 1.907938e-01
+ 7.111111e-01 2.010632e-01
+ 7.222222e-01 1.933612e-01
+ 7.333333e-01 1.856592e-01
+ 7.444444e-01 1.933612e-01
+ 7.555556e-01 1.805245e-01
+ 7.666667e-01 1.728224e-01
+ 7.777778e-01 1.856592e-01
+ 7.888889e-01 1.907938e-01
+ 8.000000e-01 1.753898e-01
+ 8.111111e-01 1.856592e-01
+ 8.222222e-01 1.830918e-01
+ 8.333333e-01 1.779571e-01
+ 8.444444e-01 1.959285e-01
+ 8.555556e-01 1.882265e-01
+ 8.666667e-01 1.805245e-01
+ 8.777778e-01 1.907938e-01
+ 8.888889e-01 2.061979e-01
+ 9.000000e-01 2.138999e-01
+ 9.111111e-01 2.344386e-01
+ 9.222222e-01 2.498427e-01
+ 9.333333e-01 2.318713e-01
+ 9.444444e-01 2.344386e-01
+ 9.555556e-01 2.498427e-01
+ 9.666667e-01 2.113326e-01
+ 9.777778e-01 1.959285e-01
+ 9.888889e-01 1.856592e-01
+ 1.000000e+00 1.805245e-01
+ 1.011111e+00 1.882265e-01
+ 1.022222e+00 1.779571e-01
+ 1.033333e+00 1.676878e-01
+ 1.044444e+00 1.779571e-01
+ 1.055556e+00 1.240430e-01
+ 1.066667e+00 7.012877e-02
+ 1.077778e+00 2.960549e-01
+ 1.088889e+00 7.633111e-01
+ 1.100000e+00 3.730751e-01
+ 1.111111e+00 1.291776e-01
+ 1.122222e+00 1.599857e-01
+ 1.133333e+00 1.574184e-01
+ 1.144444e+00 1.702551e-01
+ 1.155556e+00 1.676878e-01
+ 1.166667e+00 1.548511e-01
+ 1.177778e+00 1.651204e-01
+ 1.188889e+00 1.599857e-01
+ 1.200000e+00 1.574184e-01
+ 1.211111e+00 1.676878e-01
+ 1.222222e+00 1.702551e-01
+ 1.233333e+00 1.522837e-01
+ 1.244444e+00 1.548511e-01
+ 1.255556e+00 1.599857e-01
+ 1.266667e+00 1.676878e-01
+ 1.277778e+00 1.651204e-01
+ 1.288889e+00 1.599857e-01
+ 1.300000e+00 1.548511e-01
+ 1.311111e+00 1.625531e-01
+ 1.322222e+00 1.676878e-01
+ 1.333333e+00 1.471490e-01
+ 1.344444e+00 1.599857e-01
+ 1.355556e+00 1.522837e-01
+ 1.366667e+00 1.548511e-01
+ 1.377778e+00 1.728224e-01
+ 1.388889e+00 1.830918e-01
+ 1.400000e+00 1.882265e-01
+ 1.411111e+00 2.087652e-01
+ 1.422222e+00 2.138999e-01
+ 1.433333e+00 2.061979e-01
+ 1.444444e+00 2.138999e-01
+ 1.455556e+00 2.061979e-01
+ 1.466667e+00 1.933612e-01
+ 1.477778e+00 2.036305e-01
+ 1.488889e+00 1.959285e-01
+ 1.500000e+00 1.933612e-01
+ 1.511111e+00 1.984959e-01
+ 1.522222e+00 1.882265e-01
+ 1.533333e+00 1.830918e-01
+ 1.544444e+00 1.830918e-01
+ 1.555556e+00 1.779571e-01
+ 1.566667e+00 1.753898e-01
+ 1.577778e+00 1.830918e-01
+ 1.588889e+00 1.779571e-01
+ 1.600000e+00 1.805245e-01
+ 1.611111e+00 1.856592e-01
+ 1.622222e+00 1.882265e-01
+ 1.633333e+00 1.753898e-01
+ 1.644444e+00 1.933612e-01
+ 1.655556e+00 1.933612e-01
+ 1.666667e+00 2.061979e-01
+ 1.677778e+00 2.293040e-01
+ 1.688889e+00 2.370060e-01
+ 1.700000e+00 2.241693e-01
+ 1.711111e+00 2.216019e-01
+ 1.722222e+00 2.164673e-01
+ 1.733333e+00 1.984959e-01
+ 1.744444e+00 1.830918e-01
+ 1.755556e+00 1.753898e-01
+ 1.766667e+00 1.728224e-01
+ 1.777778e+00 1.702551e-01
+ 1.788889e+00 1.625531e-01
+ 1.800000e+00 1.574184e-01
+ 1.811111e+00 1.651204e-01
+ 1.822222e+00 1.343123e-01
+ 1.833333e+00 7.526346e-02
+ 1.844444e+00 2.087652e-01
+ 1.855556e+00 6.580500e-01
+ 1.866667e+00 5.527890e-01
+ 1.877778e+00 1.009369e-01
+ 1.888889e+00 1.497164e-01
+ 1.900000e+00 1.420143e-01
+ 1.911111e+00 1.445817e-01
+ 1.922222e+00 1.522837e-01
+ 1.933333e+00 1.445817e-01
+ 1.944444e+00 1.497164e-01
+ 1.955556e+00 1.445817e-01
+ 1.966667e+00 1.368797e-01
+ 1.977778e+00 1.420143e-01
+ 1.988889e+00 1.497164e-01
+ 2.000000e+00 1.394470e-01
+ 2.011111e+00 1.343123e-01
+ 2.022222e+00 1.420143e-01
+ 2.033333e+00 1.343123e-01
+ 2.044444e+00 1.394470e-01
+ 2.055556e+00 1.471490e-01
+ 2.066667e+00 1.394470e-01
+ 2.077778e+00 1.445817e-01
+ 2.088889e+00 1.368797e-01
+ 2.100000e+00 1.214756e-01
+ 2.111111e+00 1.214756e-01
+ 2.122222e+00 1.163409e-01
+ 2.133333e+00 1.163409e-01
+ 2.144444e+00 1.240430e-01
+ 2.155556e+00 1.291776e-01
+ 2.166667e+00 1.522837e-01
+ 2.177778e+00 1.702551e-01
+ 2.188889e+00 1.856592e-01
+ 2.200000e+00 1.907938e-01
+ 2.211111e+00 1.959285e-01
+ 2.222222e+00 1.959285e-01
+ 2.233333e+00 1.933612e-01
+ 2.244444e+00 2.010632e-01
+ 2.255556e+00 1.882265e-01
+ 2.266667e+00 1.805245e-01
+ 2.277778e+00 1.882265e-01
+ 2.288889e+00 1.882265e-01
+ 2.300000e+00 1.805245e-01
+ 2.311111e+00 1.882265e-01
+ 2.322222e+00 1.856592e-01
+ 2.333333e+00 1.753898e-01
+ 2.344444e+00 1.830918e-01
+ 2.355556e+00 1.779571e-01
+ 2.366667e+00 1.728224e-01
+ 2.377778e+00 1.856592e-01
+ 2.388889e+00 1.882265e-01
+ 2.400000e+00 1.728224e-01
+ 2.411111e+00 1.753898e-01
+ 2.422222e+00 1.805245e-01
+ 2.433333e+00 1.753898e-01
+ 2.444444e+00 1.830918e-01
+ 2.455556e+00 1.830918e-01
+ 2.466667e+00 1.830918e-01
+ 2.477778e+00 2.061979e-01
+ 2.488889e+00 2.190346e-01
+ 2.500000e+00 2.216019e-01
+ 2.511111e+00 2.370060e-01
+ 2.522222e+00 2.293040e-01
+ 2.533333e+00 2.241693e-01
+ 2.544444e+00 2.293040e-01
+ 2.555556e+00 2.344386e-01
+ 2.566667e+00 2.087652e-01
+ 2.577778e+00 1.856592e-01
+ 2.588889e+00 1.753898e-01
+ 2.600000e+00 1.779571e-01
+ 2.611111e+00 1.856592e-01
+ 2.622222e+00 1.779571e-01
+ 2.633333e+00 1.574184e-01
+ 2.644444e+00 1.753898e-01
+ 2.655556e+00 1.651204e-01
+ 2.666667e+00 1.112062e-01
+ 2.677778e+00 7.783080e-02
+ 2.688889e+00 3.474017e-01
+ 2.700000e+00 7.966865e-01
+ 2.711111e+00 4.038832e-01
+ 2.722222e+00 1.266103e-01
+ 2.733333e+00 1.497164e-01
+ 2.744444e+00 1.522837e-01
+ 2.755556e+00 1.548511e-01
+ 2.766667e+00 1.471490e-01
+ 2.777778e+00 1.522837e-01
+ 2.788889e+00 1.574184e-01
+ 2.800000e+00 1.522837e-01
+ 2.811111e+00 1.625531e-01
+ 2.822222e+00 1.574184e-01
+ 2.833333e+00 1.522837e-01
+ 2.844444e+00 1.625531e-01
+ 2.855556e+00 1.574184e-01
+ 2.866667e+00 1.522837e-01
+ 2.877778e+00 1.651204e-01
+ 2.888889e+00 1.574184e-01
+ 2.900000e+00 1.548511e-01
+ 2.911111e+00 1.625531e-01
+ 2.922222e+00 1.651204e-01
+ 2.933333e+00 1.522837e-01
+ 2.944444e+00 1.548511e-01
+ 2.955556e+00 1.497164e-01
+ 2.966667e+00 1.394470e-01
+ 2.977778e+00 1.522837e-01
+ 2.988889e+00 1.522837e-01
+ 3.000000e+00 1.728224e-01
+ 3.011111e+00 1.933612e-01
+ 3.022222e+00 1.984959e-01
+ 3.033333e+00 2.010632e-01
+ 3.044444e+00 2.138999e-01
+ 3.055556e+00 2.216019e-01
+ 3.066667e+00 2.061979e-01
+ 3.077778e+00 2.138999e-01
+ 3.088889e+00 2.190346e-01
+ 3.100000e+00 2.036305e-01
+ 3.111111e+00 2.061979e-01
+ 3.122222e+00 2.061979e-01
+ 3.133333e+00 1.959285e-01
+ 3.144444e+00 1.984959e-01
+ 3.155556e+00 1.959285e-01
+ 3.166667e+00 1.933612e-01
+ 3.177778e+00 1.959285e-01
+ 3.188889e+00 1.830918e-01
+ 3.200000e+00 1.779571e-01
+ 3.211111e+00 1.882265e-01
+ 3.222222e+00 1.779571e-01
+ 3.233333e+00 1.805245e-01
+ 3.244444e+00 1.933612e-01
+ 3.255556e+00 1.856592e-01
+ 3.266667e+00 1.753898e-01
+ 3.277778e+00 1.907938e-01
+ 3.288889e+00 1.882265e-01
+ 3.300000e+00 1.830918e-01
+ 3.311111e+00 1.907938e-01
+ 3.322222e+00 1.959285e-01
+ 3.333333e+00 2.061979e-01
+ 3.344444e+00 2.190346e-01
+ 3.355556e+00 2.293040e-01
+ 3.366667e+00 2.344386e-01
+ 3.377778e+00 2.344386e-01
+ 3.388889e+00 2.395733e-01
+ 3.400000e+00 2.293040e-01
+ 3.411111e+00 2.370060e-01
+ 3.422222e+00 1.984959e-01
+ 3.433333e+00 1.753898e-01
+ 3.444444e+00 1.753898e-01
+ 3.455556e+00 1.728224e-01
+ 3.466667e+00 1.651204e-01
+ 3.477778e+00 1.728224e-01
+ 3.488889e+00 1.702551e-01
+ 3.500000e+00 1.497164e-01
+ 3.511111e+00 1.112062e-01
+ 3.522222e+00 8.039814e-02
+ 3.533333e+00 9.066751e-02
+ 3.544444e+00 3.730751e-01
+ 3.555556e+00 7.838498e-01
+ 3.566667e+00 3.499690e-01
+ 3.577778e+00 1.189083e-01
+ 3.588889e+00 1.522837e-01
+ 3.600000e+00 1.522837e-01
+ 3.611111e+00 1.548511e-01
+ 3.622222e+00 1.574184e-01
+ 3.633333e+00 1.471490e-01
+ 3.644444e+00 1.574184e-01
+ 3.655556e+00 1.599857e-01
+ 3.666667e+00 1.471490e-01
+ 3.677778e+00 1.548511e-01
+ 3.688889e+00 1.599857e-01
+ 3.700000e+00 1.548511e-01
+ 3.711111e+00 1.651204e-01
+ 3.722222e+00 1.599857e-01
+ 3.733333e+00 1.522837e-01
+ 3.744444e+00 1.548511e-01
+ 3.755556e+00 1.599857e-01
+ 3.766667e+00 1.445817e-01
+ 3.777778e+00 1.574184e-01
+ 3.788889e+00 1.599857e-01
+ 3.800000e+00 1.522837e-01
+ 3.811111e+00 1.471490e-01
+ 3.822222e+00 1.522837e-01
+ 3.833333e+00 1.420143e-01
+ 3.844444e+00 1.548511e-01)
Vecg1 ecg_raw_L1 0 PWL(
+ 0.000000e+00 2.383374e-01
+ 1.111111e-02 2.491914e-01
+ 2.222222e-02 2.528094e-01
+ 3.333333e-02 2.419554e-01
+ 4.444444e-02 2.455734e-01
+ 5.555556e-02 2.672813e-01
+ 6.666667e-02 2.455734e-01
+ 7.777778e-02 2.600454e-01
+ 8.888889e-02 2.564274e-01
+ 1.000000e-01 2.383374e-01
+ 1.111111e-01 2.528094e-01
+ 1.222222e-01 2.853713e-01
+ 1.333333e-01 2.672813e-01
+ 1.444444e-01 2.889893e-01
+ 1.555556e-01 2.998432e-01
+ 1.666667e-01 2.708993e-01
+ 1.777778e-01 2.745173e-01
+ 1.888889e-01 2.745173e-01
+ 2.000000e-01 2.491914e-01
+ 2.111111e-01 2.455734e-01
+ 2.222222e-01 2.564274e-01
+ 2.333333e-01 2.600454e-01
+ 2.444444e-01 2.491914e-01
+ 2.555556e-01 2.202475e-01
+ 2.666667e-01 1.370338e-01
+ 2.777778e-01 4.337087e-01
+ 2.888889e-01 7.846534e-01
+ 3.000000e-01 5.350123e-01
+ 3.111111e-01 2.274835e-01
+ 3.222222e-01 2.311015e-01
+ 3.333333e-01 2.166295e-01
+ 3.444444e-01 2.202475e-01
+ 3.555556e-01 2.166295e-01
+ 3.666667e-01 2.130115e-01
+ 3.777778e-01 2.057756e-01
+ 3.888889e-01 2.238655e-01
+ 4.000000e-01 2.202475e-01
+ 4.111111e-01 2.238655e-01
+ 4.222222e-01 2.311015e-01
+ 4.333333e-01 2.202475e-01
+ 4.444444e-01 2.130115e-01
+ 4.555556e-01 2.238655e-01
+ 4.666667e-01 2.057756e-01
+ 4.777778e-01 2.057756e-01
+ 4.888889e-01 2.093936e-01
+ 5.000000e-01 1.768317e-01
+ 5.111111e-01 1.659777e-01
+ 5.222222e-01 1.551238e-01
+ 5.333333e-01 1.334158e-01
+ 5.444444e-01 1.225619e-01
+ 5.555556e-01 1.334158e-01
+ 5.666667e-01 1.334158e-01
+ 5.777778e-01 1.768317e-01
+ 5.888889e-01 2.166295e-01
+ 6.000000e-01 2.202475e-01
+ 6.111111e-01 2.528094e-01
+ 6.222222e-01 2.817533e-01
+ 6.333333e-01 2.708993e-01
+ 6.444444e-01 2.636634e-01
+ 6.555556e-01 2.781353e-01
+ 6.666667e-01 2.600454e-01
+ 6.777778e-01 2.708993e-01
+ 6.888889e-01 2.745173e-01
+ 7.000000e-01 2.564274e-01
+ 7.111111e-01 2.564274e-01
+ 7.222222e-01 2.672813e-01
+ 7.333333e-01 2.491914e-01
+ 7.444444e-01 2.600454e-01
+ 7.555556e-01 2.528094e-01
+ 7.666667e-01 2.491914e-01
+ 7.777778e-01 2.491914e-01
+ 7.888889e-01 2.636634e-01
+ 8.000000e-01 2.419554e-01
+ 8.111111e-01 2.636634e-01
+ 8.222222e-01 2.708993e-01
+ 8.333333e-01 2.491914e-01
+ 8.444444e-01 2.636634e-01
+ 8.555556e-01 2.745173e-01
+ 8.666667e-01 2.564274e-01
+ 8.777778e-01 2.708993e-01
+ 8.888889e-01 2.672813e-01
+ 9.000000e-01 2.672813e-01
+ 9.111111e-01 2.817533e-01
+ 9.222222e-01 2.998432e-01
+ 9.333333e-01 3.070792e-01
+ 9.444444e-01 3.143152e-01
+ 9.555556e-01 2.962252e-01
+ 9.666667e-01 2.817533e-01
+ 9.777778e-01 2.745173e-01
+ 9.888889e-01 2.817533e-01
+ 1.000000e+00 2.636634e-01
+ 1.011111e+00 2.708993e-01
+ 1.022222e+00 2.708993e-01
+ 1.033333e+00 2.636634e-01
+ 1.044444e+00 2.455734e-01
+ 1.055556e+00 1.804497e-01
+ 1.066667e+00 3.287871e-01
+ 1.077778e+00 6.146081e-01
+ 1.088889e+00 7.195297e-01
+ 1.100000e+00 2.021576e-01
+ 1.111111e+00 2.455734e-01
+ 1.122222e+00 2.564274e-01
+ 1.133333e+00 2.347195e-01
+ 1.144444e+00 2.455734e-01
+ 1.155556e+00 2.455734e-01
+ 1.166667e+00 2.311015e-01
+ 1.177778e+00 2.419554e-01
+ 1.188889e+00 2.491914e-01
+ 1.200000e+00 2.347195e-01
+ 1.211111e+00 2.419554e-01
+ 1.222222e+00 2.491914e-01
+ 1.233333e+00 2.383374e-01
+ 1.244444e+00 2.311015e-01
+ 1.255556e+00 2.455734e-01
+ 1.266667e+00 2.274835e-01
+ 1.277778e+00 2.166295e-01
+ 1.288889e+00 2.202475e-01
+ 1.300000e+00 1.949216e-01
+ 1.311111e+00 1.768317e-01
+ 1.322222e+00 1.804497e-01
+ 1.333333e+00 1.515058e-01
+ 1.344444e+00 1.515058e-01
+ 1.355556e+00 1.659777e-01
+ 1.366667e+00 1.804497e-01
+ 1.377778e+00 2.202475e-01
+ 1.388889e+00 2.528094e-01
+ 1.400000e+00 2.528094e-01
+ 1.411111e+00 2.600454e-01
+ 1.422222e+00 2.708993e-01
+ 1.433333e+00 2.564274e-01
+ 1.444444e+00 2.564274e-01
+ 1.455556e+00 2.636634e-01
+ 1.466667e+00 2.491914e-01
+ 1.477778e+00 2.491914e-01
+ 1.488889e+00 2.600454e-01
+ 1.500000e+00 2.383374e-01
+ 1.511111e+00 2.347195e-01
+ 1.522222e+00 2.347195e-01
+ 1.533333e+00 2.274835e-01
+ 1.544444e+00 2.274835e-01
+ 1.555556e+00 2.383374e-01
+ 1.566667e+00 2.202475e-01
+ 1.577778e+00 2.274835e-01
+ 1.588889e+00 2.347195e-01
+ 1.600000e+00 2.130115e-01
+ 1.611111e+00 2.347195e-01
+ 1.622222e+00 2.347195e-01
+ 1.633333e+00 2.202475e-01
+ 1.644444e+00 2.166295e-01
+ 1.655556e+00 2.311015e-01
+ 1.666667e+00 2.093936e-01
+ 1.677778e+00 2.455734e-01
+ 1.688889e+00 2.528094e-01
+ 1.700000e+00 2.491914e-01
+ 1.711111e+00 2.491914e-01
+ 1.722222e+00 2.528094e-01
+ 1.733333e+00 2.383374e-01
+ 1.744444e+00 2.130115e-01
+ 1.755556e+00 2.166295e-01
+ 1.766667e+00 2.202475e-01
+ 1.777778e+00 2.166295e-01
+ 1.788889e+00 2.093936e-01
+ 1.800000e+00 1.985396e-01
+ 1.811111e+00 2.021576e-01
+ 1.822222e+00 1.623597e-01
+ 1.833333e+00 1.876856e-01
+ 1.844444e+00 4.300907e-01
+ 1.855556e+00 6.688778e-01
+ 1.866667e+00 9.000000e-02
+ 1.877778e+00 1.587417e-01
+ 1.888889e+00 1.876856e-01
+ 1.900000e+00 1.732137e-01
+ 1.911111e+00 1.732137e-01
+ 1.922222e+00 1.913036e-01
+ 1.933333e+00 1.804497e-01
+ 1.944444e+00 1.876856e-01
+ 1.955556e+00 1.840677e-01
+ 1.966667e+00 1.732137e-01
+ 1.977778e+00 1.768317e-01
+ 1.988889e+00 1.876856e-01
+ 2.000000e+00 1.804497e-01
+ 2.011111e+00 1.768317e-01
+ 2.022222e+00 1.840677e-01
+ 2.033333e+00 1.695957e-01
+ 2.044444e+00 1.623597e-01
+ 2.055556e+00 1.695957e-01
+ 2.066667e+00 1.515058e-01
+ 2.077778e+00 1.442698e-01
+ 2.088889e+00 1.406518e-01
+ 2.100000e+00 1.080899e-01
+ 2.111111e+00 9.000000e-02
+ 2.122222e+00 8.638201e-02
+ 2.133333e+00 7.552805e-02
+ 2.144444e+00 1.044719e-01
+ 2.155556e+00 1.515058e-01
+ 2.166667e+00 1.623597e-01
+ 2.177778e+00 2.130115e-01
+ 2.188889e+00 2.274835e-01
+ 2.200000e+00 2.238655e-01
+ 2.211111e+00 2.274835e-01
+ 2.222222e+00 2.455734e-01
+ 2.233333e+00 2.347195e-01
+ 2.244444e+00 2.347195e-01
+ 2.255556e+00 2.383374e-01
+ 2.266667e+00 2.311015e-01
+ 2.277778e+00 2.274835e-01
+ 2.288889e+00 2.311015e-01
+ 2.300000e+00 2.166295e-01
+ 2.311111e+00 2.238655e-01
+ 2.322222e+00 2.383374e-01
+ 2.333333e+00 2.166295e-01
+ 2.344444e+00 2.238655e-01
+ 2.355556e+00 2.311015e-01
+ 2.366667e+00 2.166295e-01
+ 2.377778e+00 2.274835e-01
+ 2.388889e+00 2.311015e-01
+ 2.400000e+00 2.130115e-01
+ 2.411111e+00 2.238655e-01
+ 2.422222e+00 2.311015e-01
+ 2.433333e+00 2.202475e-01
+ 2.444444e+00 2.202475e-01
+ 2.455556e+00 2.347195e-01
+ 2.466667e+00 2.166295e-01
+ 2.477778e+00 2.238655e-01
+ 2.488889e+00 2.419554e-01
+ 2.500000e+00 2.419554e-01
+ 2.511111e+00 2.528094e-01
+ 2.522222e+00 2.636634e-01
+ 2.533333e+00 2.564274e-01
+ 2.544444e+00 2.708993e-01
+ 2.555556e+00 2.564274e-01
+ 2.566667e+00 2.383374e-01
+ 2.577778e+00 2.419554e-01
+ 2.588889e+00 2.419554e-01
+ 2.600000e+00 2.202475e-01
+ 2.611111e+00 2.311015e-01
+ 2.622222e+00 2.383374e-01
+ 2.633333e+00 2.311015e-01
+ 2.644444e+00 2.274835e-01
+ 2.655556e+00 1.985396e-01
+ 2.666667e+00 1.225619e-01
+ 2.677778e+00 3.468770e-01
+ 2.688889e+00 6.942038e-01
+ 2.700000e+00 7.484736e-01
+ 2.711111e+00 1.732137e-01
+ 2.722222e+00 2.166295e-01
+ 2.733333e+00 1.985396e-01
+ 2.744444e+00 2.021576e-01
+ 2.755556e+00 2.093936e-01
+ 2.766667e+00 1.913036e-01
+ 2.777778e+00 1.985396e-01
+ 2.788889e+00 1.985396e-01
+ 2.800000e+00 2.021576e-01
+ 2.811111e+00 2.057756e-01
+ 2.822222e+00 2.057756e-01
+ 2.833333e+00 2.057756e-01
+ 2.844444e+00 2.021576e-01
+ 2.855556e+00 2.093936e-01
+ 2.866667e+00 1.949216e-01
+ 2.877778e+00 1.949216e-01
+ 2.888889e+00 1.876856e-01
+ 2.900000e+00 1.804497e-01
+ 2.911111e+00 1.623597e-01
+ 2.922222e+00 1.623597e-01
+ 2.933333e+00 1.261799e-01
+ 2.944444e+00 1.225619e-01
+ 2.955556e+00 1.080899e-01
+ 2.966667e+00 1.080899e-01
+ 2.977778e+00 1.080899e-01
+ 2.988889e+00 1.551238e-01
+ 3.000000e+00 1.768317e-01
+ 3.011111e+00 2.238655e-01
+ 3.022222e+00 2.419554e-01
+ 3.033333e+00 2.528094e-01
+ 3.044444e+00 2.564274e-01
+ 3.055556e+00 2.672813e-01
+ 3.066667e+00 2.564274e-01
+ 3.077778e+00 2.528094e-01
+ 3.088889e+00 2.708993e-01
+ 3.100000e+00 2.528094e-01
+ 3.111111e+00 2.564274e-01
+ 3.122222e+00 2.564274e-01
+ 3.133333e+00 2.419554e-01
+ 3.144444e+00 2.347195e-01
+ 3.155556e+00 2.455734e-01
+ 3.166667e+00 2.202475e-01
+ 3.177778e+00 2.347195e-01
+ 3.188889e+00 2.383374e-01
+ 3.200000e+00 2.274835e-01
+ 3.211111e+00 2.238655e-01
+ 3.222222e+00 2.311015e-01
+ 3.233333e+00 2.238655e-01
+ 3.244444e+00 2.130115e-01
+ 3.255556e+00 2.383374e-01
+ 3.266667e+00 2.166295e-01
+ 3.277778e+00 2.238655e-01
+ 3.288889e+00 2.383374e-01
+ 3.300000e+00 2.202475e-01
+ 3.311111e+00 2.311015e-01
+ 3.322222e+00 2.311015e-01
+ 3.333333e+00 2.202475e-01
+ 3.344444e+00 2.238655e-01
+ 3.355556e+00 2.455734e-01
+ 3.366667e+00 2.383374e-01
+ 3.377778e+00 2.708993e-01
+ 3.388889e+00 2.636634e-01
+ 3.400000e+00 2.600454e-01
+ 3.411111e+00 2.419554e-01
+ 3.422222e+00 2.419554e-01
+ 3.433333e+00 2.202475e-01
+ 3.444444e+00 2.238655e-01
+ 3.455556e+00 2.274835e-01
+ 3.466667e+00 2.021576e-01
+ 3.477778e+00 2.166295e-01
+ 3.488889e+00 2.274835e-01
+ 3.500000e+00 1.623597e-01
+ 3.511111e+00 1.297979e-01
+ 3.522222e+00 1.117079e-01
+ 3.533333e+00 3.830569e-01
+ 3.544444e+00 6.869678e-01
+ 3.555556e+00 7.231476e-01
+ 3.566667e+00 1.623597e-01
+ 3.577778e+00 2.021576e-01
+ 3.588889e+00 1.949216e-01
+ 3.600000e+00 1.876856e-01
+ 3.611111e+00 1.876856e-01
+ 3.622222e+00 1.985396e-01
+ 3.633333e+00 1.768317e-01
+ 3.644444e+00 1.949216e-01
+ 3.655556e+00 1.985396e-01
+ 3.666667e+00 1.913036e-01
+ 3.677778e+00 1.949216e-01
+ 3.688889e+00 2.093936e-01
+ 3.700000e+00 1.804497e-01
+ 3.711111e+00 1.949216e-01
+ 3.722222e+00 1.949216e-01
+ 3.733333e+00 1.804497e-01
+ 3.744444e+00 1.876856e-01
+ 3.755556e+00 1.804497e-01
+ 3.766667e+00 1.551238e-01
+ 3.777778e+00 1.442698e-01
+ 3.788889e+00 1.406518e-01
+ 3.800000e+00 1.117079e-01
+ 3.811111e+00 1.008540e-01
+ 3.822222e+00 9.723597e-02
+ 3.833333e+00 9.000000e-02
+ 3.844444e+00 1.189439e-01)

* === STAGE 1: Input Conditioning (ALWAYS-ON, 8 OTAs) ===
Xbuf0 ecg_raw_L0 ecg_buf_L0 ecg_buf_L0 vdd vss vbias ota_5t
Xhpf0 ecg_buf_L0 ecg_hp_L0 vdd vss vbias otac_hpf cap_w=100 cap_l=100
Xlpf0 ecg_hp_L0 ecg_cond_L0 vdd vss vbias otac_lpf cap_w=17 cap_l=17

Xbuf1 ecg_raw_L1 ecg_buf_L1 ecg_buf_L1 vdd vss vbias ota_5t
Xhpf1 ecg_buf_L1 ecg_hp_L1 vdd vss vbias otac_hpf cap_w=100 cap_l=100
Xlpf1 ecg_hp_L1 ecg_cond_L1 vdd vss vbias otac_lpf cap_w=17 cap_l=17

* === STAGE 2: R-Peak Detection (ALWAYS-ON, 9 OTAs) ===
Xbpf ecg_cond_L0 bpf_out vdd vss vbias otac_bpf cl_hpf=39 cw_hpf=39 cl_lpf=24 cw_lpf=24
Xrect bpf_out rect_out vref vdd vss vbias rectifier
Xenv rect_out env_out vdd vss vbias otac_lpf cap_w=77 cap_l=77
Xthresh env_out thresh_out vdd vss vbias otac_lpf cap_w=50 cap_l=50
Xcmp env_out thresh_out rpeak_internal vdd vss vbias comparator

* === TIMING - External PWL (hardware: monostable from rpeak) ===
Vrpeak rpeak_trigger 0 PWL(
+ 0.0000000e+00 0.000000e+00
+ 2.9990000e-01 0.000000e+00
+ 3.0000000e-01 9.000000e-01
+ 3.0500000e-01 9.000000e-01
+ 3.0510000e-01 0.000000e+00
+ 1.0887889e+00 0.000000e+00
+ 1.0888889e+00 9.000000e-01
+ 1.0938889e+00 9.000000e-01
+ 1.0939889e+00 0.000000e+00
+ 1.8610111e+00 0.000000e+00
+ 1.8611111e+00 9.000000e-01
+ 1.8661111e+00 9.000000e-01
+ 1.8662111e+00 0.000000e+00
+ 2.6999000e+00 0.000000e+00
+ 2.7000000e+00 9.000000e-01
+ 2.7050000e+00 9.000000e-01
+ 2.7051000e+00 0.000000e+00
+ 3.5554556e+00 0.000000e+00
+ 3.5555556e+00 9.000000e-01
+ 3.5605556e+00 9.000000e-01
+ 3.5606556e+00 0.000000e+00
+ 3.8527778e+00 0.000000e+00)
Vqrs_gate qrs_gate 0 PWL(
+ 0.0000000e+00 0.000000e+00
+ 2.4990000e-01 0.000000e+00
+ 2.5000000e-01 9.000000e-01
+ 4.0000000e-01 9.000000e-01
+ 4.0010000e-01 0.000000e+00
+ 1.0387889e+00 0.000000e+00
+ 1.0388889e+00 9.000000e-01
+ 1.1888889e+00 9.000000e-01
+ 1.1889889e+00 0.000000e+00
+ 1.8110111e+00 0.000000e+00
+ 1.8111111e+00 9.000000e-01
+ 1.9611111e+00 9.000000e-01
+ 1.9612111e+00 0.000000e+00
+ 2.6499000e+00 0.000000e+00
+ 2.6500000e+00 9.000000e-01
+ 2.8000000e+00 9.000000e-01
+ 2.8001000e+00 0.000000e+00
+ 3.5054556e+00 0.000000e+00
+ 3.5055556e+00 9.000000e-01
+ 3.6555556e+00 9.000000e-01
+ 3.6556556e+00 0.000000e+00
+ 3.8527778e+00 0.000000e+00)
Vpwave_gate pwave_gate 0 PWL(
+ 0.0000000e+00 0.000000e+00
+ 1.7990000e-01 0.000000e+00
+ 1.8000000e-01 9.000000e-01
+ 2.8000000e-01 9.000000e-01
+ 2.8010000e-01 0.000000e+00
+ 9.6878889e-01 0.000000e+00
+ 9.6888889e-01 9.000000e-01
+ 1.0688889e+00 9.000000e-01
+ 1.0689889e+00 0.000000e+00
+ 1.7410111e+00 0.000000e+00
+ 1.7411111e+00 9.000000e-01
+ 1.8411111e+00 9.000000e-01
+ 1.8412111e+00 0.000000e+00
+ 2.5799000e+00 0.000000e+00
+ 2.5800000e+00 9.000000e-01
+ 2.6800000e+00 9.000000e-01
+ 2.6801000e+00 0.000000e+00
+ 3.4354556e+00 0.000000e+00
+ 3.4355556e+00 9.000000e-01
+ 3.5355556e+00 9.000000e-01
+ 3.5356556e+00 0.000000e+00
+ 3.8527778e+00 0.000000e+00)
Vsample_clk sample_clk 0 PWL(
+ 0.0000000e+00 0.000000e+00
+ 4.9990000e-01 0.000000e+00
+ 5.0000000e-01 9.000000e-01
+ 5.0200000e-01 9.000000e-01
+ 5.0210000e-01 0.000000e+00
+ 1.2887889e+00 0.000000e+00
+ 1.2888889e+00 9.000000e-01
+ 1.2908889e+00 9.000000e-01
+ 1.2909889e+00 0.000000e+00
+ 2.0610111e+00 0.000000e+00
+ 2.0611111e+00 9.000000e-01
+ 2.0631111e+00 9.000000e-01
+ 2.0632111e+00 0.000000e+00
+ 2.8999000e+00 0.000000e+00
+ 2.9000000e+00 9.000000e-01
+ 2.9020000e+00 9.000000e-01
+ 2.9021000e+00 0.000000e+00
+ 3.7554556e+00 0.000000e+00
+ 3.7555556e+00 9.000000e-01
+ 3.7575556e+00 9.000000e-01
+ 3.7576556e+00 0.000000e+00
+ 3.8527778e+00 0.000000e+00)
Vsample_clkb sample_clk_bar 0 PWL(
+ 0.0000000e+00 9.000000e-01
+ 4.9990000e-01 9.000000e-01
+ 5.0000000e-01 0.000000e+00
+ 5.0200000e-01 0.000000e+00
+ 5.0210000e-01 9.000000e-01
+ 1.2887889e+00 9.000000e-01
+ 1.2888889e+00 0.000000e+00
+ 1.2908889e+00 0.000000e+00
+ 1.2909889e+00 9.000000e-01
+ 2.0610111e+00 9.000000e-01
+ 2.0611111e+00 0.000000e+00
+ 2.0631111e+00 0.000000e+00
+ 2.0632111e+00 9.000000e-01
+ 2.8999000e+00 9.000000e-01
+ 2.9000000e+00 0.000000e+00
+ 2.9020000e+00 0.000000e+00
+ 2.9021000e+00 9.000000e-01
+ 3.7554556e+00 9.000000e-01
+ 3.7555556e+00 0.000000e+00
+ 3.7575556e+00 0.000000e+00
+ 3.7576556e+00 9.000000e-01
+ 3.8527778e+00 9.000000e-01)

* === STAGE 3: Feature Extraction ===
Xrr rpeak_trigger f_rr_ratio f_rr_asym vdd vss vbias rr_timing
Xinstab0 ecg_cond_L0 qrs_gate rpeak_trigger f_instab_L0 vdd vss vbias vref beat_instability
Xinstab1 ecg_cond_L1 qrs_gate rpeak_trigger f_instab_L1 vdd vss vbias vref beat_instability
Xpwave ecg_cond_L0 pwave_gate rpeak_trigger f_pwave vdd vss vbias vref pwave_energy
Xwidth vref ecg_cond_L0 qrs_gate rpeak_trigger f_width vdd vss vbias qrs_width
Xslope ecg_cond_L0 qrs_gate rpeak_trigger f_slope vdd vss vbias vref slope_ratio
Xsym qrs_gate rpeak_trigger f_width f_sym rpeak_trigger vdd vss vbias qrs_symmetry

* === STAGE 4: Sample-and-Hold Bank (8 channels) ===
Xsh f_rr_ratio f_rr_asym f_instab_L0 f_instab_L1 f_pwave f_width f_slope f_sym
+ o_rr_ratio o_rr_asym o_instab_L0 o_instab_L1 o_pwave o_width o_slope o_sym
+ sample_clk sample_clk_bar vdd vss sh_bank

* === SIMULATION ===
.tran 200u 3.852777777777778 uic

.meas tran I_total_avg AVG i(Vdd) FROM=1.0 TO=3.352777777777778
.meas tran I_total_rms RMS i(Vdd) FROM=1.0 TO=3.352777777777778

.control
  run
  echo ""
  echo "============================================================"
  echo " FULL FRONTEND ENERGY - SKY130 tt 27C"
  echo "============================================================"
  echo ""
  echo "--- Supply current measurements ---"
  print I_total_avg I_total_rms
  echo ""
  echo "--- Full current waveform (decimated) ---"
  print -i(Vdd)
  quit
.endc

.end
