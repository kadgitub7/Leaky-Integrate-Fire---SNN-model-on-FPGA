.title pwave_bpf_v1_test_100
.lib "sky130_minimal.lib.spice" tt
.option scale=1.0u method=gear reltol=0.01 gmin=1e-15
.temp 27

Vdd vdd 0 0.9
Vss vss 0 0

* Bias voltages (from AC characterization)
Vbias_lpf vbias_lpf 0 0.300
Vbias_hpf vbias_hpf 0 0.250

* ECG Lead 1 input
Vecg ecg_l1 0 PWL(0.0000000 0.300000 2.7450000 0.300000 2.7500000 0.284088 2.7527778 0.284383 2.7555556 0.284972 2.7583333 0.285562 2.7611111 0.284972 2.7638889 0.283794 2.7666667 0.283794 2.7694444 0.283794 2.7722222 0.284972 2.7750000 0.284972 2.7777778 0.284678 2.7805556 0.284383 2.7833333 0.283204 2.7861111 0.283499 2.7888889 0.284383 2.7916667 0.284678 2.7944444 0.284972 2.7972222 0.285267 2.8000000 0.284972 2.8027778 0.285267 2.8055556 0.285856 2.8083333 0.286446 2.8111111 0.286151 2.8138889 0.286740 2.8166667 0.286151 2.8194444 0.285856 2.8222222 0.286740 2.8250000 0.287330 2.8277778 0.286151 2.8305556 0.286446 2.8333333 0.286740 2.8361111 0.287330 2.8388889 0.287919 2.8416667 0.288214 2.8444444 0.287624 2.8472222 0.286740 2.8500000 0.286446 2.8527778 0.286740 2.8555556 0.287330 2.8583333 0.287624 2.8611111 0.286151 2.8638889 0.285856 2.8666667 0.284972 2.8694444 0.285562 2.8722222 0.286151 2.8750000 0.286446 2.8777778 0.286151 2.8805556 0.285562 2.8833333 0.284088 2.8861111 0.284678 2.8888889 0.285267 2.8916667 0.285856 2.8944444 0.285856 2.8972222 0.284972 2.9000000 0.284678 2.9027778 0.284383 2.9055556 0.284972 2.9083333 0.285562 2.9111111 0.285562 2.9138889 0.284678 2.9166667 0.284972 2.9194444 0.284678 2.9222222 0.284972 2.9250000 0.285856 2.9277778 0.285856 2.9305556 0.284678 2.9333333 0.284678 2.9361111 0.285267 2.9388889 0.285856 2.9416667 0.286151 2.9444444 0.285856 2.9472222 0.284972 2.9500000 0.284088 2.9527778 0.283204 2.9555556 0.282910 2.9583333 0.281731 2.9611111 0.280552 2.9638889 0.278490 2.9666667 0.278195 2.9694444 0.279374 2.9722222 0.284678 2.9750000 0.292044 2.9777778 0.298821 2.9805556 0.302063 2.9833333 0.305599 2.9861111 0.310902 2.9888889 0.318564 2.9916667 0.326519 2.9944444 0.330350 2.9972222 0.326519 3.0000000 0.310313 3.0027778 0.289392 3.0055556 0.277311 3.0083333 0.276722 3.0111111 0.279669 3.0138889 0.281731 3.0166667 0.282910 3.0194444 0.283794 3.0222222 0.284383 3.0250000 0.286151 3.0277778 0.285267 3.0305556 0.284383 3.0333333 0.284972 3.0361111 0.285562 3.0388889 0.285856 3.0416667 0.285856 3.0444444 0.285267 3.0472222 0.284678 3.0500000 0.284383 3.0527778 0.283794 3.0555556 0.284972 3.0583333 0.285856 3.0611111 0.285562 3.0638889 0.284678 3.0666667 0.284678 3.0694444 0.284383 3.0722222 0.285267 3.0750000 0.285267 3.0777778 0.285562 3.0805556 0.285267 3.0833333 0.284383 3.0861111 0.284972 3.0888889 0.285267 3.0916667 0.285562 3.0944444 0.285562 3.0972222 0.284972 3.1000000 0.284678 3.1027778 0.285267 3.1055556 0.285856 3.1083333 0.287330 3.1111111 0.286446 3.1138889 0.285267 3.1166667 0.285267 3.1194444 0.284972 3.1222222 0.285856 3.1250000 0.287035 3.1277778 0.286151 3.1305556 0.286151 3.1333333 0.285856 3.1361111 0.284972 3.1388889 0.285562 3.1416667 0.286740 3.1444444 0.286446 3.1472222 0.286151 3.1500000 0.285856 3.1527778 0.285856 3.1555556 0.285856 3.1583333 0.286446 3.1611111 0.285562 3.1638889 0.284972 3.1666667 0.285267 3.1694444 0.285267 3.1722222 0.286151 3.1750000 0.285856 3.1777778 0.286151 3.1805556 0.284972 3.1833333 0.284972 3.1861111 0.284972 3.1888889 0.285267 3.1916667 0.286151 3.1944444 0.284678 3.1972222 0.284972 3.2000000 0.284088 3.2027778 0.283204 3.2055556 0.283204 3.2083333 0.283499 3.2111111 0.283204 3.2138889 0.283204 3.2166667 0.282026 3.2194444 0.282615 3.2222222 0.283204 3.2250000 0.282910 3.2277778 0.282026 3.2305556 0.281142 3.2333333 0.280258 3.2361111 0.279963 3.2388889 0.281436 3.2416667 0.281436 3.2444444 0.280552 3.2472222 0.279669 3.2500000 0.279374 3.2527778 0.279079 3.2555556 0.278490 3.2583333 0.279079 3.2611111 0.278490 3.2638889 0.278195 3.2666667 0.277901 3.2694444 0.277901 3.2722222 0.278195 3.2750000 0.279079 3.2777778 0.278785 3.2805556 0.279963 3.2833333 0.279963 3.2861111 0.280552 3.2888889 0.281436 3.2916667 0.282910 3.2944444 0.283794 3.2972222 0.284383 3.3050000 0.300000 3.5616667 0.300000 3.5666667 0.290276 3.5694444 0.290571 3.5722222 0.290571 3.5750000 0.291455 3.5777778 0.291160 3.5805556 0.291160 3.5833333 0.290571 3.5861111 0.290571 3.5888889 0.291160 3.5916667 0.291160 3.5944444 0.291160 3.5972222 0.290866 3.6000000 0.290571 3.6027778 0.290571 3.6055556 0.291160 3.6083333 0.292339 3.6111111 0.291160 3.6138889 0.290866 3.6166667 0.290571 3.6194444 0.291160 3.6222222 0.292634 3.6250000 0.292928 3.6277778 0.293223 3.6305556 0.292634 3.6333333 0.292044 3.6361111 0.291750 3.6388889 0.292339 3.6416667 0.293812 3.6444444 0.293812 3.6472222 0.294107 3.6500000 0.293812 3.6527778 0.294696 3.6555556 0.295285 3.6583333 0.295580 3.6611111 0.294696 3.6638889 0.294696 3.6666667 0.294107 3.6694444 0.294107 3.6722222 0.294401 3.6750000 0.294696 3.6777778 0.293517 3.6805556 0.292634 3.6833333 0.292339 3.6861111 0.292928 3.6888889 0.292928 3.6916667 0.293517 3.6944444 0.293517 3.6972222 0.292928 3.7000000 0.292339 3.7027778 0.291750 3.7055556 0.291455 3.7083333 0.292634 3.7111111 0.292339 3.7138889 0.291160 3.7166667 0.291455 3.7194444 0.291750 3.7222222 0.291750 3.7250000 0.292928 3.7277778 0.292044 3.7305556 0.291455 3.7333333 0.290571 3.7361111 0.291160 3.7388889 0.292044 3.7416667 0.292634 3.7444444 0.292044 3.7472222 0.291455 3.7500000 0.291160 3.7527778 0.290571 3.7555556 0.291455 3.7583333 0.292044 3.7611111 0.292044 3.7638889 0.292634 3.7666667 0.290571 3.7694444 0.289687 3.7722222 0.288508 3.7750000 0.287624 3.7777778 0.286446 3.7805556 0.284088 3.7833333 0.282910 3.7861111 0.283499 3.7888889 0.288508 3.7916667 0.297053 3.7944444 0.305009 3.7972222 0.311492 3.8000000 0.317974 3.8027778 0.324751 3.8055556 0.333297 3.8083333 0.341547 3.8111111 0.347145 3.8138889 0.346851 3.8166667 0.335064 3.8194444 0.313849 3.8222222 0.295580 3.8250000 0.288803 3.8277778 0.289098 3.8305556 0.290866 3.8333333 0.289982 3.8361111 0.290276 3.8388889 0.290866 3.8416667 0.291455 3.8444444 0.290866 3.8472222 0.288803 3.8500000 0.288214 3.8527778 0.288508 3.8555556 0.289687 3.8583333 0.289687 3.8611111 0.289392 3.8638889 0.289098 3.8666667 0.288214 3.8694444 0.288508 3.8722222 0.288214 3.8750000 0.288508 3.8777778 0.288803 3.8805556 0.288508 3.8833333 0.288214 3.8861111 0.288214 3.8888889 0.288803 3.8916667 0.289392 3.8944444 0.289098 3.8972222 0.288508 3.9000000 0.287624 3.9027778 0.287624 3.9055556 0.289687 3.9083333 0.288803 3.9111111 0.289098 3.9138889 0.289098 3.9166667 0.288508 3.9194444 0.288214 3.9222222 0.288508 3.9250000 0.289392 3.9277778 0.288803 3.9305556 0.288508 3.9333333 0.288803 3.9361111 0.288508 3.9388889 0.289687 3.9416667 0.289687 3.9444444 0.289098 3.9472222 0.288803 3.9500000 0.288508 3.9527778 0.288803 3.9555556 0.289098 3.9583333 0.289982 3.9611111 0.289982 3.9638889 0.288803 3.9666667 0.288214 3.9694444 0.288214 3.9722222 0.289392 3.9750000 0.289687 3.9777778 0.288508 3.9805556 0.289687 3.9833333 0.288803 3.9861111 0.288803 3.9888889 0.288803 3.9916667 0.289392 3.9944444 0.288803 3.9972222 0.287624 4.0000000 0.287919 4.0027778 0.288214 4.0055556 0.287624 4.0083333 0.288508 4.0111111 0.287919 4.0138889 0.287330 4.0166667 0.286446 4.0194444 0.287330 4.0222222 0.286740 4.0250000 0.287919 4.0277778 0.287330 4.0305556 0.286151 4.0333333 0.285562 4.0361111 0.285562 4.0388889 0.285856 4.0416667 0.285562 4.0444444 0.286151 4.0472222 0.284678 4.0500000 0.284383 4.0527778 0.284088 4.0555556 0.284383 4.0583333 0.284383 4.0611111 0.284088 4.0638889 0.283204 4.0666667 0.282320 4.0694444 0.282615 4.0722222 0.282615 4.0750000 0.282615 4.0777778 0.282026 4.0805556 0.281731 4.0833333 0.281142 4.0861111 0.280847 4.0888889 0.281142 4.0916667 0.281731 4.0944444 0.281142 4.0972222 0.281142 4.1000000 0.280847 4.1027778 0.281731 4.1055556 0.283499 4.1083333 0.283499 4.1111111 0.283499 4.1138889 0.284383 4.1216667 0.300000 4.2144444 0.300000 4.2194444 0.292928 4.2222222 0.293223 4.2250000 0.293812 4.2277778 0.293517 4.2305556 0.292634 4.2333333 0.293223 4.2361111 0.292339 4.2388889 0.293223 4.2416667 0.294401 4.2444444 0.294107 4.2472222 0.293517 4.2500000 0.293223 4.2527778 0.293223 4.2555556 0.293812 4.2583333 0.294107 4.2611111 0.293517 4.2638889 0.294107 4.2666667 0.294107 4.2694444 0.293812 4.2722222 0.294401 4.2750000 0.294401 4.2777778 0.294401 4.2805556 0.293517 4.2833333 0.293223 4.2861111 0.293517 4.2888889 0.293812 4.2916667 0.293812 4.2944444 0.293223 4.2972222 0.293223 4.3000000 0.292044 4.3027778 0.292634 4.3055556 0.292044 4.3083333 0.292634 4.3111111 0.292339 4.3138889 0.291160 4.3166667 0.290866 4.3194444 0.290276 4.3222222 0.290276 4.3250000 0.289982 4.3277778 0.289687 4.3305556 0.289982 4.3333333 0.289687 4.3361111 0.289982 4.3388889 0.290276 4.3416667 0.290571 4.3444444 0.290571 4.3472222 0.289982 4.3500000 0.289392 4.3527778 0.289982 4.3555556 0.290866 4.3583333 0.290866 4.3611111 0.290571 4.3638889 0.290571 4.3666667 0.289687 4.3694444 0.289982 4.3722222 0.290866 4.3750000 0.291160 4.3777778 0.290571 4.3805556 0.290866 4.3833333 0.290276 4.3861111 0.290571 4.3888889 0.291160 4.3916667 0.291160 4.3944444 0.291455 4.3972222 0.290866 4.4000000 0.290276 4.4027778 0.290866 4.4055556 0.292044 4.4083333 0.292339 4.4111111 0.291455 4.4138889 0.290866 4.4166667 0.290571 4.4194444 0.290571 4.4222222 0.289687 4.4250000 0.288803 4.4277778 0.286151 4.4305556 0.285267 4.4333333 0.282615 4.4361111 0.281436 4.4388889 0.282615 4.4416667 0.288803 4.4444444 0.294991 4.4472222 0.303536 4.4500000 0.310313 4.4527778 0.315617 4.4555556 0.322394 4.4583333 0.328582 4.4611111 0.334770 4.4638889 0.339190 4.4666667 0.339190 4.4694444 0.329466 4.4722222 0.312081 4.4750000 0.295580 4.4777778 0.287330 4.4805556 0.287919 4.4833333 0.289392 4.4861111 0.289687 4.4888889 0.290276 4.4916667 0.291455 4.4944444 0.291455 4.4972222 0.290571 4.5000000 0.290276 4.5027778 0.289982 4.5055556 0.290866 4.5083333 0.290866 4.5111111 0.290866 4.5138889 0.289982 4.5166667 0.289687 4.5194444 0.289982 4.5222222 0.290866 4.5250000 0.290866 4.5277778 0.290571 4.5305556 0.290276 4.5333333 0.289392 4.5361111 0.289687 4.5388889 0.289982 4.5416667 0.290571 4.5444444 0.290571 4.5472222 0.289982 4.5500000 0.289392 4.5527778 0.289392 4.5555556 0.289982 4.5583333 0.290276 4.5611111 0.290276 4.5638889 0.289687 4.5666667 0.289392 4.5694444 0.289098 4.5722222 0.289982 4.5750000 0.290571 4.5777778 0.290276 4.5805556 0.289687 4.5833333 0.289687 4.5861111 0.289687 4.5888889 0.289392 4.5916667 0.289982 4.5944444 0.290571 4.5972222 0.289982 4.6000000 0.289392 4.6027778 0.289098 4.6055556 0.289982 4.6083333 0.290571 4.6111111 0.289392 4.6138889 0.289392 4.6166667 0.289098 4.6194444 0.289098 4.6222222 0.290276 4.6250000 0.290866 4.6277778 0.289982 4.6305556 0.289687 4.6333333 0.288508 4.6361111 0.288508 4.6388889 0.288803 4.6416667 0.289687 4.6444444 0.289687 4.6472222 0.288803 4.6500000 0.288803 4.6527778 0.288803 4.6555556 0.289098 4.6583333 0.288803 4.6611111 0.287330 4.6638889 0.287035 4.6666667 0.287330 4.6694444 0.286740 4.6722222 0.287330 4.6750000 0.288214 4.6777778 0.286446 4.6805556 0.286740 4.6833333 0.285562 4.6861111 0.285856 4.6888889 0.285562 4.6916667 0.287035 4.6944444 0.285562 4.6972222 0.284678 4.7000000 0.283499 4.7027778 0.283499 4.7055556 0.283204 4.7083333 0.284088 4.7111111 0.283204 4.7138889 0.282615 4.7166667 0.282026 4.7194444 0.282026 4.7222222 0.281436 4.7250000 0.282026 4.7277778 0.281731 4.7305556 0.280552 4.7333333 0.280847 4.7361111 0.280552 4.7388889 0.281436 4.7416667 0.281731 4.7444444 0.281436 4.7472222 0.281731 4.7500000 0.281142 4.7527778 0.282026 4.7555556 0.282910 4.7583333 0.283794 4.7611111 0.284088 4.7638889 0.284383 4.7666667 0.284383 4.7744444 0.300000 5.2088889 0.300000 5.2138889 0.287035 5.2166667 0.286740 5.2194444 0.286740 5.2222222 0.287919 5.2250000 0.288214 5.2277778 0.287919 5.2305556 0.287919 5.2333333 0.287624 5.2361111 0.287624 5.2388889 0.288508 5.2416667 0.288508 5.2444444 0.288508 5.2472222 0.288214 5.2500000 0.286740 5.2527778 0.286740 5.2555556 0.287919 5.2583333 0.288803 5.2611111 0.288508 5.2638889 0.288803 5.2666667 0.288214 5.2694444 0.289098 5.2722222 0.289392 5.2750000 0.290276 5.2777778 0.289982 5.2805556 0.289392 5.2833333 0.289687 5.2861111 0.289982 5.2888889 0.290276 5.2916667 0.291160 5.2944444 0.290866 5.2972222 0.290276 5.3000000 0.289982 5.3027778 0.290276 5.3055556 0.290276 5.3083333 0.290866 5.3111111 0.289982 5.3138889 0.289392 5.3166667 0.289982 5.3194444 0.290276 5.3222222 0.290571 5.3250000 0.290571 5.3277778 0.289392 5.3305556 0.288803 5.3333333 0.287919 5.3361111 0.288803 5.3388889 0.288803 5.3416667 0.289982 5.3444444 0.289098 5.3472222 0.288803 5.3500000 0.288508 5.3527778 0.286740 5.3555556 0.287330 5.3583333 0.288214 5.3611111 0.287919 5.3638889 0.287919 5.3666667 0.287919 5.3694444 0.287035 5.3722222 0.287624 5.3750000 0.287624 5.3777778 0.287624 5.3805556 0.287330 5.3833333 0.286740 5.3861111 0.286151 5.3888889 0.286446 5.3916667 0.287919 5.3944444 0.287330 5.3972222 0.286740 5.4000000 0.286740 5.4027778 0.287035 5.4055556 0.287035 5.4083333 0.287330 5.4111111 0.286740 5.4138889 0.286740 5.4166667 0.284972 5.4194444 0.283794 5.4222222 0.282910 5.4250000 0.282910 5.4277778 0.281436 5.4305556 0.280552 5.4333333 0.282026 5.4361111 0.285562 5.4388889 0.293223 5.4416667 0.298527 5.4444444 0.301768 5.4472222 0.304715 5.4500000 0.309134 5.4527778 0.315617 5.4555556 0.322689 5.4583333 0.329466 5.4611111 0.332118 5.4638889 0.326519 5.4666667 0.312670 5.4694444 0.294696 5.4722222 0.280847 5.4750000 0.277017 5.4777778 0.277311 5.4805556 0.278490 5.4833333 0.280258 5.4861111 0.282615 5.4888889 0.283204 5.4916667 0.284088 5.4944444 0.284383 5.4972222 0.284088 5.5000000 0.283794 5.5027778 0.283204 5.5055556 0.284383 5.5083333 0.285267 5.5111111 0.284678 5.5138889 0.284678 5.5166667 0.284383 5.5194444 0.284088 5.5222222 0.284383 5.5250000 0.285562 5.5277778 0.284678 5.5305556 0.284972 5.5333333 0.283499 5.5361111 0.284678 5.5388889 0.285267 5.5416667 0.285267 5.5444444 0.284972 5.5472222 0.284972 5.5500000 0.284678 5.5527778 0.284678 5.5555556 0.284972 5.5583333 0.286740 5.5611111 0.285856 5.5638889 0.285562 5.5666667 0.284383 5.5694444 0.283794 5.5722222 0.285267 5.5750000 0.285562 5.5777778 0.286446 5.5805556 0.285856 5.5833333 0.284972 5.5861111 0.285267 5.5888889 0.285267 5.5916667 0.285562 5.5944444 0.286151 5.5972222 0.285856 5.6000000 0.285267 5.6027778 0.285267 5.6055556 0.285562 5.6083333 0.287035 5.6111111 0.285562 5.6138889 0.285562 5.6166667 0.285856 5.6194444 0.284972 5.6222222 0.285562 5.6250000 0.286740 5.6277778 0.285856 5.6305556 0.285267 5.6333333 0.284678 5.6361111 0.284383 5.6388889 0.284972 5.6416667 0.285856 5.6444444 0.285267 5.6472222 0.285267 5.6500000 0.284383 5.6527778 0.284678 5.6555556 0.284678 5.6583333 0.284383 5.6611111 0.283794 5.6638889 0.284088 5.6666667 0.284088 5.6694444 0.284088 5.6722222 0.284088 5.6750000 0.285562 5.6777778 0.284383 5.6805556 0.284383 5.6833333 0.284088 5.6861111 0.283204 5.6888889 0.284678 5.6916667 0.285562 5.6944444 0.284972 5.6972222 0.284383 5.7000000 0.283204 5.7027778 0.282615 5.7055556 0.282320 5.7083333 0.282615 5.7111111 0.283204 5.7138889 0.281142 5.7166667 0.280847 5.7194444 0.280258 5.7222222 0.280258 5.7250000 0.280552 5.7277778 0.279374 5.7305556 0.279669 5.7333333 0.278490 5.7361111 0.277606 5.7388889 0.277901 5.7416667 0.277901 5.7444444 0.277311 5.7472222 0.277311 5.7500000 0.276427 5.7527778 0.276427 5.7555556 0.276722 5.7583333 0.277017 5.7611111 0.277017 5.7688889 0.300000 6.0533333 0.300000 6.0583333 0.289098 6.0611111 0.288508 6.0638889 0.288214 6.0666667 0.288214 6.0694444 0.287919 6.0722222 0.288508 6.0750000 0.289098 6.0777778 0.288803 6.0805556 0.288508 6.0833333 0.288214 6.0861111 0.288214 6.0888889 0.288214 6.0916667 0.288803 6.0944444 0.288214 6.0972222 0.288803 6.1000000 0.288214 6.1027778 0.288508 6.1055556 0.289392 6.1083333 0.290571 6.1111111 0.289392 6.1138889 0.289392 6.1166667 0.289098 6.1194444 0.289392 6.1222222 0.290571 6.1250000 0.291455 6.1277778 0.290866 6.1305556 0.289982 6.1333333 0.289982 6.1361111 0.290866 6.1388889 0.291455 6.1416667 0.292339 6.1444444 0.292044 6.1472222 0.291750 6.1500000 0.292044 6.1527778 0.291750 6.1555556 0.291750 6.1583333 0.292634 6.1611111 0.292339 6.1638889 0.291160 6.1666667 0.290276 6.1694444 0.290276 6.1722222 0.290276 6.1750000 0.290866 6.1777778 0.291160 6.1805556 0.290276 6.1833333 0.289392 6.1861111 0.288508 6.1888889 0.289687 6.1916667 0.289982 6.1944444 0.289687 6.1972222 0.289098 6.2000000 0.288508 6.2027778 0.288803 6.2055556 0.289687 6.2083333 0.289098 6.2111111 0.288803 6.2138889 0.287919 6.2166667 0.287330 6.2194444 0.287330 6.2222222 0.288508 6.2250000 0.289392 6.2277778 0.288803 6.2305556 0.288214 6.2333333 0.288214 6.2361111 0.287330 6.2388889 0.288214 6.2416667 0.289392 6.2444444 0.288508 6.2472222 0.288214 6.2500000 0.287919 6.2527778 0.287624 6.2555556 0.288214 6.2583333 0.287919 6.2611111 0.286151 6.2638889 0.284678 6.2666667 0.283204 6.2694444 0.282320 6.2722222 0.280847 6.2750000 0.281142 6.2777778 0.282910 6.2805556 0.288803 6.2833333 0.296759 6.2861111 0.302947 6.2888889 0.308840 6.2916667 0.314438 6.2944444 0.320331 6.2972222 0.326225 6.3000000 0.331234 6.3027778 0.335064 6.3055556 0.330645 6.3083333 0.316206 6.3111111 0.294991 6.3138889 0.282320 6.3166667 0.280258 6.3194444 0.283204 6.3222222 0.285267 6.3250000 0.285562 6.3277778 0.286151 6.3305556 0.287330 6.3333333 0.286446 6.3361111 0.286446 6.3388889 0.285856 6.3416667 0.286151 6.3444444 0.286151 6.3472222 0.285562 6.3500000 0.284972 6.3527778 0.285267 6.3555556 0.285856 6.3583333 0.286740 6.3611111 0.286446 6.3638889 0.285267 6.3666667 0.285856 6.3694444 0.284972 6.3722222 0.286446 6.3750000 0.286740 6.3777778 0.286740 6.3805556 0.286740 6.3833333 0.286446 6.3861111 0.285856 6.3888889 0.286740 6.3916667 0.287330 6.3944444 0.287330 6.3972222 0.286740 6.4000000 0.286151 6.4027778 0.285856 6.4055556 0.286740 6.4083333 0.287919 6.4111111 0.287624 6.4138889 0.286740 6.4166667 0.286446 6.4194444 0.286151 6.4222222 0.286740 6.4250000 0.287330 6.4277778 0.287035 6.4305556 0.286446 6.4333333 0.286151 6.4361111 0.286446 6.4388889 0.287330 6.4416667 0.287330 6.4444444 0.287330 6.4472222 0.286740 6.4500000 0.286151 6.4527778 0.286151 6.4555556 0.286446 6.4583333 0.287330 6.4611111 0.286740 6.4638889 0.286740 6.4666667 0.286151 6.4694444 0.285562 6.4722222 0.285856 6.4750000 0.286740 6.4777778 0.287624 6.4805556 0.286446 6.4833333 0.286446 6.4861111 0.285562 6.4888889 0.287035 6.4916667 0.286740 6.4944444 0.286151 6.4972222 0.285562 6.5000000 0.285267 6.5027778 0.285267 6.5055556 0.285856 6.5083333 0.285856 6.5111111 0.285562 6.5138889 0.285267 6.5166667 0.284088 6.5194444 0.284088 6.5222222 0.284383 6.5250000 0.284678 6.5277778 0.283499 6.5305556 0.282615 6.5333333 0.282615 6.5361111 0.281436 6.5388889 0.281731 6.5416667 0.282026 6.5444444 0.281731 6.5472222 0.280847 6.5500000 0.280552 6.5527778 0.279374 6.5555556 0.279963 6.5583333 0.280258 6.5611111 0.279374 6.5638889 0.279374 6.5666667 0.278195 6.5694444 0.278490 6.5722222 0.279079 6.5750000 0.280258 6.5777778 0.279079 6.5805556 0.278490 6.5833333 0.278195 6.5861111 0.278785 6.5888889 0.280258 6.5916667 0.281436 6.5944444 0.281436 6.5972222 0.282026 6.6000000 0.283204 6.6027778 0.283204 6.6055556 0.284088 6.6133333 0.300000 6.8644444 0.300000 6.8694444 0.287919 6.8722222 0.289098 6.8750000 0.290571 6.8777778 0.289982 6.8805556 0.288803 6.8833333 0.288803 6.8861111 0.288803 6.8888889 0.289392 6.8916667 0.289982 6.8944444 0.290571 6.8972222 0.289982 6.9000000 0.289098 6.9027778 0.288508 6.9055556 0.289392 6.9083333 0.289687 6.9111111 0.289982 6.9138889 0.289982 6.9166667 0.288508 6.9194444 0.288214 6.9222222 0.289392 6.9250000 0.289982 6.9277778 0.289687 6.9305556 0.289392 6.9333333 0.289392 6.9361111 0.289982 6.9388889 0.290866 6.9416667 0.292044 6.9444444 0.291455 6.9472222 0.290571 6.9500000 0.290571 6.9527778 0.290571 6.9555556 0.291750 6.9583333 0.292928 6.9611111 0.292928 6.9638889 0.292339 6.9666667 0.292339 6.9694444 0.292634 6.9722222 0.292634 6.9750000 0.293223 6.9777778 0.293517 6.9805556 0.292339 6.9833333 0.291455 6.9861111 0.290866 6.9888889 0.291750 6.9916667 0.291750 6.9944444 0.291455 6.9972222 0.291160 7.0000000 0.290571 7.0027778 0.290276 7.0055556 0.290571 7.0083333 0.291160 7.0111111 0.290276 7.0138889 0.289098 7.0166667 0.289392 7.0194444 0.289098 7.0222222 0.289982 7.0250000 0.290866 7.0277778 0.289687 7.0305556 0.288803 7.0333333 0.288508 7.0361111 0.288508 7.0388889 0.289392 7.0416667 0.289687 7.0444444 0.289392 7.0472222 0.289392 7.0500000 0.288803 7.0527778 0.289982 7.0555556 0.289392 7.0583333 0.289687 7.0611111 0.289392 7.0638889 0.289098 7.0666667 0.288214 7.0694444 0.288508 7.0722222 0.288214 7.0750000 0.286740 7.0777778 0.284972 7.0805556 0.282615 7.0833333 0.280552 7.0861111 0.279963 7.0888889 0.282026 7.0916667 0.288508 7.0944444 0.296169 7.0972222 0.304125 7.1000000 0.310608 7.1027778 0.316796 7.1055556 0.324457 7.1083333 0.332707 7.1111111 0.339484 7.1138889 0.341252 7.1166667 0.332707 7.1194444 0.312376 7.1222222 0.292634 7.1250000 0.284383 7.1277778 0.285856 7.1305556 0.287330 7.1333333 0.287330 7.1361111 0.286446 7.1388889 0.287035 7.1416667 0.287624 7.1444444 0.286151 7.1472222 0.286151 7.1500000 0.286151 7.1527778 0.286446 7.1555556 0.286740 7.1583333 0.287624 7.1611111 0.287330 7.1638889 0.286740 7.1666667 0.285856 7.1694444 0.285267 7.1722222 0.286446 7.1750000 0.286446 7.1777778 0.286740 7.1805556 0.286446 7.1833333 0.285856 7.1861111 0.286151 7.1888889 0.286446 7.1916667 0.286740 7.1944444 0.286446 7.1972222 0.285562 7.2000000 0.286151 7.2027778 0.286151 7.2055556 0.287035 7.2083333 0.287035 7.2111111 0.286740 7.2138889 0.286446 7.2166667 0.285562 7.2194444 0.286740 7.2222222 0.287035 7.2250000 0.287624 7.2277778 0.287624 7.2305556 0.287035 7.2333333 0.285856 7.2361111 0.286151 7.2388889 0.286740 7.2416667 0.287624 7.2444444 0.288214 7.2472222 0.286740 7.2500000 0.286740 7.2527778 0.286740 7.2555556 0.286740 7.2583333 0.287330 7.2611111 0.287330 7.2638889 0.286151 7.2666667 0.285856 7.2694444 0.285856 7.2722222 0.286151 7.2750000 0.287035 7.2777778 0.286740 7.2805556 0.286151 7.2833333 0.285562 7.2861111 0.285562 7.2888889 0.286446 7.2916667 0.286740 7.2944444 0.287035 7.2972222 0.285562 7.3000000 0.285267 7.3027778 0.284972 7.3055556 0.284972 7.3083333 0.285856 7.3111111 0.285267 7.3138889 0.284678 7.3166667 0.283794 7.3194444 0.283204 7.3222222 0.283794 7.3250000 0.283499 7.3277778 0.282910 7.3305556 0.282320 7.3333333 0.282026 7.3361111 0.281436 7.3388889 0.281731 7.3416667 0.281436 7.3444444 0.280847 7.3472222 0.280258 7.3500000 0.279374 7.3527778 0.279669 7.3555556 0.279963 7.3583333 0.280258 7.3611111 0.279374 7.3638889 0.278785 7.3666667 0.278195 7.3694444 0.278490 7.3722222 0.278785 7.3750000 0.279669 7.3777778 0.279963 7.3805556 0.279374 7.3833333 0.279079 7.3861111 0.279669 7.3888889 0.280847 7.3916667 0.282026 7.3944444 0.282320 7.3972222 0.283204 7.4000000 0.283204 7.4027778 0.283499 7.4055556 0.284383 7.4083333 0.286446 7.4111111 0.286151 7.4138889 0.285856 7.4166667 0.285562 7.4244444 0.300000 7.6533333 0.300000 7.6583333 0.291160 7.6611111 0.290571 7.6638889 0.290276 7.6666667 0.289392 7.6694444 0.289392 7.6722222 0.290276 7.6750000 0.291160 7.6777778 0.290866 7.6805556 0.290866 7.6833333 0.289982 7.6861111 0.289687 7.6888889 0.290276 7.6916667 0.290866 7.6944444 0.291160 7.6972222 0.290866 7.7000000 0.290276 7.7027778 0.290276 7.7055556 0.290571 7.7083333 0.290571 7.7111111 0.290276 7.7138889 0.289982 7.7166667 0.289687 7.7194444 0.290571 7.7222222 0.292044 7.7250000 0.291750 7.7277778 0.291455 7.7305556 0.291750 7.7333333 0.291455 7.7361111 0.292044 7.7388889 0.292634 7.7416667 0.293223 7.7444444 0.293223 7.7472222 0.292634 7.7500000 0.292339 7.7527778 0.293812 7.7555556 0.294401 7.7583333 0.294401 7.7611111 0.294401 7.7638889 0.294401 7.7666667 0.294401 7.7694444 0.293223 7.7722222 0.292928 7.7750000 0.292928 7.7777778 0.292339 7.7805556 0.292044 7.7833333 0.292634 7.7861111 0.291750 7.7888889 0.292044 7.7916667 0.292928 7.7944444 0.291160 7.7972222 0.291160 7.8000000 0.290866 7.8027778 0.290571 7.8055556 0.291455 7.8083333 0.291750 7.8111111 0.291455 7.8138889 0.291455 7.8166667 0.290571 7.8194444 0.290276 7.8222222 0.290866 7.8250000 0.291455 7.8277778 0.290866 7.8305556 0.290866 7.8333333 0.289982 7.8361111 0.290276 7.8388889 0.290571 7.8416667 0.290866 7.8444444 0.290571 7.8472222 0.289982 7.8500000 0.289982 7.8527778 0.290276 7.8555556 0.290276 7.8583333 0.291455 7.8611111 0.289982 7.8638889 0.288803 7.8666667 0.286740 7.8694444 0.285267 7.8722222 0.284088 7.8750000 0.283499 7.8777778 0.282026 7.8805556 0.282910 7.8833333 0.288214 7.8861111 0.295580 7.8888889 0.302357 7.8916667 0.307956 7.8944444 0.312670 7.8972222 0.318858 7.9000000 0.325635 7.9027778 0.331823 7.9055556 0.334180 7.9083333 0.327403 7.9111111 0.308545 7.9138889 0.290866 7.9166667 0.283204 7.9194444 0.285267 7.9222222 0.288214 7.9250000 0.289392 7.9277778 0.288803 7.9305556 0.288803 7.9333333 0.289098 7.9361111 0.288508 7.9388889 0.289098 7.9416667 0.289687 7.9444444 0.288803 7.9472222 0.288508 7.9500000 0.287919 7.9527778 0.287919 7.9555556 0.289098 7.9583333 0.290276 7.9611111 0.289098 7.9638889 0.288803 7.9666667 0.287624 7.9694444 0.287624 7.9722222 0.288214 7.9750000 0.288803 7.9777778 0.289098 7.9805556 0.288508 7.9833333 0.287624 7.9861111 0.287624 7.9888889 0.288803 7.9916667 0.289392 7.9944444 0.288803 7.9972222 0.288508 8.0000000 0.287330 8.0027778 0.287330 8.0055556 0.288508 8.0083333 0.289098 8.0111111 0.289392 8.0138889 0.289098 8.0166667 0.288214 8.0194444 0.287919 8.0222222 0.288803 8.0250000 0.289392 8.0277778 0.289098 8.0305556 0.288508 8.0333333 0.288508 8.0361111 0.288508 8.0388889 0.288803 8.0416667 0.289098 8.0444444 0.288508 8.0472222 0.288508 8.0500000 0.287919 8.0527778 0.288214 8.0555556 0.288803 8.0583333 0.289098 8.0611111 0.288508 8.0638889 0.287624 8.0666667 0.287330 8.0694444 0.287330 8.0722222 0.287919 8.0750000 0.288803 8.0777778 0.288803 8.0805556 0.287919 8.0833333 0.287035 8.0861111 0.287330 8.0888889 0.287919 8.0916667 0.287624 8.0944444 0.287035 8.0972222 0.286446 8.1000000 0.285856 8.1027778 0.284972 8.1055556 0.285856 8.1083333 0.286740 8.1111111 0.286446 8.1138889 0.285267 8.1166667 0.285267 8.1194444 0.284678 8.1222222 0.284678 8.1250000 0.284972 8.1277778 0.284678 8.1305556 0.283204 8.1333333 0.282615 8.1361111 0.282320 8.1388889 0.283204 8.1416667 0.283499 8.1444444 0.282910 8.1472222 0.282026 8.1500000 0.281436 8.1527778 0.281142 8.1555556 0.281731 8.1583333 0.282026 8.1611111 0.281731 8.1638889 0.281142 8.1666667 0.280847 8.1694444 0.280258 8.1722222 0.281142 8.1750000 0.282320 8.1777778 0.282320 8.1805556 0.282320 8.1833333 0.283204 8.1861111 0.283499 8.1888889 0.284678 8.1916667 0.285856 8.1944444 0.286151 8.1972222 0.286740 8.2000000 0.286446 8.2027778 0.286740 8.2055556 0.288803 8.2133333 0.300000 8.4255556 0.300000 8.4305556 0.287919 8.4333333 0.287624 8.4361111 0.287330 8.4388889 0.287035 8.4416667 0.287919 8.4444444 0.287035 8.4472222 0.286446 8.4500000 0.286740 8.4527778 0.286740 8.4555556 0.288508 8.4583333 0.288508 8.4611111 0.287035 8.4638889 0.286446 8.4666667 0.285267 8.4694444 0.285856 8.4722222 0.286740 8.4750000 0.287624 8.4777778 0.287624 8.4805556 0.286446 8.4833333 0.286151 8.4861111 0.285856 8.4888889 0.287624 8.4916667 0.288508 8.4944444 0.288508 8.4972222 0.288803 8.5000000 0.288214 8.5027778 0.288508 8.5055556 0.289392 8.5083333 0.289392 8.5111111 0.288803 8.5138889 0.288803 8.5166667 0.289392 8.5194444 0.289098 8.5222222 0.290276 8.5250000 0.290276 8.5277778 0.289687 8.5305556 0.289098 8.5333333 0.288214 8.5361111 0.288508 8.5388889 0.289098 8.5416667 0.289392 8.5444444 0.288508 8.5472222 0.288508 8.5500000 0.287330 8.5527778 0.288214 8.5555556 0.287624 8.5583333 0.288508 8.5611111 0.286740 8.5638889 0.286151 8.5666667 0.285562 8.5694444 0.285562 8.5722222 0.287035 8.5750000 0.286446 8.5777778 0.287035 8.5805556 0.286740 8.5833333 0.285856 8.5861111 0.286740 8.5888889 0.287624 8.5916667 0.287035 8.5944444 0.286446 8.5972222 0.286446 8.6000000 0.285856 8.6027778 0.285562 8.6055556 0.285562 8.6083333 0.285856 8.6111111 0.286151 8.6138889 0.285856 8.6166667 0.284972 8.6194444 0.284972 8.6222222 0.285267 8.6250000 0.286446 8.6277778 0.285856 8.6305556 0.285267 8.6333333 0.284383 8.6361111 0.282910 8.6388889 0.281731 8.6416667 0.282026 8.6444444 0.280258 8.6472222 0.279079 8.6500000 0.280258 8.6527778 0.284088 8.6555556 0.290571 8.6583333 0.297053 8.6611111 0.300589 8.6638889 0.303831 8.6666667 0.307956 8.6694444 0.314144 8.6722222 0.320921 8.6750000 0.323278 8.6777778 0.315028 8.6805556 0.299116 8.6833333 0.282615 8.6861111 0.276133 8.6888889 0.277017 8.6916667 0.279963 8.6944444 0.282026 8.6972222 0.281731 8.7000000 0.282615 8.7027778 0.282615 8.7055556 0.283499 8.7083333 0.284088 8.7111111 0.284383 8.7138889 0.283204 8.7166667 0.282910 8.7194444 0.282910 8.7222222 0.282910 8.7250000 0.283204 8.7277778 0.282910 8.7305556 0.282910 8.7333333 0.283204 8.7361111 0.283204 8.7388889 0.283204 8.7416667 0.284383 8.7444444 0.284383 8.7472222 0.283794 8.7500000 0.283204 8.7527778 0.283499 8.7555556 0.284088 8.7583333 0.284088 8.7611111 0.283794 8.7638889 0.284088 8.7666667 0.283204 8.7694444 0.282320 8.7722222 0.283499 8.7750000 0.283794 8.7777778 0.283204 8.7805556 0.283204 8.7833333 0.282615 8.7861111 0.282910 8.7888889 0.283204 8.7916667 0.283794 8.7944444 0.284383 8.7972222 0.283204 8.8000000 0.282320 8.8027778 0.282026 8.8055556 0.283204 8.8083333 0.284088 8.8111111 0.283499 8.8138889 0.283794 8.8166667 0.282910 8.8194444 0.283499 8.8222222 0.282910 8.8250000 0.283499 8.8277778 0.283499 8.8305556 0.283204 8.8333333 0.283204 8.8361111 0.283204 8.8388889 0.282615 8.8416667 0.283794 8.8444444 0.283499 8.8472222 0.282910 8.8500000 0.282615 8.8527778 0.282615 8.8555556 0.283204 8.8583333 0.283794 8.8611111 0.282615 8.8638889 0.282026 8.8666667 0.282026 8.8694444 0.281142 8.8722222 0.282026 8.8750000 0.282615 8.8777778 0.282320 8.8805556 0.282320 8.8833333 0.281142 8.8861111 0.281142 8.8888889 0.281731 8.8916667 0.282026 8.8944444 0.281436 8.8972222 0.280552 8.9000000 0.279669 8.9027778 0.279079 8.9055556 0.279963 8.9083333 0.280258 8.9111111 0.279374 8.9138889 0.278195 8.9166667 0.277606 8.9194444 0.277606 8.9222222 0.277901 8.9250000 0.277311 8.9277778 0.276133 8.9305556 0.276133 8.9333333 0.275249 8.9361111 0.274659 8.9388889 0.275543 8.9416667 0.275838 8.9444444 0.275543 8.9472222 0.274954 8.9500000 0.274954 8.9527778 0.274954 8.9555556 0.276133 8.9583333 0.277311 8.9611111 0.277017 8.9638889 0.277311 8.9666667 0.277311 8.9694444 0.277606 8.9722222 0.279374 8.9750000 0.281142 8.9777778 0.281436 8.9855556 0.300000 9.2644444 0.300000 9.2694444 0.285856 9.2722222 0.286740 9.2750000 0.287919 9.2777778 0.287330 9.2805556 0.287330 9.2833333 0.287035 9.2861111 0.286446 9.2888889 0.286740 9.2916667 0.287330 9.2944444 0.286740 9.2972222 0.287035 9.3000000 0.287035 9.3027778 0.286740 9.3055556 0.288508 9.3083333 0.288508 9.3111111 0.287919 9.3138889 0.288214 9.3166667 0.288214 9.3194444 0.288508 9.3222222 0.288803 9.3250000 0.289982 9.3277778 0.289982 9.3305556 0.289392 9.3333333 0.289392 9.3361111 0.289098 9.3388889 0.289982 9.3416667 0.290276 9.3444444 0.289392 9.3472222 0.289687 9.3500000 0.289098 9.3527778 0.289687 9.3555556 0.289982 9.3583333 0.291160 9.3611111 0.291160 9.3638889 0.290866 9.3666667 0.289392 9.3694444 0.289392 9.3722222 0.289982 9.3750000 0.289687 9.3777778 0.289392 9.3805556 0.288803 9.3833333 0.288508 9.3861111 0.288214 9.3888889 0.288803 9.3916667 0.289098 9.3944444 0.288214 9.3972222 0.288508 9.4000000 0.287330 9.4027778 0.287624 9.4055556 0.288214 9.4083333 0.288508 9.4111111 0.287919 9.4138889 0.287035 9.4166667 0.287330 9.4194444 0.286740 9.4222222 0.286740 9.4250000 0.287624 9.4277778 0.287919 9.4305556 0.287624 9.4333333 0.286740 9.4361111 0.286446 9.4388889 0.287330 9.4416667 0.288214 9.4444444 0.287330 9.4472222 0.287035 9.4500000 0.286740 9.4527778 0.287624 9.4555556 0.287624 9.4583333 0.288214 9.4611111 0.287624 9.4638889 0.287330 9.4666667 0.286740 9.4694444 0.286151 9.4722222 0.285856 9.4750000 0.284972 9.4777778 0.282910 9.4805556 0.281731 9.4833333 0.280258 9.4861111 0.278785 9.4888889 0.279374 9.4916667 0.283204 9.4944444 0.289687 9.4972222 0.297053 9.5000000 0.304420 9.5027778 0.311197 9.5055556 0.318564 9.5083333 0.325341 9.5111111 0.332118 9.5138889 0.338600 9.5166667 0.338600 9.5194444 0.329761 9.5222222 0.312376 9.5250000 0.294696 9.5277778 0.283794 9.5305556 0.282910 9.5333333 0.284383 9.5361111 0.285267 9.5388889 0.284972 9.5416667 0.286446 9.5444444 0.286446 9.5472222 0.285267 9.5500000 0.284972 9.5527778 0.284972 9.5555556 0.285267 9.5583333 0.286151 9.5611111 0.285267 9.5638889 0.285267 9.5666667 0.284383 9.5694444 0.284972 9.5722222 0.285267 9.5750000 0.285856 9.5777778 0.285562 9.5805556 0.284972 9.5833333 0.284972 9.5861111 0.284383 9.5888889 0.285856 9.5916667 0.285856 9.5944444 0.284972 9.5972222 0.284972 9.6000000 0.284383 9.6027778 0.284678 9.6055556 0.285267 9.6083333 0.284972 9.6111111 0.284972 9.6138889 0.284972 9.6166667 0.284972 9.6194444 0.285267 9.6222222 0.285562 9.6250000 0.286740 9.6277778 0.286446 9.6305556 0.285562 9.6333333 0.284972 9.6361111 0.284678 9.6388889 0.285562 9.6416667 0.285562 9.6444444 0.285562 9.6472222 0.285856 9.6500000 0.285267 9.6527778 0.285562 9.6555556 0.285562 9.6583333 0.285856 9.6611111 0.285856 9.6638889 0.285267 9.6666667 0.284383 9.6694444 0.284972 9.6722222 0.285856 9.6750000 0.285856 9.6777778 0.285856 9.6805556 0.284972 9.6833333 0.284678 9.6861111 0.284678 9.6888889 0.284972 9.6916667 0.284972 9.6944444 0.285267 9.6972222 0.284678 9.7000000 0.283794 9.7027778 0.283499 9.7055556 0.283499 9.7083333 0.284088 9.7111111 0.284383 9.7138889 0.283204 9.7166667 0.282910 9.7194444 0.283499 9.7222222 0.283499 9.7250000 0.283794 9.7277778 0.282615 9.7305556 0.282026 9.7333333 0.281731 9.7361111 0.281731 9.7388889 0.281142 9.7416667 0.282026 9.7444444 0.281142 9.7472222 0.279669 9.7500000 0.279374 9.7527778 0.279079 9.7555556 0.279079 9.7583333 0.279374 9.7611111 0.279374 9.7638889 0.278785 9.7666667 0.277606 9.7694444 0.277311 9.7722222 0.277606 9.7750000 0.277606 9.7777778 0.277901 9.7805556 0.277311 9.7833333 0.276722 9.7861111 0.277606 9.7888889 0.277017 9.7916667 0.277606 9.7944444 0.277311 9.7972222 0.277606 9.8000000 0.277901 9.8027778 0.278195 9.8055556 0.280258 9.8083333 0.281436 9.8111111 0.281731 9.8138889 0.282320 9.8166667 0.281731 9.8244444 0.300000 10.1200000 0.300000 10.1250000 0.287624 10.1277778 0.287919 10.1305556 0.287624 10.1333333 0.286446 10.1361111 0.286740 10.1388889 0.287330 10.1416667 0.287624 10.1444444 0.287624 10.1472222 0.286740 10.1500000 0.286740 10.1527778 0.286740 10.1555556 0.287919 10.1583333 0.288214 10.1611111 0.287624 10.1638889 0.287035 10.1666667 0.287624 10.1694444 0.287330 10.1722222 0.288803 10.1750000 0.288803 10.1777778 0.289098 10.1805556 0.289098 10.1833333 0.289098 10.1861111 0.288214 10.1888889 0.289098 10.1916667 0.289982 10.1944444 0.289982 10.1972222 0.290866 10.2000000 0.290571 10.2027778 0.290571 10.2055556 0.289687 10.2083333 0.290276 10.2111111 0.290571 10.2138889 0.290571 10.2166667 0.290276 10.2194444 0.289982 10.2222222 0.290276 10.2250000 0.290571 10.2277778 0.289687 10.2305556 0.288508 10.2333333 0.288214 10.2361111 0.287919 10.2388889 0.288508 10.2416667 0.288508 10.2444444 0.287919 10.2472222 0.288214 10.2500000 0.287035 10.2527778 0.286740 10.2555556 0.287035 10.2583333 0.287624 10.2611111 0.287330 10.2638889 0.287035 10.2666667 0.286446 10.2694444 0.285856 10.2722222 0.287330 10.2750000 0.287330 10.2777778 0.286740 10.2805556 0.286151 10.2833333 0.285856 10.2861111 0.285267 10.2888889 0.286446 10.2916667 0.287919 10.2944444 0.286740 10.2972222 0.286446 10.3000000 0.285856 10.3027778 0.285267 10.3055556 0.286446 10.3083333 0.287330 10.3111111 0.286446 10.3138889 0.284972 10.3166667 0.283499 10.3194444 0.282026 10.3222222 0.281436 10.3250000 0.280847 10.3277778 0.280552 10.3305556 0.279374 10.3333333 0.277901 10.3361111 0.275543 10.3388889 0.275543 10.3416667 0.277901 10.3444444 0.281142 10.3472222 0.286151 10.3500000 0.292634 10.3527778 0.300000 10.3555556 0.306777 10.3583333 0.312081 10.3611111 0.318564 10.3638889 0.324751 10.3666667 0.330939 10.3694444 0.335948 10.3722222 0.336243 10.3750000 0.327698 10.3777778 0.307956 10.3805556 0.290276 10.3833333 0.280847 10.3861111 0.282026 10.3888889 0.284088 10.3916667 0.284678 10.3944444 0.284678 10.3972222 0.285267 10.4000000 0.284088 10.4027778 0.283794 10.4055556 0.284678 10.4083333 0.284678 10.4111111 0.283794 10.4138889 0.284088 10.4166667 0.284088 10.4194444 0.284088 10.4222222 0.284383 10.4250000 0.284678 10.4277778 0.284088 10.4305556 0.284088 10.4333333 0.283499 10.4361111 0.283204 10.4388889 0.284383 10.4416667 0.284972 10.4444444 0.284678 10.4472222 0.284088 10.4500000 0.283794 10.4527778 0.283204 10.4555556 0.284088 10.4583333 0.284383 10.4611111 0.284383 10.4638889 0.284678 10.4666667 0.283794 10.4694444 0.284088 10.4722222 0.284383 10.4750000 0.284972 10.4777778 0.284678 10.4805556 0.284972 10.4833333 0.283794 10.4861111 0.284383 10.4888889 0.284678 10.4916667 0.284972 10.4944444 0.284972 10.4972222 0.284678 10.5000000 0.284383 10.5027778 0.283499 10.5055556 0.284678 10.5083333 0.285856 10.5111111 0.285267 10.5138889 0.284383 10.5166667 0.284088 10.5194444 0.283499 10.5222222 0.284383 10.5250000 0.285267 10.5277778 0.284972 10.5305556 0.284678 10.5333333 0.284088 10.5361111 0.283499 10.5388889 0.283794 10.5416667 0.284678 10.5444444 0.284088 10.5472222 0.283204 10.5500000 0.283499 10.5527778 0.283499 10.5555556 0.283794 10.5583333 0.283499 10.5611111 0.283794 10.5638889 0.284088 10.5666667 0.282615 10.5694444 0.282026 10.5722222 0.282615 10.5750000 0.283499 10.5777778 0.282320 10.5805556 0.281731 10.5833333 0.281731 10.5861111 0.281436 10.5888889 0.281436 10.5916667 0.281731 10.5944444 0.281436 10.5972222 0.280552 10.6000000 0.279374 10.6027778 0.279374 10.6055556 0.279079 10.6083333 0.280258 10.6111111 0.279669 10.6138889 0.279079 10.6166667 0.278195 10.6194444 0.277901 10.6222222 0.277311 10.6250000 0.277606 10.6277778 0.277017 10.6305556 0.277017 10.6333333 0.276133 10.6361111 0.275838 10.6388889 0.276722 10.6416667 0.276722 10.6444444 0.276722 10.6472222 0.276427 10.6500000 0.275838 10.6527778 0.276133 10.6555556 0.277311 10.6583333 0.277901 10.6611111 0.278490 10.6638889 0.278490 10.6666667 0.278490 10.6694444 0.279079 10.6722222 0.280847 10.6800000 0.300000 10.9422222 0.300000 10.9472222 0.285562 10.9500000 0.285856 10.9527778 0.285856 10.9555556 0.285562 10.9583333 0.286151 10.9611111 0.286151 10.9638889 0.285562 10.9666667 0.284088 10.9694444 0.284678 10.9722222 0.285267 10.9750000 0.285267 10.9777778 0.284972 10.9805556 0.285267 10.9833333 0.284088 10.9861111 0.284088 10.9888889 0.285267 10.9916667 0.286446 10.9944444 0.286151 10.9972222 0.285856 11.0000000 0.286151 11.0027778 0.286151 11.0055556 0.286446 11.0083333 0.286740 11.0111111 0.287330 11.0138889 0.286151 11.0166667 0.286740 11.0194444 0.287035 11.0222222 0.287919 11.0250000 0.287919 11.0277778 0.287919 11.0305556 0.287919 11.0333333 0.287624 11.0361111 0.286740 11.0388889 0.287624 11.0416667 0.288508 11.0444444 0.288214 11.0472222 0.287330 11.0500000 0.286151 11.0527778 0.286446 11.0555556 0.286740 11.0583333 0.286740 11.0611111 0.285562 11.0638889 0.285267 11.0666667 0.284678 11.0694444 0.284383 11.0722222 0.286446 11.0750000 0.286151 11.0777778 0.285856 11.0805556 0.285267 11.0833333 0.283499 11.0861111 0.284088 11.0888889 0.284383 11.0916667 0.284972 11.0944444 0.284383 11.0972222 0.283794 11.1000000 0.283499 11.1027778 0.282910 11.1055556 0.283794 11.1083333 0.284383 11.1111111 0.284088 11.1138889 0.284088 11.1166667 0.283499 11.1194444 0.283499 11.1222222 0.284088 11.1250000 0.284383 11.1277778 0.283499 11.1305556 0.283204 11.1333333 0.282615 11.1361111 0.282615 11.1388889 0.283499 11.1416667 0.284383 11.1444444 0.283499 11.1472222 0.282320 11.1500000 0.280847 11.1527778 0.279079 11.1555556 0.278785 11.1583333 0.279079 11.1611111 0.277311 11.1638889 0.276427 11.1666667 0.279079 11.1694444 0.284088 11.1722222 0.289982 11.1750000 0.295580 11.1777778 0.299411 11.1805556 0.302947 11.1833333 0.307956 11.1861111 0.315028 11.1888889 0.321215 11.1916667 0.322983 11.1944444 0.316206 11.1972222 0.302357 11.2000000 0.286740 11.2027778 0.276427 11.2055556 0.275838 11.2083333 0.278785 11.2111111 0.279669 11.2138889 0.279963 11.2166667 0.279669 11.2194444 0.279669 11.2222222 0.280552 11.2250000 0.282026 11.2277778 0.281436 11.2305556 0.281436 11.2333333 0.280847 11.2361111 0.280258 11.2388889 0.280552 11.2416667 0.281731 11.2444444 0.281436 11.2472222 0.281142 11.2500000 0.281142 11.2527778 0.281142 11.2555556 0.281142 11.2583333 0.281731 11.2611111 0.280847 11.2638889 0.280552 11.2666667 0.279669 11.2694444 0.279963 11.2722222 0.281142 11.2750000 0.281731 11.2777778 0.281731 11.2805556 0.281142 11.2833333 0.280847 11.2861111 0.280847 11.2888889 0.281436 11.2916667 0.281731 11.2944444 0.281731 11.2972222 0.281436 11.3000000 0.280552 11.3027778 0.281142 11.3055556 0.281436 11.3083333 0.282910 11.3111111 0.282026 11.3138889 0.282026 11.3166667 0.281142 11.3194444 0.281142 11.3222222 0.280847 11.3250000 0.281142 11.3277778 0.281436 11.3305556 0.281142 11.3333333 0.280847 11.3361111 0.280552 11.3388889 0.281436 11.3416667 0.281731 11.3444444 0.281436 11.3472222 0.280552 11.3500000 0.279963 11.3527778 0.280258 11.3555556 0.281436 11.3583333 0.282026 11.3611111 0.281142 11.3638889 0.280847 11.3666667 0.281142 11.3694444 0.280847 11.3722222 0.280552 11.3750000 0.281142 11.3777778 0.281731 11.3805556 0.280847 11.3833333 0.280847 11.3861111 0.280552 11.3888889 0.280847 11.3916667 0.280552 11.3944444 0.280552 11.3972222 0.280258 11.4000000 0.280258 11.4027778 0.279669 11.4055556 0.280258 11.4083333 0.279963 11.4111111 0.279669 11.4138889 0.279374 11.4166667 0.278785 11.4194444 0.277606 11.4222222 0.278490 11.4250000 0.278785 11.4277778 0.278195 11.4305556 0.277606 11.4333333 0.276133 11.4361111 0.274954 11.4388889 0.275249 11.4416667 0.276133 11.4444444 0.275838 11.4472222 0.274954 11.4500000 0.274070 11.4527778 0.273775 11.4555556 0.274070 11.4583333 0.274659 11.4611111 0.274659 11.4638889 0.274070 11.4666667 0.273481 11.4694444 0.272597 11.4722222 0.274070 11.4750000 0.274365 11.4777778 0.273775 11.4805556 0.272597 11.4833333 0.273481 11.4861111 0.273775 11.4888889 0.275249 11.4916667 0.276427 11.4944444 0.277311 11.5022222 0.300000 11.7700000 0.300000 11.7750000 0.281142 11.7777778 0.280847 11.7805556 0.279669 11.7833333 0.279374 11.7861111 0.279374 11.7888889 0.279669 11.7916667 0.280552 11.7944444 0.281436 11.7972222 0.280552 11.8000000 0.279963 11.8027778 0.279669 11.8055556 0.279963 11.8083333 0.281142 11.8111111 0.280552 11.8138889 0.279963 11.8166667 0.279374 11.8194444 0.280258 11.8222222 0.280847 11.8250000 0.281731 11.8277778 0.282026 11.8305556 0.281142 11.8333333 0.281436 11.8361111 0.281142 11.8388889 0.281731 11.8416667 0.282910 11.8444444 0.282615 11.8472222 0.282026 11.8500000 0.282026 11.8527778 0.281731 11.8555556 0.282615 11.8583333 0.283499 11.8611111 0.283499 11.8638889 0.283204 11.8666667 0.282910 11.8694444 0.282615 11.8722222 0.282910 11.8750000 0.283204 11.8777778 0.282615 11.8805556 0.282320 11.8833333 0.281436 11.8861111 0.281436 11.8888889 0.282026 11.8916667 0.282615 11.8944444 0.282026 11.8972222 0.281731 11.9000000 0.279669 11.9027778 0.280258 11.9055556 0.279963 11.9083333 0.280258 11.9111111 0.280552 11.9138889 0.280552 11.9166667 0.279669 11.9194444 0.279669 11.9222222 0.279963 11.9250000 0.280258 11.9277778 0.280552 11.9305556 0.280258 11.9333333 0.280258 11.9361111 0.280552 11.9388889 0.280847 11.9416667 0.281731 11.9444444 0.280847 11.9472222 0.280847 11.9500000 0.280552 11.9527778 0.280258 11.9555556 0.280258 11.9583333 0.281436 11.9611111 0.281142 11.9638889 0.280552 11.9666667 0.280847 11.9694444 0.280258 11.9722222 0.280847 11.9750000 0.280552 11.9777778 0.279374 11.9805556 0.277901 11.9833333 0.276722 11.9861111 0.274954 11.9888889 0.274954 11.9916667 0.274659 11.9944444 0.274954 11.9972222 0.278490 12.0000000 0.284088 12.0027778 0.290276 12.0055556 0.296169 12.0083333 0.300884 12.0111111 0.304715 12.0138889 0.310608 12.0166667 0.317385 12.0194444 0.322983 12.0222222 0.323867 12.0250000 0.318564 12.0277778 0.301473 12.0305556 0.284678 12.0333333 0.274070 12.0361111 0.272597 12.0388889 0.275543 12.0416667 0.277901 12.0444444 0.278785 12.0472222 0.279374 12.0500000 0.279374 12.0527778 0.279374 12.0555556 0.280258 12.0583333 0.280847 12.0611111 0.280847 12.0638889 0.279963 12.0666667 0.280552 12.0694444 0.280258 12.0722222 0.280847 12.0750000 0.280847 12.0777778 0.280258 12.0805556 0.280847 12.0833333 0.279374 12.0861111 0.279963 12.0888889 0.279963 12.0916667 0.281731 12.0944444 0.281142 12.0972222 0.280847 12.1000000 0.279669 12.1027778 0.279963 12.1055556 0.280552 12.1083333 0.281436 12.1111111 0.281731 12.1138889 0.281142 12.1166667 0.280258 12.1194444 0.280258 12.1222222 0.280847 12.1250000 0.281436 12.1277778 0.280847 12.1305556 0.280552 12.1333333 0.280847 12.1361111 0.280552 12.1388889 0.281436 12.1416667 0.281142 12.1444444 0.281731 12.1472222 0.281142 12.1500000 0.280258 12.1527778 0.280552 12.1555556 0.281436 12.1583333 0.281436 12.1611111 0.281436 12.1638889 0.281142 12.1666667 0.280552 12.1694444 0.280552 12.1722222 0.281436 12.1750000 0.281731 12.1777778 0.282026 12.1805556 0.281142 12.1833333 0.280258 12.1861111 0.280258 12.1888889 0.279669 12.1916667 0.280847 12.1944444 0.280552 12.1972222 0.280552 12.2000000 0.280258 12.2027778 0.280258 12.2055556 0.280552 12.2083333 0.280847 12.2111111 0.280552 12.2138889 0.280258 12.2166667 0.279079 12.2194444 0.279079 12.2222222 0.279374 12.2250000 0.280552 12.2277778 0.279963 12.2305556 0.278785 12.2333333 0.278490 12.2361111 0.278490 12.2388889 0.278195 12.2416667 0.279374 12.2444444 0.279079 12.2472222 0.278195 12.2500000 0.277606 12.2527778 0.277017 12.2555556 0.277311 12.2583333 0.277606 12.2611111 0.277017 12.2638889 0.276722 12.2666667 0.275249 12.2694444 0.274659 12.2722222 0.275249 12.2750000 0.275838 12.2777778 0.274954 12.2805556 0.274659 12.2833333 0.273481 12.2861111 0.272891 12.2888889 0.273775 12.2916667 0.273186 12.2944444 0.273481 12.2972222 0.273481 12.3000000 0.272302 12.3027778 0.272597 12.3055556 0.272891 12.3083333 0.274070 12.3111111 0.273775 12.3138889 0.274365 12.3166667 0.275249 12.3194444 0.276427 12.3222222 0.277606 12.3300000 0.300000 12.5922222 0.300000 12.5972222 0.284088 12.6000000 0.284088 12.6027778 0.283794 12.6055556 0.284383 12.6083333 0.285267 12.6111111 0.285267 12.6138889 0.284678 12.6166667 0.284383 12.6194444 0.283794 12.6222222 0.284383 12.6250000 0.284972 12.6277778 0.285267 12.6305556 0.284383 12.6333333 0.284678 12.6361111 0.284383 12.6388889 0.285267 12.6416667 0.286151 12.6444444 0.284678 12.6472222 0.284678 12.6500000 0.285267 12.6527778 0.285267 12.6555556 0.285856 12.6583333 0.287035 12.6611111 0.287330 12.6638889 0.286446 12.6666667 0.285856 12.6694444 0.286740 12.6722222 0.287035 12.6750000 0.288508 12.6777778 0.288214 12.6805556 0.287624 12.6833333 0.288214 12.6861111 0.287330 12.6888889 0.288803 12.6916667 0.288508 12.6944444 0.288508 12.6972222 0.288803 12.7000000 0.287624 12.7027778 0.287624 12.7055556 0.288214 12.7083333 0.287624 12.7111111 0.286740 12.7138889 0.287035 12.7166667 0.286446 12.7194444 0.286151 12.7222222 0.286740 12.7250000 0.287035 12.7277778 0.286151 12.7305556 0.285856 12.7333333 0.286446 12.7361111 0.285267 12.7388889 0.284972 12.7416667 0.285562 12.7444444 0.285856 12.7472222 0.285562 12.7500000 0.285267 12.7527778 0.284972 12.7555556 0.285856 12.7583333 0.286151 12.7611111 0.285856 12.7638889 0.285562 12.7666667 0.284972 12.7694444 0.284678 12.7722222 0.284972 12.7750000 0.286446 12.7777778 0.285856 12.7805556 0.285562 12.7833333 0.284972 12.7861111 0.284383 12.7888889 0.284383 12.7916667 0.285267 12.7944444 0.285562 12.7972222 0.285267 12.8000000 0.284088 12.8027778 0.282320 12.8055556 0.281142 12.8083333 0.280552 12.8111111 0.279079 12.8138889 0.277311 12.8166667 0.278195 12.8194444 0.281142 12.8222222 0.288803 12.8250000 0.297053 12.8277778 0.304420 12.8305556 0.311197 12.8333333 0.317974 12.8361111 0.325635 12.8388889 0.333591 12.8416667 0.338895 12.8444444 0.338011 12.8472222 0.326814 12.8500000 0.307072 12.8527778 0.289687 12.8555556 0.282615 12.8583333 0.284678 12.8611111 0.284972 12.8638889 0.283794 12.8666667 0.283499 12.8694444 0.283499 12.8722222 0.283794 12.8750000 0.283499 12.8777778 0.283499 12.8805556 0.283204 12.8833333 0.282615 12.8861111 0.282320 12.8888889 0.282910 12.8916667 0.283204 12.8944444 0.282615 12.8972222 0.282320 12.9000000 0.281731 12.9027778 0.282615 12.9055556 0.282026 12.9083333 0.282910 12.9111111 0.283204 12.9138889 0.282320 12.9166667 0.282026 12.9194444 0.282320 12.9222222 0.282910 12.9250000 0.283204 12.9277778 0.282910 12.9305556 0.282910 12.9333333 0.282615 12.9361111 0.282910 12.9388889 0.282910 12.9416667 0.283204 12.9444444 0.283204 12.9472222 0.282910 12.9500000 0.281731 12.9527778 0.282026 12.9555556 0.283204 12.9583333 0.283499 12.9611111 0.283499 12.9638889 0.283204 12.9666667 0.282615 12.9694444 0.282026 12.9722222 0.282910 12.9750000 0.284088 12.9777778 0.283499 12.9805556 0.283499 12.9833333 0.282615 12.9861111 0.282026 12.9888889 0.282615 12.9916667 0.283499 12.9944444 0.283499 12.9972222 0.283204 13.0000000 0.282615 13.0027778 0.282615 13.0055556 0.282615 13.0083333 0.282910 13.0111111 0.282615 13.0138889 0.282320 13.0166667 0.281731 13.0194444 0.282320 13.0222222 0.282320 13.0250000 0.282615 13.0277778 0.282026 13.0305556 0.281436 13.0333333 0.280552 13.0361111 0.280847 13.0388889 0.280847 13.0416667 0.281436 13.0444444 0.280847 13.0472222 0.280552 13.0500000 0.279669 13.0527778 0.279374 13.0555556 0.279669 13.0583333 0.280258 13.0611111 0.279079 13.0638889 0.277606 13.0666667 0.277901 13.0694444 0.277311 13.0722222 0.277901 13.0750000 0.278195 13.0777778 0.277606 13.0805556 0.276722 13.0833333 0.275838 13.0861111 0.275838 13.0888889 0.276133 13.0916667 0.276427 13.0944444 0.276133 13.0972222 0.275249 13.1000000 0.274659 13.1027778 0.274659 13.1055556 0.275249 13.1083333 0.275838 13.1111111 0.276133 13.1138889 0.276133 13.1166667 0.275838 13.1194444 0.276133 13.1222222 0.277311 13.1250000 0.278195 13.1277778 0.279079 13.1305556 0.279669 13.1333333 0.280258 13.1361111 0.281142 13.1388889 0.282320 13.1416667 0.283499 13.1444444 0.284088 13.1522222 0.300000 13.3866667 0.300000 13.3916667 0.286446 13.3944444 0.286151 13.3972222 0.285562 13.4000000 0.285856 13.4027778 0.286446 13.4055556 0.286740 13.4083333 0.286151 13.4111111 0.286446 13.4138889 0.286446 13.4166667 0.285856 13.4194444 0.285562 13.4222222 0.286446 13.4250000 0.286740 13.4277778 0.286740 13.4305556 0.286446 13.4333333 0.285562 13.4361111 0.285856 13.4388889 0.286446 13.4416667 0.287330 13.4444444 0.287624 13.4472222 0.286740 13.4500000 0.286740 13.4527778 0.286446 13.4555556 0.287330 13.4583333 0.288214 13.4611111 0.287919 13.4638889 0.287624 13.4666667 0.287624 13.4694444 0.288214 13.4722222 0.288803 13.4750000 0.289392 13.4777778 0.289098 13.4805556 0.288508 13.4833333 0.288214 13.4861111 0.288508 13.4888889 0.289098 13.4916667 0.290866 13.4944444 0.290276 13.4972222 0.289982 13.5000000 0.289392 13.5027778 0.289687 13.5055556 0.289392 13.5083333 0.290571 13.5111111 0.289098 13.5138889 0.288803 13.5166667 0.287919 13.5194444 0.287919 13.5222222 0.288508 13.5250000 0.288803 13.5277778 0.288214 13.5305556 0.287919 13.5333333 0.286740 13.5361111 0.286446 13.5388889 0.286740 13.5416667 0.288214 13.5444444 0.287330 13.5472222 0.286740 13.5500000 0.286446 13.5527778 0.285562 13.5555556 0.286151 13.5583333 0.287330 13.5611111 0.286740 13.5638889 0.286151 13.5666667 0.286446 13.5694444 0.286151 13.5722222 0.287035 13.5750000 0.287035 13.5777778 0.286740 13.5805556 0.286740 13.5833333 0.286740 13.5861111 0.286446 13.5888889 0.286740 13.5916667 0.286740 13.5944444 0.285562 13.5972222 0.283499 13.6000000 0.282026 13.6027778 0.280258 13.6055556 0.279374 13.6083333 0.278785 13.6111111 0.278785 13.6138889 0.281436 13.6166667 0.287035 13.6194444 0.294401 13.6222222 0.301473 13.6250000 0.308250 13.6277778 0.314438 13.6305556 0.321510 13.6333333 0.327403 13.6361111 0.333297 13.6388889 0.334180 13.6416667 0.324457 13.6444444 0.304420 13.6472222 0.287624 13.6500000 0.280552 13.6527778 0.282320 13.6555556 0.284088 13.6583333 0.284678 13.6611111 0.284678 13.6638889 0.284972 13.6666667 0.284383 13.6694444 0.284383 13.6722222 0.284972 13.6750000 0.285267 13.6777778 0.284678 13.6805556 0.284383 13.6833333 0.284678 13.6861111 0.283794 13.6888889 0.284972 13.6916667 0.284972 13.6944444 0.284678 13.6972222 0.283794 13.7000000 0.283794 13.7027778 0.283794 13.7055556 0.284678 13.7083333 0.284678 13.7111111 0.284972 13.7138889 0.283794 13.7166667 0.283204 13.7194444 0.283499 13.7222222 0.284383 13.7250000 0.285267 13.7277778 0.285267 13.7305556 0.284678 13.7333333 0.283794 13.7361111 0.283204 13.7388889 0.283794 13.7416667 0.285267 13.7444444 0.284972 13.7472222 0.284972 13.7500000 0.284088 13.7527778 0.284088 13.7555556 0.284972 13.7583333 0.285267 13.7611111 0.285267 13.7638889 0.284972 13.7666667 0.284972 13.7694444 0.285267 13.7722222 0.284972 13.7750000 0.286151 13.7777778 0.285856 13.7805556 0.284972 13.7833333 0.284972 13.7861111 0.284383 13.7888889 0.284678 13.7916667 0.285267 13.7944444 0.285267 13.7972222 0.284678 13.8000000 0.283794 13.8027778 0.283499 13.8055556 0.283794 13.8083333 0.284972 13.8111111 0.284383 13.8138889 0.283204 13.8166667 0.283499 13.8194444 0.282615 13.8222222 0.282615 13.8250000 0.283794 13.8277778 0.283204 13.8305556 0.282615 13.8333333 0.282026 13.8361111 0.282026 13.8388889 0.282026 13.8416667 0.282026 13.8444444 0.281731 13.8472222 0.281436 13.8500000 0.280552 13.8527778 0.280552 13.8555556 0.281436 13.8583333 0.281436 13.8611111 0.281142 13.8638889 0.279963 13.8666667 0.278490 13.8694444 0.278785 13.8722222 0.278785 13.8750000 0.279669 13.8777778 0.278490 13.8805556 0.278490 13.8833333 0.277311 13.8861111 0.277311 13.8888889 0.277017 13.8916667 0.277901 13.8944444 0.278490 13.8972222 0.277311 13.9000000 0.276427 13.9027778 0.276722 13.9055556 0.277017 13.9083333 0.277606 13.9111111 0.277311 13.9138889 0.276427 13.9166667 0.276133 13.9194444 0.276427 13.9222222 0.276722 13.9250000 0.278195 13.9277778 0.278195 13.9305556 0.278490 13.9333333 0.278195 13.9361111 0.279374 13.9388889 0.280258 13.9466667 0.300000 14.1838889 0.300000 14.1888889 0.283204 14.1916667 0.283204 14.1944444 0.283204 14.1972222 0.282910 14.2000000 0.282320 14.2027778 0.282615 14.2055556 0.282615 14.2083333 0.283794 14.2111111 0.283499 14.2138889 0.283499 14.2166667 0.282320 14.2194444 0.282320 14.2222222 0.283204 14.2250000 0.283794 14.2277778 0.284088 14.2305556 0.282615 14.2333333 0.282615 14.2361111 0.282026 14.2388889 0.282910 14.2416667 0.284088 14.2444444 0.283499 14.2472222 0.282910 14.2500000 0.282910 14.2527778 0.283794 14.2555556 0.284972 14.2583333 0.285267 14.2611111 0.284678 14.2638889 0.284088 14.2666667 0.283499 14.2694444 0.284088 14.2722222 0.284383 14.2750000 0.285562 14.2777778 0.285562 14.2805556 0.284972 14.2833333 0.285267 14.2861111 0.285856 14.2888889 0.286151 14.2916667 0.286446 14.2944444 0.286446 14.2972222 0.285267 14.3000000 0.284383 14.3027778 0.283794 14.3055556 0.283794 14.3083333 0.284678 14.3111111 0.284972 14.3138889 0.284383 14.3166667 0.282910 14.3194444 0.282615 14.3222222 0.282615 14.3250000 0.283499 14.3277778 0.284088 14.3305556 0.282910 14.3333333 0.282320 14.3361111 0.282615 14.3388889 0.282320 14.3416667 0.282320 14.3444444 0.282320 14.3472222 0.282026 14.3500000 0.282615 14.3527778 0.282615 14.3555556 0.282615 14.3583333 0.282320 14.3611111 0.282320 14.3638889 0.282320 14.3666667 0.282320 14.3694444 0.281436 14.3722222 0.282026 14.3750000 0.283499 14.3777778 0.282910 14.3805556 0.282615 14.3833333 0.280847 14.3861111 0.279963 14.3888889 0.278785 14.3916667 0.278490 14.3944444 0.277606 14.3972222 0.275543 14.4000000 0.273481 14.4027778 0.275249 14.4055556 0.279669 14.4083333 0.285562 14.4111111 0.290571 14.4138889 0.294696 14.4166667 0.296464 14.4194444 0.299705 14.4222222 0.302947 14.4250000 0.309724 14.4277778 0.315617 14.4305556 0.322394 14.4333333 0.327109 14.4361111 0.329171 14.4388889 0.328582 14.4416667 0.319742 14.4444444 0.302652 14.4472222 0.285562 14.4500000 0.274659 14.4527778 0.271713 14.4555556 0.274659 14.4583333 0.276427 14.4611111 0.277606 14.4638889 0.278490 14.4666667 0.279079 14.4694444 0.278490 14.4722222 0.279669 14.4750000 0.279669 14.4777778 0.279963 14.4805556 0.279669 14.4833333 0.278490 14.4861111 0.278785 14.4888889 0.278785 14.4916667 0.279963 14.4944444 0.279374 14.4972222 0.279669 14.5000000 0.278490 14.5027778 0.278785 14.5055556 0.278785 14.5083333 0.279669 14.5111111 0.279669 14.5138889 0.278785 14.5166667 0.278785 14.5194444 0.278195 14.5222222 0.279079 14.5250000 0.279669 14.5277778 0.279669 14.5305556 0.279079 14.5333333 0.278785 14.5361111 0.278785 14.5388889 0.279079 14.5416667 0.279374 14.5444444 0.279963 14.5472222 0.279669 14.5500000 0.278785 14.5527778 0.279669 14.5555556 0.279079 14.5583333 0.280258 14.5611111 0.279374 14.5638889 0.278490 14.5666667 0.278785 14.5694444 0.278195 14.5722222 0.278785 14.5750000 0.279669 14.5777778 0.279963 14.5805556 0.279079 14.5833333 0.277901 14.5861111 0.277606 14.5888889 0.278490 14.5916667 0.278785 14.5944444 0.279079 14.5972222 0.279079 14.6000000 0.279374 14.6027778 0.278490 14.6055556 0.279079 14.6083333 0.278785 14.6111111 0.278490 14.6138889 0.277311 14.6166667 0.277017 14.6194444 0.277606 14.6222222 0.278195 14.6250000 0.278490 14.6277778 0.277311 14.6305556 0.277311 14.6333333 0.275249 14.6361111 0.276133 14.6388889 0.277017 14.6416667 0.277017 14.6444444 0.277311 14.6472222 0.276722 14.6500000 0.276133 14.6527778 0.276427 14.6555556 0.276722 14.6583333 0.276722 14.6611111 0.276133 14.6638889 0.274954 14.6666667 0.274070 14.6694444 0.273186 14.6722222 0.273186 14.6750000 0.273775 14.6777778 0.272597 14.6805556 0.272597 14.6833333 0.271713 14.6861111 0.271418 14.6888889 0.271418 14.6916667 0.271418 14.6944444 0.271123 14.6972222 0.270534 14.7000000 0.269945 14.7027778 0.269061 14.7055556 0.269945 14.7083333 0.270829 14.7111111 0.270534 14.7138889 0.269650 14.7166667 0.269945 14.7194444 0.271123 14.7222222 0.272007 14.7250000 0.273481 14.7277778 0.273481 14.7305556 0.273481 14.7333333 0.274070 14.7361111 0.274659 14.7438889 0.300000 14.9755556 0.300000 14.9805556 0.279963 14.9833333 0.279374 14.9861111 0.278785 14.9888889 0.279963 14.9916667 0.279963 14.9944444 0.280258 14.9972222 0.279963 15.0000000 0.279374 15.0027778 0.279374 15.0055556 0.279963 15.0083333 0.280552 15.0111111 0.280552 15.0138889 0.279963 15.0166667 0.279669 15.0194444 0.279669 15.0222222 0.279669 15.0250000 0.280258 15.0277778 0.281142 15.0305556 0.280258 15.0333333 0.279963 15.0361111 0.279669 15.0388889 0.280847 15.0416667 0.282320 15.0444444 0.281436 15.0472222 0.281436 15.0500000 0.282026 15.0527778 0.282320 15.0555556 0.283499 15.0583333 0.284088 15.0611111 0.282910 15.0638889 0.282910 15.0666667 0.282615 15.0694444 0.282910 15.0722222 0.283794 15.0750000 0.284972 15.0777778 0.284383 15.0805556 0.283794 15.0833333 0.283499 15.0861111 0.283204 15.0888889 0.283499 15.0916667 0.284088 15.0944444 0.283204 15.0972222 0.282026 15.1000000 0.282026 15.1027778 0.282026 15.1055556 0.282615 15.1083333 0.282615 15.1111111 0.282615 15.1138889 0.281436 15.1166667 0.280847 15.1194444 0.280847 15.1222222 0.281731 15.1250000 0.282026 15.1277778 0.282320 15.1305556 0.281731 15.1333333 0.280847 15.1361111 0.280847 15.1388889 0.280847 15.1416667 0.282026 15.1444444 0.282026 15.1472222 0.280847 15.1500000 0.281142 15.1527778 0.280847 15.1555556 0.281731 15.1583333 0.281731 15.1611111 0.281436 15.1638889 0.281142 15.1666667 0.280847 15.1694444 0.281142 15.1722222 0.281436 15.1750000 0.282026 15.1777778 0.282320 15.1805556 0.280847 15.1833333 0.280258 15.1861111 0.279374 15.1888889 0.279079 15.1916667 0.277606 15.1944444 0.275543 15.1972222 0.274659 15.2000000 0.273186 15.2027778 0.275838 15.2055556 0.282026 15.2083333 0.290571 15.2111111 0.297348 15.2138889 0.302063 15.2166667 0.307072 15.2194444 0.314438 15.2222222 0.322689 15.2250000 0.329171 15.2277778 0.327993 15.2305556 0.317385 15.2333333 0.297643 15.2361111 0.279374 15.2388889 0.274070 15.2416667 0.275543 15.2444444 0.277606 15.2472222 0.278785 15.2500000 0.278490 15.2527778 0.279079 15.2555556 0.279963 15.2583333 0.279963 15.2611111 0.280258 15.2638889 0.279374 15.2666667 0.278195 15.2694444 0.278785 15.2722222 0.279079 15.2750000 0.279079 15.2777778 0.279374 15.2805556 0.279374 15.2833333 0.279079 15.2861111 0.279374 15.2888889 0.279374 15.2916667 0.279963 15.2944444 0.279669 15.2972222 0.279669 15.3000000 0.279374 15.3027778 0.279669 15.3055556 0.280258 15.3083333 0.280258 15.3111111 0.280552 15.3138889 0.279669 15.3166667 0.279669 15.3194444 0.279963 15.3222222 0.280258 15.3250000 0.281142 15.3277778 0.280258 15.3305556 0.280552 15.3333333 0.279963 15.3361111 0.279963 15.3388889 0.280258 15.3416667 0.280847 15.3444444 0.280847 15.3472222 0.279963 15.3500000 0.279669 15.3527778 0.279669 15.3555556 0.281142 15.3583333 0.281142 15.3611111 0.280552 15.3638889 0.279669 15.3666667 0.280258 15.3694444 0.279963 15.3722222 0.280552 15.3750000 0.280847 15.3777778 0.280552 15.3805556 0.279963 15.3833333 0.279669 15.3861111 0.279374 15.3888889 0.280258 15.3916667 0.280847 15.3944444 0.279963 15.3972222 0.280258 15.4000000 0.279079 15.4027778 0.278785 15.4055556 0.279079 15.4083333 0.279374 15.4111111 0.279669 15.4138889 0.279079 15.4166667 0.277901 15.4194444 0.278490 15.4222222 0.277901 15.4250000 0.277901 15.4277778 0.278490 15.4305556 0.277901 15.4333333 0.277311 15.4361111 0.277017 15.4388889 0.277606 15.4416667 0.278195 15.4444444 0.277606 15.4472222 0.277017 15.4500000 0.276133 15.4527778 0.274954 15.4555556 0.275249 15.4583333 0.274954 15.4611111 0.274954 15.4638889 0.274365 15.4666667 0.273775 15.4694444 0.273481 15.4722222 0.272891 15.4750000 0.273186 15.4777778 0.272302 15.4805556 0.272007 15.4833333 0.271123 15.4861111 0.271123 15.4888889 0.272007 15.4916667 0.272597 15.4944444 0.272302 15.4972222 0.271713 15.5000000 0.271418 15.5027778 0.272302 15.5055556 0.272597 15.5083333 0.274659 15.5111111 0.274659 15.5138889 0.275249 15.5166667 0.275249 15.5194444 0.277017 15.5222222 0.277901 15.5250000 0.278490 15.5277778 0.279374 15.5355556 0.300000 15.7977778 0.300000 15.8027778 0.283204 15.8055556 0.283499 15.8083333 0.284088 15.8111111 0.285267 15.8138889 0.284088 15.8166667 0.284383 15.8194444 0.283499 15.8222222 0.283794 15.8250000 0.284383 15.8277778 0.284088 15.8305556 0.283499 15.8333333 0.283499 15.8361111 0.283499 15.8388889 0.284972 15.8416667 0.284678 15.8444444 0.285267 15.8472222 0.284972 15.8500000 0.284678 15.8527778 0.284972 15.8555556 0.286151 15.8583333 0.287330 15.8611111 0.286740 15.8638889 0.286151 15.8666667 0.286151 15.8694444 0.285856 15.8722222 0.286446 15.8750000 0.287624 15.8777778 0.287919 15.8805556 0.287919 15.8833333 0.288214 15.8861111 0.288214 15.8888889 0.288214 15.8916667 0.288803 15.8944444 0.288803 15.8972222 0.287919 15.9000000 0.287624 15.9027778 0.287919 15.9055556 0.287919 15.9083333 0.288214 15.9111111 0.287624 15.9138889 0.286740 15.9166667 0.286151 15.9194444 0.286151 15.9222222 0.286446 15.9250000 0.287330 15.9277778 0.286740 15.9305556 0.286151 15.9333333 0.286151 15.9361111 0.285562 15.9388889 0.285856 15.9416667 0.286446 15.9444444 0.285856 15.9472222 0.285562 15.9500000 0.284972 15.9527778 0.284678 15.9555556 0.284972 15.9583333 0.286446 15.9611111 0.285562 15.9638889 0.284972 15.9666667 0.284972 15.9694444 0.284972 15.9722222 0.285562 15.9750000 0.286151 15.9777778 0.285562 15.9805556 0.285267 15.9833333 0.284678 15.9861111 0.284678 15.9888889 0.285267 15.9916667 0.285856 15.9944444 0.285267 15.9972222 0.284383 16.0000000 0.283794 16.0027778 0.283794 16.0055556 0.282615 16.0083333 0.281731 16.0111111 0.279963 16.0138889 0.277901 16.0166667 0.275838 16.0194444 0.275249 16.0222222 0.278490 16.0250000 0.286151 16.0277778 0.293223 16.0305556 0.300884 16.0333333 0.306777 16.0361111 0.313849 16.0388889 0.321805 16.0416667 0.329466 16.0444444 0.336243 16.0472222 0.341547 16.0500000 0.341842 16.0527778 0.330055 16.0555556 0.309429 16.0583333 0.292634 16.0611111 0.283204 16.0638889 0.282615 16.0666667 0.282615 16.0694444 0.282026 16.0722222 0.282910 16.0750000 0.283499 16.0777778 0.283794 16.0805556 0.284088 16.0833333 0.282910 16.0861111 0.282910 16.0888889 0.282910 16.0916667 0.283499 16.0944444 0.283204 16.0972222 0.282615 16.1000000 0.282615 16.1027778 0.282026 16.1055556 0.282320 16.1083333 0.282320 16.1111111 0.282910 16.1138889 0.282615 16.1166667 0.282026 16.1194444 0.281731 16.1222222 0.282320 16.1250000 0.282910 16.1277778 0.282910 16.1305556 0.282615 16.1333333 0.281731 16.1361111 0.282320 16.1388889 0.282615 16.1416667 0.283499 16.1444444 0.283204 16.1472222 0.282615 16.1500000 0.282026 16.1527778 0.281731 16.1555556 0.282910 16.1583333 0.283204 16.1611111 0.282910 16.1638889 0.282910 16.1666667 0.282615 16.1694444 0.282320 16.1722222 0.282910 16.1750000 0.283499 16.1777778 0.283204 16.1805556 0.282910 16.1833333 0.282320 16.1861111 0.282026 16.1888889 0.282615 16.1916667 0.283499 16.1944444 0.282320 16.1972222 0.282615 16.2000000 0.282026 16.2027778 0.282026 16.2055556 0.282910 16.2083333 0.283794 16.2111111 0.282910 16.2138889 0.282320 16.2166667 0.282026 16.2194444 0.281731 16.2222222 0.282615 16.2250000 0.282615 16.2277778 0.282320 16.2305556 0.282026 16.2333333 0.281436 16.2361111 0.281436 16.2388889 0.281142 16.2416667 0.281436 16.2444444 0.280552 16.2472222 0.281142 16.2500000 0.280258 16.2527778 0.279963 16.2555556 0.280552 16.2583333 0.281731 16.2611111 0.280847 16.2638889 0.280552 16.2666667 0.279669 16.2694444 0.279374 16.2722222 0.279079 16.2750000 0.279669 16.2777778 0.279079 16.2805556 0.278785 16.2833333 0.277901 16.2861111 0.277017 16.2888889 0.278195 16.2916667 0.277606 16.2944444 0.277017 16.2972222 0.276427 16.3000000 0.275838 16.3027778 0.275838 16.3055556 0.276133 16.3083333 0.276133 16.3111111 0.274659 16.3138889 0.274070 16.3166667 0.273775 16.3194444 0.272597 16.3222222 0.273186 16.3250000 0.273775 16.3277778 0.273186 16.3305556 0.273186 16.3333333 0.272597 16.3361111 0.272302 16.3388889 0.272891 16.3416667 0.273481 16.3444444 0.274070 16.3472222 0.273775 16.3500000 0.274070 16.3577778 0.300000 16.6672222 0.300000 16.6722222 0.284972 16.6750000 0.285856 16.6777778 0.285562 16.6805556 0.284972 16.6833333 0.285562 16.6861111 0.284383 16.6888889 0.285562 16.6916667 0.285856 16.6944444 0.285562 16.6972222 0.285267 16.7000000 0.284383 16.7027778 0.284383 16.7055556 0.285856 16.7083333 0.286740 16.7111111 0.286151 16.7138889 0.285267 16.7166667 0.285562 16.7194444 0.285267 16.7222222 0.286151 16.7250000 0.287035 16.7277778 0.287330 16.7305556 0.287624 16.7333333 0.287624 16.7361111 0.286740 16.7388889 0.287919 16.7416667 0.288214 16.7444444 0.288508 16.7472222 0.287919 16.7500000 0.288214 16.7527778 0.288508 16.7555556 0.289687 16.7583333 0.289687 16.7611111 0.289098 16.7638889 0.289098 16.7666667 0.288803 16.7694444 0.287919 16.7722222 0.288803 16.7750000 0.288508 16.7777778 0.287624 16.7805556 0.287624 16.7833333 0.287035 16.7861111 0.286740 16.7888889 0.287330 16.7916667 0.287330 16.7944444 0.286740 16.7972222 0.287035 16.8000000 0.286151 16.8027778 0.286151 16.8055556 0.286446 16.8083333 0.287035 16.8111111 0.287035 16.8138889 0.285856 16.8166667 0.285856 16.8194444 0.285562 16.8222222 0.286446 16.8250000 0.286446 16.8277778 0.286446 16.8305556 0.285562 16.8333333 0.284972 16.8361111 0.285267 16.8388889 0.285267 16.8416667 0.285856 16.8444444 0.285562 16.8472222 0.285267 16.8500000 0.285562 16.8527778 0.285267 16.8555556 0.286151 16.8583333 0.287035 16.8611111 0.286446 16.8638889 0.285562 16.8666667 0.284088 16.8694444 0.283794 16.8722222 0.283499 16.8750000 0.283204 16.8777778 0.281142 16.8805556 0.279669 16.8833333 0.277017 16.8861111 0.276722 16.8888889 0.277901 16.8916667 0.282910 16.8944444 0.289982 16.8972222 0.297053 16.9000000 0.302357 16.9027778 0.307366 16.9055556 0.314438 16.9083333 0.321510 16.9111111 0.327109 16.9138889 0.333002 16.9166667 0.335359 16.9194444 0.330350 16.9222222 0.316206 16.9250000 0.298232 16.9277778 0.284678 16.9305556 0.279963 16.9333333 0.282026 16.9361111 0.283794 16.9388889 0.283204 16.9416667 0.284383 16.9444444 0.285267 16.9472222 0.284678 16.9500000 0.284088 16.9527778 0.284088 16.9555556 0.284088 16.9583333 0.284383 16.9611111 0.284088 16.9638889 0.284088 16.9666667 0.283499 16.9694444 0.282910 16.9722222 0.283794 16.9750000 0.284383 16.9777778 0.284088 16.9805556 0.283794 16.9833333 0.283499 16.9861111 0.283499 16.9888889 0.284088 16.9916667 0.284088 16.9944444 0.284088 16.9972222 0.284678 17.0000000 0.283499 17.0027778 0.282910 17.0055556 0.284088 17.0083333 0.284972 17.0111111 0.284383 17.0138889 0.284088 17.0166667 0.283204 17.0194444 0.283204 17.0222222 0.285267 17.0250000 0.285267 17.0277778 0.284088 17.0305556 0.284383 17.0333333 0.283794 17.0361111 0.284088 17.0388889 0.284383 17.0416667 0.284972 17.0444444 0.284972 17.0472222 0.284383 17.0500000 0.283794 17.0527778 0.283794 17.0555556 0.284383 17.0583333 0.285267 17.0611111 0.284678 17.0638889 0.284088 17.0666667 0.283499 17.0694444 0.283499 17.0722222 0.283794 17.0750000 0.284678 17.0777778 0.284383 17.0805556 0.283499 17.0833333 0.283204 17.0861111 0.283204 17.0888889 0.284383 17.0916667 0.284383 17.0944444 0.283794 17.0972222 0.282615 17.1000000 0.282320 17.1027778 0.282320 17.1055556 0.283204 17.1083333 0.283794 17.1111111 0.282615 17.1138889 0.281731 17.1166667 0.282026 17.1194444 0.281142 17.1222222 0.282026 17.1250000 0.282026 17.1277778 0.281731 17.1305556 0.281436 17.1333333 0.280258 17.1361111 0.280258 17.1388889 0.280258 17.1416667 0.280847 17.1444444 0.280258 17.1472222 0.279374 17.1500000 0.278195 17.1527778 0.277606 17.1555556 0.278195 17.1583333 0.278785 17.1611111 0.277606 17.1638889 0.277311 17.1666667 0.276427 17.1694444 0.275838 17.1722222 0.276133 17.1750000 0.276722 17.1777778 0.276427 17.1805556 0.275249 17.1833333 0.274659 17.1861111 0.274659 17.1888889 0.274659 17.1916667 0.276133 17.1944444 0.275543 17.1972222 0.275249 17.2000000 0.274954 17.2027778 0.275543 17.2055556 0.275838 17.2083333 0.277606 17.2111111 0.277606 17.2138889 0.277901 17.2166667 0.277606 17.2194444 0.278195 17.2272222 0.300000 17.4894444 0.300000 17.4944444 0.283204 17.4972222 0.282910 17.5000000 0.282026 17.5027778 0.282615 17.5055556 0.283204 17.5083333 0.283499 17.5111111 0.283204 17.5138889 0.281731 17.5166667 0.281436 17.5194444 0.281731 17.5222222 0.282320 17.5250000 0.282615 17.5277778 0.282615 17.5305556 0.282615 17.5333333 0.282320 17.5361111 0.281731 17.5388889 0.282910 17.5416667 0.283499 17.5444444 0.284088 17.5472222 0.284088 17.5500000 0.284088 17.5527778 0.284383 17.5555556 0.285267 17.5583333 0.285267 17.5611111 0.284972 17.5638889 0.284383 17.5666667 0.284678 17.5694444 0.285562 17.5722222 0.286151 17.5750000 0.286740 17.5777778 0.285267 17.5805556 0.285267 17.5833333 0.284383 17.5861111 0.284383 17.5888889 0.285562 17.5916667 0.285856 17.5944444 0.285856 17.5972222 0.285267 17.6000000 0.283794 17.6027778 0.283204 17.6055556 0.283499 17.6083333 0.284383 17.6111111 0.284088 17.6138889 0.283794 17.6166667 0.282910 17.6194444 0.282320 17.6222222 0.283204 17.6250000 0.283204 17.6277778 0.282615 17.6305556 0.282615 17.6333333 0.282320 17.6361111 0.282026 17.6388889 0.283204 17.6416667 0.284383 17.6444444 0.282615 17.6472222 0.281731 17.6500000 0.281142 17.6527778 0.280847 17.6555556 0.281436 17.6583333 0.282320 17.6611111 0.282910 17.6638889 0.282320 17.6666667 0.281436 17.6694444 0.282320 17.6722222 0.282026 17.6750000 0.282910 17.6777778 0.283204 17.6805556 0.282320 17.6833333 0.282320 17.6861111 0.282615 17.6888889 0.283499 17.6916667 0.282615 17.6944444 0.281142 17.6972222 0.278785 17.7000000 0.276722 17.7027778 0.277311 17.7055556 0.276722 17.7083333 0.275249 17.7111111 0.273775 17.7138889 0.274954 17.7166667 0.278195 17.7194444 0.284678 17.7222222 0.291750 17.7250000 0.295875 17.7277778 0.299411 17.7305556 0.303831 17.7333333 0.308840 17.7361111 0.316796 17.7388889 0.323867 17.7416667 0.325046 17.7444444 0.315028 17.7472222 0.296169 17.7500000 0.279374 17.7527778 0.272302 17.7555556 0.274070 17.7583333 0.277017 17.7611111 0.278785 17.7638889 0.279374 17.7666667 0.279374 17.7694444 0.278785 17.7722222 0.279374 17.7750000 0.279963 17.7777778 0.280258 17.7805556 0.280258 17.7833333 0.280258 17.7861111 0.280258 17.7888889 0.281731 17.7916667 0.280552 17.7944444 0.279963 17.7972222 0.279669 17.8000000 0.279079 17.8027778 0.280258 17.8055556 0.280552 17.8083333 0.281436 17.8111111 0.280258 17.8138889 0.280258 17.8166667 0.280258 17.8194444 0.279963 17.8222222 0.281436 17.8250000 0.282026 17.8277778 0.282026 17.8305556 0.281731 17.8333333 0.281436 17.8361111 0.281142 17.8388889 0.281142 17.8416667 0.282026 17.8444444 0.280847 17.8472222 0.280552 17.8500000 0.280552 17.8527778 0.280847 17.8555556 0.280847 17.8583333 0.281142 17.8611111 0.280258 17.8638889 0.280552 17.8666667 0.279669 17.8694444 0.280552 17.8722222 0.280552 17.8750000 0.281142 17.8777778 0.280552 17.8805556 0.280258 17.8833333 0.280258 17.8861111 0.280552 17.8888889 0.281436 17.8916667 0.281436 17.8944444 0.281142 17.8972222 0.281142 17.9000000 0.280258 17.9027778 0.279669 17.9055556 0.279963 17.9083333 0.279963 17.9111111 0.280552 17.9138889 0.280258 17.9166667 0.279374 17.9194444 0.279079 17.9222222 0.280258 17.9250000 0.280847 17.9277778 0.279374 17.9305556 0.279079 17.9333333 0.278785 17.9361111 0.278490 17.9388889 0.279079 17.9416667 0.279079 17.9444444 0.279079 17.9472222 0.278195 17.9500000 0.278195 17.9527778 0.277901 17.9555556 0.277311 17.9583333 0.278195 17.9611111 0.276722 17.9638889 0.276427 17.9666667 0.276133 17.9694444 0.275838 17.9722222 0.274659 17.9750000 0.275249 17.9777778 0.274070 17.9805556 0.273481 17.9833333 0.273481 17.9861111 0.272891 17.9888889 0.272891 17.9916667 0.272597 17.9944444 0.272007 17.9972222 0.272007 18.0000000 0.271123 18.0027778 0.270534 18.0055556 0.272007 18.0083333 0.272302 18.0111111 0.272302 18.0138889 0.272891 18.0166667 0.272302 18.0194444 0.272302 18.0222222 0.273481 18.0250000 0.274954 18.0277778 0.275543 18.0305556 0.277311 18.0333333 0.276722 18.0361111 0.277901 18.0388889 0.278785 18.0416667 0.279079 18.0494444 0.300000 18.2755556 0.300000 18.2805556 0.284383 18.2833333 0.283499 18.2861111 0.283499 18.2888889 0.283499 18.2916667 0.284088 18.2944444 0.284972 18.2972222 0.284383 18.3000000 0.283499 18.3027778 0.283499 18.3055556 0.284088 18.3083333 0.284383 18.3111111 0.284383 18.3138889 0.283794 18.3166667 0.283794 18.3194444 0.284383 18.3222222 0.285267 18.3250000 0.286446 18.3277778 0.285562 18.3305556 0.285267 18.3333333 0.284972 18.3361111 0.285267 18.3388889 0.286446 18.3416667 0.287624 18.3444444 0.287919 18.3472222 0.287330 18.3500000 0.286446 18.3527778 0.287035 18.3555556 0.287035 18.3583333 0.288508 18.3611111 0.288803 18.3638889 0.288214 18.3666667 0.288214 18.3694444 0.288508 18.3722222 0.288214 18.3750000 0.289392 18.3777778 0.287624 18.3805556 0.287919 18.3833333 0.287624 18.3861111 0.287035 18.3888889 0.287624 18.3916667 0.287330 18.3944444 0.286740 18.3972222 0.287035 18.4000000 0.286740 18.4027778 0.285856 18.4055556 0.286740 18.4083333 0.287035 18.4111111 0.286740 18.4138889 0.286740 18.4166667 0.285562 18.4194444 0.285562 18.4222222 0.286151 18.4250000 0.286151 18.4277778 0.285562 18.4305556 0.285267 18.4333333 0.285267 18.4361111 0.285562 18.4388889 0.286151 18.4416667 0.286446 18.4444444 0.286446 18.4472222 0.285856 18.4500000 0.285267 18.4527778 0.285562 18.4555556 0.285562 18.4583333 0.286446 18.4611111 0.285856 18.4638889 0.285562 18.4666667 0.285562 18.4694444 0.284972 18.4722222 0.286151 18.4750000 0.286446 18.4777778 0.285856 18.4805556 0.285267 18.4833333 0.284088 18.4861111 0.282910 18.4888889 0.281731 18.4916667 0.280847 18.4944444 0.278490 18.4972222 0.277606 18.5000000 0.278785 18.5027778 0.284678 18.5055556 0.293223 18.5083333 0.300589 18.5111111 0.305893 18.5138889 0.311492 18.5166667 0.317090 18.5194444 0.324751 18.5222222 0.332118 18.5250000 0.336243 18.5277778 0.329761 18.5305556 0.312965 18.5333333 0.292339 18.5361111 0.279374 18.5388889 0.278490 18.5416667 0.282026 18.5444444 0.283204 18.5472222 0.283499 18.5500000 0.283794 18.5527778 0.284383 18.5555556 0.284383 18.5583333 0.284972 18.5611111 0.284678 18.5638889 0.284088 18.5666667 0.284088 18.5694444 0.283794 18.5722222 0.284678 18.5750000 0.285562 18.5777778 0.285267 18.5805556 0.284383 18.5833333 0.283794 18.5861111 0.283794 18.5888889 0.284678 18.5916667 0.285267 18.5944444 0.285562 18.5972222 0.285267 18.6000000 0.284383 18.6027778 0.284678 18.6055556 0.284678 18.6083333 0.285267 18.6111111 0.284972 18.6138889 0.284678 18.6166667 0.284972 18.6194444 0.284972 18.6222222 0.285562 18.6250000 0.285856 18.6277778 0.285562 18.6305556 0.284972 18.6333333 0.284383 18.6361111 0.284972 18.6388889 0.285856 18.6416667 0.286446 18.6444444 0.286446 18.6472222 0.286446 18.6500000 0.285267 18.6527778 0.285267 18.6555556 0.286151 18.6583333 0.285562 18.6611111 0.286151 18.6638889 0.286151 18.6666667 0.284383 18.6694444 0.285562 18.6722222 0.285856 18.6750000 0.286740 18.6777778 0.285562 18.6805556 0.286151 18.6833333 0.285267 18.6861111 0.284678 18.6888889 0.285267 18.6916667 0.286446 18.6944444 0.285856 18.6972222 0.285856 18.7000000 0.285267 18.7027778 0.284678 18.7055556 0.284972 18.7083333 0.285267 18.7111111 0.284383 18.7138889 0.284678 18.7166667 0.283499 18.7194444 0.283499 18.7222222 0.284088 18.7250000 0.284088 18.7277778 0.283794 18.7305556 0.283204 18.7333333 0.282026 18.7361111 0.282320 18.7388889 0.282026 18.7416667 0.282910 18.7444444 0.282026 18.7472222 0.281142 18.7500000 0.279963 18.7527778 0.279374 18.7555556 0.280258 18.7583333 0.280552 18.7611111 0.279669 18.7638889 0.278490 18.7666667 0.277606 18.7694444 0.277311 18.7722222 0.277311 18.7750000 0.278195 18.7777778 0.277311 18.7805556 0.276427 18.7833333 0.276427 18.7861111 0.275249 18.7888889 0.276427 18.7916667 0.277017 18.7944444 0.276722 18.7972222 0.277017 18.8000000 0.276722 18.8027778 0.277901 18.8055556 0.279079 18.8083333 0.280552 18.8111111 0.280847 18.8138889 0.281142 18.8166667 0.282026 18.8194444 0.283499 18.8222222 0.284383 18.8250000 0.285562 18.8277778 0.286151 18.8355556 0.300000 20.5305556 0.300000)

* P-wave gate
Vpwg pw_gate 0 PWL(0.0000000 0.000000 2.7934444 0.000000 2.7944444 0.900000 2.9444444 0.900000 2.9454444 0.000000 3.6101111 0.000000 3.6111111 0.900000 3.7611111 0.900000 3.7621111 0.000000 4.2628889 0.000000 4.2638889 0.900000 4.4138889 0.900000 4.4148889 0.000000 5.2573333 0.000000 5.2583333 0.900000 5.4083333 0.900000 5.4093333 0.000000 6.1017778 0.000000 6.1027778 0.900000 6.2527778 0.900000 6.2537778 0.000000 6.9128889 0.000000 6.9138889 0.900000 7.0638889 0.900000 7.0648889 0.000000 7.7017778 0.000000 7.7027778 0.900000 7.8527778 0.900000 7.8537778 0.000000 8.4740000 0.000000 8.4750000 0.900000 8.6250000 0.900000 8.6260000 0.000000 9.3128889 0.000000 9.3138889 0.900000 9.4638889 0.900000 9.4648889 0.000000 10.1684444 0.000000 10.1694444 0.900000 10.3194444 0.900000 10.3204444 0.000000 10.9906667 0.000000 10.9916667 0.900000 11.1416667 0.900000 11.1426667 0.000000 11.8184444 0.000000 11.8194444 0.900000 11.9694444 0.900000 11.9704444 0.000000 12.6406667 0.000000 12.6416667 0.900000 12.7916667 0.900000 12.7926667 0.000000 13.4351111 0.000000 13.4361111 0.900000 13.5861111 0.900000 13.5871111 0.000000 14.2323333 0.000000 14.2333333 0.900000 14.3833333 0.900000 14.3843333 0.000000 15.0240000 0.000000 15.0250000 0.900000 15.1750000 0.900000 15.1760000 0.000000 15.8462222 0.000000 15.8472222 0.900000 15.9972222 0.900000 15.9982222 0.000000 16.7156667 0.000000 16.7166667 0.900000 16.8666667 0.900000 16.8676667 0.000000 17.5378889 0.000000 17.5388889 0.900000 17.6888889 0.900000 17.6898889 0.000000 18.3240000 0.000000 18.3250000 0.900000 18.4750000 0.900000 18.4760000 0.000000 20.5305556 0.000000)

* === LPF at 8Hz ===
XM5a taila vbias_lpf vss vss sky130_fd_pr__nfet_01v8 L=8 W=0.42 nf=1
XM1a net1a ecg_l1 taila vss sky130_fd_pr__nfet_01v8 L=4 W=2 nf=1
XM2a lpf8 lpf8 taila vss sky130_fd_pr__nfet_01v8 L=4 W=2 nf=1
XM3a net1a net1a vdd vdd sky130_fd_pr__pfet_01v8 L=4 W=2 nf=1
XM4a lpf8 net1a vdd vdd sky130_fd_pr__pfet_01v8 L=4 W=2 nf=1
XCa lpf8 vss sky130_fd_pr__cap_mim_m3_1 W=71 L=71

* === LPF at 3Hz ===
XM5b tailb vbias_hpf vss vss sky130_fd_pr__nfet_01v8 L=8 W=0.42 nf=1
XM1b net1b ecg_l1 tailb vss sky130_fd_pr__nfet_01v8 L=4 W=2 nf=1
XM2b lpf3 lpf3 tailb vss sky130_fd_pr__nfet_01v8 L=4 W=2 nf=1
XM3b net1b net1b vdd vdd sky130_fd_pr__pfet_01v8 L=4 W=2 nf=1
XM4b lpf3 net1b vdd vdd sky130_fd_pr__pfet_01v8 L=4 W=2 nf=1
XCb lpf3 vss sky130_fd_pr__cap_mim_m3_1 W=71 L=71

* === Subtractor: BPF = LPF8 - LPF3 ===
XM5c tailc vbias_lpf vss vss sky130_fd_pr__nfet_01v8 L=8 W=0.42 nf=1
XM1c net1c lpf8 tailc vss sky130_fd_pr__nfet_01v8 L=1 W=8 nf=1
XM2c bpf_out lpf3 tailc vss sky130_fd_pr__nfet_01v8 L=1 W=8 nf=1
XM3c net1c net1c vdd vdd sky130_fd_pr__pfet_01v8 L=1 W=4 nf=1
XM4c bpf_out bpf_out vdd vdd sky130_fd_pr__pfet_01v8 L=1 W=4 nf=1

* === S&H: captures BPF output during P-wave window ===
* This captures the LAST value before gate closes (at PW_E)
XMsh bpf_out pw_gate peak_out vss sky130_fd_pr__nfet_01v8 L=0.5 W=2 nf=1
XCsh peak_out vss sky130_fd_pr__cap_mim_m3_1 W=32 L=32

.tran 0.5m 20.5306

.meas tran pw_b0 FIND V(peak_out) AT=2.9544444
.meas tran bpf_b0 FIND V(bpf_out) AT=2.9444444
.meas tran bpf_mid_b0 FIND V(bpf_out) AT=2.8694444
.meas tran pw_b1 FIND V(peak_out) AT=3.7711111
.meas tran bpf_b1 FIND V(bpf_out) AT=3.7611111
.meas tran bpf_mid_b1 FIND V(bpf_out) AT=3.6861111
.meas tran pw_b2 FIND V(peak_out) AT=4.4238889
.meas tran bpf_b2 FIND V(bpf_out) AT=4.4138889
.meas tran bpf_mid_b2 FIND V(bpf_out) AT=4.3388889
.meas tran pw_b3 FIND V(peak_out) AT=5.4183333
.meas tran bpf_b3 FIND V(bpf_out) AT=5.4083333
.meas tran bpf_mid_b3 FIND V(bpf_out) AT=5.3333333
.meas tran pw_b4 FIND V(peak_out) AT=6.2627778
.meas tran bpf_b4 FIND V(bpf_out) AT=6.2527778
.meas tran bpf_mid_b4 FIND V(bpf_out) AT=6.1777778
.meas tran pw_b5 FIND V(peak_out) AT=7.0738889
.meas tran bpf_b5 FIND V(bpf_out) AT=7.0638889
.meas tran bpf_mid_b5 FIND V(bpf_out) AT=6.9888889
.meas tran pw_b6 FIND V(peak_out) AT=7.8627778
.meas tran bpf_b6 FIND V(bpf_out) AT=7.8527778
.meas tran bpf_mid_b6 FIND V(bpf_out) AT=7.7777778
.meas tran pw_b7 FIND V(peak_out) AT=8.6350000
.meas tran bpf_b7 FIND V(bpf_out) AT=8.6250000
.meas tran bpf_mid_b7 FIND V(bpf_out) AT=8.5500000
.meas tran pw_b8 FIND V(peak_out) AT=9.4738889
.meas tran bpf_b8 FIND V(bpf_out) AT=9.4638889
.meas tran bpf_mid_b8 FIND V(bpf_out) AT=9.3888889
.meas tran pw_b9 FIND V(peak_out) AT=10.3294444
.meas tran bpf_b9 FIND V(bpf_out) AT=10.3194444
.meas tran bpf_mid_b9 FIND V(bpf_out) AT=10.2444444
.meas tran pw_b10 FIND V(peak_out) AT=11.1516667
.meas tran bpf_b10 FIND V(bpf_out) AT=11.1416667
.meas tran bpf_mid_b10 FIND V(bpf_out) AT=11.0666667
.meas tran pw_b11 FIND V(peak_out) AT=11.9794444
.meas tran bpf_b11 FIND V(bpf_out) AT=11.9694444
.meas tran bpf_mid_b11 FIND V(bpf_out) AT=11.8944444
.meas tran pw_b12 FIND V(peak_out) AT=12.8016667
.meas tran bpf_b12 FIND V(bpf_out) AT=12.7916667
.meas tran bpf_mid_b12 FIND V(bpf_out) AT=12.7166667
.meas tran pw_b13 FIND V(peak_out) AT=13.5961111
.meas tran bpf_b13 FIND V(bpf_out) AT=13.5861111
.meas tran bpf_mid_b13 FIND V(bpf_out) AT=13.5111111
.meas tran pw_b14 FIND V(peak_out) AT=14.3933333
.meas tran bpf_b14 FIND V(bpf_out) AT=14.3833333
.meas tran bpf_mid_b14 FIND V(bpf_out) AT=14.3083333
.meas tran pw_b15 FIND V(peak_out) AT=15.1850000
.meas tran bpf_b15 FIND V(bpf_out) AT=15.1750000
.meas tran bpf_mid_b15 FIND V(bpf_out) AT=15.1000000
.meas tran pw_b16 FIND V(peak_out) AT=16.0072222
.meas tran bpf_b16 FIND V(bpf_out) AT=15.9972222
.meas tran bpf_mid_b16 FIND V(bpf_out) AT=15.9222222
.meas tran pw_b17 FIND V(peak_out) AT=16.8766667
.meas tran bpf_b17 FIND V(bpf_out) AT=16.8666667
.meas tran bpf_mid_b17 FIND V(bpf_out) AT=16.7916667
.meas tran pw_b18 FIND V(peak_out) AT=17.6988889
.meas tran bpf_b18 FIND V(bpf_out) AT=17.6888889
.meas tran bpf_mid_b18 FIND V(bpf_out) AT=17.6138889
.meas tran pw_b19 FIND V(peak_out) AT=18.4850000
.meas tran bpf_b19 FIND V(bpf_out) AT=18.4750000
.meas tran bpf_mid_b19 FIND V(bpf_out) AT=18.4000000

.end
