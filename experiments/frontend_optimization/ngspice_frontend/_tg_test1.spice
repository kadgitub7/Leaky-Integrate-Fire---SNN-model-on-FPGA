.title tg_switch_loss_test
.lib "sky130_minimal.lib.spice" tt
.option scale=1.0u method=gear reltol=0.01 gmin=1e-15
.temp 27
Vdd vdd 0 0.9
Vss vss 0 0
Vbias vbias 0 0.300
Vrpk rpk 0 PWL(0.0000000 0.000000 0.4996000 0.000000 0.5000000 0.900000 0.5050000 0.900000 0.5054000 0.000000 1.2996000 0.000000 1.3000000 0.900000 1.3050000 0.900000 1.3054000 0.000000 2.0996000 0.000000 2.1000000 0.900000 2.1050000 0.900000 2.1054000 0.000000 2.8996000 0.000000 2.9000000 0.900000 2.9050000 0.900000 2.9054000 0.000000 3.6996000 0.000000 3.7000000 0.900000 3.7050000 0.900000 3.7054000 0.000000 4.2000000 0.000000)
Vcap capture_trig 0 PWL(0.0000000 0.000000 0.4946000 0.000000 0.4950000 0.900000 0.4970000 0.900000 0.4974000 0.000000 1.2946000 0.000000 1.2950000 0.900000 1.2970000 0.900000 1.2974000 0.000000 2.0946000 0.000000 2.0950000 0.900000 2.0970000 0.900000 2.0974000 0.000000 2.8946000 0.000000 2.8950000 0.900000 2.8970000 0.900000 2.8974000 0.000000 3.6946000 0.000000 3.6950000 0.900000 3.6970000 0.900000 3.6974000 0.000000 4.2000000 0.000000)
Vcopy copy_trig 0 PWL(0.0000000 0.000000 0.5096000 0.000000 0.5100000 0.900000 0.5120000 0.900000 0.5124000 0.000000 1.3096000 0.000000 1.3100000 0.900000 1.3120000 0.900000 1.3124000 0.000000 2.1096000 0.000000 2.1100000 0.900000 2.1120000 0.900000 2.1124000 0.000000 2.9096000 0.000000 2.9100000 0.900000 2.9120000 0.900000 2.9124000 0.000000 3.7096000 0.000000 3.7100000 0.900000 3.7120000 0.900000 3.7124000 0.000000 4.2000000 0.000000)

.include "C:/Users/kadhi/OneDrive/Desktop/amux/verilogLearning/Leaky-Integrate-Fire---SNN-model-on-FPGA/experiments/frontend_optimization/complete_frontend_v9b/inverter.spice"
.include "C:/Users/kadhi/OneDrive/Desktop/amux/verilogLearning/Leaky-Integrate-Fire---SNN-model-on-FPGA/experiments/frontend_optimization/complete_frontend_v9b/rr_timing.spice"

Xrr 0 capture_trig rpk copy_trig f1 f2 timer_out ewma_out vdd vss vbias rr_timing
.ic V(xrr.ewma_node)=0.35

.tran 0.1m 4.2000

.meas tran sf_0 FIND V(xrr.sf_out) AT=0.4980000
.meas tran esamp_0 FIND V(xrr.esamp_node) AT=0.4980000
.meas tran prev_0 FIND V(xrr.prev_node) AT=0.4980000
.meas tran ewma_0 FIND V(xrr.ewma_node) AT=0.5000000
.meas tran sf_1 FIND V(xrr.sf_out) AT=1.2980000
.meas tran esamp_1 FIND V(xrr.esamp_node) AT=1.2980000
.meas tran prev_1 FIND V(xrr.prev_node) AT=1.2980000
.meas tran ewma_1 FIND V(xrr.ewma_node) AT=1.3000000
.meas tran sf_2 FIND V(xrr.sf_out) AT=2.0980000
.meas tran esamp_2 FIND V(xrr.esamp_node) AT=2.0980000
.meas tran prev_2 FIND V(xrr.prev_node) AT=2.0980000
.meas tran ewma_2 FIND V(xrr.ewma_node) AT=2.1000000
.meas tran sf_3 FIND V(xrr.sf_out) AT=2.8980000
.meas tran esamp_3 FIND V(xrr.esamp_node) AT=2.8980000
.meas tran prev_3 FIND V(xrr.prev_node) AT=2.8980000
.meas tran ewma_3 FIND V(xrr.ewma_node) AT=2.9000000
.meas tran sf_4 FIND V(xrr.sf_out) AT=3.6980000
.meas tran esamp_4 FIND V(xrr.esamp_node) AT=3.6980000
.meas tran prev_4 FIND V(xrr.prev_node) AT=3.6980000
.meas tran ewma_4 FIND V(xrr.ewma_node) AT=3.7000000
.meas tran sfcurve_0ms FIND V(timer_out) AT=2.1060000
.meas tran sfcurve_50ms FIND V(timer_out) AT=2.1560000
.meas tran sfcurve_100ms FIND V(timer_out) AT=2.2060000
.meas tran sfcurve_200ms FIND V(timer_out) AT=2.3060000
.meas tran sfcurve_300ms FIND V(timer_out) AT=2.4060000
.meas tran sfcurve_400ms FIND V(timer_out) AT=2.5060000
.meas tran sfcurve_500ms FIND V(timer_out) AT=2.6060000
.meas tran sfcurve_600ms FIND V(timer_out) AT=2.7060000
.meas tran sfcurve_650ms FIND V(timer_out) AT=2.7560000
.meas tran sfcurve_700ms FIND V(timer_out) AT=2.8060000
.meas tran sfcurve_750ms FIND V(timer_out) AT=2.8560000
.meas tran sfcurve_795ms FIND V(timer_out) AT=2.9010000

.end
