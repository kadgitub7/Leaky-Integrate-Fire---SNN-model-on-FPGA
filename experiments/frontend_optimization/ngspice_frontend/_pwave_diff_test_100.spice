.title pwave_diff_v1_test_100
.lib "sky130_minimal.lib.spice" tt
.option scale=1.0u method=gear reltol=0.01 gmin=1e-15
.temp 27

Vdd vdd 0 0.9
Vss vss 0 0
Vbias vbias 0 0.300

Vecg ecg_in 0 PWL(0.0000000 0.300000 1.7450000 0.300000 1.7500000 0.279963 1.7527778 0.279963 1.7555556 0.279963 1.7583333 0.280847 1.7611111 0.280847 1.7638889 0.280847 1.7666667 0.279669 1.7694444 0.279374 1.7722222 0.279963 1.7750000 0.280552 1.7777778 0.281142 1.7805556 0.281731 1.7833333 0.282026 1.7861111 0.282026 1.7888889 0.283794 1.7916667 0.284088 1.7944444 0.284972 1.7972222 0.284678 1.8000000 0.284383 1.8027778 0.284678 1.8055556 0.285267 1.8083333 0.286151 1.8111111 0.286151 1.8138889 0.287035 1.8166667 0.286151 1.8194444 0.286151 1.8222222 0.287035 1.8250000 0.286446 1.8277778 0.286740 1.8305556 0.286151 1.8333333 0.285562 1.8361111 0.284972 1.8388889 0.285856 1.8416667 0.286446 1.8444444 0.286446 1.8472222 0.285267 1.8500000 0.284972 1.8527778 0.285267 1.8555556 0.286446 1.8583333 0.287919 1.8611111 0.288508 1.8638889 0.287624 1.8666667 0.286446 1.8694444 0.284088 1.8722222 0.284088 1.8750000 0.283204 1.8777778 0.283204 1.8805556 0.281731 1.8833333 0.280552 1.8861111 0.279963 1.8888889 0.279963 1.8916667 0.279669 1.8944444 0.279374 1.8972222 0.279374 1.9000000 0.279963 1.9027778 0.279079 1.9055556 0.279669 1.9083333 0.279963 1.9111111 0.279963 1.9138889 0.279669 1.9166667 0.279079 1.9194444 0.278195 1.9222222 0.279079 1.9250000 0.278195 1.9277778 0.279669 1.9305556 0.279963 1.9333333 0.278785 1.9361111 0.277606 1.9388889 0.278785 1.9416667 0.279669 1.9444444 0.279374 1.9472222 0.279374 1.9500000 0.279079 1.9527778 0.277606 1.9555556 0.277017 1.9583333 0.276722 1.9611111 0.274954 1.9638889 0.273186 1.9666667 0.272007 1.9694444 0.269945 1.9722222 0.267882 1.9750000 0.268177 1.9777778 0.270829 1.9805556 0.276133 1.9833333 0.282615 1.9861111 0.290571 1.9888889 0.302357 1.9916667 0.318564 1.9944444 0.335064 1.9972222 0.347145 2.0000000 0.352155 2.0027778 0.346851 2.0055556 0.330645 2.0083333 0.307661 2.0111111 0.287330 2.0138889 0.274954 2.0166667 0.270534 2.0194444 0.271123 2.0222222 0.273481 2.0250000 0.276427 2.0277778 0.277017 2.0305556 0.276722 2.0333333 0.276722 2.0361111 0.276427 2.0388889 0.277017 2.0416667 0.277606 2.0444444 0.277311 2.0472222 0.277311 2.0500000 0.276427 2.0527778 0.275838 2.0555556 0.275838 2.0583333 0.277017 2.0611111 0.277017 2.0638889 0.276133 2.0666667 0.276133 2.0694444 0.275543 2.0722222 0.275838 2.0750000 0.276722 2.0777778 0.276722 2.0805556 0.276427 2.0833333 0.275543 2.0861111 0.275543 2.0888889 0.275543 2.0916667 0.276427 2.0944444 0.277017 2.0972222 0.277017 2.1000000 0.275838 2.1027778 0.275543 2.1055556 0.276133 2.1083333 0.276722 2.1111111 0.276722 2.1138889 0.276722 2.1166667 0.276133 2.1194444 0.275838 2.1222222 0.275838 2.1250000 0.276427 2.1277778 0.277017 2.1305556 0.276722 2.1333333 0.275838 2.1361111 0.274954 2.1388889 0.275543 2.1416667 0.276133 2.1444444 0.275838 2.1472222 0.276133 2.1500000 0.275543 2.1527778 0.274954 2.1555556 0.274954 2.1583333 0.275838 2.1611111 0.276722 2.1638889 0.277017 2.1666667 0.276427 2.1694444 0.275838 2.1722222 0.275838 2.1750000 0.276427 2.1777778 0.277017 2.1805556 0.275838 2.1833333 0.275249 2.1861111 0.275249 2.1888889 0.275543 2.1916667 0.275543 2.1944444 0.276133 2.1972222 0.275249 2.2000000 0.275543 2.2027778 0.274954 2.2055556 0.275838 2.2083333 0.276427 2.2111111 0.276133 2.2138889 0.276427 2.2166667 0.276427 2.2194444 0.275838 2.2222222 0.276427 2.2250000 0.276722 2.2277778 0.276722 2.2305556 0.276133 2.2333333 0.275838 2.2361111 0.274954 2.2388889 0.274954 2.2416667 0.275838 2.2444444 0.275838 2.2472222 0.275249 2.2500000 0.274659 2.2527778 0.273775 2.2555556 0.274070 2.2583333 0.274365 2.2611111 0.274659 2.2638889 0.274659 2.2666667 0.273481 2.2694444 0.273775 2.2722222 0.273775 2.2750000 0.274365 2.2777778 0.274365 2.2805556 0.273775 2.2833333 0.274070 2.2861111 0.273481 2.2888889 0.274659 2.2916667 0.274659 2.2944444 0.275543 2.2972222 0.276427 2.3050000 0.300000 2.5616667 0.300000 2.5666667 0.280552 2.5694444 0.280552 2.5722222 0.280847 2.5750000 0.281436 2.5777778 0.281436 2.5805556 0.281436 2.5833333 0.280552 2.5861111 0.280552 2.5888889 0.281142 2.5916667 0.281436 2.5944444 0.282026 2.5972222 0.282026 2.6000000 0.282615 2.6027778 0.281436 2.6055556 0.282320 2.6083333 0.283794 2.6111111 0.284972 2.6138889 0.284972 2.6166667 0.284678 2.6194444 0.284383 2.6222222 0.284972 2.6250000 0.286151 2.6277778 0.286446 2.6305556 0.286740 2.6333333 0.287035 2.6361111 0.287035 2.6388889 0.287330 2.6416667 0.288214 2.6444444 0.287919 2.6472222 0.287919 2.6500000 0.286740 2.6527778 0.286151 2.6555556 0.285856 2.6583333 0.286446 2.6611111 0.287330 2.6638889 0.285856 2.6666667 0.285856 2.6694444 0.285267 2.6722222 0.286151 2.6750000 0.287624 2.6777778 0.288214 2.6805556 0.287035 2.6833333 0.284972 2.6861111 0.283794 2.6888889 0.283204 2.6916667 0.282320 2.6944444 0.282026 2.6972222 0.281142 2.7000000 0.280552 2.7027778 0.280847 2.7055556 0.281142 2.7083333 0.280552 2.7111111 0.280552 2.7138889 0.280258 2.7166667 0.279963 2.7194444 0.279669 2.7222222 0.279963 2.7250000 0.280258 2.7277778 0.281142 2.7305556 0.280847 2.7333333 0.280258 2.7361111 0.279669 2.7388889 0.279669 2.7416667 0.279669 2.7444444 0.280258 2.7472222 0.279963 2.7500000 0.279669 2.7527778 0.279079 2.7555556 0.279963 2.7583333 0.279963 2.7611111 0.279963 2.7638889 0.279963 2.7666667 0.279669 2.7694444 0.279079 2.7722222 0.278490 2.7750000 0.278195 2.7777778 0.276133 2.7805556 0.273775 2.7833333 0.271713 2.7861111 0.270829 2.7888889 0.269355 2.7916667 0.268471 2.7944444 0.270239 2.7972222 0.275543 2.8000000 0.283499 2.8027778 0.292044 2.8055556 0.303831 2.8083333 0.317680 2.8111111 0.334180 2.8138889 0.347735 2.8166667 0.355691 2.8194444 0.354217 2.8222222 0.345672 2.8250000 0.326225 2.8277778 0.301179 2.8305556 0.282615 2.8333333 0.273775 2.8361111 0.272302 2.8388889 0.274954 2.8416667 0.277606 2.8444444 0.278785 2.8472222 0.278785 2.8500000 0.278195 2.8527778 0.277606 2.8555556 0.277606 2.8583333 0.277901 2.8611111 0.278195 2.8638889 0.278490 2.8666667 0.278195 2.8694444 0.277311 2.8722222 0.277311 2.8750000 0.277901 2.8777778 0.278195 2.8805556 0.278195 2.8833333 0.277311 2.8861111 0.276722 2.8888889 0.277311 2.8916667 0.277311 2.8944444 0.277017 2.8972222 0.277311 2.9000000 0.276722 2.9027778 0.275838 2.9055556 0.276427 2.9083333 0.276722 2.9111111 0.277606 2.9138889 0.276722 2.9166667 0.276722 2.9194444 0.276427 2.9222222 0.276427 2.9250000 0.276722 2.9277778 0.277017 2.9305556 0.277017 2.9333333 0.276722 2.9361111 0.276133 2.9388889 0.277017 2.9416667 0.277311 2.9444444 0.277901 2.9472222 0.277901 2.9500000 0.277606 2.9527778 0.277017 2.9555556 0.277311 2.9583333 0.278195 2.9611111 0.278195 2.9638889 0.278195 2.9666667 0.277901 2.9694444 0.277311 2.9722222 0.278195 2.9750000 0.277017 2.9777778 0.277901 2.9805556 0.278195 2.9833333 0.277606 2.9861111 0.277017 2.9888889 0.277017 2.9916667 0.277311 2.9944444 0.277901 2.9972222 0.277901 3.0000000 0.277311 3.0027778 0.276722 3.0055556 0.277017 3.0083333 0.277311 3.0111111 0.277901 3.0138889 0.277606 3.0166667 0.277311 3.0194444 0.277017 3.0222222 0.277606 3.0250000 0.277606 3.0277778 0.278195 3.0305556 0.278195 3.0333333 0.278490 3.0361111 0.277017 3.0388889 0.278490 3.0416667 0.278490 3.0444444 0.278785 3.0472222 0.277901 3.0500000 0.277606 3.0527778 0.276427 3.0555556 0.277017 3.0583333 0.277901 3.0611111 0.277901 3.0638889 0.278195 3.0666667 0.277311 3.0694444 0.277017 3.0722222 0.277017 3.0750000 0.277017 3.0777778 0.277017 3.0805556 0.277901 3.0833333 0.277311 3.0861111 0.276722 3.0888889 0.277606 3.0916667 0.278195 3.0944444 0.277901 3.0972222 0.277901 3.1000000 0.277017 3.1027778 0.276133 3.1055556 0.277901 3.1083333 0.278195 3.1111111 0.278785 3.1138889 0.277901 3.1216667 0.300000 3.2144444 0.300000 3.2194444 0.282615 3.2222222 0.283204 3.2250000 0.283499 3.2277778 0.283794 3.2305556 0.283499 3.2333333 0.282910 3.2361111 0.281731 3.2388889 0.282026 3.2416667 0.283204 3.2444444 0.284088 3.2472222 0.284088 3.2500000 0.283794 3.2527778 0.283204 3.2555556 0.283204 3.2583333 0.284088 3.2611111 0.284383 3.2638889 0.284383 3.2666667 0.284383 3.2694444 0.283499 3.2722222 0.284383 3.2750000 0.285562 3.2777778 0.286151 3.2805556 0.286151 3.2833333 0.285267 3.2861111 0.285267 3.2888889 0.285562 3.2916667 0.287330 3.2944444 0.287035 3.2972222 0.285562 3.3000000 0.284972 3.3027778 0.286446 3.3055556 0.287919 3.3083333 0.287624 3.3111111 0.287035 3.3138889 0.286446 3.3166667 0.285856 3.3194444 0.285856 3.3222222 0.285562 3.3250000 0.285267 3.3277778 0.284088 3.3305556 0.283204 3.3333333 0.281436 3.3361111 0.281142 3.3388889 0.281142 3.3416667 0.281731 3.3444444 0.280552 3.3472222 0.279963 3.3500000 0.279669 3.3527778 0.278785 3.3555556 0.278490 3.3583333 0.278785 3.3611111 0.279374 3.3638889 0.279079 3.3666667 0.277901 3.3694444 0.277311 3.3722222 0.277901 3.3750000 0.278195 3.3777778 0.278490 3.3805556 0.278490 3.3833333 0.278195 3.3861111 0.277606 3.3888889 0.278785 3.3916667 0.279374 3.3944444 0.279079 3.3972222 0.279079 3.4000000 0.279374 3.4027778 0.278490 3.4055556 0.279374 3.4083333 0.279374 3.4111111 0.279963 3.4138889 0.279079 3.4166667 0.279374 3.4194444 0.277901 3.4222222 0.278490 3.4250000 0.277901 3.4277778 0.276427 3.4305556 0.274659 3.4333333 0.272007 3.4361111 0.269355 3.4388889 0.269355 3.4416667 0.267587 3.4444444 0.266409 3.4472222 0.268177 3.4500000 0.273775 3.4527778 0.282026 3.4555556 0.291750 3.4583333 0.301473 3.4611111 0.315322 3.4638889 0.330055 3.4666667 0.343315 3.4694444 0.349797 3.4722222 0.351565 3.4750000 0.343315 3.4777778 0.323573 3.4805556 0.298527 3.4833333 0.280258 3.4861111 0.271713 3.4888889 0.272302 3.4916667 0.275543 3.4944444 0.277901 3.4972222 0.278490 3.5000000 0.277311 3.5027778 0.276427 3.5055556 0.277606 3.5083333 0.277017 3.5111111 0.277901 3.5138889 0.277311 3.5166667 0.276722 3.5194444 0.276133 3.5222222 0.277017 3.5250000 0.277606 3.5277778 0.277311 3.5305556 0.277311 3.5333333 0.276722 3.5361111 0.276427 3.5388889 0.276133 3.5416667 0.276427 3.5444444 0.277017 3.5472222 0.277017 3.5500000 0.276722 3.5527778 0.276427 3.5555556 0.277017 3.5583333 0.277311 3.5611111 0.277017 3.5638889 0.277311 3.5666667 0.275838 3.5694444 0.275249 3.5722222 0.276133 3.5750000 0.275838 3.5777778 0.277017 3.5805556 0.277017 3.5833333 0.277017 3.5861111 0.276427 3.5888889 0.276427 3.5916667 0.277017 3.5944444 0.277901 3.5972222 0.277606 3.6000000 0.276722 3.6027778 0.276427 3.6055556 0.277017 3.6083333 0.276427 3.6111111 0.277017 3.6138889 0.276722 3.6166667 0.275838 3.6194444 0.275543 3.6222222 0.276133 3.6250000 0.277311 3.6277778 0.277311 3.6305556 0.277606 3.6333333 0.276427 3.6361111 0.276427 3.6388889 0.276722 3.6416667 0.277017 3.6444444 0.277606 3.6472222 0.277901 3.6500000 0.276722 3.6527778 0.276722 3.6555556 0.277311 3.6583333 0.277606 3.6611111 0.277901 3.6638889 0.277311 3.6666667 0.277017 3.6694444 0.276427 3.6722222 0.276427 3.6750000 0.277311 3.6777778 0.277606 3.6805556 0.276722 3.6833333 0.277017 3.6861111 0.276427 3.6888889 0.276722 3.6916667 0.277311 3.6944444 0.277606 3.6972222 0.277311 3.7000000 0.276722 3.7027778 0.276133 3.7055556 0.276427 3.7083333 0.277017 3.7111111 0.277606 3.7138889 0.277606 3.7166667 0.277311 3.7194444 0.276133 3.7222222 0.276722 3.7250000 0.276427 3.7277778 0.277017 3.7305556 0.276427 3.7333333 0.276133 3.7361111 0.274954 3.7388889 0.275249 3.7416667 0.276133 3.7444444 0.276427 3.7472222 0.276133 3.7500000 0.276133 3.7527778 0.275543 3.7555556 0.276427 3.7583333 0.277017 3.7611111 0.277606 3.7638889 0.277311 3.7666667 0.276722 3.7744444 0.300000 4.2088889 0.300000 4.2138889 0.279669 4.2166667 0.279079 4.2194444 0.278785 4.2222222 0.278785 4.2250000 0.278490 4.2277778 0.279669 4.2305556 0.279079 4.2333333 0.279374 4.2361111 0.278785 4.2388889 0.279079 4.2416667 0.278785 4.2444444 0.279669 4.2472222 0.280258 4.2500000 0.280552 4.2527778 0.280552 4.2555556 0.281731 4.2583333 0.282026 4.2611111 0.282320 4.2638889 0.282026 4.2666667 0.282615 4.2694444 0.282026 4.2722222 0.283204 4.2750000 0.283794 4.2777778 0.284383 4.2805556 0.284972 4.2833333 0.284972 4.2861111 0.284678 4.2888889 0.284383 4.2916667 0.284972 4.2944444 0.284972 4.2972222 0.284678 4.3000000 0.283499 4.3027778 0.282910 4.3055556 0.283499 4.3083333 0.284088 4.3111111 0.284972 4.3138889 0.283794 4.3166667 0.282910 4.3194444 0.281142 4.3222222 0.282320 4.3250000 0.282615 4.3277778 0.284088 4.3305556 0.284383 4.3333333 0.284088 4.3361111 0.283204 4.3388889 0.282320 4.3416667 0.281731 4.3444444 0.281436 4.3472222 0.281142 4.3500000 0.279374 4.3527778 0.278195 4.3555556 0.278490 4.3583333 0.278490 4.3611111 0.278490 4.3638889 0.278195 4.3666667 0.278195 4.3694444 0.278195 4.3722222 0.277606 4.3750000 0.278785 4.3777778 0.277901 4.3805556 0.277901 4.3833333 0.276427 4.3861111 0.275249 4.3888889 0.276133 4.3916667 0.276427 4.3944444 0.277311 4.3972222 0.277606 4.4000000 0.276427 4.4027778 0.275543 4.4055556 0.276133 4.4083333 0.276722 4.4111111 0.276722 4.4138889 0.276722 4.4166667 0.275838 4.4194444 0.274659 4.4222222 0.274070 4.4250000 0.273186 4.4277778 0.271123 4.4305556 0.271418 4.4333333 0.269355 4.4361111 0.266409 4.4388889 0.266114 4.4416667 0.269061 4.4444444 0.275249 4.4472222 0.282026 4.4500000 0.288803 4.4527778 0.298821 4.4555556 0.312965 4.4583333 0.328582 4.4611111 0.342136 4.4638889 0.349797 4.4666667 0.352155 4.4694444 0.346556 4.4722222 0.333002 4.4750000 0.313260 4.4777778 0.295875 4.4805556 0.283204 4.4833333 0.274954 4.4861111 0.270534 4.4888889 0.267587 4.4916667 0.268471 4.4944444 0.270534 4.4972222 0.272597 4.5000000 0.273481 4.5027778 0.273481 4.5055556 0.274365 4.5083333 0.275249 4.5111111 0.275838 4.5138889 0.275838 4.5166667 0.275543 4.5194444 0.275249 4.5222222 0.274954 4.5250000 0.275249 4.5277778 0.274659 4.5305556 0.274659 4.5333333 0.274070 4.5361111 0.273481 4.5388889 0.273481 4.5416667 0.274659 4.5444444 0.274659 4.5472222 0.274659 4.5500000 0.273775 4.5527778 0.273775 4.5555556 0.274070 4.5583333 0.274954 4.5611111 0.274659 4.5638889 0.274659 4.5666667 0.274954 4.5694444 0.273775 4.5722222 0.273775 4.5750000 0.274659 4.5777778 0.274365 4.5805556 0.274365 4.5833333 0.273775 4.5861111 0.273775 4.5888889 0.274365 4.5916667 0.274659 4.5944444 0.274954 4.5972222 0.274659 4.6000000 0.274659 4.6027778 0.274070 4.6055556 0.275249 4.6083333 0.274659 4.6111111 0.274954 4.6138889 0.274659 4.6166667 0.274070 4.6194444 0.274070 4.6222222 0.274659 4.6250000 0.274659 4.6277778 0.275543 4.6305556 0.274954 4.6333333 0.274659 4.6361111 0.273186 4.6388889 0.273775 4.6416667 0.273775 4.6444444 0.274659 4.6472222 0.274659 4.6500000 0.274070 4.6527778 0.274070 4.6555556 0.274365 4.6583333 0.274659 4.6611111 0.275543 4.6638889 0.275543 4.6666667 0.274954 4.6694444 0.274954 4.6722222 0.275249 4.6750000 0.276133 4.6777778 0.276133 4.6805556 0.275543 4.6833333 0.275543 4.6861111 0.274954 4.6888889 0.274659 4.6916667 0.276133 4.6944444 0.276133 4.6972222 0.276133 4.7000000 0.276133 4.7027778 0.274659 4.7055556 0.275543 4.7083333 0.275838 4.7111111 0.275543 4.7138889 0.274659 4.7166667 0.273775 4.7194444 0.272597 4.7222222 0.272891 4.7250000 0.273481 4.7277778 0.273186 4.7305556 0.272891 4.7333333 0.272597 4.7361111 0.271418 4.7388889 0.270829 4.7416667 0.272007 4.7444444 0.271123 4.7472222 0.270534 4.7500000 0.270829 4.7527778 0.269650 4.7555556 0.270534 4.7583333 0.271418 4.7611111 0.271123 4.7688889 0.300000 5.0533333 0.300000 5.0583333 0.279079 5.0611111 0.279963 5.0638889 0.279669 5.0666667 0.279079 5.0694444 0.279079 5.0722222 0.279079 5.0750000 0.279963 5.0777778 0.279963 5.0805556 0.279669 5.0833333 0.278490 5.0861111 0.278195 5.0888889 0.279374 5.0916667 0.280552 5.0944444 0.281142 5.0972222 0.281436 5.1000000 0.282615 5.1027778 0.282026 5.1055556 0.282615 5.1083333 0.282320 5.1111111 0.283204 5.1138889 0.283794 5.1166667 0.284678 5.1194444 0.283794 5.1222222 0.284383 5.1250000 0.284678 5.1277778 0.285267 5.1305556 0.285562 5.1333333 0.284972 5.1361111 0.284383 5.1388889 0.284678 5.1416667 0.284678 5.1444444 0.285267 5.1472222 0.284678 5.1500000 0.283499 5.1527778 0.283499 5.1555556 0.283794 5.1583333 0.283204 5.1611111 0.283499 5.1638889 0.284972 5.1666667 0.285562 5.1694444 0.285562 5.1722222 0.284678 5.1750000 0.283204 5.1777778 0.282910 5.1805556 0.282320 5.1833333 0.281142 5.1861111 0.280258 5.1888889 0.279079 5.1916667 0.279374 5.1944444 0.279079 5.1972222 0.279079 5.2000000 0.277901 5.2027778 0.277311 5.2055556 0.277606 5.2083333 0.278785 5.2111111 0.279374 5.2138889 0.278785 5.2166667 0.278490 5.2194444 0.278195 5.2222222 0.278195 5.2250000 0.278490 5.2277778 0.278785 5.2305556 0.278490 5.2333333 0.278195 5.2361111 0.277311 5.2388889 0.277311 5.2416667 0.278490 5.2444444 0.278785 5.2472222 0.277606 5.2500000 0.277311 5.2527778 0.276722 5.2555556 0.276722 5.2583333 0.277311 5.2611111 0.277606 5.2638889 0.276722 5.2666667 0.274954 5.2694444 0.272597 5.2722222 0.270534 5.2750000 0.269650 5.2777778 0.268766 5.2805556 0.266998 5.2833333 0.265525 5.2861111 0.268766 5.2888889 0.275838 5.2916667 0.284972 5.2944444 0.293812 5.2972222 0.306188 5.3000000 0.320921 5.3027778 0.335359 5.3055556 0.347735 5.3083333 0.352449 5.3111111 0.348913 5.3138889 0.334180 5.3166667 0.310902 5.3194444 0.287919 5.3222222 0.273481 5.3250000 0.269061 5.3277778 0.270829 5.3305556 0.272597 5.3333333 0.274365 5.3361111 0.275543 5.3388889 0.275543 5.3416667 0.275543 5.3444444 0.276427 5.3472222 0.276722 5.3500000 0.276133 5.3527778 0.274954 5.3555556 0.274365 5.3583333 0.275543 5.3611111 0.275543 5.3638889 0.275543 5.3666667 0.275543 5.3694444 0.274659 5.3722222 0.275249 5.3750000 0.275838 5.3777778 0.276133 5.3805556 0.275249 5.3833333 0.275838 5.3861111 0.275249 5.3888889 0.276427 5.3916667 0.276722 5.3944444 0.277311 5.3972222 0.276427 5.4000000 0.276427 5.4027778 0.276427 5.4055556 0.276427 5.4083333 0.276722 5.4111111 0.276427 5.4138889 0.276427 5.4166667 0.276427 5.4194444 0.275838 5.4222222 0.276722 5.4250000 0.275838 5.4277778 0.276427 5.4305556 0.276722 5.4333333 0.276133 5.4361111 0.275838 5.4388889 0.275543 5.4416667 0.276133 5.4444444 0.276427 5.4472222 0.276722 5.4500000 0.276133 5.4527778 0.275543 5.4555556 0.276133 5.4583333 0.275543 5.4611111 0.275838 5.4638889 0.276133 5.4666667 0.276133 5.4694444 0.275838 5.4722222 0.276133 5.4750000 0.276427 5.4777778 0.276722 5.4805556 0.276133 5.4833333 0.276133 5.4861111 0.276427 5.4888889 0.276722 5.4916667 0.277017 5.4944444 0.276722 5.4972222 0.277017 5.5000000 0.276722 5.5027778 0.275249 5.5055556 0.275543 5.5083333 0.276133 5.5111111 0.276427 5.5138889 0.276427 5.5166667 0.275543 5.5194444 0.275249 5.5222222 0.275838 5.5250000 0.276722 5.5277778 0.276427 5.5305556 0.276133 5.5333333 0.275543 5.5361111 0.274365 5.5388889 0.275543 5.5416667 0.275543 5.5444444 0.276427 5.5472222 0.276133 5.5500000 0.275249 5.5527778 0.274659 5.5555556 0.274954 5.5583333 0.275838 5.5611111 0.275838 5.5638889 0.276133 5.5666667 0.275543 5.5694444 0.274954 5.5722222 0.274954 5.5750000 0.275249 5.5777778 0.275838 5.5805556 0.275838 5.5833333 0.275249 5.5861111 0.274659 5.5888889 0.274954 5.5916667 0.275249 5.5944444 0.276133 5.5972222 0.275543 5.6000000 0.275838 5.6027778 0.275838 5.6055556 0.277311 5.6133333 0.300000 5.8644444 0.300000 5.8694444 0.280258 5.8722222 0.281142 5.8750000 0.280847 5.8777778 0.281436 5.8805556 0.281142 5.8833333 0.281142 5.8861111 0.279669 5.8888889 0.280258 5.8916667 0.281142 5.8944444 0.281731 5.8972222 0.281142 5.9000000 0.281142 5.9027778 0.279963 5.9055556 0.280552 5.9083333 0.281142 5.9111111 0.281731 5.9138889 0.281731 5.9166667 0.281731 5.9194444 0.282615 5.9222222 0.283499 5.9250000 0.284972 5.9277778 0.285267 5.9305556 0.285267 5.9333333 0.284972 5.9361111 0.284678 5.9388889 0.285856 5.9416667 0.287035 5.9444444 0.286446 5.9472222 0.286446 5.9500000 0.287330 5.9527778 0.287035 5.9555556 0.286740 5.9583333 0.286446 5.9611111 0.286446 5.9638889 0.286151 5.9666667 0.285562 5.9694444 0.284972 5.9722222 0.285856 5.9750000 0.286151 5.9777778 0.285562 5.9805556 0.286151 5.9833333 0.286446 5.9861111 0.287035 5.9888889 0.288508 5.9916667 0.287035 5.9944444 0.285562 5.9972222 0.284678 6.0000000 0.284088 6.0027778 0.282910 6.0055556 0.282320 6.0083333 0.282026 6.0111111 0.282026 6.0138889 0.281142 6.0166667 0.280552 6.0194444 0.279374 6.0222222 0.279374 6.0250000 0.280258 6.0277778 0.280258 6.0305556 0.280258 6.0333333 0.279963 6.0361111 0.279374 6.0388889 0.279374 6.0416667 0.279669 6.0444444 0.280258 6.0472222 0.279669 6.0500000 0.279079 6.0527778 0.278195 6.0555556 0.279374 6.0583333 0.279669 6.0611111 0.280258 6.0638889 0.280258 6.0666667 0.280258 6.0694444 0.279079 6.0722222 0.279079 6.0750000 0.279669 6.0777778 0.279079 6.0805556 0.276722 6.0833333 0.273481 6.0861111 0.271713 6.0888889 0.270239 6.0916667 0.269061 6.0944444 0.267882 6.0972222 0.270534 6.1000000 0.276722 6.1027778 0.284972 6.1055556 0.295875 6.1083333 0.308545 6.1111111 0.325046 6.1138889 0.340368 6.1166667 0.351565 6.1194444 0.354512 6.1222222 0.346851 6.1250000 0.327698 6.1277778 0.301179 6.1305556 0.280847 6.1333333 0.272302 6.1361111 0.271418 6.1388889 0.275838 6.1416667 0.278490 6.1444444 0.279079 6.1472222 0.278490 6.1500000 0.277606 6.1527778 0.277311 6.1555556 0.277606 6.1583333 0.278195 6.1611111 0.278195 6.1638889 0.277901 6.1666667 0.277311 6.1694444 0.276722 6.1722222 0.277311 6.1750000 0.277606 6.1777778 0.277311 6.1805556 0.277901 6.1833333 0.277017 6.1861111 0.276133 6.1888889 0.276133 6.1916667 0.277017 6.1944444 0.277311 6.1972222 0.277311 6.2000000 0.277017 6.2027778 0.275838 6.2055556 0.276427 6.2083333 0.277017 6.2111111 0.277311 6.2138889 0.277311 6.2166667 0.276722 6.2194444 0.277017 6.2222222 0.276722 6.2250000 0.277606 6.2277778 0.277901 6.2305556 0.277606 6.2333333 0.277311 6.2361111 0.276427 6.2388889 0.277311 6.2416667 0.277606 6.2444444 0.277901 6.2472222 0.277606 6.2500000 0.276722 6.2527778 0.276722 6.2555556 0.277311 6.2583333 0.277901 6.2611111 0.278195 6.2638889 0.278490 6.2666667 0.277311 6.2694444 0.276722 6.2722222 0.277311 6.2750000 0.277311 6.2777778 0.278195 6.2805556 0.277901 6.2833333 0.278195 6.2861111 0.277901 6.2888889 0.277901 6.2916667 0.278195 6.2944444 0.279079 6.2972222 0.278490 6.3000000 0.277606 6.3027778 0.277901 6.3055556 0.278195 6.3083333 0.277606 6.3111111 0.278490 6.3138889 0.278195 6.3166667 0.277901 6.3194444 0.277017 6.3222222 0.277606 6.3250000 0.277901 6.3277778 0.277606 6.3305556 0.278195 6.3333333 0.277901 6.3361111 0.277606 6.3388889 0.277311 6.3416667 0.277311 6.3444444 0.278195 6.3472222 0.277901 6.3500000 0.277901 6.3527778 0.277606 6.3555556 0.277606 6.3583333 0.277606 6.3611111 0.277606 6.3638889 0.277901 6.3666667 0.277017 6.3694444 0.276722 6.3722222 0.277311 6.3750000 0.277311 6.3777778 0.277901 6.3805556 0.277901 6.3833333 0.277311 6.3861111 0.277311 6.3888889 0.277017 6.3916667 0.278195 6.3944444 0.278490 6.3972222 0.278490 6.4000000 0.277901 6.4027778 0.277311 6.4055556 0.279374 6.4083333 0.279669 6.4111111 0.280847 6.4138889 0.280847 6.4166667 0.280552 6.4244444 0.300000 6.6533333 0.300000 6.6583333 0.282026 6.6611111 0.282910 6.6638889 0.283204 6.6666667 0.282910 6.6694444 0.282026 6.6722222 0.281731 6.6750000 0.282320 6.6777778 0.282320 6.6805556 0.281731 6.6833333 0.281436 6.6861111 0.281436 6.6888889 0.281731 6.6916667 0.282615 6.6944444 0.282320 6.6972222 0.282615 6.7000000 0.281436 6.7027778 0.281731 6.7055556 0.282910 6.7083333 0.284383 6.7111111 0.285856 6.7138889 0.284972 6.7166667 0.285856 6.7194444 0.285267 6.7222222 0.286740 6.7250000 0.286740 6.7277778 0.287330 6.7305556 0.287624 6.7333333 0.288214 6.7361111 0.288508 6.7388889 0.288508 6.7416667 0.289392 6.7444444 0.289687 6.7472222 0.289392 6.7500000 0.287919 6.7527778 0.287330 6.7555556 0.287624 6.7583333 0.287624 6.7611111 0.287624 6.7638889 0.287624 6.7666667 0.287330 6.7694444 0.286740 6.7722222 0.287624 6.7750000 0.289392 6.7777778 0.289982 6.7805556 0.289098 6.7833333 0.285856 6.7861111 0.284972 6.7888889 0.284972 6.7916667 0.284088 6.7944444 0.283794 6.7972222 0.283204 6.8000000 0.282320 6.8027778 0.282320 6.8055556 0.281436 6.8083333 0.282026 6.8111111 0.282320 6.8138889 0.282615 6.8166667 0.282320 6.8194444 0.281436 6.8222222 0.281731 6.8250000 0.281731 6.8277778 0.282320 6.8305556 0.282320 6.8333333 0.282026 6.8361111 0.281436 6.8388889 0.280847 6.8416667 0.281142 6.8444444 0.281142 6.8472222 0.281142 6.8500000 0.280847 6.8527778 0.279963 6.8555556 0.280258 6.8583333 0.280847 6.8611111 0.281436 6.8638889 0.281142 6.8666667 0.279669 6.8694444 0.278195 6.8722222 0.276722 6.8750000 0.274954 6.8777778 0.273775 6.8805556 0.272597 6.8833333 0.269945 6.8861111 0.268766 6.8888889 0.271418 6.8916667 0.278195 6.8944444 0.286151 6.8972222 0.294696 6.9000000 0.306188 6.9027778 0.322099 6.9055556 0.338600 6.9083333 0.348324 6.9111111 0.350976 6.9138889 0.343315 6.9166667 0.326519 6.9194444 0.303536 6.9222222 0.284088 6.9250000 0.274659 6.9277778 0.272891 6.9305556 0.275543 6.9333333 0.277311 6.9361111 0.278490 6.9388889 0.279079 6.9416667 0.279079 6.9444444 0.279669 6.9472222 0.279374 6.9500000 0.279374 6.9527778 0.278785 6.9555556 0.279669 6.9583333 0.279963 6.9611111 0.279963 6.9638889 0.280258 6.9666667 0.280258 6.9694444 0.279079 6.9722222 0.279669 6.9750000 0.279963 6.9777778 0.280258 6.9805556 0.279963 6.9833333 0.279374 6.9861111 0.278490 6.9888889 0.278785 6.9916667 0.278490 6.9944444 0.279374 6.9972222 0.279669 7.0000000 0.278490 7.0027778 0.278785 7.0055556 0.279374 7.0083333 0.279079 7.0111111 0.279374 7.0138889 0.279079 7.0166667 0.279374 7.0194444 0.278785 7.0222222 0.280258 7.0250000 0.280258 7.0277778 0.280552 7.0305556 0.279963 7.0333333 0.279374 7.0361111 0.279374 7.0388889 0.279669 7.0416667 0.280258 7.0444444 0.279669 7.0472222 0.279079 7.0500000 0.279079 7.0527778 0.278195 7.0555556 0.279079 7.0583333 0.279374 7.0611111 0.279669 7.0638889 0.278490 7.0666667 0.278490 7.0694444 0.278195 7.0722222 0.278490 7.0750000 0.279079 7.0777778 0.279669 7.0805556 0.279669 7.0833333 0.279669 7.0861111 0.279963 7.0888889 0.280258 7.0916667 0.280847 7.0944444 0.280258 7.0972222 0.279669 7.1000000 0.279374 7.1027778 0.279374 7.1055556 0.279079 7.1083333 0.279079 7.1111111 0.278785 7.1138889 0.279374 7.1166667 0.278785 7.1194444 0.278490 7.1222222 0.279669 7.1250000 0.279669 7.1277778 0.280552 7.1305556 0.279374 7.1333333 0.279669 7.1361111 0.279079 7.1388889 0.279374 7.1416667 0.279963 7.1444444 0.280258 7.1472222 0.279374 7.1500000 0.278490 7.1527778 0.277606 7.1555556 0.277311 7.1583333 0.279079 7.1611111 0.278785 7.1638889 0.279079 7.1666667 0.278195 7.1694444 0.277311 7.1722222 0.278195 7.1750000 0.278195 7.1777778 0.279374 7.1805556 0.279669 7.1833333 0.278490 7.1861111 0.278490 7.1888889 0.278785 7.1916667 0.279669 7.1944444 0.280552 7.1972222 0.280552 7.2000000 0.280552 7.2027778 0.280258 7.2055556 0.281436 7.2133333 0.300000 7.4255556 0.300000 7.4305556 0.282026 7.4333333 0.281731 7.4361111 0.281142 7.4388889 0.281731 7.4416667 0.282320 7.4444444 0.282615 7.4472222 0.282320 7.4500000 0.281436 7.4527778 0.280847 7.4555556 0.280847 7.4583333 0.282026 7.4611111 0.281731 7.4638889 0.282910 7.4666667 0.281436 7.4694444 0.280847 7.4722222 0.281142 7.4750000 0.282910 7.4777778 0.283499 7.4805556 0.284678 7.4833333 0.284678 7.4861111 0.284383 7.4888889 0.284678 7.4916667 0.285267 7.4944444 0.286446 7.4972222 0.287035 7.5000000 0.287035 7.5027778 0.286151 7.5055556 0.287035 7.5083333 0.287919 7.5111111 0.287919 7.5138889 0.287624 7.5166667 0.287624 7.5194444 0.286446 7.5222222 0.285856 7.5250000 0.286446 7.5277778 0.286740 7.5305556 0.286151 7.5333333 0.285267 7.5361111 0.284383 7.5388889 0.284678 7.5416667 0.285562 7.5444444 0.287330 7.5472222 0.287330 7.5500000 0.285562 7.5527778 0.283499 7.5555556 0.283794 7.5583333 0.283794 7.5611111 0.282615 7.5638889 0.281731 7.5666667 0.280847 7.5694444 0.279963 7.5722222 0.279963 7.5750000 0.280847 7.5777778 0.281436 7.5805556 0.281731 7.5833333 0.281436 7.5861111 0.280552 7.5888889 0.280552 7.5916667 0.280847 7.5944444 0.280847 7.5972222 0.280258 7.6000000 0.279669 7.6027778 0.279374 7.6055556 0.279374 7.6083333 0.279374 7.6111111 0.279669 7.6138889 0.279374 7.6166667 0.278490 7.6194444 0.278785 7.6222222 0.279374 7.6250000 0.279079 7.6277778 0.279669 7.6305556 0.279669 7.6333333 0.279374 7.6361111 0.278490 7.6388889 0.277606 7.6416667 0.276133 7.6444444 0.274954 7.6472222 0.274070 7.6500000 0.272302 7.6527778 0.269355 7.6555556 0.268177 7.6583333 0.271123 7.6611111 0.277017 7.6638889 0.284678 7.6666667 0.293223 7.6694444 0.305009 7.6722222 0.321215 7.6750000 0.336243 7.6777778 0.345967 7.6805556 0.349208 7.6833333 0.342431 7.6861111 0.324162 7.6888889 0.301768 7.6916667 0.284972 7.6944444 0.275543 7.6972222 0.272302 7.7000000 0.272597 7.7027778 0.274365 7.7055556 0.276722 7.7083333 0.277901 7.7111111 0.278195 7.7138889 0.277901 7.7166667 0.277901 7.7194444 0.277017 7.7222222 0.276427 7.7250000 0.277606 7.7277778 0.277311 7.7305556 0.277311 7.7333333 0.277311 7.7361111 0.277311 7.7388889 0.278195 7.7416667 0.278195 7.7444444 0.278785 7.7472222 0.277606 7.7500000 0.277606 7.7527778 0.277311 7.7555556 0.278195 7.7583333 0.278195 7.7611111 0.278490 7.7638889 0.277901 7.7666667 0.277311 7.7694444 0.277017 7.7722222 0.277017 7.7750000 0.277311 7.7777778 0.277311 7.7805556 0.276722 7.7833333 0.277017 7.7861111 0.276427 7.7888889 0.276133 7.7916667 0.277017 7.7944444 0.276722 7.7972222 0.277017 7.8000000 0.276133 7.8027778 0.276133 7.8055556 0.276427 7.8083333 0.277901 7.8111111 0.277606 7.8138889 0.277017 7.8166667 0.276722 7.8194444 0.276722 7.8222222 0.277017 7.8250000 0.277017 7.8277778 0.277311 7.8305556 0.276133 7.8333333 0.276427 7.8361111 0.276133 7.8388889 0.276722 7.8416667 0.277017 7.8444444 0.276722 7.8472222 0.277017 7.8500000 0.276427 7.8527778 0.276133 7.8555556 0.276133 7.8583333 0.277017 7.8611111 0.277017 7.8638889 0.276722 7.8666667 0.276427 7.8694444 0.276427 7.8722222 0.276722 7.8750000 0.277606 7.8777778 0.278195 7.8805556 0.277606 7.8833333 0.277311 7.8861111 0.276722 7.8888889 0.277017 7.8916667 0.277606 7.8944444 0.277606 7.8972222 0.277311 7.9000000 0.277017 7.9027778 0.277017 7.9055556 0.276427 7.9083333 0.276427 7.9111111 0.276133 7.9138889 0.275543 7.9166667 0.275249 7.9194444 0.274659 7.9222222 0.274659 7.9250000 0.274954 7.9277778 0.275249 7.9305556 0.274659 7.9333333 0.273775 7.9361111 0.272597 7.9388889 0.273186 7.9416667 0.274070 7.9444444 0.274954 7.9472222 0.274365 7.9500000 0.273481 7.9527778 0.274070 7.9555556 0.273775 7.9583333 0.274954 7.9611111 0.274954 7.9638889 0.274954 7.9666667 0.274659 7.9694444 0.274659 7.9722222 0.275543 7.9750000 0.275543 7.9777778 0.277311 7.9855556 0.300000 8.2644444 0.300000 8.2694444 0.281142 8.2722222 0.281436 8.2750000 0.281731 8.2777778 0.282615 8.2805556 0.282615 8.2833333 0.282026 8.2861111 0.281731 8.2888889 0.282320 8.2916667 0.283499 8.2944444 0.283794 8.2972222 0.284383 8.3000000 0.283794 8.3027778 0.283794 8.3055556 0.284678 8.3083333 0.285856 8.3111111 0.285856 8.3138889 0.286151 8.3166667 0.285856 8.3194444 0.286151 8.3222222 0.286740 8.3250000 0.287330 8.3277778 0.287919 8.3305556 0.287919 8.3333333 0.287624 8.3361111 0.287330 8.3388889 0.287035 8.3416667 0.287035 8.3444444 0.287330 8.3472222 0.287035 8.3500000 0.287035 8.3527778 0.286446 8.3555556 0.286446 8.3583333 0.285856 8.3611111 0.287624 8.3638889 0.287035 8.3666667 0.286446 8.3694444 0.284972 8.3722222 0.286151 8.3750000 0.287624 8.3777778 0.288803 8.3805556 0.287919 8.3833333 0.286740 8.3861111 0.284678 8.3888889 0.283794 8.3916667 0.283499 8.3944444 0.283204 8.3972222 0.282026 8.4000000 0.281142 8.4027778 0.281436 8.4055556 0.280258 8.4083333 0.280847 8.4111111 0.280258 8.4138889 0.281142 8.4166667 0.280847 8.4194444 0.281142 8.4222222 0.280847 8.4250000 0.280847 8.4277778 0.281731 8.4305556 0.282026 8.4333333 0.281142 8.4361111 0.281142 8.4388889 0.280552 8.4416667 0.281142 8.4444444 0.281142 8.4472222 0.280552 8.4500000 0.280552 8.4527778 0.278785 8.4555556 0.279079 8.4583333 0.280552 8.4611111 0.280847 8.4638889 0.280847 8.4666667 0.280258 8.4694444 0.279374 8.4722222 0.279963 8.4750000 0.279669 8.4777778 0.279079 8.4805556 0.277311 8.4833333 0.274954 8.4861111 0.273481 8.4888889 0.272302 8.4916667 0.271418 8.4944444 0.269945 8.4972222 0.269650 8.5000000 0.273186 8.5027778 0.280847 8.5055556 0.290276 8.5083333 0.300589 8.5111111 0.314733 8.5138889 0.330350 8.5166667 0.343610 8.5194444 0.352155 8.5222222 0.355101 8.5250000 0.349208 8.5277778 0.330939 8.5305556 0.307072 8.5333333 0.286446 8.5361111 0.274954 8.5388889 0.273186 8.5416667 0.275249 8.5444444 0.277606 8.5472222 0.278785 8.5500000 0.278490 8.5527778 0.277901 8.5555556 0.277606 8.5583333 0.279079 8.5611111 0.279079 8.5638889 0.278195 8.5666667 0.277901 8.5694444 0.277311 8.5722222 0.277606 8.5750000 0.278490 8.5777778 0.278195 8.5805556 0.278195 8.5833333 0.278490 8.5861111 0.277606 8.5888889 0.278195 8.5916667 0.277901 8.5944444 0.278490 8.5972222 0.278195 8.6000000 0.277606 8.6027778 0.277901 8.6055556 0.278490 8.6083333 0.278785 8.6111111 0.278785 8.6138889 0.279079 8.6166667 0.279079 8.6194444 0.278195 8.6222222 0.278490 8.6250000 0.279079 8.6277778 0.279374 8.6305556 0.279374 8.6333333 0.279374 8.6361111 0.278785 8.6388889 0.278785 8.6416667 0.278785 8.6444444 0.279374 8.6472222 0.279079 8.6500000 0.278490 8.6527778 0.278195 8.6555556 0.278785 8.6583333 0.279374 8.6611111 0.279079 8.6638889 0.279374 8.6666667 0.279079 8.6694444 0.278195 8.6722222 0.277901 8.6750000 0.278785 8.6777778 0.279374 8.6805556 0.279669 8.6833333 0.279374 8.6861111 0.278195 8.6888889 0.278195 8.6916667 0.279079 8.6944444 0.279374 8.6972222 0.279669 8.7000000 0.278785 8.7027778 0.278195 8.7055556 0.278490 8.7083333 0.278785 8.7111111 0.279374 8.7138889 0.279079 8.7166667 0.278490 8.7194444 0.278490 8.7222222 0.278195 8.7250000 0.278490 8.7277778 0.279374 8.7305556 0.279374 8.7333333 0.278785 8.7361111 0.278785 8.7388889 0.279079 8.7416667 0.279669 8.7444444 0.279374 8.7472222 0.279669 8.7500000 0.279079 8.7527778 0.278195 8.7555556 0.278490 8.7583333 0.279079 8.7611111 0.278785 8.7638889 0.278490 8.7666667 0.278490 8.7694444 0.277606 8.7722222 0.277311 8.7750000 0.277901 8.7777778 0.278195 8.7805556 0.277901 8.7833333 0.277311 8.7861111 0.276722 8.7888889 0.277901 8.7916667 0.277311 8.7944444 0.277606 8.7972222 0.278195 8.8000000 0.277311 8.8027778 0.277311 8.8055556 0.277606 8.8083333 0.278195 8.8111111 0.278785 8.8138889 0.279374 8.8166667 0.280258 8.8244444 0.300000 9.1200000 0.300000 9.1250000 0.282615 9.1277778 0.283204 9.1305556 0.282615 9.1333333 0.282615 9.1361111 0.281731 9.1388889 0.282320 9.1416667 0.283204 9.1444444 0.283499 9.1472222 0.283794 9.1500000 0.283499 9.1527778 0.284383 9.1555556 0.285562 9.1583333 0.286446 9.1611111 0.285856 9.1638889 0.285856 9.1666667 0.285856 9.1694444 0.285562 9.1722222 0.287035 9.1750000 0.287035 9.1777778 0.287330 9.1805556 0.288214 9.1833333 0.288214 9.1861111 0.287624 9.1888889 0.287919 9.1916667 0.288508 9.1944444 0.287919 9.1972222 0.287624 9.2000000 0.287330 9.2027778 0.286740 9.2055556 0.286740 9.2083333 0.288214 9.2111111 0.288214 9.2138889 0.287624 9.2166667 0.286740 9.2194444 0.287035 9.2222222 0.288508 9.2250000 0.289392 9.2277778 0.289687 9.2305556 0.287919 9.2333333 0.285562 9.2361111 0.284383 9.2388889 0.283794 9.2416667 0.283499 9.2444444 0.283204 9.2472222 0.282320 9.2500000 0.281731 9.2527778 0.280847 9.2555556 0.281142 9.2583333 0.280847 9.2611111 0.281731 9.2638889 0.280847 9.2666667 0.280552 9.2694444 0.279963 9.2722222 0.280258 9.2750000 0.280552 9.2777778 0.280847 9.2805556 0.281142 9.2833333 0.279963 9.2861111 0.279669 9.2888889 0.279963 9.2916667 0.280552 9.2944444 0.280258 9.2972222 0.280552 9.3000000 0.279963 9.3027778 0.279963 9.3055556 0.280258 9.3083333 0.280258 9.3111111 0.280552 9.3138889 0.280258 9.3166667 0.279669 9.3194444 0.277901 9.3222222 0.276722 9.3250000 0.274659 9.3277778 0.274070 9.3305556 0.273481 9.3333333 0.273481 9.3361111 0.272007 9.3388889 0.271713 9.3416667 0.269945 9.3444444 0.267587 9.3472222 0.266114 9.3500000 0.267882 9.3527778 0.271123 9.3555556 0.277901 9.3583333 0.285267 9.3611111 0.292928 9.3638889 0.303536 9.3666667 0.316796 9.3694444 0.330939 9.3722222 0.343610 9.3750000 0.350681 9.3777778 0.352449 9.3805556 0.343020 9.3833333 0.325046 9.3861111 0.300884 9.3888889 0.283204 9.3916667 0.274365 9.3944444 0.273481 9.3972222 0.274365 9.4000000 0.277311 9.4027778 0.277606 9.4055556 0.278195 9.4083333 0.278195 9.4111111 0.278195 9.4138889 0.278785 9.4166667 0.278785 9.4194444 0.278195 9.4222222 0.277311 9.4250000 0.278490 9.4277778 0.278785 9.4305556 0.278490 9.4333333 0.278490 9.4361111 0.277901 9.4388889 0.277311 9.4416667 0.278785 9.4444444 0.278490 9.4472222 0.279079 9.4500000 0.277901 9.4527778 0.277606 9.4555556 0.277901 9.4583333 0.279079 9.4611111 0.279079 9.4638889 0.278785 9.4666667 0.278490 9.4694444 0.277606 9.4722222 0.278195 9.4750000 0.279079 9.4777778 0.279374 9.4805556 0.279079 9.4833333 0.278490 9.4861111 0.277606 9.4888889 0.278490 9.4916667 0.279079 9.4944444 0.279079 9.4972222 0.278490 9.5000000 0.277311 9.5027778 0.277017 9.5055556 0.277901 9.5083333 0.279079 9.5111111 0.278490 9.5138889 0.278785 9.5166667 0.279079 9.5194444 0.278490 9.5222222 0.278490 9.5250000 0.279079 9.5277778 0.279669 9.5305556 0.279669 9.5333333 0.278490 9.5361111 0.278785 9.5388889 0.277901 9.5416667 0.279079 9.5444444 0.278785 9.5472222 0.278490 9.5500000 0.278490 9.5527778 0.278195 9.5555556 0.278785 9.5583333 0.279079 9.5611111 0.278785 9.5638889 0.278490 9.5666667 0.277311 9.5694444 0.277606 9.5722222 0.278490 9.5750000 0.279079 9.5777778 0.280258 9.5805556 0.278785 9.5833333 0.278785 9.5861111 0.277311 9.5888889 0.277606 9.5916667 0.277901 9.5944444 0.278785 9.5972222 0.278785 9.6000000 0.278490 9.6027778 0.277901 9.6055556 0.278490 9.6083333 0.279079 9.6111111 0.278785 9.6138889 0.279374 9.6166667 0.278785 9.6194444 0.278195 9.6222222 0.278195 9.6250000 0.278490 9.6277778 0.278195 9.6305556 0.277606 9.6333333 0.277017 9.6361111 0.277311 9.6388889 0.277606 9.6416667 0.278195 9.6444444 0.278195 9.6472222 0.278490 9.6500000 0.278490 9.6527778 0.277017 9.6555556 0.277901 9.6583333 0.278195 9.6611111 0.279079 9.6638889 0.278490 9.6666667 0.278785 9.6694444 0.278195 9.6722222 0.279374 9.6800000 0.300000 9.9422222 0.300000 9.9472222 0.281436 9.9500000 0.280258 9.9527778 0.280258 9.9555556 0.280552 9.9583333 0.281731 9.9611111 0.281731 9.9638889 0.281436 9.9666667 0.280552 9.9694444 0.281142 9.9722222 0.281436 9.9750000 0.282320 9.9777778 0.283204 9.9805556 0.283499 9.9833333 0.284383 9.9861111 0.284678 9.9888889 0.284383 9.9916667 0.284678 9.9944444 0.284972 9.9972222 0.284678 10.0000000 0.285267 10.0027778 0.284972 10.0055556 0.285856 10.0083333 0.286446 10.0111111 0.287919 10.0138889 0.287624 10.0166667 0.286740 10.0194444 0.286151 10.0222222 0.286740 10.0250000 0.286740 10.0277778 0.286446 10.0305556 0.286740 10.0333333 0.285856 10.0361111 0.285856 10.0388889 0.286446 10.0416667 0.286151 10.0444444 0.285267 10.0472222 0.285267 10.0500000 0.284972 10.0527778 0.286151 10.0555556 0.287035 10.0583333 0.287919 10.0611111 0.287330 10.0638889 0.285856 10.0666667 0.284383 10.0694444 0.283499 10.0722222 0.283499 10.0750000 0.284088 10.0777778 0.284088 10.0805556 0.282910 10.0833333 0.281142 10.0861111 0.280258 10.0888889 0.279963 10.0916667 0.280552 10.0944444 0.280552 10.0972222 0.280258 10.1000000 0.279374 10.1027778 0.278785 10.1055556 0.279374 10.1083333 0.279374 10.1111111 0.279669 10.1138889 0.279374 10.1166667 0.279079 10.1194444 0.278490 10.1222222 0.278785 10.1250000 0.279079 10.1277778 0.279374 10.1305556 0.279963 10.1333333 0.278785 10.1361111 0.278195 10.1388889 0.278195 10.1416667 0.279079 10.1444444 0.279669 10.1472222 0.279374 10.1500000 0.278195 10.1527778 0.277311 10.1555556 0.275838 10.1583333 0.274070 10.1611111 0.272891 10.1638889 0.271123 10.1666667 0.268177 10.1694444 0.266703 10.1722222 0.267587 10.1750000 0.271418 10.1777778 0.278490 10.1805556 0.284972 10.1833333 0.292634 10.1861111 0.305304 10.1888889 0.321215 10.1916667 0.335359 10.1944444 0.344199 10.1972222 0.346851 10.2000000 0.341252 10.2027778 0.325930 10.2055556 0.305599 10.2083333 0.289098 10.2111111 0.278195 10.2138889 0.272302 10.2166667 0.271123 10.2194444 0.272302 10.2222222 0.274070 10.2250000 0.274954 10.2277778 0.275838 10.2305556 0.275838 10.2333333 0.275838 10.2361111 0.275249 10.2388889 0.276427 10.2416667 0.276722 10.2444444 0.276133 10.2472222 0.275838 10.2500000 0.276133 10.2527778 0.275249 10.2555556 0.276722 10.2583333 0.276722 10.2611111 0.277017 10.2638889 0.276722 10.2666667 0.276722 10.2694444 0.275838 10.2722222 0.276427 10.2750000 0.276427 10.2777778 0.275838 10.2805556 0.276427 10.2833333 0.276133 10.2861111 0.275838 10.2888889 0.275838 10.2916667 0.276427 10.2944444 0.277017 10.2972222 0.277017 10.3000000 0.276427 10.3027778 0.276427 10.3055556 0.276722 10.3083333 0.277017 10.3111111 0.277311 10.3138889 0.277017 10.3166667 0.275838 10.3194444 0.275838 10.3222222 0.275838 10.3250000 0.275543 10.3277778 0.275838 10.3305556 0.276133 10.3333333 0.275249 10.3361111 0.275249 10.3388889 0.275249 10.3416667 0.275543 10.3444444 0.275838 10.3472222 0.275543 10.3500000 0.274954 10.3527778 0.274954 10.3555556 0.275249 10.3583333 0.274954 10.3611111 0.275249 10.3638889 0.275838 10.3666667 0.275838 10.3694444 0.275543 10.3722222 0.275838 10.3750000 0.275838 10.3777778 0.276427 10.3805556 0.276133 10.3833333 0.276133 10.3861111 0.274954 10.3888889 0.275249 10.3916667 0.275838 10.3944444 0.276427 10.3972222 0.276133 10.4000000 0.275543 10.4027778 0.275249 10.4055556 0.275838 10.4083333 0.275838 10.4111111 0.276427 10.4138889 0.275838 10.4166667 0.275543 10.4194444 0.275249 10.4222222 0.275838 10.4250000 0.276427 10.4277778 0.277017 10.4305556 0.276427 10.4333333 0.275543 10.4361111 0.275249 10.4388889 0.275543 10.4416667 0.275543 10.4444444 0.276427 10.4472222 0.275543 10.4500000 0.274659 10.4527778 0.273481 10.4555556 0.274070 10.4583333 0.274070 10.4611111 0.274365 10.4638889 0.274365 10.4666667 0.274070 10.4694444 0.273481 10.4722222 0.274365 10.4750000 0.274070 10.4777778 0.274659 10.4805556 0.274070 10.4833333 0.273775 10.4861111 0.273775 10.4888889 0.274070 10.4916667 0.274365 10.4944444 0.275249 10.5022222 0.300000 10.7700000 0.300000 10.7750000 0.279374 10.7777778 0.280258 10.7805556 0.279669 10.7833333 0.279374 10.7861111 0.279374 10.7888889 0.279079 10.7916667 0.279963 10.7944444 0.280258 10.7972222 0.280552 10.8000000 0.279963 10.8027778 0.279079 10.8055556 0.279079 10.8083333 0.280552 10.8111111 0.281436 10.8138889 0.281436 10.8166667 0.281436 10.8194444 0.281142 10.8222222 0.282320 10.8250000 0.282320 10.8277778 0.283499 10.8305556 0.284383 10.8333333 0.283499 10.8361111 0.283204 10.8388889 0.284383 10.8416667 0.286151 10.8444444 0.286446 10.8472222 0.286446 10.8500000 0.285562 10.8527778 0.284972 10.8555556 0.285267 10.8583333 0.285562 10.8611111 0.285267 10.8638889 0.284972 10.8666667 0.284383 10.8694444 0.284088 10.8722222 0.282910 10.8750000 0.283499 10.8777778 0.283794 10.8805556 0.284678 10.8833333 0.284972 10.8861111 0.284678 10.8888889 0.283794 10.8916667 0.282615 10.8944444 0.282320 10.8972222 0.282026 10.9000000 0.280258 10.9027778 0.279079 10.9055556 0.279374 10.9083333 0.279374 10.9111111 0.279374 10.9138889 0.279079 10.9166667 0.278195 10.9194444 0.278195 10.9222222 0.278785 10.9250000 0.278490 10.9277778 0.279079 10.9305556 0.278490 10.9333333 0.277901 10.9361111 0.277311 10.9388889 0.277606 10.9416667 0.277901 10.9444444 0.279079 10.9472222 0.278195 10.9500000 0.277311 10.9527778 0.277017 10.9555556 0.277017 10.9583333 0.278195 10.9611111 0.278785 10.9638889 0.278195 10.9666667 0.277606 10.9694444 0.277311 10.9722222 0.277606 10.9750000 0.277901 10.9777778 0.278195 10.9805556 0.277606 10.9833333 0.276133 10.9861111 0.273775 10.9888889 0.272597 10.9916667 0.271713 10.9944444 0.271418 10.9972222 0.269061 11.0000000 0.267293 11.0027778 0.268471 11.0055556 0.273481 11.0083333 0.280847 11.0111111 0.289098 11.0138889 0.298527 11.0166667 0.310902 11.0194444 0.325341 11.0222222 0.338895 11.0250000 0.348029 11.0277778 0.350092 11.0305556 0.344199 11.0333333 0.328582 11.0361111 0.306483 11.0388889 0.287624 11.0416667 0.277017 11.0444444 0.272891 11.0472222 0.271418 11.0500000 0.272302 11.0527778 0.273481 11.0555556 0.274954 11.0583333 0.275543 11.0611111 0.276133 11.0638889 0.275543 11.0666667 0.275543 11.0694444 0.275249 11.0722222 0.276427 11.0750000 0.276722 11.0777778 0.277311 11.0805556 0.276722 11.0833333 0.276427 11.0861111 0.275249 11.0888889 0.275838 11.0916667 0.276427 11.0944444 0.276427 11.0972222 0.276133 11.1000000 0.276133 11.1027778 0.274365 11.1055556 0.275249 11.1083333 0.275838 11.1111111 0.276133 11.1138889 0.275543 11.1166667 0.274659 11.1194444 0.274070 11.1222222 0.274365 11.1250000 0.275543 11.1277778 0.275249 11.1305556 0.274659 11.1333333 0.275543 11.1361111 0.274659 11.1388889 0.274954 11.1416667 0.275249 11.1444444 0.275249 11.1472222 0.275543 11.1500000 0.274954 11.1527778 0.274954 11.1555556 0.275249 11.1583333 0.275838 11.1611111 0.275838 11.1638889 0.275838 11.1666667 0.275249 11.1694444 0.274659 11.1722222 0.275249 11.1750000 0.275543 11.1777778 0.276722 11.1805556 0.276133 11.1833333 0.275543 11.1861111 0.274659 11.1888889 0.275249 11.1916667 0.275249 11.1944444 0.275543 11.1972222 0.275249 11.2000000 0.274954 11.2027778 0.274070 11.2055556 0.274659 11.2083333 0.274954 11.2111111 0.275543 11.2138889 0.275249 11.2166667 0.274954 11.2194444 0.274070 11.2222222 0.274659 11.2250000 0.274659 11.2277778 0.274954 11.2305556 0.275249 11.2333333 0.275543 11.2361111 0.274954 11.2388889 0.274659 11.2416667 0.274954 11.2444444 0.275543 11.2472222 0.276133 11.2500000 0.276133 11.2527778 0.274954 11.2555556 0.275543 11.2583333 0.275249 11.2611111 0.275249 11.2638889 0.275249 11.2666667 0.274365 11.2694444 0.274365 11.2722222 0.274070 11.2750000 0.275249 11.2777778 0.274659 11.2805556 0.273481 11.2833333 0.273186 11.2861111 0.272597 11.2888889 0.272597 11.2916667 0.272597 11.2944444 0.272597 11.2972222 0.272597 11.3000000 0.272302 11.3027778 0.271123 11.3055556 0.271418 11.3083333 0.272891 11.3111111 0.273186 11.3138889 0.272891 11.3166667 0.273186 11.3194444 0.273186 11.3222222 0.274070 11.3300000 0.300000 11.5922222 0.300000 11.5972222 0.280258 11.6000000 0.279079 11.6027778 0.279669 11.6055556 0.279963 11.6083333 0.280552 11.6111111 0.279963 11.6138889 0.279669 11.6166667 0.279374 11.6194444 0.279079 11.6222222 0.279374 11.6250000 0.280258 11.6277778 0.280552 11.6305556 0.280552 11.6333333 0.280552 11.6361111 0.280552 11.6388889 0.282026 11.6416667 0.283204 11.6444444 0.283794 11.6472222 0.283499 11.6500000 0.283204 11.6527778 0.282910 11.6555556 0.283794 11.6583333 0.284678 11.6611111 0.285562 11.6638889 0.285856 11.6666667 0.285856 11.6694444 0.285856 11.6722222 0.286151 11.6750000 0.286740 11.6777778 0.287035 11.6805556 0.286446 11.6833333 0.285856 11.6861111 0.284972 11.6888889 0.284972 11.6916667 0.285856 11.6944444 0.285856 11.6972222 0.285267 11.7000000 0.284088 11.7027778 0.284088 11.7055556 0.285856 11.7083333 0.286446 11.7111111 0.286740 11.7138889 0.284383 11.7166667 0.282615 11.7194444 0.282026 11.7222222 0.280847 11.7250000 0.281436 11.7277778 0.280847 11.7305556 0.280552 11.7333333 0.279669 11.7361111 0.278785 11.7388889 0.278490 11.7416667 0.279079 11.7444444 0.279669 11.7472222 0.279963 11.7500000 0.280258 11.7527778 0.278785 11.7555556 0.279079 11.7583333 0.279669 11.7611111 0.280258 11.7638889 0.279079 11.7666667 0.279374 11.7694444 0.277901 11.7722222 0.277901 11.7750000 0.278490 11.7777778 0.278490 11.7805556 0.279374 11.7833333 0.278195 11.7861111 0.277606 11.7888889 0.278490 11.7916667 0.278195 11.7944444 0.279079 11.7972222 0.278195 11.8000000 0.277606 11.8027778 0.277311 11.8055556 0.277311 11.8083333 0.276427 11.8111111 0.274659 11.8138889 0.272597 11.8166667 0.271418 11.8194444 0.269355 11.8222222 0.267293 11.8250000 0.269061 11.8277778 0.274365 11.8305556 0.282026 11.8333333 0.290866 11.8361111 0.300589 11.8388889 0.315322 11.8416667 0.331529 11.8444444 0.344788 11.8472222 0.352449 11.8500000 0.353333 11.8527778 0.341547 11.8555556 0.321215 11.8583333 0.298232 11.8611111 0.281142 11.8638889 0.273186 11.8666667 0.272007 11.8694444 0.274070 11.8722222 0.276722 11.8750000 0.277606 11.8777778 0.277606 11.8805556 0.277311 11.8833333 0.276722 11.8861111 0.276427 11.8888889 0.276133 11.8916667 0.276722 11.8944444 0.275838 11.8972222 0.277017 11.9000000 0.276722 11.9027778 0.276133 11.9055556 0.276133 11.9083333 0.276722 11.9111111 0.277311 11.9138889 0.277311 11.9166667 0.276133 11.9194444 0.276133 11.9222222 0.276427 11.9250000 0.277311 11.9277778 0.277606 11.9305556 0.277311 11.9333333 0.276133 11.9361111 0.275838 11.9388889 0.276427 11.9416667 0.276722 11.9444444 0.277311 11.9472222 0.276722 11.9500000 0.275838 11.9527778 0.276133 11.9555556 0.276133 11.9583333 0.276722 11.9611111 0.277017 11.9638889 0.276722 11.9666667 0.276722 11.9694444 0.276133 11.9722222 0.275838 11.9750000 0.276427 11.9777778 0.277311 11.9805556 0.276722 11.9833333 0.276427 11.9861111 0.276722 11.9888889 0.277311 11.9916667 0.277311 11.9944444 0.277901 11.9972222 0.277901 12.0000000 0.277606 12.0027778 0.276722 12.0055556 0.277311 12.0083333 0.277017 12.0111111 0.277311 12.0138889 0.277606 12.0166667 0.277017 12.0194444 0.276427 12.0222222 0.276427 12.0250000 0.277017 12.0277778 0.278490 12.0305556 0.277901 12.0333333 0.277311 12.0361111 0.276427 12.0388889 0.276427 12.0416667 0.277017 12.0444444 0.277606 12.0472222 0.277901 12.0500000 0.277311 12.0527778 0.276722 12.0555556 0.277606 12.0583333 0.278195 12.0611111 0.278490 12.0638889 0.278490 12.0666667 0.277901 12.0694444 0.277311 12.0722222 0.277901 12.0750000 0.277901 12.0777778 0.278490 12.0805556 0.278195 12.0833333 0.277901 12.0861111 0.276427 12.0888889 0.276722 12.0916667 0.276133 12.0944444 0.278195 12.0972222 0.277311 12.1000000 0.276427 12.1027778 0.275838 12.1055556 0.276427 12.1083333 0.276722 12.1111111 0.277901 12.1138889 0.277606 12.1166667 0.277311 12.1194444 0.276133 12.1222222 0.277311 12.1250000 0.277901 12.1277778 0.278195 12.1305556 0.278490 12.1333333 0.278490 12.1361111 0.279374 12.1388889 0.279079 12.1416667 0.281142 12.1444444 0.281731 12.1522222 0.300000 12.3866667 0.300000 12.3916667 0.281142 12.3944444 0.281731 12.3972222 0.282026 12.4000000 0.281436 12.4027778 0.280552 12.4055556 0.281142 12.4083333 0.281731 12.4111111 0.282026 12.4138889 0.282320 12.4166667 0.282615 12.4194444 0.281142 12.4222222 0.281731 12.4250000 0.282320 12.4277778 0.283794 12.4305556 0.284088 12.4333333 0.284678 12.4361111 0.285267 12.4388889 0.286151 12.4416667 0.286446 12.4444444 0.286740 12.4472222 0.286446 12.4500000 0.286446 12.4527778 0.285856 12.4555556 0.286446 12.4583333 0.286740 12.4611111 0.287919 12.4638889 0.287919 12.4666667 0.288214 12.4694444 0.287624 12.4722222 0.288508 12.4750000 0.288214 12.4777778 0.288803 12.4805556 0.288214 12.4833333 0.287624 12.4861111 0.286740 12.4888889 0.286740 12.4916667 0.287035 12.4944444 0.287035 12.4972222 0.287035 12.5000000 0.286446 12.5027778 0.285267 12.5055556 0.285562 12.5083333 0.286446 12.5111111 0.287919 12.5138889 0.289098 12.5166667 0.288508 12.5194444 0.286740 12.5222222 0.285267 12.5250000 0.284972 12.5277778 0.284383 12.5305556 0.283794 12.5333333 0.282026 12.5361111 0.281142 12.5388889 0.280847 12.5416667 0.280847 12.5444444 0.280552 12.5472222 0.280552 12.5500000 0.280847 12.5527778 0.280258 12.5555556 0.279963 12.5583333 0.280258 12.5611111 0.281142 12.5638889 0.280258 12.5666667 0.279669 12.5694444 0.279079 12.5722222 0.279374 12.5750000 0.279079 12.5777778 0.279374 12.5805556 0.279669 12.5833333 0.279963 12.5861111 0.279079 12.5888889 0.279374 12.5916667 0.279963 12.5944444 0.279963 12.5972222 0.279963 12.6000000 0.279079 12.6027778 0.276427 12.6055556 0.274365 12.6083333 0.273186 12.6111111 0.272302 12.6138889 0.270534 12.6166667 0.268177 12.6194444 0.267882 12.6222222 0.272597 12.6250000 0.279079 12.6277778 0.287624 12.6305556 0.297937 12.6333333 0.310902 12.6361111 0.325635 12.6388889 0.339779 12.6416667 0.348324 12.6444444 0.348619 12.6472222 0.337716 12.6500000 0.318858 12.6527778 0.295875 12.6555556 0.279963 12.6583333 0.273775 12.6611111 0.273775 12.6638889 0.275838 12.6666667 0.277606 12.6694444 0.277901 12.6722222 0.277901 12.6750000 0.278195 12.6777778 0.278490 12.6805556 0.278785 12.6833333 0.278195 12.6861111 0.277901 12.6888889 0.278195 12.6916667 0.278785 12.6944444 0.279374 12.6972222 0.279079 12.7000000 0.278490 12.7027778 0.277606 12.7055556 0.277606 12.7083333 0.278195 12.7111111 0.278490 12.7138889 0.278490 12.7166667 0.277606 12.7194444 0.277311 12.7222222 0.277017 12.7250000 0.277606 12.7277778 0.277901 12.7305556 0.277901 12.7333333 0.277606 12.7361111 0.277017 12.7388889 0.277606 12.7416667 0.277901 12.7444444 0.278195 12.7472222 0.278490 12.7500000 0.277901 12.7527778 0.277311 12.7555556 0.278490 12.7583333 0.278785 12.7611111 0.279374 12.7638889 0.279079 12.7666667 0.279079 12.7694444 0.278195 12.7722222 0.278490 12.7750000 0.279374 12.7777778 0.278785 12.7805556 0.278490 12.7833333 0.278490 12.7861111 0.277901 12.7888889 0.277901 12.7916667 0.279079 12.7944444 0.279079 12.7972222 0.278195 12.8000000 0.277901 12.8027778 0.277606 12.8055556 0.277311 12.8083333 0.278195 12.8111111 0.278195 12.8138889 0.278785 12.8166667 0.278195 12.8194444 0.277901 12.8222222 0.278490 12.8250000 0.279079 12.8277778 0.279669 12.8305556 0.278785 12.8333333 0.279079 12.8361111 0.278490 12.8388889 0.278785 12.8416667 0.279669 12.8444444 0.280258 12.8472222 0.280258 12.8500000 0.279079 12.8527778 0.279079 12.8555556 0.279374 12.8583333 0.279963 12.8611111 0.279374 12.8638889 0.279374 12.8666667 0.279079 12.8694444 0.278490 12.8722222 0.278785 12.8750000 0.278490 12.8777778 0.278490 12.8805556 0.278490 12.8833333 0.278195 12.8861111 0.277901 12.8888889 0.277606 12.8916667 0.278490 12.8944444 0.279374 12.8972222 0.278785 12.9000000 0.278490 12.9027778 0.277606 12.9055556 0.277901 12.9083333 0.278195 12.9111111 0.278785 12.9138889 0.278490 12.9166667 0.277901 12.9194444 0.277606 12.9222222 0.277901 12.9250000 0.278785 12.9277778 0.279079 12.9305556 0.279079 12.9333333 0.279079 12.9361111 0.279374 12.9388889 0.279374 12.9466667 0.300000 13.1838889 0.300000 13.1888889 0.280258 13.1916667 0.280847 13.1944444 0.280847 13.1972222 0.281142 13.2000000 0.280847 13.2027778 0.280258 13.2055556 0.281142 13.2083333 0.281142 13.2111111 0.281731 13.2138889 0.281731 13.2166667 0.281142 13.2194444 0.280552 13.2222222 0.279963 13.2250000 0.280847 13.2277778 0.282026 13.2305556 0.282026 13.2333333 0.282910 13.2361111 0.282910 13.2388889 0.284088 13.2416667 0.284383 13.2444444 0.284383 13.2472222 0.284678 13.2500000 0.284678 13.2527778 0.284088 13.2555556 0.283794 13.2583333 0.284678 13.2611111 0.285562 13.2638889 0.286151 13.2666667 0.286446 13.2694444 0.285562 13.2722222 0.285856 13.2750000 0.286446 13.2777778 0.285856 13.2805556 0.286740 13.2833333 0.285856 13.2861111 0.285562 13.2888889 0.285856 13.2916667 0.287035 13.2944444 0.287035 13.2972222 0.286446 13.3000000 0.285562 13.3027778 0.284972 13.3055556 0.285856 13.3083333 0.287330 13.3111111 0.286740 13.3138889 0.284972 13.3166667 0.283204 13.3194444 0.281731 13.3222222 0.281731 13.3250000 0.280552 13.3277778 0.280258 13.3305556 0.279374 13.3333333 0.279374 13.3361111 0.278785 13.3388889 0.279079 13.3416667 0.279963 13.3444444 0.279963 13.3472222 0.280258 13.3500000 0.279374 13.3527778 0.278785 13.3555556 0.278785 13.3583333 0.279669 13.3611111 0.279669 13.3638889 0.279374 13.3666667 0.279374 13.3694444 0.278785 13.3722222 0.279374 13.3750000 0.279374 13.3777778 0.279669 13.3805556 0.279079 13.3833333 0.279079 13.3861111 0.278195 13.3888889 0.277901 13.3916667 0.277017 13.3944444 0.274954 13.3972222 0.273186 13.4000000 0.272007 13.4027778 0.270534 13.4055556 0.268177 13.4083333 0.266409 13.4111111 0.269945 13.4138889 0.275543 13.4166667 0.280258 13.4194444 0.284678 13.4222222 0.291160 13.4250000 0.299705 13.4277778 0.312081 13.4305556 0.327698 13.4333333 0.340074 13.4361111 0.348619 13.4388889 0.354512 13.4416667 0.357164 13.4444444 0.352155 13.4472222 0.340663 13.4500000 0.324457 13.4527778 0.306188 13.4555556 0.291160 13.4583333 0.279669 13.4611111 0.274365 13.4638889 0.272597 13.4666667 0.273186 13.4694444 0.274954 13.4722222 0.275543 13.4750000 0.276722 13.4777778 0.277901 13.4805556 0.278195 13.4833333 0.276722 13.4861111 0.276427 13.4888889 0.276427 13.4916667 0.275838 13.4944444 0.276427 13.4972222 0.276133 13.5000000 0.276427 13.5027778 0.276133 13.5055556 0.276722 13.5083333 0.277017 13.5111111 0.277606 13.5138889 0.277311 13.5166667 0.276133 13.5194444 0.275249 13.5222222 0.276133 13.5250000 0.276427 13.5277778 0.277017 13.5305556 0.277606 13.5333333 0.276722 13.5361111 0.276722 13.5388889 0.276427 13.5416667 0.277017 13.5444444 0.275838 13.5472222 0.276133 13.5500000 0.275838 13.5527778 0.275838 13.5555556 0.276722 13.5583333 0.277311 13.5611111 0.276722 13.5638889 0.276133 13.5666667 0.275249 13.5694444 0.274365 13.5722222 0.275543 13.5750000 0.276133 13.5777778 0.275838 13.5805556 0.276427 13.5833333 0.275838 13.5861111 0.275543 13.5888889 0.275838 13.5916667 0.276427 13.5944444 0.276133 13.5972222 0.277017 13.6000000 0.277017 13.6027778 0.276427 13.6055556 0.277017 13.6083333 0.277017 13.6111111 0.277017 13.6138889 0.276722 13.6166667 0.275249 13.6194444 0.275249 13.6222222 0.275543 13.6250000 0.275838 13.6277778 0.276722 13.6305556 0.276722 13.6333333 0.276427 13.6361111 0.275543 13.6388889 0.275543 13.6416667 0.276427 13.6444444 0.276427 13.6472222 0.277311 13.6500000 0.277017 13.6527778 0.275838 13.6555556 0.276722 13.6583333 0.277017 13.6611111 0.277606 13.6638889 0.277901 13.6666667 0.277017 13.6694444 0.276133 13.6722222 0.275249 13.6750000 0.275543 13.6777778 0.275543 13.6805556 0.275543 13.6833333 0.274365 13.6861111 0.272597 13.6888889 0.273186 13.6916667 0.272597 13.6944444 0.272891 13.6972222 0.273775 13.7000000 0.273186 13.7027778 0.272597 13.7055556 0.272007 13.7083333 0.273186 13.7111111 0.272891 13.7138889 0.273481 13.7166667 0.273186 13.7194444 0.272302 13.7222222 0.273186 13.7250000 0.274070 13.7277778 0.275249 13.7305556 0.275543 13.7333333 0.275249 13.7361111 0.275838 13.7438889 0.300000 13.9755556 0.300000 13.9805556 0.279374 13.9833333 0.278490 13.9861111 0.279079 13.9888889 0.279374 13.9916667 0.279963 13.9944444 0.279963 13.9972222 0.279079 14.0000000 0.279079 14.0027778 0.279374 14.0055556 0.279374 14.0083333 0.280258 14.0111111 0.279963 14.0138889 0.279963 14.0166667 0.280552 14.0194444 0.279374 14.0222222 0.281436 14.0250000 0.282320 14.0277778 0.282910 14.0305556 0.283794 14.0333333 0.283499 14.0361111 0.283204 14.0388889 0.283794 14.0416667 0.284088 14.0444444 0.284972 14.0472222 0.285856 14.0500000 0.285267 14.0527778 0.284972 14.0555556 0.285856 14.0583333 0.286740 14.0611111 0.286740 14.0638889 0.285856 14.0666667 0.284972 14.0694444 0.284678 14.0722222 0.283794 14.0750000 0.284678 14.0777778 0.285562 14.0805556 0.284972 14.0833333 0.284383 14.0861111 0.283499 14.0888889 0.284088 14.0916667 0.285267 14.0944444 0.286151 14.0972222 0.286446 14.1000000 0.285562 14.1027778 0.284088 14.1055556 0.283499 14.1083333 0.283499 14.1111111 0.282910 14.1138889 0.281436 14.1166667 0.280258 14.1194444 0.279079 14.1222222 0.279079 14.1250000 0.279079 14.1277778 0.278785 14.1305556 0.278785 14.1333333 0.277901 14.1361111 0.277606 14.1388889 0.278785 14.1416667 0.279079 14.1444444 0.279374 14.1472222 0.279669 14.1500000 0.278195 14.1527778 0.278195 14.1555556 0.279079 14.1583333 0.279079 14.1611111 0.279374 14.1638889 0.279669 14.1666667 0.279079 14.1694444 0.279079 14.1722222 0.278785 14.1750000 0.279079 14.1777778 0.279079 14.1805556 0.279079 14.1833333 0.278785 14.1861111 0.277901 14.1888889 0.278195 14.1916667 0.277017 14.1944444 0.274954 14.1972222 0.272597 14.2000000 0.271123 14.2027778 0.269061 14.2055556 0.266998 14.2083333 0.266998 14.2111111 0.270829 14.2138889 0.278785 14.2166667 0.287035 14.2194444 0.297348 14.2222222 0.311197 14.2250000 0.327993 14.2277778 0.342726 14.2305556 0.352744 14.2333333 0.352744 14.2361111 0.341842 14.2388889 0.320626 14.2416667 0.296759 14.2444444 0.279374 14.2472222 0.271713 14.2500000 0.271123 14.2527778 0.272597 14.2555556 0.275543 14.2583333 0.276133 14.2611111 0.276722 14.2638889 0.276133 14.2666667 0.275249 14.2694444 0.276722 14.2722222 0.275543 14.2750000 0.276427 14.2777778 0.277017 14.2805556 0.277311 14.2833333 0.276722 14.2861111 0.276133 14.2888889 0.276722 14.2916667 0.276427 14.2944444 0.277017 14.2972222 0.277017 14.3000000 0.276427 14.3027778 0.275543 14.3055556 0.276133 14.3083333 0.277017 14.3111111 0.277606 14.3138889 0.277606 14.3166667 0.276133 14.3194444 0.277017 14.3222222 0.276427 14.3250000 0.277017 14.3277778 0.277606 14.3305556 0.277606 14.3333333 0.276133 14.3361111 0.276427 14.3388889 0.275838 14.3416667 0.276427 14.3444444 0.276722 14.3472222 0.276427 14.3500000 0.276427 14.3527778 0.276133 14.3555556 0.277017 14.3583333 0.277606 14.3611111 0.277311 14.3638889 0.277311 14.3666667 0.277017 14.3694444 0.276133 14.3722222 0.276427 14.3750000 0.276427 14.3777778 0.277017 14.3805556 0.277017 14.3833333 0.275838 14.3861111 0.275838 14.3888889 0.276133 14.3916667 0.276427 14.3944444 0.275838 14.3972222 0.276133 14.4000000 0.275838 14.4027778 0.275543 14.4055556 0.275838 14.4083333 0.276133 14.4111111 0.276722 14.4138889 0.276133 14.4166667 0.276427 14.4194444 0.276427 14.4222222 0.276722 14.4250000 0.276133 14.4277778 0.277606 14.4305556 0.277311 14.4333333 0.277017 14.4361111 0.275838 14.4388889 0.276722 14.4416667 0.277017 14.4444444 0.277606 14.4472222 0.277311 14.4500000 0.276133 14.4527778 0.276133 14.4555556 0.276133 14.4583333 0.276427 14.4611111 0.275838 14.4638889 0.275838 14.4666667 0.275543 14.4694444 0.274365 14.4722222 0.274659 14.4750000 0.275543 14.4777778 0.275249 14.4805556 0.275249 14.4833333 0.274070 14.4861111 0.274070 14.4888889 0.274365 14.4916667 0.274365 14.4944444 0.274365 14.4972222 0.274659 14.5000000 0.273775 14.5027778 0.273775 14.5055556 0.275249 14.5083333 0.274954 14.5111111 0.275838 14.5138889 0.276133 14.5166667 0.276427 14.5194444 0.275838 14.5222222 0.277606 14.5250000 0.278195 14.5277778 0.279374 14.5355556 0.300000 14.7977778 0.300000 14.8027778 0.280847 14.8055556 0.281436 14.8083333 0.282320 14.8111111 0.282615 14.8138889 0.281731 14.8166667 0.281436 14.8194444 0.281142 14.8222222 0.281436 14.8250000 0.281731 14.8277778 0.282615 14.8305556 0.283204 14.8333333 0.284088 14.8361111 0.285267 14.8388889 0.285562 14.8416667 0.286446 14.8444444 0.287035 14.8472222 0.286740 14.8500000 0.286151 14.8527778 0.286446 14.8555556 0.287035 14.8583333 0.287919 14.8611111 0.288803 14.8638889 0.288803 14.8666667 0.288803 14.8694444 0.287919 14.8722222 0.287919 14.8750000 0.287919 14.8777778 0.287624 14.8805556 0.287330 14.8833333 0.286740 14.8861111 0.286446 14.8888889 0.286740 14.8916667 0.287035 14.8944444 0.287035 14.8972222 0.285856 14.9000000 0.285856 14.9027778 0.286446 14.9055556 0.287919 14.9083333 0.288508 14.9111111 0.288508 14.9138889 0.287035 14.9166667 0.285562 14.9194444 0.283794 14.9222222 0.284678 14.9250000 0.283794 14.9277778 0.283204 14.9305556 0.282320 14.9333333 0.282320 14.9361111 0.281731 14.9388889 0.281731 14.9416667 0.281142 14.9444444 0.281142 14.9472222 0.280847 14.9500000 0.280258 14.9527778 0.279669 14.9555556 0.280258 14.9583333 0.280258 14.9611111 0.280552 14.9638889 0.280258 14.9666667 0.279669 14.9694444 0.278785 14.9722222 0.279669 14.9750000 0.280258 14.9777778 0.279669 14.9805556 0.279669 14.9833333 0.279079 14.9861111 0.278785 14.9888889 0.279079 14.9916667 0.279963 14.9944444 0.279963 14.9972222 0.279374 15.0000000 0.279374 15.0027778 0.279079 15.0055556 0.279079 15.0083333 0.279079 15.0111111 0.278195 15.0138889 0.274954 15.0166667 0.272597 15.0194444 0.271713 15.0222222 0.270534 15.0250000 0.268766 15.0277778 0.268471 15.0305556 0.271418 15.0333333 0.276722 15.0361111 0.284972 15.0388889 0.294401 15.0416667 0.305599 15.0444444 0.320626 15.0472222 0.337127 15.0500000 0.349797 15.0527778 0.356280 15.0555556 0.357459 15.0583333 0.348619 15.0611111 0.328287 15.0638889 0.303241 15.0666667 0.284088 15.0694444 0.273186 15.0722222 0.271418 15.0750000 0.274070 15.0777778 0.276133 15.0805556 0.277901 15.0833333 0.277901 15.0861111 0.277017 15.0888889 0.277606 15.0916667 0.278785 15.0944444 0.279079 15.0972222 0.279669 15.1000000 0.278490 15.1027778 0.277901 15.1055556 0.278195 15.1083333 0.278195 15.1111111 0.279079 15.1138889 0.278195 15.1166667 0.277901 15.1194444 0.277606 15.1222222 0.277311 15.1250000 0.277606 15.1277778 0.277606 15.1305556 0.277606 15.1333333 0.277311 15.1361111 0.276722 15.1388889 0.276722 15.1416667 0.277017 15.1444444 0.277311 15.1472222 0.277606 15.1500000 0.277606 15.1527778 0.276722 15.1555556 0.277017 15.1583333 0.277606 15.1611111 0.278195 15.1638889 0.277901 15.1666667 0.277311 15.1694444 0.277606 15.1722222 0.277901 15.1750000 0.278490 15.1777778 0.278785 15.1805556 0.278490 15.1833333 0.278490 15.1861111 0.277311 15.1888889 0.278195 15.1916667 0.278490 15.1944444 0.279079 15.1972222 0.277311 15.2000000 0.276722 15.2027778 0.276722 15.2055556 0.277311 15.2083333 0.278195 15.2111111 0.277606 15.2138889 0.278195 15.2166667 0.277901 15.2194444 0.277017 15.2222222 0.277311 15.2250000 0.277606 15.2277778 0.278195 15.2305556 0.278195 15.2333333 0.277311 15.2361111 0.277311 15.2388889 0.277606 15.2416667 0.277311 15.2444444 0.278195 15.2472222 0.277901 15.2500000 0.277901 15.2527778 0.277606 15.2555556 0.277606 15.2583333 0.279079 15.2611111 0.278785 15.2638889 0.278490 15.2666667 0.278195 15.2694444 0.277606 15.2722222 0.278195 15.2750000 0.277901 15.2777778 0.278785 15.2805556 0.278195 15.2833333 0.277606 15.2861111 0.277311 15.2888889 0.277901 15.2916667 0.277901 15.2944444 0.278195 15.2972222 0.278195 15.3000000 0.277311 15.3027778 0.276427 15.3055556 0.276722 15.3083333 0.277311 15.3111111 0.276722 15.3138889 0.277606 15.3166667 0.276427 15.3194444 0.276427 15.3222222 0.276427 15.3250000 0.277017 15.3277778 0.277017 15.3305556 0.277311 15.3333333 0.276427 15.3361111 0.276427 15.3388889 0.277311 15.3416667 0.277606 15.3444444 0.277606 15.3472222 0.277311 15.3500000 0.277311 15.3577778 0.300000 15.6672222 0.300000 15.6722222 0.281142 15.6750000 0.282026 15.6777778 0.281731 15.6805556 0.282026 15.6833333 0.282615 15.6861111 0.281142 15.6888889 0.282026 15.6916667 0.282910 15.6944444 0.283204 15.6972222 0.283204 15.7000000 0.283204 15.7027778 0.283204 15.7055556 0.284383 15.7083333 0.285267 15.7111111 0.285267 15.7138889 0.285267 15.7166667 0.285267 15.7194444 0.285267 15.7222222 0.285267 15.7250000 0.286446 15.7277778 0.287330 15.7305556 0.286740 15.7333333 0.286740 15.7361111 0.286446 15.7388889 0.286446 15.7416667 0.286740 15.7444444 0.287330 15.7472222 0.287330 15.7500000 0.286446 15.7527778 0.285267 15.7555556 0.285856 15.7583333 0.286446 15.7611111 0.286446 15.7638889 0.285856 15.7666667 0.285267 15.7694444 0.284972 15.7722222 0.287035 15.7750000 0.288214 15.7777778 0.288214 15.7805556 0.286740 15.7833333 0.284383 15.7861111 0.282910 15.7888889 0.282910 15.7916667 0.282320 15.7944444 0.281731 15.7972222 0.280847 15.8000000 0.280258 15.8027778 0.279963 15.8055556 0.279374 15.8083333 0.279963 15.8111111 0.279963 15.8138889 0.279669 15.8166667 0.280552 15.8194444 0.279374 15.8222222 0.279669 15.8250000 0.279669 15.8277778 0.279963 15.8305556 0.279374 15.8333333 0.279079 15.8361111 0.279079 15.8388889 0.279079 15.8416667 0.279669 15.8444444 0.279963 15.8472222 0.279963 15.8500000 0.279079 15.8527778 0.278785 15.8555556 0.278785 15.8583333 0.279079 15.8611111 0.279669 15.8638889 0.279669 15.8666667 0.278785 15.8694444 0.278195 15.8722222 0.277901 15.8750000 0.278195 15.8777778 0.277606 15.8805556 0.275249 15.8833333 0.272597 15.8861111 0.271418 15.8888889 0.269650 15.8916667 0.267882 15.8944444 0.266114 15.8972222 0.267882 15.9000000 0.273481 15.9027778 0.280847 15.9055556 0.288508 15.9083333 0.297348 15.9111111 0.309724 15.9138889 0.325046 15.9166667 0.338600 15.9194444 0.347735 15.9222222 0.351565 15.9250000 0.348029 15.9277778 0.334770 15.9305556 0.312965 15.9333333 0.291160 15.9361111 0.277606 15.9388889 0.272302 15.9416667 0.272597 15.9444444 0.274954 15.9472222 0.277311 15.9500000 0.277901 15.9527778 0.276722 15.9555556 0.277311 15.9583333 0.277901 15.9611111 0.279079 15.9638889 0.278195 15.9666667 0.278785 15.9694444 0.278490 15.9722222 0.278195 15.9750000 0.278195 15.9777778 0.278785 15.9805556 0.278490 15.9833333 0.277901 15.9861111 0.277606 15.9888889 0.278195 15.9916667 0.278195 15.9944444 0.278195 15.9972222 0.277606 16.0000000 0.277311 16.0027778 0.276722 16.0055556 0.277017 16.0083333 0.277606 16.0111111 0.277901 16.0138889 0.277901 16.0166667 0.276722 16.0194444 0.276427 16.0222222 0.276722 16.0250000 0.278195 16.0277778 0.278195 16.0305556 0.278195 16.0333333 0.278490 16.0361111 0.277017 16.0388889 0.277311 16.0416667 0.277901 16.0444444 0.278785 16.0472222 0.277606 16.0500000 0.277017 16.0527778 0.277017 16.0555556 0.277311 16.0583333 0.277901 16.0611111 0.277901 16.0638889 0.277901 16.0666667 0.277606 16.0694444 0.277017 16.0722222 0.277606 16.0750000 0.278490 16.0777778 0.277606 16.0805556 0.277606 16.0833333 0.277311 16.0861111 0.277017 16.0888889 0.277017 16.0916667 0.277606 16.0944444 0.277606 16.0972222 0.277311 16.1000000 0.276722 16.1027778 0.276427 16.1055556 0.277311 16.1083333 0.277606 16.1111111 0.278785 16.1138889 0.278195 16.1166667 0.277901 16.1194444 0.278195 16.1222222 0.277311 16.1250000 0.278195 16.1277778 0.278490 16.1305556 0.278785 16.1333333 0.278490 16.1361111 0.277901 16.1388889 0.277606 16.1416667 0.278490 16.1444444 0.278195 16.1472222 0.278785 16.1500000 0.278195 16.1527778 0.276722 16.1555556 0.277311 16.1583333 0.277311 16.1611111 0.277017 16.1638889 0.277017 16.1666667 0.277017 16.1694444 0.275838 16.1722222 0.277017 16.1750000 0.277606 16.1777778 0.277017 16.1805556 0.277606 16.1833333 0.276722 16.1861111 0.276133 16.1888889 0.276133 16.1916667 0.276722 16.1944444 0.277017 16.1972222 0.277017 16.2000000 0.275838 16.2027778 0.275543 16.2055556 0.277017 16.2083333 0.277606 16.2111111 0.277017 16.2138889 0.277311 16.2166667 0.277017 16.2194444 0.277017 16.2272222 0.300000 16.4894444 0.300000 16.4944444 0.281436 16.4972222 0.281142 16.5000000 0.280847 16.5027778 0.280552 16.5055556 0.280552 16.5083333 0.281436 16.5111111 0.281731 16.5138889 0.282026 16.5166667 0.281731 16.5194444 0.281731 16.5222222 0.282320 16.5250000 0.283204 16.5277778 0.283794 16.5305556 0.284088 16.5333333 0.284088 16.5361111 0.283499 16.5388889 0.284383 16.5416667 0.284972 16.5444444 0.285267 16.5472222 0.285562 16.5500000 0.285267 16.5527778 0.285562 16.5555556 0.286740 16.5583333 0.287330 16.5611111 0.287035 16.5638889 0.287035 16.5666667 0.286446 16.5694444 0.286151 16.5722222 0.285856 16.5750000 0.285856 16.5777778 0.286446 16.5805556 0.286740 16.5833333 0.285856 16.5861111 0.284088 16.5888889 0.285267 16.5916667 0.284972 16.5944444 0.286151 16.5972222 0.286740 16.6000000 0.287330 16.6027778 0.285856 16.6055556 0.284678 16.6083333 0.283794 16.6111111 0.283204 16.6138889 0.281436 16.6166667 0.281142 16.6194444 0.279669 16.6222222 0.279374 16.6250000 0.279374 16.6277778 0.278785 16.6305556 0.278490 16.6333333 0.279079 16.6361111 0.278785 16.6388889 0.278785 16.6416667 0.278785 16.6444444 0.279374 16.6472222 0.279669 16.6500000 0.279079 16.6527778 0.277901 16.6555556 0.278490 16.6583333 0.279374 16.6611111 0.279669 16.6638889 0.279963 16.6666667 0.280258 16.6694444 0.279079 16.6722222 0.278490 16.6750000 0.279374 16.6777778 0.279669 16.6805556 0.279669 16.6833333 0.279079 16.6861111 0.278195 16.6888889 0.278195 16.6916667 0.278490 16.6944444 0.278785 16.6972222 0.277311 16.7000000 0.275543 16.7027778 0.273186 16.7055556 0.272597 16.7083333 0.272891 16.7111111 0.272007 16.7138889 0.270829 16.7166667 0.267293 16.7194444 0.265525 16.7222222 0.267587 16.7250000 0.272891 16.7277778 0.279669 16.7305556 0.287919 16.7333333 0.297643 16.7361111 0.311197 16.7388889 0.326814 16.7416667 0.340074 16.7444444 0.349503 16.7472222 0.351860 16.7500000 0.342726 16.7527778 0.323573 16.7555556 0.300000 16.7583333 0.283499 16.7611111 0.274365 16.7638889 0.269945 16.7666667 0.271418 16.7694444 0.272891 16.7722222 0.274659 16.7750000 0.276133 16.7777778 0.275838 16.7805556 0.275838 16.7833333 0.275543 16.7861111 0.276133 16.7888889 0.275543 16.7916667 0.276722 16.7944444 0.277017 16.7972222 0.276722 16.8000000 0.276133 16.8027778 0.275838 16.8055556 0.275838 16.8083333 0.276722 16.8111111 0.277017 16.8138889 0.276427 16.8166667 0.276427 16.8194444 0.276722 16.8222222 0.276427 16.8250000 0.277311 16.8277778 0.277311 16.8305556 0.276722 16.8333333 0.275838 16.8361111 0.275249 16.8388889 0.275838 16.8416667 0.276427 16.8444444 0.277017 16.8472222 0.275838 16.8500000 0.275543 16.8527778 0.274954 16.8555556 0.274954 16.8583333 0.276133 16.8611111 0.276427 16.8638889 0.274954 16.8666667 0.275543 16.8694444 0.275543 16.8722222 0.275838 16.8750000 0.276133 16.8777778 0.276427 16.8805556 0.275838 16.8833333 0.276133 16.8861111 0.275543 16.8888889 0.275838 16.8916667 0.276427 16.8944444 0.276722 16.8972222 0.276427 16.9000000 0.276133 16.9027778 0.276133 16.9055556 0.275543 16.9083333 0.276133 16.9111111 0.276427 16.9138889 0.276133 16.9166667 0.275838 16.9194444 0.275249 16.9222222 0.275543 16.9250000 0.276427 16.9277778 0.276722 16.9305556 0.276427 16.9333333 0.275543 16.9361111 0.275249 16.9388889 0.275838 16.9416667 0.276427 16.9444444 0.276722 16.9472222 0.276427 16.9500000 0.275543 16.9527778 0.275838 16.9555556 0.275543 16.9583333 0.275543 16.9611111 0.276133 16.9638889 0.275838 16.9666667 0.275249 16.9694444 0.274070 16.9722222 0.274659 16.9750000 0.274659 16.9777778 0.274954 16.9805556 0.274365 16.9833333 0.274365 16.9861111 0.274070 16.9888889 0.273481 16.9916667 0.273481 16.9944444 0.273481 16.9972222 0.272597 17.0000000 0.272302 17.0027778 0.271418 17.0055556 0.272597 17.0083333 0.273186 17.0111111 0.273481 17.0138889 0.273481 17.0166667 0.272302 17.0194444 0.271418 17.0222222 0.272891 17.0250000 0.273775 17.0277778 0.274365 17.0305556 0.274954 17.0333333 0.274659 17.0361111 0.274659 17.0388889 0.275543 17.0416667 0.277311 17.0494444 0.300000 17.2755556 0.300000 17.2805556 0.279963 17.2833333 0.279669 17.2861111 0.278785 17.2888889 0.279374 17.2916667 0.279669 17.2944444 0.280258 17.2972222 0.279669 17.3000000 0.279669 17.3027778 0.279079 17.3055556 0.279669 17.3083333 0.280258 17.3111111 0.280847 17.3138889 0.281142 17.3166667 0.282026 17.3194444 0.282026 17.3222222 0.282320 17.3250000 0.283204 17.3277778 0.283499 17.3305556 0.284383 17.3333333 0.283794 17.3361111 0.284088 17.3388889 0.285562 17.3416667 0.285856 17.3444444 0.286446 17.3472222 0.286151 17.3500000 0.286446 17.3527778 0.285562 17.3555556 0.285562 17.3583333 0.285856 17.3611111 0.285267 17.3638889 0.284972 17.3666667 0.284972 17.3694444 0.284088 17.3722222 0.284383 17.3750000 0.284383 17.3777778 0.284383 17.3805556 0.284972 17.3833333 0.285267 17.3861111 0.286151 17.3888889 0.286446 17.3916667 0.285267 17.3944444 0.284678 17.3972222 0.283499 17.4000000 0.282026 17.4027778 0.279963 17.4055556 0.280552 17.4083333 0.280258 17.4111111 0.280552 17.4138889 0.279669 17.4166667 0.279374 17.4194444 0.278785 17.4222222 0.278785 17.4250000 0.278785 17.4277778 0.278490 17.4305556 0.278490 17.4333333 0.279079 17.4361111 0.278490 17.4388889 0.278785 17.4416667 0.278785 17.4444444 0.278785 17.4472222 0.279079 17.4500000 0.277901 17.4527778 0.277901 17.4555556 0.278490 17.4583333 0.278785 17.4611111 0.278195 17.4638889 0.278785 17.4666667 0.277606 17.4694444 0.277017 17.4722222 0.277311 17.4750000 0.277311 17.4777778 0.278490 17.4805556 0.277901 17.4833333 0.277901 17.4861111 0.276427 17.4888889 0.276722 17.4916667 0.274659 17.4944444 0.272891 17.4972222 0.271713 17.5000000 0.269945 17.5027778 0.266409 17.5055556 0.265525 17.5083333 0.269650 17.5111111 0.277311 17.5138889 0.285856 17.5166667 0.294991 17.5194444 0.307366 17.5222222 0.323867 17.5250000 0.339779 17.5277778 0.350976 17.5305556 0.355101 17.5333333 0.349503 17.5361111 0.332707 17.5388889 0.308250 17.5416667 0.288214 17.5444444 0.276133 17.5472222 0.271418 17.5500000 0.271418 17.5527778 0.273481 17.5555556 0.277311 17.5583333 0.277311 17.5611111 0.277311 17.5638889 0.277017 17.5666667 0.277311 17.5694444 0.276722 17.5722222 0.277017 17.5750000 0.277311 17.5777778 0.277311 17.5805556 0.277017 17.5833333 0.276722 17.5861111 0.277017 17.5888889 0.277017 17.5916667 0.276722 17.5944444 0.277606 17.5972222 0.277311 17.6000000 0.277017 17.6027778 0.276133 17.6055556 0.276427 17.6083333 0.276722 17.6111111 0.277017 17.6138889 0.277017 17.6166667 0.277017 17.6194444 0.276133 17.6222222 0.277901 17.6250000 0.277017 17.6277778 0.277606 17.6305556 0.277017 17.6333333 0.277311 17.6361111 0.277017 17.6388889 0.277311 17.6416667 0.278195 17.6444444 0.278490 17.6472222 0.278490 17.6500000 0.277606 17.6527778 0.277017 17.6555556 0.277017 17.6583333 0.277311 17.6611111 0.277901 17.6638889 0.277606 17.6666667 0.277017 17.6694444 0.277017 17.6722222 0.276722 17.6750000 0.277901 17.6777778 0.277311 17.6805556 0.277311 17.6833333 0.276427 17.6861111 0.277017 17.6888889 0.277311 17.6916667 0.277311 17.6944444 0.277901 17.6972222 0.277606 17.7000000 0.276722 17.7027778 0.276133 17.7055556 0.277311 17.7083333 0.277606 17.7111111 0.277901 17.7138889 0.277606 17.7166667 0.277606 17.7194444 0.277017 17.7222222 0.277017 17.7250000 0.277606 17.7277778 0.279079 17.7305556 0.279079 17.7333333 0.278195 17.7361111 0.277311 17.7388889 0.277901 17.7416667 0.277311 17.7444444 0.277901 17.7472222 0.277017 17.7500000 0.277017 17.7527778 0.276427 17.7555556 0.276427 17.7583333 0.277311 17.7611111 0.277017 17.7638889 0.277017 17.7666667 0.276133 17.7694444 0.275543 17.7722222 0.276133 17.7750000 0.276133 17.7777778 0.276133 17.7805556 0.275838 17.7833333 0.274954 17.7861111 0.274659 17.7888889 0.275249 17.7916667 0.276133 17.7944444 0.275838 17.7972222 0.275838 17.8000000 0.275838 17.8027778 0.275838 17.8055556 0.276427 17.8083333 0.277311 17.8111111 0.278195 17.8138889 0.277901 17.8166667 0.278785 17.8194444 0.278490 17.8222222 0.279079 17.8250000 0.280258 17.8277778 0.281436 17.8355556 0.300000 18.5305556 0.300000)
Vbt bt 0 PWL(0.0000000 0.000000 1.7934444 0.000000 1.7944444 0.900000 1.7949444 0.900000 1.7959444 0.000000 2.6101111 0.000000 2.6111111 0.900000 2.6116111 0.900000 2.6126111 0.000000 3.2628889 0.000000 3.2638889 0.900000 3.2643889 0.900000 3.2653889 0.000000 4.2573333 0.000000 4.2583333 0.900000 4.2588333 0.900000 4.2598333 0.000000 5.1017778 0.000000 5.1027778 0.900000 5.1032778 0.900000 5.1042778 0.000000 5.9128889 0.000000 5.9138889 0.900000 5.9143889 0.900000 5.9153889 0.000000 6.7017778 0.000000 6.7027778 0.900000 6.7032778 0.900000 6.7042778 0.000000 7.4740000 0.000000 7.4750000 0.900000 7.4755000 0.900000 7.4765000 0.000000 8.3128889 0.000000 8.3138889 0.900000 8.3143889 0.900000 8.3153889 0.000000 9.1684444 0.000000 9.1694444 0.900000 9.1699444 0.900000 9.1709444 0.000000 9.9906667 0.000000 9.9916667 0.900000 9.9921667 0.900000 9.9931667 0.000000 10.8184444 0.000000 10.8194444 0.900000 10.8199444 0.900000 10.8209444 0.000000 11.6406667 0.000000 11.6416667 0.900000 11.6421667 0.900000 11.6431667 0.000000 12.4351111 0.000000 12.4361111 0.900000 12.4366111 0.900000 12.4376111 0.000000 13.2323333 0.000000 13.2333333 0.900000 13.2338333 0.900000 13.2348333 0.000000 14.0240000 0.000000 14.0250000 0.900000 14.0255000 0.900000 14.0265000 0.000000 14.8462222 0.000000 14.8472222 0.900000 14.8477222 0.900000 14.8487222 0.000000 15.7156667 0.000000 15.7166667 0.900000 15.7171667 0.900000 15.7181667 0.000000 16.5378889 0.000000 16.5388889 0.900000 16.5393889 0.900000 16.5403889 0.000000 17.3240000 0.000000 17.3250000 0.900000 17.3255000 0.900000 17.3265000 0.000000 18.5305556 0.000000)
Vpt pt 0 PWL(0.0000000 0.000000 1.8684444 0.000000 1.8694444 0.900000 1.8699444 0.900000 1.8709444 0.000000 2.6851111 0.000000 2.6861111 0.900000 2.6866111 0.900000 2.6876111 0.000000 3.3378889 0.000000 3.3388889 0.900000 3.3393889 0.900000 3.3403889 0.000000 4.3323333 0.000000 4.3333333 0.900000 4.3338333 0.900000 4.3348333 0.000000 5.1767778 0.000000 5.1777778 0.900000 5.1782778 0.900000 5.1792778 0.000000 5.9878889 0.000000 5.9888889 0.900000 5.9893889 0.900000 5.9903889 0.000000 6.7767778 0.000000 6.7777778 0.900000 6.7782778 0.900000 6.7792778 0.000000 7.5490000 0.000000 7.5500000 0.900000 7.5505000 0.900000 7.5515000 0.000000 8.3878889 0.000000 8.3888889 0.900000 8.3893889 0.900000 8.3903889 0.000000 9.2434444 0.000000 9.2444444 0.900000 9.2449444 0.900000 9.2459444 0.000000 10.0656667 0.000000 10.0666667 0.900000 10.0671667 0.900000 10.0681667 0.000000 10.8934444 0.000000 10.8944444 0.900000 10.8949444 0.900000 10.8959444 0.000000 11.7156667 0.000000 11.7166667 0.900000 11.7171667 0.900000 11.7181667 0.000000 12.5101111 0.000000 12.5111111 0.900000 12.5116111 0.900000 12.5126111 0.000000 13.3073333 0.000000 13.3083333 0.900000 13.3088333 0.900000 13.3098333 0.000000 14.0990000 0.000000 14.1000000 0.900000 14.1005000 0.900000 14.1015000 0.000000 14.9212222 0.000000 14.9222222 0.900000 14.9227222 0.900000 14.9237222 0.000000 15.7906667 0.000000 15.7916667 0.900000 15.7921667 0.900000 15.7931667 0.000000 16.6128889 0.000000 16.6138889 0.900000 16.6143889 0.900000 16.6153889 0.000000 17.3990000 0.000000 17.4000000 0.900000 17.4005000 0.900000 17.4015000 0.000000 18.5305556 0.000000)

* S&H for baseline (R - 206ms)
XMsb ecg_in bt shb vss sky130_fd_pr__nfet_01v8 L=0.5 W=2 nf=1
XCsb shb vss sky130_fd_pr__cap_mim_m3_1 W=32 L=32

* S&H for P-wave peak (R - 131ms)
XMsp ecg_in pt shp vss sky130_fd_pr__nfet_01v8 L=0.5 W=2 nf=1
XCsp shp vss sky130_fd_pr__cap_mim_m3_1 W=32 L=32

* Diff pair: signed (shp - shb)
XMd_tail dtail vbias vss vss sky130_fd_pr__nfet_01v8 L=8 W=0.42 nf=1
XMd1 dnet shb dtail vss sky130_fd_pr__nfet_01v8 L=1 W=8 nf=1
XMd2 pw_out shp dtail vss sky130_fd_pr__nfet_01v8 L=1 W=8 nf=1
XMd3 dnet dnet vdd vdd sky130_fd_pr__pfet_01v8 L=1 W=4 nf=1
XMd4 pw_out dnet vdd vdd sky130_fd_pr__pfet_01v8 L=1 W=4 nf=1

.tran 0.5m 18.5306

.meas tran pw_b0 FIND V(pw_out) AT=1.8899444
.meas tran shb_b0 FIND V(shb) AT=1.8899444
.meas tran shp_b0 FIND V(shp) AT=1.8899444
.meas tran pw_b1 FIND V(pw_out) AT=2.7066111
.meas tran shb_b1 FIND V(shb) AT=2.7066111
.meas tran shp_b1 FIND V(shp) AT=2.7066111
.meas tran pw_b2 FIND V(pw_out) AT=3.3593889
.meas tran shb_b2 FIND V(shb) AT=3.3593889
.meas tran shp_b2 FIND V(shp) AT=3.3593889
.meas tran pw_b3 FIND V(pw_out) AT=4.3538333
.meas tran shb_b3 FIND V(shb) AT=4.3538333
.meas tran shp_b3 FIND V(shp) AT=4.3538333
.meas tran pw_b4 FIND V(pw_out) AT=5.1982778
.meas tran shb_b4 FIND V(shb) AT=5.1982778
.meas tran shp_b4 FIND V(shp) AT=5.1982778
.meas tran pw_b5 FIND V(pw_out) AT=6.0093889
.meas tran shb_b5 FIND V(shb) AT=6.0093889
.meas tran shp_b5 FIND V(shp) AT=6.0093889
.meas tran pw_b6 FIND V(pw_out) AT=6.7982778
.meas tran shb_b6 FIND V(shb) AT=6.7982778
.meas tran shp_b6 FIND V(shp) AT=6.7982778
.meas tran pw_b7 FIND V(pw_out) AT=7.5705000
.meas tran shb_b7 FIND V(shb) AT=7.5705000
.meas tran shp_b7 FIND V(shp) AT=7.5705000
.meas tran pw_b8 FIND V(pw_out) AT=8.4093889
.meas tran shb_b8 FIND V(shb) AT=8.4093889
.meas tran shp_b8 FIND V(shp) AT=8.4093889
.meas tran pw_b9 FIND V(pw_out) AT=9.2649444
.meas tran shb_b9 FIND V(shb) AT=9.2649444
.meas tran shp_b9 FIND V(shp) AT=9.2649444
.meas tran pw_b10 FIND V(pw_out) AT=10.0871667
.meas tran shb_b10 FIND V(shb) AT=10.0871667
.meas tran shp_b10 FIND V(shp) AT=10.0871667
.meas tran pw_b11 FIND V(pw_out) AT=10.9149444
.meas tran shb_b11 FIND V(shb) AT=10.9149444
.meas tran shp_b11 FIND V(shp) AT=10.9149444
.meas tran pw_b12 FIND V(pw_out) AT=11.7371667
.meas tran shb_b12 FIND V(shb) AT=11.7371667
.meas tran shp_b12 FIND V(shp) AT=11.7371667
.meas tran pw_b13 FIND V(pw_out) AT=12.5316111
.meas tran shb_b13 FIND V(shb) AT=12.5316111
.meas tran shp_b13 FIND V(shp) AT=12.5316111
.meas tran pw_b14 FIND V(pw_out) AT=13.3288333
.meas tran shb_b14 FIND V(shb) AT=13.3288333
.meas tran shp_b14 FIND V(shp) AT=13.3288333
.meas tran pw_b15 FIND V(pw_out) AT=14.1205000
.meas tran shb_b15 FIND V(shb) AT=14.1205000
.meas tran shp_b15 FIND V(shp) AT=14.1205000
.meas tran pw_b16 FIND V(pw_out) AT=14.9427222
.meas tran shb_b16 FIND V(shb) AT=14.9427222
.meas tran shp_b16 FIND V(shp) AT=14.9427222
.meas tran pw_b17 FIND V(pw_out) AT=15.8121667
.meas tran shb_b17 FIND V(shb) AT=15.8121667
.meas tran shp_b17 FIND V(shp) AT=15.8121667
.meas tran pw_b18 FIND V(pw_out) AT=16.6343889
.meas tran shb_b18 FIND V(shb) AT=16.6343889
.meas tran shp_b18 FIND V(shp) AT=16.6343889
.meas tran pw_b19 FIND V(pw_out) AT=17.4205000
.meas tran shb_b19 FIND V(shb) AT=17.4205000
.meas tran shp_b19 FIND V(shp) AT=17.4205000

.end
