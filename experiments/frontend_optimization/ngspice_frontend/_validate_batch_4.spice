* ANALOG vs DIGITAL VALIDATION - Batch 4
* MIT-BIH record, full frontend, SKY130 tt 27C

.title validate_batch_4

.lib "sky130_minimal.lib.spice" tt
.option scale=1.0u
.option method=gear
.option gmin=1e-15
.option abstol=1e-15
.option reltol=0.005
.temp 27

.include "ota_5t_subthreshold.spice"
.include "inverter.spice"
.include "resistor_div.spice"
.include "otac_lpf.spice"
.include "otac_hpf.spice"
.include "otac_bpf.spice"
.include "rectifier.spice"
.include "comparator.spice"
.include "rr_timing.spice"
.include "beat_instability.spice"
.include "pwave_energy.spice"
.include "qrs_width.spice"
.include "slope_ratio.spice"
.include "qrs_symmetry.spice"
.include "sh_channel.spice"
.include "sh_bank.spice"

Vdd vdd 0 0.9
Vss vss 0 0
Xvref_gen vdd vss vref resistor_div
Vbias_src vbias 0 0.35

Vecg0 ecg_raw_L0 0 PWL(
+ 0.000000e+00 8.723284e-02
+ 1.111111e-02 9.000000e-02
+ 2.222222e-02 8.584926e-02
+ 3.333333e-02 8.861642e-02
+ 4.444444e-02 9.691791e-02
+ 5.555556e-02 9.415074e-02
+ 6.666667e-02 9.553433e-02
+ 7.777778e-02 1.010687e-01
+ 8.888889e-02 9.553433e-02
+ 1.000000e-01 9.415074e-02
+ 1.111111e-01 1.052194e-01
+ 1.222222e-01 1.052194e-01
+ 1.333333e-01 1.093701e-01
+ 1.444444e-01 1.287403e-01
+ 1.555556e-01 1.273567e-01
+ 1.666667e-01 1.218224e-01
+ 1.777778e-01 1.315074e-01
+ 1.888889e-01 1.121373e-01
+ 2.000000e-01 1.079866e-01
+ 2.111111e-01 1.190552e-01
+ 2.222222e-01 1.121373e-01
+ 2.333333e-01 1.149045e-01
+ 2.444444e-01 1.273567e-01
+ 2.555556e-01 1.245895e-01
+ 2.666667e-01 9.691791e-02
+ 2.777778e-01 1.245895e-01
+ 2.888889e-01 4.663342e-01
+ 3.000000e-01 8.177639e-01
+ 3.111111e-01 3.736342e-01
+ 3.222222e-01 7.062986e-02
+ 3.333333e-01 7.754777e-02
+ 3.444444e-01 1.162880e-01
+ 3.555556e-01 1.411925e-01
+ 3.666667e-01 1.411925e-01
+ 3.777778e-01 1.536447e-01
+ 3.888889e-01 1.494940e-01
+ 4.000000e-01 1.494940e-01
+ 4.111111e-01 1.591791e-01
+ 4.222222e-01 1.605627e-01
+ 4.333333e-01 1.605627e-01
+ 4.444444e-01 1.688641e-01
+ 4.555556e-01 1.674806e-01
+ 4.666667e-01 1.730149e-01
+ 4.777778e-01 1.840835e-01
+ 4.888889e-01 1.813164e-01
+ 5.000000e-01 1.896179e-01
+ 5.111111e-01 2.006865e-01
+ 5.222222e-01 2.020701e-01
+ 5.333333e-01 2.117552e-01
+ 5.444444e-01 2.338925e-01
+ 5.555556e-01 2.435775e-01
+ 5.666667e-01 2.615641e-01
+ 5.777778e-01 2.920029e-01
+ 5.888889e-01 3.155238e-01
+ 6.000000e-01 3.459626e-01
+ 6.111111e-01 3.805521e-01
+ 6.222222e-01 4.054566e-01
+ 6.333333e-01 4.358954e-01
+ 6.444444e-01 4.635670e-01
+ 6.555556e-01 4.524984e-01
+ 6.666667e-01 4.137581e-01
+ 6.777778e-01 3.584148e-01
+ 6.888889e-01 2.795507e-01
+ 7.000000e-01 2.214402e-01
+ 7.111111e-01 1.799328e-01
+ 7.222222e-01 1.508776e-01
+ 7.333333e-01 1.370418e-01
+ 7.444444e-01 1.342746e-01
+ 7.555556e-01 1.204388e-01
+ 7.666667e-01 1.176716e-01
+ 7.777778e-01 1.232060e-01
+ 7.888889e-01 1.162880e-01
+ 8.000000e-01 1.162880e-01
+ 8.111111e-01 1.218224e-01
+ 8.222222e-01 1.218224e-01
+ 8.333333e-01 1.232060e-01
+ 8.444444e-01 1.273567e-01
+ 8.555556e-01 1.232060e-01
+ 8.666667e-01 1.259731e-01
+ 8.777778e-01 1.287403e-01
+ 8.888889e-01 1.204388e-01
+ 9.000000e-01 1.218224e-01
+ 9.111111e-01 1.287403e-01
+ 9.222222e-01 1.218224e-01
+ 9.333333e-01 1.176716e-01
+ 9.444444e-01 1.232060e-01
+ 9.555556e-01 1.190552e-01
+ 9.666667e-01 1.176716e-01
+ 9.777778e-01 1.218224e-01
+ 9.888889e-01 1.232060e-01
+ 1.000000e+00 1.176716e-01
+ 1.011111e+00 1.218224e-01
+ 1.022222e+00 1.204388e-01
+ 1.033333e+00 1.204388e-01
+ 1.044444e+00 1.287403e-01
+ 1.055556e+00 1.232060e-01
+ 1.066667e+00 1.232060e-01
+ 1.077778e+00 1.301239e-01
+ 1.088889e+00 1.245895e-01
+ 1.100000e+00 1.259731e-01
+ 1.111111e+00 1.328910e-01
+ 1.122222e+00 1.259731e-01
+ 1.133333e+00 1.273567e-01
+ 1.144444e+00 1.356582e-01
+ 1.155556e+00 1.342746e-01
+ 1.166667e+00 1.315074e-01
+ 1.177778e+00 1.398089e-01
+ 1.188889e+00 1.342746e-01
+ 1.200000e+00 1.370418e-01
+ 1.211111e+00 1.425761e-01
+ 1.222222e+00 1.398089e-01
+ 1.233333e+00 1.411925e-01
+ 1.244444e+00 1.425761e-01
+ 1.255556e+00 1.425761e-01
+ 1.266667e+00 1.439597e-01
+ 1.277778e+00 1.564119e-01
+ 1.288889e+00 1.605627e-01
+ 1.300000e+00 1.591791e-01
+ 1.311111e+00 1.771656e-01
+ 1.322222e+00 1.660970e-01
+ 1.333333e+00 1.633298e-01
+ 1.344444e+00 1.605627e-01
+ 1.355556e+00 1.508776e-01
+ 1.366667e+00 1.508776e-01
+ 1.377778e+00 1.550283e-01
+ 1.388889e+00 1.508776e-01
+ 1.400000e+00 1.591791e-01
+ 1.411111e+00 1.660970e-01
+ 1.422222e+00 1.522612e-01
+ 1.433333e+00 1.301239e-01
+ 1.444444e+00 3.335103e-01
+ 1.455556e+00 7.942430e-01
+ 1.466667e+00 5.438147e-01
+ 1.477778e+00 8.446567e-02
+ 1.488889e+00 1.121373e-01
+ 1.500000e+00 1.245895e-01
+ 1.511111e+00 1.771656e-01
+ 1.522222e+00 1.771656e-01
+ 1.533333e+00 1.840835e-01
+ 1.544444e+00 1.937686e-01
+ 1.555556e+00 1.910014e-01
+ 1.566667e+00 1.951522e-01
+ 1.577778e+00 2.048373e-01
+ 1.588889e+00 2.020701e-01
+ 1.600000e+00 2.048373e-01
+ 1.611111e+00 2.172895e-01
+ 1.622222e+00 2.117552e-01
+ 1.633333e+00 2.131388e-01
+ 1.644444e+00 2.283581e-01
+ 1.655556e+00 2.297417e-01
+ 1.666667e+00 2.380432e-01
+ 1.677778e+00 2.532626e-01
+ 1.688889e+00 2.615641e-01
+ 1.700000e+00 2.726328e-01
+ 1.711111e+00 2.975372e-01
+ 1.722222e+00 3.141402e-01
+ 1.733333e+00 3.404283e-01
+ 1.744444e+00 3.777850e-01
+ 1.755556e+00 4.040730e-01
+ 1.766667e+00 4.331282e-01
+ 1.777778e+00 4.677177e-01
+ 1.788889e+00 4.898551e-01
+ 1.800000e+00 4.981565e-01
+ 1.811111e+00 4.857043e-01
+ 1.822222e+00 4.234431e-01
+ 1.833333e+00 3.528805e-01
+ 1.844444e+00 2.864686e-01
+ 1.855556e+00 2.269746e-01
+ 1.866667e+00 1.979194e-01
+ 1.877778e+00 1.854671e-01
+ 1.888889e+00 1.716313e-01
+ 1.900000e+00 1.647134e-01
+ 1.911111e+00 1.674806e-01
+ 1.922222e+00 1.577955e-01
+ 1.933333e+00 1.619462e-01
+ 1.944444e+00 1.674806e-01
+ 1.955556e+00 1.647134e-01
+ 1.966667e+00 1.647134e-01
+ 1.977778e+00 1.702477e-01
+ 1.988889e+00 1.688641e-01
+ 2.000000e+00 1.674806e-01
+ 2.011111e+00 1.757821e-01
+ 2.022222e+00 1.688641e-01
+ 2.033333e+00 1.688641e-01
+ 2.044444e+00 1.730149e-01
+ 2.055556e+00 1.647134e-01
+ 2.066667e+00 1.688641e-01
+ 2.077778e+00 1.688641e-01
+ 2.088889e+00 1.591791e-01
+ 2.100000e+00 1.605627e-01
+ 2.111111e+00 1.647134e-01
+ 2.122222e+00 1.633298e-01
+ 2.133333e+00 1.605627e-01
+ 2.144444e+00 1.688641e-01
+ 2.155556e+00 1.591791e-01
+ 2.166667e+00 1.647134e-01
+ 2.177778e+00 1.702477e-01
+ 2.188889e+00 1.605627e-01
+ 2.200000e+00 1.591791e-01
+ 2.211111e+00 1.674806e-01
+ 2.222222e+00 1.674806e-01
+ 2.233333e+00 1.660970e-01
+ 2.244444e+00 1.688641e-01
+ 2.255556e+00 1.674806e-01
+ 2.266667e+00 1.702477e-01
+ 2.277778e+00 1.730149e-01
+ 2.288889e+00 1.799328e-01
+ 2.300000e+00 1.840835e-01
+ 2.311111e+00 1.965358e-01
+ 2.322222e+00 1.979194e-01
+ 2.333333e+00 1.951522e-01
+ 2.344444e+00 1.937686e-01
+ 2.355556e+00 1.785492e-01
+ 2.366667e+00 1.702477e-01
+ 2.377778e+00 1.785492e-01
+ 2.388889e+00 1.743985e-01
+ 2.400000e+00 1.757821e-01
+ 2.411111e+00 1.854671e-01
+ 2.422222e+00 1.854671e-01
+ 2.433333e+00 1.564119e-01
+ 2.444444e+00 1.910014e-01
+ 2.455556e+00 6.392819e-01
+ 2.466667e+00 8.136131e-01
+ 2.477778e+00 1.328910e-01
+ 2.488889e+00 1.384254e-01
+ 2.500000e+00 1.494940e-01
+ 2.511111e+00 1.965358e-01
+ 2.522222e+00 1.951522e-01
+ 2.533333e+00 1.951522e-01
+ 2.544444e+00 2.062208e-01
+ 2.555556e+00 2.076044e-01
+ 2.566667e+00 2.048373e-01
+ 2.577778e+00 2.172895e-01
+ 2.588889e+00 2.131388e-01
+ 2.600000e+00 2.172895e-01
+ 2.611111e+00 2.255910e-01
+ 2.622222e+00 2.269746e-01
+ 2.633333e+00 2.380432e-01
+ 2.644444e+00 2.491119e-01
+ 2.655556e+00 2.546462e-01
+ 2.666667e+00 2.726328e-01
+ 2.677778e+00 2.947701e-01
+ 2.688889e+00 3.127566e-01
+ 2.700000e+00 3.376611e-01
+ 2.711111e+00 3.736342e-01
+ 2.722222e+00 4.040730e-01
+ 2.733333e+00 4.345118e-01
+ 2.744444e+00 4.746357e-01
+ 2.755556e+00 4.981565e-01
+ 2.766667e+00 5.078416e-01
+ 2.777778e+00 4.912386e-01
+ 2.788889e+00 4.220596e-01
+ 2.800000e+00 3.501133e-01
+ 2.811111e+00 2.823178e-01
+ 2.822222e+00 2.269746e-01
+ 2.833333e+00 1.923850e-01
+ 2.844444e+00 1.868507e-01
+ 2.855556e+00 1.660970e-01
+ 2.866667e+00 1.605627e-01
+ 2.877778e+00 1.633298e-01
+ 2.888889e+00 1.605627e-01
+ 2.900000e+00 1.577955e-01
+ 2.911111e+00 1.619462e-01
+ 2.922222e+00 1.591791e-01
+ 2.933333e+00 1.605627e-01
+ 2.944444e+00 1.633298e-01
+ 2.955556e+00 1.619462e-01
+ 2.966667e+00 1.605627e-01
+ 2.977778e+00 1.660970e-01
+ 2.988889e+00 1.605627e-01
+ 3.000000e+00 1.564119e-01
+ 3.011111e+00 1.605627e-01
+ 3.022222e+00 1.564119e-01
+ 3.033333e+00 1.481104e-01
+ 3.044444e+00 1.550283e-01
+ 3.055556e+00 1.494940e-01
+ 3.066667e+00 1.439597e-01
+ 3.077778e+00 1.522612e-01
+ 3.088889e+00 1.425761e-01
+ 3.100000e+00 1.425761e-01
+ 3.111111e+00 1.467268e-01
+ 3.122222e+00 1.411925e-01
+ 3.133333e+00 1.398089e-01
+ 3.144444e+00 1.425761e-01
+ 3.155556e+00 1.411925e-01
+ 3.166667e+00 1.398089e-01
+ 3.177778e+00 1.411925e-01
+ 3.188889e+00 1.328910e-01
+ 3.200000e+00 1.370418e-01
+ 3.211111e+00 1.439597e-01
+ 3.222222e+00 1.370418e-01
+ 3.233333e+00 1.342746e-01
+ 3.244444e+00 1.370418e-01
+ 3.255556e+00 1.328910e-01
+ 3.266667e+00 1.315074e-01
+ 3.277778e+00 1.411925e-01
+ 3.288889e+00 1.342746e-01
+ 3.300000e+00 1.342746e-01
+ 3.311111e+00 1.384254e-01
+ 3.322222e+00 1.301239e-01
+ 3.333333e+00 1.315074e-01
+ 3.344444e+00 1.315074e-01
+ 3.355556e+00 1.370418e-01
+ 3.366667e+00 1.425761e-01
+ 3.377778e+00 1.494940e-01
+ 3.388889e+00 1.494940e-01
+ 3.400000e+00 1.481104e-01
+ 3.411111e+00 1.411925e-01
+ 3.422222e+00 1.273567e-01
+ 3.433333e+00 1.273567e-01
+ 3.444444e+00 1.356582e-01
+ 3.455556e+00 1.273567e-01
+ 3.466667e+00 1.301239e-01
+ 3.477778e+00 1.384254e-01
+ 3.488889e+00 9.968507e-02
+ 3.500000e+00 2.518790e-01
+ 3.511111e+00 7.638042e-01
+ 3.522222e+00 5.784043e-01
+ 3.533333e+00 5.000000e-02
+ 3.544444e+00 8.446567e-02
+ 3.555556e+00 1.107537e-01
+ 3.566667e+00 1.328910e-01
+ 3.577778e+00 1.370418e-01
+ 3.588889e+00 1.370418e-01
+ 3.600000e+00 1.370418e-01
+ 3.611111e+00 1.411925e-01
+ 3.622222e+00 1.411925e-01
+ 3.633333e+00 1.411925e-01
+ 3.644444e+00 1.522612e-01
+ 3.655556e+00 1.494940e-01
+ 3.666667e+00 1.481104e-01
+ 3.677778e+00 1.591791e-01
+ 3.688889e+00 1.633298e-01
+ 3.700000e+00 1.647134e-01
+ 3.711111e+00 1.730149e-01
+ 3.722222e+00 1.799328e-01
+ 3.733333e+00 1.896179e-01
+ 3.744444e+00 2.089880e-01
+ 3.755556e+00 2.228238e-01
+ 3.766667e+00 2.380432e-01
+ 3.777778e+00 2.684820e-01
+ 3.788889e+00 2.933865e-01
+ 3.800000e+00 3.293596e-01
+ 3.811111e+00 3.653327e-01
+ 3.822222e+00 3.943879e-01
+ 3.833333e+00 4.179088e-01
+ 3.844444e+00 4.345118e-01
+ 3.855556e+00 4.013058e-01
+ 3.866667e+00 3.335103e-01
+ 3.877778e+00 2.684820e-01
+ 3.888889e+00 1.951522e-01
+ 3.900000e+00 1.481104e-01
+ 3.911111e+00 1.301239e-01
+ 3.922222e+00 1.149045e-01
+ 3.933333e+00 1.052194e-01
+ 3.944444e+00 1.024522e-01
+ 3.955556e+00 1.010687e-01
+ 3.966667e+00 9.415074e-02
+ 3.977778e+00 9.691791e-02
+ 3.988889e+00 9.830149e-02
+ 4.000000e+00 9.691791e-02
+ 4.011111e+00 1.024522e-01
+ 4.022222e+00 9.968507e-02
+ 4.033333e+00 9.691791e-02
+ 4.044444e+00 1.066030e-01
+ 4.055556e+00 9.968507e-02
+ 4.066667e+00 1.024522e-01
+ 4.077778e+00 1.010687e-01
+ 4.088889e+00 9.830149e-02
+ 4.100000e+00 9.276716e-02
+ 4.111111e+00 1.010687e-01
+ 4.122222e+00 9.415074e-02
+ 4.133333e+00 9.138358e-02
+ 4.144444e+00 9.691791e-02
+ 4.155556e+00 9.138358e-02
+ 4.166667e+00 9.138358e-02
+ 4.177778e+00 9.691791e-02
+ 4.188889e+00 9.415074e-02
+ 4.200000e+00 9.553433e-02
+ 4.211111e+00 1.010687e-01
+ 4.222222e+00 9.415074e-02
+ 4.233333e+00 9.553433e-02
+ 4.244444e+00 9.830149e-02
+ 4.255556e+00 9.830149e-02
+ 4.266667e+00 9.553433e-02
+ 4.277778e+00 1.024522e-01
+ 4.288889e+00 9.415074e-02
+ 4.300000e+00 9.830149e-02
+ 4.311111e+00 1.066030e-01
+ 4.322222e+00 1.010687e-01
+ 4.333333e+00 9.968507e-02
+ 4.344444e+00 1.093701e-01
+ 4.355556e+00 1.066030e-01
+ 4.366667e+00 1.052194e-01
+ 4.377778e+00 1.149045e-01
+ 4.388889e+00 1.079866e-01
+ 4.400000e+00 1.107537e-01
+ 4.411111e+00 1.135209e-01
+ 4.422222e+00 1.149045e-01
+ 4.433333e+00 1.107537e-01
+ 4.444444e+00 1.245895e-01
+ 4.455556e+00 1.273567e-01
+ 4.466667e+00 1.342746e-01
+ 4.477778e+00 1.439597e-01
+ 4.488889e+00 1.342746e-01
+ 4.500000e+00 1.384254e-01
+ 4.511111e+00 1.328910e-01
+ 4.522222e+00 1.301239e-01
+ 4.533333e+00 1.273567e-01
+ 4.544444e+00 1.356582e-01
+ 4.555556e+00 1.342746e-01
+ 4.566667e+00 1.411925e-01
+ 4.577778e+00 1.356582e-01
+ 4.588889e+00 1.107537e-01
+ 4.600000e+00 3.584148e-01
+ 4.611111e+00 8.232982e-01
+ 4.622222e+00 4.926222e-01
+ 4.633333e+00 7.339702e-02
+ 4.644444e+00 9.830149e-02
+ 4.655556e+00 1.273567e-01
+ 4.666667e+00 1.536447e-01
+ 4.677778e+00 1.660970e-01
+ 4.688889e+00 1.605627e-01
+ 4.700000e+00 1.660970e-01
+ 4.711111e+00 1.730149e-01
+ 4.722222e+00 1.688641e-01
+ 4.733333e+00 1.757821e-01
+ 4.744444e+00 1.799328e-01
+ 4.755556e+00 1.813164e-01
+ 4.766667e+00 1.840835e-01
+ 4.777778e+00 1.923850e-01
+ 4.788889e+00 1.979194e-01
+ 4.800000e+00 2.006865e-01
+ 4.811111e+00 2.145223e-01
+ 4.822222e+00 2.159059e-01
+ 4.833333e+00 2.255910e-01
+ 4.844444e+00 2.421940e-01
+ 4.855556e+00 2.518790e-01
+ 4.866667e+00 2.657149e-01
+ 4.877778e+00 2.961536e-01
+ 4.888889e+00 3.155238e-01
+ 4.900000e+00 3.445790e-01
+ 4.911111e+00 3.860864e-01
+ 4.922222e+00 4.151417e-01
+ 4.933333e+00 4.483476e-01
+ 4.944444e+00 4.787864e-01
+ 4.955556e+00 4.732521e-01
+ 4.966667e+00 4.372790e-01
+ 4.977778e+00 3.736342e-01
+ 4.988889e+00 3.003044e-01
+ 5.000000e+00 2.311253e-01
+ 5.011111e+00 2.034537e-01
+ 5.022222e+00 1.743985e-01
+ 5.033333e+00 1.591791e-01
+ 5.044444e+00 1.577955e-01
+ 5.055556e+00 1.467268e-01
+ 5.066667e+00 1.439597e-01
+ 5.077778e+00 1.494940e-01
+ 5.088889e+00 1.481104e-01
+ 5.100000e+00 1.481104e-01
+ 5.111111e+00 1.481104e-01
+ 5.122222e+00 1.508776e-01
+ 5.133333e+00 1.467268e-01
+ 5.144444e+00 1.577955e-01
+ 5.155556e+00 1.508776e-01
+ 5.166667e+00 1.522612e-01
+ 5.177778e+00 1.564119e-01
+ 5.188889e+00 1.508776e-01
+ 5.200000e+00 1.494940e-01
+ 5.211111e+00 1.536447e-01
+ 5.222222e+00 1.439597e-01
+ 5.233333e+00 1.467268e-01
+ 5.244444e+00 1.522612e-01
+ 5.255556e+00 1.536447e-01
+ 5.266667e+00 1.508776e-01
+ 5.277778e+00 1.564119e-01
+ 5.288889e+00 1.494940e-01
+ 5.300000e+00 1.467268e-01
+ 5.311111e+00 1.536447e-01
+ 5.322222e+00 1.522612e-01
+ 5.333333e+00 1.536447e-01
+ 5.344444e+00 1.605627e-01
+ 5.355556e+00 1.591791e-01
+ 5.366667e+00 1.564119e-01
+ 5.377778e+00 1.633298e-01
+ 5.388889e+00 1.619462e-01
+ 5.400000e+00 1.605627e-01
+ 5.411111e+00 1.647134e-01
+ 5.422222e+00 1.647134e-01
+ 5.433333e+00 1.660970e-01
+ 5.444444e+00 1.702477e-01
+ 5.455556e+00 1.702477e-01
+ 5.466667e+00 1.743985e-01
+ 5.477778e+00 1.868507e-01
+ 5.488889e+00 1.854671e-01
+ 5.500000e+00 1.965358e-01
+ 5.511111e+00 1.965358e-01
+ 5.522222e+00 1.854671e-01
+ 5.533333e+00 1.771656e-01
+ 5.544444e+00 1.799328e-01
+ 5.555556e+00 1.813164e-01
+ 5.566667e+00 1.799328e-01
+ 5.577778e+00 1.882343e-01
+ 5.588889e+00 1.896179e-01
+ 5.600000e+00 1.840835e-01
+ 5.611111e+00 1.619462e-01
+ 5.622222e+00 2.352761e-01
+ 5.633333e+00 6.877072e-01
+ 5.644444e+00 7.900922e-01
+ 5.655556e+00 1.176716e-01
+ 5.666667e+00 1.481104e-01
+ 5.677778e+00 1.522612e-01
+ 5.688889e+00 1.923850e-01
+ 5.700000e+00 2.020701e-01
+ 5.711111e+00 2.131388e-01
+ 5.722222e+00 2.117552e-01
+ 5.733333e+00 2.131388e-01
+ 5.744444e+00 2.228238e-01
+ 5.755556e+00 2.172895e-01
+ 5.766667e+00 2.214402e-01
+ 5.777778e+00 2.311253e-01
+ 5.788889e+00 2.297417e-01
+ 5.800000e+00 2.297417e-01
+ 5.811111e+00 2.435775e-01
+ 5.822222e+00 2.435775e-01
+ 5.833333e+00 2.491119e-01
+ 5.844444e+00 2.587969e-01
+ 5.855556e+00 2.587969e-01
+ 5.866667e+00 2.726328e-01
+ 5.877778e+00 2.933865e-01
+ 5.888889e+00 2.975372e-01
+ 5.900000e+00 3.086059e-01
+ 5.911111e+00 3.362775e-01
+ 5.922222e+00 3.611820e-01
+ 5.933333e+00 3.888536e-01
+ 5.944444e+00 4.248267e-01
+ 5.955556e+00 4.497312e-01
+ 5.966667e+00 4.746357e-01
+ 5.977778e+00 5.078416e-01
+ 5.988889e+00 5.106088e-01
+ 6.000000e+00 4.843207e-01
+ 6.011111e+00 4.345118e-01
+ 6.022222e+00 3.639491e-01
+ 6.033333e+00 2.920029e-01
+ 6.044444e+00 2.491119e-01
+ 6.055556e+00 2.131388e-01
+ 6.066667e+00 1.896179e-01
+ 6.077778e+00 1.882343e-01
+ 6.088889e+00 1.799328e-01
+ 6.100000e+00 1.730149e-01
+ 6.111111e+00 1.757821e-01
+ 6.122222e+00 1.702477e-01
+ 6.133333e+00 1.702477e-01
+ 6.144444e+00 1.799328e-01
+ 6.155556e+00 1.702477e-01
+ 6.166667e+00 1.743985e-01
+ 6.177778e+00 1.799328e-01
+ 6.188889e+00 1.771656e-01
+ 6.200000e+00 1.716313e-01
+ 6.211111e+00 1.785492e-01
+ 6.222222e+00 1.716313e-01
+ 6.233333e+00 1.660970e-01
+ 6.244444e+00 1.730149e-01
+ 6.255556e+00 1.647134e-01
+ 6.266667e+00 1.660970e-01
+ 6.277778e+00 1.674806e-01
+ 6.288889e+00 1.633298e-01
+ 6.300000e+00 1.577955e-01
+ 6.311111e+00 1.660970e-01
+ 6.322222e+00 1.591791e-01
+ 6.333333e+00 1.577955e-01
+ 6.344444e+00 1.633298e-01
+ 6.355556e+00 1.605627e-01
+ 6.366667e+00 1.550283e-01
+ 6.377778e+00 1.647134e-01
+ 6.388889e+00 1.702477e-01
+ 6.400000e+00 1.743985e-01
+ 6.411111e+00 1.882343e-01
+ 6.422222e+00 1.923850e-01
+ 6.433333e+00 1.743985e-01
+ 6.444444e+00 1.813164e-01
+ 6.455556e+00 1.660970e-01
+ 6.466667e+00 1.550283e-01
+ 6.477778e+00 1.605627e-01
+ 6.488889e+00 1.619462e-01
+ 6.500000e+00 1.605627e-01
+ 6.511111e+00 1.688641e-01
+ 6.522222e+00 1.702477e-01
+ 6.533333e+00 1.577955e-01
+ 6.544444e+00 1.356582e-01
+ 6.555556e+00 3.252089e-01
+ 6.566667e+00 7.610370e-01
+ 6.577778e+00 6.904744e-01
+ 6.588889e+00 7.201344e-02
+ 6.600000e+00 1.066030e-01
+ 6.611111e+00 1.245895e-01
+ 6.622222e+00 1.647134e-01
+ 6.633333e+00 1.688641e-01
+ 6.644444e+00 1.730149e-01
+ 6.655556e+00 1.757821e-01
+ 6.666667e+00 1.730149e-01
+ 6.677778e+00 1.813164e-01
+ 6.688889e+00 1.827000e-01
+ 6.700000e+00 1.813164e-01
+ 6.711111e+00 1.896179e-01
+ 6.722222e+00 1.896179e-01
+ 6.733333e+00 1.965358e-01
+ 6.744444e+00 2.048373e-01
+ 6.755556e+00 2.034537e-01
+ 6.766667e+00 2.117552e-01
+ 6.777778e+00 2.269746e-01
+ 6.788889e+00 2.228238e-01
+ 6.800000e+00 2.366596e-01
+ 6.811111e+00 2.546462e-01
+ 6.822222e+00 2.643313e-01
+ 6.833333e+00 2.795507e-01
+ 6.844444e+00 3.072223e-01
+ 6.855556e+00 3.293596e-01
+ 6.866667e+00 3.611820e-01
+ 6.877778e+00 4.013058e-01
+ 6.888889e+00 4.331282e-01
+ 6.900000e+00 4.580327e-01
+ 6.911111e+00 4.926222e-01
+ 6.922222e+00 4.801700e-01
+ 6.933333e+00 4.358954e-01
+ 6.944444e+00 3.667163e-01
+ 6.955556e+00 2.850850e-01
+ 6.966667e+00 2.283581e-01
+ 6.977778e+00 1.937686e-01
+ 6.988889e+00 1.674806e-01
+ 7.000000e+00 1.508776e-01
+ 7.011111e+00 1.522612e-01
+ 7.022222e+00 1.467268e-01
+ 7.033333e+00 1.439597e-01
+ 7.044444e+00 1.508776e-01
+ 7.055556e+00 1.439597e-01
+ 7.066667e+00 1.481104e-01
+ 7.077778e+00 1.522612e-01
+ 7.088889e+00 1.508776e-01
+ 7.100000e+00 1.467268e-01
+ 7.111111e+00 1.550283e-01
+ 7.122222e+00 1.508776e-01
+ 7.133333e+00 1.508776e-01
+ 7.144444e+00 1.536447e-01
+ 7.155556e+00 1.467268e-01
+ 7.166667e+00 1.425761e-01
+ 7.177778e+00 1.494940e-01
+ 7.188889e+00 1.453433e-01
+ 7.200000e+00 1.425761e-01
+ 7.211111e+00 1.508776e-01
+ 7.222222e+00 1.398089e-01
+ 7.233333e+00 1.411925e-01
+ 7.244444e+00 1.453433e-01
+ 7.255556e+00 1.384254e-01
+ 7.266667e+00 1.384254e-01
+ 7.277778e+00 1.439597e-01
+ 7.288889e+00 1.453433e-01
+ 7.300000e+00 1.439597e-01
+ 7.311111e+00 1.481104e-01
+ 7.322222e+00 1.425761e-01
+ 7.333333e+00 1.411925e-01
+ 7.344444e+00 1.481104e-01
+ 7.355556e+00 1.481104e-01
+ 7.366667e+00 1.619462e-01
+ 7.377778e+00 1.660970e-01
+ 7.388889e+00 1.730149e-01
+ 7.400000e+00 1.757821e-01
+ 7.411111e+00 1.730149e-01
+ 7.422222e+00 1.550283e-01
+ 7.433333e+00 1.467268e-01
+ 7.444444e+00 1.508776e-01
+ 7.455556e+00 1.522612e-01
+ 7.466667e+00 1.494940e-01
+ 7.477778e+00 1.577955e-01
+ 7.488889e+00 1.605627e-01
+ 7.500000e+00 1.577955e-01
+ 7.511111e+00 1.370418e-01
+ 7.522222e+00 2.380432e-01
+ 7.533333e+00 7.388997e-01
+ 7.544444e+00 6.724878e-01
+ 7.555556e+00 6.647911e-02
+ 7.566667e+00 1.135209e-01
+ 7.577778e+00 1.467268e-01
+ 7.588889e+00 1.757821e-01
+ 7.600000e+00 1.757821e-01
+ 7.611111e+00 1.854671e-01
+ 7.622222e+00 1.827000e-01
+ 7.633333e+00 1.882343e-01
+ 7.644444e+00 1.923850e-01
+ 7.655556e+00 1.882343e-01
+ 7.666667e+00 1.937686e-01
+ 7.677778e+00 2.020701e-01
+ 7.688889e+00 2.020701e-01
+ 7.700000e+00 2.048373e-01
+ 7.711111e+00 2.159059e-01
+ 7.722222e+00 2.159059e-01
+ 7.733333e+00 2.186731e-01
+ 7.744444e+00 2.338925e-01
+ 7.755556e+00 2.408104e-01
+ 7.766667e+00 2.518790e-01
+ 7.777778e+00 2.726328e-01
+ 7.788889e+00 2.837014e-01
+ 7.800000e+00 3.030716e-01
+ 7.811111e+00 3.307432e-01
+ 7.822222e+00 3.570312e-01
+ 7.833333e+00 3.874700e-01
+ 7.844444e+00 4.275939e-01
+ 7.855556e+00 4.483476e-01
+ 7.866667e+00 4.691013e-01
+ 7.877778e+00 4.898551e-01
+ 7.888889e+00 4.635670e-01
+ 7.900000e+00 4.082237e-01
+ 7.911111e+00 3.431954e-01
+ 7.922222e+00 2.684820e-01
+ 7.933333e+00 2.228238e-01
+ 7.944444e+00 1.965358e-01
+ 7.955556e+00 1.730149e-01
+ 7.966667e+00 1.647134e-01
+ 7.977778e+00 1.633298e-01
+ 7.988889e+00 1.550283e-01
+ 8.000000e+00 1.536447e-01
+ 8.011111e+00 1.577955e-01
+ 8.022222e+00 1.577955e-01
+ 8.033333e+00 1.577955e-01
+ 8.044444e+00 1.619462e-01
+ 8.055556e+00 1.605627e-01
+ 8.066667e+00 1.550283e-01
+ 8.077778e+00 1.633298e-01
+ 8.088889e+00 1.619462e-01
+ 8.100000e+00 1.550283e-01
+ 8.111111e+00 1.647134e-01
+ 8.122222e+00 1.605627e-01
+ 8.133333e+00 1.536447e-01
+ 8.144444e+00 1.577955e-01
+ 8.155556e+00 1.536447e-01
+ 8.166667e+00 1.550283e-01
+ 8.177778e+00 1.508776e-01
+ 8.188889e+00 1.508776e-01
+ 8.200000e+00 1.522612e-01
+ 8.211111e+00 1.536447e-01
+ 8.222222e+00 1.481104e-01
+ 8.233333e+00 1.508776e-01
+ 8.244444e+00 1.550283e-01
+ 8.255556e+00 1.508776e-01
+ 8.266667e+00 1.481104e-01
+ 8.277778e+00 1.564119e-01
+ 8.288889e+00 1.508776e-01
+ 8.300000e+00 1.522612e-01
+ 8.311111e+00 1.550283e-01
+ 8.322222e+00 1.508776e-01
+ 8.333333e+00 1.522612e-01
+ 8.344444e+00 1.550283e-01
+ 8.355556e+00 1.522612e-01
+ 8.366667e+00 1.467268e-01
+ 8.377778e+00 1.550283e-01
+ 8.388889e+00 1.550283e-01
+ 8.400000e+00 1.467268e-01
+ 8.411111e+00 1.591791e-01
+ 8.422222e+00 1.577955e-01
+ 8.433333e+00 1.564119e-01
+ 8.444444e+00 1.688641e-01
+ 8.455556e+00 1.743985e-01
+ 8.466667e+00 1.743985e-01
+ 8.477778e+00 1.854671e-01
+ 8.488889e+00 1.757821e-01
+ 8.500000e+00 1.674806e-01
+ 8.511111e+00 1.660970e-01
+ 8.522222e+00 1.605627e-01
+ 8.533333e+00 1.633298e-01
+ 8.544444e+00 1.688641e-01
+ 8.555556e+00 1.660970e-01
+ 8.566667e+00 1.716313e-01
+ 8.577778e+00 1.591791e-01
+ 8.588889e+00 1.564119e-01
+ 8.600000e+00 5.825550e-01
+ 8.611111e+00 8.066952e-01
+ 8.622222e+00 1.481104e-01
+ 8.633333e+00 1.315074e-01
+ 8.644444e+00 1.481104e-01
+ 8.655556e+00 1.854671e-01
+ 8.666667e+00 1.771656e-01
+ 8.677778e+00 1.923850e-01
+ 8.688889e+00 1.923850e-01
+ 8.700000e+00 1.910014e-01
+ 8.711111e+00 1.993029e-01
+ 8.722222e+00 1.965358e-01
+ 8.733333e+00 1.979194e-01
+ 8.744444e+00 2.076044e-01
+ 8.755556e+00 2.062208e-01
+ 8.766667e+00 2.076044e-01
+ 8.777778e+00 2.200567e-01
+ 8.788889e+00 2.200567e-01
+ 8.800000e+00 2.214402e-01
+ 8.811111e+00 2.325089e-01
+ 8.822222e+00 2.408104e-01
+ 8.833333e+00 2.504955e-01
+ 8.844444e+00 2.670984e-01
+ 8.855556e+00 2.781671e-01
+ 8.866667e+00 2.878522e-01
+ 8.877778e+00 3.196745e-01
+ 8.888889e+00 3.473462e-01
+ 8.900000e+00 3.777850e-01
+ 8.911111e+00 4.151417e-01
+ 8.922222e+00 4.455804e-01
+ 8.933333e+00 4.649506e-01
+ 8.944444e+00 4.898551e-01
+ 8.955556e+00 4.621834e-01
+ 8.966667e+00 4.151417e-01
+ 8.977778e+00 3.528805e-01
+ 8.988889e+00 2.753999e-01
+ 9.000000e+00 2.172895e-01
+ 9.011111e+00 1.979194e-01
+ 9.022222e+00 1.702477e-01
+ 9.033333e+00 1.647134e-01
+ 9.044444e+00 1.660970e-01
+ 9.055556e+00 1.605627e-01
+ 9.066667e+00 1.550283e-01
+ 9.077778e+00 1.564119e-01
+ 9.088889e+00 1.536447e-01
+ 9.100000e+00 1.536447e-01
+ 9.111111e+00 1.536447e-01
+ 9.122222e+00 1.550283e-01
+ 9.133333e+00 1.536447e-01
+ 9.144444e+00 1.619462e-01
+ 9.155556e+00 1.577955e-01
+ 9.166667e+00 1.494940e-01
+ 9.177778e+00 1.605627e-01
+ 9.188889e+00 1.522612e-01
+ 9.200000e+00 1.453433e-01
+ 9.211111e+00 1.577955e-01
+ 9.222222e+00 1.508776e-01
+ 9.233333e+00 1.494940e-01
+ 9.244444e+00 1.522612e-01
+ 9.255556e+00 1.439597e-01
+ 9.266667e+00 1.481104e-01
+ 9.277778e+00 1.494940e-01
+ 9.288889e+00 1.439597e-01
+ 9.300000e+00 1.453433e-01
+ 9.311111e+00 1.508776e-01
+ 9.322222e+00 1.467268e-01
+ 9.333333e+00 1.411925e-01
+ 9.344444e+00 1.453433e-01
+ 9.355556e+00 1.411925e-01
+ 9.366667e+00 1.411925e-01
+ 9.377778e+00 1.508776e-01
+ 9.388889e+00 1.494940e-01
+ 9.400000e+00 1.439597e-01
+ 9.411111e+00 1.481104e-01
+ 9.422222e+00 1.481104e-01
+ 9.433333e+00 1.384254e-01
+ 9.444444e+00 1.508776e-01
+ 9.455556e+00 1.481104e-01
+ 9.466667e+00 1.564119e-01
+ 9.477778e+00 1.688641e-01
+ 9.488889e+00 1.688641e-01
+ 9.500000e+00 1.674806e-01
+ 9.511111e+00 1.757821e-01
+ 9.522222e+00 1.619462e-01
+ 9.533333e+00 1.550283e-01
+ 9.544444e+00 1.605627e-01
+ 9.555556e+00 1.508776e-01
+ 9.566667e+00 1.522612e-01
+ 9.577778e+00 1.619462e-01
+ 9.588889e+00 1.647134e-01
+ 9.600000e+00 1.342746e-01
+ 9.611111e+00 1.688641e-01
+ 9.622222e+00 5.797879e-01
+ 9.633333e+00 7.928594e-01
+ 9.644444e+00 1.799328e-01
+ 9.655556e+00 1.176716e-01
+ 9.666667e+00 1.135209e-01
+ 9.677778e+00 1.647134e-01
+ 9.688889e+00 1.702477e-01
+ 9.700000e+00 1.743985e-01
+ 9.711111e+00 1.827000e-01
+ 9.722222e+00 1.827000e-01
+ 9.733333e+00 1.882343e-01
+ 9.744444e+00 1.965358e-01
+ 9.755556e+00 1.951522e-01
+ 9.766667e+00 1.965358e-01
+ 9.777778e+00 2.020701e-01
+ 9.788889e+00 2.062208e-01
+ 9.800000e+00 2.103716e-01
+ 9.811111e+00 2.172895e-01
+ 9.822222e+00 2.255910e-01
+ 9.833333e+00 2.325089e-01
+ 9.844444e+00 2.504955e-01
+ 9.855556e+00 2.615641e-01
+ 9.866667e+00 2.753999e-01
+ 9.877778e+00 3.044551e-01
+ 9.888889e+00 3.279760e-01
+ 9.900000e+00 3.584148e-01
+ 9.911111e+00 3.985387e-01
+ 9.922222e+00 4.248267e-01)
Vecg1 ecg_raw_L1 0 PWL(
+ 0.000000e+00 1.585427e-01
+ 1.111111e-02 1.765093e-01
+ 2.222222e-02 1.720177e-01
+ 3.333333e-02 1.585427e-01
+ 4.444444e-02 1.765093e-01
+ 5.555556e-02 1.720177e-01
+ 6.666667e-02 1.540510e-01
+ 7.777778e-02 1.675260e-01
+ 8.888889e-02 1.720177e-01
+ 1.000000e-01 1.675260e-01
+ 1.111111e-01 1.765093e-01
+ 1.222222e-01 1.989676e-01
+ 1.333333e-01 1.944760e-01
+ 1.444444e-01 1.899843e-01
+ 1.555556e-01 1.450677e-01
+ 1.666667e-01 1.495594e-01
+ 1.777778e-01 1.720177e-01
+ 1.888889e-01 1.765093e-01
+ 2.000000e-01 1.540510e-01
+ 2.111111e-01 1.675260e-01
+ 2.222222e-01 1.765093e-01
+ 2.333333e-01 1.540510e-01
+ 2.444444e-01 1.899843e-01
+ 2.555556e-01 2.977841e-01
+ 2.666667e-01 3.427007e-01
+ 2.777778e-01 1.450677e-01
+ 2.888889e-01 5.000000e-02
+ 3.000000e-01 5.000000e-02
+ 3.111111e-01 1.315928e-01
+ 3.222222e-01 1.854927e-01
+ 3.333333e-01 1.720177e-01
+ 3.444444e-01 2.124426e-01
+ 3.555556e-01 2.214259e-01
+ 3.666667e-01 1.944760e-01
+ 3.777778e-01 2.259176e-01
+ 3.888889e-01 2.124426e-01
+ 4.000000e-01 2.034593e-01
+ 4.111111e-01 2.259176e-01
+ 4.222222e-01 2.169343e-01
+ 4.333333e-01 2.034593e-01
+ 4.444444e-01 2.214259e-01
+ 4.555556e-01 2.169343e-01
+ 4.666667e-01 2.124426e-01
+ 4.777778e-01 2.079509e-01
+ 4.888889e-01 2.124426e-01
+ 5.000000e-01 1.944760e-01
+ 5.111111e-01 2.259176e-01
+ 5.222222e-01 2.079509e-01
+ 5.333333e-01 1.989676e-01
+ 5.444444e-01 2.169343e-01
+ 5.555556e-01 2.079509e-01
+ 5.666667e-01 1.899843e-01
+ 5.777778e-01 1.989676e-01
+ 5.888889e-01 1.944760e-01
+ 6.000000e-01 1.810010e-01
+ 6.111111e-01 1.944760e-01
+ 6.222222e-01 1.854927e-01
+ 6.333333e-01 1.720177e-01
+ 6.444444e-01 1.944760e-01
+ 6.555556e-01 2.034593e-01
+ 6.666667e-01 1.944760e-01
+ 6.777778e-01 2.214259e-01
+ 6.888889e-01 2.259176e-01
+ 7.000000e-01 2.214259e-01
+ 7.111111e-01 2.393926e-01
+ 7.222222e-01 2.349009e-01
+ 7.333333e-01 2.214259e-01
+ 7.444444e-01 2.349009e-01
+ 7.555556e-01 2.349009e-01
+ 7.666667e-01 2.169343e-01
+ 7.777778e-01 2.393926e-01
+ 7.888889e-01 2.349009e-01
+ 8.000000e-01 2.393926e-01
+ 8.111111e-01 2.393926e-01
+ 8.222222e-01 2.528675e-01
+ 8.333333e-01 2.393926e-01
+ 8.444444e-01 2.528675e-01
+ 8.555556e-01 2.393926e-01
+ 8.666667e-01 2.214259e-01
+ 8.777778e-01 2.528675e-01
+ 8.888889e-01 2.483759e-01
+ 9.000000e-01 2.259176e-01
+ 9.111111e-01 2.393926e-01
+ 9.222222e-01 2.483759e-01
+ 9.333333e-01 2.438842e-01
+ 9.444444e-01 2.483759e-01
+ 9.555556e-01 2.528675e-01
+ 9.666667e-01 2.349009e-01
+ 9.777778e-01 2.618508e-01
+ 9.888889e-01 2.618508e-01
+ 1.000000e+00 2.393926e-01
+ 1.011111e+00 2.573592e-01
+ 1.022222e+00 2.438842e-01
+ 1.033333e+00 2.483759e-01
+ 1.044444e+00 2.618508e-01
+ 1.055556e+00 2.528675e-01
+ 1.066667e+00 2.483759e-01
+ 1.077778e+00 2.663425e-01
+ 1.088889e+00 2.438842e-01
+ 1.100000e+00 2.438842e-01
+ 1.111111e+00 2.573592e-01
+ 1.122222e+00 2.573592e-01
+ 1.133333e+00 2.483759e-01
+ 1.144444e+00 2.708342e-01
+ 1.155556e+00 2.528675e-01
+ 1.166667e+00 2.393926e-01
+ 1.177778e+00 2.573592e-01
+ 1.188889e+00 2.663425e-01
+ 1.200000e+00 2.528675e-01
+ 1.211111e+00 2.843091e-01
+ 1.222222e+00 2.573592e-01
+ 1.233333e+00 2.438842e-01
+ 1.244444e+00 2.753258e-01
+ 1.255556e+00 2.663425e-01
+ 1.266667e+00 2.798175e-01
+ 1.277778e+00 2.977841e-01
+ 1.288889e+00 2.888008e-01
+ 1.300000e+00 2.618508e-01
+ 1.311111e+00 2.438842e-01
+ 1.322222e+00 2.618508e-01
+ 1.333333e+00 2.663425e-01
+ 1.344444e+00 2.708342e-01
+ 1.355556e+00 2.798175e-01
+ 1.366667e+00 2.573592e-01
+ 1.377778e+00 2.843091e-01
+ 1.388889e+00 2.798175e-01
+ 1.400000e+00 2.798175e-01
+ 1.411111e+00 3.471924e-01
+ 1.422222e+00 4.729588e-01
+ 1.433333e+00 3.876173e-01
+ 1.444444e+00 5.523456e-02
+ 1.455556e+00 5.000000e-02
+ 1.466667e+00 2.528675e-01
+ 1.477778e+00 2.843091e-01
+ 1.488889e+00 3.112591e-01
+ 1.500000e+00 2.932925e-01
+ 1.511111e+00 3.247341e-01
+ 1.522222e+00 3.202424e-01
+ 1.533333e+00 2.932925e-01
+ 1.544444e+00 3.157507e-01
+ 1.555556e+00 3.067674e-01
+ 1.566667e+00 2.977841e-01
+ 1.577778e+00 3.157507e-01
+ 1.588889e+00 3.067674e-01
+ 1.600000e+00 2.977841e-01
+ 1.611111e+00 3.067674e-01
+ 1.622222e+00 3.067674e-01
+ 1.633333e+00 3.022758e-01
+ 1.644444e+00 3.157507e-01
+ 1.655556e+00 3.067674e-01
+ 1.666667e+00 2.932925e-01
+ 1.677778e+00 3.112591e-01
+ 1.688889e+00 3.067674e-01
+ 1.700000e+00 2.932925e-01
+ 1.711111e+00 3.022758e-01
+ 1.722222e+00 2.932925e-01
+ 1.733333e+00 2.708342e-01
+ 1.744444e+00 2.843091e-01
+ 1.755556e+00 2.708342e-01
+ 1.766667e+00 2.573592e-01
+ 1.777778e+00 2.618508e-01
+ 1.788889e+00 2.618508e-01
+ 1.800000e+00 2.618508e-01
+ 1.811111e+00 2.977841e-01
+ 1.822222e+00 3.067674e-01
+ 1.833333e+00 3.112591e-01
+ 1.844444e+00 3.247341e-01
+ 1.855556e+00 3.292257e-01
+ 1.866667e+00 3.157507e-01
+ 1.877778e+00 3.382090e-01
+ 1.888889e+00 3.247341e-01
+ 1.900000e+00 3.112591e-01
+ 1.911111e+00 3.247341e-01
+ 1.922222e+00 3.427007e-01
+ 1.933333e+00 3.157507e-01
+ 1.944444e+00 3.471924e-01
+ 1.955556e+00 3.337174e-01
+ 1.966667e+00 3.202424e-01
+ 1.977778e+00 3.516840e-01
+ 1.988889e+00 3.202424e-01
+ 2.000000e+00 3.202424e-01
+ 2.011111e+00 3.382090e-01
+ 2.022222e+00 3.337174e-01
+ 2.033333e+00 3.157507e-01
+ 2.044444e+00 3.382090e-01
+ 2.055556e+00 3.337174e-01
+ 2.066667e+00 3.157507e-01
+ 2.077778e+00 3.337174e-01
+ 2.088889e+00 3.337174e-01
+ 2.100000e+00 3.067674e-01
+ 2.111111e+00 3.337174e-01
+ 2.122222e+00 3.337174e-01
+ 2.133333e+00 2.977841e-01
+ 2.144444e+00 3.292257e-01
+ 2.155556e+00 3.202424e-01
+ 2.166667e+00 3.157507e-01
+ 2.177778e+00 3.292257e-01
+ 2.188889e+00 3.157507e-01
+ 2.200000e+00 3.067674e-01
+ 2.211111e+00 3.382090e-01
+ 2.222222e+00 3.157507e-01
+ 2.233333e+00 3.067674e-01
+ 2.244444e+00 3.292257e-01
+ 2.255556e+00 3.247341e-01
+ 2.266667e+00 3.157507e-01
+ 2.277778e+00 3.471924e-01
+ 2.288889e+00 3.741423e-01
+ 2.300000e+00 3.516840e-01
+ 2.311111e+00 3.427007e-01
+ 2.322222e+00 3.157507e-01
+ 2.333333e+00 3.022758e-01
+ 2.344444e+00 3.247341e-01
+ 2.355556e+00 3.292257e-01
+ 2.366667e+00 3.112591e-01
+ 2.377778e+00 3.247341e-01
+ 2.388889e+00 3.292257e-01
+ 2.400000e+00 3.157507e-01
+ 2.411111e+00 3.471924e-01
+ 2.422222e+00 4.460088e-01
+ 2.433333e+00 5.178754e-01
+ 2.444444e+00 2.708342e-01
+ 2.455556e+00 5.000000e-02
+ 2.466667e+00 2.483759e-01
+ 2.477778e+00 3.202424e-01
+ 2.488889e+00 3.696506e-01
+ 2.500000e+00 3.427007e-01
+ 2.511111e+00 3.606673e-01
+ 2.522222e+00 3.606673e-01
+ 2.533333e+00 3.471924e-01
+ 2.544444e+00 3.427007e-01
+ 2.555556e+00 3.516840e-01
+ 2.566667e+00 3.292257e-01
+ 2.577778e+00 3.606673e-01
+ 2.588889e+00 3.427007e-01
+ 2.600000e+00 3.292257e-01
+ 2.611111e+00 3.516840e-01
+ 2.622222e+00 3.427007e-01
+ 2.633333e+00 3.247341e-01
+ 2.644444e+00 3.337174e-01
+ 2.655556e+00 3.337174e-01
+ 2.666667e+00 3.112591e-01
+ 2.677778e+00 3.427007e-01
+ 2.688889e+00 3.157507e-01
+ 2.700000e+00 3.022758e-01
+ 2.711111e+00 3.157507e-01
+ 2.722222e+00 2.977841e-01
+ 2.733333e+00 2.932925e-01
+ 2.744444e+00 3.067674e-01
+ 2.755556e+00 2.932925e-01
+ 2.766667e+00 2.888008e-01
+ 2.777778e+00 3.202424e-01
+ 2.788889e+00 3.337174e-01
+ 2.800000e+00 3.247341e-01
+ 2.811111e+00 3.471924e-01
+ 2.822222e+00 3.337174e-01
+ 2.833333e+00 3.112591e-01
+ 2.844444e+00 3.337174e-01
+ 2.855556e+00 3.202424e-01
+ 2.866667e+00 3.157507e-01
+ 2.877778e+00 3.427007e-01
+ 2.888889e+00 3.382090e-01
+ 2.900000e+00 3.247341e-01
+ 2.911111e+00 3.382090e-01
+ 2.922222e+00 3.337174e-01
+ 2.933333e+00 3.292257e-01
+ 2.944444e+00 3.427007e-01
+ 2.955556e+00 3.382090e-01
+ 2.966667e+00 3.247341e-01
+ 2.977778e+00 3.382090e-01
+ 2.988889e+00 3.427007e-01
+ 3.000000e+00 3.202424e-01
+ 3.011111e+00 3.516840e-01
+ 3.022222e+00 3.382090e-01
+ 3.033333e+00 3.247341e-01
+ 3.044444e+00 3.471924e-01
+ 3.055556e+00 3.427007e-01
+ 3.066667e+00 3.202424e-01
+ 3.077778e+00 3.427007e-01
+ 3.088889e+00 3.516840e-01
+ 3.100000e+00 3.337174e-01
+ 3.111111e+00 3.516840e-01
+ 3.122222e+00 3.427007e-01
+ 3.133333e+00 3.337174e-01
+ 3.144444e+00 3.606673e-01
+ 3.155556e+00 3.516840e-01
+ 3.166667e+00 3.382090e-01
+ 3.177778e+00 3.651590e-01
+ 3.188889e+00 3.651590e-01
+ 3.200000e+00 3.427007e-01
+ 3.211111e+00 3.651590e-01
+ 3.222222e+00 3.651590e-01
+ 3.233333e+00 3.471924e-01
+ 3.244444e+00 3.651590e-01
+ 3.255556e+00 3.651590e-01
+ 3.266667e+00 3.516840e-01
+ 3.277778e+00 3.786340e-01
+ 3.288889e+00 3.786340e-01
+ 3.300000e+00 3.606673e-01
+ 3.311111e+00 3.876173e-01
+ 3.322222e+00 3.831256e-01
+ 3.333333e+00 3.741423e-01
+ 3.344444e+00 4.010923e-01
+ 3.355556e+00 4.370255e-01
+ 3.366667e+00 3.921089e-01
+ 3.377778e+00 3.741423e-01
+ 3.388889e+00 3.876173e-01
+ 3.400000e+00 3.786340e-01
+ 3.411111e+00 4.055839e-01
+ 3.422222e+00 4.100756e-01
+ 3.433333e+00 3.921089e-01
+ 3.444444e+00 4.235505e-01
+ 3.455556e+00 4.280422e-01
+ 3.466667e+00 4.280422e-01
+ 3.477778e+00 5.717753e-01
+ 3.488889e+00 5.717753e-01
+ 3.500000e+00 1.765093e-01
+ 3.511111e+00 1.495594e-01
+ 3.522222e+00 3.876173e-01
+ 3.533333e+00 4.325339e-01
+ 3.544444e+00 4.639755e-01
+ 3.555556e+00 4.864338e-01
+ 3.566667e+00 4.639755e-01
+ 3.577778e+00 4.999087e-01
+ 3.588889e+00 4.909254e-01
+ 3.600000e+00 4.774504e-01
+ 3.611111e+00 5.044004e-01
+ 3.622222e+00 4.954171e-01
+ 3.633333e+00 4.819421e-01
+ 3.644444e+00 5.088921e-01
+ 3.655556e+00 4.999087e-01
+ 3.666667e+00 4.864338e-01
+ 3.677778e+00 5.088921e-01
+ 3.688889e+00 4.999087e-01
+ 3.700000e+00 4.864338e-01
+ 3.711111e+00 5.044004e-01
+ 3.722222e+00 4.999087e-01
+ 3.733333e+00 4.909254e-01
+ 3.744444e+00 5.133837e-01
+ 3.755556e+00 5.044004e-01
+ 3.766667e+00 4.864338e-01
+ 3.777778e+00 5.133837e-01
+ 3.788889e+00 4.999087e-01
+ 3.800000e+00 4.729588e-01
+ 3.811111e+00 4.954171e-01
+ 3.822222e+00 4.864338e-01
+ 3.833333e+00 4.729588e-01
+ 3.844444e+00 5.044004e-01
+ 3.855556e+00 5.178754e-01
+ 3.866667e+00 5.088921e-01
+ 3.877778e+00 5.358420e-01
+ 3.888889e+00 5.268587e-01
+ 3.900000e+00 5.178754e-01
+ 3.911111e+00 5.313503e-01
+ 3.922222e+00 5.403337e-01
+ 3.933333e+00 5.133837e-01
+ 3.944444e+00 5.358420e-01
+ 3.955556e+00 5.358420e-01
+ 3.966667e+00 5.223670e-01
+ 3.977778e+00 5.403337e-01
+ 3.988889e+00 5.403337e-01
+ 4.000000e+00 5.268587e-01
+ 4.011111e+00 5.538086e-01
+ 4.022222e+00 5.448253e-01
+ 4.033333e+00 5.403337e-01
+ 4.044444e+00 5.583003e-01
+ 4.055556e+00 5.583003e-01
+ 4.066667e+00 5.313503e-01
+ 4.077778e+00 5.493170e-01
+ 4.088889e+00 5.448253e-01
+ 4.100000e+00 5.223670e-01
+ 4.111111e+00 5.448253e-01
+ 4.122222e+00 5.448253e-01
+ 4.133333e+00 5.358420e-01
+ 4.144444e+00 5.493170e-01
+ 4.155556e+00 5.403337e-01
+ 4.166667e+00 5.178754e-01
+ 4.177778e+00 5.358420e-01
+ 4.188889e+00 5.403337e-01
+ 4.200000e+00 5.223670e-01
+ 4.211111e+00 5.403337e-01
+ 4.222222e+00 5.448253e-01
+ 4.233333e+00 5.223670e-01
+ 4.244444e+00 5.403337e-01
+ 4.255556e+00 5.448253e-01
+ 4.266667e+00 5.268587e-01
+ 4.277778e+00 5.358420e-01
+ 4.288889e+00 5.403337e-01
+ 4.300000e+00 5.223670e-01
+ 4.311111e+00 5.448253e-01
+ 4.322222e+00 5.358420e-01
+ 4.333333e+00 5.178754e-01
+ 4.344444e+00 5.313503e-01
+ 4.355556e+00 5.403337e-01
+ 4.366667e+00 5.133837e-01
+ 4.377778e+00 5.313503e-01
+ 4.388889e+00 5.313503e-01
+ 4.400000e+00 5.178754e-01
+ 4.411111e+00 5.448253e-01
+ 4.422222e+00 5.313503e-01
+ 4.433333e+00 5.223670e-01
+ 4.444444e+00 5.538086e-01
+ 4.455556e+00 5.672836e-01
+ 4.466667e+00 5.268587e-01
+ 4.477778e+00 5.088921e-01
+ 4.488889e+00 5.178754e-01
+ 4.500000e+00 5.088921e-01
+ 4.511111e+00 5.268587e-01
+ 4.522222e+00 5.223670e-01
+ 4.533333e+00 4.999087e-01
+ 4.544444e+00 5.268587e-01
+ 4.555556e+00 5.313503e-01
+ 4.566667e+00 5.538086e-01
+ 4.577778e+00 7.155083e-01
+ 4.588889e+00 5.942336e-01
+ 4.600000e+00 1.899843e-01
+ 4.611111e+00 2.708342e-01
+ 4.622222e+00 4.684671e-01
+ 4.633333e+00 4.954171e-01
+ 4.644444e+00 5.403337e-01
+ 4.655556e+00 5.403337e-01
+ 4.666667e+00 5.133837e-01
+ 4.677778e+00 5.403337e-01
+ 4.688889e+00 5.403337e-01
+ 4.700000e+00 5.223670e-01
+ 4.711111e+00 5.268587e-01
+ 4.722222e+00 5.223670e-01
+ 4.733333e+00 5.088921e-01
+ 4.744444e+00 5.268587e-01
+ 4.755556e+00 5.313503e-01
+ 4.766667e+00 5.044004e-01
+ 4.777778e+00 5.178754e-01
+ 4.788889e+00 5.088921e-01
+ 4.800000e+00 4.909254e-01
+ 4.811111e+00 5.133837e-01
+ 4.822222e+00 4.999087e-01
+ 4.833333e+00 4.819421e-01
+ 4.844444e+00 5.044004e-01
+ 4.855556e+00 4.909254e-01
+ 4.866667e+00 4.684671e-01
+ 4.877778e+00 4.819421e-01
+ 4.888889e+00 4.774504e-01
+ 4.900000e+00 4.460088e-01
+ 4.911111e+00 4.549922e-01
+ 4.922222e+00 4.549922e-01
+ 4.933333e+00 4.415172e-01
+ 4.944444e+00 4.505005e-01
+ 4.955556e+00 4.505005e-01
+ 4.966667e+00 4.505005e-01
+ 4.977778e+00 4.729588e-01
+ 4.988889e+00 4.774504e-01
+ 5.000000e+00 4.594838e-01
+ 5.011111e+00 4.774504e-01
+ 5.022222e+00 4.774504e-01
+ 5.033333e+00 4.505005e-01
+ 5.044444e+00 4.639755e-01
+ 5.055556e+00 4.639755e-01
+ 5.066667e+00 4.505005e-01
+ 5.077778e+00 4.774504e-01
+ 5.088889e+00 4.729588e-01
+ 5.100000e+00 4.549922e-01
+ 5.111111e+00 4.594838e-01
+ 5.122222e+00 4.774504e-01
+ 5.133333e+00 4.460088e-01
+ 5.144444e+00 4.684671e-01
+ 5.155556e+00 4.549922e-01
+ 5.166667e+00 4.505005e-01
+ 5.177778e+00 4.505005e-01
+ 5.188889e+00 4.460088e-01
+ 5.200000e+00 4.370255e-01
+ 5.211111e+00 4.460088e-01
+ 5.222222e+00 4.415172e-01
+ 5.233333e+00 4.280422e-01
+ 5.244444e+00 4.505005e-01
+ 5.255556e+00 4.460088e-01
+ 5.266667e+00 4.280422e-01
+ 5.277778e+00 4.325339e-01
+ 5.288889e+00 4.370255e-01
+ 5.300000e+00 4.145672e-01
+ 5.311111e+00 4.280422e-01
+ 5.322222e+00 4.235505e-01
+ 5.333333e+00 4.055839e-01
+ 5.344444e+00 4.235505e-01
+ 5.355556e+00 4.235505e-01
+ 5.366667e+00 4.055839e-01
+ 5.377778e+00 4.055839e-01
+ 5.388889e+00 4.190589e-01
+ 5.400000e+00 3.921089e-01
+ 5.411111e+00 4.190589e-01
+ 5.422222e+00 4.100756e-01
+ 5.433333e+00 3.921089e-01
+ 5.444444e+00 4.055839e-01
+ 5.455556e+00 4.055839e-01
+ 5.466667e+00 4.325339e-01
+ 5.477778e+00 4.325339e-01
+ 5.488889e+00 4.010923e-01
+ 5.500000e+00 3.427007e-01
+ 5.511111e+00 3.966006e-01
+ 5.522222e+00 3.966006e-01
+ 5.533333e+00 3.741423e-01
+ 5.544444e+00 3.921089e-01
+ 5.555556e+00 3.786340e-01
+ 5.566667e+00 3.831256e-01
+ 5.577778e+00 4.100756e-01
+ 5.588889e+00 4.055839e-01
+ 5.600000e+00 5.133837e-01
+ 5.611111e+00 5.493170e-01
+ 5.622222e+00 2.663425e-01
+ 5.633333e+00 5.074291e-02
+ 5.644444e+00 3.337174e-01
+ 5.655556e+00 3.606673e-01
+ 5.666667e+00 3.831256e-01
+ 5.677778e+00 4.100756e-01
+ 5.688889e+00 4.145672e-01
+ 5.700000e+00 3.921089e-01
+ 5.711111e+00 4.100756e-01
+ 5.722222e+00 4.010923e-01
+ 5.733333e+00 3.966006e-01
+ 5.744444e+00 3.966006e-01
+ 5.755556e+00 3.966006e-01
+ 5.766667e+00 3.786340e-01
+ 5.777778e+00 3.966006e-01
+ 5.788889e+00 4.010923e-01
+ 5.800000e+00 3.741423e-01
+ 5.811111e+00 4.010923e-01
+ 5.822222e+00 3.876173e-01
+ 5.833333e+00 3.696506e-01
+ 5.844444e+00 3.831256e-01
+ 5.855556e+00 3.876173e-01
+ 5.866667e+00 3.651590e-01
+ 5.877778e+00 3.921089e-01
+ 5.888889e+00 3.741423e-01
+ 5.900000e+00 3.606673e-01
+ 5.911111e+00 3.741423e-01
+ 5.922222e+00 3.696506e-01
+ 5.933333e+00 3.516840e-01
+ 5.944444e+00 3.561757e-01
+ 5.955556e+00 3.516840e-01
+ 5.966667e+00 3.157507e-01
+ 5.977778e+00 3.337174e-01
+ 5.988889e+00 3.516840e-01
+ 6.000000e+00 3.651590e-01
+ 6.011111e+00 3.876173e-01
+ 6.022222e+00 3.921089e-01
+ 6.033333e+00 3.966006e-01
+ 6.044444e+00 4.145672e-01
+ 6.055556e+00 4.055839e-01
+ 6.066667e+00 3.921089e-01
+ 6.077778e+00 4.190589e-01
+ 6.088889e+00 4.145672e-01
+ 6.100000e+00 4.100756e-01
+ 6.111111e+00 4.280422e-01
+ 6.122222e+00 4.235505e-01
+ 6.133333e+00 4.190589e-01
+ 6.144444e+00 4.325339e-01
+ 6.155556e+00 4.370255e-01
+ 6.166667e+00 4.190589e-01
+ 6.177778e+00 4.460088e-01
+ 6.188889e+00 4.460088e-01
+ 6.200000e+00 4.325339e-01
+ 6.211111e+00 4.505005e-01
+ 6.222222e+00 4.684671e-01
+ 6.233333e+00 4.594838e-01
+ 6.244444e+00 4.819421e-01
+ 6.255556e+00 4.774504e-01
+ 6.266667e+00 4.639755e-01
+ 6.277778e+00 4.864338e-01
+ 6.288889e+00 4.819421e-01
+ 6.300000e+00 4.729588e-01
+ 6.311111e+00 5.044004e-01
+ 6.322222e+00 4.954171e-01
+ 6.333333e+00 4.864338e-01
+ 6.344444e+00 5.223670e-01
+ 6.355556e+00 5.268587e-01
+ 6.366667e+00 5.044004e-01
+ 6.377778e+00 5.538086e-01
+ 6.388889e+00 5.807586e-01
+ 6.400000e+00 5.403337e-01
+ 6.411111e+00 5.223670e-01
+ 6.422222e+00 5.403337e-01
+ 6.433333e+00 5.178754e-01
+ 6.444444e+00 5.538086e-01
+ 6.455556e+00 5.358420e-01
+ 6.466667e+00 5.403337e-01
+ 6.477778e+00 5.627920e-01
+ 6.488889e+00 5.627920e-01
+ 6.500000e+00 5.493170e-01
+ 6.511111e+00 5.807586e-01
+ 6.522222e+00 6.346585e-01
+ 6.533333e+00 7.289833e-01
+ 6.544444e+00 6.930500e-01
+ 6.555556e+00 3.561757e-01
+ 6.566667e+00 2.798175e-01
+ 6.577778e+00 5.672836e-01
+ 6.588889e+00 5.942336e-01
+ 6.600000e+00 6.211835e-01
+ 6.611111e+00 6.436418e-01
+ 6.622222e+00 6.526251e-01
+ 6.633333e+00 6.346585e-01
+ 6.644444e+00 6.481335e-01
+ 6.655556e+00 6.526251e-01
+ 6.666667e+00 6.391501e-01
+ 6.677778e+00 6.705918e-01
+ 6.688889e+00 6.616084e-01
+ 6.700000e+00 6.481335e-01
+ 6.711111e+00 6.750834e-01
+ 6.722222e+00 6.705918e-01
+ 6.733333e+00 6.571168e-01
+ 6.744444e+00 6.795751e-01
+ 6.755556e+00 6.705918e-01
+ 6.766667e+00 6.571168e-01
+ 6.777778e+00 6.795751e-01
+ 6.788889e+00 6.750834e-01
+ 6.800000e+00 6.661001e-01
+ 6.811111e+00 6.840667e-01
+ 6.822222e+00 6.840667e-01
+ 6.833333e+00 6.616084e-01
+ 6.844444e+00 6.750834e-01
+ 6.855556e+00 6.750834e-01
+ 6.866667e+00 6.481335e-01
+ 6.877778e+00 6.661001e-01
+ 6.888889e+00 6.616084e-01
+ 6.900000e+00 6.436418e-01
+ 6.911111e+00 6.705918e-01
+ 6.922222e+00 6.840667e-01
+ 6.933333e+00 6.750834e-01
+ 6.944444e+00 7.110167e-01
+ 6.955556e+00 7.244917e-01
+ 6.966667e+00 7.065250e-01
+ 6.977778e+00 7.289833e-01
+ 6.988889e+00 7.244917e-01
+ 7.000000e+00 6.885584e-01
+ 7.011111e+00 7.155083e-01
+ 7.022222e+00 7.200000e-01
+ 7.033333e+00 6.975417e-01
+ 7.044444e+00 7.110167e-01
+ 7.055556e+00 7.110167e-01
+ 7.066667e+00 7.020334e-01
+ 7.077778e+00 7.244917e-01
+ 7.088889e+00 7.200000e-01
+ 7.100000e+00 7.020334e-01
+ 7.111111e+00 7.155083e-01
+ 7.122222e+00 7.110167e-01
+ 7.133333e+00 7.065250e-01
+ 7.144444e+00 7.244917e-01
+ 7.155556e+00 7.200000e-01
+ 7.166667e+00 6.930500e-01
+ 7.177778e+00 7.110167e-01
+ 7.188889e+00 7.110167e-01
+ 7.200000e+00 6.840667e-01
+ 7.211111e+00 7.065250e-01
+ 7.222222e+00 6.975417e-01
+ 7.233333e+00 6.795751e-01
+ 7.244444e+00 6.930500e-01
+ 7.255556e+00 6.885584e-01
+ 7.266667e+00 6.705918e-01
+ 7.277778e+00 6.930500e-01
+ 7.288889e+00 6.750834e-01
+ 7.300000e+00 6.616084e-01
+ 7.311111e+00 6.750834e-01
+ 7.322222e+00 6.705918e-01
+ 7.333333e+00 6.436418e-01
+ 7.344444e+00 6.750834e-01
+ 7.355556e+00 6.930500e-01
+ 7.366667e+00 6.975417e-01
+ 7.377778e+00 6.795751e-01
+ 7.388889e+00 6.571168e-01
+ 7.400000e+00 6.301668e-01
+ 7.411111e+00 6.436418e-01
+ 7.422222e+00 6.301668e-01
+ 7.433333e+00 6.166919e-01
+ 7.444444e+00 6.346585e-01
+ 7.455556e+00 6.346585e-01
+ 7.466667e+00 6.166919e-01
+ 7.477778e+00 6.301668e-01
+ 7.488889e+00 6.436418e-01
+ 7.500000e+00 7.604249e-01
+ 7.511111e+00 7.873749e-01
+ 7.522222e+00 4.549922e-01
+ 7.533333e+00 2.573592e-01
+ 7.544444e+00 5.807586e-01
+ 7.555556e+00 6.032169e-01
+ 7.566667e+00 6.077085e-01
+ 7.577778e+00 6.436418e-01
+ 7.588889e+00 6.346585e-01
+ 7.600000e+00 6.166919e-01
+ 7.611111e+00 6.346585e-01
+ 7.622222e+00 6.166919e-01
+ 7.633333e+00 6.032169e-01
+ 7.644444e+00 6.166919e-01
+ 7.655556e+00 5.987252e-01
+ 7.666667e+00 5.852502e-01
+ 7.677778e+00 5.987252e-01
+ 7.688889e+00 5.987252e-01
+ 7.700000e+00 5.717753e-01
+ 7.711111e+00 5.852502e-01
+ 7.722222e+00 5.852502e-01
+ 7.733333e+00 5.493170e-01
+ 7.744444e+00 5.627920e-01
+ 7.755556e+00 5.627920e-01
+ 7.766667e+00 5.313503e-01
+ 7.777778e+00 5.448253e-01
+ 7.788889e+00 5.403337e-01
+ 7.800000e+00 5.133837e-01
+ 7.811111e+00 5.223670e-01
+ 7.822222e+00 5.178754e-01
+ 7.833333e+00 4.999087e-01
+ 7.844444e+00 5.133837e-01
+ 7.855556e+00 4.909254e-01
+ 7.866667e+00 4.684671e-01
+ 7.877778e+00 4.954171e-01
+ 7.888889e+00 5.044004e-01
+ 7.900000e+00 4.999087e-01
+ 7.911111e+00 5.133837e-01
+ 7.922222e+00 5.133837e-01
+ 7.933333e+00 4.999087e-01
+ 7.944444e+00 5.044004e-01
+ 7.955556e+00 5.044004e-01
+ 7.966667e+00 4.774504e-01
+ 7.977778e+00 5.133837e-01
+ 7.988889e+00 4.909254e-01
+ 8.000000e+00 4.684671e-01
+ 8.011111e+00 4.954171e-01
+ 8.022222e+00 4.819421e-01
+ 8.033333e+00 4.684671e-01
+ 8.044444e+00 4.819421e-01
+ 8.055556e+00 4.729588e-01
+ 8.066667e+00 4.594838e-01
+ 8.077778e+00 4.729588e-01
+ 8.088889e+00 4.729588e-01
+ 8.100000e+00 4.639755e-01
+ 8.111111e+00 4.684671e-01
+ 8.122222e+00 4.594838e-01
+ 8.133333e+00 4.370255e-01
+ 8.144444e+00 4.549922e-01
+ 8.155556e+00 4.594838e-01
+ 8.166667e+00 4.235505e-01
+ 8.177778e+00 4.460088e-01
+ 8.188889e+00 4.460088e-01
+ 8.200000e+00 4.190589e-01
+ 8.211111e+00 4.325339e-01
+ 8.222222e+00 4.325339e-01
+ 8.233333e+00 4.100756e-01
+ 8.244444e+00 4.280422e-01
+ 8.255556e+00 4.190589e-01
+ 8.266667e+00 3.876173e-01
+ 8.277778e+00 4.190589e-01
+ 8.288889e+00 4.010923e-01
+ 8.300000e+00 3.786340e-01
+ 8.311111e+00 3.966006e-01
+ 8.322222e+00 4.010923e-01
+ 8.333333e+00 3.741423e-01
+ 8.344444e+00 3.966006e-01
+ 8.355556e+00 3.921089e-01
+ 8.366667e+00 3.651590e-01
+ 8.377778e+00 3.831256e-01
+ 8.388889e+00 3.831256e-01
+ 8.400000e+00 3.606673e-01
+ 8.411111e+00 3.831256e-01
+ 8.422222e+00 3.741423e-01
+ 8.433333e+00 3.606673e-01
+ 8.444444e+00 4.055839e-01
+ 8.455556e+00 3.786340e-01
+ 8.466667e+00 3.337174e-01
+ 8.477778e+00 3.427007e-01
+ 8.488889e+00 3.471924e-01
+ 8.500000e+00 3.337174e-01
+ 8.511111e+00 3.471924e-01
+ 8.522222e+00 3.382090e-01
+ 8.533333e+00 3.247341e-01
+ 8.544444e+00 3.471924e-01
+ 8.555556e+00 3.382090e-01
+ 8.566667e+00 3.651590e-01
+ 8.577778e+00 5.268587e-01
+ 8.588889e+00 3.292257e-01
+ 8.600000e+00 5.000000e-02
+ 8.611111e+00 2.349009e-01
+ 8.622222e+00 2.843091e-01
+ 8.633333e+00 3.157507e-01
+ 8.644444e+00 3.337174e-01
+ 8.655556e+00 3.337174e-01
+ 8.666667e+00 3.157507e-01
+ 8.677778e+00 3.337174e-01
+ 8.688889e+00 3.337174e-01
+ 8.700000e+00 3.067674e-01
+ 8.711111e+00 3.157507e-01
+ 8.722222e+00 3.202424e-01
+ 8.733333e+00 3.022758e-01
+ 8.744444e+00 3.202424e-01
+ 8.755556e+00 3.157507e-01
+ 8.766667e+00 2.888008e-01
+ 8.777778e+00 3.022758e-01
+ 8.788889e+00 3.067674e-01
+ 8.800000e+00 2.798175e-01
+ 8.811111e+00 3.022758e-01
+ 8.822222e+00 3.022758e-01
+ 8.833333e+00 2.843091e-01
+ 8.844444e+00 2.798175e-01
+ 8.855556e+00 2.708342e-01
+ 8.866667e+00 2.483759e-01
+ 8.877778e+00 2.618508e-01
+ 8.888889e+00 2.573592e-01
+ 8.900000e+00 2.393926e-01
+ 8.911111e+00 2.438842e-01
+ 8.922222e+00 2.349009e-01
+ 8.933333e+00 2.169343e-01
+ 8.944444e+00 2.304092e-01
+ 8.955556e+00 2.438842e-01
+ 8.966667e+00 2.483759e-01
+ 8.977778e+00 2.753258e-01
+ 8.988889e+00 2.618508e-01
+ 9.000000e+00 2.393926e-01
+ 9.011111e+00 2.618508e-01
+ 9.022222e+00 2.663425e-01
+ 9.033333e+00 2.349009e-01
+ 9.044444e+00 2.528675e-01
+ 9.055556e+00 2.528675e-01
+ 9.066667e+00 2.393926e-01
+ 9.077778e+00 2.663425e-01
+ 9.088889e+00 2.483759e-01
+ 9.100000e+00 2.259176e-01
+ 9.111111e+00 2.618508e-01
+ 9.122222e+00 2.483759e-01
+ 9.133333e+00 2.393926e-01
+ 9.144444e+00 2.528675e-01
+ 9.155556e+00 2.438842e-01
+ 9.166667e+00 2.259176e-01
+ 9.177778e+00 2.393926e-01
+ 9.188889e+00 2.349009e-01
+ 9.200000e+00 2.124426e-01
+ 9.211111e+00 2.214259e-01
+ 9.222222e+00 2.304092e-01
+ 9.233333e+00 2.214259e-01
+ 9.244444e+00 2.214259e-01
+ 9.255556e+00 2.259176e-01
+ 9.266667e+00 1.899843e-01
+ 9.277778e+00 2.214259e-01
+ 9.288889e+00 2.124426e-01
+ 9.300000e+00 1.989676e-01
+ 9.311111e+00 2.214259e-01
+ 9.322222e+00 2.169343e-01
+ 9.333333e+00 1.989676e-01
+ 9.344444e+00 2.214259e-01
+ 9.355556e+00 2.124426e-01
+ 9.366667e+00 1.944760e-01
+ 9.377778e+00 2.124426e-01
+ 9.388889e+00 1.989676e-01
+ 9.400000e+00 1.899843e-01
+ 9.411111e+00 1.989676e-01
+ 9.422222e+00 2.214259e-01
+ 9.433333e+00 1.944760e-01
+ 9.444444e+00 2.124426e-01
+ 9.455556e+00 2.214259e-01
+ 9.466667e+00 2.214259e-01
+ 9.477778e+00 2.259176e-01
+ 9.488889e+00 1.944760e-01
+ 9.500000e+00 1.765093e-01
+ 9.511111e+00 1.899843e-01
+ 9.522222e+00 1.899843e-01
+ 9.533333e+00 1.765093e-01
+ 9.544444e+00 1.899843e-01
+ 9.555556e+00 1.944760e-01
+ 9.566667e+00 1.899843e-01
+ 9.577778e+00 2.079509e-01
+ 9.588889e+00 2.843091e-01
+ 9.600000e+00 3.561757e-01
+ 9.611111e+00 1.630344e-01
+ 9.622222e+00 5.000000e-02
+ 9.633333e+00 8.667617e-02
+ 9.644444e+00 1.765093e-01
+ 9.655556e+00 2.034593e-01
+ 9.666667e+00 1.854927e-01
+ 9.677778e+00 2.214259e-01
+ 9.688889e+00 2.079509e-01
+ 9.700000e+00 1.899843e-01
+ 9.711111e+00 2.079509e-01
+ 9.722222e+00 2.214259e-01
+ 9.733333e+00 1.854927e-01
+ 9.744444e+00 2.124426e-01
+ 9.755556e+00 2.079509e-01
+ 9.766667e+00 1.810010e-01
+ 9.777778e+00 2.034593e-01
+ 9.788889e+00 1.989676e-01
+ 9.800000e+00 1.810010e-01
+ 9.811111e+00 1.899843e-01
+ 9.822222e+00 1.989676e-01
+ 9.833333e+00 1.720177e-01
+ 9.844444e+00 1.810010e-01
+ 9.855556e+00 1.854927e-01
+ 9.866667e+00 1.585427e-01
+ 9.877778e+00 1.675260e-01
+ 9.888889e+00 1.720177e-01
+ 9.900000e+00 1.315928e-01
+ 9.911111e+00 1.495594e-01
+ 9.922222e+00 1.450677e-01)

* Stage 1: Input Conditioning
Xbuf0 ecg_raw_L0 ecg_buf_L0 ecg_buf_L0 vdd vss vbias ota_5t
Xhpf0 ecg_buf_L0 ecg_hp_L0 vdd vss vbias otac_hpf cap_w=100 cap_l=100
Xlpf0 ecg_hp_L0 ecg_cond_L0 vdd vss vbias otac_lpf cap_w=17 cap_l=17

Xbuf1 ecg_raw_L1 ecg_buf_L1 ecg_buf_L1 vdd vss vbias ota_5t
Xhpf1 ecg_buf_L1 ecg_hp_L1 vdd vss vbias otac_hpf cap_w=100 cap_l=100
Xlpf1 ecg_hp_L1 ecg_cond_L1 vdd vss vbias otac_lpf cap_w=17 cap_l=17

* Stage 2: R-Peak Detection
Xbpf ecg_cond_L0 bpf_out vdd vss vbias otac_bpf cl_hpf=39 cw_hpf=39 cl_lpf=24 cw_lpf=24
Xrect bpf_out rect_out vref vdd vss vbias rectifier
Xenv rect_out env_out vdd vss vbias otac_lpf cap_w=77 cap_l=77
Xthresh env_out thresh_out vdd vss vbias otac_lpf cap_w=50 cap_l=50
Xcmp env_out thresh_out rpeak_internal vdd vss vbias comparator

* Timing signals (from annotations, not from R-peak detector)
Vrpeak rpeak_trigger 0 PWL(
+ 0.0000000e+00 0.000000e+00
+ 2.9990000e-01 0.000000e+00
+ 3.0000000e-01 9.000000e-01
+ 3.0500000e-01 9.000000e-01
+ 3.0510000e-01 0.000000e+00
+ 1.4582333e+00 0.000000e+00
+ 1.4583333e+00 9.000000e-01
+ 1.4633333e+00 9.000000e-01
+ 1.4634333e+00 0.000000e+00
+ 2.4610111e+00 0.000000e+00
+ 2.4611111e+00 9.000000e-01
+ 2.4661111e+00 9.000000e-01
+ 2.4662111e+00 0.000000e+00
+ 3.5137889e+00 0.000000e+00
+ 3.5138889e+00 9.000000e-01
+ 3.5188889e+00 9.000000e-01
+ 3.5189889e+00 0.000000e+00
+ 4.6110111e+00 0.000000e+00
+ 4.6111111e+00 9.000000e-01
+ 4.6161111e+00 9.000000e-01
+ 4.6162111e+00 0.000000e+00
+ 5.6387889e+00 0.000000e+00
+ 5.6388889e+00 9.000000e-01
+ 5.6438889e+00 9.000000e-01
+ 5.6439889e+00 0.000000e+00
+ 6.5693444e+00 0.000000e+00
+ 6.5694444e+00 9.000000e-01
+ 6.5744444e+00 9.000000e-01
+ 6.5745444e+00 0.000000e+00
+ 7.5360111e+00 0.000000e+00
+ 7.5361111e+00 9.000000e-01
+ 7.5411111e+00 9.000000e-01
+ 7.5412111e+00 0.000000e+00
+ 8.6082333e+00 0.000000e+00
+ 8.6083333e+00 9.000000e-01
+ 8.6133333e+00 9.000000e-01
+ 8.6134333e+00 0.000000e+00
+ 9.6304556e+00 0.000000e+00
+ 9.6305556e+00 9.000000e-01
+ 9.6355556e+00 9.000000e-01
+ 9.6356556e+00 0.000000e+00
+ 9.9277778e+00 0.000000e+00)
Vqrs_gate qrs_gate 0 PWL(
+ 0.0000000e+00 0.000000e+00
+ 2.4990000e-01 0.000000e+00
+ 2.5000000e-01 9.000000e-01
+ 4.0000000e-01 9.000000e-01
+ 4.0010000e-01 0.000000e+00
+ 1.4082333e+00 0.000000e+00
+ 1.4083333e+00 9.000000e-01
+ 1.5583333e+00 9.000000e-01
+ 1.5584333e+00 0.000000e+00
+ 2.4110111e+00 0.000000e+00
+ 2.4111111e+00 9.000000e-01
+ 2.5611111e+00 9.000000e-01
+ 2.5612111e+00 0.000000e+00
+ 3.4637889e+00 0.000000e+00
+ 3.4638889e+00 9.000000e-01
+ 3.6138889e+00 9.000000e-01
+ 3.6139889e+00 0.000000e+00
+ 4.5610111e+00 0.000000e+00
+ 4.5611111e+00 9.000000e-01
+ 4.7111111e+00 9.000000e-01
+ 4.7112111e+00 0.000000e+00
+ 5.5887889e+00 0.000000e+00
+ 5.5888889e+00 9.000000e-01
+ 5.7388889e+00 9.000000e-01
+ 5.7389889e+00 0.000000e+00
+ 6.5193444e+00 0.000000e+00
+ 6.5194444e+00 9.000000e-01
+ 6.6694444e+00 9.000000e-01
+ 6.6695444e+00 0.000000e+00
+ 7.4860111e+00 0.000000e+00
+ 7.4861111e+00 9.000000e-01
+ 7.6361111e+00 9.000000e-01
+ 7.6362111e+00 0.000000e+00
+ 8.5582333e+00 0.000000e+00
+ 8.5583333e+00 9.000000e-01
+ 8.7083333e+00 9.000000e-01
+ 8.7084333e+00 0.000000e+00
+ 9.5804556e+00 0.000000e+00
+ 9.5805556e+00 9.000000e-01
+ 9.7305556e+00 9.000000e-01
+ 9.7306556e+00 0.000000e+00
+ 9.9277778e+00 0.000000e+00)
Vpwave_gate pwave_gate 0 PWL(
+ 0.0000000e+00 0.000000e+00
+ 1.7990000e-01 0.000000e+00
+ 1.8000000e-01 9.000000e-01
+ 2.8000000e-01 9.000000e-01
+ 2.8010000e-01 0.000000e+00
+ 1.3382333e+00 0.000000e+00
+ 1.3383333e+00 9.000000e-01
+ 1.4383333e+00 9.000000e-01
+ 1.4384333e+00 0.000000e+00
+ 2.3410111e+00 0.000000e+00
+ 2.3411111e+00 9.000000e-01
+ 2.4411111e+00 9.000000e-01
+ 2.4412111e+00 0.000000e+00
+ 3.3937889e+00 0.000000e+00
+ 3.3938889e+00 9.000000e-01
+ 3.4938889e+00 9.000000e-01
+ 3.4939889e+00 0.000000e+00
+ 4.4910111e+00 0.000000e+00
+ 4.4911111e+00 9.000000e-01
+ 4.5911111e+00 9.000000e-01
+ 4.5912111e+00 0.000000e+00
+ 5.5187889e+00 0.000000e+00
+ 5.5188889e+00 9.000000e-01
+ 5.6188889e+00 9.000000e-01
+ 5.6189889e+00 0.000000e+00
+ 6.4493444e+00 0.000000e+00
+ 6.4494444e+00 9.000000e-01
+ 6.5494444e+00 9.000000e-01
+ 6.5495444e+00 0.000000e+00
+ 7.4160111e+00 0.000000e+00
+ 7.4161111e+00 9.000000e-01
+ 7.5161111e+00 9.000000e-01
+ 7.5162111e+00 0.000000e+00
+ 8.4882333e+00 0.000000e+00
+ 8.4883333e+00 9.000000e-01
+ 8.5883333e+00 9.000000e-01
+ 8.5884333e+00 0.000000e+00
+ 9.5104556e+00 0.000000e+00
+ 9.5105556e+00 9.000000e-01
+ 9.6105556e+00 9.000000e-01
+ 9.6106556e+00 0.000000e+00
+ 9.9277778e+00 0.000000e+00)
Vsample_clk sample_clk 0 PWL(
+ 0.0000000e+00 0.000000e+00
+ 4.9990000e-01 0.000000e+00
+ 5.0000000e-01 9.000000e-01
+ 5.0200000e-01 9.000000e-01
+ 5.0210000e-01 0.000000e+00
+ 1.6582333e+00 0.000000e+00
+ 1.6583333e+00 9.000000e-01
+ 1.6603333e+00 9.000000e-01
+ 1.6604333e+00 0.000000e+00
+ 2.6610111e+00 0.000000e+00
+ 2.6611111e+00 9.000000e-01
+ 2.6631111e+00 9.000000e-01
+ 2.6632111e+00 0.000000e+00
+ 3.7137889e+00 0.000000e+00
+ 3.7138889e+00 9.000000e-01
+ 3.7158889e+00 9.000000e-01
+ 3.7159889e+00 0.000000e+00
+ 4.8110111e+00 0.000000e+00
+ 4.8111111e+00 9.000000e-01
+ 4.8131111e+00 9.000000e-01
+ 4.8132111e+00 0.000000e+00
+ 5.8387889e+00 0.000000e+00
+ 5.8388889e+00 9.000000e-01
+ 5.8408889e+00 9.000000e-01
+ 5.8409889e+00 0.000000e+00
+ 6.7693444e+00 0.000000e+00
+ 6.7694444e+00 9.000000e-01
+ 6.7714444e+00 9.000000e-01
+ 6.7715444e+00 0.000000e+00
+ 7.7360111e+00 0.000000e+00
+ 7.7361111e+00 9.000000e-01
+ 7.7381111e+00 9.000000e-01
+ 7.7382111e+00 0.000000e+00
+ 8.8082333e+00 0.000000e+00
+ 8.8083333e+00 9.000000e-01
+ 8.8103333e+00 9.000000e-01
+ 8.8104333e+00 0.000000e+00
+ 9.8304556e+00 0.000000e+00
+ 9.8305556e+00 9.000000e-01
+ 9.8325556e+00 9.000000e-01
+ 9.8326556e+00 0.000000e+00
+ 9.9277778e+00 0.000000e+00)
Vsample_clkb sample_clk_bar 0 PWL(
+ 0.0000000e+00 9.000000e-01
+ 4.9990000e-01 9.000000e-01
+ 5.0000000e-01 0.000000e+00
+ 5.0200000e-01 0.000000e+00
+ 5.0210000e-01 9.000000e-01
+ 1.6582333e+00 9.000000e-01
+ 1.6583333e+00 0.000000e+00
+ 1.6603333e+00 0.000000e+00
+ 1.6604333e+00 9.000000e-01
+ 2.6610111e+00 9.000000e-01
+ 2.6611111e+00 0.000000e+00
+ 2.6631111e+00 0.000000e+00
+ 2.6632111e+00 9.000000e-01
+ 3.7137889e+00 9.000000e-01
+ 3.7138889e+00 0.000000e+00
+ 3.7158889e+00 0.000000e+00
+ 3.7159889e+00 9.000000e-01
+ 4.8110111e+00 9.000000e-01
+ 4.8111111e+00 0.000000e+00
+ 4.8131111e+00 0.000000e+00
+ 4.8132111e+00 9.000000e-01
+ 5.8387889e+00 9.000000e-01
+ 5.8388889e+00 0.000000e+00
+ 5.8408889e+00 0.000000e+00
+ 5.8409889e+00 9.000000e-01
+ 6.7693444e+00 9.000000e-01
+ 6.7694444e+00 0.000000e+00
+ 6.7714444e+00 0.000000e+00
+ 6.7715444e+00 9.000000e-01
+ 7.7360111e+00 9.000000e-01
+ 7.7361111e+00 0.000000e+00
+ 7.7381111e+00 0.000000e+00
+ 7.7382111e+00 9.000000e-01
+ 8.8082333e+00 9.000000e-01
+ 8.8083333e+00 0.000000e+00
+ 8.8103333e+00 0.000000e+00
+ 8.8104333e+00 9.000000e-01
+ 9.8304556e+00 9.000000e-01
+ 9.8305556e+00 0.000000e+00
+ 9.8325556e+00 0.000000e+00
+ 9.8326556e+00 9.000000e-01
+ 9.9277778e+00 9.000000e-01)

* Stage 3: Feature Extraction
Xrr rpeak_trigger f_rr_ratio f_rr_asym vdd vss vbias rr_timing
Xinstab0 ecg_cond_L0 qrs_gate rpeak_trigger f_instab_L0 vdd vss vbias vref beat_instability
Xinstab1 ecg_cond_L1 qrs_gate rpeak_trigger f_instab_L1 vdd vss vbias vref beat_instability
Xpwave ecg_cond_L0 pwave_gate rpeak_trigger f_pwave vdd vss vbias vref pwave_energy
Xwidth vref ecg_cond_L0 qrs_gate rpeak_trigger f_width vdd vss vbias qrs_width
Xslope ecg_cond_L0 qrs_gate rpeak_trigger f_slope vdd vss vbias vref slope_ratio
Xsym qrs_gate rpeak_trigger f_width f_sym rpeak_trigger vdd vss vbias qrs_symmetry

* Stage 4: Sample-and-Hold
Xsh f_rr_ratio f_rr_asym f_instab_L0 f_instab_L1 f_pwave f_width f_slope f_sym
+ o_rr_ratio o_rr_asym o_instab_L0 o_instab_L1 o_pwave o_width o_slope o_sym
+ sample_clk sample_clk_bar vdd vss sh_bank

.tran 200u 9.927777777777777 uic

* Measure S&H outputs at each sample time
.meas tran f_rr_ratio_b0 FIND v(f_rr_ratio) AT=2.456111e+00
.meas tran f_rr_asym_b0 FIND v(f_rr_asym) AT=2.456111e+00
.meas tran f_instab_l0_b0 FIND v(f_instab_l0) AT=2.456111e+00
.meas tran f_instab_l1_b0 FIND v(f_instab_l1) AT=2.456111e+00
.meas tran f_pwave_b0 FIND v(f_pwave) AT=2.456111e+00
.meas tran f_width_b0 FIND v(f_width) AT=2.456111e+00
.meas tran f_slope_b0 FIND v(f_slope) AT=2.456111e+00
.meas tran f_sym_b0 FIND v(f_sym) AT=2.456111e+00
.meas tran f_rr_ratio_b1 FIND v(f_rr_ratio) AT=3.508889e+00
.meas tran f_rr_asym_b1 FIND v(f_rr_asym) AT=3.508889e+00
.meas tran f_instab_l0_b1 FIND v(f_instab_l0) AT=3.508889e+00
.meas tran f_instab_l1_b1 FIND v(f_instab_l1) AT=3.508889e+00
.meas tran f_pwave_b1 FIND v(f_pwave) AT=3.508889e+00
.meas tran f_width_b1 FIND v(f_width) AT=3.508889e+00
.meas tran f_slope_b1 FIND v(f_slope) AT=3.508889e+00
.meas tran f_sym_b1 FIND v(f_sym) AT=3.508889e+00
.meas tran f_rr_ratio_b2 FIND v(f_rr_ratio) AT=4.606111e+00
.meas tran f_rr_asym_b2 FIND v(f_rr_asym) AT=4.606111e+00
.meas tran f_instab_l0_b2 FIND v(f_instab_l0) AT=4.606111e+00
.meas tran f_instab_l1_b2 FIND v(f_instab_l1) AT=4.606111e+00
.meas tran f_pwave_b2 FIND v(f_pwave) AT=4.606111e+00
.meas tran f_width_b2 FIND v(f_width) AT=4.606111e+00
.meas tran f_slope_b2 FIND v(f_slope) AT=4.606111e+00
.meas tran f_sym_b2 FIND v(f_sym) AT=4.606111e+00
.meas tran f_rr_ratio_b3 FIND v(f_rr_ratio) AT=5.633889e+00
.meas tran f_rr_asym_b3 FIND v(f_rr_asym) AT=5.633889e+00
.meas tran f_instab_l0_b3 FIND v(f_instab_l0) AT=5.633889e+00
.meas tran f_instab_l1_b3 FIND v(f_instab_l1) AT=5.633889e+00
.meas tran f_pwave_b3 FIND v(f_pwave) AT=5.633889e+00
.meas tran f_width_b3 FIND v(f_width) AT=5.633889e+00
.meas tran f_slope_b3 FIND v(f_slope) AT=5.633889e+00
.meas tran f_sym_b3 FIND v(f_sym) AT=5.633889e+00
.meas tran f_rr_ratio_b4 FIND v(f_rr_ratio) AT=6.564444e+00
.meas tran f_rr_asym_b4 FIND v(f_rr_asym) AT=6.564444e+00
.meas tran f_instab_l0_b4 FIND v(f_instab_l0) AT=6.564444e+00
.meas tran f_instab_l1_b4 FIND v(f_instab_l1) AT=6.564444e+00
.meas tran f_pwave_b4 FIND v(f_pwave) AT=6.564444e+00
.meas tran f_width_b4 FIND v(f_width) AT=6.564444e+00
.meas tran f_slope_b4 FIND v(f_slope) AT=6.564444e+00
.meas tran f_sym_b4 FIND v(f_sym) AT=6.564444e+00
.meas tran f_rr_ratio_b5 FIND v(f_rr_ratio) AT=7.531111e+00
.meas tran f_rr_asym_b5 FIND v(f_rr_asym) AT=7.531111e+00
.meas tran f_instab_l0_b5 FIND v(f_instab_l0) AT=7.531111e+00
.meas tran f_instab_l1_b5 FIND v(f_instab_l1) AT=7.531111e+00
.meas tran f_pwave_b5 FIND v(f_pwave) AT=7.531111e+00
.meas tran f_width_b5 FIND v(f_width) AT=7.531111e+00
.meas tran f_slope_b5 FIND v(f_slope) AT=7.531111e+00
.meas tran f_sym_b5 FIND v(f_sym) AT=7.531111e+00
.meas tran f_rr_ratio_b6 FIND v(f_rr_ratio) AT=8.603333e+00
.meas tran f_rr_asym_b6 FIND v(f_rr_asym) AT=8.603333e+00
.meas tran f_instab_l0_b6 FIND v(f_instab_l0) AT=8.603333e+00
.meas tran f_instab_l1_b6 FIND v(f_instab_l1) AT=8.603333e+00
.meas tran f_pwave_b6 FIND v(f_pwave) AT=8.603333e+00
.meas tran f_width_b6 FIND v(f_width) AT=8.603333e+00
.meas tran f_slope_b6 FIND v(f_slope) AT=8.603333e+00
.meas tran f_sym_b6 FIND v(f_sym) AT=8.603333e+00

.control
  run
  echo "=== VALIDATION COMPLETE ==="
  quit
.endc

.end
