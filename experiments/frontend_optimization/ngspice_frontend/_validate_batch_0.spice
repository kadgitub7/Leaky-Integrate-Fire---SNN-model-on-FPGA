* Analog Frontend Validation - Batch 0
.title validate_batch_0

.lib "sky130_minimal.lib.spice" tt
.option scale=1.0u
.option method=gear
.option gmin=1e-15
.option abstol=1e-15
.option reltol=0.005
.temp 27

.include "ota_5t_subthreshold.spice"
.include "inverter.spice"
.include "resistor_div.spice"
.include "rr_timing.spice"
.include "beat_instability.spice"
.include "pwave_energy.spice"
.include "qrs_width.spice"
.include "slope_ratio.spice"
.include "qrs_symmetry.spice"

Vdd vdd 0 0.9
Vss vss 0 0
Vbias vbias 0 0.35
Vref vref 0 0.45

Vecg ecg_in 0 PWL(0.0000000 0.250000 0.2500000 0.010000 0.2527778 0.010000 0.2555556 0.010000 0.2583333 0.010000 0.2611111 0.010000 0.2638889 0.010000 0.2666667 0.010000 0.2694444 0.010000 0.2722222 0.010000 0.2750000 0.010000 0.2777778 0.010000 0.2805556 0.010000 0.2833333 0.010000 0.2861111 0.010000 0.2888889 0.010000 0.2916667 0.010000 0.2944444 0.010000 0.2972222 0.010000 0.3000000 0.010000 0.3027778 0.010000 0.3055556 0.010000 0.3083333 0.010000 0.3111111 0.010000 0.3138889 0.010000 0.3166667 0.010000 0.3194444 0.010000 0.3222222 0.010000 0.3250000 0.010000 0.3277778 0.010000 0.3305556 0.010000 0.3333333 0.010000 0.3361111 0.010000 0.3388889 0.010000 0.3416667 0.010000 0.3444444 0.010000 0.3472222 0.010000 0.3500000 0.010000 0.3527778 0.010000 0.3555556 0.016234 0.3583333 0.027922 0.3611111 0.039610 0.3638889 0.041280 0.3666667 0.031262 0.3694444 0.024583 0.3722222 0.014564 0.3750000 0.016234 0.3777778 0.021243 0.3805556 0.019573 0.3833333 0.014564 0.3861111 0.010000 0.3888889 0.010000 0.3916667 0.010000 0.3944444 0.010000 0.3972222 0.010000 0.4000000 0.010000 0.4027778 0.010000 0.4055556 0.010000 0.4083333 0.010000 0.4111111 0.010000 0.4138889 0.010000 0.4166667 0.010000 0.4194444 0.010000 0.4222222 0.010000 0.4250000 0.010000 0.4277778 0.010000 0.4305556 0.010000 0.4333333 0.010000 0.4361111 0.010000 0.4388889 0.010000 0.4416667 0.010000 0.4444444 0.010000 0.4472222 0.010000 0.4500000 0.010000 0.4527778 0.010000 0.4555556 0.010000 0.4583333 0.010000 0.4611111 0.010000 0.4638889 0.010000 0.4666667 0.010000 0.4694444 0.010000 0.4722222 0.010000 0.4750000 0.010000 0.4777778 0.010000 0.4805556 0.010000 0.4833333 0.057978 0.4861111 0.159833 0.4888889 0.278386 0.4916667 0.401948 0.4944444 0.510482 0.4972222 0.593970 0.5000000 0.632375 0.5027778 0.630705 0.5055556 0.580612 0.5083333 0.478757 0.5111111 0.330148 0.5138889 0.149814 0.5166667 0.010000 0.5194444 0.010000 0.5222222 0.010000 0.5250000 0.010000 0.5277778 0.010000 0.5305556 0.010000 0.5333333 0.010000 0.5361111 0.010000 0.5388889 0.010000 0.5416667 0.010000 0.5444444 0.010000 0.5472222 0.010000 0.5500000 0.010000 0.5527778 0.010000 0.5555556 0.010000 0.5583333 0.010000 0.5611111 0.010000 0.5638889 0.010000 0.5666667 0.010000 0.5694444 0.010000 0.5722222 0.010000 0.5750000 0.010000 0.5777778 0.010000 0.5805556 0.010000 0.5833333 0.010000 0.5861111 0.010000 0.5888889 0.010000 0.5916667 0.010000 0.5944444 0.010000 0.5972222 0.010000 0.6000000 0.010000 0.6027778 0.010000 0.6055556 0.010000 0.6083333 0.010000 0.6111111 0.010000 0.6138889 0.010000 0.6166667 0.010000 0.6194444 0.010000 0.6222222 0.010000 0.6250000 0.010000 0.6277778 0.010000 0.6305556 0.010000 0.6333333 0.010000 0.6361111 0.010000 0.6388889 0.010000 0.6416667 0.010000 0.6444444 0.010000 0.6472222 0.010000 0.6500000 0.010000 0.6527778 0.010000 0.6555556 0.010000 0.6583333 0.010000 0.6611111 0.010000 0.6638889 0.010000 0.6666667 0.010000 0.6694444 0.010000 0.6722222 0.010000 0.6750000 0.010000 0.6777778 0.010000 0.6805556 0.010000 0.6833333 0.010000 0.6861111 0.010000 0.6888889 0.010000 0.6916667 0.010000 0.6944444 0.010000 0.6972222 0.010000 0.7000000 0.010000 0.7027778 0.010000 0.7055556 0.010000 0.7083333 0.010000 0.7111111 0.010000 0.7138889 0.010000 0.7166667 0.010000 0.7194444 0.010000 0.7222222 0.010000 0.7250000 0.010000 0.7277778 0.010000 0.7305556 0.010000 0.7333333 0.010000 0.7361111 0.010000 0.7388889 0.010000 0.7416667 0.010000 0.7444444 0.010000 0.7472222 0.010000 0.7500000 0.010000 0.7527778 0.010000 0.7555556 0.010000 0.7583333 0.012894 0.7611111 0.017904 0.7638889 0.019573 0.7666667 0.024583 0.7694444 0.029592 0.7722222 0.032931 0.7750000 0.042950 0.7777778 0.042950 0.7805556 0.057978 0.7833333 0.067996 0.7861111 0.067996 0.7888889 0.071336 0.7916667 0.076345 0.7944444 0.078015 0.7972222 0.079685 1.1888889 0.010000 1.1916667 0.010000 1.1944444 0.010000 1.1972222 0.010000 1.2000000 0.010000 1.2027778 0.010000 1.2055556 0.010000 1.2083333 0.010000 1.2111111 0.010000 1.2138889 0.010000 1.2166667 0.010000 1.2194444 0.010000 1.2222222 0.010000 1.2250000 0.010000 1.2277778 0.010000 1.2305556 0.010000 1.2333333 0.010000 1.2361111 0.010000 1.2388889 0.010000 1.2416667 0.010000 1.2444444 0.010000 1.2472222 0.010000 1.2500000 0.010000 1.2527778 0.010000 1.2555556 0.010000 1.2583333 0.010000 1.2611111 0.010000 1.2638889 0.010000 1.2666667 0.012894 1.2694444 0.026252 1.2722222 0.037941 1.2750000 0.049629 1.2777778 0.054638 1.2805556 0.056308 1.2833333 0.052968 1.2861111 0.051299 1.2888889 0.046289 1.2916667 0.044620 1.2944444 0.044620 1.2972222 0.042950 1.3000000 0.032931 1.3027778 0.021243 1.3055556 0.010000 1.3083333 0.010000 1.3111111 0.010000 1.3138889 0.010000 1.3166667 0.010000 1.3194444 0.010000 1.3222222 0.010000 1.3250000 0.010000 1.3277778 0.010000 1.3305556 0.010000 1.3333333 0.010000 1.3361111 0.010000 1.3388889 0.010000 1.3416667 0.010000 1.3444444 0.010000 1.3472222 0.010000 1.3500000 0.010000 1.3527778 0.010000 1.3555556 0.010000 1.3583333 0.010000 1.3611111 0.010000 1.3638889 0.010000 1.3666667 0.010000 1.3694444 0.010000 1.3722222 0.010000 1.3750000 0.010000 1.3777778 0.010000 1.3805556 0.010000 1.3833333 0.010000 1.3861111 0.010000 1.3888889 0.010000 1.3916667 0.010000 1.3944444 0.010000 1.3972222 0.010000 1.4000000 0.010000 1.4027778 0.010000 1.4055556 0.010000 1.4083333 0.010000 1.4111111 0.010000 1.4138889 0.010000 1.4166667 0.017904 1.4194444 0.089703 1.4222222 0.174861 1.4250000 0.280056 1.4277778 0.381911 1.4305556 0.488776 1.4333333 0.568924 1.4361111 0.622356 1.4388889 0.640724 1.4416667 0.639054 1.4444444 0.615677 1.4472222 0.558905 1.4500000 0.463729 1.4527778 0.326809 1.4555556 0.161503 1.4583333 0.014564 1.4611111 0.010000 1.4638889 0.010000 1.4666667 0.010000 1.4694444 0.010000 1.4722222 0.010000 1.4750000 0.012894 1.4777778 0.016234 1.4805556 0.010000 1.4833333 0.010000 1.4861111 0.010000 1.4888889 0.010000 1.4916667 0.010000 1.4944444 0.010000 1.4972222 0.010000 1.5000000 0.010000 1.5027778 0.010000 1.5055556 0.010000 1.5083333 0.010000 1.5111111 0.010000 1.5138889 0.010000 1.5166667 0.010000 1.5194444 0.010000 1.5222222 0.010000 1.5250000 0.010000 1.5277778 0.010000 1.5305556 0.010000 1.5333333 0.010000 1.5361111 0.010000 1.5388889 0.010000 1.5416667 0.010000 1.5444444 0.010000 1.5472222 0.010000 1.5500000 0.010000 1.5527778 0.010000 1.5555556 0.010000 1.5583333 0.010000 1.5611111 0.010000 1.5638889 0.010000 1.5666667 0.010000 1.5694444 0.010000 1.5722222 0.010000 1.5750000 0.010000 1.5777778 0.010000 1.5805556 0.010000 1.5833333 0.010000 1.5861111 0.010000 1.5888889 0.010000 1.5916667 0.010000 1.5944444 0.010000 1.5972222 0.010000 1.6000000 0.010000 1.6027778 0.010000 1.6055556 0.010000 1.6083333 0.010000 1.6111111 0.010000 1.6138889 0.010000 1.6166667 0.010000 1.6194444 0.010000 1.6222222 0.010000 1.6250000 0.010000 1.6277778 0.010000 1.6305556 0.010000 1.6333333 0.010000 1.6361111 0.010000 1.6388889 0.010000 1.6416667 0.010000 1.6444444 0.010000 1.6472222 0.010000 1.6500000 0.010000 1.6527778 0.010000 1.6555556 0.010000 1.6583333 0.010000 1.6611111 0.010000 1.6638889 0.010000 1.6666667 0.010000 1.6694444 0.010000 1.6722222 0.010000 1.6750000 0.010000 1.6777778 0.010000 1.6805556 0.010000 1.6833333 0.010000 1.6861111 0.012894 1.6888889 0.012894 1.6916667 0.014564 1.6944444 0.024583 1.6972222 0.026252 1.7000000 0.032931 1.7027778 0.034601 1.7055556 0.041280 1.7083333 0.047959 1.7111111 0.052968 1.7138889 0.061317 1.7166667 0.071336 1.7194444 0.079685 1.7222222 0.083024 1.7250000 0.088033 1.7277778 0.088033 1.7305556 0.091373 1.7333333 0.093043 1.7361111 0.091373 2.1222222 0.010000 2.1250000 0.010000 2.1277778 0.010000 2.1305556 0.010000 2.1333333 0.010000 2.1361111 0.010000 2.1388889 0.010000 2.1416667 0.010000 2.1444444 0.010000 2.1472222 0.010000 2.1500000 0.010000 2.1527778 0.010000 2.1555556 0.010000 2.1583333 0.010000 2.1611111 0.010000 2.1638889 0.010000 2.1666667 0.010000 2.1694444 0.010000 2.1722222 0.010000 2.1750000 0.010000 2.1777778 0.010000 2.1805556 0.010000 2.1833333 0.010000 2.1861111 0.010000 2.1888889 0.010000 2.1916667 0.010000 2.1944444 0.010000 2.1972222 0.010000 2.2000000 0.010000 2.2027778 0.019573 2.2055556 0.032931 2.2083333 0.032931 2.2111111 0.036271 2.2138889 0.036271 2.2166667 0.034601 2.2194444 0.036271 2.2222222 0.032931 2.2250000 0.027922 2.2277778 0.029592 2.2305556 0.026252 2.2333333 0.010000 2.2361111 0.010000 2.2388889 0.010000 2.2416667 0.010000 2.2444444 0.010000 2.2472222 0.010000 2.2500000 0.010000 2.2527778 0.010000 2.2555556 0.010000 2.2583333 0.010000 2.2611111 0.010000 2.2638889 0.010000 2.2666667 0.010000 2.2694444 0.010000 2.2722222 0.010000 2.2750000 0.010000 2.2777778 0.010000 2.2805556 0.010000 2.2833333 0.010000 2.2861111 0.010000 2.2888889 0.010000 2.2916667 0.010000 2.2944444 0.010000 2.2972222 0.010000 2.3000000 0.010000 2.3027778 0.010000 2.3055556 0.010000 2.3083333 0.010000 2.3111111 0.010000 2.3138889 0.010000 2.3166667 0.010000 2.3194444 0.010000 2.3222222 0.010000 2.3250000 0.010000 2.3277778 0.010000 2.3305556 0.010000 2.3333333 0.010000 2.3361111 0.010000 2.3388889 0.010000 2.3416667 0.010000 2.3444444 0.010000 2.3472222 0.010000 2.3500000 0.010000 2.3527778 0.022913 2.3555556 0.106401 2.3583333 0.214935 2.3611111 0.335158 2.3638889 0.447032 2.3666667 0.543878 2.3694444 0.602319 2.3722222 0.620686 2.3750000 0.603989 2.3777778 0.553896 2.3805556 0.455380 2.3833333 0.315121 2.3861111 0.151484 2.3888889 0.010000 2.3916667 0.010000 2.3944444 0.010000 2.3972222 0.010000 2.4000000 0.010000 2.4027778 0.010000 2.4055556 0.010000 2.4083333 0.010000 2.4111111 0.010000 2.4138889 0.010000 2.4166667 0.010000 2.4194444 0.010000 2.4222222 0.010000 2.4250000 0.010000 2.4277778 0.010000 2.4305556 0.010000 2.4333333 0.010000 2.4361111 0.010000 2.4388889 0.010000 2.4416667 0.010000 2.4444444 0.010000 2.4472222 0.010000 2.4500000 0.010000 2.4527778 0.010000 2.4555556 0.010000 2.4583333 0.010000 2.4611111 0.010000 2.4638889 0.010000 2.4666667 0.010000 2.4694444 0.010000 2.4722222 0.010000 2.4750000 0.010000 2.4777778 0.010000 2.4805556 0.010000 2.4833333 0.010000 2.4861111 0.010000 2.4888889 0.010000 2.4916667 0.010000 2.4944444 0.010000 2.4972222 0.010000 2.5000000 0.010000 2.5027778 0.010000 2.5055556 0.010000 2.5083333 0.010000 2.5111111 0.010000 2.5138889 0.010000 2.5166667 0.010000 2.5194444 0.010000 2.5222222 0.010000 2.5250000 0.010000 2.5277778 0.010000 2.5305556 0.010000 2.5333333 0.010000 2.5361111 0.010000 2.5388889 0.010000 2.5416667 0.010000 2.5444444 0.010000 2.5472222 0.010000 2.5500000 0.010000 2.5527778 0.010000 2.5555556 0.010000 2.5583333 0.010000 2.5611111 0.010000 2.5638889 0.010000 2.5666667 0.010000 2.5694444 0.010000 2.5722222 0.010000 2.5750000 0.010000 2.5777778 0.010000 2.5805556 0.010000 2.5833333 0.010000 2.5861111 0.010000 2.5888889 0.010000 2.5916667 0.010000 2.5944444 0.010000 2.5972222 0.010000 2.6000000 0.010000 2.6027778 0.010000 2.6055556 0.010000 2.6083333 0.010000 2.6111111 0.010000 2.6138889 0.010000 2.6166667 0.010000 2.6194444 0.010000 2.6222222 0.011224 2.6250000 0.014564 2.6277778 0.014564 2.6305556 0.019573 2.6333333 0.021243 2.6361111 0.026252 2.6388889 0.029592 2.6416667 0.039610 2.6444444 0.037941 2.6472222 0.052968 2.6500000 0.062987 2.6527778 0.064657 2.6555556 0.073006 2.6583333 0.076345 2.6611111 0.076345 2.6638889 0.079685 2.6666667 0.079685 2.6694444 0.079685 3.0111111 0.010000 3.0138889 0.010000 3.0166667 0.010000 3.0194444 0.010000 3.0222222 0.010000 3.0250000 0.010000 3.0277778 0.010000 3.0305556 0.010000 3.0333333 0.010000 3.0361111 0.010000 3.0388889 0.010000 3.0416667 0.010000 3.0444444 0.010000 3.0472222 0.010000 3.0500000 0.010000 3.0527778 0.010000 3.0555556 0.010000 3.0583333 0.010000 3.0611111 0.010000 3.0638889 0.010000 3.0666667 0.010000 3.0694444 0.010000 3.0722222 0.010000 3.0750000 0.010000 3.0777778 0.010000 3.0805556 0.010000 3.0833333 0.010000 3.0861111 0.010000 3.0888889 0.010000 3.0916667 0.010000 3.0944444 0.010000 3.0972222 0.010000 3.1000000 0.010000 3.1027778 0.010000 3.1055556 0.012894 3.1083333 0.017904 3.1111111 0.016234 3.1138889 0.014564 3.1166667 0.010000 3.1194444 0.017904 3.1222222 0.012894 3.1250000 0.010000 3.1277778 0.010000 3.1305556 0.010000 3.1333333 0.010000 3.1361111 0.010000 3.1388889 0.010000 3.1416667 0.010000 3.1444444 0.010000 3.1472222 0.010000 3.1500000 0.010000 3.1527778 0.010000 3.1555556 0.010000 3.1583333 0.010000 3.1611111 0.010000 3.1638889 0.010000 3.1666667 0.010000 3.1694444 0.010000 3.1722222 0.010000 3.1750000 0.010000 3.1777778 0.010000 3.1805556 0.010000 3.1833333 0.010000 3.1861111 0.010000 3.1888889 0.010000 3.1916667 0.010000 3.1944444 0.010000 3.1972222 0.010000 3.2000000 0.010000 3.2027778 0.010000 3.2055556 0.010000 3.2083333 0.010000 3.2111111 0.010000 3.2138889 0.010000 3.2166667 0.010000 3.2194444 0.010000 3.2222222 0.010000 3.2250000 0.010000 3.2277778 0.010000 3.2305556 0.010000 3.2333333 0.010000 3.2361111 0.010000 3.2388889 0.010000 3.2416667 0.010000 3.2444444 0.057978 3.2472222 0.164842 3.2500000 0.298423 3.2527778 0.428664 3.2555556 0.538868 3.2583333 0.605659 3.2611111 0.639054 3.2638889 0.620686 3.2666667 0.550557 3.2694444 0.425325 3.2722222 0.244991 3.2750000 0.057978 3.2777778 0.010000 3.2805556 0.010000 3.2833333 0.010000 3.2861111 0.010000 3.2888889 0.010000 3.2916667 0.010000 3.2944444 0.010000 3.2972222 0.010000 3.3000000 0.010000 3.3027778 0.010000 3.3055556 0.010000 3.3083333 0.010000 3.3111111 0.010000 3.3138889 0.010000 3.3166667 0.010000 3.3194444 0.010000 3.3222222 0.010000 3.3250000 0.010000 3.3277778 0.010000 3.3305556 0.010000 3.3333333 0.010000 3.3361111 0.010000 3.3388889 0.010000 3.3416667 0.010000 3.3444444 0.010000 3.3472222 0.010000 3.3500000 0.010000 3.3527778 0.010000 3.3555556 0.010000 3.3583333 0.010000 3.3611111 0.010000 3.3638889 0.010000 3.3666667 0.010000 3.3694444 0.010000 3.3722222 0.010000 3.3750000 0.010000 3.3777778 0.010000 3.3805556 0.010000 3.3833333 0.010000 3.3861111 0.010000 3.3888889 0.010000 3.3916667 0.010000 3.3944444 0.010000 3.3972222 0.010000 3.4000000 0.010000 3.4027778 0.010000 3.4055556 0.010000 3.4083333 0.010000 3.4111111 0.010000 3.4138889 0.010000 3.4166667 0.010000 3.4194444 0.010000 3.4222222 0.010000 3.4250000 0.010000 3.4277778 0.010000 3.4305556 0.010000 3.4333333 0.010000 3.4361111 0.010000 3.4388889 0.010000 3.4416667 0.010000 3.4444444 0.010000 3.4472222 0.010000 3.4500000 0.010000 3.4527778 0.010000 3.4555556 0.010000 3.4583333 0.010000 3.4611111 0.010000 3.4638889 0.010000 3.4666667 0.010000 3.4694444 0.010000 3.4722222 0.010000 3.4750000 0.010000 3.4777778 0.010000 3.4805556 0.010000 3.4833333 0.010000 3.4861111 0.010000 3.4888889 0.010000 3.4916667 0.012894 3.4944444 0.010000 3.4972222 0.017904 3.5000000 0.024583 3.5027778 0.036271 3.5055556 0.041280 3.5083333 0.047959 3.5111111 0.059647 3.5138889 0.066327 3.5166667 0.073006 3.5194444 0.079685 3.5222222 0.088033 3.5250000 0.093043 3.5277778 0.093043 3.5305556 0.099722 3.5333333 0.101391 3.5361111 0.109740 3.5388889 0.108071 3.5416667 0.111410 3.5444444 0.113080 3.5472222 0.118089 3.5500000 0.118089 3.5527778 0.126438 3.5555556 0.116419 3.5583333 0.113080 3.9083333 0.010000 3.9111111 0.010000 3.9138889 0.010000 3.9166667 0.010000 3.9194444 0.010000 3.9222222 0.010000 3.9250000 0.010000 3.9277778 0.010000 3.9305556 0.010000 3.9333333 0.010000 3.9361111 0.010000 3.9388889 0.010000 3.9416667 0.010000 3.9444444 0.010000 3.9472222 0.010000 3.9500000 0.010000 3.9527778 0.010000 3.9555556 0.010000 3.9583333 0.010000 3.9611111 0.010000 3.9638889 0.010000 3.9666667 0.010000 3.9694444 0.010000 3.9722222 0.010000 3.9750000 0.010000 3.9777778 0.010000 3.9805556 0.010000 3.9833333 0.021243 3.9861111 0.039610 3.9888889 0.047959 3.9916667 0.052968 3.9944444 0.052968 3.9972222 0.049629 4.0000000 0.042950 4.0027778 0.037941 4.0055556 0.027922 4.0083333 0.034601 4.0111111 0.036271 4.0138889 0.034601 4.0166667 0.032931 4.0194444 0.012894 4.0222222 0.010000 4.0250000 0.010000 4.0277778 0.010000 4.0305556 0.010000 4.0333333 0.010000 4.0361111 0.010000 4.0388889 0.010000 4.0416667 0.010000 4.0444444 0.010000 4.0472222 0.010000 4.0500000 0.010000 4.0527778 0.010000 4.0555556 0.010000 4.0583333 0.010000 4.0611111 0.010000 4.0638889 0.010000 4.0666667 0.010000 4.0694444 0.010000 4.0722222 0.010000 4.0750000 0.010000 4.0777778 0.010000 4.0805556 0.010000 4.0833333 0.010000 4.0861111 0.010000 4.0888889 0.010000 4.0916667 0.010000 4.0944444 0.010000 4.0972222 0.010000 4.1000000 0.010000 4.1027778 0.010000 4.1055556 0.010000 4.1083333 0.010000 4.1111111 0.010000 4.1138889 0.010000 4.1166667 0.010000 4.1194444 0.010000 4.1222222 0.010000 4.1250000 0.010000 4.1277778 0.010000 4.1305556 0.010000 4.1333333 0.010000 4.1361111 0.010000 4.1388889 0.012894 4.1416667 0.099722 4.1444444 0.201577 4.1472222 0.325139 4.1500000 0.450371 4.1527778 0.557236 4.1555556 0.627365 4.1583333 0.652412 4.1611111 0.650742 4.1638889 0.612338 4.1666667 0.532189 4.1694444 0.400278 4.1722222 0.234972 4.1750000 0.059647 4.1777778 0.010000 4.1805556 0.010000 4.1833333 0.010000 4.1861111 0.010000 4.1888889 0.010000 4.1916667 0.010000 4.1944444 0.010000 4.1972222 0.010000 4.2000000 0.010000 4.2027778 0.010000 4.2055556 0.010000 4.2083333 0.010000 4.2111111 0.010000 4.2138889 0.010000 4.2166667 0.010000 4.2194444 0.010000 4.2222222 0.010000 4.2250000 0.010000 4.2277778 0.010000 4.2305556 0.010000 4.2333333 0.010000 4.2361111 0.010000 4.2388889 0.010000 4.2416667 0.010000 4.2444444 0.010000 4.2472222 0.010000 4.2500000 0.010000 4.2527778 0.010000 4.2555556 0.010000 4.2583333 0.010000 4.2611111 0.010000 4.2638889 0.010000 4.2666667 0.010000 4.2694444 0.010000 4.2722222 0.010000 4.2750000 0.010000 4.2777778 0.010000 4.2805556 0.010000 4.2833333 0.010000 4.2861111 0.010000 4.2888889 0.010000 4.2916667 0.010000 4.2944444 0.010000 4.2972222 0.010000 4.3000000 0.010000 4.3027778 0.010000 4.3055556 0.010000 4.3083333 0.010000 4.3111111 0.010000 4.3138889 0.010000 4.3166667 0.010000 4.3194444 0.010000 4.3222222 0.010000 4.3250000 0.010000 4.3277778 0.010000 4.3305556 0.010000 4.3333333 0.010000 4.3361111 0.010000 4.3388889 0.010000 4.3416667 0.010000 4.3444444 0.010000 4.3472222 0.010000 4.3500000 0.010000 4.3527778 0.010000 4.3555556 0.010000 4.3583333 0.010000 4.3611111 0.010000 4.3638889 0.010000 4.3666667 0.010000 4.3694444 0.010000 4.3722222 0.010000 4.3750000 0.010000 4.3777778 0.010000 4.3805556 0.010000 4.3833333 0.010000 4.3861111 0.010000 4.3888889 0.010000 4.3916667 0.010000 4.3944444 0.010000 4.3972222 0.010000 4.4000000 0.010000 4.4027778 0.010000 4.4055556 0.010000 4.4083333 0.010000 4.4111111 0.017904 4.4138889 0.026252 4.4166667 0.037941 4.4194444 0.049629 4.4222222 0.052968 4.4250000 0.057978 4.4277778 0.062987 4.4305556 0.069666 4.4333333 0.071336 4.4361111 0.078015 4.4388889 0.081354 4.4416667 0.089703 4.4444444 0.096382 4.4472222 0.104731 4.4500000 0.109740 4.4527778 0.116419 4.4555556 0.123098 4.4583333 0.131447 4.4611111 0.126438 4.4638889 0.128108 4.4666667 0.126438 4.4694444 0.124768 4.4722222 0.121429 4.4750000 0.116419 4.4777778 0.109740 4.4805556 0.103061 4.4833333 0.096382 4.4861111 0.093043 4.4888889 0.081354 4.4916667 0.071336 4.4944444 0.057978 4.4972222 0.039610 4.5000000 0.036271 4.5027778 0.019573 4.5055556 0.011224 4.5083333 0.010000 4.5111111 0.010000 4.5138889 0.010000 4.5166667 0.010000 4.5194444 0.010000 4.5222222 0.010000 4.5250000 0.010000 4.5277778 0.010000 4.5305556 0.010000 4.5333333 0.010000 4.5361111 0.010000 4.5388889 0.010000 4.5416667 0.010000 4.5444444 0.010000 4.5472222 0.010000 4.5500000 0.010000 4.5527778 0.010000 4.5555556 0.010000 4.5583333 0.010000 4.5611111 0.010000 4.5638889 0.010000 4.5666667 0.010000 4.5694444 0.010000 4.5722222 0.010000 4.5750000 0.010000 4.5777778 0.010000 4.5805556 0.010000 4.5833333 0.010000 4.5861111 0.010000 4.5888889 0.010000 4.5916667 0.010000 4.5944444 0.010000 4.5972222 0.010000 4.6000000 0.010000 4.6027778 0.010000 4.6055556 0.010000 4.6083333 0.010000 4.6111111 0.010000 4.6138889 0.010000 4.6166667 0.010000 4.6194444 0.010000 4.6222222 0.010000 4.6250000 0.010000 4.6277778 0.010000 4.6305556 0.010000 4.6333333 0.010000 4.6361111 0.010000 4.6388889 0.010000 4.6416667 0.010000 4.6444444 0.010000 4.6472222 0.010000 4.6500000 0.019573 4.6527778 0.064657 4.6555556 0.114750 4.6583333 0.156494 4.6611111 0.204917 4.6638889 0.251670 4.6666667 0.308442 4.6694444 0.370223 4.6722222 0.435343 4.6750000 0.510482 4.6777778 0.583952 4.6805556 0.655751 4.6833333 0.715863 4.6861111 0.774304 4.6888889 0.822727 4.6916667 0.850000 4.6944444 0.850000 4.6972222 0.850000 4.7000000 0.850000 4.7027778 0.850000 4.7055556 0.850000 4.7083333 0.850000 4.7111111 0.850000 4.7138889 0.829406 4.7166667 0.809369 4.7194444 0.794341 4.7222222 0.784323 4.7250000 0.785993 4.7277778 0.787662 4.7305556 0.774304 4.7333333 0.760946 4.7361111 0.730891 4.7388889 0.684137 4.7416667 0.634045 4.7444444 0.578942 4.7472222 0.510482 4.7500000 0.426994 4.7527778 0.310111 4.7555556 0.179870 4.7583333 0.049629 4.7611111 0.010000 4.7638889 0.010000 4.7666667 0.010000 4.7694444 0.010000 4.7722222 0.010000 4.7750000 0.010000 4.7777778 0.010000 4.7805556 0.010000 4.7833333 0.010000 4.7861111 0.010000 4.7888889 0.010000 4.7916667 0.010000 4.7944444 0.010000 4.7972222 0.010000 4.8000000 0.010000 4.8027778 0.010000 4.8055556 0.010000 4.8083333 0.010000 4.8111111 0.010000 4.8138889 0.010000 4.8166667 0.010000 4.8194444 0.010000 4.8222222 0.010000 4.8250000 0.010000 4.8277778 0.010000 4.8305556 0.010000 4.8333333 0.010000 4.8361111 0.010000 4.8388889 0.010000 4.8416667 0.010000 4.8444444 0.010000 4.8472222 0.010000 4.8500000 0.010000 4.8527778 0.010000 4.8555556 0.010000 4.8583333 0.010000 4.8611111 0.010000 4.8638889 0.010000 4.8666667 0.010000 4.8694444 0.010000 4.8722222 0.010000 4.8750000 0.010000 4.8777778 0.010000 4.8805556 0.010000 4.8833333 0.010000 4.8861111 0.010000 4.8888889 0.010000 4.8916667 0.010000 4.8944444 0.010000 4.8972222 0.010000 4.9000000 0.010000 4.9027778 0.010000 4.9055556 0.010000 4.9083333 0.010000 4.9111111 0.010000 4.9138889 0.010000 4.9166667 0.010000 4.9194444 0.010000 4.9222222 0.010000 4.9250000 0.010000 4.9277778 0.010000 4.9305556 0.010000 4.9333333 0.010000 4.9361111 0.010000 4.9388889 0.010000 4.9416667 0.010000 4.9444444 0.010000 4.9472222 0.010000 4.9500000 0.010000 4.9527778 0.010000 4.9555556 0.010000 4.9583333 0.010000 4.9611111 0.010000 4.9638889 0.010000 4.9666667 0.010000 4.9694444 0.010000 4.9722222 0.010000 4.9750000 0.010000 4.9777778 0.010000 4.9805556 0.010000 4.9833333 0.010000 4.9861111 0.010000 4.9888889 0.010000 4.9916667 0.010000 4.9944444 0.010000 5.7472222 0.010000 5.7500000 0.010000 5.7527778 0.010000 5.7555556 0.010000 5.7583333 0.010000 5.7611111 0.010000 5.7638889 0.010000 5.7666667 0.010000 5.7694444 0.010000 5.7722222 0.010000 5.7750000 0.010000 5.7777778 0.010000 5.7805556 0.010000 5.7833333 0.010000 5.7861111 0.010000 5.7888889 0.010000 5.7916667 0.010000 5.7944444 0.010000 5.7972222 0.010000 5.8000000 0.010000 5.8027778 0.010000 5.8055556 0.010000 5.8083333 0.010000 5.8111111 0.010000 5.8138889 0.010000 5.8166667 0.010000 5.8194444 0.010000 5.8222222 0.010000 5.8250000 0.010000 5.8277778 0.010000 5.8305556 0.010000 5.8333333 0.010000 5.8361111 0.010000 5.8388889 0.010000 5.8416667 0.019573 5.8444444 0.031262 5.8472222 0.047959 5.8500000 0.064657 5.8527778 0.076345 5.8555556 0.076345 5.8583333 0.076345 5.8611111 0.067996 5.8638889 0.067996 5.8666667 0.056308 5.8694444 0.057978 5.8722222 0.057978 5.8750000 0.057978 5.8777778 0.054638 5.8805556 0.047959 5.8833333 0.034601 5.8861111 0.021243 5.8888889 0.010000 5.8916667 0.010000 5.8944444 0.010000 5.8972222 0.010000 5.9000000 0.010000 5.9027778 0.010000 5.9055556 0.010000 5.9083333 0.010000 5.9111111 0.010000 5.9138889 0.010000 5.9166667 0.010000 5.9194444 0.010000 5.9222222 0.010000 5.9250000 0.010000 5.9277778 0.010000 5.9305556 0.010000 5.9333333 0.010000 5.9361111 0.010000 5.9388889 0.010000 5.9416667 0.010000 5.9444444 0.010000 5.9472222 0.010000 5.9500000 0.010000 5.9527778 0.010000 5.9555556 0.010000 5.9583333 0.010000 5.9611111 0.010000 5.9638889 0.010000 5.9666667 0.010000 5.9694444 0.010000 5.9722222 0.010000 5.9750000 0.010000 5.9777778 0.074675 5.9805556 0.163173 5.9833333 0.273377 5.9861111 0.395269 5.9888889 0.515492 5.9916667 0.608998 5.9944444 0.675788 5.9972222 0.699165 6.0000000 0.690816 6.0027778 0.647403 6.0055556 0.562245 6.0083333 0.432004 6.0111111 0.265028 6.0138889 0.096382 6.0166667 0.010000 6.0194444 0.010000 6.0222222 0.010000 6.0250000 0.010000 6.0277778 0.010000 6.0305556 0.026252 6.0333333 0.027922 6.0361111 0.017904 6.0388889 0.010000 6.0416667 0.010000 6.0444444 0.010000 6.0472222 0.010000 6.0500000 0.010000 6.0527778 0.010000 6.0555556 0.010000 6.0583333 0.010000 6.0611111 0.010000 6.0638889 0.010000 6.0666667 0.010000 6.0694444 0.010000 6.0722222 0.010000 6.0750000 0.010000 6.0777778 0.010000 6.0805556 0.010000 6.0833333 0.010000 6.0861111 0.010000 6.0888889 0.010000 6.0916667 0.010000 6.0944444 0.010000 6.0972222 0.010000 6.1000000 0.010000 6.1027778 0.010000 6.1055556 0.010000 6.1083333 0.010000 6.1111111 0.010000 6.1138889 0.010000 6.1166667 0.010000 6.1194444 0.010000 6.1222222 0.010000 6.1250000 0.010000 6.1277778 0.010000 6.1305556 0.010000 6.1333333 0.010000 6.1361111 0.010000 6.1388889 0.010000 6.1416667 0.010000 6.1444444 0.010000 6.1472222 0.010000 6.1500000 0.010000 6.1527778 0.010000 6.1555556 0.010000 6.1583333 0.010000 6.1611111 0.010000 6.1638889 0.010000 6.1666667 0.010000 6.1694444 0.010000 6.1722222 0.010000 6.1750000 0.010000 6.1777778 0.010000 6.1805556 0.010000 6.1833333 0.010000 6.1861111 0.010000 6.1888889 0.010000 6.1916667 0.010000 6.1944444 0.010000 6.1972222 0.010000 6.2000000 0.010000 6.2027778 0.010000 6.2055556 0.010000 6.2083333 0.010000 6.2111111 0.010000 6.2138889 0.010000 6.2166667 0.010000 6.2194444 0.010000 6.2222222 0.010000 6.2250000 0.010000 6.2277778 0.010000 6.2305556 0.010000 6.2333333 0.010000 6.2361111 0.010000 6.2388889 0.010000 6.2416667 0.010000 6.2444444 0.017904 6.2472222 0.026252 6.2500000 0.032931 6.2527778 0.042950 6.2555556 0.047959 6.2583333 0.051299 6.2611111 0.057978 6.2638889 0.059647 6.2666667 0.061317 6.2694444 0.064657 6.2722222 0.067996 6.2750000 0.071336 6.2777778 0.078015 6.2805556 0.089703 6.2833333 0.091373 6.2861111 0.094712 6.2888889 0.104731 6.2916667 0.108071 6.2944444 0.113080 6.6916667 0.010000 6.6944444 0.010000 6.6972222 0.010000 6.7000000 0.010000 6.7027778 0.010000 6.7055556 0.010000 6.7083333 0.010000 6.7111111 0.010000 6.7138889 0.010000 6.7166667 0.010000 6.7194444 0.010000 6.7222222 0.010000 6.7250000 0.010000 6.7277778 0.010000 6.7305556 0.010000 6.7333333 0.010000 6.7361111 0.010000 6.7388889 0.010000 6.7416667 0.010000 6.7444444 0.010000 6.7472222 0.010000 6.7500000 0.010000 6.7527778 0.010000 6.7555556 0.010000 6.7583333 0.010000 6.7611111 0.010000 6.7638889 0.010000 6.7666667 0.010000 6.7694444 0.010000 6.7722222 0.016234 6.7750000 0.019573 6.7777778 0.031262 6.7805556 0.052968 6.7833333 0.062987 6.7861111 0.076345 6.7888889 0.084694 6.7916667 0.078015 6.7944444 0.071336 6.7972222 0.061317 6.8000000 0.059647 6.8027778 0.061317 6.8055556 0.054638 6.8083333 0.057978 6.8111111 0.052968 6.8138889 0.051299 6.8166667 0.047959 6.8194444 0.032931 6.8222222 0.014564 6.8250000 0.010000 6.8277778 0.010000 6.8305556 0.010000 6.8333333 0.010000 6.8361111 0.010000 6.8388889 0.010000 6.8416667 0.010000 6.8444444 0.010000 6.8472222 0.010000 6.8500000 0.010000 6.8527778 0.010000 6.8555556 0.010000 6.8583333 0.010000 6.8611111 0.010000 6.8638889 0.010000 6.8666667 0.010000 6.8694444 0.010000 6.8722222 0.010000 6.8750000 0.010000 6.8777778 0.010000 6.8805556 0.010000 6.8833333 0.010000 6.8861111 0.010000 6.8888889 0.010000 6.8916667 0.010000 6.8944444 0.010000 6.8972222 0.010000 6.9000000 0.010000 6.9027778 0.010000 6.9055556 0.010000 6.9083333 0.010000 6.9111111 0.010000 6.9138889 0.010000 6.9166667 0.010000 6.9194444 0.010000 6.9222222 0.016234 6.9250000 0.083024 6.9277778 0.188219 6.9305556 0.301763 6.9333333 0.428664 6.9361111 0.543878 6.9388889 0.627365 6.9416667 0.677458 6.9444444 0.680798 6.9472222 0.660761 6.9500000 0.595640 6.9527778 0.487106 6.9555556 0.333488 6.9583333 0.154824 6.9611111 0.011224 6.9638889 0.010000 6.9666667 0.010000 6.9694444 0.010000 6.9722222 0.010000 6.9750000 0.010000 6.9777778 0.027922 6.9805556 0.026252 6.9833333 0.012894 6.9861111 0.010000 6.9888889 0.010000 6.9916667 0.010000 6.9944444 0.010000 6.9972222 0.010000 7.0000000 0.010000 7.0027778 0.010000 7.0055556 0.010000 7.0083333 0.010000 7.0111111 0.010000 7.0138889 0.010000 7.0166667 0.010000 7.0194444 0.010000 7.0222222 0.010000 7.0250000 0.010000 7.0277778 0.010000 7.0305556 0.010000 7.0333333 0.010000 7.0361111 0.010000 7.0388889 0.010000 7.0416667 0.010000 7.0444444 0.010000 7.0472222 0.010000 7.0500000 0.010000 7.0527778 0.010000 7.0555556 0.010000 7.0583333 0.010000 7.0611111 0.010000 7.0638889 0.010000 7.0666667 0.010000 7.0694444 0.010000 7.0722222 0.010000 7.0750000 0.010000 7.0777778 0.010000 7.0805556 0.010000 7.0833333 0.010000 7.0861111 0.010000 7.0888889 0.010000 7.0916667 0.010000 7.0944444 0.010000 7.0972222 0.010000 7.1000000 0.010000 7.1027778 0.010000 7.1055556 0.010000 7.1083333 0.010000 7.1111111 0.010000 7.1138889 0.010000 7.1166667 0.010000 7.1194444 0.010000 7.1222222 0.010000 7.1250000 0.010000 7.1277778 0.010000 7.1305556 0.010000 7.1333333 0.010000 7.1361111 0.010000 7.1388889 0.010000 7.1416667 0.010000 7.1444444 0.010000 7.1472222 0.010000 7.1500000 0.010000 7.1527778 0.010000 7.1555556 0.010000 7.1583333 0.010000 7.1611111 0.010000 7.1638889 0.010000 7.1666667 0.010000 7.1694444 0.010000 7.1722222 0.010000 7.1750000 0.012894 7.1777778 0.014564 7.1805556 0.026252 7.1833333 0.027922 7.1861111 0.042950 7.1888889 0.051299 7.1916667 0.061317 7.1944444 0.062987 7.1972222 0.069666 7.2000000 0.071336 7.2027778 0.071336 7.2055556 0.078015 7.2083333 0.083024 7.2111111 0.091373 7.2138889 0.101391 7.2166667 0.113080 7.2194444 0.123098 7.2222222 0.129777 7.2250000 0.133117 7.2277778 0.139796 7.2305556 0.134787 7.2333333 0.138126 7.2361111 0.143135 7.2388889 0.139796 7.5722222 0.010000 7.5750000 0.010000 7.5777778 0.010000 7.5805556 0.010000 7.5833333 0.010000 7.5861111 0.010000 7.5888889 0.010000 7.5916667 0.010000 7.5944444 0.010000 7.5972222 0.010000 7.6000000 0.010000 7.6027778 0.010000 7.6055556 0.010000 7.6083333 0.010000 7.6111111 0.010000 7.6138889 0.010000 7.6166667 0.010000 7.6194444 0.010000 7.6222222 0.010000 7.6250000 0.010000 7.6277778 0.010000 7.6305556 0.010000 7.6333333 0.010000 7.6361111 0.010000 7.6388889 0.010000 7.6416667 0.010000 7.6444444 0.010000 7.6472222 0.010000 7.6500000 0.010000 7.6527778 0.011224 7.6555556 0.027922 7.6583333 0.039610 7.6611111 0.054638 7.6638889 0.054638 7.6666667 0.062987 7.6694444 0.059647 7.6722222 0.054638 7.6750000 0.052968 7.6777778 0.052968 7.6805556 0.056308 7.6833333 0.061317 7.6861111 0.057978 7.6888889 0.052968 7.6916667 0.039610 7.6944444 0.017904 7.6972222 0.010000 7.7000000 0.010000 7.7027778 0.010000 7.7055556 0.010000 7.7083333 0.010000 7.7111111 0.010000 7.7138889 0.010000 7.7166667 0.010000 7.7194444 0.010000 7.7222222 0.010000 7.7250000 0.010000 7.7277778 0.010000 7.7305556 0.010000 7.7333333 0.010000 7.7361111 0.010000 7.7388889 0.010000 7.7416667 0.010000 7.7444444 0.010000 7.7472222 0.010000 7.7500000 0.010000 7.7527778 0.010000 7.7555556 0.010000 7.7583333 0.010000 7.7611111 0.010000 7.7638889 0.010000 7.7666667 0.010000 7.7694444 0.010000 7.7722222 0.010000 7.7750000 0.010000 7.7777778 0.010000 7.7805556 0.010000 7.7833333 0.010000 7.7861111 0.010000 7.7888889 0.010000 7.7916667 0.010000 7.7944444 0.010000 7.7972222 0.010000 7.8000000 0.010000 7.8027778 0.021243 7.8055556 0.091373 7.8083333 0.193228 7.8111111 0.315121 7.8138889 0.442022 7.8166667 0.548887 7.8194444 0.629035 7.8222222 0.672449 7.8250000 0.679128 7.8277778 0.650742 7.8305556 0.578942 7.8333333 0.473748 7.8361111 0.328479 7.8388889 0.146475 7.8416667 0.010000 7.8444444 0.010000 7.8472222 0.010000 7.8500000 0.010000 7.8527778 0.010000 7.8555556 0.010000 7.8583333 0.016234 7.8611111 0.014564 7.8638889 0.010000 7.8666667 0.010000 7.8694444 0.010000 7.8722222 0.010000 7.8750000 0.010000 7.8777778 0.010000 7.8805556 0.010000 7.8833333 0.010000 7.8861111 0.010000 7.8888889 0.010000 7.8916667 0.010000 7.8944444 0.010000 7.8972222 0.010000 7.9000000 0.010000 7.9027778 0.010000 7.9055556 0.010000 7.9083333 0.010000 7.9111111 0.010000 7.9138889 0.010000 7.9166667 0.010000 7.9194444 0.010000 7.9222222 0.010000 7.9250000 0.010000 7.9277778 0.010000 7.9305556 0.010000 7.9333333 0.010000 7.9361111 0.010000 7.9388889 0.010000 7.9416667 0.010000 7.9444444 0.010000 7.9472222 0.010000 7.9500000 0.010000 7.9527778 0.010000 7.9555556 0.010000 7.9583333 0.010000 7.9611111 0.010000 7.9638889 0.010000 7.9666667 0.010000 7.9694444 0.010000 7.9722222 0.010000 7.9750000 0.010000 7.9777778 0.010000 7.9805556 0.010000 7.9833333 0.010000 7.9861111 0.010000 7.9888889 0.010000 7.9916667 0.010000 7.9944444 0.010000 7.9972222 0.010000 8.0000000 0.010000 8.0027778 0.010000 8.0055556 0.010000 8.0083333 0.010000 8.0111111 0.010000 8.0138889 0.010000 8.0166667 0.010000 8.0194444 0.010000 8.0222222 0.010000 8.0250000 0.010000 8.0277778 0.010000 8.0305556 0.010000 8.0333333 0.010000 8.0361111 0.010000 8.0388889 0.010000 8.0416667 0.010000 8.0444444 0.010000 8.0472222 0.010000 8.0500000 0.010000 8.0527778 0.010000 8.0555556 0.010000 8.0583333 0.010000 8.0611111 0.010000 8.0638889 0.010000 8.0666667 0.011224 8.0694444 0.014564 8.0722222 0.022913 8.0750000 0.029592 8.0777778 0.037941 8.0805556 0.046289 8.0833333 0.061317 8.0861111 0.066327 8.0888889 0.073006 8.0916667 0.074675 8.0944444 0.079685 8.0972222 0.088033 8.1000000 0.091373 8.1027778 0.091373 8.1055556 0.096382 8.1083333 0.098052 8.1111111 0.106401 8.1138889 0.113080 8.1166667 0.118089 8.1194444 0.119759 8.4333333 0.010000 8.4361111 0.010000 8.4388889 0.010000 8.4416667 0.010000 8.4444444 0.010000 8.4472222 0.010000 8.4500000 0.010000 8.4527778 0.010000 8.4555556 0.010000 8.4583333 0.010000 8.4611111 0.010000 8.4638889 0.010000 8.4666667 0.010000 8.4694444 0.010000 8.4722222 0.010000 8.4750000 0.010000 8.4777778 0.010000 8.4805556 0.010000 8.4833333 0.010000 8.4861111 0.010000 8.4888889 0.010000 8.4916667 0.010000 8.4944444 0.010000 8.4972222 0.010000 8.5000000 0.010000 8.5027778 0.010000 8.5055556 0.010000 8.5083333 0.010000 8.5111111 0.010000 8.5138889 0.012894 8.5166667 0.026252 8.5194444 0.032931 8.5222222 0.036271 8.5250000 0.036271 8.5277778 0.027922 8.5305556 0.022913 8.5333333 0.019573 8.5361111 0.021243 8.5388889 0.012894 8.5416667 0.010000 8.5444444 0.010000 8.5472222 0.010000 8.5500000 0.010000 8.5527778 0.010000 8.5555556 0.010000 8.5583333 0.010000 8.5611111 0.010000 8.5638889 0.010000 8.5666667 0.010000 8.5694444 0.010000 8.5722222 0.010000 8.5750000 0.010000 8.5777778 0.010000 8.5805556 0.010000 8.5833333 0.010000 8.5861111 0.010000 8.5888889 0.010000 8.5916667 0.010000 8.5944444 0.010000 8.5972222 0.010000 8.6000000 0.010000 8.6027778 0.010000 8.6055556 0.010000 8.6083333 0.010000 8.6111111 0.010000 8.6138889 0.010000 8.6166667 0.010000 8.6194444 0.010000 8.6222222 0.010000 8.6250000 0.010000 8.6277778 0.010000 8.6305556 0.010000 8.6333333 0.010000 8.6361111 0.010000 8.6388889 0.010000 8.6416667 0.010000 8.6444444 0.010000 8.6472222 0.010000 8.6500000 0.010000 8.6527778 0.010000 8.6555556 0.010000 8.6583333 0.010000 8.6611111 0.010000 8.6638889 0.010000 8.6666667 0.057978 8.6694444 0.153154 8.6722222 0.266698 8.6750000 0.386920 8.6777778 0.497124 8.6805556 0.582282 8.6833333 0.632375 8.6861111 0.647403 8.6888889 0.627365 8.6916667 0.568924 8.6944444 0.460390 8.6972222 0.313451 8.7000000 0.136456 8.7027778 0.010000 8.7055556 0.010000 8.7083333 0.010000 8.7111111 0.010000 8.7138889 0.010000 8.7166667 0.010000 8.7194444 0.010000 8.7222222 0.010000 8.7250000 0.010000 8.7277778 0.010000 8.7305556 0.010000 8.7333333 0.010000 8.7361111 0.010000 8.7388889 0.010000 8.7416667 0.010000 8.7444444 0.010000 8.7472222 0.010000 8.7500000 0.010000 8.7527778 0.010000 8.7555556 0.010000 8.7583333 0.010000 8.7611111 0.010000 8.7638889 0.010000 8.7666667 0.010000 8.7694444 0.010000 8.7722222 0.010000 8.7750000 0.010000 8.7777778 0.010000 8.7805556 0.010000 8.7833333 0.010000 8.7861111 0.010000 8.7888889 0.010000 8.7916667 0.010000 8.7944444 0.010000 8.7972222 0.010000 8.8000000 0.010000 8.8027778 0.010000 8.8055556 0.010000 8.8083333 0.010000 8.8111111 0.010000 8.8138889 0.010000 8.8166667 0.010000 8.8194444 0.010000 8.8222222 0.010000 8.8250000 0.010000 8.8277778 0.010000 8.8305556 0.010000 8.8333333 0.010000 8.8361111 0.010000 8.8388889 0.010000 8.8416667 0.010000 8.8444444 0.010000 8.8472222 0.010000 8.8500000 0.010000 8.8527778 0.010000 8.8555556 0.010000 8.8583333 0.010000 8.8611111 0.010000 8.8638889 0.010000 8.8666667 0.010000 8.8694444 0.010000 8.8722222 0.010000 8.8750000 0.010000 8.8777778 0.010000 8.8805556 0.010000 8.8833333 0.010000 8.8861111 0.010000 8.8888889 0.010000 8.8916667 0.010000 8.8944444 0.010000 8.8972222 0.010000 8.9000000 0.010000 8.9027778 0.010000 8.9055556 0.010000 8.9083333 0.010000 8.9111111 0.010000 8.9138889 0.010000 8.9166667 0.010000 8.9194444 0.010000 8.9222222 0.010000 8.9250000 0.010000 8.9277778 0.010000 8.9305556 0.010000 8.9333333 0.010000 8.9361111 0.010000 8.9388889 0.014564 8.9416667 0.016234 8.9444444 0.027922 8.9472222 0.032931 8.9500000 0.042950 8.9527778 0.051299 8.9555556 0.064657 8.9583333 0.071336 8.9611111 0.079685 8.9638889 0.076345 8.9666667 0.088033 8.9694444 0.084694 8.9722222 0.088033 8.9750000 0.094712 8.9777778 0.103061 8.9805556 0.108071 9.3611111 0.010000 9.3638889 0.010000 9.3666667 0.010000 9.3694444 0.010000 9.3722222 0.010000 9.3750000 0.010000 9.3777778 0.010000 9.3805556 0.010000 9.3833333 0.010000 9.3861111 0.010000 9.3888889 0.010000 9.3916667 0.010000 9.3944444 0.010000 9.3972222 0.010000 9.4000000 0.010000 9.4027778 0.010000 9.4055556 0.010000 9.4083333 0.010000 9.4111111 0.010000 9.4138889 0.010000 9.4166667 0.010000 9.4194444 0.010000 9.4222222 0.010000 9.4250000 0.010000 9.4277778 0.010000 9.4305556 0.010000 9.4333333 0.010000 9.4361111 0.010000 9.4388889 0.012894 9.4416667 0.022913 9.4444444 0.037941 9.4472222 0.051299 9.4500000 0.061317 9.4527778 0.069666 9.4555556 0.066327 9.4583333 0.067996 9.4611111 0.057978 9.4638889 0.054638 9.4666667 0.051299 9.4694444 0.052968 9.4722222 0.044620 9.4750000 0.037941 9.4777778 0.031262 9.4805556 0.016234 9.4833333 0.010000 9.4861111 0.010000 9.4888889 0.010000 9.4916667 0.010000 9.4944444 0.010000 9.4972222 0.010000 9.5000000 0.010000 9.5027778 0.010000 9.5055556 0.010000 9.5083333 0.010000 9.5111111 0.010000 9.5138889 0.010000 9.5166667 0.010000 9.5194444 0.010000 9.5222222 0.010000 9.5250000 0.010000 9.5277778 0.010000 9.5305556 0.010000 9.5333333 0.010000 9.5361111 0.010000 9.5388889 0.010000 9.5416667 0.010000 9.5444444 0.010000 9.5472222 0.010000 9.5500000 0.010000 9.5527778 0.010000 9.5555556 0.010000 9.5583333 0.010000 9.5611111 0.010000 9.5638889 0.010000 9.5666667 0.010000 9.5694444 0.010000 9.5722222 0.010000 9.5750000 0.010000 9.5777778 0.010000 9.5805556 0.010000 9.5833333 0.010000 9.5861111 0.010000 9.5888889 0.010000 9.5916667 0.010000 9.5944444 0.084694 9.5972222 0.178200 9.6000000 0.298423 9.6027778 0.425325 9.6055556 0.530519 9.6083333 0.615677 9.6111111 0.652412 9.6138889 0.662430 9.6166667 0.632375 9.6194444 0.565584 9.6222222 0.465399 9.6250000 0.300093 9.6277778 0.128108 9.6305556 0.010000 9.6333333 0.010000 9.6361111 0.010000 9.6388889 0.010000 9.6416667 0.010000 9.6444444 0.010000 9.6472222 0.017904 9.6500000 0.011224 9.6527778 0.010000 9.6555556 0.010000 9.6583333 0.010000 9.6611111 0.010000 9.6638889 0.010000 9.6666667 0.010000 9.6694444 0.010000 9.6722222 0.010000 9.6750000 0.010000 9.6777778 0.010000 9.6805556 0.010000 9.6833333 0.010000 9.6861111 0.010000 9.6888889 0.010000 9.6916667 0.010000 9.6944444 0.010000 9.6972222 0.010000 9.7000000 0.010000 9.7027778 0.010000 9.7055556 0.010000 9.7083333 0.010000 9.7111111 0.010000 9.7138889 0.010000 9.7166667 0.010000 9.7194444 0.010000 9.7222222 0.010000 9.7250000 0.010000 9.7277778 0.010000 9.7305556 0.010000 9.7333333 0.010000 9.7361111 0.010000 9.7388889 0.010000 9.7416667 0.010000 9.7444444 0.010000 9.7472222 0.010000 9.7500000 0.010000 9.7527778 0.010000 9.7555556 0.010000 9.7583333 0.010000 9.7611111 0.010000 9.7638889 0.010000 9.7666667 0.010000 9.7694444 0.010000 9.7722222 0.010000 9.7750000 0.010000 9.7777778 0.010000 9.7805556 0.010000 9.7833333 0.010000 9.7861111 0.010000 9.7888889 0.010000 9.7916667 0.010000 9.7944444 0.010000 9.7972222 0.010000 9.8000000 0.010000 9.8027778 0.010000 9.8055556 0.010000 9.8083333 0.010000 9.8111111 0.010000 9.8138889 0.010000 9.8166667 0.010000 9.8194444 0.010000 9.8222222 0.010000 9.8250000 0.010000 9.8277778 0.010000 9.8305556 0.010000 9.8333333 0.010000 9.8361111 0.010000 9.8388889 0.010000 9.8416667 0.010000 9.8444444 0.010000 9.8472222 0.010000 9.8500000 0.019573 9.8527778 0.027922 9.8555556 0.044620 9.8583333 0.047959 9.8611111 0.047959 9.8638889 0.056308 9.8666667 0.059647 9.8694444 0.067996 9.8722222 0.069666 9.8750000 0.079685 9.8777778 0.081354 9.8805556 0.093043 9.8833333 0.108071 9.8861111 0.114750 9.8888889 0.128108 9.8916667 0.128108 9.8944444 0.131447 9.8972222 0.134787 9.9000000 0.133117 9.9027778 0.136456 9.9055556 0.141466 9.9083333 0.136456 9.9111111 0.138126 9.9138889 0.144805 9.9166667 0.151484 9.9194444 0.148145 9.9222222 0.146475 9.9250000 0.139796 9.9277778 0.131447 9.9305556 0.119759 9.9333333 0.108071 9.9361111 0.094712 9.9388889 0.089703 9.9416667 0.078015 9.9444444 0.062987 9.9472222 0.052968 9.9500000 0.042950 9.9527778 0.037941 9.9555556 0.034601 9.9583333 0.022913 9.9611111 0.014564 9.9638889 0.010000 9.9666667 0.010000 9.9694444 0.010000 9.9722222 0.010000 9.9750000 0.010000 9.9777778 0.010000 9.9805556 0.010000 9.9833333 0.010000 9.9861111 0.010000 9.9888889 0.010000 9.9916667 0.010000 9.9944444 0.010000 9.9972222 0.010000 10.0000000 0.010000 10.0027778 0.010000 10.0055556 0.010000 10.0083333 0.010000 10.0111111 0.010000 10.0138889 0.010000 10.0166667 0.010000 10.0194444 0.010000 10.0222222 0.010000 10.0250000 0.010000 10.0277778 0.010000 10.0305556 0.010000 10.0333333 0.010000 10.0361111 0.010000 10.0388889 0.010000 10.0416667 0.010000 10.0444444 0.010000 10.0472222 0.010000 10.0500000 0.010000 10.0527778 0.010000 10.0555556 0.010000 10.0583333 0.010000 10.0611111 0.010000 10.0638889 0.010000 10.0666667 0.010000 10.0694444 0.010000 10.0722222 0.010000 10.0750000 0.010000 10.0777778 0.010000 10.0805556 0.010000 10.0833333 0.010000 10.0861111 0.010000 10.0888889 0.010000 10.0916667 0.010000 10.0944444 0.016234 10.0972222 0.049629 10.1000000 0.096382 10.1027778 0.146475 10.1055556 0.198237 10.1083333 0.253340 10.1111111 0.318460 10.1138889 0.376902 10.1166667 0.447032 10.1194444 0.523840 10.1222222 0.597310 10.1250000 0.670779 10.1277778 0.742579 10.1305556 0.796011 10.1333333 0.837755 10.1361111 0.850000 10.1388889 0.850000 10.1416667 0.850000 10.1444444 0.850000 10.1472222 0.850000 10.1500000 0.850000 10.1527778 0.850000 10.1555556 0.850000 10.1583333 0.837755 10.1611111 0.809369 10.1638889 0.792672 10.1666667 0.780983 10.1694444 0.784323 10.1722222 0.780983 10.1750000 0.767625 10.1777778 0.742579 10.1805556 0.710853 10.1833333 0.662430 10.1861111 0.608998 10.1888889 0.543878 10.1916667 0.470408 10.1944444 0.366883 10.1972222 0.239981 10.2000000 0.114750 10.2027778 0.010000 10.2055556 0.010000 10.2083333 0.010000 10.2111111 0.010000 10.2138889 0.010000 10.2166667 0.010000 10.2194444 0.010000 10.2222222 0.010000 10.2250000 0.010000 10.2277778 0.010000 10.2305556 0.010000 10.2333333 0.010000 10.2361111 0.010000 10.2388889 0.010000 10.2416667 0.010000 10.2444444 0.010000 10.2472222 0.010000 10.2500000 0.010000 10.2527778 0.010000 10.2555556 0.010000 10.2583333 0.010000 10.2611111 0.010000 10.2638889 0.010000 10.2666667 0.010000 10.2694444 0.010000 10.2722222 0.010000 10.2750000 0.010000 10.2777778 0.010000 10.2805556 0.010000 10.2833333 0.010000 10.2861111 0.010000 10.2888889 0.010000 10.2916667 0.010000 10.2944444 0.010000 10.2972222 0.010000 10.3000000 0.010000 10.3027778 0.010000 10.3055556 0.010000 10.3083333 0.010000 10.3111111 0.010000 10.3138889 0.010000 10.3166667 0.010000 10.3194444 0.010000 10.3222222 0.010000 10.3250000 0.010000 10.3277778 0.010000 10.3305556 0.010000 10.3333333 0.010000 10.3361111 0.010000 10.3388889 0.010000 10.3416667 0.010000 10.3444444 0.010000 10.3472222 0.010000 10.3500000 0.010000 10.3527778 0.010000 10.3555556 0.010000 10.3583333 0.010000 10.3611111 0.010000 10.3638889 0.010000 10.3666667 0.010000 10.3694444 0.010000 10.3722222 0.010000 10.3750000 0.010000 10.3777778 0.010000 10.3805556 0.010000 10.3833333 0.010000 10.3861111 0.010000 10.3888889 0.010000 10.3916667 0.010000 10.3944444 0.010000 10.3972222 0.010000 10.4000000 0.010000 10.4027778 0.010000 10.4055556 0.010000 10.4083333 0.010000 10.4111111 0.010000 10.4138889 0.010000 10.4166667 0.010000 10.4194444 0.010000 10.4222222 0.010000 10.4250000 0.010000 10.4277778 0.010000 10.4305556 0.010000 10.4333333 0.010000 10.4361111 0.010000 10.4388889 0.010000 11.1638889 0.010000 11.1666667 0.010000 11.1694444 0.010000 11.1722222 0.010000 11.1750000 0.010000 11.1777778 0.010000 11.1805556 0.010000 11.1833333 0.010000 11.1861111 0.010000 11.1888889 0.010000 11.1916667 0.010000 11.1944444 0.010000 11.1972222 0.010000 11.2000000 0.010000 11.2027778 0.010000 11.2055556 0.010000 11.2083333 0.010000 11.2111111 0.010000 11.2138889 0.010000 11.2166667 0.010000 11.2194444 0.010000 11.2222222 0.010000 11.2250000 0.010000 11.2277778 0.010000 11.2305556 0.010000 11.2333333 0.010000 11.2361111 0.010000 11.2388889 0.010000 11.2416667 0.010000 11.2444444 0.010000 11.2472222 0.010000 11.2500000 0.014564 11.2527778 0.022913 11.2555556 0.036271 11.2583333 0.056308 11.2611111 0.067996 11.2638889 0.079685 11.2666667 0.081354 11.2694444 0.071336 11.2722222 0.064657 11.2750000 0.057978 11.2777778 0.061317 11.2805556 0.064657 11.2833333 0.067996 11.2861111 0.071336 11.2888889 0.073006 11.2916667 0.067996 11.2944444 0.051299 11.2972222 0.029592 11.3000000 0.010000 11.3027778 0.010000 11.3055556 0.010000 11.3083333 0.010000 11.3111111 0.010000 11.3138889 0.010000 11.3166667 0.010000 11.3194444 0.010000 11.3222222 0.010000 11.3250000 0.010000 11.3277778 0.010000 11.3305556 0.010000 11.3333333 0.010000 11.3361111 0.010000 11.3388889 0.010000 11.3416667 0.010000 11.3444444 0.010000 11.3472222 0.010000 11.3500000 0.010000 11.3527778 0.010000 11.3555556 0.010000 11.3583333 0.010000 11.3611111 0.010000 11.3638889 0.010000 11.3666667 0.010000 11.3694444 0.010000 11.3722222 0.010000 11.3750000 0.010000 11.3777778 0.010000 11.3805556 0.010000 11.3833333 0.010000 11.3861111 0.010000 11.3888889 0.010000 11.3916667 0.041280 11.3944444 0.113080 11.3972222 0.208256 11.4000000 0.316790 11.4027778 0.437013 11.4055556 0.543878 11.4083333 0.639054 11.4111111 0.689147 11.4138889 0.707514 11.4166667 0.694156 11.4194444 0.654082 11.4222222 0.570594 11.4250000 0.452041 11.4277778 0.291744 11.4305556 0.121429 11.4333333 0.010000 11.4361111 0.010000 11.4388889 0.010000 11.4416667 0.010000 11.4444444 0.010000 11.4472222 0.032931 11.4500000 0.047959 11.4527778 0.034601 11.4555556 0.017904 11.4583333 0.010000 11.4611111 0.010000 11.4638889 0.010000 11.4666667 0.010000 11.4694444 0.010000 11.4722222 0.010000 11.4750000 0.010000 11.4777778 0.010000 11.4805556 0.010000 11.4833333 0.010000 11.4861111 0.010000 11.4888889 0.010000 11.4916667 0.010000 11.4944444 0.010000 11.4972222 0.010000 11.5000000 0.010000 11.5027778 0.010000 11.5055556 0.010000 11.5083333 0.010000 11.5111111 0.010000 11.5138889 0.010000 11.5166667 0.010000 11.5194444 0.010000 11.5222222 0.010000 11.5250000 0.010000 11.5277778 0.010000 11.5305556 0.010000 11.5333333 0.010000 11.5361111 0.010000 11.5388889 0.010000 11.5416667 0.010000 11.5444444 0.010000 11.5472222 0.010000 11.5500000 0.010000 11.5527778 0.010000 11.5555556 0.010000 11.5583333 0.010000 11.5611111 0.010000 11.5638889 0.010000 11.5666667 0.010000 11.5694444 0.010000 11.5722222 0.010000 11.5750000 0.010000 11.5777778 0.010000 11.5805556 0.010000 11.5833333 0.010000 11.5861111 0.010000 11.5888889 0.010000 11.5916667 0.010000 11.5944444 0.010000 11.5972222 0.010000 11.6000000 0.010000 11.6027778 0.010000 11.6055556 0.010000 11.6083333 0.010000 11.6111111 0.010000 11.6138889 0.010000 11.6166667 0.010000 11.6194444 0.010000 11.6222222 0.010000 11.6250000 0.010000 11.6277778 0.010000 11.6305556 0.010000 11.6333333 0.010000 11.6361111 0.010000 11.6388889 0.010000 11.6416667 0.010000 11.6444444 0.010000 11.6472222 0.010000 11.6500000 0.010000 11.6527778 0.010000 11.6555556 0.012894 11.6583333 0.019573 11.6611111 0.022913 11.6638889 0.027922 11.6666667 0.036271 11.6694444 0.032931 11.6722222 0.037941 11.6750000 0.044620 11.6777778 0.044620 11.6805556 0.052968 11.6833333 0.062987 11.6861111 0.071336 11.6888889 0.076345 11.6916667 0.084694 11.6944444 0.088033 11.6972222 0.098052 11.7000000 0.101391 11.7027778 0.101391 11.7055556 0.104731 11.7083333 0.111410 11.7111111 0.113080 12.0888889 0.010000 12.0916667 0.010000 12.0944444 0.010000 12.0972222 0.010000 12.1000000 0.010000 12.1027778 0.010000 12.1055556 0.010000 12.1083333 0.010000 12.1111111 0.010000 12.1138889 0.010000 12.1166667 0.010000 12.1194444 0.010000 12.1222222 0.010000 12.1250000 0.010000 12.1277778 0.010000 12.1305556 0.010000 12.1333333 0.010000 12.1361111 0.010000 12.1388889 0.010000 12.1416667 0.010000 12.1444444 0.010000 12.1472222 0.010000 12.1500000 0.010000 12.1527778 0.010000 12.1555556 0.010000 12.1583333 0.012894 12.1611111 0.019573 12.1638889 0.022913 12.1666667 0.024583 12.1694444 0.026252 12.1722222 0.037941 12.1750000 0.054638 12.1777778 0.064657 12.1805556 0.076345 12.1833333 0.083024 12.1861111 0.086364 12.1888889 0.079685 12.1916667 0.079685 12.1944444 0.078015 12.1972222 0.076345 12.2000000 0.073006 12.2027778 0.062987 12.2055556 0.052968 12.2083333 0.037941 12.2111111 0.021243 12.2138889 0.010000 12.2166667 0.010000 12.2194444 0.010000 12.2222222 0.010000 12.2250000 0.010000 12.2277778 0.010000 12.2305556 0.010000 12.2333333 0.010000 12.2361111 0.010000 12.2388889 0.010000 12.2416667 0.010000 12.2444444 0.010000 12.2472222 0.010000 12.2500000 0.010000 12.2527778 0.010000 12.2555556 0.010000 12.2583333 0.010000 12.2611111 0.010000 12.2638889 0.010000 12.2666667 0.010000 12.2694444 0.010000 12.2722222 0.010000 12.2750000 0.010000 12.2777778 0.010000 12.2805556 0.010000 12.2833333 0.010000 12.2861111 0.010000 12.2888889 0.010000 12.2916667 0.010000 12.2944444 0.010000 12.2972222 0.010000 12.3000000 0.010000 12.3027778 0.010000 12.3055556 0.010000 12.3083333 0.010000 12.3111111 0.010000 12.3138889 0.010000 12.3166667 0.010000 12.3194444 0.017904 12.3222222 0.094712 12.3250000 0.196568 12.3277778 0.318460 12.3305556 0.447032 12.3333333 0.565584 12.3361111 0.642393 12.3388889 0.687477 12.3416667 0.689147 12.3444444 0.649072 12.3472222 0.572263 12.3500000 0.445362 12.3527778 0.275046 12.3555556 0.104731 12.3583333 0.010000 12.3611111 0.010000 12.3638889 0.010000 12.3666667 0.010000 12.3694444 0.010000 12.3722222 0.016234 12.3750000 0.029592 12.3777778 0.022913 12.3805556 0.010000 12.3833333 0.010000 12.3861111 0.010000 12.3888889 0.010000 12.3916667 0.010000 12.3944444 0.010000 12.3972222 0.010000 12.4000000 0.010000 12.4027778 0.010000 12.4055556 0.010000 12.4083333 0.010000 12.4111111 0.010000 12.4138889 0.010000 12.4166667 0.010000 12.4194444 0.010000 12.4222222 0.010000 12.4250000 0.010000 12.4277778 0.010000 12.4305556 0.010000 12.4333333 0.010000 12.4361111 0.010000 12.4388889 0.010000 12.4416667 0.010000 12.4444444 0.010000 12.4472222 0.010000 12.4500000 0.010000 12.4527778 0.010000 12.4555556 0.010000 12.4583333 0.010000 12.4611111 0.010000 12.4638889 0.010000 12.4666667 0.010000 12.4694444 0.010000 12.4722222 0.010000 12.4750000 0.010000 12.4777778 0.010000 12.4805556 0.010000 12.4833333 0.010000 12.4861111 0.010000 12.4888889 0.010000 12.4916667 0.010000 12.4944444 0.010000 12.4972222 0.010000 12.5000000 0.010000 12.5027778 0.010000 12.5055556 0.010000 12.5083333 0.010000 12.5111111 0.010000 12.5138889 0.010000 12.5166667 0.010000 12.5194444 0.010000 12.5222222 0.010000 12.5250000 0.010000 12.5277778 0.010000 12.5305556 0.010000 12.5333333 0.010000 12.5361111 0.010000 12.5388889 0.010000 12.5416667 0.010000 12.5444444 0.010000 12.5472222 0.010000 12.5500000 0.010000 12.5527778 0.010000 12.5555556 0.010000 12.5583333 0.010000 12.5611111 0.010000 12.5638889 0.010000 12.5666667 0.012894 12.5694444 0.011224 12.5722222 0.016234 12.5750000 0.021243 12.5777778 0.031262 12.5805556 0.031262 12.5833333 0.037941 12.5861111 0.047959 12.5888889 0.057978 12.5916667 0.071336 12.5944444 0.084694 12.5972222 0.084694 12.6000000 0.088033 12.6027778 0.094712 12.6055556 0.099722 12.6083333 0.099722 12.6111111 0.099722 12.6138889 0.104731 12.6166667 0.118089 12.6194444 0.124768 12.6222222 0.134787 12.6250000 0.133117 12.6277778 0.133117 12.6305556 0.138126 12.6333333 0.134787 12.6361111 0.139796 12.9583333 0.010000 12.9611111 0.010000 12.9638889 0.010000 12.9666667 0.010000 12.9694444 0.010000 12.9722222 0.010000 12.9750000 0.010000 12.9777778 0.010000 12.9805556 0.010000 12.9833333 0.010000 12.9861111 0.010000 12.9888889 0.010000 12.9916667 0.010000 12.9944444 0.010000 12.9972222 0.010000 13.0000000 0.010000 13.0027778 0.010000 13.0055556 0.010000 13.0083333 0.010000 13.0111111 0.010000 13.0138889 0.010000 13.0166667 0.010000 13.0194444 0.010000 13.0222222 0.010000 13.0250000 0.010000 13.0277778 0.010000 13.0305556 0.010000 13.0333333 0.010000 13.0361111 0.014564 13.0388889 0.019573 13.0416667 0.034601 13.0444444 0.042950 13.0472222 0.054638 13.0500000 0.056308 13.0527778 0.057978 13.0555556 0.056308 13.0583333 0.054638 13.0611111 0.056308 13.0638889 0.049629 13.0666667 0.054638 13.0694444 0.047959 13.0722222 0.042950 13.0750000 0.031262 13.0777778 0.014564 13.0805556 0.010000 13.0833333 0.010000 13.0861111 0.010000 13.0888889 0.010000 13.0916667 0.010000 13.0944444 0.010000 13.0972222 0.010000 13.1000000 0.010000 13.1027778 0.010000 13.1055556 0.010000 13.1083333 0.010000 13.1111111 0.010000 13.1138889 0.010000 13.1166667 0.010000 13.1194444 0.010000 13.1222222 0.010000 13.1250000 0.010000 13.1277778 0.010000 13.1305556 0.010000 13.1333333 0.010000 13.1361111 0.010000 13.1388889 0.010000 13.1416667 0.010000 13.1444444 0.010000 13.1472222 0.010000 13.1500000 0.010000 13.1527778 0.010000 13.1555556 0.010000 13.1583333 0.010000 13.1611111 0.010000 13.1638889 0.010000 13.1666667 0.010000 13.1694444 0.010000 13.1722222 0.010000 13.1750000 0.010000 13.1777778 0.010000 13.1805556 0.010000 13.1833333 0.010000 13.1861111 0.010000 13.1888889 0.039610 13.1916667 0.121429 13.1944444 0.223284 13.1972222 0.340167 13.2000000 0.462059 13.2027778 0.562245 13.2055556 0.635714 13.2083333 0.662430 13.2111111 0.660761 13.2138889 0.620686 13.2166667 0.533859 13.2194444 0.396939 13.2222222 0.219944 13.2250000 0.054638 13.2277778 0.010000 13.2305556 0.010000 13.2333333 0.010000 13.2361111 0.010000 13.2388889 0.010000 13.2416667 0.010000 13.2444444 0.010000 13.2472222 0.010000 13.2500000 0.010000 13.2527778 0.010000 13.2555556 0.010000 13.2583333 0.010000 13.2611111 0.010000 13.2638889 0.010000 13.2666667 0.010000 13.2694444 0.010000 13.2722222 0.010000 13.2750000 0.010000 13.2777778 0.010000 13.2805556 0.010000 13.2833333 0.010000 13.2861111 0.010000 13.2888889 0.010000 13.2916667 0.010000 13.2944444 0.010000 13.2972222 0.010000 13.3000000 0.010000 13.3027778 0.010000 13.3055556 0.010000 13.3083333 0.010000 13.3111111 0.010000 13.3138889 0.010000 13.3166667 0.010000 13.3194444 0.010000 13.3222222 0.010000 13.3250000 0.010000 13.3277778 0.010000 13.3305556 0.010000 13.3333333 0.010000 13.3361111 0.010000 13.3388889 0.010000 13.3416667 0.010000 13.3444444 0.010000 13.3472222 0.010000 13.3500000 0.010000 13.3527778 0.010000 13.3555556 0.010000 13.3583333 0.010000 13.3611111 0.010000 13.3638889 0.010000 13.3666667 0.010000 13.3694444 0.010000 13.3722222 0.010000 13.3750000 0.010000 13.3777778 0.010000 13.3805556 0.010000 13.3833333 0.010000 13.3861111 0.010000 13.3888889 0.010000 13.3916667 0.010000 13.3944444 0.010000 13.3972222 0.010000 13.4000000 0.010000 13.4027778 0.010000 13.4055556 0.010000 13.4083333 0.010000 13.4111111 0.010000 13.4138889 0.010000 13.4166667 0.010000 13.4194444 0.010000 13.4222222 0.010000 13.4250000 0.010000 13.4277778 0.010000 13.4305556 0.010000 13.4333333 0.010000 13.4361111 0.010000 13.4388889 0.010000 13.4416667 0.010000 13.4444444 0.010000 13.4472222 0.011224 13.4500000 0.019573 13.4527778 0.031262 13.4555556 0.036271 13.4583333 0.042950 13.4611111 0.054638 13.4638889 0.057978 13.4666667 0.061317 13.4694444 0.069666 13.4722222 0.071336 13.4750000 0.079685 13.4777778 0.081354 13.4805556 0.086364 13.4833333 0.093043 13.4861111 0.108071 13.4888889 0.109740 13.4916667 0.118089 13.4944444 0.123098 13.4972222 0.124768 13.5000000 0.126438 13.5027778 0.123098 13.5055556 0.129777 13.8750000 0.010000 13.8777778 0.010000 13.8805556 0.010000 13.8833333 0.010000 13.8861111 0.010000 13.8888889 0.010000 13.8916667 0.010000 13.8944444 0.010000 13.8972222 0.010000 13.9000000 0.010000 13.9027778 0.010000 13.9055556 0.010000 13.9083333 0.010000 13.9111111 0.010000 13.9138889 0.010000 13.9166667 0.010000 13.9194444 0.010000 13.9222222 0.010000 13.9250000 0.010000 13.9277778 0.010000 13.9305556 0.010000 13.9333333 0.010000 13.9361111 0.010000 13.9388889 0.010000 13.9416667 0.010000 13.9444444 0.011224 13.9472222 0.021243 13.9500000 0.031262 13.9527778 0.049629 13.9555556 0.064657 13.9583333 0.074675 13.9611111 0.071336 13.9638889 0.064657 13.9666667 0.057978 13.9694444 0.054638 13.9722222 0.049629 13.9750000 0.047959 13.9777778 0.047959 13.9805556 0.042950 13.9833333 0.042950 13.9861111 0.034601 13.9888889 0.022913 13.9916667 0.010000 13.9944444 0.010000 13.9972222 0.010000 14.0000000 0.010000 14.0027778 0.010000 14.0055556 0.010000 14.0083333 0.010000 14.0111111 0.010000 14.0138889 0.010000 14.0166667 0.010000 14.0194444 0.010000 14.0222222 0.010000 14.0250000 0.010000 14.0277778 0.010000 14.0305556 0.010000 14.0333333 0.010000 14.0361111 0.010000 14.0388889 0.010000 14.0416667 0.010000 14.0444444 0.010000 14.0472222 0.010000 14.0500000 0.010000 14.0527778 0.010000 14.0555556 0.010000 14.0583333 0.010000 14.0611111 0.010000 14.0638889 0.010000 14.0666667 0.010000 14.0694444 0.010000 14.0722222 0.010000 14.0750000 0.010000 14.0777778 0.010000 14.0805556 0.010000 14.0833333 0.010000 14.0861111 0.010000 14.0888889 0.010000 14.0916667 0.010000 14.0944444 0.010000 14.0972222 0.010000 14.1000000 0.010000 14.1027778 0.010000 14.1055556 0.044620 14.1083333 0.126438 14.1111111 0.239981 14.1138889 0.363544 14.1166667 0.492115 14.1194444 0.600649 14.1222222 0.672449 14.1250000 0.700835 14.1277778 0.697495 14.1305556 0.647403 14.1333333 0.557236 14.1361111 0.410297 14.1388889 0.239981 14.1416667 0.064657 14.1444444 0.010000 14.1472222 0.010000 14.1500000 0.010000 14.1527778 0.010000 14.1555556 0.010000 14.1583333 0.014564 14.1611111 0.022913 14.1638889 0.012894 14.1666667 0.010000 14.1694444 0.010000 14.1722222 0.010000 14.1750000 0.010000 14.1777778 0.010000 14.1805556 0.010000 14.1833333 0.010000 14.1861111 0.010000 14.1888889 0.010000 14.1916667 0.010000 14.1944444 0.010000 14.1972222 0.010000 14.2000000 0.010000 14.2027778 0.010000 14.2055556 0.010000 14.2083333 0.010000 14.2111111 0.010000 14.2138889 0.010000 14.2166667 0.010000 14.2194444 0.010000 14.2222222 0.010000 14.2250000 0.010000 14.2277778 0.010000 14.2305556 0.010000 14.2333333 0.010000 14.2361111 0.010000 14.2388889 0.010000 14.2416667 0.010000 14.2444444 0.010000 14.2472222 0.010000 14.2500000 0.010000 14.2527778 0.010000 14.2555556 0.010000 14.2583333 0.010000 14.2611111 0.010000 14.2638889 0.010000 14.2666667 0.010000 14.2694444 0.010000 14.2722222 0.010000 14.2750000 0.010000 14.2777778 0.010000 14.2805556 0.010000 14.2833333 0.010000 14.2861111 0.010000 14.2888889 0.010000 14.2916667 0.010000 14.2944444 0.010000 14.2972222 0.010000 14.3000000 0.010000 14.3027778 0.010000 14.3055556 0.010000 14.3083333 0.010000 14.3111111 0.010000 14.3138889 0.010000 14.3166667 0.010000 14.3194444 0.010000 14.3222222 0.010000 14.3250000 0.010000 14.3277778 0.010000 14.3305556 0.010000 14.3333333 0.010000 14.3361111 0.010000 14.3388889 0.010000 14.3416667 0.010000 14.3444444 0.010000 14.3472222 0.010000 14.3500000 0.010000 14.3527778 0.010000 14.3555556 0.010000 14.3583333 0.012894 14.3611111 0.022913 14.3638889 0.029592 14.3666667 0.037941 14.3694444 0.041280 14.3722222 0.042950 14.3750000 0.044620 14.3777778 0.052968 14.3805556 0.062987 14.3833333 0.066327 14.3861111 0.081354 14.3888889 0.084694 14.3916667 0.094712 14.3944444 0.109740 14.3972222 0.113080 14.4000000 0.118089 14.4027778 0.121429 14.4055556 0.124768 14.4083333 0.129777 14.4111111 0.129777 14.4138889 0.138126 14.4166667 0.143135 14.4194444 0.151484 14.4222222 0.156494 14.7861111 0.010000 14.7888889 0.010000 14.7916667 0.010000 14.7944444 0.010000 14.7972222 0.010000 14.8000000 0.010000 14.8027778 0.010000 14.8055556 0.010000 14.8083333 0.010000 14.8111111 0.010000 14.8138889 0.010000 14.8166667 0.010000 14.8194444 0.010000 14.8222222 0.010000 14.8250000 0.010000 14.8277778 0.010000 14.8305556 0.010000 14.8333333 0.010000 14.8361111 0.010000 14.8388889 0.010000 14.8416667 0.010000 14.8444444 0.010000 14.8472222 0.010000 14.8500000 0.010000 14.8527778 0.010000 14.8555556 0.012894 14.8583333 0.019573 14.8611111 0.029592 14.8638889 0.037941 14.8666667 0.051299 14.8694444 0.057978 14.8722222 0.057978 14.8750000 0.067996 14.8777778 0.062987 14.8805556 0.059647 14.8833333 0.056308 14.8861111 0.057978 14.8888889 0.062987 14.8916667 0.062987 14.8944444 0.061317 14.8972222 0.049629 14.9000000 0.036271 14.9027778 0.019573 14.9055556 0.010000 14.9083333 0.010000 14.9111111 0.010000 14.9138889 0.010000 14.9166667 0.010000 14.9194444 0.010000 14.9222222 0.010000 14.9250000 0.010000 14.9277778 0.010000 14.9305556 0.010000 14.9333333 0.010000 14.9361111 0.010000 14.9388889 0.010000 14.9416667 0.010000 14.9444444 0.010000 14.9472222 0.010000 14.9500000 0.010000 14.9527778 0.010000 14.9555556 0.010000 14.9583333 0.010000 14.9611111 0.010000 14.9638889 0.010000 14.9666667 0.010000 14.9694444 0.010000 14.9722222 0.010000 14.9750000 0.010000 14.9777778 0.010000 14.9805556 0.010000 14.9833333 0.010000 14.9861111 0.010000 14.9888889 0.010000 14.9916667 0.010000 14.9944444 0.010000 14.9972222 0.010000 15.0000000 0.010000 15.0027778 0.010000 15.0055556 0.010000 15.0083333 0.010000 15.0111111 0.010000 15.0138889 0.010000 15.0166667 0.034601 15.0194444 0.123098 15.0222222 0.234972 15.0250000 0.360204 15.0277778 0.480427 15.0305556 0.578942 15.0333333 0.647403 15.0361111 0.674119 15.0388889 0.659091 15.0416667 0.607328 15.0444444 0.513822 15.0472222 0.361874 15.0500000 0.186549 15.0527778 0.016234 15.0555556 0.010000 15.0583333 0.010000 15.0611111 0.010000 15.0638889 0.010000 15.0666667 0.010000 15.0694444 0.010000 15.0722222 0.012894 15.0750000 0.010000 15.0777778 0.010000 15.0805556 0.010000 15.0833333 0.010000 15.0861111 0.010000 15.0888889 0.010000 15.0916667 0.010000 15.0944444 0.010000 15.0972222 0.010000 15.1000000 0.010000 15.1027778 0.010000 15.1055556 0.010000 15.1083333 0.010000 15.1111111 0.010000 15.1138889 0.010000 15.1166667 0.010000 15.1194444 0.010000 15.1222222 0.010000 15.1250000 0.010000 15.1277778 0.010000 15.1305556 0.010000 15.1333333 0.010000 15.1361111 0.010000 15.1388889 0.010000 15.1416667 0.010000 15.1444444 0.010000 15.1472222 0.010000 15.1500000 0.010000 15.1527778 0.010000 15.1555556 0.010000 15.1583333 0.010000 15.1611111 0.010000 15.1638889 0.010000 15.1666667 0.010000 15.1694444 0.010000 15.1722222 0.010000 15.1750000 0.010000 15.1777778 0.010000 15.1805556 0.010000 15.1833333 0.010000 15.1861111 0.010000 15.1888889 0.010000 15.1916667 0.010000 15.1944444 0.010000 15.1972222 0.010000 15.2000000 0.010000 15.2027778 0.010000 15.2055556 0.010000 15.2083333 0.010000 15.2111111 0.010000 15.2138889 0.010000 15.2166667 0.010000 15.2194444 0.010000 15.2222222 0.010000 15.2250000 0.010000 15.2277778 0.010000 15.2305556 0.010000 15.2333333 0.010000 15.2361111 0.010000 15.2388889 0.010000 15.2416667 0.010000 15.2444444 0.010000 15.2472222 0.010000 15.2500000 0.010000 15.2527778 0.010000 15.2555556 0.010000 15.2583333 0.010000 15.2611111 0.010000 15.2638889 0.010000 15.2666667 0.011224 15.2694444 0.012894 15.2722222 0.022913 15.2750000 0.022913 15.2777778 0.029592 15.2805556 0.031262 15.2833333 0.046289 15.2861111 0.057978 15.2888889 0.064657 15.2916667 0.079685 15.2944444 0.086364 15.2972222 0.093043 15.3000000 0.094712 15.3027778 0.094712 15.3055556 0.101391 15.3083333 0.103061 15.3111111 0.111410 15.3138889 0.114750 15.3166667 0.114750 15.3194444 0.124768 15.3222222 0.131447 15.3250000 0.138126 15.3277778 0.144805 15.3305556 0.146475 15.3333333 0.143135 15.6500000 0.010000 15.6527778 0.010000 15.6555556 0.010000 15.6583333 0.010000 15.6611111 0.010000 15.6638889 0.010000 15.6666667 0.010000 15.6694444 0.010000 15.6722222 0.010000 15.6750000 0.010000 15.6777778 0.010000 15.6805556 0.010000 15.6833333 0.010000 15.6861111 0.010000 15.6888889 0.010000 15.6916667 0.010000 15.6944444 0.010000 15.6972222 0.010000 15.7000000 0.010000 15.7027778 0.010000 15.7055556 0.010000 15.7083333 0.010000 15.7111111 0.010000 15.7138889 0.010000 15.7166667 0.010000 15.7194444 0.010000 15.7222222 0.010000 15.7250000 0.010000 15.7277778 0.019573 15.7305556 0.031262 15.7333333 0.041280 15.7361111 0.047959 15.7388889 0.046289 15.7416667 0.042950 15.7444444 0.042950 15.7472222 0.034601 15.7500000 0.034601 15.7527778 0.031262 15.7555556 0.031262 15.7583333 0.031262 15.7611111 0.024583 15.7638889 0.010000 15.7666667 0.010000 15.7694444 0.010000 15.7722222 0.010000 15.7750000 0.010000 15.7777778 0.010000 15.7805556 0.010000 15.7833333 0.010000 15.7861111 0.010000 15.7888889 0.010000 15.7916667 0.010000 15.7944444 0.010000 15.7972222 0.010000 15.8000000 0.010000 15.8027778 0.010000 15.8055556 0.010000 15.8083333 0.010000 15.8111111 0.010000 15.8138889 0.010000 15.8166667 0.010000 15.8194444 0.010000 15.8222222 0.010000 15.8250000 0.010000 15.8277778 0.010000 15.8305556 0.010000 15.8333333 0.010000 15.8361111 0.010000 15.8388889 0.010000 15.8416667 0.010000 15.8444444 0.010000 15.8472222 0.010000 15.8500000 0.010000 15.8527778 0.010000 15.8555556 0.010000 15.8583333 0.010000 15.8611111 0.010000 15.8638889 0.010000 15.8666667 0.010000 15.8694444 0.010000 15.8722222 0.010000 15.8750000 0.010000 15.8777778 0.010000 15.8805556 0.051299 15.8833333 0.131447 15.8861111 0.241651 15.8888889 0.366883 15.8916667 0.483766 15.8944444 0.575603 15.8972222 0.630705 15.9000000 0.650742 15.9027778 0.644063 15.9055556 0.598980 15.9083333 0.508813 15.9111111 0.378571 15.9138889 0.213265 15.9166667 0.042950 15.9194444 0.010000 15.9222222 0.010000 15.9250000 0.010000 15.9277778 0.010000 15.9305556 0.010000 15.9333333 0.010000 15.9361111 0.010000 15.9388889 0.010000 15.9416667 0.010000 15.9444444 0.010000 15.9472222 0.010000 15.9500000 0.010000 15.9527778 0.010000 15.9555556 0.010000 15.9583333 0.010000 15.9611111 0.010000 15.9638889 0.010000 15.9666667 0.010000 15.9694444 0.010000 15.9722222 0.010000 15.9750000 0.010000 15.9777778 0.010000 15.9805556 0.010000 15.9833333 0.010000 15.9861111 0.010000 15.9888889 0.010000 15.9916667 0.010000 15.9944444 0.010000 15.9972222 0.010000 16.0000000 0.010000 16.0027778 0.010000 16.0055556 0.010000 16.0083333 0.010000 16.0111111 0.010000 16.0138889 0.010000 16.0166667 0.010000 16.0194444 0.010000 16.0222222 0.010000 16.0250000 0.010000 16.0277778 0.010000 16.0305556 0.010000 16.0333333 0.010000 16.0361111 0.010000 16.0388889 0.010000 16.0416667 0.010000 16.0444444 0.010000 16.0472222 0.010000 16.0500000 0.010000 16.0527778 0.010000 16.0555556 0.010000 16.0583333 0.010000 16.0611111 0.010000 16.0638889 0.010000 16.0666667 0.010000 16.0694444 0.010000 16.0722222 0.010000 16.0750000 0.010000 16.0777778 0.010000 16.0805556 0.010000 16.0833333 0.010000 16.0861111 0.010000 16.0888889 0.010000 16.0916667 0.010000 16.0944444 0.010000 16.0972222 0.010000 16.1000000 0.010000 16.1027778 0.010000 16.1055556 0.010000 16.1083333 0.010000 16.1111111 0.010000 16.1138889 0.010000 16.1166667 0.010000 16.1194444 0.010000 16.1222222 0.010000 16.1250000 0.010000 16.1277778 0.010000 16.1305556 0.010000 16.1333333 0.010000 16.1361111 0.010000 16.1388889 0.010000 16.1416667 0.010000 16.1444444 0.010000 16.1472222 0.010000 16.1500000 0.010000 16.1527778 0.014564 16.1555556 0.029592 16.1583333 0.036271 16.1611111 0.041280 16.1638889 0.051299 16.1666667 0.056308 16.1694444 0.057978 16.1722222 0.061317 16.1750000 0.069666 16.1777778 0.076345 16.1805556 0.081354 16.1833333 0.088033 16.1861111 0.101391 16.1888889 0.108071 16.1916667 0.118089 16.1944444 0.123098 16.1972222 0.123098 16.6027778 0.010000 16.6055556 0.010000 16.6083333 0.010000 16.6111111 0.010000 16.6138889 0.010000 16.6166667 0.010000 16.6194444 0.010000 16.6222222 0.010000 16.6250000 0.010000 16.6277778 0.010000 16.6305556 0.010000 16.6333333 0.010000 16.6361111 0.010000 16.6388889 0.010000 16.6416667 0.010000 16.6444444 0.010000 16.6472222 0.010000 16.6500000 0.010000 16.6527778 0.010000 16.6555556 0.010000 16.6583333 0.010000 16.6611111 0.010000 16.6638889 0.010000 16.6666667 0.010000 16.6694444 0.010000 16.6722222 0.010000 16.6750000 0.010000 16.6777778 0.010000 16.6805556 0.010000 16.6833333 0.022913 16.6861111 0.036271 16.6888889 0.047959 16.6916667 0.056308 16.6944444 0.069666 16.6972222 0.073006 16.7000000 0.064657 16.7027778 0.057978 16.7055556 0.052968 16.7083333 0.044620 16.7111111 0.046289 16.7138889 0.037941 16.7166667 0.034601 16.7194444 0.026252 16.7222222 0.014564 16.7250000 0.010000 16.7277778 0.010000 16.7305556 0.010000 16.7333333 0.010000 16.7361111 0.010000 16.7388889 0.010000 16.7416667 0.010000 16.7444444 0.010000 16.7472222 0.010000 16.7500000 0.010000 16.7527778 0.010000 16.7555556 0.010000 16.7583333 0.010000 16.7611111 0.010000 16.7638889 0.010000 16.7666667 0.010000 16.7694444 0.010000 16.7722222 0.010000 16.7750000 0.010000 16.7777778 0.010000 16.7805556 0.010000 16.7833333 0.010000 16.7861111 0.010000 16.7888889 0.010000 16.7916667 0.010000 16.7944444 0.010000 16.7972222 0.010000 16.8000000 0.010000 16.8027778 0.010000 16.8055556 0.010000 16.8083333 0.010000 16.8111111 0.010000 16.8138889 0.010000 16.8166667 0.010000 16.8194444 0.010000 16.8222222 0.010000 16.8250000 0.010000 16.8277778 0.010000 16.8305556 0.010000 16.8333333 0.034601 16.8361111 0.124768 16.8388889 0.236642 16.8416667 0.366883 16.8444444 0.493785 16.8472222 0.593970 16.8500000 0.660761 16.8527778 0.682468 16.8555556 0.670779 16.8583333 0.619017 16.8611111 0.520501 16.8638889 0.380241 16.8666667 0.208256 16.8694444 0.039610 16.8722222 0.010000 16.8750000 0.010000 16.8777778 0.010000 16.8805556 0.010000 16.8833333 0.010000 16.8861111 0.017904 16.8888889 0.024583 16.8916667 0.012894 16.8944444 0.010000 16.8972222 0.010000 16.9000000 0.010000 16.9027778 0.010000 16.9055556 0.010000 16.9083333 0.010000 16.9111111 0.010000 16.9138889 0.010000 16.9166667 0.010000 16.9194444 0.010000 16.9222222 0.010000 16.9250000 0.010000 16.9277778 0.010000 16.9305556 0.010000 16.9333333 0.010000 16.9361111 0.010000 16.9388889 0.010000 16.9416667 0.010000 16.9444444 0.010000 16.9472222 0.010000 16.9500000 0.010000 16.9527778 0.010000 16.9555556 0.010000 16.9583333 0.010000 16.9611111 0.010000 16.9638889 0.010000 16.9666667 0.010000 16.9694444 0.010000 16.9722222 0.010000 16.9750000 0.010000 16.9777778 0.010000 16.9805556 0.010000 16.9833333 0.010000 16.9861111 0.010000 16.9888889 0.010000 16.9916667 0.010000 16.9944444 0.010000 16.9972222 0.010000 17.0000000 0.010000 17.0027778 0.010000 17.0055556 0.010000 17.0083333 0.010000 17.0111111 0.010000 17.0138889 0.010000 17.0166667 0.010000 17.0194444 0.010000 17.0222222 0.010000 17.0250000 0.010000 17.0277778 0.010000 17.0305556 0.010000 17.0333333 0.010000 17.0361111 0.010000 17.0388889 0.010000 17.0416667 0.010000 17.0444444 0.010000 17.0472222 0.010000 17.0500000 0.010000 17.0527778 0.010000 17.0555556 0.010000 17.0583333 0.010000 17.0611111 0.010000 17.0638889 0.010000 17.0666667 0.010000 17.0694444 0.010000 17.0722222 0.010000 17.0750000 0.010000 17.0777778 0.010000 17.0805556 0.010000 17.0833333 0.011224 17.0861111 0.019573 17.0888889 0.024583 17.0916667 0.031262 17.0944444 0.042950 17.0972222 0.051299 17.1000000 0.059647 17.1027778 0.064657 17.1055556 0.067996 17.1083333 0.066327 17.1111111 0.074675 17.1138889 0.078015 17.1166667 0.089703 17.1194444 0.098052 17.1222222 0.108071 17.1250000 0.118089 17.1277778 0.126438 17.1305556 0.131447 17.1333333 0.131447 17.1361111 0.138126 17.1388889 0.136456 17.1416667 0.146475 17.1444444 0.143135 17.1472222 0.151484 17.1500000 0.153154 17.5361111 0.010000 17.5388889 0.010000 17.5416667 0.010000 17.5444444 0.010000 17.5472222 0.010000 17.5500000 0.010000 17.5527778 0.010000 17.5555556 0.010000 17.5583333 0.010000 17.5611111 0.010000 17.5638889 0.010000 17.5666667 0.010000 17.5694444 0.010000 17.5722222 0.010000 17.5750000 0.010000 17.5777778 0.010000 17.5805556 0.010000 17.5833333 0.010000 17.5861111 0.010000 17.5888889 0.010000 17.5916667 0.010000 17.5944444 0.010000 17.5972222 0.010000 17.6000000 0.010000 17.6027778 0.016234 17.6055556 0.021243 17.6083333 0.031262 17.6111111 0.046289 17.6138889 0.056308 17.6166667 0.067996 17.6194444 0.074675 17.6222222 0.076345 17.6250000 0.074675 17.6277778 0.073006 17.6305556 0.069666 17.6333333 0.067996 17.6361111 0.067996 17.6388889 0.061317 17.6416667 0.051299 17.6444444 0.039610 17.6472222 0.022913 17.6500000 0.010000 17.6527778 0.010000 17.6555556 0.010000 17.6583333 0.010000 17.6611111 0.010000 17.6638889 0.010000 17.6666667 0.010000 17.6694444 0.010000 17.6722222 0.010000 17.6750000 0.010000 17.6777778 0.010000 17.6805556 0.010000 17.6833333 0.010000 17.6861111 0.010000 17.6888889 0.010000 17.6916667 0.010000 17.6944444 0.010000 17.6972222 0.010000 17.7000000 0.010000 17.7027778 0.010000 17.7055556 0.010000 17.7083333 0.010000 17.7111111 0.010000 17.7138889 0.010000 17.7166667 0.010000 17.7194444 0.010000 17.7222222 0.010000 17.7250000 0.010000 17.7277778 0.010000 17.7305556 0.010000 17.7333333 0.010000 17.7361111 0.010000 17.7388889 0.010000 17.7416667 0.010000 17.7444444 0.010000 17.7472222 0.010000 17.7500000 0.010000 17.7527778 0.010000 17.7555556 0.010000 17.7583333 0.010000 17.7611111 0.010000 17.7638889 0.010000 17.7666667 0.047959 17.7694444 0.131447 17.7722222 0.243321 17.7750000 0.375232 17.7777778 0.497124 17.7805556 0.590631 17.7833333 0.655751 17.7861111 0.679128 17.7888889 0.662430 17.7916667 0.590631 17.7944444 0.475417 17.7972222 0.305102 17.8000000 0.119759 17.8027778 0.010000 17.8055556 0.010000 17.8083333 0.010000 17.8111111 0.010000 17.8138889 0.010000 17.8166667 0.010000 17.8194444 0.014564 17.8222222 0.012894 17.8250000 0.010000 17.8277778 0.010000 17.8305556 0.010000 17.8333333 0.010000 17.8361111 0.010000 17.8388889 0.010000 17.8416667 0.010000 17.8444444 0.010000 17.8472222 0.010000 17.8500000 0.010000 17.8527778 0.010000 17.8555556 0.010000 17.8583333 0.010000 17.8611111 0.010000 17.8638889 0.010000 17.8666667 0.010000 17.8694444 0.010000 17.8722222 0.010000 17.8750000 0.010000 17.8777778 0.010000 17.8805556 0.010000 17.8833333 0.010000 17.8861111 0.010000 17.8888889 0.010000 17.8916667 0.010000 17.8944444 0.010000 17.8972222 0.010000 17.9000000 0.010000 17.9027778 0.010000 17.9055556 0.010000 17.9083333 0.010000 17.9111111 0.010000 17.9138889 0.010000 17.9166667 0.010000 17.9194444 0.010000 17.9222222 0.010000 17.9250000 0.010000 17.9277778 0.010000 17.9305556 0.010000 17.9333333 0.010000 17.9361111 0.010000 17.9388889 0.010000 17.9416667 0.010000 17.9444444 0.010000 17.9472222 0.010000 17.9500000 0.010000 17.9527778 0.010000 17.9555556 0.010000 17.9583333 0.010000 17.9611111 0.010000 17.9638889 0.010000 17.9666667 0.010000 17.9694444 0.010000 17.9722222 0.010000 17.9750000 0.010000 17.9777778 0.010000 17.9805556 0.010000 17.9833333 0.010000 17.9861111 0.010000 17.9888889 0.010000 17.9916667 0.010000 17.9944444 0.010000 17.9972222 0.010000 18.0000000 0.010000 18.0027778 0.010000 18.0055556 0.010000 18.0083333 0.010000 18.0111111 0.010000 18.0138889 0.010000 18.0166667 0.010000 18.0194444 0.016234 18.0222222 0.027922 18.0250000 0.032931 18.0277778 0.042950 18.0305556 0.052968 18.0333333 0.056308 18.0361111 0.061317 18.0388889 0.066327 18.0416667 0.069666 18.0444444 0.074675 18.0472222 0.079685 18.0500000 0.089703 18.0527778 0.096382 18.0555556 0.106401 18.0583333 0.116419 18.0611111 0.126438 18.0638889 0.134787 18.0666667 0.139796 18.0694444 0.139796 18.0722222 0.139796 18.0750000 0.133117 18.0777778 0.136456 18.0805556 0.139796 18.0833333 0.139796 18.4027778 0.010000 18.4055556 0.010000 18.4083333 0.010000 18.4111111 0.010000 18.4138889 0.010000 18.4166667 0.010000 18.4194444 0.010000 18.4222222 0.010000 18.4250000 0.010000 18.4277778 0.010000 18.4305556 0.010000 18.4333333 0.010000 18.4361111 0.010000 18.4388889 0.010000 18.4416667 0.010000 18.4444444 0.010000 18.4472222 0.010000 18.4500000 0.010000 18.4527778 0.010000 18.4555556 0.010000 18.4583333 0.010000 18.4611111 0.010000 18.4638889 0.010000 18.4666667 0.014564 18.4694444 0.022913 18.4722222 0.032931 18.4750000 0.042950 18.4777778 0.047959 18.4805556 0.062987 18.4833333 0.066327 18.4861111 0.064657 18.4888889 0.059647 18.4916667 0.064657 18.4944444 0.064657 18.4972222 0.067996 18.5000000 0.067996 18.5027778 0.064657 18.5055556 0.052968 18.5083333 0.041280 18.5111111 0.024583 18.5138889 0.014564 18.5166667 0.010000 18.5194444 0.010000 18.5222222 0.010000 18.5250000 0.010000 18.5277778 0.010000 18.5305556 0.010000 18.5333333 0.010000 18.5361111 0.010000 18.5388889 0.010000 18.5416667 0.010000 18.5444444 0.010000 18.5472222 0.010000 18.5500000 0.010000 18.5527778 0.010000 18.5555556 0.010000 18.5583333 0.010000 18.5611111 0.010000 18.5638889 0.010000 18.5666667 0.010000 18.5694444 0.010000 18.5722222 0.010000 18.5750000 0.010000 18.5777778 0.010000 18.5805556 0.010000 18.5833333 0.010000 18.5861111 0.010000 18.5888889 0.010000 18.5916667 0.010000 18.5944444 0.010000 18.5972222 0.010000 18.6000000 0.010000 18.6027778 0.010000 18.6055556 0.010000 18.6083333 0.010000 18.6111111 0.010000 18.6138889 0.010000 18.6166667 0.010000 18.6194444 0.010000 18.6222222 0.010000 18.6250000 0.010000 18.6277778 0.010000 18.6305556 0.010000 18.6333333 0.029592 18.6361111 0.096382 18.6388889 0.189889 18.6416667 0.308442 18.6444444 0.428664 18.6472222 0.540538 18.6500000 0.629035 18.6527778 0.682468 18.6555556 0.704174 18.6583333 0.690816 18.6611111 0.639054 18.6638889 0.538868 18.6666667 0.386920 18.6694444 0.199907 18.6722222 0.037941 18.6750000 0.010000 18.6777778 0.010000 18.6805556 0.010000 18.6833333 0.010000 18.6861111 0.010000 18.6888889 0.031262 18.6916667 0.034601 18.6944444 0.024583 18.6972222 0.010000 18.7000000 0.010000 18.7027778 0.010000 18.7055556 0.010000 18.7083333 0.010000 18.7111111 0.010000 18.7138889 0.010000 18.7166667 0.010000 18.7194444 0.010000 18.7222222 0.010000 18.7250000 0.010000 18.7277778 0.010000 18.7305556 0.010000 18.7333333 0.010000 18.7361111 0.010000 18.7388889 0.010000 18.7416667 0.010000 18.7444444 0.010000 18.7472222 0.010000 18.7500000 0.010000 18.7527778 0.010000 18.7555556 0.010000 18.7583333 0.010000 18.7611111 0.010000 18.7638889 0.010000 18.7666667 0.010000 18.7694444 0.010000 18.7722222 0.010000 18.7750000 0.010000 18.7777778 0.010000 18.7805556 0.010000 18.7833333 0.010000 18.7861111 0.010000 18.7888889 0.010000 18.7916667 0.010000 18.7944444 0.010000 18.7972222 0.010000 18.8000000 0.010000 18.8027778 0.010000 18.8055556 0.010000 18.8083333 0.010000 18.8111111 0.010000 18.8138889 0.010000 18.8166667 0.010000 18.8194444 0.010000 18.8222222 0.010000 18.8250000 0.010000 18.8277778 0.010000 18.8305556 0.010000 18.8333333 0.010000 18.8361111 0.010000 18.8388889 0.010000 18.8416667 0.010000 18.8444444 0.010000 18.8472222 0.010000 18.8500000 0.010000 18.8527778 0.010000 18.8555556 0.010000 18.8583333 0.010000 18.8611111 0.010000 18.8638889 0.010000 18.8666667 0.010000 18.8694444 0.010000 18.8722222 0.010000 18.8750000 0.011224 18.8777778 0.010000 18.8805556 0.012894 18.8833333 0.014564 18.8861111 0.021243 18.8888889 0.029592 18.8916667 0.037941 18.8944444 0.042950 18.8972222 0.049629 18.9000000 0.057978 18.9027778 0.061317 18.9055556 0.067996 18.9083333 0.069666 18.9111111 0.076345 18.9138889 0.081354 18.9166667 0.084694 18.9194444 0.096382 18.9222222 0.108071 18.9250000 0.111410 18.9277778 0.116419 18.9305556 0.124768 18.9333333 0.136456 18.9361111 0.141466 18.9388889 0.144805 18.9416667 0.146475 18.9444444 0.149814 18.9472222 0.146475 18.9500000 0.149814 18.9527778 0.158163 18.9555556 0.161503 18.9583333 0.168182 18.9611111 0.178200 18.9638889 0.181540 18.9666667 0.183210 18.9694444 0.183210 18.9722222 0.173191 18.9750000 0.173191 18.9777778 0.166512 18.9805556 0.158163 18.9833333 0.151484 18.9861111 0.139796 18.9888889 0.138126 18.9916667 0.131447 18.9944444 0.123098 18.9972222 0.113080 19.0000000 0.106401 19.0027778 0.094712 19.0055556 0.083024 19.0083333 0.067996 19.0111111 0.059647 19.0138889 0.046289 19.0166667 0.039610 19.0194444 0.032931 19.0222222 0.027922 19.0250000 0.024583 19.0277778 0.019573 19.0305556 0.014564 19.0333333 0.010000 19.0361111 0.010000 19.0388889 0.010000 19.0416667 0.010000 19.0444444 0.010000 19.0472222 0.010000 19.0500000 0.010000 19.0527778 0.010000 19.0555556 0.010000 19.0583333 0.010000 19.0611111 0.010000 19.0638889 0.010000 19.0666667 0.010000 19.0694444 0.010000 19.0722222 0.010000 19.0750000 0.010000 19.0777778 0.010000 19.0805556 0.010000 19.0833333 0.010000 19.0861111 0.010000 19.0888889 0.010000 19.0916667 0.010000 19.0944444 0.010000 19.0972222 0.010000 19.1000000 0.010000 19.1027778 0.010000 19.1055556 0.010000 19.1083333 0.010000 19.1111111 0.010000 19.1138889 0.010000 19.1166667 0.010000 19.1194444 0.010000 19.1222222 0.010000 19.1250000 0.010000 19.1277778 0.010000 19.1305556 0.010000 19.1333333 0.010000 19.1361111 0.010000 19.1388889 0.010000 19.1416667 0.010000 19.1444444 0.010000 19.1472222 0.010000 19.1500000 0.010000 19.1527778 0.027922 19.1555556 0.061317 19.1583333 0.111410 19.1611111 0.159833 19.1638889 0.213265 19.1666667 0.270037 19.1694444 0.330148 19.1722222 0.391929 19.1750000 0.457050 19.1777778 0.532189 19.1805556 0.612338 19.1833333 0.685807 19.1861111 0.762616 19.1888889 0.827737 19.1916667 0.850000 19.1944444 0.850000 19.1972222 0.850000 19.2000000 0.850000 19.2027778 0.850000 19.2055556 0.850000 19.2083333 0.850000 19.2111111 0.850000 19.2138889 0.850000 19.2166667 0.850000 19.2194444 0.847774 19.2222222 0.844434 19.2250000 0.846104 19.2277778 0.850000 19.2305556 0.850000 19.2333333 0.850000 19.2361111 0.822727 19.2388889 0.780983 19.2416667 0.729221 19.2444444 0.665770 19.2472222 0.587291 19.2500000 0.485436 19.2527778 0.371892 19.2555556 0.244991 19.2583333 0.113080 19.2611111 0.010000 19.2638889 0.010000 19.2666667 0.010000 19.2694444 0.010000 19.2722222 0.010000 19.2750000 0.010000 19.2777778 0.010000 19.2805556 0.010000 19.2833333 0.010000 19.2861111 0.010000 19.2888889 0.010000 19.2916667 0.010000 19.2944444 0.010000 19.2972222 0.010000 19.3000000 0.010000 19.3027778 0.010000 19.3055556 0.010000 19.3083333 0.010000 19.3111111 0.010000 19.3138889 0.010000 19.3166667 0.010000 19.3194444 0.010000 19.3222222 0.010000 19.3250000 0.010000 19.3277778 0.010000 19.3305556 0.010000 19.3333333 0.010000 19.3361111 0.010000 19.3388889 0.010000 19.3416667 0.010000 19.3444444 0.010000 19.3472222 0.010000 19.3500000 0.010000 19.3527778 0.010000 19.3555556 0.010000 19.3583333 0.010000 19.3611111 0.010000 19.3638889 0.010000 19.3666667 0.010000 19.3694444 0.010000 19.3722222 0.010000 19.3750000 0.010000 19.3777778 0.010000 19.3805556 0.010000 19.3833333 0.010000 19.3861111 0.010000 19.3888889 0.010000 19.3916667 0.010000 19.3944444 0.010000 19.3972222 0.010000 19.4000000 0.010000 19.4027778 0.010000 19.4055556 0.010000 19.4083333 0.010000 19.4111111 0.010000 19.4138889 0.010000 19.4166667 0.010000 19.4194444 0.010000 19.4222222 0.010000 19.4250000 0.010000 19.4277778 0.010000 19.4305556 0.010000 19.4333333 0.010000 19.4361111 0.010000 19.4388889 0.010000 19.4416667 0.010000 19.4444444 0.010000 19.4472222 0.010000 19.4500000 0.010000 19.4527778 0.010000 19.4555556 0.010000 19.4583333 0.010000 19.4611111 0.010000 19.4638889 0.010000 19.4666667 0.010000 19.4694444 0.010000 19.4722222 0.010000 19.4750000 0.010000 19.4777778 0.010000 19.4805556 0.010000 19.4833333 0.010000 19.4861111 0.010000 19.4888889 0.010000 19.4916667 0.010000 19.4944444 0.010000 19.4972222 0.010000 20.2527778 0.010000 20.2555556 0.010000 20.2583333 0.010000 20.2611111 0.010000 20.2638889 0.010000 20.2666667 0.010000 20.2694444 0.010000 20.2722222 0.010000 20.2750000 0.010000 20.2777778 0.010000 20.2805556 0.010000 20.2833333 0.010000 20.2861111 0.010000 20.2888889 0.010000 20.2916667 0.010000 20.2944444 0.010000 20.2972222 0.010000 20.3000000 0.010000 20.3027778 0.010000 20.3055556 0.010000 20.3083333 0.010000 20.3111111 0.010000 20.3138889 0.010000 20.3166667 0.010000 20.3194444 0.010000 20.3222222 0.010000 20.3250000 0.010000 20.3277778 0.010000 20.3305556 0.010000 20.3333333 0.010000 20.3361111 0.010000 20.3388889 0.010000 20.3416667 0.010000 20.3444444 0.010000 20.3472222 0.010000 20.3500000 0.010000 20.3527778 0.014564 20.3555556 0.027922 20.3583333 0.044620 20.3611111 0.054638 20.3638889 0.059647 20.3666667 0.064657 20.3694444 0.061317 20.3722222 0.057978 20.3750000 0.042950 20.3777778 0.051299 20.3805556 0.051299 20.3833333 0.046289 20.3861111 0.049629 20.3888889 0.047959 20.3916667 0.037941 20.3944444 0.026252 20.3972222 0.014564 20.4000000 0.010000 20.4027778 0.010000 20.4055556 0.010000 20.4083333 0.010000 20.4111111 0.010000 20.4138889 0.010000 20.4166667 0.010000 20.4194444 0.010000 20.4222222 0.010000 20.4250000 0.010000 20.4277778 0.010000 20.4305556 0.010000 20.4333333 0.010000 20.4361111 0.010000 20.4388889 0.010000 20.4416667 0.010000 20.4444444 0.010000 20.4472222 0.010000 20.4500000 0.010000 20.4527778 0.010000 20.4555556 0.010000 20.4583333 0.010000 20.4611111 0.010000 20.4638889 0.010000 20.4666667 0.010000 20.4694444 0.010000 20.4722222 0.010000 20.4750000 0.010000 20.4777778 0.010000 20.4805556 0.010000 20.4833333 0.010000 20.4861111 0.088033 20.4888889 0.199907 20.4916667 0.331818 20.4944444 0.457050 20.4972222 0.573933 20.5000000 0.649072 20.5027778 0.685807 20.5055556 0.687477 20.5083333 0.652412 20.5111111 0.575603 20.5138889 0.462059 20.5166667 0.300093 20.5194444 0.124768 20.5222222 0.010000 20.5250000 0.010000 20.5277778 0.010000 20.5305556 0.010000 20.5333333 0.010000 20.5361111 0.010000 20.5388889 0.026252 20.5416667 0.017904 20.5444444 0.010000 20.5472222 0.010000 20.5500000 0.010000 20.5527778 0.010000 20.5555556 0.010000 20.5583333 0.010000 20.5611111 0.010000 20.5638889 0.010000 20.5666667 0.010000 20.5694444 0.010000 20.5722222 0.010000 20.5750000 0.010000 20.5777778 0.010000 20.5805556 0.010000 20.5833333 0.010000 20.5861111 0.010000 20.5888889 0.010000 20.5916667 0.010000 20.5944444 0.010000 20.5972222 0.010000 20.6000000 0.010000 20.6027778 0.010000 20.6055556 0.010000 20.6083333 0.010000 20.6111111 0.010000 20.6138889 0.010000 20.6166667 0.010000 20.6194444 0.010000 20.6222222 0.010000 20.6250000 0.010000 20.6277778 0.010000 20.6305556 0.010000 20.6333333 0.010000 20.6361111 0.010000 20.6388889 0.010000 20.6416667 0.010000 20.6444444 0.010000 20.6472222 0.010000 20.6500000 0.010000 20.6527778 0.010000 20.6555556 0.010000 20.6583333 0.010000 20.6611111 0.010000 20.6638889 0.010000 20.6666667 0.010000 20.6694444 0.010000 20.6722222 0.010000 20.6750000 0.010000 20.6777778 0.010000 20.6805556 0.010000 20.6833333 0.010000 20.6861111 0.010000 20.6888889 0.010000 20.6916667 0.010000 20.6944444 0.010000 20.6972222 0.010000 20.7000000 0.010000 20.7027778 0.010000 20.7055556 0.010000 20.7083333 0.010000 20.7111111 0.010000 20.7138889 0.010000 20.7166667 0.010000 20.7194444 0.010000 20.7222222 0.010000 20.7250000 0.010000 20.7277778 0.010000 20.7305556 0.010000 20.7333333 0.010000 20.7361111 0.010000 20.7388889 0.010000 20.7416667 0.010000 20.7444444 0.010000 20.7472222 0.010000 20.7500000 0.010000 20.7527778 0.010000 20.7555556 0.010000 20.7583333 0.010000 20.7611111 0.012894 20.7638889 0.026252 20.7666667 0.027922 20.7694444 0.032931 20.7722222 0.039610 20.7750000 0.037941 20.7777778 0.041280 20.7805556 0.046289 20.7833333 0.056308 20.7861111 0.057978 20.7888889 0.067996 20.7916667 0.076345 20.7944444 0.081354 20.7972222 0.086364 20.8000000 0.091373 20.8055556 0.099722 20.8083333 0.098052 20.8111111 0.099722 20.8138889 0.098052 20.8166667 0.104731 20.8194444 0.114750 20.8222222 0.119759 20.8250000 0.124768 20.8277778 0.129777 20.8305556 0.129777 20.8333333 0.129777 20.8361111 0.123098 20.8388889 0.116419 20.8416667 0.114750 20.8444444 0.108071 20.8472222 0.094712 20.8500000 0.086364 20.8527778 0.081354 20.8555556 0.074675 20.8583333 0.069666 20.8611111 0.062987 20.8638889 0.057978 20.8666667 0.042950 20.8694444 0.036271 20.8722222 0.026252 20.8750000 0.022913 20.8777778 0.012894 20.8805556 0.010000 20.8833333 0.010000 20.8861111 0.010000 20.8888889 0.010000 20.8916667 0.010000 20.8944444 0.010000 20.8972222 0.010000 20.9000000 0.010000 20.9027778 0.010000 20.9055556 0.010000 20.9083333 0.010000 20.9111111 0.010000 20.9138889 0.010000 20.9166667 0.010000 20.9194444 0.010000 20.9222222 0.010000 20.9250000 0.010000 20.9277778 0.010000 20.9305556 0.010000 20.9333333 0.010000 20.9361111 0.010000 20.9388889 0.010000 20.9416667 0.010000 20.9444444 0.010000 20.9472222 0.010000 20.9500000 0.010000 20.9527778 0.010000 20.9555556 0.010000 20.9583333 0.010000 20.9611111 0.010000 20.9638889 0.010000 20.9666667 0.010000 20.9694444 0.010000 20.9722222 0.010000 20.9750000 0.010000 20.9777778 0.010000 20.9805556 0.010000 20.9833333 0.010000 20.9861111 0.010000 20.9888889 0.010000 20.9916667 0.010000 20.9944444 0.010000 20.9972222 0.010000 21.0000000 0.010000 21.0027778 0.010000 21.0055556 0.012894 21.0083333 0.044620 21.0111111 0.069666 21.0138889 0.108071 21.0166667 0.153154 21.0194444 0.213265 21.0222222 0.265028 21.0250000 0.331818 21.0277778 0.400278 21.0305556 0.473748 21.0333333 0.547217 21.0361111 0.620686 21.0388889 0.690816 21.0416667 0.757607 21.0444444 0.819388 21.0472222 0.850000 21.0500000 0.850000 21.0527778 0.850000 21.0555556 0.850000 21.0583333 0.850000 21.0611111 0.850000 21.0638889 0.850000 21.0666667 0.850000 21.0694444 0.850000 21.0722222 0.850000 21.0750000 0.850000 21.0777778 0.846104 21.0805556 0.834416 21.0833333 0.832746 21.0861111 0.842764 21.0888889 0.850000 21.0916667 0.850000 21.0944444 0.841095 21.0972222 0.814378 21.1000000 0.767625 21.1027778 0.704174 21.1055556 0.640724 21.1083333 0.565584 21.1111111 0.480427 21.1138889 0.373562 21.1166667 0.255009 21.1194444 0.133117 21.1222222 0.019573 21.1250000 0.010000 21.1277778 0.010000 21.1305556 0.010000 21.1333333 0.010000 21.1361111 0.010000 21.1388889 0.010000 21.1416667 0.010000 21.1444444 0.010000 21.1472222 0.010000 21.1500000 0.010000 21.1527778 0.010000 21.1555556 0.010000 21.1583333 0.010000 21.1611111 0.010000 21.1638889 0.010000 21.1666667 0.010000 21.1694444 0.010000 21.1722222 0.010000 21.1750000 0.010000 21.1777778 0.010000 21.1805556 0.010000 21.1833333 0.010000 21.1861111 0.010000 21.1888889 0.010000 21.1916667 0.010000 21.1944444 0.010000 21.1972222 0.010000 21.2000000 0.010000 21.2027778 0.010000 21.2055556 0.010000 21.2083333 0.010000 21.2111111 0.010000 21.2138889 0.010000 21.2166667 0.010000 21.2194444 0.010000 21.2222222 0.010000 21.2250000 0.010000 21.2277778 0.010000 21.2305556 0.010000 21.2333333 0.010000 21.2361111 0.010000 21.2388889 0.010000 21.2416667 0.010000 21.2444444 0.010000 21.2472222 0.010000 21.2500000 0.010000 21.2527778 0.010000 21.2555556 0.010000 21.2583333 0.010000 21.2611111 0.010000 21.2638889 0.010000 21.2666667 0.010000 21.2694444 0.010000 21.2722222 0.010000 21.2750000 0.010000 21.2777778 0.010000 21.2805556 0.010000 21.2833333 0.010000 21.2861111 0.010000 21.2888889 0.010000 21.2916667 0.010000 21.2944444 0.010000 21.2972222 0.010000 21.3000000 0.010000 21.3027778 0.010000 21.3055556 0.010000 21.3083333 0.010000 21.3111111 0.010000 21.3138889 0.010000 21.3166667 0.010000 21.3194444 0.010000 21.3222222 0.010000 21.3250000 0.010000 21.3277778 0.010000 21.3305556 0.010000 21.3333333 0.010000 21.3361111 0.010000 21.3388889 0.010000 21.3416667 0.010000 21.3444444 0.010000 21.3472222 0.010000 21.3500000 0.010000 21.3527778 0.010000 22.1472222 0.010000 22.1500000 0.010000 22.1527778 0.010000 22.1555556 0.010000 22.1583333 0.010000 22.1611111 0.010000 22.1638889 0.010000 22.1666667 0.010000 22.1694444 0.010000 22.1722222 0.010000 22.1750000 0.010000 22.1777778 0.010000 22.1805556 0.010000 22.1833333 0.010000 22.1861111 0.010000 22.1888889 0.010000 22.1916667 0.010000 22.1944444 0.010000 22.1972222 0.010000 22.2000000 0.010000 22.2027778 0.010000 22.2055556 0.010000 22.2083333 0.010000 22.2111111 0.010000 22.2138889 0.010000 22.2166667 0.010000 22.2194444 0.010000 22.2222222 0.010000 22.2250000 0.010000 22.2277778 0.014564 22.2305556 0.017904 22.2333333 0.021243 22.2361111 0.024583 22.2388889 0.029592 22.2416667 0.032931 22.2444444 0.039610 22.2472222 0.042950 22.2500000 0.059647 22.2527778 0.074675 22.2555556 0.079685 22.2583333 0.094712 22.2611111 0.093043 22.2638889 0.091373 22.2666667 0.088033 22.2694444 0.081354 22.2722222 0.074675 22.2750000 0.078015 22.2777778 0.074675 22.2805556 0.071336 22.2833333 0.054638 22.2861111 0.041280 22.2888889 0.022913 22.2916667 0.010000 22.2944444 0.010000 22.2972222 0.010000 22.3000000 0.010000 22.3027778 0.010000 22.3055556 0.010000 22.3083333 0.010000 22.3111111 0.010000 22.3138889 0.010000 22.3166667 0.010000 22.3194444 0.010000 22.3222222 0.010000 22.3250000 0.010000 22.3277778 0.010000 22.3305556 0.010000 22.3333333 0.010000 22.3361111 0.010000 22.3388889 0.010000 22.3416667 0.010000 22.3444444 0.010000 22.3472222 0.010000 22.3500000 0.010000 22.3527778 0.010000 22.3555556 0.010000 22.3583333 0.010000 22.3611111 0.010000 22.3638889 0.010000 22.3666667 0.010000 22.3694444 0.010000 22.3722222 0.010000 22.3750000 0.010000 22.3777778 0.054638 22.3805556 0.141466 22.3833333 0.244991 22.3861111 0.371892 22.3888889 0.502134 22.3916667 0.605659 22.3944444 0.679128 22.3972222 0.705844 22.4000000 0.692486 22.4027778 0.637384 22.4055556 0.530519 22.4083333 0.385250 22.4111111 0.211596 22.4138889 0.049629 22.4166667 0.010000 22.4194444 0.010000 22.4222222 0.010000 22.4250000 0.010000 22.4277778 0.026252 22.4305556 0.047959 22.4333333 0.046289 22.4361111 0.026252 22.4388889 0.010000 22.4416667 0.010000 22.4444444 0.010000 22.4472222 0.010000 22.4500000 0.010000 22.4527778 0.010000 22.4555556 0.010000 22.4583333 0.010000 22.4611111 0.010000 22.4638889 0.010000 22.4666667 0.010000 22.4694444 0.010000 22.4722222 0.010000 22.4750000 0.010000 22.4777778 0.010000 22.4805556 0.010000 22.4833333 0.010000 22.4861111 0.010000 22.4888889 0.010000 22.4916667 0.010000 22.4944444 0.010000 22.4972222 0.010000 22.5000000 0.010000 22.5027778 0.010000 22.5055556 0.010000 22.5083333 0.010000 22.5111111 0.010000 22.5138889 0.010000 22.5166667 0.010000 22.5194444 0.010000 22.5222222 0.010000 22.5250000 0.010000 22.5277778 0.010000 22.5305556 0.010000 22.5333333 0.010000 22.5361111 0.010000 22.5388889 0.010000 22.5416667 0.010000 22.5444444 0.010000 22.5472222 0.010000 22.5500000 0.010000 22.5527778 0.010000 22.5555556 0.010000 22.5583333 0.010000 22.5611111 0.010000 22.5638889 0.010000 22.5666667 0.010000 22.5694444 0.010000 22.5722222 0.010000 22.5750000 0.010000 22.5777778 0.010000 22.5805556 0.010000 22.5833333 0.010000 22.5861111 0.010000 22.5888889 0.010000 22.5916667 0.010000 22.5944444 0.010000 22.5972222 0.010000 22.6000000 0.010000 22.6027778 0.010000 22.6055556 0.010000 22.6083333 0.010000 22.6111111 0.010000 22.6138889 0.010000 22.6166667 0.010000 22.6194444 0.010000 22.6222222 0.010000 22.6250000 0.010000 22.6277778 0.010000 22.6305556 0.016234 22.6333333 0.019573 22.6361111 0.021243 22.6388889 0.026252 22.6416667 0.027922 22.6444444 0.026252 22.6472222 0.032931 22.6500000 0.032931 22.6527778 0.041280 22.6555556 0.042950 22.6583333 0.049629 22.6611111 0.057978 22.6638889 0.066327 22.6666667 0.078015 22.6694444 0.083024 22.6722222 0.079685 22.6750000 0.086364 22.6777778 0.091373 22.6805556 0.093043 22.6833333 0.093043 22.6861111 0.099722 22.6888889 0.108071 22.6916667 0.111410 22.6944444 0.123098 22.6972222 0.129777 22.7000000 0.139796 22.7027778 0.139796 22.7055556 0.141466 22.7083333 0.146475 22.7111111 0.149814 22.7138889 0.146475 22.7166667 0.151484 22.7194444 0.146475 22.7222222 0.149814 22.7250000 0.149814 22.7277778 0.151484 22.7305556 0.151484 22.7333333 0.143135 22.7361111 0.134787 22.7388889 0.119759 22.7416667 0.118089 22.7444444 0.106401 22.7472222 0.101391 22.7500000 0.091373 22.7527778 0.078015 22.7555556 0.069666 22.7583333 0.069666 22.7611111 0.061317 22.7638889 0.059647 22.7666667 0.054638 22.7694444 0.047959 22.7722222 0.037941 22.7750000 0.031262 22.7777778 0.022913 22.7805556 0.016234 22.7833333 0.014564 22.7861111 0.010000 22.7888889 0.011224 22.7916667 0.010000 22.7944444 0.010000 22.7972222 0.010000 22.8000000 0.010000 22.8027778 0.010000 22.8055556 0.010000 22.8083333 0.010000 22.8111111 0.010000 22.8138889 0.010000 22.8166667 0.010000 22.8194444 0.010000 22.8222222 0.010000 22.8250000 0.010000 22.8277778 0.010000 22.8305556 0.010000 22.8333333 0.010000 22.8361111 0.010000 22.8388889 0.011224 22.8416667 0.010000 22.8444444 0.010000 22.8472222 0.010000 22.8500000 0.010000 22.8527778 0.010000 22.8555556 0.010000 22.8583333 0.016234 22.8611111 0.016234 22.8638889 0.012894 22.8666667 0.014564 22.8694444 0.010000 22.8722222 0.010000 22.8750000 0.010000 22.8777778 0.010000 22.8805556 0.012894 22.8833333 0.042950 22.8861111 0.066327 22.8888889 0.111410 22.8916667 0.171521 22.8944444 0.226623 22.8972222 0.281725 22.9000000 0.345176 22.9027778 0.415306 22.9055556 0.483766 22.9083333 0.563915 22.9111111 0.647403 22.9138889 0.720872 22.9166667 0.791002 22.9194444 0.850000 22.9222222 0.850000 22.9250000 0.850000 22.9277778 0.850000 22.9305556 0.850000 22.9333333 0.850000 22.9361111 0.850000 22.9388889 0.850000 22.9416667 0.850000 22.9444444 0.850000 22.9472222 0.850000 22.9500000 0.850000 22.9527778 0.850000 22.9555556 0.850000 22.9583333 0.850000 22.9611111 0.850000 22.9638889 0.850000 22.9666667 0.819388 22.9694444 0.777644 22.9722222 0.714193 22.9750000 0.655751 22.9777778 0.585622 22.9805556 0.512152 22.9833333 0.421985 22.9861111 0.303432 22.9888889 0.189889 22.9916667 0.073006 22.9944444 0.010000 22.9972222 0.010000 23.0000000 0.010000 23.0027778 0.010000 23.0055556 0.010000 23.0083333 0.010000 23.0111111 0.010000 23.0138889 0.010000 23.0166667 0.010000 23.0194444 0.010000 23.0222222 0.010000 23.0250000 0.010000 23.0277778 0.010000 23.0305556 0.010000 23.0333333 0.010000 23.0361111 0.010000 23.0388889 0.010000 23.0416667 0.010000 23.0444444 0.010000 23.0472222 0.010000 23.0500000 0.010000 23.0527778 0.010000 23.0555556 0.010000 23.0583333 0.010000 23.0611111 0.010000 23.0638889 0.010000 23.0666667 0.010000 23.0694444 0.010000 23.0722222 0.010000 23.0750000 0.010000 23.0777778 0.010000 23.0805556 0.010000 23.0833333 0.010000 23.0861111 0.010000 23.0888889 0.010000 23.0916667 0.010000 23.0944444 0.010000 23.0972222 0.010000 23.1000000 0.010000 23.1027778 0.010000 23.1055556 0.010000 23.1083333 0.010000 23.1111111 0.010000 23.1138889 0.010000 23.1166667 0.010000 23.1194444 0.010000 23.1222222 0.010000 23.1250000 0.010000 23.1277778 0.010000 23.1305556 0.010000 23.1333333 0.010000 23.1361111 0.010000 23.1388889 0.010000 23.1416667 0.010000 23.1444444 0.010000 23.1472222 0.010000 23.1500000 0.010000 23.1527778 0.010000 23.1555556 0.010000 23.1583333 0.010000 23.1611111 0.010000 23.1638889 0.010000 23.1666667 0.010000 23.1694444 0.010000 23.1722222 0.010000 23.1750000 0.010000 23.1777778 0.010000 23.1805556 0.010000 23.1833333 0.010000 23.1861111 0.010000 23.1888889 0.010000 23.1916667 0.010000 23.1944444 0.010000 23.1972222 0.010000 23.2000000 0.010000 23.2027778 0.010000 23.2055556 0.010000 23.2083333 0.010000 23.2111111 0.010000 23.2138889 0.010000 23.2166667 0.010000 23.2194444 0.010000 23.2222222 0.010000 23.2250000 0.010000 23.2277778 0.010000 24.0111111 0.010000 24.0138889 0.010000 24.0166667 0.010000 24.0194444 0.010000 24.0222222 0.010000 24.0250000 0.010000 24.0277778 0.010000 24.0305556 0.010000 24.0333333 0.010000 24.0361111 0.010000 24.0388889 0.010000 24.0416667 0.010000 24.0444444 0.010000 24.0472222 0.010000 24.0500000 0.010000 24.0527778 0.010000 24.0555556 0.010000 24.0583333 0.010000 24.0611111 0.010000 24.0638889 0.010000 24.0666667 0.010000 24.0694444 0.010000 24.0722222 0.010000 24.0750000 0.010000 24.0777778 0.010000 24.0805556 0.010000 24.0833333 0.010000 24.0861111 0.010000 24.0888889 0.010000 24.0916667 0.010000 24.0944444 0.010000 24.0972222 0.014564 24.1000000 0.027922 24.1027778 0.034601 24.1055556 0.042950 24.1083333 0.057978 24.1111111 0.064657 24.1138889 0.076345 24.1166667 0.083024 24.1194444 0.079685 24.1222222 0.079685 24.1250000 0.078015 24.1277778 0.078015 24.1305556 0.079685 24.1333333 0.081354 24.1361111 0.079685 24.1388889 0.071336 24.1416667 0.064657 24.1444444 0.037941 24.1472222 0.019573 24.1500000 0.010000 24.1527778 0.010000 24.1555556 0.010000 24.1583333 0.010000 24.1611111 0.010000 24.1638889 0.010000 24.1666667 0.010000 24.1694444 0.010000 24.1722222 0.010000 24.1750000 0.010000 24.1777778 0.010000 24.1805556 0.010000 24.1833333 0.010000 24.1861111 0.010000 24.1888889 0.010000 24.1916667 0.010000 24.1944444 0.010000 24.1972222 0.010000 24.2000000 0.010000 24.2027778 0.010000 24.2055556 0.010000 24.2083333 0.010000 24.2111111 0.010000 24.2138889 0.010000 24.2166667 0.010000 24.2194444 0.010000 24.2222222 0.010000 24.2250000 0.010000 24.2277778 0.010000 24.2305556 0.010000 24.2333333 0.010000 24.2361111 0.010000 24.2388889 0.032931 24.2416667 0.103061 24.2444444 0.194898 24.2472222 0.308442 24.2500000 0.425325 24.2527778 0.548887 24.2555556 0.645733 24.2583333 0.707514 24.2611111 0.725881 24.2638889 0.719202 24.2666667 0.659091 24.2694444 0.553896 24.2722222 0.393599 24.2750000 0.206586 24.2777778 0.046289 24.2805556 0.010000 24.2833333 0.010000 24.2861111 0.010000 24.2888889 0.010000 24.2916667 0.037941 24.2944444 0.051299 24.2972222 0.054638 24.3000000 0.037941 24.3027778 0.014564 24.3055556 0.010000 24.3083333 0.010000 24.3111111 0.010000 24.3138889 0.010000 24.3166667 0.010000 24.3194444 0.010000 24.3222222 0.010000 24.3250000 0.010000 24.3277778 0.010000 24.3305556 0.010000 24.3333333 0.010000 24.3361111 0.010000 24.3388889 0.010000 24.3416667 0.010000 24.3444444 0.010000 24.3472222 0.010000 24.3500000 0.010000 24.3527778 0.010000 24.3555556 0.010000 24.3583333 0.010000 24.3611111 0.010000 24.3638889 0.010000 24.3666667 0.010000 24.3694444 0.010000 24.3722222 0.010000 24.3750000 0.010000 24.3777778 0.010000 24.3805556 0.010000 24.3833333 0.010000 24.3861111 0.010000 24.3888889 0.010000 24.3916667 0.010000 24.3944444 0.010000 24.3972222 0.010000 24.4000000 0.010000 24.4027778 0.010000 24.4055556 0.010000 24.4083333 0.010000 24.4111111 0.010000 24.4138889 0.010000 24.4166667 0.010000 24.4194444 0.010000 24.4222222 0.010000 24.4250000 0.010000 24.4277778 0.010000 24.4305556 0.010000 24.4333333 0.010000 24.4361111 0.010000 24.4388889 0.010000 24.4416667 0.010000 24.4444444 0.010000 24.4472222 0.010000 24.4500000 0.010000 24.4527778 0.010000 24.4555556 0.010000 24.4583333 0.010000 24.4611111 0.010000 24.4638889 0.010000 24.4666667 0.010000 24.4694444 0.010000 24.4722222 0.010000 24.4750000 0.010000 24.4777778 0.012894 24.4805556 0.010000 24.4833333 0.011224 24.4861111 0.016234 24.4888889 0.022913 24.4916667 0.029592 24.4944444 0.032931 24.4972222 0.039610 24.5000000 0.047959 24.5027778 0.057978 24.5055556 0.054638 24.5083333 0.064657 24.5111111 0.066327 24.5138889 0.071336 24.5166667 0.074675 24.5194444 0.078015 24.5222222 0.084694 24.5250000 0.096382 24.5277778 0.101391 24.5305556 0.111410 24.5333333 0.121429 24.5361111 0.123098 24.5388889 0.124768 24.5416667 0.123098 24.5444444 0.124768 24.5472222 0.131447 24.5500000 0.131447 24.5527778 0.144805 24.5555556 0.149814 24.5583333 0.159833 24.5805556 0.158163 24.5833333 0.161503 24.5861111 0.153154 24.5888889 0.146475 24.5916667 0.143135 24.5944444 0.141466 24.5972222 0.138126 24.6000000 0.136456 24.6027778 0.128108 24.6055556 0.116419 24.6083333 0.101391 24.6111111 0.094712 24.6138889 0.089703 24.6166667 0.083024 24.6194444 0.079685 24.6222222 0.069666 24.6250000 0.062987 24.6277778 0.061317 24.6305556 0.061317 24.6333333 0.061317 24.6361111 0.052968 24.6388889 0.049629 24.6416667 0.042950 24.6444444 0.037941 24.6472222 0.032931 24.6500000 0.029592 24.6527778 0.026252 24.6555556 0.027922 24.6583333 0.027922 24.6611111 0.026252 24.6638889 0.026252 24.6666667 0.027922 24.6694444 0.027922 24.6722222 0.022913 24.6750000 0.027922 24.6777778 0.022913 24.6805556 0.021243 24.6833333 0.017904 24.6861111 0.019573 24.6888889 0.017904 24.6916667 0.019573 24.6944444 0.024583 24.6972222 0.027922 24.7000000 0.026252 24.7027778 0.026252 24.7055556 0.029592 24.7083333 0.024583 24.7111111 0.022913 24.7138889 0.029592 24.7166667 0.021243 24.7194444 0.021243 24.7222222 0.026252 24.7250000 0.026252 24.7277778 0.029592 24.7305556 0.029592 24.7333333 0.031262 24.7361111 0.029592 24.7388889 0.034601 24.7416667 0.034601 24.7444444 0.034601 24.7472222 0.031262 24.7500000 0.034601 24.7527778 0.032931 24.7555556 0.032931 24.7583333 0.032931 24.7611111 0.029592 24.7638889 0.031262 24.7666667 0.032931 24.7694444 0.029592 24.7722222 0.026252 24.7750000 0.021243 24.7777778 0.024583 24.7805556 0.034601 24.7833333 0.057978 24.7861111 0.088033 24.7888889 0.128108 24.7916667 0.183210 24.7944444 0.236642 24.7972222 0.291744 24.8000000 0.363544 24.8027778 0.430334 24.8055556 0.502134 24.8083333 0.570594 24.8111111 0.640724 24.8138889 0.717532 24.8166667 0.784323 24.8194444 0.844434 24.8222222 0.850000 24.8250000 0.850000 24.8277778 0.850000 24.8305556 0.850000 24.8333333 0.850000 24.8361111 0.850000 24.8388889 0.850000 24.8416667 0.850000 24.8444444 0.850000 24.8472222 0.850000 24.8500000 0.850000 24.8527778 0.850000 24.8555556 0.850000 24.8583333 0.850000 24.8611111 0.850000 24.8638889 0.850000 24.8666667 0.850000 24.8694444 0.819388 24.8722222 0.770965 24.8750000 0.705844 24.8777778 0.637384 24.8805556 0.562245 24.8833333 0.470408 24.8861111 0.360204 24.8888889 0.234972 24.8916667 0.113080 24.8944444 0.019573 24.8972222 0.010000 24.9000000 0.010000 24.9027778 0.010000 24.9055556 0.010000 24.9083333 0.010000 24.9111111 0.010000 24.9138889 0.010000 24.9166667 0.010000 24.9194444 0.010000 24.9222222 0.010000 24.9250000 0.010000 24.9277778 0.010000 24.9305556 0.010000 24.9333333 0.010000 24.9361111 0.010000 24.9388889 0.010000 24.9416667 0.010000 24.9444444 0.010000 24.9472222 0.010000 24.9500000 0.010000 24.9527778 0.010000 24.9555556 0.010000 24.9583333 0.010000 24.9611111 0.010000 24.9638889 0.010000 24.9666667 0.010000 24.9694444 0.010000 24.9722222 0.010000 24.9750000 0.010000 24.9777778 0.010000 24.9805556 0.010000 24.9833333 0.010000 24.9861111 0.010000 24.9888889 0.010000 24.9916667 0.010000 24.9944444 0.010000 24.9972222 0.010000 25.0000000 0.010000 25.0027778 0.010000 25.0055556 0.010000 25.0083333 0.010000 25.0111111 0.010000 25.0138889 0.010000 25.0166667 0.010000 25.0194444 0.010000 25.0222222 0.010000 25.0250000 0.010000 25.0277778 0.010000 25.0305556 0.010000 25.0333333 0.010000 25.0361111 0.010000 25.0388889 0.010000 25.0416667 0.010000 25.0444444 0.010000 25.0472222 0.010000 25.0500000 0.010000 25.0527778 0.010000 25.0555556 0.010000 25.0583333 0.010000 25.0611111 0.010000 25.0638889 0.010000 25.0666667 0.010000 25.0694444 0.010000 25.0722222 0.010000 25.0750000 0.010000 25.0777778 0.010000 25.0805556 0.010000 25.0833333 0.010000 25.0861111 0.010000 25.0888889 0.010000 25.0916667 0.010000 25.0944444 0.010000 25.0972222 0.010000 25.1000000 0.010000 25.1027778 0.010000 25.1055556 0.010000 25.1083333 0.010000 25.1111111 0.010000 25.1138889 0.010000 25.1166667 0.010000 25.1194444 0.010000 25.1222222 0.010000 25.1250000 0.010000 25.1277778 0.010000 25.8527778 0.010000 25.8555556 0.010000 25.8583333 0.010000 25.8611111 0.010000 25.8638889 0.010000 25.8666667 0.010000 25.8694444 0.010000 25.8722222 0.010000 25.8750000 0.010000 25.8777778 0.010000 25.8805556 0.010000 25.8833333 0.010000 25.8861111 0.010000 25.8888889 0.010000 25.8916667 0.010000 25.8944444 0.010000 25.8972222 0.010000 25.9000000 0.010000 25.9027778 0.010000 25.9055556 0.010000 25.9083333 0.010000 25.9111111 0.010000 25.9138889 0.010000 25.9166667 0.010000 25.9194444 0.010000 25.9222222 0.010000 25.9250000 0.010000 25.9277778 0.010000 25.9305556 0.010000 25.9333333 0.010000 25.9361111 0.010000 25.9388889 0.012894 25.9416667 0.011224 25.9444444 0.021243 25.9472222 0.022913 25.9500000 0.032931 25.9527778 0.046289 25.9555556 0.061317 25.9583333 0.079685 25.9611111 0.086364 25.9638889 0.086364 25.9666667 0.083024 25.9694444 0.079685 25.9722222 0.073006 25.9750000 0.076345 25.9777778 0.073006 25.9805556 0.066327 25.9833333 0.054638 25.9861111 0.041280 25.9888889 0.027922 25.9916667 0.011224 25.9944444 0.010000 25.9972222 0.010000 26.0000000 0.010000 26.0027778 0.010000 26.0055556 0.010000 26.0083333 0.010000 26.0111111 0.010000 26.0138889 0.010000 26.0166667 0.010000 26.0194444 0.010000 26.0222222 0.010000 26.0250000 0.010000 26.0277778 0.010000 26.0305556 0.010000 26.0333333 0.010000 26.0361111 0.010000 26.0388889 0.010000 26.0416667 0.010000 26.0444444 0.010000 26.0472222 0.010000 26.0500000 0.010000 26.0527778 0.010000 26.0555556 0.010000 26.0583333 0.010000 26.0611111 0.010000 26.0638889 0.010000 26.0666667 0.010000 26.0694444 0.010000 26.0722222 0.010000 26.0750000 0.010000 26.0777778 0.010000 26.0805556 0.026252 26.0833333 0.096382 26.0861111 0.184879 26.0888889 0.305102 26.0916667 0.437013 26.0944444 0.553896 26.0972222 0.652412 26.1000000 0.710853 26.1027778 0.734230 26.1055556 0.715863 26.1083333 0.654082 26.1111111 0.547217 26.1138889 0.390260 26.1166667 0.201577 26.1194444 0.039610 26.1222222 0.010000 26.1250000 0.010000 26.1277778 0.010000 26.1305556 0.010000 26.1333333 0.032931 26.1361111 0.054638 26.1388889 0.052968 26.1416667 0.024583 26.1444444 0.010000 26.1472222 0.010000 26.1500000 0.010000 26.1527778 0.010000 26.1555556 0.010000 26.1583333 0.010000 26.1611111 0.010000 26.1638889 0.010000 26.1666667 0.010000 26.1694444 0.010000 26.1722222 0.010000 26.1750000 0.010000 26.1777778 0.010000 26.1805556 0.010000 26.1833333 0.010000 26.1861111 0.010000 26.1888889 0.010000 26.1916667 0.010000 26.1944444 0.010000 26.1972222 0.010000 26.2000000 0.010000 26.2027778 0.010000 26.2055556 0.010000 26.2083333 0.010000 26.2111111 0.010000 26.2138889 0.010000 26.2166667 0.010000 26.2194444 0.010000 26.2222222 0.010000 26.2250000 0.010000 26.2277778 0.010000 26.2305556 0.010000 26.2333333 0.010000 26.2361111 0.010000 26.2388889 0.010000 26.2416667 0.010000 26.2444444 0.010000 26.2472222 0.010000 26.2500000 0.010000 26.2527778 0.010000 26.2555556 0.010000 26.2583333 0.010000 26.2611111 0.010000 26.2638889 0.010000 26.2666667 0.010000 26.2694444 0.010000 26.2722222 0.010000 26.2750000 0.010000 26.2777778 0.010000 26.2805556 0.010000 26.2833333 0.010000 26.2861111 0.010000 26.2888889 0.010000 26.2916667 0.010000 26.2944444 0.010000 26.2972222 0.010000 26.3000000 0.010000 26.3027778 0.010000 26.3055556 0.010000 26.3083333 0.010000 26.3111111 0.010000 26.3138889 0.010000 26.3166667 0.010000 26.3194444 0.010000 26.3222222 0.010000 26.3250000 0.010000 26.3277778 0.010000 26.3305556 0.010000 26.3333333 0.010000 26.3361111 0.010000 26.3388889 0.010000 26.3416667 0.010000 26.3444444 0.010000 26.3472222 0.010000 26.3500000 0.011224 26.3527778 0.012894 26.3555556 0.019573 26.3583333 0.024583 26.3611111 0.032931 26.3638889 0.041280 26.3666667 0.051299 26.3694444 0.056308 26.3722222 0.056308 26.3750000 0.059647 26.3777778 0.066327 26.3805556 0.066327 26.3833333 0.071336 26.3861111 0.074675 26.3888889 0.079685 26.3916667 0.086364 26.3944444 0.094712 26.3972222 0.098052 26.4000000 0.108071 26.4833333 0.047959 26.4861111 0.039610 26.4888889 0.036271 26.4916667 0.037941 26.4944444 0.037941 26.4972222 0.032931 26.5000000 0.031262 26.5027778 0.027922 26.5055556 0.026252 26.5083333 0.022913 26.5111111 0.014564 26.5138889 0.012894 26.5166667 0.012894 26.5194444 0.012894 26.5222222 0.010000 26.5250000 0.011224 26.5277778 0.010000 26.5305556 0.012894 26.5333333 0.016234 26.5361111 0.017904 26.5388889 0.017904 26.5416667 0.014564 26.5444444 0.014564 26.5472222 0.011224 26.5500000 0.010000 26.5527778 0.011224 26.5555556 0.014564 26.5583333 0.016234 26.5611111 0.019573 26.5638889 0.021243 26.5666667 0.022913 26.5694444 0.024583 26.5722222 0.021243 26.5750000 0.019573 26.5777778 0.021243 26.5805556 0.022913 26.5833333 0.021243 26.5861111 0.021243 26.5888889 0.022913 26.5916667 0.027922 26.5944444 0.022913 26.5972222 0.026252 26.6000000 0.032931 26.6027778 0.036271 26.6055556 0.034601 26.6083333 0.034601 26.6111111 0.029592 26.6138889 0.029592 26.6166667 0.027922 26.6194444 0.022913 26.6222222 0.022913 26.6250000 0.019573 26.6277778 0.019573 26.6305556 0.022913 26.6333333 0.024583 26.6361111 0.022913 26.6388889 0.024583 26.6416667 0.027922 26.6444444 0.032931 26.6472222 0.051299 26.6500000 0.074675 26.6527778 0.113080 26.6555556 0.161503 26.6583333 0.206586 26.6611111 0.260019 26.6638889 0.315121 26.6666667 0.380241 26.6694444 0.447032 26.6722222 0.517161 26.6750000 0.592301 26.6777778 0.664100 26.6805556 0.727551 26.6833333 0.794341 26.6861111 0.844434 26.6888889 0.850000 26.6916667 0.850000 26.6944444 0.850000 26.6972222 0.850000 26.7000000 0.850000 26.7027778 0.850000 26.7055556 0.850000 26.7083333 0.850000 26.7111111 0.850000 26.7138889 0.850000 26.7166667 0.850000 26.7194444 0.850000 26.7222222 0.850000 26.7250000 0.850000 26.7277778 0.850000 26.7305556 0.850000 26.7333333 0.850000 26.7361111 0.850000 26.7388889 0.850000 26.7416667 0.804360 26.7444444 0.742579 26.7472222 0.677458 26.7500000 0.595640 26.7527778 0.497124 26.7555556 0.376902 26.7583333 0.244991 26.7611111 0.116419 26.7638889 0.026252 26.7666667 0.010000 26.7694444 0.010000 26.7722222 0.010000 26.7750000 0.010000 26.7777778 0.010000 26.7805556 0.010000 26.7833333 0.010000 26.7861111 0.010000 26.7888889 0.010000 26.7916667 0.010000 26.7944444 0.010000 26.7972222 0.010000 26.8000000 0.010000 26.8027778 0.010000 26.8055556 0.010000 26.8083333 0.010000 26.8111111 0.010000 26.8138889 0.010000 26.8166667 0.010000 26.8194444 0.010000 26.8222222 0.010000 26.8250000 0.010000 26.8277778 0.010000 26.8305556 0.010000 26.8333333 0.010000 26.8361111 0.010000 26.8388889 0.010000 26.8416667 0.010000 26.8444444 0.010000 26.8472222 0.010000 26.8500000 0.010000 26.8527778 0.010000 26.8555556 0.010000 26.8583333 0.010000 26.8611111 0.010000 26.8638889 0.010000 26.8666667 0.010000 26.8694444 0.010000 26.8722222 0.010000 26.8750000 0.010000 26.8777778 0.010000 26.8805556 0.010000 26.8833333 0.010000 26.8861111 0.010000 26.8888889 0.010000 26.8916667 0.010000 26.8944444 0.010000 26.8972222 0.010000 26.9000000 0.010000 26.9027778 0.010000 26.9055556 0.010000 26.9083333 0.010000 26.9111111 0.010000 26.9138889 0.010000 26.9166667 0.010000 26.9194444 0.010000 26.9222222 0.010000 26.9250000 0.010000 26.9277778 0.010000 26.9305556 0.010000 26.9333333 0.010000 26.9361111 0.010000 26.9388889 0.010000 26.9416667 0.010000 26.9444444 0.010000 26.9472222 0.010000 26.9500000 0.010000 26.9527778 0.010000 26.9555556 0.010000 26.9583333 0.010000 26.9611111 0.010000 26.9638889 0.010000 26.9666667 0.010000 26.9694444 0.010000 26.9722222 0.010000 26.9750000 0.010000 26.9777778 0.010000 26.9805556 0.010000 26.9833333 0.010000 26.9861111 0.010000 26.9888889 0.010000 26.9916667 0.010000 26.9944444 0.010000 26.9972222 0.010000 27.0000000 0.010000 27.0027778 0.010000 27.0055556 0.010000 27.0083333 0.010000 27.0111111 0.010000 27.0138889 0.010000 27.0166667 0.010000 27.0194444 0.010000 27.0222222 0.010000 27.0250000 0.010000 27.0277778 0.010000 27.0305556 0.010000 27.7222222 0.010000 27.7250000 0.010000 27.7277778 0.010000 27.7305556 0.010000 27.7333333 0.010000 27.7361111 0.010000 27.7388889 0.010000 27.7416667 0.010000 27.7444444 0.010000 27.7472222 0.010000 27.7500000 0.010000 27.7527778 0.010000 27.7555556 0.010000 27.7583333 0.010000 27.7611111 0.010000 27.7638889 0.010000 27.7666667 0.010000 27.7694444 0.010000 27.7722222 0.010000 27.7750000 0.010000 27.7777778 0.010000 27.7805556 0.010000 27.7833333 0.010000 27.7861111 0.010000 27.7888889 0.010000 27.7916667 0.010000 27.7944444 0.010000 27.7972222 0.010000 27.8000000 0.016234 27.8027778 0.022913 27.8055556 0.024583 27.8083333 0.027922 27.8111111 0.027922 27.8138889 0.032931 27.8166667 0.037941 27.8194444 0.044620 27.8222222 0.056308 27.8250000 0.069666 27.8277778 0.084694 27.8305556 0.091373 27.8333333 0.094712 27.8361111 0.096382 27.8388889 0.093043 27.8416667 0.084694 27.8444444 0.086364 27.8472222 0.083024 27.8500000 0.083024 27.8527778 0.084694 27.8555556 0.074675 27.8583333 0.062987 27.8611111 0.044620 27.8638889 0.032931 27.8666667 0.022913 27.8694444 0.010000 27.8722222 0.010000 27.8750000 0.010000 27.8777778 0.010000 27.8805556 0.010000 27.8833333 0.010000 27.8861111 0.010000 27.8888889 0.010000 27.8916667 0.010000 27.8944444 0.010000 27.8972222 0.010000 27.9000000 0.010000 27.9027778 0.010000 27.9055556 0.010000 27.9083333 0.010000 27.9111111 0.010000 27.9138889 0.010000 27.9166667 0.010000 27.9194444 0.010000 27.9222222 0.010000 27.9250000 0.010000 27.9277778 0.010000 27.9305556 0.010000 27.9333333 0.010000 27.9361111 0.010000 27.9388889 0.010000 27.9416667 0.010000 27.9444444 0.010000 27.9472222 0.010000 27.9500000 0.010000 27.9527778 0.039610 27.9555556 0.113080 27.9583333 0.214935 27.9611111 0.336827 27.9638889 0.472078 27.9666667 0.585622 27.9694444 0.674119 27.9722222 0.720872 27.9750000 0.730891 27.9777778 0.697495 27.9805556 0.619017 27.9833333 0.500464 27.9861111 0.328479 27.9888889 0.151484 27.9916667 0.010000 27.9944444 0.010000 27.9972222 0.010000 28.0000000 0.010000 28.0027778 0.010000 28.0055556 0.042950 28.0083333 0.056308 28.0111111 0.046289 28.0138889 0.017904 28.0166667 0.010000 28.0194444 0.010000 28.0222222 0.010000 28.0250000 0.010000 28.0277778 0.010000 28.0305556 0.010000 28.0333333 0.010000 28.0361111 0.010000 28.0388889 0.010000 28.0416667 0.010000 28.0444444 0.010000 28.0472222 0.010000 28.0500000 0.010000 28.0527778 0.010000 28.0555556 0.010000 28.0583333 0.010000 28.0611111 0.010000 28.0638889 0.010000 28.0666667 0.010000 28.0694444 0.010000 28.0722222 0.010000 28.0750000 0.010000 28.0777778 0.010000 28.0805556 0.010000 28.0833333 0.010000 28.0861111 0.010000 28.0888889 0.010000 28.0916667 0.010000 28.0944444 0.010000 28.0972222 0.010000 28.1000000 0.010000 28.1027778 0.010000 28.1055556 0.010000 28.1083333 0.010000 28.1111111 0.010000 28.1138889 0.010000 28.1166667 0.010000 28.1194444 0.010000 28.1222222 0.010000 28.1250000 0.010000 28.1277778 0.010000 28.1305556 0.010000 28.1333333 0.010000 28.1361111 0.010000 28.1388889 0.010000 28.1416667 0.010000 28.1444444 0.010000 28.1472222 0.010000 28.1500000 0.010000 28.1527778 0.010000 28.1555556 0.010000 28.1583333 0.010000 28.1611111 0.010000 28.1638889 0.010000 28.1666667 0.010000 28.1694444 0.010000 28.1722222 0.010000 28.1750000 0.010000 28.1777778 0.010000 28.1805556 0.010000 28.1833333 0.010000 28.1861111 0.010000 28.1888889 0.010000 28.1916667 0.010000 28.1944444 0.010000 28.1972222 0.010000 28.2000000 0.010000 28.2027778 0.010000 28.2055556 0.014564 28.2083333 0.021243 28.2111111 0.022913 28.2138889 0.022913 28.2166667 0.022913 28.2194444 0.027922 28.2222222 0.029592 28.2250000 0.039610 28.2277778 0.046289 28.2305556 0.056308 28.2333333 0.062987 28.2361111 0.066327 28.2388889 0.071336 28.2416667 0.078015 28.2444444 0.078015 28.2472222 0.071336 28.2500000 0.081354 28.2527778 0.079685 28.2555556 0.083024 28.2583333 0.088033 28.2611111 0.091373 28.2638889 0.106401 28.2666667 0.114750 28.2694444 0.118089 28.2722222 0.121429 28.2750000 0.126438 28.2777778 0.129777 28.2805556 0.121429 28.2833333 0.129777 28.2861111 0.128108 28.2888889 0.133117 28.2916667 0.138126 28.2944444 0.144805 28.2972222 0.148145 28.3000000 0.154824 28.3027778 0.159833 28.3055556 0.161503 28.3083333 0.159833 28.3111111 0.153154 28.3138889 0.149814 28.3166667 0.139796 28.3194444 0.134787 28.3222222 0.128108 28.3250000 0.119759 28.3277778 0.111410 28.3305556 0.116419 28.3333333 0.111410 28.3361111 0.108071 28.3388889 0.106401 28.3416667 0.094712 28.3444444 0.083024 28.3472222 0.071336 28.3500000 0.061317 28.3527778 0.052968 28.3555556 0.051299 28.3583333 0.042950 28.3611111 0.046289 28.3638889 0.046289 28.3666667 0.037941 28.3694444 0.039610 28.3722222 0.041280 28.3750000 0.032931 28.3777778 0.026252 28.3805556 0.017904 28.3833333 0.019573 28.3861111 0.017904 28.3888889 0.016234 28.3916667 0.017904 28.3944444 0.019573 28.3972222 0.022913 28.4000000 0.017904 28.4027778 0.024583 28.4055556 0.022913 28.4083333 0.022913 28.4111111 0.022913 28.4138889 0.019573 28.4166667 0.019573 28.4194444 0.017904 28.4222222 0.016234 28.4250000 0.017904 28.4277778 0.027922 28.4305556 0.031262 28.4333333 0.037941 28.4361111 0.037941 28.4388889 0.039610 28.4416667 0.036271 28.4444444 0.039610 28.4472222 0.034601 28.4500000 0.032931 28.4527778 0.026252 28.4555556 0.022913 28.4583333 0.027922 28.4611111 0.027922 28.4638889 0.031262 28.4666667 0.029592 28.4694444 0.044620 28.4722222 0.051299 28.4750000 0.069666 28.4777778 0.089703 28.4805556 0.119759 28.4833333 0.163173 28.4861111 0.211596 28.4888889 0.265028 28.4916667 0.323469 28.4944444 0.386920 28.4972222 0.463729 28.5000000 0.540538 28.5027778 0.614007 28.5055556 0.690816 28.5083333 0.769295 28.5111111 0.841095 28.5138889 0.850000 28.5166667 0.850000 28.5194444 0.850000 28.5222222 0.850000 28.5250000 0.850000 28.5277778 0.850000 28.5305556 0.850000 28.5333333 0.850000 28.5361111 0.850000 28.5388889 0.850000 28.5416667 0.850000 28.5444444 0.850000 28.5472222 0.850000 28.5500000 0.850000 28.5527778 0.850000 28.5555556 0.850000 28.5583333 0.850000 28.5611111 0.850000 28.5638889 0.850000 28.5666667 0.850000 28.5694444 0.831076 28.5722222 0.774304 28.5750000 0.715863 28.5777778 0.640724 28.5805556 0.557236 28.5833333 0.453711 28.5861111 0.330148 28.5888889 0.198237 28.5916667 0.084694 28.5944444 0.010000 28.5972222 0.010000 28.6000000 0.010000 28.6027778 0.010000 28.6055556 0.010000 28.6083333 0.010000 28.6111111 0.010000 28.6138889 0.010000 28.6166667 0.010000 28.6194444 0.010000 28.6222222 0.010000 28.6250000 0.010000 28.6277778 0.010000 28.6305556 0.010000 28.6333333 0.010000 28.6361111 0.010000 28.6388889 0.010000 28.6416667 0.010000 28.6444444 0.010000 28.6472222 0.010000 28.6500000 0.010000 28.6527778 0.010000 28.6555556 0.010000 28.6583333 0.010000 28.6611111 0.010000 28.6638889 0.010000 28.6666667 0.010000 28.6694444 0.010000 28.6722222 0.010000 28.6750000 0.010000 28.6777778 0.010000 28.6805556 0.010000 28.6833333 0.010000 28.6861111 0.010000 28.6888889 0.010000 28.6916667 0.010000 28.6944444 0.010000 28.6972222 0.010000 28.7000000 0.010000 28.7027778 0.010000 28.7055556 0.010000 28.7083333 0.010000 28.7111111 0.010000 28.7138889 0.010000 28.7166667 0.010000 28.7194444 0.010000 28.7222222 0.010000 28.7250000 0.010000 28.7277778 0.010000 28.7305556 0.010000 28.7333333 0.010000 28.7361111 0.010000 28.7388889 0.010000 28.7416667 0.010000 28.7444444 0.010000 28.7472222 0.010000 28.7500000 0.010000 28.7527778 0.010000 28.7555556 0.010000 28.7583333 0.010000 28.7611111 0.010000 28.7638889 0.010000 28.7666667 0.010000 28.7694444 0.010000 28.7722222 0.010000 28.7750000 0.010000 28.7777778 0.010000 28.7805556 0.010000 28.7833333 0.010000 28.7861111 0.010000 28.7888889 0.010000 28.7916667 0.010000 28.7944444 0.010000 28.7972222 0.010000 28.8000000 0.010000 28.8027778 0.010000 28.8055556 0.010000 28.8083333 0.010000 28.8111111 0.010000 28.8138889 0.010000 28.8166667 0.010000 28.8194444 0.010000 29.6055556 0.010000 29.6083333 0.010000 29.6111111 0.010000 29.6138889 0.010000 29.6166667 0.010000 29.6194444 0.010000 29.6222222 0.010000 29.6250000 0.010000 29.6277778 0.010000 29.6305556 0.010000 29.6333333 0.010000 29.6361111 0.010000 29.6388889 0.010000 29.6416667 0.010000 29.6444444 0.010000 29.6472222 0.010000 29.6500000 0.010000 29.6527778 0.010000 29.6555556 0.010000 29.6583333 0.010000 29.6611111 0.010000 29.6638889 0.010000 29.6666667 0.010000 29.6694444 0.014564 29.6722222 0.017904 29.6750000 0.026252 29.6777778 0.027922 29.6805556 0.029592 29.6833333 0.031262 29.6861111 0.036271 29.6888889 0.031262 29.6916667 0.037941 29.6944444 0.042950 29.6972222 0.052968 29.7000000 0.061317 29.7027778 0.069666 29.7055556 0.088033 29.7083333 0.098052 29.7111111 0.106401 29.7138889 0.114750 29.7166667 0.121429 29.7194444 0.118089 29.7222222 0.116419 29.7250000 0.111410 29.7277778 0.114750 29.7305556 0.118089 29.7333333 0.118089 29.7361111 0.118089 29.7388889 0.119759 29.7416667 0.096382 29.7444444 0.083024 29.7472222 0.064657 29.7500000 0.037941 29.7527778 0.022913 29.7555556 0.010000 29.7583333 0.010000 29.7611111 0.010000 29.7638889 0.010000 29.7666667 0.010000 29.7694444 0.010000 29.7722222 0.010000 29.7750000 0.010000 29.7777778 0.010000 29.7805556 0.010000 29.7833333 0.010000 29.7861111 0.010000 29.7888889 0.010000 29.7916667 0.010000 29.7944444 0.010000 29.7972222 0.010000 29.8000000 0.010000 29.8027778 0.010000 29.8055556 0.010000 29.8083333 0.010000 29.8111111 0.010000 29.8138889 0.010000 29.8166667 0.010000 29.8194444 0.010000 29.8222222 0.010000 29.8250000 0.010000 29.8277778 0.010000 29.8305556 0.010000 29.8333333 0.031262 29.8361111 0.096382 29.8388889 0.188219 29.8416667 0.301763 29.8444444 0.432004 29.8472222 0.555566 29.8500000 0.660761 29.8527778 0.725881 29.8555556 0.749258 29.8583333 0.737570 29.8611111 0.675788 29.8638889 0.578942 29.8666667 0.426994 29.8694444 0.250000 29.8722222 0.093043 29.8750000 0.010000 29.8777778 0.010000 29.8805556 0.010000 29.8833333 0.016234 29.8861111 0.056308 29.8888889 0.078015 29.8916667 0.073006 29.8944444 0.057978 29.8972222 0.037941 29.9000000 0.021243 29.9027778 0.010000 29.9055556 0.010000 29.9083333 0.010000 29.9111111 0.010000 29.9138889 0.010000 29.9166667 0.010000 29.9194444 0.010000 29.9222222 0.010000 29.9250000 0.010000 29.9277778 0.010000 29.9305556 0.010000 29.9333333 0.010000 29.9361111 0.010000 29.9388889 0.010000 29.9416667 0.010000 29.9444444 0.010000 29.9472222 0.010000 29.9500000 0.010000 29.9527778 0.010000 29.9555556 0.010000 29.9583333 0.010000 29.9611111 0.010000 29.9638889 0.010000 29.9666667 0.010000 29.9694444 0.010000 29.9722222 0.010000 29.9750000 0.010000 29.9777778 0.010000 29.9805556 0.010000 29.9833333 0.010000 29.9861111 0.010000 29.9888889 0.010000 29.9916667 0.010000 29.9944444 0.010000 29.9972222 0.010000 30.0000000 0.010000 30.0027778 0.010000 30.0055556 0.010000 30.0083333 0.010000 30.0111111 0.010000 30.0138889 0.010000 30.0166667 0.010000 30.0194444 0.010000 30.0222222 0.010000 30.0250000 0.010000 30.0277778 0.010000 30.0305556 0.010000 30.0333333 0.010000 30.0361111 0.010000 30.0388889 0.010000 30.0416667 0.010000 30.0444444 0.010000 30.0472222 0.010000 30.0500000 0.010000 30.0527778 0.010000 30.0555556 0.010000 30.0583333 0.010000 30.0611111 0.010000 30.0638889 0.010000 30.0666667 0.019573 30.0694444 0.022913 30.0722222 0.021243 30.0750000 0.021243 30.0777778 0.021243 30.0805556 0.027922 30.0833333 0.027922 30.0861111 0.031262 30.0888889 0.034601 30.0916667 0.041280 30.0944444 0.046289 30.0972222 0.054638 30.1000000 0.057978 30.1027778 0.067996 30.1055556 0.071336 30.1083333 0.074675 30.1111111 0.078015 30.1138889 0.079685 30.1166667 0.083024 30.1194444 0.084694 30.1222222 0.088033 30.1250000 0.094712 30.1277778 0.101391 30.1305556 0.111410 30.1333333 0.114750 30.1361111 0.116419 30.1388889 0.124768 30.1416667 0.128108 30.1444444 0.136456 30.1472222 0.136456 30.1500000 0.133117 30.1527778 0.139796 30.4888889 0.010000 30.4916667 0.010000 30.4944444 0.010000 30.4972222 0.010000 30.5000000 0.010000 30.5027778 0.010000 30.5055556 0.010000 30.5083333 0.010000 30.5111111 0.010000 30.5138889 0.010000 30.5166667 0.010000 30.5194444 0.010000 30.5222222 0.010000 30.5250000 0.010000 30.5277778 0.010000 30.5305556 0.010000 30.5333333 0.010000 30.5361111 0.010000 30.5388889 0.010000 30.5416667 0.012894 30.5444444 0.019573 30.5472222 0.019573 30.5500000 0.022913 30.5527778 0.024583 30.5555556 0.029592 30.5583333 0.032931 30.5611111 0.039610 30.5638889 0.042950 30.5666667 0.054638 30.5694444 0.067996 30.5722222 0.074675 30.5750000 0.086364 30.5777778 0.099722 30.5805556 0.103061 30.5833333 0.109740 30.5861111 0.101391 30.5888889 0.098052 30.5916667 0.096382 30.5944444 0.096382 30.5972222 0.101391 30.6000000 0.096382 30.6027778 0.096382 30.6055556 0.091373 30.6083333 0.073006 30.6111111 0.054638 30.6138889 0.034601 30.6166667 0.012894 30.6194444 0.010000 30.6222222 0.010000 30.6250000 0.010000 30.6277778 0.010000 30.6305556 0.010000 30.6333333 0.010000 30.6361111 0.010000 30.6388889 0.010000 30.6416667 0.010000 30.6444444 0.010000 30.6472222 0.010000 30.6500000 0.010000 30.6527778 0.010000 30.6555556 0.010000 30.6583333 0.010000 30.6611111 0.010000 30.6638889 0.010000 30.6666667 0.010000 30.6694444 0.010000 30.6722222 0.010000 30.6750000 0.010000 30.6777778 0.010000 30.6805556 0.010000 30.6833333 0.010000 30.6861111 0.010000 30.6888889 0.010000 30.6916667 0.010000 30.6944444 0.010000 30.6972222 0.010000 30.7000000 0.010000 30.7027778 0.010000 30.7055556 0.010000 30.7083333 0.010000 30.7111111 0.010000 30.7138889 0.010000 30.7166667 0.064657 30.7194444 0.138126 30.7222222 0.234972 30.7250000 0.345176 30.7277778 0.463729 30.7305556 0.572263 30.7333333 0.660761 30.7361111 0.712523 30.7388889 0.737570 30.7416667 0.724212 30.7444444 0.675788 30.7472222 0.592301 30.7500000 0.453711 30.7527778 0.276716 30.7555556 0.104731 30.7583333 0.010000 30.7611111 0.010000 30.7638889 0.010000 30.7666667 0.010000 30.7694444 0.017904 30.7722222 0.051299 30.7750000 0.064657 30.7777778 0.049629 30.7805556 0.027922 30.7833333 0.010000 30.7861111 0.010000 30.7888889 0.010000 30.7916667 0.010000 30.7944444 0.010000 30.7972222 0.010000 30.8000000 0.010000 30.8027778 0.010000 30.8055556 0.010000 30.8083333 0.010000 30.8111111 0.010000 30.8138889 0.010000 30.8166667 0.010000 30.8194444 0.010000 30.8222222 0.010000 30.8250000 0.010000 30.8277778 0.010000 30.8305556 0.010000 30.8333333 0.010000 30.8361111 0.010000 30.8388889 0.010000 30.8416667 0.010000 30.8444444 0.010000 30.8472222 0.010000 30.8500000 0.010000 30.8527778 0.010000 30.8555556 0.010000 30.8583333 0.010000 30.8611111 0.010000 30.8638889 0.010000 30.8666667 0.010000 30.8694444 0.010000 30.8722222 0.010000 30.8750000 0.010000 30.8777778 0.010000 30.8805556 0.010000 30.8833333 0.010000 30.8861111 0.010000 30.8888889 0.010000 30.8916667 0.010000 30.8944444 0.010000 30.8972222 0.010000 30.9000000 0.010000 30.9027778 0.010000 30.9055556 0.010000 30.9083333 0.010000 30.9111111 0.010000 30.9138889 0.010000 30.9166667 0.010000 30.9194444 0.010000 30.9222222 0.010000 30.9250000 0.010000 30.9277778 0.010000 30.9305556 0.010000 30.9333333 0.010000 30.9361111 0.010000 30.9388889 0.010000 30.9416667 0.010000 30.9444444 0.010000 30.9472222 0.010000 30.9500000 0.010000 30.9527778 0.010000 30.9555556 0.010000 30.9583333 0.010000 30.9611111 0.012894 30.9638889 0.014564 30.9666667 0.021243 30.9694444 0.027922 30.9722222 0.032931 30.9750000 0.032931 30.9777778 0.039610 30.9805556 0.037941 30.9833333 0.039610 30.9861111 0.046289 30.9888889 0.052968 30.9916667 0.051299 30.9944444 0.061317 30.9972222 0.067996 31.0000000 0.078015 31.0027778 0.083024 31.0055556 0.088033 31.0083333 0.089703 31.0111111 0.101391 31.0138889 0.103061 31.0166667 0.101391 31.0194444 0.106401 31.0222222 0.113080 31.0250000 0.116419 31.0277778 0.121429 31.0305556 0.124768 31.0333333 0.131447 31.0361111 0.139796 31.3861111 0.010000 31.3888889 0.010000 31.3916667 0.010000 31.3944444 0.010000 31.3972222 0.010000 31.4000000 0.010000 31.4027778 0.010000 31.4055556 0.010000 31.4083333 0.010000 31.4111111 0.010000 31.4138889 0.010000 31.4166667 0.010000 31.4194444 0.010000 31.4222222 0.010000 31.4250000 0.010000 31.4277778 0.010000 31.4305556 0.010000 31.4333333 0.010000 31.4361111 0.010000 31.4388889 0.010000 31.4416667 0.010000 31.4444444 0.010000 31.4472222 0.010000 31.4500000 0.010000 31.4527778 0.010000 31.4555556 0.010000 31.4583333 0.010000 31.4611111 0.014564 31.4638889 0.022913 31.4666667 0.029592 31.4694444 0.037941 31.4722222 0.042950 31.4750000 0.057978 31.4777778 0.071336 31.4805556 0.084694 31.4833333 0.088033 31.4861111 0.086364 31.4888889 0.078015 31.4916667 0.073006 31.4944444 0.069666 31.4972222 0.071336 31.5000000 0.081354 31.5027778 0.076345 31.5055556 0.076345 31.5083333 0.066327 31.5111111 0.049629 31.5138889 0.031262 31.5166667 0.010000 31.5194444 0.010000 31.5222222 0.010000 31.5250000 0.010000 31.5277778 0.010000 31.5305556 0.010000 31.5333333 0.010000 31.5361111 0.010000 31.5388889 0.010000 31.5416667 0.010000 31.5444444 0.010000 31.5472222 0.010000 31.5500000 0.010000 31.5527778 0.010000 31.5555556 0.010000 31.5583333 0.010000 31.5611111 0.010000 31.5638889 0.010000 31.5666667 0.010000 31.5694444 0.010000 31.5722222 0.010000 31.5750000 0.010000 31.5777778 0.010000 31.5805556 0.010000 31.5833333 0.010000 31.5861111 0.010000 31.5888889 0.010000 31.5916667 0.010000 31.5944444 0.010000 31.5972222 0.010000 31.6000000 0.010000 31.6027778 0.010000 31.6055556 0.010000 31.6083333 0.010000 31.6111111 0.010000 31.6138889 0.010000 31.6166667 0.010000 31.6194444 0.078015 31.6222222 0.176531 31.6250000 0.303432 31.6277778 0.442022 31.6305556 0.567254 31.6333333 0.662430 31.6361111 0.712523 31.6388889 0.722542 31.6416667 0.675788 31.6444444 0.580612 31.6472222 0.423655 31.6500000 0.234972 31.6527778 0.057978 31.6555556 0.010000 31.6583333 0.010000 31.6611111 0.010000 31.6638889 0.010000 31.6666667 0.010000 31.6694444 0.032931 31.6722222 0.039610 31.6750000 0.024583 31.6777778 0.010000 31.6805556 0.010000 31.6833333 0.010000 31.6861111 0.010000 31.6888889 0.010000 31.6916667 0.010000 31.6944444 0.010000 31.6972222 0.010000 31.7000000 0.010000 31.7027778 0.010000 31.7055556 0.010000 31.7083333 0.010000 31.7111111 0.010000 31.7138889 0.010000 31.7166667 0.010000 31.7194444 0.010000 31.7222222 0.010000 31.7250000 0.010000 31.7277778 0.010000 31.7305556 0.010000 31.7333333 0.010000 31.7361111 0.010000 31.7388889 0.010000 31.7416667 0.010000 31.7444444 0.010000 31.7472222 0.010000 31.7500000 0.010000 31.7527778 0.010000 31.7555556 0.010000 31.7583333 0.010000 31.7611111 0.010000 31.7638889 0.010000 31.7666667 0.010000 31.7694444 0.010000 31.7722222 0.010000 31.7750000 0.010000 31.7777778 0.010000 31.7805556 0.010000 31.7833333 0.010000 31.7861111 0.010000 31.7888889 0.010000 31.7916667 0.010000 31.7944444 0.010000 31.7972222 0.010000 31.8000000 0.010000 31.8027778 0.010000 31.8055556 0.010000 31.8083333 0.010000 31.8111111 0.010000 31.8138889 0.010000 31.8166667 0.010000 31.8194444 0.010000 31.8222222 0.010000 31.8250000 0.010000 31.8277778 0.010000 31.8305556 0.010000 31.8333333 0.010000 31.8361111 0.010000 31.8388889 0.010000 31.8416667 0.010000 31.8444444 0.010000 31.8472222 0.010000 31.8500000 0.010000 31.8527778 0.010000 31.8555556 0.010000 31.8583333 0.010000 31.8611111 0.010000 31.8638889 0.016234 31.8666667 0.027922 31.8694444 0.027922 31.8722222 0.039610 31.8750000 0.051299 31.8777778 0.054638 31.8805556 0.059647 31.8833333 0.052968 31.8861111 0.057978 31.8888889 0.066327 31.8916667 0.073006 31.8944444 0.083024 31.8972222 0.089703 31.9000000 0.098052 31.9027778 0.109740 31.9055556 0.118089 31.9083333 0.123098 31.9111111 0.121429 31.9138889 0.126438 31.9166667 0.129777 31.9194444 0.131447 31.9222222 0.138126 31.9250000 0.133117 31.9277778 0.141466 31.9305556 0.151484 31.9333333 0.154824 32.2638889 0.010000 32.2666667 0.010000 32.2694444 0.010000 32.2722222 0.010000 32.2750000 0.010000 32.2777778 0.010000 32.2805556 0.010000 32.2833333 0.010000 32.2861111 0.010000 32.2888889 0.010000 32.2916667 0.010000 32.2944444 0.010000 32.2972222 0.010000 32.3000000 0.010000 32.3027778 0.010000 32.3055556 0.010000 32.3083333 0.010000 32.3111111 0.010000 32.3138889 0.010000 32.3166667 0.010000 32.3194444 0.010000 32.3222222 0.010000 32.3250000 0.010000 32.3277778 0.010000 32.3305556 0.010000 32.3333333 0.010000 32.3361111 0.010000 32.3388889 0.010000 32.3416667 0.010000 32.3444444 0.014564 32.3472222 0.024583 32.3500000 0.026252 32.3527778 0.042950 32.3555556 0.044620 32.3583333 0.054638 32.3611111 0.062987 32.3638889 0.062987 32.3666667 0.057978 32.3694444 0.056308 32.3722222 0.057978 32.3750000 0.056308 32.3777778 0.051299 32.3805556 0.046289 32.3833333 0.034601 32.3861111 0.017904 32.3888889 0.010000 32.3916667 0.010000 32.3944444 0.010000 32.3972222 0.010000 32.4000000 0.010000 32.4027778 0.010000 32.4055556 0.010000 32.4083333 0.010000 32.4111111 0.010000 32.4138889 0.010000 32.4166667 0.010000 32.4194444 0.010000 32.4222222 0.010000 32.4250000 0.010000 32.4277778 0.010000 32.4305556 0.010000 32.4333333 0.010000 32.4361111 0.010000 32.4388889 0.010000 32.4416667 0.010000 32.4444444 0.010000 32.4472222 0.010000 32.4500000 0.010000 32.4527778 0.010000 32.4555556 0.010000 32.4583333 0.010000 32.4611111 0.010000 32.4638889 0.010000 32.4666667 0.010000 32.4694444 0.010000 32.4722222 0.010000 32.4750000 0.010000 32.4777778 0.010000 32.4805556 0.010000 32.4833333 0.010000 32.4861111 0.010000 32.4888889 0.010000 32.4916667 0.010000 32.4944444 0.032931 32.4972222 0.128108 32.5000000 0.243321 32.5027778 0.370223 32.5055556 0.498794 32.5083333 0.598980 32.5111111 0.662430 32.5138889 0.685807 32.5166667 0.667440 32.5194444 0.600649 32.5222222 0.490445 32.5250000 0.336827 32.5277778 0.144805 32.5305556 0.010000 32.5333333 0.010000 32.5361111 0.010000 32.5388889 0.010000 32.5416667 0.010000 32.5444444 0.010000 32.5472222 0.012894 32.5500000 0.010000 32.5527778 0.010000 32.5555556 0.010000 32.5583333 0.010000 32.5611111 0.010000 32.5638889 0.010000 32.5666667 0.010000 32.5694444 0.010000 32.5722222 0.010000 32.5750000 0.010000 32.5777778 0.010000 32.5805556 0.010000 32.5833333 0.010000 32.5861111 0.010000 32.5888889 0.010000 32.5916667 0.010000 32.5944444 0.010000 32.5972222 0.010000 32.6000000 0.010000 32.6027778 0.010000 32.6055556 0.010000 32.6083333 0.010000 32.6111111 0.010000 32.6138889 0.010000 32.6166667 0.010000 32.6194444 0.010000 32.6222222 0.010000 32.6250000 0.010000 32.6277778 0.010000 32.6305556 0.010000 32.6333333 0.010000 32.6361111 0.010000 32.6388889 0.010000 32.6416667 0.010000 32.6444444 0.010000 32.6472222 0.010000 32.6500000 0.010000 32.6527778 0.010000 32.6555556 0.010000 32.6583333 0.010000 32.6611111 0.010000 32.6638889 0.010000 32.6666667 0.010000 32.6694444 0.010000 32.6722222 0.010000 32.6750000 0.010000 32.6777778 0.010000 32.6805556 0.010000 32.6833333 0.010000 32.6861111 0.010000 32.6888889 0.010000 32.6916667 0.010000 32.6944444 0.010000 32.6972222 0.010000 32.7000000 0.010000 32.7027778 0.010000 32.7055556 0.010000 32.7083333 0.010000 32.7111111 0.010000 32.7138889 0.010000 32.7166667 0.010000 32.7194444 0.010000 32.7222222 0.010000 32.7250000 0.010000 32.7277778 0.010000 32.7305556 0.010000 32.7333333 0.010000 32.7361111 0.010000 32.7388889 0.010000 32.7416667 0.010000 32.7444444 0.010000 32.7472222 0.010000 32.7500000 0.010000 32.7527778 0.010000 32.7555556 0.010000 32.7583333 0.014564 32.7611111 0.022913 32.7638889 0.029592 32.7666667 0.041280 32.7694444 0.049629 32.7722222 0.062987 32.7750000 0.066327 32.7777778 0.073006 32.7805556 0.078015 32.7833333 0.074675 32.7861111 0.079685 32.7888889 0.079685 32.7916667 0.088033 32.7944444 0.093043 32.7972222 0.104731 32.8000000 0.111410 32.8027778 0.118089 32.8055556 0.123098 32.8083333 0.126438 32.8111111 0.124768 33.1027778 0.010000 33.1055556 0.010000 33.1083333 0.010000 33.1111111 0.010000 33.1138889 0.010000 33.1166667 0.010000 33.1194444 0.010000 33.1222222 0.010000 33.1250000 0.010000 33.1277778 0.010000 33.1305556 0.010000 33.1333333 0.010000 33.1361111 0.010000 33.1388889 0.010000 33.1416667 0.010000 33.1444444 0.010000 33.1472222 0.010000 33.1500000 0.010000 33.1527778 0.010000 33.1555556 0.010000 33.1583333 0.010000 33.1611111 0.010000 33.1638889 0.010000 33.1666667 0.010000 33.1694444 0.010000 33.1722222 0.010000 33.1750000 0.010000 33.1777778 0.010000 33.1805556 0.010000 33.1833333 0.010000 33.1861111 0.010000 33.1888889 0.010000 33.1916667 0.017904 33.1944444 0.029592 33.1972222 0.037941 33.2000000 0.044620 33.2027778 0.042950 33.2055556 0.041280 33.2083333 0.042950 33.2111111 0.032931 33.2138889 0.034601 33.2166667 0.019573 33.2194444 0.014564 33.2222222 0.010000 33.2250000 0.010000 33.2277778 0.010000 33.2305556 0.010000 33.2333333 0.010000 33.2361111 0.010000 33.2388889 0.010000 33.2416667 0.010000 33.2444444 0.010000 33.2472222 0.010000 33.2500000 0.010000 33.2527778 0.010000 33.2555556 0.010000 33.2583333 0.010000 33.2611111 0.010000 33.2638889 0.010000 33.2666667 0.010000 33.2694444 0.010000 33.2722222 0.010000 33.2750000 0.010000 33.2777778 0.010000 33.2805556 0.010000 33.2833333 0.010000 33.2861111 0.010000 33.2888889 0.010000 33.2916667 0.010000 33.2944444 0.010000 33.2972222 0.010000 33.3000000 0.010000 33.3027778 0.010000 33.3055556 0.010000 33.3083333 0.010000 33.3111111 0.010000 33.3138889 0.010000 33.3166667 0.010000 33.3194444 0.010000 33.3222222 0.010000 33.3250000 0.010000 33.3277778 0.010000 33.3305556 0.010000 33.3333333 0.031262 33.3361111 0.114750 33.3388889 0.223284 33.3416667 0.328479 33.3444444 0.455380 33.3472222 0.557236 33.3500000 0.625696 33.3527778 0.657421 33.3555556 0.660761 33.3583333 0.640724 33.3611111 0.585622 33.3638889 0.498794 33.3666667 0.380241 33.3694444 0.223284 33.3722222 0.071336 33.3750000 0.010000 33.3777778 0.010000 33.3805556 0.010000 33.3833333 0.010000 33.3861111 0.010000 33.3888889 0.010000 33.3916667 0.010000 33.3944444 0.010000 33.3972222 0.010000 33.4000000 0.010000 33.4027778 0.010000 33.4055556 0.010000 33.4083333 0.010000 33.4111111 0.010000 33.4138889 0.010000 33.4166667 0.010000 33.4194444 0.010000 33.4222222 0.010000 33.4250000 0.010000 33.4277778 0.010000 33.4305556 0.010000 33.4333333 0.010000 33.4361111 0.010000 33.4388889 0.010000 33.4416667 0.010000 33.4444444 0.010000 33.4472222 0.010000 33.4500000 0.010000 33.4527778 0.010000 33.4555556 0.010000 33.4583333 0.010000 33.4611111 0.010000 33.4638889 0.010000 33.4666667 0.010000 33.4694444 0.010000 33.4722222 0.010000 33.4750000 0.010000 33.4777778 0.010000 33.4805556 0.010000 33.4833333 0.010000 33.4861111 0.010000 33.4888889 0.010000 33.4916667 0.010000 33.4944444 0.010000 33.4972222 0.010000 33.5000000 0.010000 33.5027778 0.010000 33.5055556 0.010000 33.5083333 0.010000 33.5111111 0.010000 33.5138889 0.010000 33.5166667 0.010000 33.5194444 0.010000 33.5222222 0.010000 33.5250000 0.010000 33.5277778 0.010000 33.5305556 0.010000 33.5333333 0.010000 33.5361111 0.010000 33.5388889 0.010000 33.5416667 0.010000 33.5444444 0.010000 33.5472222 0.010000 33.5500000 0.010000 33.5527778 0.010000 33.5555556 0.010000 33.5583333 0.010000 33.5611111 0.010000 33.5638889 0.010000 33.5666667 0.010000 33.5694444 0.010000 33.5722222 0.010000 33.5750000 0.010000 33.5777778 0.010000 33.5805556 0.010000 33.5833333 0.010000 33.5861111 0.010000 33.5888889 0.010000 33.5916667 0.010000 33.5944444 0.010000 33.5972222 0.010000 33.6000000 0.010000 33.6027778 0.010000 33.6055556 0.010000 33.6083333 0.014564 33.6111111 0.017904 33.6138889 0.024583 33.6166667 0.024583 33.6194444 0.031262 33.6222222 0.036271 33.6250000 0.042950 33.6277778 0.051299 33.6305556 0.057978 33.6333333 0.064657 33.6361111 0.067996 33.6388889 0.078015 33.6416667 0.083024 33.6444444 0.086364 33.6472222 0.091373 33.6500000 0.091373 33.6527778 0.094712 33.6555556 0.094712 33.6583333 0.093043 33.6611111 0.106401 33.6638889 0.113080 33.6666667 0.121429 33.6694444 0.119759 33.6722222 0.119759 33.6750000 0.126438 33.6777778 0.121429 33.6805556 0.116419 33.6833333 0.109740 33.6861111 0.103061 33.6888889 0.091373 33.6916667 0.084694 33.6944444 0.064657 33.6972222 0.067996 33.7000000 0.061317 33.7027778 0.054638 33.7055556 0.044620 33.7083333 0.037941 33.7111111 0.024583 33.7138889 0.016234 33.7166667 0.010000 33.7194444 0.010000 33.7222222 0.010000 33.7250000 0.010000 33.7277778 0.010000 33.7305556 0.010000 33.7333333 0.010000 33.7361111 0.010000 33.7388889 0.010000 33.7416667 0.010000 33.7444444 0.010000 33.7472222 0.010000 33.7500000 0.010000 33.7527778 0.010000 33.7555556 0.010000 33.7583333 0.010000 33.7611111 0.010000 33.7638889 0.010000 33.7666667 0.010000 33.7694444 0.010000 33.7722222 0.010000 33.7750000 0.010000 33.7777778 0.010000 33.7805556 0.010000 33.7833333 0.010000 33.7861111 0.010000 33.7888889 0.010000 33.7916667 0.010000 33.7944444 0.010000 33.7972222 0.010000 33.8000000 0.010000 33.8027778 0.010000 33.8055556 0.010000 33.8083333 0.010000 33.8111111 0.010000 33.8138889 0.010000 33.8166667 0.010000 33.8194444 0.010000 33.8222222 0.010000 33.8250000 0.010000 33.8277778 0.010000 33.8305556 0.010000 33.8333333 0.010000 33.8361111 0.010000 33.8388889 0.010000 33.8416667 0.010000 33.8444444 0.010000 33.8472222 0.010000 33.8500000 0.010000 33.8527778 0.017904 33.8555556 0.061317 33.8583333 0.113080 33.8611111 0.173191 33.8638889 0.241651 33.8666667 0.316790 33.8694444 0.390260 33.8722222 0.468738 33.8750000 0.553896 33.8777778 0.645733 33.8805556 0.722542 33.8833333 0.792672 33.8861111 0.849443 33.8888889 0.850000 33.8916667 0.850000 33.8944444 0.850000 33.8972222 0.850000 33.9000000 0.850000 33.9027778 0.850000 33.9055556 0.850000 33.9083333 0.850000 33.9111111 0.850000 33.9138889 0.850000 33.9166667 0.834416 33.9194444 0.819388 33.9222222 0.821058 33.9250000 0.826067 33.9277778 0.832746 33.9305556 0.831076 33.9333333 0.814378 33.9361111 0.785993 33.9388889 0.744249 33.9416667 0.692486 33.9444444 0.627365 33.9472222 0.553896 33.9500000 0.460390 33.9527778 0.336827 33.9555556 0.203247 33.9583333 0.071336 33.9611111 0.010000 33.9638889 0.010000 33.9666667 0.010000 33.9694444 0.010000 33.9722222 0.010000 33.9750000 0.010000 33.9777778 0.010000 33.9805556 0.010000 33.9833333 0.010000 33.9861111 0.010000 33.9888889 0.010000 33.9916667 0.010000 33.9944444 0.010000 33.9972222 0.010000 34.0000000 0.010000 34.0027778 0.010000 34.0055556 0.010000 34.0083333 0.010000 34.0111111 0.010000 34.0138889 0.010000 34.0166667 0.010000 34.0194444 0.010000 34.0222222 0.010000 34.0250000 0.010000 34.0277778 0.010000 34.0305556 0.010000 34.0333333 0.010000 34.0361111 0.010000 34.0388889 0.010000 34.0416667 0.010000 34.0444444 0.010000 34.0472222 0.010000 34.0500000 0.010000 34.0527778 0.010000 34.0555556 0.010000 34.0583333 0.010000 34.0611111 0.010000 34.0638889 0.010000 34.0666667 0.010000 34.0694444 0.010000 34.0722222 0.010000 34.0750000 0.010000 34.0777778 0.010000 34.0805556 0.010000 34.0833333 0.010000 34.0861111 0.010000 34.0888889 0.010000 34.0916667 0.010000 34.0944444 0.010000 34.0972222 0.010000 34.1000000 0.010000 34.1027778 0.010000 34.1055556 0.010000 34.1083333 0.010000 34.1111111 0.010000 34.1138889 0.010000 34.1166667 0.010000 34.1194444 0.010000 34.1222222 0.010000 34.1250000 0.010000 34.1277778 0.010000 34.1305556 0.010000 34.1333333 0.010000 34.1361111 0.010000 34.1388889 0.010000 34.1416667 0.010000 34.1444444 0.010000 34.1472222 0.010000 34.1500000 0.010000 34.1527778 0.010000 34.1555556 0.010000 34.1583333 0.010000 34.1611111 0.010000 34.1638889 0.010000 34.1666667 0.010000 34.1694444 0.010000 34.1722222 0.010000 34.1750000 0.010000 34.1777778 0.010000 34.1805556 0.010000 34.1833333 0.010000 34.1861111 0.010000 34.1888889 0.010000 34.1916667 0.010000 34.9305556 0.010000 34.9333333 0.010000 34.9361111 0.010000 34.9388889 0.010000 34.9416667 0.010000 34.9444444 0.010000 34.9472222 0.010000 34.9500000 0.010000 34.9527778 0.010000 34.9555556 0.010000 34.9583333 0.010000 34.9611111 0.010000 34.9638889 0.010000 34.9666667 0.010000 34.9694444 0.010000 34.9722222 0.010000 34.9750000 0.010000 34.9777778 0.010000 34.9805556 0.010000 34.9833333 0.010000 34.9861111 0.010000 34.9888889 0.010000 34.9916667 0.010000 34.9944444 0.010000 34.9972222 0.010000 35.0000000 0.010000 35.0027778 0.010000 35.0055556 0.010000 35.0083333 0.010000 35.0111111 0.010000 35.0138889 0.010000 35.0166667 0.010000 35.0194444 0.010000 35.0222222 0.010000 35.0250000 0.010000 35.0277778 0.010000 35.0305556 0.010000 35.0333333 0.010000 35.0361111 0.019573 35.0388889 0.036271 35.0416667 0.052968 35.0444444 0.057978 35.0472222 0.062987 35.0500000 0.056308 35.0527778 0.051299 35.0555556 0.044620 35.0583333 0.046289 35.0611111 0.042950 35.0638889 0.036271 35.0666667 0.036271 35.0694444 0.032931 35.0722222 0.017904 35.0750000 0.010000 35.0777778 0.010000 35.0805556 0.010000 35.0833333 0.010000 35.0861111 0.010000 35.0888889 0.010000 35.0916667 0.010000 35.0944444 0.010000 35.0972222 0.010000 35.1000000 0.010000 35.1027778 0.010000 35.1055556 0.010000 35.1083333 0.010000 35.1111111 0.010000 35.1138889 0.010000 35.1166667 0.010000 35.1194444 0.010000 35.1222222 0.010000 35.1250000 0.010000 35.1277778 0.010000 35.1305556 0.010000 35.1333333 0.010000 35.1361111 0.010000 35.1388889 0.010000 35.1416667 0.010000 35.1444444 0.010000 35.1472222 0.010000 35.1500000 0.010000 35.1527778 0.010000 35.1555556 0.010000 35.1583333 0.010000 35.1611111 0.010000 35.1638889 0.054638 35.1666667 0.156494 35.1694444 0.280056 35.1722222 0.411967 35.1750000 0.538868 35.1777778 0.625696 35.1805556 0.679128 35.1833333 0.689147 35.1861111 0.662430 35.1888889 0.592301 35.1916667 0.473748 35.1944444 0.308442 35.1972222 0.136456 35.2000000 0.010000 35.2027778 0.010000 35.2055556 0.010000 35.2083333 0.010000 35.2111111 0.010000 35.2138889 0.010000 35.2166667 0.011224 35.2194444 0.010000 35.2222222 0.010000 35.2250000 0.010000 35.2277778 0.010000 35.2305556 0.010000 35.2333333 0.010000 35.2361111 0.010000 35.2388889 0.010000 35.2416667 0.010000 35.2444444 0.010000 35.2472222 0.010000 35.2500000 0.010000 35.2527778 0.010000 35.2555556 0.010000 35.2583333 0.010000 35.2611111 0.010000 35.2638889 0.010000 35.2666667 0.010000 35.2694444 0.010000 35.2722222 0.010000 35.2750000 0.010000 35.2777778 0.010000 35.2805556 0.010000 35.2833333 0.010000 35.2861111 0.010000 35.2888889 0.010000 35.2916667 0.010000 35.2944444 0.010000 35.2972222 0.010000 35.3000000 0.010000 35.3027778 0.010000 35.3055556 0.010000 35.3083333 0.010000 35.3111111 0.010000 35.3138889 0.010000 35.3166667 0.010000 35.3194444 0.010000 35.3222222 0.010000 35.3250000 0.010000 35.3277778 0.010000 35.3305556 0.010000 35.3333333 0.010000 35.3361111 0.010000 35.3388889 0.010000 35.3416667 0.010000 35.3444444 0.010000 35.3472222 0.010000 35.3500000 0.010000 35.3527778 0.010000 35.3555556 0.010000 35.3583333 0.010000 35.3611111 0.010000 35.3638889 0.010000 35.3666667 0.010000 35.3694444 0.010000 35.3722222 0.010000 35.3750000 0.010000 35.3777778 0.010000 35.3805556 0.010000 35.3833333 0.010000 35.3861111 0.010000 35.3888889 0.010000 35.3916667 0.010000 35.3944444 0.010000 35.3972222 0.010000 35.4000000 0.010000 35.4027778 0.010000 35.4055556 0.010000 35.4083333 0.010000 35.4111111 0.010000 35.4138889 0.010000 35.4166667 0.010000 35.4194444 0.010000 35.4222222 0.010000 35.4250000 0.010000 35.4277778 0.010000 35.4305556 0.010000 35.4333333 0.010000 35.4361111 0.019573 35.4388889 0.026252 35.4416667 0.034601 35.4444444 0.037941 35.4472222 0.037941 35.4500000 0.042950 35.4527778 0.041280 35.4555556 0.039610 35.4583333 0.051299 35.4611111 0.056308 35.4638889 0.062987 35.4666667 0.069666 35.4694444 0.078015 35.4722222 0.088033 35.4750000 0.093043 35.4777778 0.098052 35.4805556 0.099722 35.4833333 0.099722 35.4861111 0.096382 35.4888889 0.104731 35.4916667 0.108071 35.4944444 0.104731 35.4972222 0.113080 35.5000000 0.119759 35.5027778 0.123098 35.5055556 0.121429 35.5083333 0.121429 35.5111111 0.119759 35.5138889 0.114750 35.5166667 0.099722 35.5194444 0.089703 35.5222222 0.086364 35.5250000 0.078015 35.5277778 0.069666 35.5305556 0.066327 35.5333333 0.057978 35.5361111 0.056308 35.5388889 0.052968 35.5416667 0.044620 35.5444444 0.032931 35.5472222 0.027922 35.5500000 0.011224 35.5527778 0.010000 35.5555556 0.010000 35.5583333 0.010000 35.5611111 0.010000 35.5638889 0.010000 35.5666667 0.010000 35.5694444 0.010000 35.5722222 0.010000 35.5750000 0.010000 35.5777778 0.010000 35.5805556 0.010000 35.5833333 0.010000 35.5861111 0.010000 35.5888889 0.010000 35.5916667 0.010000 35.5944444 0.010000 35.5972222 0.010000 35.6000000 0.010000 35.6027778 0.010000 35.6055556 0.010000 35.6083333 0.010000 35.6111111 0.010000 35.6138889 0.010000 35.6166667 0.010000 35.6194444 0.010000 35.6222222 0.010000 35.6250000 0.010000 35.6277778 0.010000 35.6305556 0.010000 35.6333333 0.010000 35.6361111 0.010000 35.6388889 0.010000 35.6416667 0.010000 35.6444444 0.010000 35.6472222 0.010000 35.6500000 0.010000 35.6527778 0.010000 35.6555556 0.010000 35.6583333 0.010000 35.6611111 0.010000 35.6638889 0.010000 35.6666667 0.010000 35.6694444 0.010000 35.6722222 0.017904 35.6750000 0.044620 35.6777778 0.086364 35.6805556 0.128108 35.6833333 0.178200 35.6861111 0.216605 35.6888889 0.278386 35.6916667 0.343506 35.6944444 0.408627 35.6972222 0.485436 35.7000000 0.567254 35.7027778 0.647403 35.7055556 0.724212 35.7083333 0.780983 35.7111111 0.837755 35.7138889 0.850000 35.7166667 0.850000 35.7194444 0.850000 35.7222222 0.850000 35.7250000 0.850000 35.7277778 0.850000 35.7305556 0.850000 35.7333333 0.850000 35.7361111 0.850000 35.7388889 0.850000 35.7416667 0.850000 35.7444444 0.850000 35.7472222 0.844434 35.7500000 0.844434 35.7527778 0.841095 35.7555556 0.834416 35.7583333 0.811039 35.7611111 0.774304 35.7638889 0.722542 35.7666667 0.675788 35.7694444 0.615677 35.7722222 0.548887 35.7750000 0.465399 35.7777778 0.353525 35.7805556 0.228293 35.7833333 0.103061 35.7861111 0.010000 35.7888889 0.010000 35.7916667 0.010000 35.7944444 0.010000 35.7972222 0.010000 35.8000000 0.010000 35.8027778 0.010000 35.8055556 0.010000 35.8083333 0.010000 35.8111111 0.010000 35.8138889 0.010000 35.8166667 0.010000 35.8194444 0.010000 35.8222222 0.010000 35.8250000 0.010000 35.8277778 0.010000 35.8305556 0.010000 35.8333333 0.010000 35.8361111 0.010000 35.8388889 0.010000 35.8416667 0.010000 35.8444444 0.010000 35.8472222 0.010000 35.8500000 0.010000 35.8527778 0.010000 35.8555556 0.010000 35.8583333 0.010000 35.8611111 0.010000 35.8638889 0.010000 35.8666667 0.010000 35.8694444 0.010000 35.8722222 0.010000 35.8750000 0.010000 35.8777778 0.010000 35.8805556 0.010000 35.8833333 0.010000 35.8861111 0.010000 35.8888889 0.010000 35.8916667 0.010000 35.8944444 0.010000 35.8972222 0.010000 35.9000000 0.010000 35.9027778 0.010000 35.9055556 0.010000 35.9083333 0.010000 35.9111111 0.010000 35.9138889 0.010000 35.9166667 0.010000 35.9194444 0.010000 35.9222222 0.010000 35.9250000 0.010000 35.9277778 0.010000 35.9305556 0.010000 35.9333333 0.010000 35.9361111 0.010000 35.9388889 0.010000 35.9416667 0.010000 35.9444444 0.010000 35.9472222 0.010000 35.9500000 0.010000 35.9527778 0.010000 35.9555556 0.010000 35.9583333 0.010000 35.9611111 0.010000 35.9638889 0.010000 35.9666667 0.010000 35.9694444 0.010000 35.9722222 0.010000 35.9750000 0.010000 35.9777778 0.010000 35.9805556 0.010000 35.9833333 0.010000 35.9861111 0.010000 35.9888889 0.010000 35.9916667 0.010000 35.9944444 0.010000 35.9972222 0.010000 36.0000000 0.010000 36.0027778 0.010000 36.0055556 0.010000 36.0083333 0.010000 36.0111111 0.010000 36.0138889 0.010000 36.0166667 0.010000 36.0194444 0.010000 36.2222222 0.250000)
Vecg2 ecg_in_l1 0 PWL(0.0000000 0.250000 0.2500000 0.103061 0.2527778 0.099722 0.2555556 0.106401 0.2583333 0.101391 0.2611111 0.099722 0.2638889 0.099722 0.2666667 0.099722 0.2694444 0.096382 0.2722222 0.101391 0.2750000 0.098052 0.2777778 0.106401 0.2805556 0.103061 0.2833333 0.109740 0.2861111 0.108071 0.2888889 0.111410 0.2916667 0.108071 0.2944444 0.099722 0.2972222 0.103061 0.3000000 0.099722 0.3027778 0.093043 0.3055556 0.094712 0.3083333 0.101391 0.3111111 0.096382 0.3138889 0.103061 0.3166667 0.103061 0.3194444 0.104731 0.3222222 0.108071 0.3250000 0.111410 0.3277778 0.109740 0.3305556 0.109740 0.3333333 0.116419 0.3361111 0.118089 0.3388889 0.119759 0.3416667 0.128108 0.3444444 0.133117 0.3472222 0.131447 0.3500000 0.139796 0.3527778 0.139796 0.3555556 0.136456 0.3583333 0.134787 0.3611111 0.124768 0.3638889 0.113080 0.3666667 0.106401 0.3694444 0.094712 0.3722222 0.086364 0.3750000 0.094712 0.3777778 0.088033 0.3805556 0.088033 0.3833333 0.096382 0.3861111 0.096382 0.3888889 0.093043 0.3916667 0.096382 0.3944444 0.096382 0.3972222 0.089703 0.4000000 0.089703 0.4027778 0.088033 0.4055556 0.084694 0.4083333 0.086364 0.4111111 0.088033 0.4138889 0.088033 0.4166667 0.088033 0.4194444 0.086364 0.4222222 0.091373 0.4250000 0.089703 0.4277778 0.084694 0.4305556 0.084694 0.4333333 0.074675 0.4361111 0.073006 0.4388889 0.074675 0.4416667 0.076345 0.4444444 0.081354 0.4472222 0.083024 0.4500000 0.089703 0.4527778 0.094712 0.4555556 0.094712 0.4583333 0.089703 0.4611111 0.084694 0.4638889 0.083024 0.4666667 0.081354 0.4694444 0.088033 0.4722222 0.096382 0.4750000 0.109740 0.4777778 0.133117 0.4805556 0.153154 0.4833333 0.159833 0.4861111 0.149814 0.4888889 0.124768 0.4916667 0.074675 0.4944444 0.010000 0.4972222 0.010000 0.5000000 0.010000 0.5027778 0.010000 0.5055556 0.010000 0.5083333 0.010000 0.5111111 0.010000 0.5138889 0.010000 0.5166667 0.010000 0.5194444 0.010000 0.5222222 0.010000 0.5250000 0.010000 0.5277778 0.010000 0.5305556 0.010000 0.5333333 0.010000 0.5361111 0.012894 0.5388889 0.037941 0.5416667 0.052968 0.5444444 0.071336 0.5472222 0.078015 0.5500000 0.086364 0.5527778 0.088033 0.5555556 0.089703 0.5583333 0.094712 0.5611111 0.088033 0.5638889 0.086364 0.5666667 0.091373 0.5694444 0.098052 0.5722222 0.101391 0.5750000 0.108071 0.5777778 0.113080 0.5805556 0.111410 0.5833333 0.116419 0.5861111 0.113080 0.5888889 0.111410 0.5916667 0.108071 0.5944444 0.106401 0.5972222 0.101391 0.6000000 0.104731 0.6027778 0.101391 0.6055556 0.103061 0.6083333 0.109740 0.6111111 0.109740 0.6138889 0.111410 0.6166667 0.113080 0.6194444 0.109740 0.6222222 0.113080 0.6250000 0.106401 0.6277778 0.108071 0.6305556 0.104731 0.6333333 0.104731 0.6361111 0.113080 0.6388889 0.108071 0.6416667 0.113080 0.6444444 0.114750 0.6472222 0.116419 0.6500000 0.118089 0.6527778 0.118089 0.6555556 0.121429 0.6583333 0.111410 0.6611111 0.108071 0.6638889 0.108071 0.6666667 0.108071 0.6694444 0.109740 0.6722222 0.106401 0.6750000 0.109740 0.6777778 0.113080 0.6805556 0.113080 0.6833333 0.119759 0.6861111 0.118089 0.6888889 0.121429 0.6916667 0.114750 0.6944444 0.114750 0.6972222 0.116419 0.7000000 0.116419 0.7027778 0.116419 0.7055556 0.116419 0.7083333 0.123098 0.7111111 0.124768 0.7138889 0.128108 0.7166667 0.133117 0.7194444 0.133117 0.7222222 0.133117 0.7250000 0.129777 0.7277778 0.133117 0.7305556 0.131447 0.7333333 0.129777 0.7361111 0.128108 0.7388889 0.126438 0.7416667 0.131447 0.7444444 0.138126 0.7472222 0.144805 0.7500000 0.143135 0.7527778 0.146475 0.7555556 0.148145 0.7583333 0.144805 0.7611111 0.138126 0.7638889 0.143135 0.7666667 0.131447 0.7694444 0.141466 0.7722222 0.138126 0.7750000 0.134787 0.7777778 0.144805 0.7805556 0.141466 0.7833333 0.144805 0.7861111 0.139796 0.7888889 0.139796 0.7916667 0.134787 0.7944444 0.123098 0.7972222 0.123098 1.1888889 0.088033 1.1916667 0.084694 1.1944444 0.078015 1.1972222 0.081354 1.2000000 0.079685 1.2027778 0.081354 1.2055556 0.076345 1.2083333 0.083024 1.2111111 0.086364 1.2138889 0.081354 1.2166667 0.089703 1.2194444 0.084694 1.2222222 0.088033 1.2250000 0.084694 1.2277778 0.084694 1.2305556 0.083024 1.2333333 0.081354 1.2361111 0.083024 1.2388889 0.093043 1.2416667 0.101391 1.2444444 0.103061 1.2472222 0.106401 1.2500000 0.111410 1.2527778 0.109740 1.2555556 0.119759 1.2583333 0.116419 1.2611111 0.116419 1.2638889 0.114750 1.2666667 0.116419 1.2694444 0.116419 1.2722222 0.113080 1.2750000 0.111410 1.2777778 0.108071 1.2805556 0.101391 1.2833333 0.101391 1.2861111 0.096382 1.2888889 0.086364 1.2916667 0.076345 1.2944444 0.078015 1.2972222 0.071336 1.3000000 0.074675 1.3027778 0.074675 1.3055556 0.071336 1.3083333 0.071336 1.3111111 0.073006 1.3138889 0.076345 1.3166667 0.078015 1.3194444 0.083024 1.3222222 0.081354 1.3250000 0.076345 1.3277778 0.069666 1.3305556 0.066327 1.3333333 0.064657 1.3361111 0.062987 1.3388889 0.062987 1.3416667 0.071336 1.3444444 0.073006 1.3472222 0.078015 1.3500000 0.076345 1.3527778 0.076345 1.3555556 0.076345 1.3583333 0.076345 1.3611111 0.076345 1.3638889 0.071336 1.3666667 0.069666 1.3694444 0.071336 1.3722222 0.069666 1.3750000 0.073006 1.3777778 0.071336 1.3805556 0.074675 1.3833333 0.076345 1.3861111 0.074675 1.3888889 0.074675 1.3916667 0.074675 1.3944444 0.073006 1.3972222 0.069666 1.4000000 0.066327 1.4027778 0.069666 1.4055556 0.083024 1.4083333 0.103061 1.4111111 0.128108 1.4138889 0.136456 1.4166667 0.158163 1.4194444 0.158163 1.4222222 0.143135 1.4250000 0.111410 1.4277778 0.066327 1.4305556 0.010000 1.4333333 0.010000 1.4361111 0.010000 1.4388889 0.010000 1.4416667 0.010000 1.4444444 0.010000 1.4472222 0.010000 1.4500000 0.010000 1.4527778 0.010000 1.4555556 0.010000 1.4583333 0.010000 1.4611111 0.010000 1.4638889 0.010000 1.4666667 0.010000 1.4694444 0.010000 1.4722222 0.010000 1.4750000 0.010000 1.4777778 0.010000 1.4805556 0.010000 1.4833333 0.032931 1.4861111 0.047959 1.4888889 0.062987 1.4916667 0.071336 1.4944444 0.073006 1.4972222 0.076345 1.5000000 0.076345 1.5027778 0.078015 1.5055556 0.076345 1.5083333 0.084694 1.5111111 0.093043 1.5138889 0.093043 1.5166667 0.096382 1.5194444 0.101391 1.5222222 0.094712 1.5250000 0.089703 1.5277778 0.093043 1.5305556 0.091373 1.5333333 0.089703 1.5361111 0.086364 1.5388889 0.089703 1.5416667 0.098052 1.5444444 0.099722 1.5472222 0.101391 1.5500000 0.109740 1.5527778 0.109740 1.5555556 0.108071 1.5583333 0.104731 1.5611111 0.103061 1.5638889 0.096382 1.5666667 0.098052 1.5694444 0.098052 1.5722222 0.101391 1.5750000 0.101391 1.5777778 0.103061 1.5805556 0.104731 1.5833333 0.109740 1.5861111 0.104731 1.5888889 0.108071 1.5916667 0.104731 1.5944444 0.103061 1.5972222 0.094712 1.6000000 0.096382 1.6027778 0.093043 1.6055556 0.098052 1.6083333 0.096382 1.6111111 0.103061 1.6138889 0.104731 1.6166667 0.113080 1.6194444 0.113080 1.6222222 0.114750 1.6250000 0.113080 1.6277778 0.101391 1.6305556 0.098052 1.6333333 0.103061 1.6361111 0.104731 1.6388889 0.106401 1.6416667 0.101391 1.6444444 0.108071 1.6472222 0.114750 1.6500000 0.118089 1.6527778 0.114750 1.6555556 0.113080 1.6583333 0.113080 1.6611111 0.104731 1.6638889 0.101391 1.6666667 0.108071 1.6694444 0.108071 1.6722222 0.109740 1.6750000 0.113080 1.6777778 0.121429 1.6805556 0.121429 1.6833333 0.128108 1.6861111 0.126438 1.6888889 0.124768 1.6916667 0.119759 1.6944444 0.119759 1.6972222 0.113080 1.7000000 0.116419 1.7027778 0.109740 1.7055556 0.121429 1.7083333 0.119759 1.7111111 0.124768 1.7138889 0.126438 1.7166667 0.128108 1.7194444 0.129777 1.7222222 0.119759 1.7250000 0.119759 1.7277778 0.111410 1.7305556 0.113080 1.7333333 0.108071 1.7361111 0.103061 2.1222222 0.093043 2.1250000 0.091373 2.1277778 0.084694 2.1305556 0.084694 2.1333333 0.079685 2.1361111 0.079685 2.1388889 0.083024 2.1416667 0.084694 2.1444444 0.086364 2.1472222 0.098052 2.1500000 0.093043 2.1527778 0.089703 2.1555556 0.091373 2.1583333 0.089703 2.1611111 0.089703 2.1638889 0.088033 2.1666667 0.086364 2.1694444 0.081354 2.1722222 0.096382 2.1750000 0.103061 2.1777778 0.106401 2.1805556 0.113080 2.1833333 0.119759 2.1861111 0.123098 2.1888889 0.118089 2.1916667 0.119759 2.1944444 0.116419 2.1972222 0.114750 2.2000000 0.118089 2.2027778 0.114750 2.2055556 0.109740 2.2083333 0.108071 2.2111111 0.098052 2.2138889 0.091373 2.2166667 0.093043 2.2194444 0.084694 2.2222222 0.083024 2.2250000 0.081354 2.2277778 0.078015 2.2305556 0.073006 2.2333333 0.073006 2.2361111 0.078015 2.2388889 0.073006 2.2416667 0.076345 2.2444444 0.076345 2.2472222 0.081354 2.2500000 0.083024 2.2527778 0.084694 2.2555556 0.083024 2.2583333 0.076345 2.2611111 0.069666 2.2638889 0.067996 2.2666667 0.066327 2.2694444 0.064657 2.2722222 0.064657 2.2750000 0.067996 2.2777778 0.067996 2.2805556 0.074675 2.2833333 0.081354 2.2861111 0.071336 2.2888889 0.076345 2.2916667 0.074675 2.2944444 0.069666 2.2972222 0.069666 2.3000000 0.073006 2.3027778 0.069666 2.3055556 0.069666 2.3083333 0.069666 2.3111111 0.076345 2.3138889 0.076345 2.3166667 0.078015 2.3194444 0.074675 2.3222222 0.079685 2.3250000 0.073006 2.3277778 0.071336 2.3305556 0.067996 2.3333333 0.066327 2.3361111 0.074675 2.3388889 0.069666 2.3416667 0.084694 2.3444444 0.104731 2.3472222 0.124768 2.3500000 0.143135 2.3527778 0.153154 2.3555556 0.144805 2.3583333 0.119759 2.3611111 0.073006 2.3638889 0.016234 2.3666667 0.010000 2.3694444 0.010000 2.3722222 0.010000 2.3750000 0.010000 2.3777778 0.010000 2.3805556 0.010000 2.3833333 0.010000 2.3861111 0.010000 2.3888889 0.010000 2.3916667 0.010000 2.3944444 0.010000 2.3972222 0.010000 2.4000000 0.010000 2.4027778 0.010000 2.4055556 0.010000 2.4083333 0.010000 2.4111111 0.014564 2.4138889 0.037941 2.4166667 0.061317 2.4194444 0.071336 2.4222222 0.078015 2.4250000 0.084694 2.4277778 0.079685 2.4305556 0.078015 2.4333333 0.079685 2.4361111 0.076345 2.4388889 0.084694 2.4416667 0.089703 2.4444444 0.098052 2.4472222 0.099722 2.4500000 0.104731 2.4527778 0.099722 2.4555556 0.101391 2.4583333 0.099722 2.4611111 0.096382 2.4638889 0.091373 2.4666667 0.094712 2.4694444 0.093043 2.4722222 0.093043 2.4750000 0.099722 2.4777778 0.103061 2.4805556 0.108071 2.4833333 0.106401 2.4861111 0.113080 2.4888889 0.108071 2.4916667 0.106401 2.4944444 0.098052 2.4972222 0.101391 2.5000000 0.094712 2.5027778 0.091373 2.5055556 0.098052 2.5083333 0.101391 2.5111111 0.098052 2.5138889 0.101391 2.5166667 0.106401 2.5194444 0.103061 2.5222222 0.101391 2.5250000 0.104731 2.5277778 0.096382 2.5305556 0.094712 2.5333333 0.098052 2.5361111 0.094712 2.5388889 0.098052 2.5416667 0.099722 2.5444444 0.103061 2.5472222 0.108071 2.5500000 0.111410 2.5527778 0.113080 2.5555556 0.111410 2.5583333 0.103061 2.5611111 0.103061 2.5638889 0.096382 2.5666667 0.096382 2.5694444 0.096382 2.5722222 0.096382 2.5750000 0.106401 2.5777778 0.099722 2.5805556 0.103061 2.5833333 0.109740 2.5861111 0.108071 2.5888889 0.103061 2.5916667 0.101391 2.5944444 0.101391 2.5972222 0.101391 2.6000000 0.103061 2.6027778 0.104731 2.6055556 0.104731 2.6083333 0.111410 2.6111111 0.109740 2.6138889 0.114750 2.6166667 0.118089 2.6194444 0.118089 2.6222222 0.104731 2.6250000 0.106401 2.6277778 0.104731 2.6305556 0.099722 2.6333333 0.096382 2.6361111 0.089703 2.6388889 0.089703 2.6416667 0.093043 2.6444444 0.094712 2.6472222 0.093043 2.6500000 0.098052 2.6527778 0.098052 2.6555556 0.101391 2.6583333 0.098052 2.6611111 0.094712 2.6638889 0.093043 2.6666667 0.093043 2.6694444 0.091373 3.0111111 0.089703 3.0138889 0.091373 3.0166667 0.098052 3.0194444 0.093043 3.0222222 0.093043 3.0250000 0.084694 3.0277778 0.088033 3.0305556 0.088033 3.0333333 0.083024 3.0361111 0.081354 3.0388889 0.091373 3.0416667 0.084694 3.0444444 0.093043 3.0472222 0.099722 3.0500000 0.101391 3.0527778 0.099722 3.0555556 0.099722 3.0583333 0.099722 3.0611111 0.096382 3.0638889 0.093043 3.0666667 0.096382 3.0694444 0.098052 3.0722222 0.099722 3.0750000 0.106401 3.0777778 0.104731 3.0805556 0.111410 3.0833333 0.114750 3.0861111 0.123098 3.0888889 0.116419 3.0916667 0.119759 3.0944444 0.119759 3.0972222 0.119759 3.1000000 0.114750 3.1027778 0.108071 3.1055556 0.104731 3.1083333 0.094712 3.1111111 0.096382 3.1138889 0.091373 3.1166667 0.093043 3.1194444 0.088033 3.1222222 0.091373 3.1250000 0.081354 3.1277778 0.078015 3.1305556 0.074675 3.1333333 0.067996 3.1361111 0.064657 3.1388889 0.064657 3.1416667 0.071336 3.1444444 0.078015 3.1472222 0.078015 3.1500000 0.083024 3.1527778 0.086364 3.1555556 0.086364 3.1583333 0.078015 3.1611111 0.078015 3.1638889 0.078015 3.1666667 0.067996 3.1694444 0.067996 3.1722222 0.069666 3.1750000 0.073006 3.1777778 0.076345 3.1805556 0.081354 3.1833333 0.079685 3.1861111 0.078015 3.1888889 0.081354 3.1916667 0.074675 3.1944444 0.073006 3.1972222 0.074675 3.2000000 0.064657 3.2027778 0.064657 3.2055556 0.067996 3.2083333 0.074675 3.2111111 0.076345 3.2138889 0.078015 3.2166667 0.084694 3.2194444 0.084694 3.2222222 0.086364 3.2250000 0.083024 3.2277778 0.084694 3.2305556 0.091373 3.2333333 0.096382 3.2361111 0.111410 3.2388889 0.133117 3.2416667 0.146475 3.2444444 0.148145 3.2472222 0.131447 3.2500000 0.094712 3.2527778 0.031262 3.2555556 0.010000 3.2583333 0.010000 3.2611111 0.010000 3.2638889 0.010000 3.2666667 0.010000 3.2694444 0.010000 3.2722222 0.010000 3.2750000 0.010000 3.2777778 0.010000 3.2805556 0.010000 3.2833333 0.010000 3.2861111 0.010000 3.2888889 0.010000 3.2916667 0.010000 3.2944444 0.010000 3.2972222 0.021243 3.3000000 0.034601 3.3027778 0.051299 3.3055556 0.062987 3.3083333 0.069666 3.3111111 0.079685 3.3138889 0.079685 3.3166667 0.084694 3.3194444 0.088033 3.3222222 0.088033 3.3250000 0.093043 3.3277778 0.088033 3.3305556 0.094712 3.3333333 0.088033 3.3361111 0.088033 3.3388889 0.089703 3.3416667 0.098052 3.3444444 0.099722 3.3472222 0.101391 3.3500000 0.101391 3.3527778 0.104731 3.3555556 0.106401 3.3583333 0.108071 3.3611111 0.099722 3.3638889 0.094712 3.3666667 0.093043 3.3694444 0.088033 3.3722222 0.091373 3.3750000 0.098052 3.3777778 0.099722 3.3805556 0.099722 3.3833333 0.101391 3.3861111 0.103061 3.3888889 0.104731 3.3916667 0.106401 3.3944444 0.099722 3.3972222 0.094712 3.4000000 0.088033 3.4027778 0.089703 3.4055556 0.089703 3.4083333 0.096382 3.4111111 0.096382 3.4138889 0.098052 3.4166667 0.103061 3.4194444 0.099722 3.4222222 0.103061 3.4250000 0.098052 3.4277778 0.098052 3.4305556 0.096382 3.4333333 0.093043 3.4361111 0.098052 3.4388889 0.098052 3.4416667 0.103061 3.4444444 0.104731 3.4472222 0.111410 3.4500000 0.111410 3.4527778 0.113080 3.4555556 0.113080 3.4583333 0.111410 3.4611111 0.103061 3.4638889 0.111410 3.4666667 0.099722 3.4694444 0.098052 3.4722222 0.104731 3.4750000 0.104731 3.4777778 0.108071 3.4805556 0.113080 3.4833333 0.113080 3.4861111 0.111410 3.4888889 0.111410 3.4916667 0.113080 3.4944444 0.108071 3.4972222 0.111410 3.5000000 0.104731 3.5027778 0.109740 3.5055556 0.106401 3.5083333 0.108071 3.5111111 0.113080 3.5138889 0.116419 3.5166667 0.113080 3.5194444 0.118089 3.5222222 0.113080 3.5250000 0.109740 3.5277778 0.103061 3.5305556 0.103061 3.5333333 0.098052 3.5361111 0.099722 3.5388889 0.099722 3.5416667 0.098052 3.5444444 0.103061 3.5472222 0.101391 3.5500000 0.103061 3.5527778 0.113080 3.5555556 0.106401 3.5583333 0.099722 3.9083333 0.076345 3.9111111 0.079685 3.9138889 0.081354 3.9166667 0.079685 3.9194444 0.081354 3.9222222 0.079685 3.9250000 0.081354 3.9277778 0.073006 3.9305556 0.071336 3.9333333 0.069666 3.9361111 0.074675 3.9388889 0.073006 3.9416667 0.076345 3.9444444 0.086364 3.9472222 0.086364 3.9500000 0.096382 3.9527778 0.099722 3.9555556 0.098052 3.9583333 0.098052 3.9611111 0.096382 3.9638889 0.099722 3.9666667 0.094712 3.9694444 0.094712 3.9722222 0.096382 3.9750000 0.099722 3.9777778 0.108071 3.9805556 0.113080 3.9833333 0.119759 3.9861111 0.118089 3.9888889 0.118089 3.9916667 0.104731 3.9944444 0.096382 3.9972222 0.086364 4.0000000 0.079685 4.0027778 0.073006 4.0055556 0.069666 4.0083333 0.071336 4.0111111 0.076345 4.0138889 0.081354 4.0166667 0.076345 4.0194444 0.076345 4.0222222 0.071336 4.0250000 0.074675 4.0277778 0.067996 4.0305556 0.073006 4.0333333 0.069666 4.0361111 0.062987 4.0388889 0.064657 4.0416667 0.067996 4.0444444 0.074675 4.0472222 0.076345 4.0500000 0.076345 4.0527778 0.078015 4.0555556 0.078015 4.0583333 0.078015 4.0611111 0.073006 4.0638889 0.073006 4.0666667 0.071336 4.0694444 0.064657 4.0722222 0.071336 4.0750000 0.073006 4.0777778 0.071336 4.0805556 0.074675 4.0833333 0.074675 4.0861111 0.073006 4.0888889 0.074675 4.0916667 0.074675 4.0944444 0.073006 4.0972222 0.073006 4.1000000 0.067996 4.1027778 0.067996 4.1055556 0.061317 4.1083333 0.071336 4.1111111 0.071336 4.1138889 0.071336 4.1166667 0.074675 4.1194444 0.081354 4.1222222 0.086364 4.1250000 0.089703 4.1277778 0.101391 4.1305556 0.116419 4.1333333 0.134787 4.1361111 0.151484 4.1388889 0.161503 4.1416667 0.144805 4.1444444 0.119759 4.1472222 0.081354 4.1500000 0.019573 4.1527778 0.010000 4.1555556 0.010000 4.1583333 0.010000 4.1611111 0.010000 4.1638889 0.010000 4.1666667 0.010000 4.1694444 0.010000 4.1722222 0.010000 4.1750000 0.010000 4.1777778 0.010000 4.1805556 0.010000 4.1833333 0.010000 4.1861111 0.010000 4.1888889 0.010000 4.1916667 0.010000 4.1944444 0.010000 4.1972222 0.010000 4.2000000 0.029592 4.2027778 0.047959 4.2055556 0.057978 4.2083333 0.067996 4.2111111 0.073006 4.2138889 0.081354 4.2166667 0.084694 4.2194444 0.083024 4.2222222 0.086364 4.2250000 0.088033 4.2277778 0.088033 4.2305556 0.088033 4.2333333 0.081354 4.2361111 0.088033 4.2388889 0.084694 4.2416667 0.084694 4.2444444 0.093043 4.2472222 0.096382 4.2500000 0.104731 4.2527778 0.108071 4.2555556 0.106401 4.2583333 0.103061 4.2611111 0.099722 4.2638889 0.101391 4.2666667 0.098052 4.2694444 0.094712 4.2722222 0.098052 4.2750000 0.096382 4.2777778 0.099722 4.2805556 0.103061 4.2833333 0.111410 4.2861111 0.109740 4.2888889 0.111410 4.2916667 0.106401 4.2944444 0.099722 4.2972222 0.099722 4.3000000 0.096382 4.3027778 0.093043 4.3055556 0.098052 4.3083333 0.096382 4.3111111 0.099722 4.3138889 0.104731 4.3166667 0.114750 4.3194444 0.116419 4.3222222 0.118089 4.3250000 0.113080 4.3277778 0.114750 4.3305556 0.109740 4.3333333 0.104731 4.3361111 0.103061 4.3388889 0.103061 4.3416667 0.104731 4.3444444 0.108071 4.3472222 0.116419 4.3500000 0.109740 4.3527778 0.113080 4.3555556 0.114750 4.3583333 0.109740 4.3611111 0.108071 4.3638889 0.104731 4.3666667 0.108071 4.3694444 0.104731 4.3722222 0.106401 4.3750000 0.114750 4.3777778 0.116419 4.3805556 0.123098 4.3833333 0.123098 4.3861111 0.126438 4.3888889 0.126438 4.3916667 0.126438 4.3944444 0.124768 4.3972222 0.119759 4.4000000 0.118089 4.4027778 0.111410 4.4055556 0.118089 4.4083333 0.121429 4.4111111 0.124768 4.4138889 0.128108 4.4166667 0.128108 4.4194444 0.129777 4.4222222 0.128108 4.4250000 0.128108 4.4277778 0.118089 4.4305556 0.119759 4.4333333 0.118089 4.4361111 0.114750 4.4388889 0.114750 4.4416667 0.119759 4.4444444 0.121429 4.4472222 0.121429 4.4500000 0.128108 4.4527778 0.126438 4.4555556 0.126438 4.4583333 0.118089 4.4611111 0.116419 4.4638889 0.108071 4.4666667 0.108071 4.4694444 0.106401 4.4722222 0.108071 4.4750000 0.101391 4.4777778 0.104731 4.4805556 0.109740 4.4833333 0.113080 4.4861111 0.114750 4.4888889 0.113080 4.4916667 0.118089 4.4944444 0.114750 4.4972222 0.111410 4.5000000 0.113080 4.5027778 0.113080 4.5055556 0.111410 4.5083333 0.113080 4.5111111 0.116419 4.5138889 0.113080 4.5166667 0.118089 4.5194444 0.111410 4.5222222 0.111410 4.5250000 0.113080 4.5277778 0.106401 4.5305556 0.106401 4.5333333 0.098052 4.5361111 0.094712 4.5388889 0.094712 4.5416667 0.098052 4.5444444 0.101391 4.5472222 0.099722 4.5500000 0.108071 4.5527778 0.101391 4.5555556 0.104731 4.5583333 0.109740 4.5611111 0.108071 4.5638889 0.099722 4.5666667 0.098052 4.5694444 0.098052 4.5722222 0.099722 4.5750000 0.094712 4.5777778 0.099722 4.5805556 0.106401 4.5833333 0.104731 4.5861111 0.106401 4.5888889 0.103061 4.5916667 0.104731 4.5944444 0.101391 4.5972222 0.098052 4.6000000 0.093043 4.6027778 0.091373 4.6055556 0.091373 4.6083333 0.091373 4.6111111 0.096382 4.6138889 0.098052 4.6166667 0.109740 4.6194444 0.114750 4.6222222 0.111410 4.6250000 0.113080 4.6277778 0.116419 4.6305556 0.113080 4.6333333 0.116419 4.6361111 0.123098 4.6388889 0.131447 4.6416667 0.139796 4.6444444 0.153154 4.6472222 0.181540 4.6500000 0.191558 4.6527778 0.189889 4.6555556 0.163173 4.6583333 0.126438 4.6611111 0.076345 4.6638889 0.019573 4.6666667 0.010000 4.6694444 0.010000 4.6722222 0.010000 4.6750000 0.010000 4.6777778 0.010000 4.6805556 0.010000 4.6833333 0.010000 4.6861111 0.010000 4.6888889 0.010000 4.6916667 0.010000 4.6944444 0.010000 4.6972222 0.010000 4.7000000 0.010000 4.7027778 0.010000 4.7055556 0.010000 4.7083333 0.010000 4.7111111 0.010000 4.7138889 0.010000 4.7166667 0.010000 4.7194444 0.010000 4.7222222 0.010000 4.7250000 0.010000 4.7277778 0.010000 4.7305556 0.010000 4.7333333 0.010000 4.7361111 0.010000 4.7388889 0.010000 4.7416667 0.010000 4.7444444 0.010000 4.7472222 0.010000 4.7500000 0.010000 4.7527778 0.010000 4.7555556 0.010000 4.7583333 0.010000 4.7611111 0.010000 4.7638889 0.032931 4.7666667 0.073006 4.7694444 0.093043 4.7722222 0.109740 4.7750000 0.121429 4.7777778 0.123098 4.7805556 0.131447 4.7833333 0.134787 4.7861111 0.144805 4.7888889 0.148145 4.7916667 0.154824 4.7944444 0.153154 4.7972222 0.153154 4.8000000 0.156494 4.8027778 0.161503 4.8055556 0.164842 4.8083333 0.169852 4.8111111 0.176531 4.8138889 0.183210 4.8166667 0.186549 4.8194444 0.189889 4.8222222 0.193228 4.8250000 0.194898 4.8277778 0.193228 4.8305556 0.194898 4.8333333 0.193228 4.8361111 0.193228 4.8388889 0.194898 4.8416667 0.201577 4.8444444 0.211596 4.8472222 0.218275 4.8500000 0.229963 4.8527778 0.231633 4.8555556 0.239981 4.8583333 0.244991 4.8611111 0.246660 4.8638889 0.248330 4.8666667 0.251670 4.8694444 0.261688 4.8722222 0.266698 4.8750000 0.276716 4.8777778 0.288404 4.8805556 0.300093 4.8833333 0.305102 4.8861111 0.313451 4.8888889 0.320130 4.8916667 0.318460 4.8944444 0.320130 4.8972222 0.310111 4.9000000 0.308442 4.9027778 0.303432 4.9055556 0.301763 4.9083333 0.308442 4.9111111 0.310111 4.9138889 0.321800 4.9166667 0.331818 4.9194444 0.340167 4.9222222 0.345176 4.9250000 0.355195 4.9277778 0.356865 4.9305556 0.361874 4.9333333 0.363544 4.9361111 0.368553 4.9388889 0.380241 4.9416667 0.386920 4.9444444 0.398609 4.9472222 0.408627 4.9500000 0.408627 4.9527778 0.415306 4.9555556 0.420315 4.9583333 0.413636 4.9611111 0.410297 4.9638889 0.410297 4.9666667 0.401948 4.9694444 0.395269 4.9722222 0.393599 4.9750000 0.386920 4.9777778 0.388590 4.9805556 0.383581 4.9833333 0.380241 4.9861111 0.371892 4.9888889 0.363544 4.9916667 0.353525 4.9944444 0.338497 5.7472222 0.078015 5.7500000 0.081354 5.7527778 0.083024 5.7555556 0.081354 5.7583333 0.079685 5.7611111 0.078015 5.7638889 0.073006 5.7666667 0.067996 5.7694444 0.069666 5.7722222 0.061317 5.7750000 0.067996 5.7777778 0.069666 5.7805556 0.071336 5.7833333 0.076345 5.7861111 0.084694 5.7888889 0.079685 5.7916667 0.083024 5.7944444 0.079685 5.7972222 0.076345 5.8000000 0.073006 5.8027778 0.073006 5.8055556 0.067996 5.8083333 0.073006 5.8111111 0.078015 5.8138889 0.083024 5.8166667 0.081354 5.8194444 0.091373 5.8222222 0.091373 5.8250000 0.089703 5.8277778 0.093043 5.8305556 0.096382 5.8333333 0.093043 5.8361111 0.091373 5.8388889 0.094712 5.8416667 0.098052 5.8444444 0.101391 5.8472222 0.108071 5.8500000 0.108071 5.8527778 0.111410 5.8555556 0.104731 5.8583333 0.093043 5.8611111 0.079685 5.8638889 0.074675 5.8666667 0.067996 5.8694444 0.062987 5.8722222 0.062987 5.8750000 0.064657 5.8777778 0.064657 5.8805556 0.062987 5.8833333 0.066327 5.8861111 0.076345 5.8888889 0.071336 5.8916667 0.067996 5.8944444 0.064657 5.8972222 0.066327 5.9000000 0.061317 5.9027778 0.064657 5.9055556 0.059647 5.9083333 0.057978 5.9111111 0.059647 5.9138889 0.061317 5.9166667 0.066327 5.9194444 0.069666 5.9222222 0.069666 5.9250000 0.066327 5.9277778 0.062987 5.9305556 0.062987 5.9333333 0.052968 5.9361111 0.056308 5.9388889 0.056308 5.9416667 0.054638 5.9444444 0.059647 5.9472222 0.066327 5.9500000 0.064657 5.9527778 0.066327 5.9555556 0.064657 5.9583333 0.064657 5.9611111 0.066327 5.9638889 0.066327 5.9666667 0.073006 5.9694444 0.088033 5.9722222 0.109740 5.9750000 0.123098 5.9777778 0.134787 5.9805556 0.126438 5.9833333 0.108071 5.9861111 0.076345 5.9888889 0.022913 5.9916667 0.010000 5.9944444 0.010000 5.9972222 0.010000 6.0000000 0.010000 6.0027778 0.010000 6.0055556 0.010000 6.0083333 0.010000 6.0111111 0.010000 6.0138889 0.010000 6.0166667 0.010000 6.0194444 0.010000 6.0222222 0.010000 6.0250000 0.010000 6.0277778 0.010000 6.0305556 0.010000 6.0333333 0.010000 6.0361111 0.010000 6.0388889 0.022913 6.0416667 0.036271 6.0444444 0.049629 6.0472222 0.061317 6.0500000 0.066327 6.0527778 0.071336 6.0555556 0.073006 6.0583333 0.073006 6.0611111 0.073006 6.0638889 0.073006 6.0666667 0.071336 6.0694444 0.073006 6.0722222 0.073006 6.0750000 0.074675 6.0777778 0.083024 6.0805556 0.083024 6.0833333 0.086364 6.0861111 0.088033 6.0888889 0.094712 6.0916667 0.093043 6.0944444 0.089703 6.0972222 0.083024 6.1000000 0.086364 6.1027778 0.086364 6.1055556 0.083024 6.1083333 0.088033 6.1111111 0.088033 6.1138889 0.094712 6.1166667 0.094712 6.1194444 0.096382 6.1222222 0.098052 6.1250000 0.094712 6.1277778 0.099722 6.1305556 0.093043 6.1333333 0.084694 6.1361111 0.084694 6.1388889 0.086364 6.1416667 0.088033 6.1444444 0.091373 6.1472222 0.093043 6.1500000 0.101391 6.1527778 0.108071 6.1555556 0.103061 6.1583333 0.106401 6.1611111 0.104731 6.1638889 0.103061 6.1666667 0.094712 6.1694444 0.096382 6.1722222 0.089703 6.1750000 0.093043 6.1777778 0.094712 6.1805556 0.103061 6.1833333 0.106401 6.1861111 0.108071 6.1888889 0.104731 6.1916667 0.106401 6.1944444 0.111410 6.1972222 0.103061 6.2000000 0.101391 6.2027778 0.101391 6.2055556 0.099722 6.2083333 0.101391 6.2111111 0.111410 6.2138889 0.111410 6.2166667 0.114750 6.2194444 0.121429 6.2222222 0.119759 6.2250000 0.124768 6.2277778 0.124768 6.2305556 0.118089 6.2333333 0.116419 6.2361111 0.111410 6.2388889 0.108071 6.2416667 0.114750 6.2444444 0.118089 6.2472222 0.121429 6.2500000 0.124768 6.2527778 0.129777 6.2555556 0.126438 6.2583333 0.128108 6.2611111 0.118089 6.2638889 0.116419 6.2666667 0.116419 6.2694444 0.114750 6.2722222 0.114750 6.2750000 0.113080 6.2777778 0.118089 6.2805556 0.119759 6.2833333 0.126438 6.2861111 0.129777 6.2888889 0.123098 6.2916667 0.126438 6.2944444 0.121429 6.6916667 0.086364 6.6944444 0.086364 6.6972222 0.076345 6.7000000 0.078015 6.7027778 0.073006 6.7055556 0.071336 6.7083333 0.076345 6.7111111 0.079685 6.7138889 0.078015 6.7166667 0.079685 6.7194444 0.083024 6.7222222 0.088033 6.7250000 0.084694 6.7277778 0.081354 6.7305556 0.083024 6.7333333 0.078015 6.7361111 0.078015 6.7388889 0.086364 6.7416667 0.081354 6.7444444 0.084694 6.7472222 0.088033 6.7500000 0.091373 6.7527778 0.096382 6.7555556 0.104731 6.7583333 0.108071 6.7611111 0.106401 6.7638889 0.106401 6.7666667 0.101391 6.7694444 0.106401 6.7722222 0.104731 6.7750000 0.101391 6.7777778 0.116419 6.7805556 0.116419 6.7833333 0.114750 6.7861111 0.119759 6.7888889 0.113080 6.7916667 0.104731 6.7944444 0.098052 6.7972222 0.089703 6.8000000 0.079685 6.8027778 0.074675 6.8055556 0.071336 6.8083333 0.069666 6.8111111 0.073006 6.8138889 0.074675 6.8166667 0.076345 6.8194444 0.076345 6.8222222 0.073006 6.8250000 0.071336 6.8277778 0.074675 6.8305556 0.073006 6.8333333 0.062987 6.8361111 0.066327 6.8388889 0.059647 6.8416667 0.064657 6.8444444 0.057978 6.8472222 0.059647 6.8500000 0.061317 6.8527778 0.069666 6.8555556 0.069666 6.8583333 0.071336 6.8611111 0.062987 6.8638889 0.056308 6.8666667 0.052968 6.8694444 0.051299 6.8722222 0.051299 6.8750000 0.051299 6.8777778 0.054638 6.8805556 0.061317 6.8833333 0.061317 6.8861111 0.064657 6.8888889 0.069666 6.8916667 0.071336 6.8944444 0.064657 6.8972222 0.066327 6.9000000 0.052968 6.9027778 0.061317 6.9055556 0.064657 6.9083333 0.059647 6.9111111 0.074675 6.9138889 0.089703 6.9166667 0.113080 6.9194444 0.131447 6.9222222 0.143135 6.9250000 0.144805 6.9277778 0.128108 6.9305556 0.084694 6.9333333 0.026252 6.9361111 0.010000 6.9388889 0.010000 6.9416667 0.010000 6.9444444 0.010000 6.9472222 0.010000 6.9500000 0.010000 6.9527778 0.010000 6.9555556 0.010000 6.9583333 0.010000 6.9611111 0.010000 6.9638889 0.010000 6.9666667 0.010000 6.9694444 0.010000 6.9722222 0.010000 6.9750000 0.010000 6.9777778 0.010000 6.9805556 0.010000 6.9833333 0.016234 6.9861111 0.034601 6.9888889 0.047959 6.9916667 0.056308 6.9944444 0.066327 6.9972222 0.064657 7.0000000 0.059647 7.0027778 0.064657 7.0055556 0.064657 7.0083333 0.071336 7.0111111 0.071336 7.0138889 0.074675 7.0166667 0.081354 7.0194444 0.086364 7.0222222 0.081354 7.0250000 0.079685 7.0277778 0.089703 7.0305556 0.081354 7.0333333 0.079685 7.0361111 0.081354 7.0388889 0.079685 7.0416667 0.081354 7.0444444 0.088033 7.0472222 0.086364 7.0500000 0.089703 7.0527778 0.091373 7.0555556 0.096382 7.0583333 0.091373 7.0611111 0.089703 7.0638889 0.086364 7.0666667 0.083024 7.0694444 0.086364 7.0722222 0.081354 7.0750000 0.079685 7.0777778 0.081354 7.0805556 0.089703 7.0833333 0.091373 7.0861111 0.091373 7.0888889 0.091373 7.0916667 0.091373 7.0944444 0.088033 7.0972222 0.091373 7.1000000 0.086364 7.1027778 0.084694 7.1055556 0.084694 7.1083333 0.088033 7.1111111 0.084694 7.1138889 0.094712 7.1166667 0.094712 7.1194444 0.098052 7.1222222 0.094712 7.1250000 0.099722 7.1277778 0.094712 7.1305556 0.088033 7.1333333 0.089703 7.1361111 0.079685 7.1388889 0.084694 7.1416667 0.083024 7.1444444 0.086364 7.1472222 0.086364 7.1500000 0.096382 7.1527778 0.089703 7.1555556 0.098052 7.1583333 0.093043 7.1611111 0.098052 7.1638889 0.093043 7.1666667 0.091373 7.1694444 0.093043 7.1722222 0.091373 7.1750000 0.091373 7.1777778 0.094712 7.1805556 0.099722 7.1833333 0.101391 7.1861111 0.106401 7.1888889 0.104731 7.1916667 0.103061 7.1944444 0.096382 7.1972222 0.098052 7.2000000 0.094712 7.2027778 0.088033 7.2055556 0.086364 7.2083333 0.094712 7.2111111 0.098052 7.2138889 0.101391 7.2166667 0.106401 7.2194444 0.111410 7.2222222 0.108071 7.2250000 0.113080 7.2277778 0.111410 7.2305556 0.106401 7.2333333 0.099722 7.2361111 0.096382 7.2388889 0.093043 7.5722222 0.059647 7.5750000 0.056308 7.5777778 0.056308 7.5805556 0.064657 7.5833333 0.067996 7.5861111 0.067996 7.5888889 0.076345 7.5916667 0.071336 7.5944444 0.071336 7.5972222 0.067996 7.6000000 0.066327 7.6027778 0.061317 7.6055556 0.062987 7.6083333 0.056308 7.6111111 0.064657 7.6138889 0.066327 7.6166667 0.069666 7.6194444 0.071336 7.6222222 0.074675 7.6250000 0.074675 7.6277778 0.074675 7.6305556 0.076345 7.6333333 0.078015 7.6361111 0.079685 7.6388889 0.076345 7.6416667 0.081354 7.6444444 0.091373 7.6472222 0.094712 7.6500000 0.103061 7.6527778 0.106401 7.6555556 0.113080 7.6583333 0.113080 7.6611111 0.108071 7.6638889 0.101391 7.6666667 0.093043 7.6694444 0.084694 7.6722222 0.073006 7.6750000 0.067996 7.6777778 0.062987 7.6805556 0.066327 7.6833333 0.061317 7.6861111 0.061317 7.6888889 0.066327 7.6916667 0.054638 7.6944444 0.049629 7.6972222 0.052968 7.7000000 0.049629 7.7027778 0.054638 7.7055556 0.054638 7.7083333 0.052968 7.7111111 0.051299 7.7138889 0.057978 7.7166667 0.064657 7.7194444 0.062987 7.7222222 0.061317 7.7250000 0.056308 7.7277778 0.054638 7.7305556 0.051299 7.7333333 0.047959 7.7361111 0.042950 7.7388889 0.039610 7.7416667 0.044620 7.7444444 0.047959 7.7472222 0.051299 7.7500000 0.056308 7.7527778 0.052968 7.7555556 0.054638 7.7583333 0.049629 7.7611111 0.047959 7.7638889 0.054638 7.7666667 0.042950 7.7694444 0.044620 7.7722222 0.049629 7.7750000 0.041280 7.7777778 0.046289 7.7805556 0.056308 7.7833333 0.051299 7.7861111 0.057978 7.7888889 0.059647 7.7916667 0.073006 7.7944444 0.086364 7.7972222 0.094712 7.8000000 0.118089 7.8027778 0.121429 7.8055556 0.116419 7.8083333 0.098052 7.8111111 0.057978 7.8138889 0.010000 7.8166667 0.010000 7.8194444 0.010000 7.8222222 0.010000 7.8250000 0.010000 7.8277778 0.010000 7.8305556 0.010000 7.8333333 0.010000 7.8361111 0.010000 7.8388889 0.010000 7.8416667 0.010000 7.8444444 0.010000 7.8472222 0.010000 7.8500000 0.010000 7.8527778 0.010000 7.8555556 0.010000 7.8583333 0.010000 7.8611111 0.010000 7.8638889 0.010000 7.8666667 0.012894 7.8694444 0.022913 7.8722222 0.032931 7.8750000 0.042950 7.8777778 0.047959 7.8805556 0.052968 7.8833333 0.051299 7.8861111 0.064657 7.8888889 0.064657 7.8916667 0.066327 7.8944444 0.071336 7.8972222 0.071336 7.9000000 0.071336 7.9027778 0.069666 7.9055556 0.064657 7.9083333 0.067996 7.9111111 0.066327 7.9138889 0.069666 7.9166667 0.074675 7.9194444 0.076345 7.9222222 0.079685 7.9250000 0.081354 7.9277778 0.074675 7.9305556 0.078015 7.9333333 0.069666 7.9361111 0.066327 7.9388889 0.066327 7.9416667 0.071336 7.9444444 0.069666 7.9472222 0.069666 7.9500000 0.076345 7.9527778 0.083024 7.9555556 0.089703 7.9583333 0.084694 7.9611111 0.089703 7.9638889 0.084694 7.9666667 0.079685 7.9694444 0.074675 7.9722222 0.078015 7.9750000 0.079685 7.9777778 0.083024 7.9805556 0.079685 7.9833333 0.084694 7.9861111 0.088033 7.9888889 0.088033 7.9916667 0.091373 7.9944444 0.088033 7.9972222 0.081354 8.0000000 0.081354 8.0027778 0.078015 8.0055556 0.079685 8.0083333 0.079685 8.0111111 0.081354 8.0138889 0.088033 8.0166667 0.088033 8.0194444 0.091373 8.0222222 0.091373 8.0250000 0.091373 8.0277778 0.093043 8.0305556 0.089703 8.0333333 0.086364 8.0361111 0.084694 8.0388889 0.081354 8.0416667 0.083024 8.0444444 0.089703 8.0472222 0.089703 8.0500000 0.098052 8.0527778 0.093043 8.0555556 0.096382 8.0583333 0.098052 8.0611111 0.091373 8.0638889 0.081354 8.0666667 0.083024 8.0694444 0.083024 8.0722222 0.081354 8.0750000 0.081354 8.0777778 0.084694 8.0805556 0.084694 8.0833333 0.093043 8.0861111 0.099722 8.0888889 0.094712 8.0916667 0.093043 8.0944444 0.088033 8.0972222 0.084694 8.1000000 0.078015 8.1027778 0.074675 8.1055556 0.073006 8.1083333 0.074675 8.1111111 0.073006 8.1138889 0.076345 8.1166667 0.076345 8.1194444 0.074675 8.4333333 0.079685 8.4361111 0.076345 8.4388889 0.073006 8.4416667 0.079685 8.4444444 0.081354 8.4472222 0.086364 8.4500000 0.091373 8.4527778 0.091373 8.4555556 0.091373 8.4583333 0.089703 8.4611111 0.089703 8.4638889 0.083024 8.4666667 0.078015 8.4694444 0.078015 8.4722222 0.078015 8.4750000 0.078015 8.4777778 0.078015 8.4805556 0.084694 8.4833333 0.093043 8.4861111 0.096382 8.4888889 0.103061 8.4916667 0.111410 8.4944444 0.101391 8.4972222 0.106401 8.5000000 0.104731 8.5027778 0.104731 8.5055556 0.103061 8.5083333 0.106401 8.5111111 0.108071 8.5138889 0.111410 8.5166667 0.113080 8.5194444 0.111410 8.5222222 0.108071 8.5250000 0.096382 8.5277778 0.084694 8.5305556 0.078015 8.5333333 0.071336 8.5361111 0.069666 8.5388889 0.066327 8.5416667 0.064657 8.5444444 0.069666 8.5472222 0.074675 8.5500000 0.076345 8.5527778 0.076345 8.5555556 0.086364 8.5583333 0.089703 8.5611111 0.089703 8.5638889 0.081354 8.5666667 0.076345 8.5694444 0.071336 8.5722222 0.067996 8.5750000 0.067996 8.5777778 0.067996 8.5805556 0.069666 8.5833333 0.073006 8.5861111 0.081354 8.5888889 0.079685 8.5916667 0.079685 8.5944444 0.074675 8.5972222 0.066327 8.6000000 0.061317 8.6027778 0.056308 8.6055556 0.056308 8.6083333 0.056308 8.6111111 0.061317 8.6138889 0.067996 8.6166667 0.071336 8.6194444 0.074675 8.6222222 0.079685 8.6250000 0.078015 8.6277778 0.083024 8.6305556 0.076345 8.6333333 0.073006 8.6361111 0.067996 8.6388889 0.062987 8.6416667 0.069666 8.6444444 0.066327 8.6472222 0.073006 8.6500000 0.079685 8.6527778 0.091373 8.6555556 0.101391 8.6583333 0.121429 8.6611111 0.136456 8.6638889 0.146475 8.6666667 0.139796 8.6694444 0.116419 8.6722222 0.073006 8.6750000 0.026252 8.6777778 0.010000 8.6805556 0.010000 8.6833333 0.010000 8.6861111 0.010000 8.6888889 0.010000 8.6916667 0.010000 8.6944444 0.010000 8.6972222 0.010000 8.7000000 0.010000 8.7027778 0.010000 8.7055556 0.010000 8.7083333 0.010000 8.7111111 0.010000 8.7138889 0.010000 8.7166667 0.010000 8.7194444 0.010000 8.7222222 0.010000 8.7250000 0.010000 8.7277778 0.021243 8.7305556 0.037941 8.7333333 0.047959 8.7361111 0.051299 8.7388889 0.057978 8.7416667 0.057978 8.7444444 0.064657 8.7472222 0.076345 8.7500000 0.083024 8.7527778 0.091373 8.7555556 0.091373 8.7583333 0.094712 8.7611111 0.093043 8.7638889 0.088033 8.7666667 0.088033 8.7694444 0.083024 8.7722222 0.088033 8.7750000 0.086364 8.7777778 0.089703 8.7805556 0.093043 8.7833333 0.096382 8.7861111 0.099722 8.7888889 0.101391 8.7916667 0.098052 8.7944444 0.096382 8.7972222 0.096382 8.8000000 0.086364 8.8027778 0.086364 8.8055556 0.088033 8.8083333 0.089703 8.8111111 0.089703 8.8138889 0.096382 8.8166667 0.096382 8.8194444 0.101391 8.8222222 0.108071 8.8250000 0.103061 8.8277778 0.103061 8.8305556 0.099722 8.8333333 0.099722 8.8361111 0.093043 8.8388889 0.086364 8.8416667 0.086364 8.8444444 0.093043 8.8472222 0.096382 8.8500000 0.098052 8.8527778 0.103061 8.8555556 0.106401 8.8583333 0.104731 8.8611111 0.101391 8.8638889 0.098052 8.8666667 0.093043 8.8694444 0.091373 8.8722222 0.094712 8.8750000 0.093043 8.8777778 0.099722 8.8805556 0.104731 8.8833333 0.104731 8.8861111 0.108071 8.8888889 0.109740 8.8916667 0.106401 8.8944444 0.109740 8.8972222 0.103061 8.9000000 0.104731 8.9027778 0.103061 8.9055556 0.098052 8.9083333 0.099722 8.9111111 0.101391 8.9138889 0.104731 8.9166667 0.104731 8.9194444 0.109740 8.9222222 0.109740 8.9250000 0.111410 8.9277778 0.113080 8.9305556 0.108071 8.9333333 0.109740 8.9361111 0.098052 8.9388889 0.101391 8.9416667 0.104731 8.9444444 0.113080 8.9472222 0.111410 8.9500000 0.113080 8.9527778 0.114750 8.9555556 0.123098 8.9583333 0.118089 8.9611111 0.113080 8.9638889 0.106401 8.9666667 0.108071 8.9694444 0.103061 8.9722222 0.099722 8.9750000 0.098052 8.9777778 0.104731 8.9805556 0.101391 9.3611111 0.074675 9.3638889 0.073006 9.3666667 0.069666 9.3694444 0.069666 9.3722222 0.067996 9.3750000 0.061317 9.3777778 0.066327 9.3805556 0.067996 9.3833333 0.074675 9.3861111 0.084694 9.3888889 0.079685 9.3916667 0.081354 9.3944444 0.081354 9.3972222 0.083024 9.4000000 0.076345 9.4027778 0.081354 9.4055556 0.076345 9.4083333 0.071336 9.4111111 0.079685 9.4138889 0.088033 9.4166667 0.091373 9.4194444 0.096382 9.4222222 0.104731 9.4250000 0.101391 9.4277778 0.104731 9.4305556 0.098052 9.4333333 0.099722 9.4361111 0.094712 9.4388889 0.098052 9.4416667 0.099722 9.4444444 0.106401 9.4472222 0.113080 9.4500000 0.108071 9.4527778 0.101391 9.4555556 0.099722 9.4583333 0.091373 9.4611111 0.079685 9.4638889 0.071336 9.4666667 0.069666 9.4694444 0.064657 9.4722222 0.064657 9.4750000 0.056308 9.4777778 0.062987 9.4805556 0.061317 9.4833333 0.064657 9.4861111 0.064657 9.4888889 0.071336 9.4916667 0.073006 9.4944444 0.062987 9.4972222 0.059647 9.5000000 0.061317 9.5027778 0.051299 9.5055556 0.056308 9.5083333 0.051299 9.5111111 0.059647 9.5138889 0.054638 9.5166667 0.061317 9.5194444 0.069666 9.5222222 0.066327 9.5250000 0.064657 9.5277778 0.059647 9.5305556 0.062987 9.5333333 0.054638 9.5361111 0.054638 9.5388889 0.056308 9.5416667 0.049629 9.5444444 0.047959 9.5472222 0.057978 9.5500000 0.056308 9.5527778 0.062987 9.5555556 0.062987 9.5583333 0.061317 9.5611111 0.056308 9.5638889 0.057978 9.5666667 0.057978 9.5694444 0.054638 9.5722222 0.054638 9.5750000 0.059647 9.5777778 0.066327 9.5805556 0.074675 9.5833333 0.084694 9.5861111 0.106401 9.5888889 0.134787 9.5916667 0.141466 9.5944444 0.133117 9.5972222 0.116419 9.6000000 0.069666 9.6027778 0.016234 9.6055556 0.010000 9.6083333 0.010000 9.6111111 0.010000 9.6138889 0.010000 9.6166667 0.010000 9.6194444 0.010000 9.6222222 0.010000 9.6250000 0.010000 9.6277778 0.010000 9.6305556 0.010000 9.6333333 0.010000 9.6361111 0.010000 9.6388889 0.010000 9.6416667 0.010000 9.6444444 0.010000 9.6472222 0.010000 9.6500000 0.010000 9.6527778 0.026252 9.6555556 0.039610 9.6583333 0.054638 9.6611111 0.062987 9.6638889 0.057978 9.6666667 0.059647 9.6694444 0.061317 9.6722222 0.064657 9.6750000 0.062987 9.6777778 0.073006 9.6805556 0.078015 9.6833333 0.078015 9.6861111 0.088033 9.6888889 0.086364 9.6916667 0.094712 9.6944444 0.093043 9.6972222 0.093043 9.7000000 0.091373 9.7027778 0.086364 9.7055556 0.081354 9.7083333 0.083024 9.7111111 0.081354 9.7138889 0.089703 9.7166667 0.093043 9.7194444 0.094712 9.7222222 0.101391 9.7250000 0.099722 9.7277778 0.096382 9.7305556 0.094712 9.7333333 0.089703 9.7361111 0.086364 9.7388889 0.084694 9.7416667 0.088033 9.7444444 0.086364 9.7472222 0.091373 9.7500000 0.094712 9.7527778 0.099722 9.7555556 0.104731 9.7583333 0.106401 9.7611111 0.106401 9.7638889 0.104731 9.7666667 0.101391 9.7694444 0.101391 9.7722222 0.096382 9.7750000 0.093043 9.7777778 0.101391 9.7805556 0.098052 9.7833333 0.106401 9.7861111 0.108071 9.7888889 0.106401 9.7916667 0.109740 9.7944444 0.101391 9.7972222 0.104731 9.8000000 0.101391 9.8027778 0.094712 9.8055556 0.101391 9.8083333 0.098052 9.8111111 0.098052 9.8138889 0.099722 9.8166667 0.113080 9.8194444 0.118089 9.8222222 0.121429 9.8250000 0.114750 9.8277778 0.118089 9.8305556 0.109740 9.8333333 0.109740 9.8361111 0.106401 9.8388889 0.106401 9.8416667 0.099722 9.8444444 0.104731 9.8472222 0.108071 9.8500000 0.109740 9.8527778 0.116419 9.8555556 0.119759 9.8583333 0.119759 9.8611111 0.111410 9.8638889 0.111410 9.8666667 0.106401 9.8694444 0.106401 9.8722222 0.101391 9.8750000 0.101391 9.8777778 0.103061 9.8805556 0.109740 9.8833333 0.113080 9.8861111 0.109740 9.8888889 0.114750 9.8916667 0.106401 9.8944444 0.111410 9.8972222 0.101391 9.9000000 0.104731 9.9027778 0.091373 9.9055556 0.094712 9.9083333 0.093043 9.9111111 0.089703 9.9138889 0.091373 9.9166667 0.089703 9.9194444 0.094712 9.9222222 0.096382 9.9250000 0.099722 9.9277778 0.096382 9.9305556 0.096382 9.9333333 0.094712 9.9361111 0.094712 9.9388889 0.093043 9.9416667 0.093043 9.9444444 0.098052 9.9472222 0.101391 9.9500000 0.109740 9.9527778 0.113080 9.9555556 0.111410 9.9583333 0.111410 9.9611111 0.108071 9.9638889 0.096382 9.9666667 0.104731 9.9694444 0.094712 9.9722222 0.098052 9.9750000 0.094712 9.9777778 0.093043 9.9805556 0.093043 9.9833333 0.094712 9.9861111 0.096382 9.9888889 0.099722 9.9916667 0.098052 9.9944444 0.094712 9.9972222 0.094712 10.0000000 0.091373 10.0027778 0.093043 10.0055556 0.091373 10.0083333 0.084694 10.0111111 0.088033 10.0138889 0.093043 10.0166667 0.094712 10.0194444 0.096382 10.0222222 0.104731 10.0250000 0.099722 10.0277778 0.098052 10.0305556 0.098052 10.0333333 0.091373 10.0361111 0.093043 10.0388889 0.088033 10.0416667 0.083024 10.0444444 0.088033 10.0472222 0.086364 10.0500000 0.096382 10.0527778 0.094712 10.0555556 0.096382 10.0583333 0.094712 10.0611111 0.099722 10.0638889 0.094712 10.0666667 0.098052 10.0694444 0.099722 10.0722222 0.098052 10.0750000 0.099722 10.0777778 0.104731 10.0805556 0.111410 10.0833333 0.119759 10.0861111 0.128108 10.0888889 0.139796 10.0916667 0.151484 10.0944444 0.163173 10.0972222 0.169852 10.1000000 0.158163 10.1027778 0.133117 10.1055556 0.084694 10.1083333 0.031262 10.1111111 0.010000 10.1138889 0.010000 10.1166667 0.010000 10.1194444 0.010000 10.1222222 0.010000 10.1250000 0.010000 10.1277778 0.010000 10.1305556 0.010000 10.1333333 0.010000 10.1361111 0.010000 10.1388889 0.010000 10.1416667 0.010000 10.1444444 0.010000 10.1472222 0.010000 10.1500000 0.010000 10.1527778 0.010000 10.1555556 0.010000 10.1583333 0.010000 10.1611111 0.010000 10.1638889 0.010000 10.1666667 0.010000 10.1694444 0.010000 10.1722222 0.010000 10.1750000 0.010000 10.1777778 0.010000 10.1805556 0.010000 10.1833333 0.010000 10.1861111 0.010000 10.1888889 0.010000 10.1916667 0.010000 10.1944444 0.010000 10.1972222 0.010000 10.2000000 0.010000 10.2027778 0.010000 10.2055556 0.017904 10.2083333 0.054638 10.2111111 0.088033 10.2138889 0.104731 10.2166667 0.119759 10.2194444 0.126438 10.2222222 0.131447 10.2250000 0.133117 10.2277778 0.129777 10.2305556 0.138126 10.2333333 0.141466 10.2361111 0.138126 10.2388889 0.146475 10.2416667 0.148145 10.2444444 0.153154 10.2472222 0.159833 10.2500000 0.166512 10.2527778 0.173191 10.2555556 0.178200 10.2583333 0.183210 10.2611111 0.184879 10.2638889 0.181540 10.2666667 0.183210 10.2694444 0.183210 10.2722222 0.176531 10.2750000 0.186549 10.2777778 0.189889 10.2805556 0.194898 10.2833333 0.206586 10.2861111 0.211596 10.2888889 0.223284 10.2916667 0.226623 10.2944444 0.226623 10.2972222 0.231633 10.3000000 0.233302 10.3027778 0.231633 10.3055556 0.234972 10.3083333 0.238312 10.3111111 0.244991 10.3138889 0.256679 10.3166667 0.261688 10.3194444 0.261688 10.3222222 0.256679 10.3250000 0.255009 10.3277778 0.248330 10.3305556 0.243321 10.3333333 0.251670 10.3361111 0.248330 10.3388889 0.251670 10.3416667 0.261688 10.3444444 0.266698 10.3472222 0.273377 10.3500000 0.286735 10.3527778 0.293414 10.3555556 0.300093 10.3583333 0.310111 10.3611111 0.316790 10.3638889 0.315121 10.3666667 0.321800 10.3694444 0.333488 10.3722222 0.338497 10.3750000 0.340167 10.3777778 0.346846 10.3805556 0.361874 10.3833333 0.375232 10.3861111 0.380241 10.3888889 0.381911 10.3916667 0.390260 10.3944444 0.391929 10.3972222 0.393599 10.4000000 0.395269 10.4027778 0.386920 10.4055556 0.383581 10.4083333 0.381911 10.4111111 0.381911 10.4138889 0.381911 10.4166667 0.380241 10.4194444 0.381911 10.4222222 0.378571 10.4250000 0.373562 10.4277778 0.361874 10.4305556 0.358534 10.4333333 0.345176 10.4361111 0.338497 10.4388889 0.321800 11.1638889 0.091373 11.1666667 0.088033 11.1694444 0.081354 11.1722222 0.076345 11.1750000 0.084694 11.1777778 0.078015 11.1805556 0.084694 11.1833333 0.088033 11.1861111 0.086364 11.1888889 0.088033 11.1916667 0.094712 11.1944444 0.088033 11.1972222 0.086364 11.2000000 0.083024 11.2027778 0.083024 11.2055556 0.083024 11.2083333 0.078015 11.2111111 0.084694 11.2138889 0.089703 11.2166667 0.094712 11.2194444 0.101391 11.2222222 0.099722 11.2250000 0.101391 11.2277778 0.103061 11.2305556 0.098052 11.2333333 0.099722 11.2361111 0.099722 11.2388889 0.096382 11.2416667 0.103061 11.2444444 0.108071 11.2472222 0.106401 11.2500000 0.114750 11.2527778 0.116419 11.2555556 0.119759 11.2583333 0.121429 11.2611111 0.121429 11.2638889 0.121429 11.2666667 0.109740 11.2694444 0.099722 11.2722222 0.093043 11.2750000 0.086364 11.2777778 0.079685 11.2805556 0.081354 11.2833333 0.086364 11.2861111 0.086364 11.2888889 0.083024 11.2916667 0.086364 11.2944444 0.086364 11.2972222 0.076345 11.3000000 0.076345 11.3027778 0.076345 11.3055556 0.078015 11.3083333 0.073006 11.3111111 0.073006 11.3138889 0.073006 11.3166667 0.073006 11.3194444 0.074675 11.3222222 0.076345 11.3250000 0.073006 11.3277778 0.071336 11.3305556 0.073006 11.3333333 0.069666 11.3361111 0.071336 11.3388889 0.069666 11.3416667 0.066327 11.3444444 0.066327 11.3472222 0.073006 11.3500000 0.069666 11.3527778 0.073006 11.3555556 0.079685 11.3583333 0.076345 11.3611111 0.076345 11.3638889 0.078015 11.3666667 0.069666 11.3694444 0.071336 11.3722222 0.061317 11.3750000 0.067996 11.3777778 0.071336 11.3805556 0.079685 11.3833333 0.091373 11.3861111 0.113080 11.3888889 0.129777 11.3916667 0.144805 11.3944444 0.141466 11.3972222 0.128108 11.4000000 0.096382 11.4027778 0.049629 11.4055556 0.010000 11.4083333 0.010000 11.4111111 0.010000 11.4138889 0.010000 11.4166667 0.010000 11.4194444 0.010000 11.4222222 0.010000 11.4250000 0.010000 11.4277778 0.010000 11.4305556 0.010000 11.4333333 0.010000 11.4361111 0.010000 11.4388889 0.010000 11.4416667 0.010000 11.4444444 0.010000 11.4472222 0.010000 11.4500000 0.010000 11.4527778 0.010000 11.4555556 0.021243 11.4583333 0.044620 11.4611111 0.057978 11.4638889 0.067996 11.4666667 0.071336 11.4694444 0.071336 11.4722222 0.067996 11.4750000 0.071336 11.4777778 0.076345 11.4805556 0.078015 11.4833333 0.083024 11.4861111 0.091373 11.4888889 0.093043 11.4916667 0.093043 11.4944444 0.096382 11.4972222 0.096382 11.5000000 0.093043 11.5027778 0.089703 11.5055556 0.088033 11.5083333 0.088033 11.5111111 0.089703 11.5138889 0.093043 11.5166667 0.099722 11.5194444 0.096382 11.5222222 0.101391 11.5250000 0.101391 11.5277778 0.099722 11.5305556 0.101391 11.5333333 0.099722 11.5361111 0.096382 11.5388889 0.089703 11.5416667 0.093043 11.5444444 0.096382 11.5472222 0.099722 11.5500000 0.099722 11.5527778 0.106401 11.5555556 0.109740 11.5583333 0.106401 11.5611111 0.109740 11.5638889 0.109740 11.5666667 0.103061 11.5694444 0.101391 11.5722222 0.096382 11.5750000 0.094712 11.5777778 0.101391 11.5805556 0.108071 11.5833333 0.109740 11.5861111 0.114750 11.5888889 0.116419 11.5916667 0.118089 11.5944444 0.119759 11.5972222 0.123098 11.6000000 0.119759 11.6027778 0.113080 11.6055556 0.113080 11.6083333 0.104731 11.6111111 0.114750 11.6138889 0.118089 11.6166667 0.119759 11.6194444 0.119759 11.6222222 0.126438 11.6250000 0.124768 11.6277778 0.119759 11.6305556 0.119759 11.6333333 0.116419 11.6361111 0.119759 11.6388889 0.113080 11.6416667 0.118089 11.6444444 0.114750 11.6472222 0.124768 11.6500000 0.126438 11.6527778 0.133117 11.6555556 0.138126 11.6583333 0.138126 11.6611111 0.134787 11.6638889 0.136456 11.6666667 0.136456 11.6694444 0.131447 11.6722222 0.126438 11.6750000 0.128108 11.6777778 0.134787 11.6805556 0.134787 11.6833333 0.134787 11.6861111 0.133117 11.6888889 0.136456 11.6916667 0.136456 11.6944444 0.134787 11.6972222 0.131447 11.7000000 0.123098 11.7027778 0.121429 11.7055556 0.118089 11.7083333 0.118089 11.7111111 0.119759 12.0888889 0.098052 12.0916667 0.093043 12.0944444 0.089703 12.0972222 0.091373 12.1000000 0.084694 12.1027778 0.079685 12.1055556 0.079685 12.1083333 0.078015 12.1111111 0.079685 12.1138889 0.079685 12.1166667 0.083024 12.1194444 0.083024 12.1222222 0.086364 12.1250000 0.086364 12.1277778 0.086364 12.1305556 0.083024 12.1333333 0.081354 12.1361111 0.081354 12.1388889 0.078015 12.1416667 0.081354 12.1444444 0.086364 12.1472222 0.091373 12.1500000 0.103061 12.1527778 0.104731 12.1555556 0.111410 12.1583333 0.114750 12.1611111 0.113080 12.1638889 0.116419 12.1666667 0.114750 12.1694444 0.113080 12.1722222 0.111410 12.1750000 0.109740 12.1777778 0.111410 12.1805556 0.101391 12.1833333 0.101391 12.1861111 0.099722 12.1888889 0.094712 12.1916667 0.089703 12.1944444 0.084694 12.1972222 0.083024 12.2000000 0.081354 12.2027778 0.076345 12.2055556 0.069666 12.2083333 0.066327 12.2111111 0.066327 12.2138889 0.064657 12.2166667 0.069666 12.2194444 0.078015 12.2222222 0.084694 12.2250000 0.076345 12.2277778 0.079685 12.2305556 0.074675 12.2333333 0.069666 12.2361111 0.061317 12.2388889 0.057978 12.2416667 0.056308 12.2444444 0.056308 12.2472222 0.059647 12.2500000 0.062987 12.2527778 0.064657 12.2555556 0.071336 12.2583333 0.074675 12.2611111 0.073006 12.2638889 0.076345 12.2666667 0.071336 12.2694444 0.067996 12.2722222 0.061317 12.2750000 0.061317 12.2777778 0.061317 12.2805556 0.064657 12.2833333 0.073006 12.2861111 0.073006 12.2888889 0.073006 12.2916667 0.074675 12.2944444 0.067996 12.2972222 0.073006 12.3000000 0.066327 12.3027778 0.067996 12.3055556 0.062987 12.3083333 0.069666 12.3111111 0.086364 12.3138889 0.096382 12.3166667 0.124768 12.3194444 0.143135 12.3222222 0.146475 12.3250000 0.133117 12.3277778 0.098052 12.3305556 0.046289 12.3333333 0.010000 12.3361111 0.010000 12.3388889 0.010000 12.3416667 0.010000 12.3444444 0.010000 12.3472222 0.010000 12.3500000 0.010000 12.3527778 0.010000 12.3555556 0.010000 12.3583333 0.010000 12.3611111 0.010000 12.3638889 0.010000 12.3666667 0.010000 12.3694444 0.010000 12.3722222 0.010000 12.3750000 0.010000 12.3777778 0.010000 12.3805556 0.012894 12.3833333 0.039610 12.3861111 0.054638 12.3888889 0.071336 12.3916667 0.079685 12.3944444 0.079685 12.3972222 0.081354 12.4000000 0.078015 12.4027778 0.081354 12.4055556 0.076345 12.4083333 0.079685 12.4111111 0.083024 12.4138889 0.086364 12.4166667 0.093043 12.4194444 0.093043 12.4222222 0.099722 12.4250000 0.096382 12.4277778 0.096382 12.4305556 0.096382 12.4333333 0.094712 12.4361111 0.099722 12.4388889 0.089703 12.4416667 0.094712 12.4444444 0.093043 12.4472222 0.101391 12.4500000 0.101391 12.4527778 0.104731 12.4555556 0.108071 12.4583333 0.111410 12.4611111 0.108071 12.4638889 0.109740 12.4666667 0.104731 12.4694444 0.101391 12.4722222 0.096382 12.4750000 0.094712 12.4777778 0.099722 12.4805556 0.098052 12.4833333 0.101391 12.4861111 0.103061 12.4888889 0.109740 12.4916667 0.109740 12.4944444 0.109740 12.4972222 0.111410 12.5000000 0.103061 12.5027778 0.106401 12.5055556 0.104731 12.5083333 0.108071 12.5111111 0.106401 12.5138889 0.108071 12.5166667 0.111410 12.5194444 0.113080 12.5222222 0.114750 12.5250000 0.114750 12.5277778 0.114750 12.5305556 0.116419 12.5333333 0.109740 12.5361111 0.108071 12.5388889 0.108071 12.5416667 0.103061 12.5444444 0.106401 12.5472222 0.106401 12.5500000 0.109740 12.5527778 0.111410 12.5555556 0.114750 12.5583333 0.118089 12.5611111 0.118089 12.5638889 0.118089 12.5666667 0.116419 12.5694444 0.114750 12.5722222 0.109740 12.5750000 0.104731 12.5777778 0.108071 12.5805556 0.108071 12.5833333 0.109740 12.5861111 0.116419 12.5888889 0.113080 12.5916667 0.119759 12.5944444 0.116419 12.5972222 0.111410 12.6000000 0.106401 12.6027778 0.103061 12.6055556 0.098052 12.6083333 0.098052 12.6111111 0.098052 12.6138889 0.094712 12.6166667 0.099722 12.6194444 0.103061 12.6222222 0.108071 12.6250000 0.108071 12.6277778 0.104731 12.6305556 0.104731 12.6333333 0.099722 12.6361111 0.098052 12.9583333 0.099722 12.9611111 0.101391 12.9638889 0.094712 12.9666667 0.091373 12.9694444 0.091373 12.9722222 0.081354 12.9750000 0.084694 12.9777778 0.084694 12.9805556 0.088033 12.9833333 0.094712 12.9861111 0.098052 12.9888889 0.101391 12.9916667 0.103061 12.9944444 0.104731 12.9972222 0.106401 13.0000000 0.101391 13.0027778 0.098052 13.0055556 0.096382 13.0083333 0.091373 13.0111111 0.096382 13.0138889 0.106401 13.0166667 0.111410 13.0194444 0.109740 13.0222222 0.121429 13.0250000 0.121429 13.0277778 0.121429 13.0305556 0.113080 13.0333333 0.118089 13.0361111 0.114750 13.0388889 0.118089 13.0416667 0.114750 13.0444444 0.118089 13.0472222 0.118089 13.0500000 0.116419 13.0527778 0.118089 13.0555556 0.109740 13.0583333 0.108071 13.0611111 0.101391 13.0638889 0.094712 13.0666667 0.084694 13.0694444 0.083024 13.0722222 0.079685 13.0750000 0.074675 13.0777778 0.071336 13.0805556 0.076345 13.0833333 0.078015 13.0861111 0.078015 13.0888889 0.086364 13.0916667 0.091373 13.0944444 0.089703 13.0972222 0.084694 13.1000000 0.084694 13.1027778 0.078015 13.1055556 0.074675 13.1083333 0.078015 13.1111111 0.073006 13.1138889 0.074675 13.1166667 0.078015 13.1194444 0.081354 13.1222222 0.084694 13.1250000 0.084694 13.1277778 0.084694 13.1305556 0.083024 13.1333333 0.078015 13.1361111 0.081354 13.1388889 0.076345 13.1416667 0.071336 13.1444444 0.066327 13.1472222 0.071336 13.1500000 0.073006 13.1527778 0.076345 13.1555556 0.081354 13.1583333 0.081354 13.1611111 0.078015 13.1638889 0.079685 13.1666667 0.081354 13.1694444 0.083024 13.1722222 0.078015 13.1750000 0.081354 13.1777778 0.093043 13.1805556 0.104731 13.1833333 0.121429 13.1861111 0.141466 13.1888889 0.153154 13.1916667 0.144805 13.1944444 0.124768 13.1972222 0.089703 13.2000000 0.039610 13.2027778 0.010000 13.2055556 0.010000 13.2083333 0.010000 13.2111111 0.010000 13.2138889 0.010000 13.2166667 0.010000 13.2194444 0.010000 13.2222222 0.010000 13.2250000 0.010000 13.2277778 0.010000 13.2305556 0.010000 13.2333333 0.010000 13.2361111 0.010000 13.2388889 0.010000 13.2416667 0.010000 13.2444444 0.010000 13.2472222 0.010000 13.2500000 0.026252 13.2527778 0.046289 13.2555556 0.064657 13.2583333 0.078015 13.2611111 0.079685 13.2638889 0.076345 13.2666667 0.076345 13.2694444 0.074675 13.2722222 0.074675 13.2750000 0.073006 13.2777778 0.074675 13.2805556 0.078015 13.2833333 0.084694 13.2861111 0.089703 13.2888889 0.098052 13.2916667 0.098052 13.2944444 0.101391 13.2972222 0.098052 13.3000000 0.098052 13.3027778 0.093043 13.3055556 0.094712 13.3083333 0.089703 13.3111111 0.093043 13.3138889 0.088033 13.3166667 0.089703 13.3194444 0.098052 13.3222222 0.098052 13.3250000 0.104731 13.3277778 0.104731 13.3305556 0.104731 13.3333333 0.098052 13.3361111 0.096382 13.3388889 0.094712 13.3416667 0.093043 13.3444444 0.091373 13.3472222 0.094712 13.3500000 0.101391 13.3527778 0.109740 13.3555556 0.113080 13.3583333 0.118089 13.3611111 0.113080 13.3638889 0.111410 13.3666667 0.106401 13.3694444 0.101391 13.3722222 0.106401 13.3750000 0.099722 13.3777778 0.101391 13.3805556 0.103061 13.3833333 0.106401 13.3861111 0.113080 13.3888889 0.113080 13.3916667 0.114750 13.3944444 0.111410 13.3972222 0.111410 13.4000000 0.111410 13.4027778 0.108071 13.4055556 0.106401 13.4083333 0.103061 13.4111111 0.101391 13.4138889 0.106401 13.4166667 0.111410 13.4194444 0.116419 13.4222222 0.123098 13.4250000 0.123098 13.4277778 0.119759 13.4305556 0.118089 13.4333333 0.111410 13.4361111 0.116419 13.4388889 0.113080 13.4416667 0.113080 13.4444444 0.109740 13.4472222 0.114750 13.4500000 0.113080 13.4527778 0.116419 13.4555556 0.118089 13.4583333 0.118089 13.4611111 0.114750 13.4638889 0.111410 13.4666667 0.118089 13.4694444 0.108071 13.4722222 0.104731 13.4750000 0.106401 13.4777778 0.106401 13.4805556 0.106401 13.4833333 0.108071 13.4861111 0.114750 13.4888889 0.118089 13.4916667 0.119759 13.4944444 0.114750 13.4972222 0.109740 13.5000000 0.109740 13.5027778 0.104731 13.5055556 0.108071 13.8750000 0.078015 13.8777778 0.078015 13.8805556 0.079685 13.8833333 0.079685 13.8861111 0.084694 13.8888889 0.084694 13.8916667 0.086364 13.8944444 0.089703 13.8972222 0.086364 13.9000000 0.086364 13.9027778 0.078015 13.9055556 0.078015 13.9083333 0.078015 13.9111111 0.076345 13.9138889 0.083024 13.9166667 0.091373 13.9194444 0.096382 13.9222222 0.104731 13.9250000 0.108071 13.9277778 0.108071 13.9305556 0.108071 13.9333333 0.108071 13.9361111 0.113080 13.9388889 0.106401 13.9416667 0.108071 13.9444444 0.111410 13.9472222 0.113080 13.9500000 0.114750 13.9527778 0.116419 13.9555556 0.118089 13.9583333 0.111410 13.9611111 0.099722 13.9638889 0.089703 13.9666667 0.081354 13.9694444 0.074675 13.9722222 0.071336 13.9750000 0.069666 13.9777778 0.076345 13.9805556 0.071336 13.9833333 0.073006 13.9861111 0.073006 13.9888889 0.076345 13.9916667 0.078015 13.9944444 0.073006 13.9972222 0.076345 14.0000000 0.073006 14.0027778 0.074675 14.0055556 0.069666 14.0083333 0.071336 14.0111111 0.064657 14.0138889 0.064657 14.0166667 0.067996 14.0194444 0.071336 14.0222222 0.069666 14.0250000 0.076345 14.0277778 0.071336 14.0305556 0.069666 14.0333333 0.064657 14.0361111 0.064657 14.0388889 0.061317 14.0416667 0.064657 14.0444444 0.066327 14.0472222 0.062987 14.0500000 0.069666 14.0527778 0.069666 14.0555556 0.071336 14.0583333 0.071336 14.0611111 0.074675 14.0638889 0.074675 14.0666667 0.066327 14.0694444 0.066327 14.0722222 0.064657 14.0750000 0.067996 14.0777778 0.062987 14.0805556 0.066327 14.0833333 0.062987 14.0861111 0.066327 14.0888889 0.073006 14.0916667 0.081354 14.0944444 0.093043 14.0972222 0.103061 14.1000000 0.123098 14.1027778 0.138126 14.1055556 0.141466 14.1083333 0.134787 14.1111111 0.101391 14.1138889 0.057978 14.1166667 0.010000 14.1194444 0.010000 14.1222222 0.010000 14.1250000 0.010000 14.1277778 0.010000 14.1305556 0.010000 14.1333333 0.010000 14.1361111 0.010000 14.1388889 0.010000 14.1416667 0.010000 14.1444444 0.010000 14.1472222 0.010000 14.1500000 0.010000 14.1527778 0.010000 14.1555556 0.010000 14.1583333 0.010000 14.1611111 0.010000 14.1638889 0.012894 14.1666667 0.027922 14.1694444 0.044620 14.1722222 0.056308 14.1750000 0.061317 14.1777778 0.066327 14.1805556 0.066327 14.1833333 0.071336 14.1861111 0.079685 14.1888889 0.081354 14.1916667 0.088033 14.1944444 0.088033 14.1972222 0.084694 14.2000000 0.083024 14.2027778 0.088033 14.2055556 0.083024 14.2083333 0.083024 14.2111111 0.079685 14.2138889 0.079685 14.2166667 0.088033 14.2194444 0.086364 14.2222222 0.091373 14.2250000 0.094712 14.2277778 0.094712 14.2305556 0.094712 14.2333333 0.093043 14.2361111 0.089703 14.2388889 0.086364 14.2416667 0.084694 14.2444444 0.088033 14.2472222 0.091373 14.2500000 0.093043 14.2527778 0.096382 14.2555556 0.098052 14.2583333 0.104731 14.2611111 0.099722 14.2638889 0.096382 14.2666667 0.101391 14.2694444 0.096382 14.2722222 0.096382 14.2750000 0.088033 14.2777778 0.089703 14.2805556 0.084694 14.2833333 0.096382 14.2861111 0.091373 14.2888889 0.101391 14.2916667 0.109740 14.2944444 0.104731 14.2972222 0.103061 14.3000000 0.106401 14.3027778 0.104731 14.3055556 0.103061 14.3083333 0.094712 14.3111111 0.096382 14.3138889 0.098052 14.3166667 0.098052 14.3194444 0.103061 14.3222222 0.106401 14.3250000 0.108071 14.3277778 0.109740 14.3305556 0.111410 14.3333333 0.104731 14.3361111 0.104731 14.3388889 0.099722 14.3416667 0.101391 14.3444444 0.098052 14.3472222 0.104731 14.3500000 0.108071 14.3527778 0.109740 14.3555556 0.118089 14.3583333 0.126438 14.3611111 0.123098 14.3638889 0.124768 14.3666667 0.116419 14.3694444 0.116419 14.3722222 0.113080 14.3750000 0.108071 14.3777778 0.111410 14.3805556 0.111410 14.3833333 0.116419 14.3861111 0.123098 14.3888889 0.118089 14.3916667 0.123098 14.3944444 0.118089 14.3972222 0.114750 14.4000000 0.111410 14.4027778 0.106401 14.4055556 0.108071 14.4083333 0.104731 14.4111111 0.103061 14.4138889 0.103061 14.4166667 0.114750 14.4194444 0.113080 14.4222222 0.113080 14.7861111 0.064657 14.7888889 0.076345 14.7916667 0.079685 14.7944444 0.079685 14.7972222 0.074675 14.8000000 0.076345 14.8027778 0.071336 14.8055556 0.067996 14.8083333 0.066327 14.8111111 0.066327 14.8138889 0.066327 14.8166667 0.073006 14.8194444 0.074675 14.8222222 0.074675 14.8250000 0.074675 14.8277778 0.078015 14.8305556 0.076345 14.8333333 0.081354 14.8361111 0.081354 14.8388889 0.084694 14.8416667 0.081354 14.8444444 0.084694 14.8472222 0.094712 14.8500000 0.098052 14.8527778 0.104731 14.8555556 0.113080 14.8583333 0.118089 14.8611111 0.114750 14.8638889 0.114750 14.8666667 0.111410 14.8694444 0.103061 14.8722222 0.094712 14.8750000 0.084694 14.8777778 0.076345 14.8805556 0.071336 14.8833333 0.071336 14.8861111 0.062987 14.8888889 0.059647 14.8916667 0.067996 14.8944444 0.067996 14.8972222 0.062987 14.9000000 0.064657 14.9027778 0.059647 14.9055556 0.054638 14.9083333 0.057978 14.9111111 0.054638 14.9138889 0.062987 14.9166667 0.064657 14.9194444 0.069666 14.9222222 0.064657 14.9250000 0.071336 14.9277778 0.064657 14.9305556 0.057978 14.9333333 0.059647 14.9361111 0.051299 14.9388889 0.051299 14.9416667 0.044620 14.9444444 0.044620 14.9472222 0.046289 14.9500000 0.051299 14.9527778 0.052968 14.9555556 0.056308 14.9583333 0.061317 14.9611111 0.064657 14.9638889 0.066327 14.9666667 0.064657 14.9694444 0.061317 14.9722222 0.052968 14.9750000 0.052968 14.9777778 0.054638 14.9805556 0.059647 14.9833333 0.057978 14.9861111 0.057978 14.9888889 0.061317 14.9916667 0.067996 14.9944444 0.064657 14.9972222 0.067996 15.0000000 0.066327 15.0027778 0.071336 15.0055556 0.078015 15.0083333 0.088033 15.0111111 0.106401 15.0138889 0.121429 15.0166667 0.131447 15.0194444 0.121429 15.0222222 0.103061 15.0250000 0.062987 15.0277778 0.010000 15.0305556 0.010000 15.0333333 0.010000 15.0361111 0.010000 15.0388889 0.010000 15.0416667 0.010000 15.0444444 0.010000 15.0472222 0.010000 15.0500000 0.010000 15.0527778 0.010000 15.0555556 0.010000 15.0583333 0.010000 15.0611111 0.010000 15.0638889 0.010000 15.0666667 0.010000 15.0694444 0.010000 15.0722222 0.010000 15.0750000 0.010000 15.0777778 0.010000 15.0805556 0.024583 15.0833333 0.037941 15.0861111 0.052968 15.0888889 0.064657 15.0916667 0.069666 15.0944444 0.074675 15.0972222 0.076345 15.1000000 0.071336 15.1027778 0.078015 15.1055556 0.074675 15.1083333 0.073006 15.1111111 0.074675 15.1138889 0.079685 15.1166667 0.076345 15.1194444 0.081354 15.1222222 0.086364 15.1250000 0.089703 15.1277778 0.089703 15.1305556 0.089703 15.1333333 0.084694 15.1361111 0.079685 15.1388889 0.079685 15.1416667 0.076345 15.1444444 0.076345 15.1472222 0.079685 15.1500000 0.088033 15.1527778 0.088033 15.1555556 0.098052 15.1583333 0.098052 15.1611111 0.096382 15.1638889 0.096382 15.1666667 0.093043 15.1694444 0.088033 15.1722222 0.086364 15.1750000 0.074675 15.1777778 0.081354 15.1805556 0.078015 15.1833333 0.079685 15.1861111 0.083024 15.1888889 0.081354 15.1916667 0.086364 15.1944444 0.094712 15.1972222 0.091373 15.2000000 0.089703 15.2027778 0.086364 15.2055556 0.089703 15.2083333 0.088033 15.2111111 0.086364 15.2138889 0.093043 15.2166667 0.088033 15.2194444 0.093043 15.2222222 0.099722 15.2250000 0.101391 15.2277778 0.103061 15.2305556 0.099722 15.2333333 0.096382 15.2361111 0.093043 15.2388889 0.093043 15.2416667 0.091373 15.2444444 0.084694 15.2472222 0.086364 15.2500000 0.089703 15.2527778 0.096382 15.2555556 0.096382 15.2583333 0.099722 15.2611111 0.098052 15.2638889 0.104731 15.2666667 0.098052 15.2694444 0.096382 15.2722222 0.098052 15.2750000 0.091373 15.2777778 0.088033 15.2805556 0.091373 15.2833333 0.091373 15.2861111 0.099722 15.2888889 0.093043 15.2916667 0.094712 15.2944444 0.094712 15.2972222 0.088033 15.3000000 0.089703 15.3027778 0.084694 15.3055556 0.084694 15.3083333 0.079685 15.3111111 0.071336 15.3138889 0.074675 15.3166667 0.074675 15.3194444 0.073006 15.3222222 0.078015 15.3250000 0.083024 15.3277778 0.086364 15.3305556 0.084694 15.3333333 0.084694 15.6500000 0.081354 15.6527778 0.084694 15.6555556 0.091373 15.6583333 0.094712 15.6611111 0.091373 15.6638889 0.086364 15.6666667 0.088033 15.6694444 0.086364 15.6722222 0.079685 15.6750000 0.074675 15.6777778 0.079685 15.6805556 0.079685 15.6833333 0.081354 15.6861111 0.088033 15.6888889 0.091373 15.6916667 0.094712 15.6944444 0.096382 15.6972222 0.099722 15.7000000 0.101391 15.7027778 0.094712 15.7055556 0.098052 15.7083333 0.096382 15.7111111 0.101391 15.7138889 0.096382 15.7166667 0.104731 15.7194444 0.114750 15.7222222 0.109740 15.7250000 0.119759 15.7277778 0.118089 15.7305556 0.116419 15.7333333 0.116419 15.7361111 0.103061 15.7388889 0.093043 15.7416667 0.083024 15.7444444 0.076345 15.7472222 0.069666 15.7500000 0.076345 15.7527778 0.073006 15.7555556 0.079685 15.7583333 0.079685 15.7611111 0.079685 15.7638889 0.078015 15.7666667 0.076345 15.7694444 0.076345 15.7722222 0.069666 15.7750000 0.074675 15.7777778 0.069666 15.7805556 0.067996 15.7833333 0.074675 15.7861111 0.069666 15.7888889 0.073006 15.7916667 0.074675 15.7944444 0.074675 15.7972222 0.071336 15.8000000 0.076345 15.8027778 0.064657 15.8055556 0.064657 15.8083333 0.061317 15.8111111 0.064657 15.8138889 0.067996 15.8166667 0.069666 15.8194444 0.069666 15.8222222 0.081354 15.8250000 0.076345 15.8277778 0.079685 15.8305556 0.079685 15.8333333 0.076345 15.8361111 0.074675 15.8388889 0.069666 15.8416667 0.066327 15.8444444 0.061317 15.8472222 0.062987 15.8500000 0.064657 15.8527778 0.067996 15.8555556 0.066327 15.8583333 0.071336 15.8611111 0.074675 15.8638889 0.083024 15.8666667 0.088033 15.8694444 0.096382 15.8722222 0.106401 15.8750000 0.118089 15.8777778 0.133117 15.8805556 0.143135 15.8833333 0.133117 15.8861111 0.109740 15.8888889 0.074675 15.8916667 0.026252 15.8944444 0.010000 15.8972222 0.010000 15.9000000 0.010000 15.9027778 0.010000 15.9055556 0.010000 15.9083333 0.010000 15.9111111 0.010000 15.9138889 0.010000 15.9166667 0.010000 15.9194444 0.010000 15.9222222 0.010000 15.9250000 0.010000 15.9277778 0.010000 15.9305556 0.010000 15.9333333 0.010000 15.9361111 0.010000 15.9388889 0.010000 15.9416667 0.016234 15.9444444 0.031262 15.9472222 0.054638 15.9500000 0.066327 15.9527778 0.074675 15.9555556 0.076345 15.9583333 0.083024 15.9611111 0.084694 15.9638889 0.084694 15.9666667 0.089703 15.9694444 0.078015 15.9722222 0.088033 15.9750000 0.083024 15.9777778 0.081354 15.9805556 0.083024 15.9833333 0.083024 15.9861111 0.094712 15.9888889 0.091373 15.9916667 0.099722 15.9944444 0.101391 15.9972222 0.099722 16.0000000 0.103061 16.0027778 0.098052 16.0055556 0.096382 16.0083333 0.098052 16.0111111 0.091373 16.0138889 0.093043 16.0166667 0.096382 16.0194444 0.101391 16.0222222 0.101391 16.0250000 0.104731 16.0277778 0.099722 16.0305556 0.101391 16.0333333 0.101391 16.0361111 0.094712 16.0388889 0.094712 16.0416667 0.086364 16.0444444 0.086364 16.0472222 0.084694 16.0500000 0.088033 16.0527778 0.091373 16.0555556 0.094712 16.0583333 0.104731 16.0611111 0.104731 16.0638889 0.104731 16.0666667 0.103061 16.0694444 0.103061 16.0722222 0.099722 16.0750000 0.094712 16.0777778 0.093043 16.0805556 0.091373 16.0833333 0.088033 16.0861111 0.098052 16.0888889 0.101391 16.0916667 0.104731 16.0944444 0.104731 16.0972222 0.103061 16.1000000 0.098052 16.1027778 0.093043 16.1055556 0.093043 16.1083333 0.088033 16.1111111 0.091373 16.1138889 0.083024 16.1166667 0.089703 16.1194444 0.091373 16.1222222 0.096382 16.1250000 0.099722 16.1277778 0.101391 16.1305556 0.101391 16.1333333 0.104731 16.1361111 0.098052 16.1388889 0.099722 16.1416667 0.089703 16.1444444 0.088033 16.1472222 0.089703 16.1500000 0.098052 16.1527778 0.098052 16.1555556 0.101391 16.1583333 0.104731 16.1611111 0.103061 16.1638889 0.103061 16.1666667 0.098052 16.1694444 0.093043 16.1722222 0.094712 16.1750000 0.094712 16.1777778 0.091373 16.1805556 0.089703 16.1833333 0.098052 16.1861111 0.099722 16.1888889 0.099722 16.1916667 0.096382 16.1944444 0.104731 16.1972222 0.099722 16.6027778 0.074675 16.6055556 0.071336 16.6083333 0.067996 16.6111111 0.064657 16.6138889 0.062987 16.6166667 0.067996 16.6194444 0.066327 16.6222222 0.071336 16.6250000 0.069666 16.6277778 0.074675 16.6305556 0.073006 16.6333333 0.076345 16.6361111 0.069666 16.6388889 0.067996 16.6416667 0.069666 16.6444444 0.069666 16.6472222 0.069666 16.6500000 0.071336 16.6527778 0.074675 16.6555556 0.081354 16.6583333 0.094712 16.6611111 0.088033 16.6638889 0.088033 16.6666667 0.093043 16.6694444 0.089703 16.6722222 0.091373 16.6750000 0.093043 16.6777778 0.093043 16.6805556 0.098052 16.6833333 0.099722 16.6861111 0.103061 16.6888889 0.106401 16.6916667 0.103061 16.6944444 0.103061 16.6972222 0.091373 16.7000000 0.083024 16.7027778 0.069666 16.7055556 0.061317 16.7083333 0.052968 16.7111111 0.052968 16.7138889 0.047959 16.7166667 0.049629 16.7194444 0.054638 16.7222222 0.049629 16.7250000 0.054638 16.7277778 0.059647 16.7305556 0.062987 16.7333333 0.054638 16.7361111 0.054638 16.7388889 0.049629 16.7416667 0.046289 16.7444444 0.042950 16.7472222 0.044620 16.7500000 0.041280 16.7527778 0.049629 16.7555556 0.051299 16.7583333 0.052968 16.7611111 0.062987 16.7638889 0.057978 16.7666667 0.056308 16.7694444 0.057978 16.7722222 0.052968 16.7750000 0.046289 16.7777778 0.044620 16.7805556 0.046289 16.7833333 0.047959 16.7861111 0.051299 16.7888889 0.056308 16.7916667 0.061317 16.7944444 0.061317 16.7972222 0.056308 16.8000000 0.054638 16.8027778 0.054638 16.8055556 0.047959 16.8083333 0.042950 16.8111111 0.044620 16.8138889 0.042950 16.8166667 0.046289 16.8194444 0.057978 16.8222222 0.061317 16.8250000 0.084694 16.8277778 0.108071 16.8305556 0.123098 16.8333333 0.134787 16.8361111 0.129777 16.8388889 0.099722 16.8416667 0.047959 16.8444444 0.010000 16.8472222 0.010000 16.8500000 0.010000 16.8527778 0.010000 16.8555556 0.010000 16.8583333 0.010000 16.8611111 0.010000 16.8638889 0.010000 16.8666667 0.010000 16.8694444 0.010000 16.8722222 0.010000 16.8750000 0.010000 16.8777778 0.010000 16.8805556 0.010000 16.8833333 0.010000 16.8861111 0.010000 16.8888889 0.010000 16.8916667 0.010000 16.8944444 0.019573 16.8972222 0.034601 16.9000000 0.046289 16.9027778 0.047959 16.9055556 0.057978 16.9083333 0.052968 16.9111111 0.056308 16.9138889 0.049629 16.9166667 0.059647 16.9194444 0.066327 16.9222222 0.069666 16.9250000 0.078015 16.9277778 0.076345 16.9305556 0.078015 16.9333333 0.076345 16.9361111 0.076345 16.9388889 0.073006 16.9416667 0.071336 16.9444444 0.074675 16.9472222 0.074675 16.9500000 0.079685 16.9527778 0.079685 16.9555556 0.084694 16.9583333 0.091373 16.9611111 0.094712 16.9638889 0.094712 16.9666667 0.091373 16.9694444 0.081354 16.9722222 0.076345 16.9750000 0.079685 16.9777778 0.079685 16.9805556 0.078015 16.9833333 0.083024 16.9861111 0.084694 16.9888889 0.091373 16.9916667 0.091373 16.9944444 0.093043 16.9972222 0.089703 17.0000000 0.091373 17.0027778 0.083024 17.0055556 0.086364 17.0083333 0.079685 17.0111111 0.084694 17.0138889 0.086364 17.0166667 0.086364 17.0194444 0.089703 17.0222222 0.091373 17.0250000 0.096382 17.0277778 0.096382 17.0305556 0.094712 17.0333333 0.096382 17.0361111 0.094712 17.0388889 0.086364 17.0416667 0.084694 17.0444444 0.083024 17.0472222 0.084694 17.0500000 0.088033 17.0527778 0.089703 17.0555556 0.086364 17.0583333 0.094712 17.0611111 0.096382 17.0638889 0.099722 17.0666667 0.094712 17.0694444 0.098052 17.0722222 0.096382 17.0750000 0.093043 17.0777778 0.099722 17.0805556 0.094712 17.0833333 0.096382 17.0861111 0.104731 17.0888889 0.104731 17.0916667 0.103061 17.0944444 0.106401 17.0972222 0.106401 17.1000000 0.099722 17.1027778 0.096382 17.1055556 0.096382 17.1083333 0.093043 17.1111111 0.091373 17.1138889 0.084694 17.1166667 0.086364 17.1194444 0.091373 17.1222222 0.099722 17.1250000 0.101391 17.1277778 0.098052 17.1305556 0.096382 17.1333333 0.098052 17.1361111 0.094712 17.1388889 0.089703 17.1416667 0.094712 17.1444444 0.089703 17.1472222 0.088033 17.1500000 0.086364 17.5361111 0.059647 17.5388889 0.057978 17.5416667 0.052968 17.5444444 0.049629 17.5472222 0.052968 17.5500000 0.049629 17.5527778 0.054638 17.5555556 0.061317 17.5583333 0.059647 17.5611111 0.062987 17.5638889 0.066327 17.5666667 0.066327 17.5694444 0.069666 17.5722222 0.064657 17.5750000 0.061317 17.5777778 0.067996 17.5805556 0.064657 17.5833333 0.069666 17.5861111 0.076345 17.5888889 0.084694 17.5916667 0.079685 17.5944444 0.086364 17.5972222 0.084694 17.6000000 0.086364 17.6027778 0.094712 17.6055556 0.086364 17.6083333 0.088033 17.6111111 0.091373 17.6138889 0.086364 17.6166667 0.083024 17.6194444 0.081354 17.6222222 0.067996 17.6250000 0.071336 17.6277778 0.067996 17.6305556 0.066327 17.6333333 0.061317 17.6361111 0.059647 17.6388889 0.054638 17.6416667 0.046289 17.6444444 0.047959 17.6472222 0.041280 17.6500000 0.041280 17.6527778 0.044620 17.6555556 0.047959 17.6583333 0.051299 17.6611111 0.054638 17.6638889 0.051299 17.6666667 0.046289 17.6694444 0.044620 17.6722222 0.039610 17.6750000 0.031262 17.6777778 0.029592 17.6805556 0.026252 17.6833333 0.031262 17.6861111 0.037941 17.6888889 0.041280 17.6916667 0.044620 17.6944444 0.051299 17.6972222 0.049629 17.7000000 0.046289 17.7027778 0.046289 17.7055556 0.039610 17.7083333 0.037941 17.7111111 0.036271 17.7138889 0.031262 17.7166667 0.034601 17.7194444 0.037941 17.7222222 0.049629 17.7250000 0.041280 17.7277778 0.047959 17.7305556 0.046289 17.7333333 0.042950 17.7361111 0.044620 17.7388889 0.037941 17.7416667 0.031262 17.7444444 0.034601 17.7472222 0.032931 17.7500000 0.036271 17.7527778 0.052968 17.7555556 0.056308 17.7583333 0.076345 17.7611111 0.099722 17.7638889 0.116419 17.7666667 0.123098 17.7694444 0.114750 17.7722222 0.093043 17.7750000 0.047959 17.7777778 0.010000 17.7805556 0.010000 17.7833333 0.010000 17.7861111 0.010000 17.7888889 0.010000 17.7916667 0.010000 17.7944444 0.010000 17.7972222 0.010000 17.8000000 0.010000 17.8027778 0.010000 17.8055556 0.010000 17.8083333 0.010000 17.8111111 0.010000 17.8138889 0.010000 17.8166667 0.010000 17.8194444 0.010000 17.8222222 0.010000 17.8250000 0.010000 17.8277778 0.031262 17.8305556 0.039610 17.8333333 0.039610 17.8361111 0.044620 17.8388889 0.046289 17.8416667 0.049629 17.8444444 0.044620 17.8472222 0.044620 17.8500000 0.049629 17.8527778 0.057978 17.8555556 0.057978 17.8583333 0.061317 17.8611111 0.064657 17.8638889 0.066327 17.8666667 0.062987 17.8694444 0.064657 17.8722222 0.064657 17.8750000 0.062987 17.8777778 0.064657 17.8805556 0.066327 17.8833333 0.069666 17.8861111 0.071336 17.8888889 0.079685 17.8916667 0.074675 17.8944444 0.081354 17.8972222 0.079685 17.9000000 0.071336 17.9027778 0.076345 17.9055556 0.073006 17.9083333 0.071336 17.9111111 0.071336 17.9138889 0.064657 17.9166667 0.066327 17.9194444 0.062987 17.9222222 0.073006 17.9250000 0.074675 17.9277778 0.079685 17.9305556 0.074675 17.9333333 0.078015 17.9361111 0.079685 17.9388889 0.073006 17.9416667 0.071336 17.9444444 0.074675 17.9472222 0.074675 17.9500000 0.069666 17.9527778 0.071336 17.9555556 0.071336 17.9583333 0.081354 17.9611111 0.078015 17.9638889 0.083024 17.9666667 0.078015 17.9694444 0.069666 17.9722222 0.067996 17.9750000 0.059647 17.9777778 0.064657 17.9805556 0.059647 17.9833333 0.066327 17.9861111 0.071336 17.9888889 0.074675 17.9916667 0.073006 17.9944444 0.081354 17.9972222 0.086364 18.0000000 0.078015 18.0027778 0.081354 18.0055556 0.081354 18.0083333 0.076345 18.0111111 0.071336 18.0138889 0.074675 18.0166667 0.076345 18.0194444 0.076345 18.0222222 0.081354 18.0250000 0.081354 18.0277778 0.084694 18.0305556 0.079685 18.0333333 0.079685 18.0361111 0.076345 18.0388889 0.073006 18.0416667 0.061317 18.0444444 0.064657 18.0472222 0.061317 18.0500000 0.059647 18.0527778 0.064657 18.0555556 0.061317 18.0583333 0.069666 18.0611111 0.071336 18.0638889 0.074675 18.0666667 0.066327 18.0694444 0.071336 18.0722222 0.056308 18.0750000 0.059647 18.0777778 0.052968 18.0805556 0.046289 18.0833333 0.046289 18.4027778 0.062987 18.4055556 0.061317 18.4083333 0.056308 18.4111111 0.057978 18.4138889 0.059647 18.4166667 0.061317 18.4194444 0.057978 18.4222222 0.066327 18.4250000 0.067996 18.4277778 0.069666 18.4305556 0.069666 18.4333333 0.069666 18.4361111 0.069666 18.4388889 0.062987 18.4416667 0.064657 18.4444444 0.066327 18.4472222 0.066327 18.4500000 0.073006 18.4527778 0.078015 18.4555556 0.078015 18.4583333 0.084694 18.4611111 0.088033 18.4638889 0.098052 18.4666667 0.094712 18.4694444 0.096382 18.4722222 0.094712 18.4750000 0.091373 18.4777778 0.088033 18.4805556 0.076345 18.4833333 0.073006 18.4861111 0.066327 18.4888889 0.066327 18.4916667 0.064657 18.4944444 0.062987 18.4972222 0.059647 18.5000000 0.061317 18.5027778 0.057978 18.5055556 0.047959 18.5083333 0.047959 18.5111111 0.042950 18.5138889 0.044620 18.5166667 0.039610 18.5194444 0.047959 18.5222222 0.051299 18.5250000 0.056308 18.5277778 0.056308 18.5305556 0.061317 18.5333333 0.059647 18.5361111 0.056308 18.5388889 0.054638 18.5416667 0.049629 18.5444444 0.041280 18.5472222 0.044620 18.5500000 0.046289 18.5527778 0.049629 18.5555556 0.052968 18.5583333 0.054638 18.5611111 0.054638 18.5638889 0.056308 18.5666667 0.051299 18.5694444 0.047959 18.5722222 0.049629 18.5750000 0.042950 18.5777778 0.036271 18.5805556 0.034601 18.5833333 0.039610 18.5861111 0.037941 18.5888889 0.051299 18.5916667 0.049629 18.5944444 0.049629 18.5972222 0.056308 18.6000000 0.054638 18.6027778 0.051299 18.6055556 0.052968 18.6083333 0.051299 18.6111111 0.047959 18.6138889 0.044620 18.6166667 0.046289 18.6194444 0.052968 18.6222222 0.061317 18.6250000 0.079685 18.6277778 0.101391 18.6305556 0.118089 18.6333333 0.128108 18.6361111 0.124768 18.6388889 0.106401 18.6416667 0.069666 18.6444444 0.024583 18.6472222 0.010000 18.6500000 0.010000 18.6527778 0.010000 18.6555556 0.010000 18.6583333 0.010000 18.6611111 0.010000 18.6638889 0.010000 18.6666667 0.010000 18.6694444 0.010000 18.6722222 0.010000 18.6750000 0.010000 18.6777778 0.010000 18.6805556 0.010000 18.6833333 0.010000 18.6861111 0.010000 18.6888889 0.010000 18.6916667 0.010000 18.6944444 0.010000 18.6972222 0.011224 18.7000000 0.019573 18.7027778 0.029592 18.7055556 0.041280 18.7083333 0.041280 18.7111111 0.039610 18.7138889 0.037941 18.7166667 0.044620 18.7194444 0.057978 18.7222222 0.056308 18.7250000 0.061317 18.7277778 0.067996 18.7305556 0.066327 18.7333333 0.073006 18.7361111 0.069666 18.7388889 0.071336 18.7416667 0.062987 18.7444444 0.064657 18.7472222 0.064657 18.7500000 0.071336 18.7527778 0.066327 18.7555556 0.073006 18.7583333 0.076345 18.7611111 0.074675 18.7638889 0.078015 18.7666667 0.074675 18.7694444 0.069666 18.7722222 0.069666 18.7750000 0.062987 18.7777778 0.062987 18.7805556 0.064657 18.7833333 0.061317 18.7861111 0.071336 18.7888889 0.074675 18.7916667 0.078015 18.7944444 0.083024 18.7972222 0.078015 18.8000000 0.076345 18.8027778 0.076345 18.8055556 0.073006 18.8083333 0.074675 18.8111111 0.067996 18.8138889 0.069666 18.8166667 0.071336 18.8194444 0.074675 18.8222222 0.071336 18.8250000 0.073006 18.8277778 0.076345 18.8305556 0.078015 18.8333333 0.078015 18.8361111 0.079685 18.8388889 0.073006 18.8416667 0.061317 18.8444444 0.067996 18.8472222 0.069666 18.8500000 0.076345 18.8527778 0.078015 18.8555556 0.084694 18.8583333 0.083024 18.8611111 0.086364 18.8638889 0.091373 18.8666667 0.086364 18.8694444 0.086364 18.8722222 0.081354 18.8750000 0.076345 18.8777778 0.078015 18.8805556 0.079685 18.8833333 0.078015 18.8861111 0.078015 18.8888889 0.084694 18.8916667 0.084694 18.8944444 0.088033 18.8972222 0.091373 18.9000000 0.089703 18.9027778 0.084694 18.9055556 0.084694 18.9083333 0.076345 18.9111111 0.079685 18.9138889 0.076345 18.9166667 0.081354 18.9194444 0.081354 18.9222222 0.081354 18.9250000 0.088033 18.9277778 0.096382 18.9305556 0.086364 18.9333333 0.083024 18.9361111 0.079685 18.9388889 0.078015 18.9416667 0.069666 18.9444444 0.069666 18.9472222 0.069666 18.9500000 0.067996 18.9527778 0.076345 18.9555556 0.078015 18.9583333 0.081354 18.9611111 0.083024 18.9638889 0.086364 18.9666667 0.078015 18.9694444 0.073006 18.9722222 0.071336 18.9750000 0.066327 18.9777778 0.069666 18.9805556 0.067996 18.9833333 0.073006 18.9861111 0.071336 18.9888889 0.081354 18.9916667 0.083024 18.9944444 0.076345 18.9972222 0.079685 19.0000000 0.081354 19.0027778 0.081354 19.0055556 0.074675 19.0083333 0.078015 19.0111111 0.073006 19.0138889 0.069666 19.0166667 0.069666 19.0194444 0.076345 19.0222222 0.073006 19.0250000 0.071336 19.0277778 0.074675 19.0305556 0.076345 19.0333333 0.071336 19.0361111 0.067996 19.0388889 0.066327 19.0416667 0.066327 19.0444444 0.066327 19.0472222 0.064657 19.0500000 0.062987 19.0527778 0.064657 19.0555556 0.062987 19.0583333 0.067996 19.0611111 0.071336 19.0638889 0.069666 19.0666667 0.066327 19.0694444 0.071336 19.0722222 0.064657 19.0750000 0.062987 19.0777778 0.054638 19.0805556 0.059647 19.0833333 0.056308 19.0861111 0.057978 19.0888889 0.059647 19.0916667 0.061317 19.0944444 0.061317 19.0972222 0.061317 19.1000000 0.066327 19.1027778 0.059647 19.1055556 0.061317 19.1083333 0.059647 19.1111111 0.052968 19.1138889 0.049629 19.1166667 0.052968 19.1194444 0.059647 19.1222222 0.061317 19.1250000 0.062987 19.1277778 0.067996 19.1305556 0.073006 19.1333333 0.071336 19.1361111 0.067996 19.1388889 0.071336 19.1416667 0.076345 19.1444444 0.076345 19.1472222 0.089703 19.1500000 0.103061 19.1527778 0.116419 19.1555556 0.133117 19.1583333 0.138126 19.1611111 0.124768 19.1638889 0.099722 19.1666667 0.051299 19.1694444 0.010000 19.1722222 0.010000 19.1750000 0.010000 19.1777778 0.010000 19.1805556 0.010000 19.1833333 0.010000 19.1861111 0.010000 19.1888889 0.010000 19.1916667 0.010000 19.1944444 0.010000 19.1972222 0.010000 19.2000000 0.010000 19.2027778 0.010000 19.2055556 0.010000 19.2083333 0.010000 19.2111111 0.010000 19.2138889 0.010000 19.2166667 0.010000 19.2194444 0.010000 19.2222222 0.010000 19.2250000 0.010000 19.2277778 0.010000 19.2305556 0.010000 19.2333333 0.010000 19.2361111 0.010000 19.2388889 0.010000 19.2416667 0.010000 19.2444444 0.010000 19.2472222 0.010000 19.2500000 0.010000 19.2527778 0.010000 19.2555556 0.010000 19.2583333 0.010000 19.2611111 0.010000 19.2638889 0.010000 19.2666667 0.022913 19.2694444 0.049629 19.2722222 0.071336 19.2750000 0.079685 19.2777778 0.083024 19.2805556 0.084694 19.2833333 0.089703 19.2861111 0.094712 19.2888889 0.113080 19.2916667 0.114750 19.2944444 0.124768 19.2972222 0.126438 19.3000000 0.129777 19.3027778 0.138126 19.3055556 0.136456 19.3083333 0.133117 19.3111111 0.134787 19.3138889 0.134787 19.3166667 0.139796 19.3194444 0.144805 19.3222222 0.151484 19.3250000 0.153154 19.3277778 0.159833 19.3305556 0.163173 19.3333333 0.163173 19.3361111 0.163173 19.3388889 0.164842 19.3416667 0.166512 19.3444444 0.164842 19.3472222 0.169852 19.3500000 0.178200 19.3527778 0.181540 19.3555556 0.193228 19.3583333 0.199907 19.3611111 0.204917 19.3638889 0.211596 19.3666667 0.209926 19.3694444 0.216605 19.3722222 0.219944 19.3750000 0.223284 19.3777778 0.228293 19.3805556 0.238312 19.3833333 0.244991 19.3861111 0.250000 19.3888889 0.263358 19.3916667 0.275046 19.3944444 0.283395 19.3972222 0.291744 19.4000000 0.301763 19.4027778 0.300093 19.4055556 0.301763 19.4083333 0.305102 19.4111111 0.298423 19.4138889 0.298423 19.4166667 0.293414 19.4194444 0.305102 19.4222222 0.316790 19.4250000 0.320130 19.4277778 0.328479 19.4305556 0.338497 19.4333333 0.348516 19.4361111 0.350186 19.4388889 0.353525 19.4416667 0.358534 19.4444444 0.360204 19.4472222 0.365213 19.4500000 0.375232 19.4527778 0.376902 19.4555556 0.386920 19.4583333 0.390260 19.4611111 0.395269 19.4638889 0.390260 19.4666667 0.391929 19.4694444 0.388590 19.4722222 0.380241 19.4750000 0.378571 19.4777778 0.363544 19.4805556 0.356865 19.4833333 0.351855 19.4861111 0.348516 19.4888889 0.340167 19.4916667 0.331818 19.4944444 0.323469 19.4972222 0.308442 20.2527778 0.046289 20.2555556 0.049629 20.2583333 0.052968 20.2611111 0.057978 20.2638889 0.057978 20.2666667 0.054638 20.2694444 0.062987 20.2722222 0.059647 20.2750000 0.052968 20.2777778 0.049629 20.2805556 0.047959 20.2833333 0.051299 20.2861111 0.052968 20.2888889 0.052968 20.2916667 0.056308 20.2944444 0.056308 20.2972222 0.057978 20.3000000 0.057978 20.3027778 0.057978 20.3055556 0.052968 20.3083333 0.056308 20.3111111 0.047959 20.3138889 0.047959 20.3166667 0.052968 20.3194444 0.056308 20.3222222 0.066327 20.3250000 0.067996 20.3277778 0.076345 20.3305556 0.081354 20.3333333 0.083024 20.3361111 0.084694 20.3388889 0.081354 20.3416667 0.083024 20.3444444 0.081354 20.3472222 0.076345 20.3500000 0.083024 20.3527778 0.086364 20.3555556 0.086364 20.3583333 0.088033 20.3611111 0.094712 20.3638889 0.093043 20.3666667 0.081354 20.3694444 0.073006 20.3722222 0.067996 20.3750000 0.054638 20.3777778 0.051299 20.3805556 0.044620 20.3833333 0.046289 20.3861111 0.041280 20.3888889 0.052968 20.3916667 0.054638 20.3944444 0.051299 20.3972222 0.061317 20.4000000 0.052968 20.4027778 0.054638 20.4055556 0.056308 20.4083333 0.054638 20.4111111 0.042950 20.4138889 0.044620 20.4166667 0.039610 20.4194444 0.041280 20.4222222 0.046289 20.4250000 0.046289 20.4277778 0.046289 20.4305556 0.044620 20.4333333 0.046289 20.4361111 0.049629 20.4388889 0.046289 20.4416667 0.032931 20.4444444 0.037941 20.4472222 0.034601 20.4500000 0.039610 20.4527778 0.039610 20.4555556 0.042950 20.4583333 0.047959 20.4611111 0.046289 20.4638889 0.049629 20.4666667 0.046289 20.4694444 0.051299 20.4722222 0.052968 20.4750000 0.057978 20.4777778 0.067996 20.4805556 0.083024 20.4833333 0.093043 20.4861111 0.098052 20.4888889 0.094712 20.4916667 0.071336 20.4944444 0.036271 20.4972222 0.010000 20.5000000 0.010000 20.5027778 0.010000 20.5055556 0.010000 20.5083333 0.010000 20.5111111 0.010000 20.5138889 0.010000 20.5166667 0.010000 20.5194444 0.010000 20.5222222 0.010000 20.5250000 0.010000 20.5277778 0.010000 20.5305556 0.010000 20.5333333 0.010000 20.5361111 0.010000 20.5388889 0.010000 20.5416667 0.010000 20.5444444 0.010000 20.5472222 0.010000 20.5500000 0.019573 20.5527778 0.032931 20.5555556 0.039610 20.5583333 0.044620 20.5611111 0.052968 20.5638889 0.057978 20.5666667 0.056308 20.5694444 0.057978 20.5722222 0.056308 20.5750000 0.059647 20.5777778 0.061317 20.5805556 0.061317 20.5833333 0.061317 20.5861111 0.061317 20.5888889 0.066327 20.5916667 0.071336 20.5944444 0.076345 20.5972222 0.079685 20.6000000 0.081354 20.6027778 0.076345 20.6055556 0.073006 20.6083333 0.071336 20.6111111 0.069666 20.6138889 0.066327 20.6166667 0.064657 20.6194444 0.062987 20.6222222 0.071336 20.6250000 0.071336 20.6277778 0.081354 20.6305556 0.078015 20.6333333 0.083024 20.6361111 0.079685 20.6388889 0.078015 20.6416667 0.076345 20.6444444 0.074675 20.6472222 0.067996 20.6500000 0.073006 20.6527778 0.073006 20.6555556 0.078015 20.6583333 0.078015 20.6611111 0.083024 20.6638889 0.086364 20.6666667 0.084694 20.6694444 0.086364 20.6722222 0.081354 20.6750000 0.079685 20.6777778 0.074675 20.6805556 0.078015 20.6833333 0.069666 20.6861111 0.076345 20.6888889 0.079685 20.6916667 0.081354 20.6944444 0.084694 20.6972222 0.091373 20.7000000 0.089703 20.7027778 0.088033 20.7055556 0.086364 20.7083333 0.084694 20.7111111 0.086364 20.7138889 0.081354 20.7166667 0.079685 20.7194444 0.079685 20.7222222 0.083024 20.7250000 0.091373 20.7277778 0.091373 20.7305556 0.096382 20.7333333 0.093043 20.7361111 0.096382 20.7388889 0.088033 20.7416667 0.086364 20.7444444 0.084694 20.7472222 0.081354 20.7500000 0.088033 20.7527778 0.088033 20.7555556 0.091373 20.7583333 0.096382 20.7611111 0.101391 20.7638889 0.099722 20.7666667 0.103061 20.7694444 0.098052 20.7722222 0.098052 20.7750000 0.088033 20.7777778 0.088033 20.7805556 0.086364 20.7833333 0.083024 20.7861111 0.088033 20.7888889 0.091373 20.7916667 0.089703 20.7944444 0.098052 20.7972222 0.098052 20.8000000 0.093043 20.8055556 0.084694 20.8083333 0.081354 20.8111111 0.079685 20.8138889 0.074675 20.8166667 0.073006 20.8194444 0.078015 20.8222222 0.079685 20.8250000 0.076345 20.8277778 0.083024 20.8305556 0.079685 20.8333333 0.081354 20.8361111 0.074675 20.8388889 0.067996 20.8416667 0.071336 20.8444444 0.064657 20.8472222 0.062987 20.8500000 0.067996 20.8527778 0.064657 20.8555556 0.071336 20.8583333 0.069666 20.8611111 0.076345 20.8638889 0.078015 20.8666667 0.078015 20.8694444 0.071336 20.8722222 0.071336 20.8750000 0.071336 20.8777778 0.071336 20.8805556 0.067996 20.8833333 0.069666 20.8861111 0.078015 20.8888889 0.079685 20.8916667 0.076345 20.8944444 0.084694 20.8972222 0.076345 20.9000000 0.079685 20.9027778 0.081354 20.9055556 0.078015 20.9083333 0.069666 20.9111111 0.067996 20.9138889 0.069666 20.9166667 0.066327 20.9194444 0.067996 20.9222222 0.071336 20.9250000 0.071336 20.9277778 0.076345 20.9305556 0.079685 20.9333333 0.078015 20.9361111 0.073006 20.9388889 0.074675 20.9416667 0.073006 20.9444444 0.069666 20.9472222 0.067996 20.9500000 0.069666 20.9527778 0.062987 20.9555556 0.071336 20.9583333 0.076345 20.9611111 0.074675 20.9638889 0.079685 20.9666667 0.073006 20.9694444 0.071336 20.9722222 0.073006 20.9750000 0.066327 20.9777778 0.064657 20.9805556 0.064657 20.9833333 0.064657 20.9861111 0.071336 20.9888889 0.076345 20.9916667 0.084694 20.9944444 0.091373 20.9972222 0.106401 21.0000000 0.113080 21.0027778 0.118089 21.0055556 0.134787 21.0083333 0.149814 21.0111111 0.158163 21.0138889 0.156494 21.0166667 0.136456 21.0194444 0.108071 21.0222222 0.059647 21.0250000 0.016234 21.0277778 0.010000 21.0305556 0.010000 21.0333333 0.010000 21.0361111 0.010000 21.0388889 0.010000 21.0416667 0.010000 21.0444444 0.010000 21.0472222 0.010000 21.0500000 0.010000 21.0527778 0.010000 21.0555556 0.010000 21.0583333 0.010000 21.0611111 0.010000 21.0638889 0.010000 21.0666667 0.010000 21.0694444 0.010000 21.0722222 0.010000 21.0750000 0.010000 21.0777778 0.010000 21.0805556 0.010000 21.0833333 0.010000 21.0861111 0.010000 21.0888889 0.010000 21.0916667 0.010000 21.0944444 0.010000 21.0972222 0.010000 21.1000000 0.010000 21.1027778 0.010000 21.1055556 0.010000 21.1083333 0.010000 21.1111111 0.010000 21.1138889 0.010000 21.1166667 0.010000 21.1194444 0.010000 21.1222222 0.010000 21.1250000 0.010000 21.1277778 0.017904 21.1305556 0.052968 21.1333333 0.076345 21.1361111 0.096382 21.1388889 0.103061 21.1416667 0.104731 21.1444444 0.104731 21.1472222 0.109740 21.1500000 0.113080 21.1527778 0.123098 21.1555556 0.129777 21.1583333 0.143135 21.1611111 0.144805 21.1638889 0.151484 21.1666667 0.148145 21.1694444 0.149814 21.1722222 0.144805 21.1750000 0.146475 21.1777778 0.148145 21.1805556 0.148145 21.1833333 0.154824 21.1861111 0.151484 21.1888889 0.159833 21.1916667 0.161503 21.1944444 0.171521 21.1972222 0.176531 21.2000000 0.178200 21.2027778 0.176531 21.2055556 0.179870 21.2083333 0.181540 21.2111111 0.183210 21.2138889 0.181540 21.2166667 0.184879 21.2194444 0.191558 21.2222222 0.198237 21.2250000 0.198237 21.2277778 0.214935 21.2305556 0.216605 21.2333333 0.216605 21.2361111 0.221614 21.2388889 0.226623 21.2416667 0.228293 21.2444444 0.228293 21.2472222 0.233302 21.2500000 0.238312 21.2527778 0.248330 21.2555556 0.260019 21.2583333 0.275046 21.2611111 0.285065 21.2638889 0.300093 21.2666667 0.306772 21.2694444 0.316790 21.2722222 0.325139 21.2750000 0.328479 21.2777778 0.336827 21.2805556 0.346846 21.2833333 0.348516 21.2861111 0.356865 21.2888889 0.371892 21.2916667 0.375232 21.2944444 0.376902 21.2972222 0.378571 21.3000000 0.373562 21.3027778 0.376902 21.3055556 0.376902 21.3083333 0.378571 21.3111111 0.378571 21.3138889 0.381911 21.3166667 0.388590 21.3194444 0.390260 21.3222222 0.400278 21.3250000 0.405288 21.3277778 0.413636 21.3305556 0.413636 21.3333333 0.413636 21.3361111 0.415306 21.3388889 0.410297 21.3416667 0.406957 21.3444444 0.401948 21.3472222 0.395269 21.3500000 0.388590 21.3527778 0.383581 22.1472222 0.064657 22.1500000 0.066327 22.1527778 0.062987 22.1555556 0.071336 22.1583333 0.073006 22.1611111 0.076345 22.1638889 0.079685 22.1666667 0.078015 22.1694444 0.073006 22.1722222 0.074675 22.1750000 0.067996 22.1777778 0.062987 22.1805556 0.059647 22.1833333 0.066327 22.1861111 0.071336 22.1888889 0.073006 22.1916667 0.073006 22.1944444 0.074675 22.1972222 0.081354 22.2000000 0.079685 22.2027778 0.081354 22.2055556 0.069666 22.2083333 0.073006 22.2111111 0.066327 22.2138889 0.071336 22.2166667 0.067996 22.2194444 0.067996 22.2222222 0.079685 22.2250000 0.088033 22.2277778 0.093043 22.2305556 0.101391 22.2333333 0.099722 22.2361111 0.099722 22.2388889 0.099722 22.2416667 0.101391 22.2444444 0.098052 22.2472222 0.103061 22.2500000 0.101391 22.2527778 0.103061 22.2555556 0.103061 22.2583333 0.101391 22.2611111 0.096382 22.2638889 0.093043 22.2666667 0.083024 22.2694444 0.078015 22.2722222 0.073006 22.2750000 0.066327 22.2777778 0.064657 22.2805556 0.057978 22.2833333 0.056308 22.2861111 0.057978 22.2888889 0.061317 22.2916667 0.059647 22.2944444 0.066327 22.2972222 0.066327 22.3000000 0.062987 22.3027778 0.062987 22.3055556 0.062987 22.3083333 0.059647 22.3111111 0.057978 22.3138889 0.044620 22.3166667 0.049629 22.3194444 0.046289 22.3222222 0.052968 22.3250000 0.057978 22.3277778 0.061317 22.3305556 0.064657 22.3333333 0.064657 22.3361111 0.059647 22.3388889 0.054638 22.3416667 0.056308 22.3444444 0.054638 22.3472222 0.049629 22.3500000 0.042950 22.3527778 0.046289 22.3555556 0.047959 22.3583333 0.057978 22.3611111 0.061317 22.3638889 0.069666 22.3666667 0.069666 22.3694444 0.079685 22.3722222 0.098052 22.3750000 0.113080 22.3777778 0.121429 22.3805556 0.114750 22.3833333 0.101391 22.3861111 0.069666 22.3888889 0.026252 22.3916667 0.010000 22.3944444 0.010000 22.3972222 0.010000 22.4000000 0.010000 22.4027778 0.010000 22.4055556 0.010000 22.4083333 0.010000 22.4111111 0.010000 22.4138889 0.010000 22.4166667 0.010000 22.4194444 0.010000 22.4222222 0.010000 22.4250000 0.010000 22.4277778 0.010000 22.4305556 0.010000 22.4333333 0.010000 22.4361111 0.010000 22.4388889 0.022913 22.4416667 0.037941 22.4444444 0.042950 22.4472222 0.046289 22.4500000 0.052968 22.4527778 0.052968 22.4555556 0.061317 22.4583333 0.061317 22.4611111 0.074675 22.4638889 0.076345 22.4666667 0.078015 22.4694444 0.078015 22.4722222 0.078015 22.4750000 0.074675 22.4777778 0.071336 22.4805556 0.073006 22.4833333 0.074675 22.4861111 0.074675 22.4888889 0.081354 22.4916667 0.088033 22.4944444 0.089703 22.4972222 0.091373 22.5000000 0.093043 22.5027778 0.089703 22.5055556 0.088033 22.5083333 0.084694 22.5111111 0.086364 22.5138889 0.083024 22.5166667 0.083024 22.5194444 0.083024 22.5222222 0.083024 22.5250000 0.089703 22.5277778 0.089703 22.5305556 0.094712 22.5333333 0.094712 22.5361111 0.091373 22.5388889 0.091373 22.5416667 0.083024 22.5444444 0.084694 22.5472222 0.083024 22.5500000 0.088033 22.5527778 0.091373 22.5555556 0.093043 22.5583333 0.099722 22.5611111 0.098052 22.5638889 0.106401 22.5666667 0.101391 22.5694444 0.099722 22.5722222 0.101391 22.5750000 0.094712 22.5777778 0.096382 22.5805556 0.093043 22.5833333 0.091373 22.5861111 0.098052 22.5888889 0.098052 22.5916667 0.098052 22.5944444 0.098052 22.5972222 0.104731 22.6000000 0.104731 22.6027778 0.099722 22.6055556 0.099722 22.6083333 0.101391 22.6111111 0.099722 22.6138889 0.096382 22.6166667 0.098052 22.6194444 0.101391 22.6222222 0.104731 22.6250000 0.109740 22.6277778 0.113080 22.6305556 0.118089 22.6333333 0.119759 22.6361111 0.114750 22.6388889 0.113080 22.6416667 0.109740 22.6444444 0.106401 22.6472222 0.108071 22.6500000 0.104731 22.6527778 0.106401 22.6555556 0.109740 22.6583333 0.111410 22.6611111 0.109740 22.6638889 0.113080 22.6666667 0.119759 22.6694444 0.111410 22.6722222 0.113080 22.6750000 0.108071 22.6777778 0.104731 22.6805556 0.101391 22.6833333 0.099722 22.6861111 0.104731 22.6888889 0.106401 22.6916667 0.108071 22.6944444 0.109740 22.6972222 0.108071 22.7000000 0.106401 22.7027778 0.108071 22.7055556 0.099722 22.7083333 0.098052 22.7111111 0.091373 22.7138889 0.086364 22.7166667 0.079685 22.7194444 0.079685 22.7222222 0.078015 22.7250000 0.083024 22.7277778 0.083024 22.7305556 0.088033 22.7333333 0.089703 22.7361111 0.093043 22.7388889 0.088033 22.7416667 0.086364 22.7444444 0.088033 22.7472222 0.084694 22.7500000 0.083024 22.7527778 0.079685 22.7555556 0.086364 22.7583333 0.088033 22.7611111 0.089703 22.7638889 0.093043 22.7666667 0.091373 22.7694444 0.096382 22.7722222 0.089703 22.7750000 0.084694 22.7777778 0.081354 22.7805556 0.073006 22.7833333 0.076345 22.7861111 0.069666 22.7888889 0.079685 22.7916667 0.081354 22.7944444 0.081354 22.7972222 0.088033 22.8000000 0.088033 22.8027778 0.093043 22.8055556 0.091373 22.8083333 0.089703 22.8111111 0.084694 22.8138889 0.079685 22.8166667 0.079685 22.8194444 0.081354 22.8222222 0.086364 22.8250000 0.083024 22.8277778 0.086364 22.8305556 0.089703 22.8333333 0.084694 22.8361111 0.083024 22.8388889 0.079685 22.8416667 0.076345 22.8444444 0.073006 22.8472222 0.074675 22.8500000 0.069666 22.8527778 0.073006 22.8555556 0.079685 22.8583333 0.084694 22.8611111 0.096382 22.8638889 0.098052 22.8666667 0.101391 22.8694444 0.099722 22.8722222 0.108071 22.8750000 0.104731 22.8777778 0.113080 22.8805556 0.124768 22.8833333 0.138126 22.8861111 0.156494 22.8888889 0.163173 22.8916667 0.156494 22.8944444 0.119759 22.8972222 0.076345 22.9000000 0.021243 22.9027778 0.010000 22.9055556 0.010000 22.9083333 0.010000 22.9111111 0.010000 22.9138889 0.010000 22.9166667 0.010000 22.9194444 0.010000 22.9222222 0.010000 22.9250000 0.010000 22.9277778 0.010000 22.9305556 0.010000 22.9333333 0.010000 22.9361111 0.010000 22.9388889 0.010000 22.9416667 0.010000 22.9444444 0.010000 22.9472222 0.010000 22.9500000 0.010000 22.9527778 0.010000 22.9555556 0.010000 22.9583333 0.010000 22.9611111 0.010000 22.9638889 0.010000 22.9666667 0.010000 22.9694444 0.010000 22.9722222 0.010000 22.9750000 0.010000 22.9777778 0.010000 22.9805556 0.010000 22.9833333 0.010000 22.9861111 0.010000 22.9888889 0.010000 22.9916667 0.010000 22.9944444 0.010000 22.9972222 0.032931 23.0000000 0.062987 23.0027778 0.086364 23.0055556 0.106401 23.0083333 0.113080 23.0111111 0.114750 23.0138889 0.118089 23.0166667 0.116419 23.0194444 0.124768 23.0222222 0.126438 23.0250000 0.134787 23.0277778 0.143135 23.0305556 0.156494 23.0333333 0.159833 23.0361111 0.159833 23.0388889 0.161503 23.0416667 0.156494 23.0444444 0.163173 23.0472222 0.161503 23.0500000 0.164842 23.0527778 0.176531 23.0555556 0.174861 23.0583333 0.186549 23.0611111 0.189889 23.0638889 0.191558 23.0666667 0.194898 23.0694444 0.198237 23.0722222 0.196568 23.0750000 0.198237 23.0777778 0.199907 23.0805556 0.203247 23.0833333 0.204917 23.0861111 0.206586 23.0888889 0.213265 23.0916667 0.221614 23.0944444 0.233302 23.0972222 0.243321 23.1000000 0.251670 23.1027778 0.261688 23.1055556 0.263358 23.1083333 0.268367 23.1111111 0.273377 23.1138889 0.273377 23.1166667 0.285065 23.1194444 0.286735 23.1222222 0.296753 23.1250000 0.303432 23.1277778 0.306772 23.1305556 0.310111 23.1333333 0.300093 23.1361111 0.303432 23.1388889 0.305102 23.1416667 0.306772 23.1444444 0.310111 23.1472222 0.320130 23.1500000 0.323469 23.1527778 0.333488 23.1555556 0.343506 23.1583333 0.355195 23.1611111 0.371892 23.1638889 0.381911 23.1666667 0.386920 23.1694444 0.398609 23.1722222 0.401948 23.1750000 0.398609 23.1777778 0.396939 23.1805556 0.395269 23.1833333 0.396939 23.1861111 0.398609 23.1888889 0.396939 23.1916667 0.398609 23.1944444 0.398609 23.1972222 0.393599 23.2000000 0.388590 23.2027778 0.380241 23.2055556 0.373562 23.2083333 0.365213 23.2111111 0.348516 23.2138889 0.340167 23.2166667 0.331818 23.2194444 0.323469 23.2222222 0.316790 23.2250000 0.310111 23.2277778 0.308442 24.0111111 0.081354 24.0138889 0.081354 24.0166667 0.074675 24.0194444 0.084694 24.0222222 0.078015 24.0250000 0.079685 24.0277778 0.081354 24.0305556 0.089703 24.0333333 0.094712 24.0361111 0.091373 24.0388889 0.088033 24.0416667 0.084694 24.0444444 0.086364 24.0472222 0.083024 24.0500000 0.079685 24.0527778 0.083024 24.0555556 0.084694 24.0583333 0.089703 24.0611111 0.093043 24.0638889 0.094712 24.0666667 0.094712 24.0694444 0.093043 24.0722222 0.093043 24.0750000 0.094712 24.0777778 0.089703 24.0805556 0.093043 24.0833333 0.093043 24.0861111 0.094712 24.0888889 0.099722 24.0916667 0.106401 24.0944444 0.116419 24.0972222 0.118089 24.1000000 0.124768 24.1027778 0.124768 24.1055556 0.126438 24.1083333 0.118089 24.1111111 0.119759 24.1138889 0.111410 24.1166667 0.108071 24.1194444 0.106401 24.1222222 0.093043 24.1250000 0.096382 24.1277778 0.096382 24.1305556 0.094712 24.1333333 0.093043 24.1361111 0.093043 24.1388889 0.088033 24.1416667 0.084694 24.1444444 0.083024 24.1472222 0.074675 24.1500000 0.071336 24.1527778 0.069666 24.1555556 0.076345 24.1583333 0.078015 24.1611111 0.081354 24.1638889 0.086364 24.1666667 0.088033 24.1694444 0.086364 24.1722222 0.081354 24.1750000 0.074675 24.1777778 0.073006 24.1805556 0.074675 24.1833333 0.069666 24.1861111 0.067996 24.1888889 0.078015 24.1916667 0.074675 24.1944444 0.079685 24.1972222 0.081354 24.2000000 0.076345 24.2027778 0.076345 24.2055556 0.073006 24.2083333 0.071336 24.2111111 0.069666 24.2138889 0.066327 24.2166667 0.064657 24.2194444 0.067996 24.2222222 0.066327 24.2250000 0.079685 24.2277778 0.089703 24.2305556 0.099722 24.2333333 0.116419 24.2361111 0.131447 24.2388889 0.143135 24.2416667 0.151484 24.2444444 0.138126 24.2472222 0.118089 24.2500000 0.073006 24.2527778 0.022913 24.2555556 0.010000 24.2583333 0.010000 24.2611111 0.010000 24.2638889 0.010000 24.2666667 0.010000 24.2694444 0.010000 24.2722222 0.010000 24.2750000 0.010000 24.2777778 0.010000 24.2805556 0.010000 24.2833333 0.010000 24.2861111 0.010000 24.2888889 0.010000 24.2916667 0.010000 24.2944444 0.010000 24.2972222 0.016234 24.3000000 0.036271 24.3027778 0.054638 24.3055556 0.064657 24.3083333 0.073006 24.3111111 0.071336 24.3138889 0.069666 24.3166667 0.073006 24.3194444 0.076345 24.3222222 0.079685 24.3250000 0.088033 24.3277778 0.091373 24.3305556 0.094712 24.3333333 0.098052 24.3361111 0.094712 24.3388889 0.098052 24.3416667 0.096382 24.3444444 0.091373 24.3472222 0.091373 24.3500000 0.091373 24.3527778 0.094712 24.3555556 0.093043 24.3583333 0.103061 24.3611111 0.101391 24.3638889 0.108071 24.3666667 0.108071 24.3694444 0.106401 24.3722222 0.104731 24.3750000 0.099722 24.3777778 0.101391 24.3805556 0.096382 24.3833333 0.098052 24.3861111 0.094712 24.3888889 0.103061 24.3916667 0.106401 24.3944444 0.104731 24.3972222 0.109740 24.4000000 0.109740 24.4027778 0.109740 24.4055556 0.114750 24.4083333 0.114750 24.4111111 0.113080 24.4138889 0.104731 24.4166667 0.108071 24.4194444 0.106401 24.4222222 0.113080 24.4250000 0.114750 24.4277778 0.113080 24.4305556 0.123098 24.4333333 0.123098 24.4361111 0.123098 24.4388889 0.118089 24.4416667 0.118089 24.4444444 0.118089 24.4472222 0.113080 24.4500000 0.108071 24.4527778 0.111410 24.4555556 0.114750 24.4583333 0.119759 24.4611111 0.123098 24.4638889 0.123098 24.4666667 0.126438 24.4694444 0.126438 24.4722222 0.129777 24.4750000 0.128108 24.4777778 0.124768 24.4805556 0.126438 24.4833333 0.124768 24.4861111 0.123098 24.4888889 0.129777 24.4916667 0.133117 24.4944444 0.134787 24.4972222 0.141466 24.5000000 0.144805 24.5027778 0.141466 24.5055556 0.138126 24.5083333 0.134787 24.5111111 0.134787 24.5138889 0.134787 24.5166667 0.129777 24.5194444 0.124768 24.5222222 0.134787 24.5250000 0.134787 24.5277778 0.139796 24.5305556 0.143135 24.5333333 0.146475 24.5361111 0.148145 24.5388889 0.143135 24.5416667 0.139796 24.5444444 0.136456 24.5472222 0.131447 24.5500000 0.126438 24.5527778 0.124768 24.5555556 0.124768 24.5583333 0.126438 24.5805556 0.106401 24.5833333 0.106401 24.5861111 0.106401 24.5888889 0.108071 24.5916667 0.111410 24.5944444 0.111410 24.5972222 0.118089 24.6000000 0.116419 24.6027778 0.114750 24.6055556 0.114750 24.6083333 0.109740 24.6111111 0.111410 24.6138889 0.104731 24.6166667 0.104731 24.6194444 0.099722 24.6222222 0.103061 24.6250000 0.106401 24.6277778 0.108071 24.6305556 0.108071 24.6333333 0.111410 24.6361111 0.104731 24.6388889 0.108071 24.6416667 0.101391 24.6444444 0.098052 24.6472222 0.096382 24.6500000 0.096382 24.6527778 0.096382 24.6555556 0.099722 24.6583333 0.103061 24.6611111 0.104731 24.6638889 0.106401 24.6666667 0.108071 24.6694444 0.109740 24.6722222 0.104731 24.6750000 0.101391 24.6777778 0.098052 24.6805556 0.096382 24.6833333 0.098052 24.6861111 0.089703 24.6888889 0.098052 24.6916667 0.096382 24.6944444 0.101391 24.6972222 0.103061 24.7000000 0.098052 24.7027778 0.103061 24.7055556 0.096382 24.7083333 0.098052 24.7111111 0.094712 24.7138889 0.091373 24.7166667 0.088033 24.7194444 0.084694 24.7222222 0.094712 24.7250000 0.096382 24.7277778 0.099722 24.7305556 0.098052 24.7333333 0.103061 24.7361111 0.098052 24.7388889 0.099722 24.7416667 0.093043 24.7444444 0.088033 24.7472222 0.088033 24.7500000 0.086364 24.7527778 0.084694 24.7555556 0.084694 24.7583333 0.098052 24.7611111 0.094712 24.7638889 0.103061 24.7666667 0.109740 24.7694444 0.116419 24.7722222 0.119759 24.7750000 0.124768 24.7777778 0.141466 24.7805556 0.144805 24.7833333 0.163173 24.7861111 0.181540 24.7888889 0.184879 24.7916667 0.169852 24.7944444 0.131447 24.7972222 0.086364 24.8000000 0.034601 24.8027778 0.010000 24.8055556 0.010000 24.8083333 0.010000 24.8111111 0.010000 24.8138889 0.010000 24.8166667 0.010000 24.8194444 0.010000 24.8222222 0.010000 24.8250000 0.010000 24.8277778 0.010000 24.8305556 0.010000 24.8333333 0.010000 24.8361111 0.010000 24.8388889 0.010000 24.8416667 0.010000 24.8444444 0.010000 24.8472222 0.010000 24.8500000 0.010000 24.8527778 0.010000 24.8555556 0.010000 24.8583333 0.010000 24.8611111 0.010000 24.8638889 0.010000 24.8666667 0.010000 24.8694444 0.010000 24.8722222 0.010000 24.8750000 0.010000 24.8777778 0.010000 24.8805556 0.010000 24.8833333 0.010000 24.8861111 0.010000 24.8888889 0.010000 24.8916667 0.010000 24.8944444 0.010000 24.8972222 0.016234 24.9000000 0.054638 24.9027778 0.081354 24.9055556 0.109740 24.9083333 0.118089 24.9111111 0.118089 24.9138889 0.119759 24.9166667 0.123098 24.9194444 0.124768 24.9222222 0.133117 24.9250000 0.141466 24.9277778 0.151484 24.9305556 0.153154 24.9333333 0.161503 24.9361111 0.161503 24.9388889 0.166512 24.9416667 0.161503 24.9444444 0.163173 24.9472222 0.164842 24.9500000 0.161503 24.9527778 0.169852 24.9555556 0.169852 24.9583333 0.181540 24.9611111 0.186549 24.9638889 0.196568 24.9666667 0.201577 24.9694444 0.208256 24.9722222 0.209926 24.9750000 0.208256 24.9777778 0.214935 24.9805556 0.213265 24.9833333 0.223284 24.9861111 0.228293 24.9888889 0.234972 24.9916667 0.239981 24.9944444 0.246660 24.9972222 0.260019 25.0000000 0.263358 25.0027778 0.270037 25.0055556 0.265028 25.0083333 0.265028 25.0111111 0.260019 25.0138889 0.255009 25.0166667 0.250000 25.0194444 0.250000 25.0222222 0.250000 25.0250000 0.258349 25.0277778 0.266698 25.0305556 0.278386 25.0333333 0.293414 25.0361111 0.293414 25.0388889 0.298423 25.0416667 0.296753 25.0444444 0.305102 25.0472222 0.310111 25.0500000 0.311781 25.0527778 0.318460 25.0555556 0.330148 25.0583333 0.345176 25.0611111 0.356865 25.0638889 0.366883 25.0666667 0.380241 25.0694444 0.385250 25.0722222 0.385250 25.0750000 0.391929 25.0777778 0.391929 25.0805556 0.395269 25.0833333 0.398609 25.0861111 0.403618 25.0888889 0.408627 25.0916667 0.408627 25.0944444 0.411967 25.0972222 0.416976 25.1000000 0.421985 25.1027778 0.418646 25.1055556 0.411967 25.1083333 0.403618 25.1111111 0.388590 25.1138889 0.383581 25.1166667 0.375232 25.1194444 0.363544 25.1222222 0.365213 25.1250000 0.356865 25.1277778 0.348516 25.8527778 0.076345 25.8555556 0.076345 25.8583333 0.079685 25.8611111 0.084694 25.8638889 0.093043 25.8666667 0.094712 25.8694444 0.093043 25.8722222 0.093043 25.8750000 0.091373 25.8777778 0.083024 25.8805556 0.083024 25.8833333 0.083024 25.8861111 0.086364 25.8888889 0.083024 25.8916667 0.086364 25.8944444 0.086364 25.8972222 0.091373 25.9000000 0.094712 25.9027778 0.094712 25.9055556 0.098052 25.9083333 0.088033 25.9111111 0.086364 25.9138889 0.086364 25.9166667 0.084694 25.9194444 0.086364 25.9222222 0.089703 25.9250000 0.096382 25.9277778 0.101391 25.9305556 0.111410 25.9333333 0.124768 25.9361111 0.121429 25.9388889 0.121429 25.9416667 0.123098 25.9444444 0.121429 25.9472222 0.119759 25.9500000 0.118089 25.9527778 0.119759 25.9555556 0.116419 25.9583333 0.124768 25.9611111 0.123098 25.9638889 0.118089 25.9666667 0.113080 25.9694444 0.106401 25.9722222 0.101391 25.9750000 0.088033 25.9777778 0.083024 25.9805556 0.076345 25.9833333 0.079685 25.9861111 0.073006 25.9888889 0.076345 25.9916667 0.081354 25.9944444 0.088033 25.9972222 0.086364 26.0000000 0.089703 26.0027778 0.096382 26.0055556 0.088033 26.0083333 0.089703 26.0111111 0.078015 26.0138889 0.078015 26.0166667 0.074675 26.0194444 0.071336 26.0222222 0.074675 26.0250000 0.076345 26.0277778 0.078015 26.0305556 0.081354 26.0333333 0.086364 26.0361111 0.078015 26.0388889 0.081354 26.0416667 0.079685 26.0444444 0.069666 26.0472222 0.066327 26.0500000 0.071336 26.0527778 0.066327 26.0555556 0.073006 26.0583333 0.076345 26.0611111 0.083024 26.0638889 0.083024 26.0666667 0.093043 26.0694444 0.093043 26.0722222 0.094712 26.0750000 0.101391 26.0777778 0.123098 26.0805556 0.133117 26.0833333 0.138126 26.0861111 0.129777 26.0888889 0.119759 26.0916667 0.089703 26.0944444 0.047959 26.0972222 0.010000 26.1000000 0.010000 26.1027778 0.010000 26.1055556 0.010000 26.1083333 0.010000 26.1111111 0.010000 26.1138889 0.010000 26.1166667 0.010000 26.1194444 0.010000 26.1222222 0.010000 26.1250000 0.010000 26.1277778 0.010000 26.1305556 0.010000 26.1333333 0.010000 26.1361111 0.010000 26.1388889 0.014564 26.1416667 0.027922 26.1444444 0.041280 26.1472222 0.047959 26.1500000 0.059647 26.1527778 0.066327 26.1555556 0.073006 26.1583333 0.076345 26.1611111 0.081354 26.1638889 0.083024 26.1666667 0.088033 26.1694444 0.091373 26.1722222 0.093043 26.1750000 0.089703 26.1777778 0.093043 26.1805556 0.088033 26.1833333 0.096382 26.1861111 0.091373 26.1888889 0.098052 26.1916667 0.094712 26.1944444 0.101391 26.1972222 0.104731 26.2000000 0.108071 26.2027778 0.108071 26.2055556 0.111410 26.2083333 0.101391 26.2111111 0.103061 26.2138889 0.101391 26.2166667 0.099722 26.2194444 0.099722 26.2222222 0.098052 26.2250000 0.101391 26.2277778 0.108071 26.2305556 0.103061 26.2333333 0.111410 26.2361111 0.108071 26.2388889 0.108071 26.2416667 0.109740 26.2444444 0.103061 26.2472222 0.106401 26.2500000 0.099722 26.2527778 0.098052 26.2555556 0.098052 26.2583333 0.109740 26.2611111 0.113080 26.2638889 0.116419 26.2666667 0.116419 26.2694444 0.114750 26.2722222 0.119759 26.2750000 0.116419 26.2777778 0.109740 26.2805556 0.103061 26.2833333 0.101391 26.2861111 0.103061 26.2888889 0.103061 26.2916667 0.103061 26.2944444 0.111410 26.2972222 0.113080 26.3000000 0.119759 26.3027778 0.119759 26.3055556 0.114750 26.3083333 0.116419 26.3111111 0.113080 26.3138889 0.113080 26.3166667 0.114750 26.3194444 0.113080 26.3222222 0.116419 26.3250000 0.126438 26.3277778 0.129777 26.3305556 0.126438 26.3333333 0.131447 26.3361111 0.129777 26.3388889 0.131447 26.3416667 0.129777 26.3444444 0.126438 26.3472222 0.124768 26.3500000 0.124768 26.3527778 0.123098 26.3555556 0.128108 26.3583333 0.128108 26.3611111 0.136456 26.3638889 0.139796 26.3666667 0.141466 26.3694444 0.141466 26.3722222 0.134787 26.3750000 0.139796 26.3777778 0.138126 26.3805556 0.133117 26.3833333 0.136456 26.3861111 0.134787 26.3888889 0.131447 26.3916667 0.133117 26.3944444 0.133117 26.3972222 0.143135 26.4000000 0.143135 26.4833333 0.089703 26.4861111 0.088033 26.4888889 0.089703 26.4916667 0.091373 26.4944444 0.098052 26.4972222 0.101391 26.5000000 0.101391 26.5027778 0.103061 26.5055556 0.094712 26.5083333 0.098052 26.5111111 0.093043 26.5138889 0.091373 26.5166667 0.086364 26.5194444 0.079685 26.5222222 0.084694 26.5250000 0.086364 26.5277778 0.093043 26.5305556 0.093043 26.5333333 0.098052 26.5361111 0.093043 26.5388889 0.096382 26.5416667 0.088033 26.5444444 0.091373 26.5472222 0.084694 26.5500000 0.084694 26.5527778 0.083024 26.5555556 0.086364 26.5583333 0.083024 26.5611111 0.093043 26.5638889 0.093043 26.5666667 0.099722 26.5694444 0.098052 26.5722222 0.096382 26.5750000 0.088033 26.5777778 0.089703 26.5805556 0.083024 26.5833333 0.083024 26.5861111 0.076345 26.5888889 0.074675 26.5916667 0.083024 26.5944444 0.083024 26.5972222 0.084694 26.6000000 0.086364 26.6027778 0.086364 26.6055556 0.081354 26.6083333 0.083024 26.6111111 0.079685 26.6138889 0.076345 26.6166667 0.078015 26.6194444 0.078015 26.6222222 0.081354 26.6250000 0.091373 26.6277778 0.098052 26.6305556 0.104731 26.6333333 0.111410 26.6361111 0.114750 26.6388889 0.121429 26.6416667 0.129777 26.6444444 0.136456 26.6472222 0.153154 26.6500000 0.164842 26.6527778 0.171521 26.6555556 0.169852 26.6583333 0.138126 26.6611111 0.104731 26.6638889 0.059647 26.6666667 0.010000 26.6694444 0.010000 26.6722222 0.010000 26.6750000 0.010000 26.6777778 0.010000 26.6805556 0.010000 26.6833333 0.010000 26.6861111 0.010000 26.6888889 0.010000 26.6916667 0.010000 26.6944444 0.010000 26.6972222 0.010000 26.7000000 0.010000 26.7027778 0.010000 26.7055556 0.010000 26.7083333 0.010000 26.7111111 0.010000 26.7138889 0.010000 26.7166667 0.010000 26.7194444 0.010000 26.7222222 0.010000 26.7250000 0.010000 26.7277778 0.010000 26.7305556 0.010000 26.7333333 0.010000 26.7361111 0.010000 26.7388889 0.010000 26.7416667 0.010000 26.7444444 0.010000 26.7472222 0.010000 26.7500000 0.010000 26.7527778 0.010000 26.7555556 0.010000 26.7583333 0.010000 26.7611111 0.010000 26.7638889 0.010000 26.7666667 0.017904 26.7694444 0.062987 26.7722222 0.084694 26.7750000 0.109740 26.7777778 0.114750 26.7805556 0.114750 26.7833333 0.111410 26.7861111 0.113080 26.7888889 0.118089 26.7916667 0.134787 26.7944444 0.136456 26.7972222 0.151484 26.8000000 0.156494 26.8027778 0.161503 26.8055556 0.168182 26.8083333 0.163173 26.8111111 0.169852 26.8138889 0.169852 26.8166667 0.168182 26.8194444 0.169852 26.8222222 0.173191 26.8250000 0.183210 26.8277778 0.189889 26.8305556 0.188219 26.8333333 0.201577 26.8361111 0.206586 26.8388889 0.204917 26.8416667 0.208256 26.8444444 0.214935 26.8472222 0.213265 26.8500000 0.219944 26.8527778 0.226623 26.8555556 0.228293 26.8583333 0.241651 26.8611111 0.244991 26.8638889 0.263358 26.8666667 0.270037 26.8694444 0.278386 26.8722222 0.281725 26.8750000 0.286735 26.8777778 0.290074 26.8805556 0.286735 26.8833333 0.286735 26.8861111 0.280056 26.8888889 0.281725 26.8916667 0.280056 26.8944444 0.285065 26.8972222 0.293414 26.9000000 0.306772 26.9027778 0.318460 26.9055556 0.316790 26.9083333 0.326809 26.9111111 0.323469 26.9138889 0.326809 26.9166667 0.333488 26.9194444 0.338497 26.9222222 0.351855 26.9250000 0.368553 26.9277778 0.381911 26.9305556 0.391929 26.9333333 0.406957 26.9361111 0.411967 26.9388889 0.418646 26.9416667 0.408627 26.9444444 0.413636 26.9472222 0.418646 26.9500000 0.421985 26.9527778 0.420315 26.9555556 0.426994 26.9583333 0.421985 26.9611111 0.425325 26.9638889 0.426994 26.9666667 0.430334 26.9694444 0.423655 26.9722222 0.415306 26.9750000 0.405288 26.9777778 0.396939 26.9805556 0.385250 26.9833333 0.378571 26.9861111 0.368553 26.9888889 0.360204 26.9916667 0.358534 26.9944444 0.351855 26.9972222 0.341837 27.0000000 0.331818 27.0027778 0.318460 27.0055556 0.316790 27.0083333 0.301763 27.0111111 0.280056 27.0138889 0.271707 27.0166667 0.253340 27.0194444 0.243321 27.0222222 0.233302 27.0250000 0.219944 27.0277778 0.213265 27.0305556 0.206586 27.7222222 0.088033 27.7250000 0.086364 27.7277778 0.089703 27.7305556 0.091373 27.7333333 0.099722 27.7361111 0.096382 27.7388889 0.096382 27.7416667 0.094712 27.7444444 0.093043 27.7472222 0.088033 27.7500000 0.081354 27.7527778 0.088033 27.7555556 0.088033 27.7583333 0.089703 27.7611111 0.086364 27.7638889 0.094712 27.7666667 0.091373 27.7694444 0.094712 27.7722222 0.096382 27.7750000 0.096382 27.7777778 0.094712 27.7805556 0.096382 27.7833333 0.094712 27.7861111 0.091373 27.7888889 0.094712 27.7916667 0.101391 27.7944444 0.108071 27.7972222 0.108071 27.8000000 0.116419 27.8027778 0.126438 27.8055556 0.123098 27.8083333 0.123098 27.8111111 0.116419 27.8138889 0.116419 27.8166667 0.113080 27.8194444 0.119759 27.8222222 0.116419 27.8250000 0.124768 27.8277778 0.124768 27.8305556 0.123098 27.8333333 0.123098 27.8361111 0.119759 27.8388889 0.113080 27.8416667 0.101391 27.8444444 0.101391 27.8472222 0.091373 27.8500000 0.089703 27.8527778 0.088033 27.8555556 0.091373 27.8583333 0.091373 27.8611111 0.093043 27.8638889 0.099722 27.8666667 0.093043 27.8694444 0.098052 27.8722222 0.099722 27.8750000 0.098052 27.8777778 0.088033 27.8805556 0.084694 27.8833333 0.081354 27.8861111 0.083024 27.8888889 0.081354 27.8916667 0.083024 27.8944444 0.083024 27.8972222 0.086364 27.9000000 0.089703 27.9027778 0.096382 27.9055556 0.091373 27.9083333 0.094712 27.9111111 0.089703 27.9138889 0.086364 27.9166667 0.084694 27.9194444 0.079685 27.9222222 0.086364 27.9250000 0.086364 27.9277778 0.088033 27.9305556 0.096382 27.9333333 0.096382 27.9361111 0.093043 27.9388889 0.094712 27.9416667 0.094712 27.9444444 0.106401 27.9472222 0.111410 27.9500000 0.123098 27.9527778 0.131447 27.9555556 0.143135 27.9583333 0.141466 27.9611111 0.133117 27.9638889 0.098052 27.9666667 0.047959 27.9694444 0.010000 27.9722222 0.010000 27.9750000 0.010000 27.9777778 0.010000 27.9805556 0.010000 27.9833333 0.010000 27.9861111 0.010000 27.9888889 0.010000 27.9916667 0.010000 27.9944444 0.010000 27.9972222 0.010000 28.0000000 0.010000 28.0027778 0.010000 28.0055556 0.010000 28.0083333 0.010000 28.0111111 0.019573 28.0138889 0.032931 28.0166667 0.046289 28.0194444 0.052968 28.0222222 0.067996 28.0250000 0.081354 28.0277778 0.088033 28.0305556 0.093043 28.0333333 0.098052 28.0361111 0.104731 28.0388889 0.104731 28.0416667 0.106401 28.0444444 0.099722 28.0472222 0.101391 28.0500000 0.098052 28.0527778 0.099722 28.0555556 0.094712 28.0583333 0.104731 28.0611111 0.104731 28.0638889 0.116419 28.0666667 0.109740 28.0694444 0.116419 28.0722222 0.113080 28.0750000 0.113080 28.0777778 0.109740 28.0805556 0.109740 28.0833333 0.103061 28.0861111 0.104731 28.0888889 0.106401 28.0916667 0.109740 28.0944444 0.121429 28.0972222 0.121429 28.1000000 0.124768 28.1027778 0.123098 28.1055556 0.123098 28.1083333 0.123098 28.1111111 0.121429 28.1138889 0.114750 28.1166667 0.116419 28.1194444 0.109740 28.1222222 0.111410 28.1250000 0.114750 28.1277778 0.116419 28.1305556 0.119759 28.1333333 0.123098 28.1361111 0.124768 28.1388889 0.119759 28.1416667 0.123098 28.1444444 0.114750 28.1472222 0.113080 28.1500000 0.111410 28.1527778 0.113080 28.1555556 0.114750 28.1583333 0.121429 28.1611111 0.123098 28.1638889 0.126438 28.1666667 0.128108 28.1694444 0.138126 28.1722222 0.131447 28.1750000 0.131447 28.1777778 0.123098 28.1805556 0.126438 28.1833333 0.123098 28.1861111 0.116419 28.1888889 0.124768 28.1916667 0.121429 28.1944444 0.124768 28.1972222 0.129777 28.2000000 0.138126 28.2027778 0.129777 28.2055556 0.139796 28.2083333 0.131447 28.2111111 0.136456 28.2138889 0.134787 28.2166667 0.131447 28.2194444 0.133117 28.2222222 0.138126 28.2250000 0.138126 28.2277778 0.141466 28.2305556 0.148145 28.2333333 0.144805 28.2361111 0.143135 28.2388889 0.149814 28.2416667 0.148145 28.2444444 0.143135 28.2472222 0.143135 28.2500000 0.139796 28.2527778 0.138126 28.2555556 0.134787 28.2583333 0.134787 28.2611111 0.138126 28.2638889 0.138126 28.2666667 0.144805 28.2694444 0.143135 28.2722222 0.143135 28.2750000 0.141466 28.2777778 0.138126 28.2805556 0.131447 28.2833333 0.129777 28.2861111 0.126438 28.2888889 0.128108 28.2916667 0.126438 28.2944444 0.124768 28.2972222 0.128108 28.3000000 0.126438 28.3027778 0.126438 28.3055556 0.118089 28.3083333 0.114750 28.3111111 0.113080 28.3138889 0.116419 28.3166667 0.104731 28.3194444 0.109740 28.3222222 0.104731 28.3250000 0.106401 28.3277778 0.109740 28.3305556 0.111410 28.3333333 0.114750 28.3361111 0.119759 28.3388889 0.119759 28.3416667 0.116419 28.3444444 0.113080 28.3472222 0.116419 28.3500000 0.114750 28.3527778 0.114750 28.3555556 0.109740 28.3583333 0.116419 28.3611111 0.118089 28.3638889 0.121429 28.3666667 0.123098 28.3694444 0.119759 28.3722222 0.119759 28.3750000 0.121429 28.3777778 0.111410 28.3805556 0.111410 28.3833333 0.108071 28.3861111 0.106401 28.3888889 0.103061 28.3916667 0.106401 28.3944444 0.108071 28.3972222 0.109740 28.4000000 0.109740 28.4027778 0.111410 28.4055556 0.111410 28.4083333 0.114750 28.4111111 0.109740 28.4138889 0.111410 28.4166667 0.108071 28.4194444 0.104731 28.4222222 0.106401 28.4250000 0.108071 28.4277778 0.111410 28.4305556 0.113080 28.4333333 0.118089 28.4361111 0.113080 28.4388889 0.113080 28.4416667 0.113080 28.4444444 0.111410 28.4472222 0.103061 28.4500000 0.103061 28.4527778 0.094712 28.4555556 0.099722 28.4583333 0.108071 28.4611111 0.108071 28.4638889 0.119759 28.4666667 0.133117 28.4694444 0.139796 28.4722222 0.153154 28.4750000 0.164842 28.4777778 0.178200 28.4805556 0.181540 28.4833333 0.186549 28.4861111 0.174861 28.4888889 0.139796 28.4916667 0.101391 28.4944444 0.061317 28.4972222 0.016234 28.5000000 0.010000 28.5027778 0.010000 28.5055556 0.010000 28.5083333 0.010000 28.5111111 0.010000 28.5138889 0.010000 28.5166667 0.010000 28.5194444 0.010000 28.5222222 0.010000 28.5250000 0.010000 28.5277778 0.010000 28.5305556 0.010000 28.5333333 0.010000 28.5361111 0.010000 28.5388889 0.010000 28.5416667 0.010000 28.5444444 0.010000 28.5472222 0.010000 28.5500000 0.010000 28.5527778 0.010000 28.5555556 0.010000 28.5583333 0.010000 28.5611111 0.010000 28.5638889 0.010000 28.5666667 0.010000 28.5694444 0.010000 28.5722222 0.010000 28.5750000 0.010000 28.5777778 0.010000 28.5805556 0.010000 28.5833333 0.010000 28.5861111 0.010000 28.5888889 0.010000 28.5916667 0.010000 28.5944444 0.010000 28.5972222 0.046289 28.6000000 0.084694 28.6027778 0.111410 28.6055556 0.126438 28.6083333 0.143135 28.6111111 0.143135 28.6138889 0.143135 28.6166667 0.143135 28.6194444 0.141466 28.6222222 0.146475 28.6250000 0.158163 28.6277778 0.166512 28.6305556 0.174861 28.6333333 0.183210 28.6361111 0.184879 28.6388889 0.189889 28.6416667 0.186549 28.6444444 0.184879 28.6472222 0.184879 28.6500000 0.179870 28.6527778 0.186549 28.6555556 0.184879 28.6583333 0.194898 28.6611111 0.198237 28.6638889 0.206586 28.6666667 0.213265 28.6694444 0.223284 28.6722222 0.216605 28.6750000 0.216605 28.6777778 0.216605 28.6805556 0.221614 28.6833333 0.216605 28.6861111 0.218275 28.6888889 0.224954 28.6916667 0.224954 28.6944444 0.234972 28.6972222 0.241651 28.7000000 0.250000 28.7027778 0.256679 28.7055556 0.256679 28.7083333 0.256679 28.7111111 0.253340 28.7138889 0.261688 28.7166667 0.263358 28.7194444 0.270037 28.7222222 0.276716 28.7250000 0.285065 28.7277778 0.291744 28.7305556 0.308442 28.7333333 0.320130 28.7361111 0.330148 28.7388889 0.341837 28.7416667 0.350186 28.7444444 0.353525 28.7472222 0.356865 28.7500000 0.360204 28.7527778 0.373562 28.7555556 0.378571 28.7583333 0.391929 28.7611111 0.401948 28.7638889 0.410297 28.7666667 0.415306 28.7694444 0.423655 28.7722222 0.416976 28.7750000 0.420315 28.7777778 0.413636 28.7805556 0.413636 28.7833333 0.411967 28.7861111 0.411967 28.7888889 0.418646 28.7916667 0.425325 28.7944444 0.435343 28.7972222 0.442022 28.8000000 0.448701 28.8027778 0.453711 28.8055556 0.450371 28.8083333 0.452041 28.8111111 0.445362 28.8138889 0.443692 28.8166667 0.437013 28.8194444 0.426994 29.6055556 0.104731 29.6083333 0.101391 29.6111111 0.103061 29.6138889 0.096382 29.6166667 0.094712 29.6194444 0.088033 29.6222222 0.091373 29.6250000 0.091373 29.6277778 0.096382 29.6305556 0.098052 29.6333333 0.099722 29.6361111 0.101391 29.6388889 0.099722 29.6416667 0.091373 29.6444444 0.091373 29.6472222 0.094712 29.6500000 0.086364 29.6527778 0.081354 29.6555556 0.091373 29.6583333 0.089703 29.6611111 0.096382 29.6638889 0.096382 29.6666667 0.106401 29.6694444 0.099722 29.6722222 0.106401 29.6750000 0.103061 29.6777778 0.101391 29.6805556 0.101391 29.6833333 0.104731 29.6861111 0.109740 29.6888889 0.104731 29.6916667 0.109740 29.6944444 0.116419 29.6972222 0.121429 29.7000000 0.128108 29.7027778 0.126438 29.7055556 0.128108 29.7083333 0.123098 29.7111111 0.119759 29.7138889 0.113080 29.7166667 0.111410 29.7194444 0.101391 29.7222222 0.094712 29.7250000 0.091373 29.7277778 0.094712 29.7305556 0.098052 29.7333333 0.093043 29.7361111 0.098052 29.7388889 0.099722 29.7416667 0.093043 29.7444444 0.086364 29.7472222 0.079685 29.7500000 0.079685 29.7527778 0.078015 29.7555556 0.079685 29.7583333 0.081354 29.7611111 0.086364 29.7638889 0.088033 29.7666667 0.091373 29.7694444 0.088033 29.7722222 0.086364 29.7750000 0.081354 29.7777778 0.078015 29.7805556 0.079685 29.7833333 0.076345 29.7861111 0.079685 29.7888889 0.078015 29.7916667 0.078015 29.7944444 0.089703 29.7972222 0.089703 29.8000000 0.091373 29.8027778 0.091373 29.8055556 0.089703 29.8083333 0.084694 29.8111111 0.084694 29.8138889 0.079685 29.8166667 0.076345 29.8194444 0.079685 29.8222222 0.083024 29.8250000 0.088033 29.8277778 0.098052 29.8305556 0.116419 29.8333333 0.133117 29.8361111 0.141466 29.8388889 0.149814 29.8416667 0.138126 29.8444444 0.111410 29.8472222 0.061317 29.8500000 0.010000 29.8527778 0.010000 29.8555556 0.010000 29.8583333 0.010000 29.8611111 0.010000 29.8638889 0.010000 29.8666667 0.010000 29.8694444 0.010000 29.8722222 0.010000 29.8750000 0.010000 29.8777778 0.010000 29.8805556 0.010000 29.8833333 0.010000 29.8861111 0.010000 29.8888889 0.010000 29.8916667 0.010000 29.8944444 0.017904 29.8972222 0.037941 29.9000000 0.056308 29.9027778 0.067996 29.9055556 0.083024 29.9083333 0.084694 29.9111111 0.091373 29.9138889 0.083024 29.9166667 0.086364 29.9194444 0.084694 29.9222222 0.091373 29.9250000 0.096382 29.9277778 0.096382 29.9305556 0.104731 29.9333333 0.106401 29.9361111 0.111410 29.9388889 0.106401 29.9416667 0.106401 29.9444444 0.106401 29.9472222 0.106401 29.9500000 0.104731 29.9527778 0.099722 29.9555556 0.103061 29.9583333 0.103061 29.9611111 0.104731 29.9638889 0.109740 29.9666667 0.111410 29.9694444 0.118089 29.9722222 0.118089 29.9750000 0.119759 29.9777778 0.123098 29.9805556 0.118089 29.9833333 0.111410 29.9861111 0.104731 29.9888889 0.108071 29.9916667 0.109740 29.9944444 0.113080 29.9972222 0.118089 30.0000000 0.121429 30.0027778 0.123098 30.0055556 0.119759 30.0083333 0.119759 30.0111111 0.118089 30.0138889 0.109740 30.0166667 0.109740 30.0194444 0.109740 30.0222222 0.106401 30.0250000 0.109740 30.0277778 0.116419 30.0305556 0.116419 30.0333333 0.126438 30.0361111 0.128108 30.0388889 0.129777 30.0416667 0.129777 30.0444444 0.126438 30.0472222 0.119759 30.0500000 0.119759 30.0527778 0.118089 30.0555556 0.116419 30.0583333 0.114750 30.0611111 0.119759 30.0638889 0.126438 30.0666667 0.129777 30.0694444 0.129777 30.0722222 0.129777 30.0750000 0.126438 30.0777778 0.124768 30.0805556 0.124768 30.0833333 0.114750 30.0861111 0.118089 30.0888889 0.119759 30.0916667 0.121429 30.0944444 0.121429 30.0972222 0.133117 30.1000000 0.138126 30.1027778 0.138126 30.1055556 0.136456 30.1083333 0.134787 30.1111111 0.136456 30.1138889 0.129777 30.1166667 0.128108 30.1194444 0.123098 30.1222222 0.121429 30.1250000 0.121429 30.1277778 0.124768 30.1305556 0.124768 30.1333333 0.126438 30.1361111 0.138126 30.1388889 0.131447 30.1416667 0.124768 30.1444444 0.119759 30.1472222 0.118089 30.1500000 0.111410 30.1527778 0.111410 30.4888889 0.094712 30.4916667 0.101391 30.4944444 0.094712 30.4972222 0.101391 30.5000000 0.098052 30.5027778 0.103061 30.5055556 0.104731 30.5083333 0.101391 30.5111111 0.101391 30.5138889 0.094712 30.5166667 0.094712 30.5194444 0.091373 30.5222222 0.096382 30.5250000 0.096382 30.5277778 0.099722 30.5305556 0.104731 30.5333333 0.103061 30.5361111 0.116419 30.5388889 0.111410 30.5416667 0.109740 30.5444444 0.111410 30.5472222 0.106401 30.5500000 0.103061 30.5527778 0.111410 30.5555556 0.113080 30.5583333 0.109740 30.5611111 0.118089 30.5638889 0.118089 30.5666667 0.126438 30.5694444 0.133117 30.5722222 0.133117 30.5750000 0.134787 30.5777778 0.133117 30.5805556 0.123098 30.5833333 0.118089 30.5861111 0.108071 30.5888889 0.104731 30.5916667 0.096382 30.5944444 0.094712 30.5972222 0.093043 30.6000000 0.101391 30.6027778 0.096382 30.6055556 0.101391 30.6083333 0.098052 30.6111111 0.093043 30.6138889 0.086364 30.6166667 0.086364 30.6194444 0.081354 30.6222222 0.081354 30.6250000 0.084694 30.6277778 0.083024 30.6305556 0.081354 30.6333333 0.091373 30.6361111 0.091373 30.6388889 0.088033 30.6416667 0.089703 30.6444444 0.091373 30.6472222 0.086364 30.6500000 0.083024 30.6527778 0.081354 30.6555556 0.083024 30.6583333 0.078015 30.6611111 0.078015 30.6638889 0.083024 30.6666667 0.079685 30.6694444 0.089703 30.6722222 0.091373 30.6750000 0.089703 30.6777778 0.086364 30.6805556 0.079685 30.6833333 0.079685 30.6861111 0.078015 30.6888889 0.076345 30.6916667 0.076345 30.6944444 0.079685 30.6972222 0.084694 30.7000000 0.091373 30.7027778 0.096382 30.7055556 0.108071 30.7083333 0.119759 30.7111111 0.126438 30.7138889 0.141466 30.7166667 0.151484 30.7194444 0.154824 30.7222222 0.134787 30.7250000 0.113080 30.7277778 0.083024 30.7305556 0.041280 30.7333333 0.010000 30.7361111 0.010000 30.7388889 0.010000 30.7416667 0.010000 30.7444444 0.010000 30.7472222 0.010000 30.7500000 0.010000 30.7527778 0.010000 30.7555556 0.010000 30.7583333 0.010000 30.7611111 0.010000 30.7638889 0.010000 30.7666667 0.010000 30.7694444 0.010000 30.7722222 0.010000 30.7750000 0.010000 30.7777778 0.021243 30.7805556 0.034601 30.7833333 0.054638 30.7861111 0.064657 30.7888889 0.076345 30.7916667 0.079685 30.7944444 0.081354 30.7972222 0.093043 30.8000000 0.099722 30.8027778 0.101391 30.8055556 0.099722 30.8083333 0.108071 30.8111111 0.104731 30.8138889 0.096382 30.8166667 0.099722 30.8194444 0.098052 30.8222222 0.098052 30.8250000 0.101391 30.8277778 0.104731 30.8305556 0.106401 30.8333333 0.108071 30.8361111 0.111410 30.8388889 0.118089 30.8416667 0.116419 30.8444444 0.119759 30.8472222 0.118089 30.8500000 0.108071 30.8527778 0.104731 30.8555556 0.104731 30.8583333 0.101391 30.8611111 0.106401 30.8638889 0.118089 30.8666667 0.119759 30.8694444 0.118089 30.8722222 0.116419 30.8750000 0.118089 30.8777778 0.114750 30.8805556 0.111410 30.8833333 0.109740 30.8861111 0.104731 30.8888889 0.108071 30.8916667 0.108071 30.8944444 0.111410 30.8972222 0.116419 30.9000000 0.119759 30.9027778 0.121429 30.9055556 0.119759 30.9083333 0.123098 30.9111111 0.119759 30.9138889 0.116419 30.9166667 0.116419 30.9194444 0.109740 30.9222222 0.104731 30.9250000 0.106401 30.9277778 0.111410 30.9305556 0.114750 30.9333333 0.124768 30.9361111 0.123098 30.9388889 0.126438 30.9416667 0.119759 30.9444444 0.119759 30.9472222 0.111410 30.9500000 0.109740 30.9527778 0.108071 30.9555556 0.109740 30.9583333 0.108071 30.9611111 0.114750 30.9638889 0.116419 30.9666667 0.124768 30.9694444 0.128108 30.9722222 0.133117 30.9750000 0.128108 30.9777778 0.126438 30.9805556 0.126438 30.9833333 0.119759 30.9861111 0.114750 30.9888889 0.116419 30.9916667 0.113080 30.9944444 0.119759 30.9972222 0.126438 31.0000000 0.124768 31.0027778 0.131447 31.0055556 0.121429 31.0083333 0.119759 31.0111111 0.119759 31.0138889 0.119759 31.0166667 0.116419 31.0194444 0.113080 31.0222222 0.113080 31.0250000 0.113080 31.0277778 0.119759 31.0305556 0.121429 31.0333333 0.126438 31.0361111 0.128108 31.3861111 0.106401 31.3888889 0.094712 31.3916667 0.103061 31.3944444 0.096382 31.3972222 0.099722 31.4000000 0.101391 31.4027778 0.108071 31.4055556 0.108071 31.4083333 0.108071 31.4111111 0.106401 31.4138889 0.104731 31.4166667 0.103061 31.4194444 0.101391 31.4222222 0.101391 31.4250000 0.101391 31.4277778 0.106401 31.4305556 0.106401 31.4333333 0.109740 31.4361111 0.114750 31.4388889 0.121429 31.4416667 0.118089 31.4444444 0.118089 31.4472222 0.118089 31.4500000 0.114750 31.4527778 0.114750 31.4555556 0.118089 31.4583333 0.116419 31.4611111 0.121429 31.4638889 0.126438 31.4666667 0.134787 31.4694444 0.143135 31.4722222 0.144805 31.4750000 0.146475 31.4777778 0.146475 31.4805556 0.138126 31.4833333 0.131447 31.4861111 0.123098 31.4888889 0.113080 31.4916667 0.104731 31.4944444 0.104731 31.4972222 0.104731 31.5000000 0.099722 31.5027778 0.099722 31.5055556 0.099722 31.5083333 0.104731 31.5111111 0.098052 31.5138889 0.088033 31.5166667 0.089703 31.5194444 0.086364 31.5222222 0.084694 31.5250000 0.093043 31.5277778 0.088033 31.5305556 0.096382 31.5333333 0.101391 31.5361111 0.099722 31.5388889 0.101391 31.5416667 0.093043 31.5444444 0.098052 31.5472222 0.096382 31.5500000 0.089703 31.5527778 0.083024 31.5555556 0.084694 31.5583333 0.084694 31.5611111 0.088033 31.5638889 0.094712 31.5666667 0.094712 31.5694444 0.101391 31.5722222 0.099722 31.5750000 0.096382 31.5777778 0.091373 31.5805556 0.083024 31.5833333 0.088033 31.5861111 0.081354 31.5888889 0.084694 31.5916667 0.083024 31.5944444 0.089703 31.5972222 0.093043 31.6000000 0.096382 31.6027778 0.101391 31.6055556 0.108071 31.6083333 0.113080 31.6111111 0.126438 31.6138889 0.139796 31.6166667 0.148145 31.6194444 0.156494 31.6222222 0.151484 31.6250000 0.126438 31.6277778 0.083024 31.6305556 0.021243 31.6333333 0.010000 31.6361111 0.010000 31.6388889 0.010000 31.6416667 0.010000 31.6444444 0.010000 31.6472222 0.010000 31.6500000 0.010000 31.6527778 0.010000 31.6555556 0.010000 31.6583333 0.010000 31.6611111 0.010000 31.6638889 0.010000 31.6666667 0.010000 31.6694444 0.010000 31.6722222 0.010000 31.6750000 0.034601 31.6777778 0.049629 31.6805556 0.061317 31.6833333 0.076345 31.6861111 0.079685 31.6888889 0.083024 31.6916667 0.083024 31.6944444 0.089703 31.6972222 0.096382 31.7000000 0.099722 31.7027778 0.109740 31.7055556 0.116419 31.7083333 0.109740 31.7111111 0.109740 31.7138889 0.106401 31.7166667 0.109740 31.7194444 0.111410 31.7222222 0.113080 31.7250000 0.114750 31.7277778 0.114750 31.7305556 0.116419 31.7333333 0.119759 31.7361111 0.123098 31.7388889 0.129777 31.7416667 0.126438 31.7444444 0.119759 31.7472222 0.114750 31.7500000 0.111410 31.7527778 0.109740 31.7555556 0.113080 31.7583333 0.109740 31.7611111 0.113080 31.7638889 0.118089 31.7666667 0.121429 31.7694444 0.118089 31.7722222 0.124768 31.7750000 0.119759 31.7777778 0.121429 31.7805556 0.121429 31.7833333 0.121429 31.7861111 0.114750 31.7888889 0.116419 31.7916667 0.119759 31.7944444 0.119759 31.7972222 0.126438 31.8000000 0.126438 31.8027778 0.131447 31.8055556 0.129777 31.8083333 0.133117 31.8111111 0.129777 31.8138889 0.128108 31.8166667 0.124768 31.8194444 0.121429 31.8222222 0.121429 31.8250000 0.119759 31.8277778 0.121429 31.8305556 0.131447 31.8333333 0.131447 31.8361111 0.133117 31.8388889 0.134787 31.8416667 0.136456 31.8444444 0.136456 31.8472222 0.131447 31.8500000 0.133117 31.8527778 0.131447 31.8555556 0.131447 31.8583333 0.131447 31.8611111 0.136456 31.8638889 0.138126 31.8666667 0.146475 31.8694444 0.143135 31.8722222 0.146475 31.8750000 0.146475 31.8777778 0.141466 31.8805556 0.139796 31.8833333 0.141466 31.8861111 0.141466 31.8888889 0.136456 31.8916667 0.134787 31.8944444 0.143135 31.8972222 0.134787 31.9000000 0.143135 31.9027778 0.149814 31.9055556 0.144805 31.9083333 0.146475 31.9111111 0.146475 31.9138889 0.139796 31.9166667 0.139796 31.9194444 0.133117 31.9222222 0.131447 31.9250000 0.131447 31.9277778 0.128108 31.9305556 0.136456 31.9333333 0.139796 32.2638889 0.089703 32.2666667 0.096382 32.2694444 0.106401 32.2722222 0.101391 32.2750000 0.106401 32.2777778 0.104731 32.2805556 0.099722 32.2833333 0.091373 32.2861111 0.094712 32.2888889 0.093043 32.2916667 0.094712 32.2944444 0.094712 32.2972222 0.099722 32.3000000 0.099722 32.3027778 0.103061 32.3055556 0.103061 32.3083333 0.104731 32.3111111 0.109740 32.3138889 0.098052 32.3166667 0.094712 32.3194444 0.098052 32.3222222 0.103061 32.3250000 0.108071 32.3277778 0.106401 32.3305556 0.118089 32.3333333 0.119759 32.3361111 0.128108 32.3388889 0.128108 32.3416667 0.133117 32.3444444 0.134787 32.3472222 0.134787 32.3500000 0.129777 32.3527778 0.128108 32.3555556 0.124768 32.3583333 0.119759 32.3611111 0.109740 32.3638889 0.111410 32.3666667 0.106401 32.3694444 0.106401 32.3722222 0.098052 32.3750000 0.094712 32.3777778 0.093043 32.3805556 0.086364 32.3833333 0.088033 32.3861111 0.078015 32.3888889 0.071336 32.3916667 0.071336 32.3944444 0.074675 32.3972222 0.079685 32.4000000 0.086364 32.4027778 0.091373 32.4055556 0.091373 32.4083333 0.096382 32.4111111 0.093043 32.4138889 0.084694 32.4166667 0.084694 32.4194444 0.079685 32.4222222 0.074675 32.4250000 0.078015 32.4277778 0.076345 32.4305556 0.076345 32.4333333 0.084694 32.4361111 0.084694 32.4388889 0.083024 32.4416667 0.084694 32.4444444 0.079685 32.4472222 0.078015 32.4500000 0.076345 32.4527778 0.069666 32.4555556 0.069666 32.4583333 0.069666 32.4611111 0.076345 32.4638889 0.081354 32.4666667 0.081354 32.4694444 0.088033 32.4722222 0.088033 32.4750000 0.086364 32.4777778 0.086364 32.4805556 0.088033 32.4833333 0.088033 32.4861111 0.099722 32.4888889 0.116419 32.4916667 0.136456 32.4944444 0.149814 32.4972222 0.148145 32.5000000 0.134787 32.5027778 0.104731 32.5055556 0.051299 32.5083333 0.010000 32.5111111 0.010000 32.5138889 0.010000 32.5166667 0.010000 32.5194444 0.010000 32.5222222 0.010000 32.5250000 0.010000 32.5277778 0.010000 32.5305556 0.010000 32.5333333 0.010000 32.5361111 0.010000 32.5388889 0.010000 32.5416667 0.010000 32.5444444 0.010000 32.5472222 0.010000 32.5500000 0.010000 32.5527778 0.012894 32.5555556 0.032931 32.5583333 0.042950 32.5611111 0.059647 32.5638889 0.066327 32.5666667 0.071336 32.5694444 0.084694 32.5722222 0.078015 32.5750000 0.081354 32.5777778 0.081354 32.5805556 0.084694 32.5833333 0.083024 32.5861111 0.083024 32.5888889 0.084694 32.5916667 0.089703 32.5944444 0.091373 32.5972222 0.096382 32.6000000 0.101391 32.6027778 0.106401 32.6055556 0.103061 32.6083333 0.106401 32.6111111 0.096382 32.6138889 0.098052 32.6166667 0.091373 32.6194444 0.093043 32.6222222 0.088033 32.6250000 0.091373 32.6277778 0.094712 32.6305556 0.094712 32.6333333 0.098052 32.6361111 0.098052 32.6388889 0.104731 32.6416667 0.108071 32.6444444 0.103061 32.6472222 0.103061 32.6500000 0.093043 32.6527778 0.101391 32.6555556 0.098052 32.6583333 0.099722 32.6611111 0.103061 32.6638889 0.103061 32.6666667 0.103061 32.6694444 0.106401 32.6722222 0.108071 32.6750000 0.109740 32.6777778 0.108071 32.6805556 0.101391 32.6833333 0.099722 32.6861111 0.091373 32.6888889 0.096382 32.6916667 0.094712 32.6944444 0.096382 32.6972222 0.099722 32.7000000 0.098052 32.7027778 0.104731 32.7055556 0.106401 32.7083333 0.103061 32.7111111 0.103061 32.7138889 0.106401 32.7166667 0.104731 32.7194444 0.096382 32.7222222 0.098052 32.7250000 0.098052 32.7277778 0.098052 32.7305556 0.103061 32.7333333 0.103061 32.7361111 0.108071 32.7388889 0.108071 32.7416667 0.111410 32.7444444 0.113080 32.7472222 0.104731 32.7500000 0.103061 32.7527778 0.098052 32.7555556 0.093043 32.7583333 0.094712 32.7611111 0.093043 32.7638889 0.099722 32.7666667 0.103061 32.7694444 0.104731 32.7722222 0.104731 32.7750000 0.103061 32.7777778 0.111410 32.7805556 0.098052 32.7833333 0.098052 32.7861111 0.096382 32.7888889 0.088033 32.7916667 0.089703 32.7944444 0.084694 32.7972222 0.089703 32.8000000 0.089703 32.8027778 0.094712 32.8055556 0.093043 32.8083333 0.088033 32.8111111 0.084694 33.1027778 0.081354 33.1055556 0.083024 33.1083333 0.084694 33.1111111 0.081354 33.1138889 0.079685 33.1166667 0.076345 33.1194444 0.073006 33.1222222 0.076345 33.1250000 0.069666 33.1277778 0.073006 33.1305556 0.088033 33.1333333 0.088033 33.1361111 0.089703 33.1388889 0.089703 33.1416667 0.089703 33.1444444 0.094712 33.1472222 0.084694 33.1500000 0.079685 33.1527778 0.078015 33.1555556 0.079685 33.1583333 0.079685 33.1611111 0.081354 33.1638889 0.088033 33.1666667 0.093043 33.1694444 0.101391 33.1722222 0.108071 33.1750000 0.104731 33.1777778 0.104731 33.1805556 0.103061 33.1833333 0.106401 33.1861111 0.101391 33.1888889 0.108071 33.1916667 0.104731 33.1944444 0.106401 33.1972222 0.104731 33.2000000 0.099722 33.2027778 0.089703 33.2055556 0.088033 33.2083333 0.083024 33.2111111 0.073006 33.2138889 0.067996 33.2166667 0.064657 33.2194444 0.061317 33.2222222 0.054638 33.2250000 0.057978 33.2277778 0.057978 33.2305556 0.061317 33.2333333 0.066327 33.2361111 0.074675 33.2388889 0.079685 33.2416667 0.069666 33.2444444 0.073006 33.2472222 0.069666 33.2500000 0.062987 33.2527778 0.062987 33.2555556 0.061317 33.2583333 0.057978 33.2611111 0.061317 33.2638889 0.064657 33.2666667 0.064657 33.2694444 0.069666 33.2722222 0.073006 33.2750000 0.069666 33.2777778 0.066327 33.2805556 0.067996 33.2833333 0.066327 33.2861111 0.059647 33.2888889 0.054638 33.2916667 0.061317 33.2944444 0.057978 33.2972222 0.062987 33.3000000 0.066327 33.3027778 0.062987 33.3055556 0.067996 33.3083333 0.073006 33.3111111 0.067996 33.3138889 0.069666 33.3166667 0.071336 33.3194444 0.071336 33.3222222 0.076345 33.3250000 0.081354 33.3277778 0.101391 33.3305556 0.121429 33.3333333 0.136456 33.3361111 0.139796 33.3388889 0.123098 33.3416667 0.098052 33.3444444 0.046289 33.3472222 0.010000 33.3500000 0.010000 33.3527778 0.010000 33.3555556 0.010000 33.3583333 0.010000 33.3611111 0.010000 33.3638889 0.010000 33.3666667 0.010000 33.3694444 0.010000 33.3722222 0.010000 33.3750000 0.010000 33.3777778 0.010000 33.3805556 0.010000 33.3833333 0.010000 33.3861111 0.010000 33.3888889 0.010000 33.3916667 0.010000 33.3944444 0.010000 33.3972222 0.010000 33.4000000 0.010000 33.4027778 0.032931 33.4055556 0.047959 33.4083333 0.052968 33.4111111 0.066327 33.4138889 0.059647 33.4166667 0.069666 33.4194444 0.061317 33.4222222 0.059647 33.4250000 0.064657 33.4277778 0.066327 33.4305556 0.067996 33.4333333 0.074675 33.4361111 0.078015 33.4388889 0.091373 33.4416667 0.084694 33.4444444 0.088033 33.4472222 0.088033 33.4500000 0.084694 33.4527778 0.083024 33.4555556 0.079685 33.4583333 0.091373 33.4611111 0.086364 33.4638889 0.086364 33.4666667 0.088033 33.4694444 0.093043 33.4722222 0.099722 33.4750000 0.098052 33.4777778 0.091373 33.4805556 0.093043 33.4833333 0.083024 33.4861111 0.084694 33.4888889 0.086364 33.4916667 0.088033 33.4944444 0.083024 33.4972222 0.089703 33.5000000 0.093043 33.5027778 0.093043 33.5055556 0.098052 33.5083333 0.093043 33.5111111 0.096382 33.5138889 0.096382 33.5166667 0.091373 33.5194444 0.089703 33.5222222 0.091373 33.5250000 0.084694 33.5277778 0.084694 33.5305556 0.088033 33.5333333 0.091373 33.5361111 0.091373 33.5388889 0.093043 33.5416667 0.091373 33.5444444 0.089703 33.5472222 0.091373 33.5500000 0.081354 33.5527778 0.083024 33.5555556 0.081354 33.5583333 0.081354 33.5611111 0.079685 33.5638889 0.081354 33.5666667 0.089703 33.5694444 0.093043 33.5722222 0.098052 33.5750000 0.093043 33.5777778 0.096382 33.5805556 0.094712 33.5833333 0.094712 33.5861111 0.091373 33.5888889 0.091373 33.5916667 0.089703 33.5944444 0.088033 33.5972222 0.091373 33.6000000 0.096382 33.6027778 0.106401 33.6055556 0.106401 33.6083333 0.108071 33.6111111 0.103061 33.6138889 0.099722 33.6166667 0.101391 33.6194444 0.094712 33.6222222 0.098052 33.6250000 0.089703 33.6277778 0.088033 33.6305556 0.096382 33.6333333 0.106401 33.6361111 0.106401 33.6388889 0.109740 33.6416667 0.111410 33.6444444 0.103061 33.6472222 0.098052 33.6500000 0.096382 33.6527778 0.091373 33.6555556 0.091373 33.6583333 0.089703 33.6611111 0.089703 33.6638889 0.091373 33.6666667 0.093043 33.6694444 0.096382 33.6722222 0.093043 33.6750000 0.094712 33.6777778 0.089703 33.6805556 0.088033 33.6833333 0.078015 33.6861111 0.081354 33.6888889 0.083024 33.6916667 0.081354 33.6944444 0.083024 33.6972222 0.091373 33.7000000 0.093043 33.7027778 0.099722 33.7055556 0.103061 33.7083333 0.103061 33.7111111 0.096382 33.7138889 0.096382 33.7166667 0.089703 33.7194444 0.086364 33.7222222 0.093043 33.7250000 0.086364 33.7277778 0.084694 33.7305556 0.086364 33.7333333 0.091373 33.7361111 0.094712 33.7388889 0.096382 33.7416667 0.091373 33.7444444 0.089703 33.7472222 0.086364 33.7500000 0.081354 33.7527778 0.078015 33.7555556 0.076345 33.7583333 0.074675 33.7611111 0.081354 33.7638889 0.083024 33.7666667 0.089703 33.7694444 0.094712 33.7722222 0.096382 33.7750000 0.089703 33.7777778 0.084694 33.7805556 0.083024 33.7833333 0.078015 33.7861111 0.078015 33.7888889 0.073006 33.7916667 0.073006 33.7944444 0.076345 33.7972222 0.081354 33.8000000 0.078015 33.8027778 0.084694 33.8055556 0.081354 33.8083333 0.084694 33.8111111 0.081354 33.8138889 0.076345 33.8166667 0.081354 33.8194444 0.076345 33.8222222 0.074675 33.8250000 0.078015 33.8277778 0.083024 33.8305556 0.088033 33.8333333 0.094712 33.8361111 0.101391 33.8388889 0.108071 33.8416667 0.111410 33.8444444 0.118089 33.8472222 0.126438 33.8500000 0.136456 33.8527778 0.149814 33.8555556 0.151484 33.8583333 0.143135 33.8611111 0.116419 33.8638889 0.073006 33.8666667 0.021243 33.8694444 0.010000 33.8722222 0.010000 33.8750000 0.010000 33.8777778 0.010000 33.8805556 0.010000 33.8833333 0.010000 33.8861111 0.010000 33.8888889 0.010000 33.8916667 0.010000 33.8944444 0.010000 33.8972222 0.010000 33.9000000 0.010000 33.9027778 0.010000 33.9055556 0.010000 33.9083333 0.010000 33.9111111 0.010000 33.9138889 0.010000 33.9166667 0.010000 33.9194444 0.010000 33.9222222 0.010000 33.9250000 0.010000 33.9277778 0.010000 33.9305556 0.010000 33.9333333 0.010000 33.9361111 0.010000 33.9388889 0.010000 33.9416667 0.010000 33.9444444 0.010000 33.9472222 0.010000 33.9500000 0.010000 33.9527778 0.010000 33.9555556 0.010000 33.9583333 0.010000 33.9611111 0.010000 33.9638889 0.010000 33.9666667 0.032931 33.9694444 0.066327 33.9722222 0.096382 33.9750000 0.106401 33.9777778 0.111410 33.9805556 0.113080 33.9833333 0.109740 33.9861111 0.113080 33.9888889 0.119759 33.9916667 0.121429 33.9944444 0.128108 33.9972222 0.133117 34.0000000 0.143135 34.0027778 0.151484 34.0055556 0.159833 34.0083333 0.158163 34.0111111 0.161503 34.0138889 0.168182 34.0166667 0.168182 34.0194444 0.161503 34.0222222 0.163173 34.0250000 0.159833 34.0277778 0.164842 34.0305556 0.169852 34.0333333 0.171521 34.0361111 0.179870 34.0388889 0.189889 34.0416667 0.189889 34.0444444 0.194898 34.0472222 0.194898 34.0500000 0.196568 34.0527778 0.196568 34.0555556 0.203247 34.0583333 0.204917 34.0611111 0.211596 34.0638889 0.224954 34.0666667 0.236642 34.0694444 0.246660 34.0722222 0.256679 34.0750000 0.265028 34.0777778 0.270037 34.0805556 0.273377 34.0833333 0.276716 34.0861111 0.285065 34.0888889 0.290074 34.0916667 0.296753 34.0944444 0.301763 34.0972222 0.310111 34.1000000 0.313451 34.1027778 0.318460 34.1055556 0.313451 34.1083333 0.315121 34.1111111 0.316790 34.1138889 0.316790 34.1166667 0.321800 34.1194444 0.328479 34.1222222 0.336827 34.1250000 0.345176 34.1277778 0.355195 34.1305556 0.363544 34.1333333 0.370223 34.1361111 0.388590 34.1388889 0.395269 34.1416667 0.406957 34.1444444 0.406957 34.1472222 0.406957 34.1500000 0.403618 34.1527778 0.398609 34.1555556 0.401948 34.1583333 0.393599 34.1611111 0.390260 34.1638889 0.388590 34.1666667 0.393599 34.1694444 0.388590 34.1722222 0.385250 34.1750000 0.380241 34.1777778 0.370223 34.1805556 0.363544 34.1833333 0.350186 34.1861111 0.341837 34.1888889 0.331818 34.1916667 0.320130 34.9305556 0.057978 34.9333333 0.061317 34.9361111 0.066327 34.9388889 0.069666 34.9416667 0.066327 34.9444444 0.062987 34.9472222 0.061317 34.9500000 0.057978 34.9527778 0.052968 34.9555556 0.047959 34.9583333 0.049629 34.9611111 0.054638 34.9638889 0.051299 34.9666667 0.059647 34.9694444 0.062987 34.9722222 0.061317 34.9750000 0.066327 34.9777778 0.061317 34.9805556 0.062987 34.9833333 0.062987 34.9861111 0.061317 34.9888889 0.059647 34.9916667 0.054638 34.9944444 0.056308 34.9972222 0.059647 35.0000000 0.066327 35.0027778 0.069666 35.0055556 0.071336 35.0083333 0.074675 35.0111111 0.076345 35.0138889 0.076345 35.0166667 0.076345 35.0194444 0.074675 35.0222222 0.074675 35.0250000 0.078015 35.0277778 0.081354 35.0305556 0.089703 35.0333333 0.088033 35.0361111 0.101391 35.0388889 0.101391 35.0416667 0.101391 35.0444444 0.101391 35.0472222 0.094712 35.0500000 0.078015 35.0527778 0.066327 35.0555556 0.057978 35.0583333 0.052968 35.0611111 0.052968 35.0638889 0.051299 35.0666667 0.051299 35.0694444 0.052968 35.0722222 0.059647 35.0750000 0.052968 35.0777778 0.046289 35.0805556 0.047959 35.0833333 0.046289 35.0861111 0.046289 35.0888889 0.037941 35.0916667 0.042950 35.0944444 0.041280 35.0972222 0.044620 35.1000000 0.049629 35.1027778 0.049629 35.1055556 0.052968 35.1083333 0.052968 35.1111111 0.049629 35.1138889 0.042950 35.1166667 0.042950 35.1194444 0.042950 35.1222222 0.037941 35.1250000 0.039610 35.1277778 0.037941 35.1305556 0.039610 35.1333333 0.044620 35.1361111 0.039610 35.1388889 0.047959 35.1416667 0.046289 35.1444444 0.049629 35.1472222 0.047959 35.1500000 0.046289 35.1527778 0.051299 35.1555556 0.061317 35.1583333 0.081354 35.1611111 0.094712 35.1638889 0.111410 35.1666667 0.109740 35.1694444 0.103061 35.1722222 0.069666 35.1750000 0.019573 35.1777778 0.010000 35.1805556 0.010000 35.1833333 0.010000 35.1861111 0.010000 35.1888889 0.010000 35.1916667 0.010000 35.1944444 0.010000 35.1972222 0.010000 35.2000000 0.010000 35.2027778 0.010000 35.2055556 0.010000 35.2083333 0.010000 35.2111111 0.010000 35.2138889 0.010000 35.2166667 0.010000 35.2194444 0.010000 35.2222222 0.010000 35.2250000 0.010000 35.2277778 0.022913 35.2305556 0.032931 35.2333333 0.046289 35.2361111 0.051299 35.2388889 0.054638 35.2416667 0.052968 35.2444444 0.057978 35.2472222 0.061317 35.2500000 0.056308 35.2527778 0.061317 35.2555556 0.059647 35.2583333 0.054638 35.2611111 0.059647 35.2638889 0.064657 35.2666667 0.066327 35.2694444 0.069666 35.2722222 0.073006 35.2750000 0.073006 35.2777778 0.067996 35.2805556 0.073006 35.2833333 0.071336 35.2861111 0.071336 35.2888889 0.067996 35.2916667 0.071336 35.2944444 0.069666 35.2972222 0.069666 35.3000000 0.073006 35.3027778 0.074675 35.3055556 0.084694 35.3083333 0.083024 35.3111111 0.074675 35.3138889 0.074675 35.3166667 0.073006 35.3194444 0.067996 35.3222222 0.066327 35.3250000 0.062987 35.3277778 0.067996 35.3305556 0.067996 35.3333333 0.073006 35.3361111 0.078015 35.3388889 0.084694 35.3416667 0.084694 35.3444444 0.081354 35.3472222 0.083024 35.3500000 0.079685 35.3527778 0.076345 35.3555556 0.079685 35.3583333 0.074675 35.3611111 0.079685 35.3638889 0.078015 35.3666667 0.084694 35.3694444 0.088033 35.3722222 0.093043 35.3750000 0.089703 35.3777778 0.093043 35.3805556 0.089703 35.3833333 0.083024 35.3861111 0.079685 35.3888889 0.076345 35.3916667 0.071336 35.3944444 0.076345 35.3972222 0.079685 35.4000000 0.086364 35.4027778 0.091373 35.4055556 0.091373 35.4083333 0.093043 35.4111111 0.094712 35.4138889 0.093043 35.4166667 0.089703 35.4194444 0.088033 35.4222222 0.086364 35.4250000 0.088033 35.4277778 0.086364 35.4305556 0.089703 35.4333333 0.096382 35.4361111 0.094712 35.4388889 0.096382 35.4416667 0.094712 35.4444444 0.094712 35.4472222 0.093043 35.4500000 0.089703 35.4527778 0.081354 35.4555556 0.081354 35.4583333 0.079685 35.4611111 0.079685 35.4638889 0.081354 35.4666667 0.086364 35.4694444 0.089703 35.4722222 0.089703 35.4750000 0.093043 35.4777778 0.091373 35.4805556 0.084694 35.4833333 0.078015 35.4861111 0.076345 35.4888889 0.067996 35.4916667 0.066327 35.4944444 0.062987 35.4972222 0.066327 35.5000000 0.066327 35.5027778 0.064657 35.5055556 0.066327 35.5083333 0.062987 35.5111111 0.064657 35.5138889 0.062987 35.5166667 0.059647 35.5194444 0.064657 35.5222222 0.057978 35.5250000 0.054638 35.5277778 0.056308 35.5305556 0.061317 35.5333333 0.066327 35.5361111 0.073006 35.5388889 0.076345 35.5416667 0.076345 35.5444444 0.067996 35.5472222 0.071336 35.5500000 0.071336 35.5527778 0.066327 35.5555556 0.062987 35.5583333 0.061317 35.5611111 0.061317 35.5638889 0.069666 35.5666667 0.069666 35.5694444 0.073006 35.5722222 0.069666 35.5750000 0.074675 35.5777778 0.073006 35.5805556 0.073006 35.5833333 0.067996 35.5861111 0.064657 35.5888889 0.064657 35.5916667 0.069666 35.5944444 0.066327 35.5972222 0.066327 35.6000000 0.067996 35.6027778 0.069666 35.6055556 0.073006 35.6083333 0.076345 35.6111111 0.074675 35.6138889 0.073006 35.6166667 0.064657 35.6194444 0.062987 35.6222222 0.062987 35.6250000 0.054638 35.6277778 0.056308 35.6305556 0.061317 35.6333333 0.066327 35.6361111 0.071336 35.6388889 0.069666 35.6416667 0.074675 35.6444444 0.071336 35.6472222 0.074675 35.6500000 0.071336 35.6527778 0.078015 35.6555556 0.073006 35.6583333 0.081354 35.6611111 0.083024 35.6638889 0.089703 35.6666667 0.099722 35.6694444 0.113080 35.6722222 0.126438 35.6750000 0.143135 35.6777778 0.151484 35.6805556 0.156494 35.6833333 0.134787 35.6861111 0.091373 35.6888889 0.042950 35.6916667 0.010000 35.6944444 0.010000 35.6972222 0.010000 35.7000000 0.010000 35.7027778 0.010000 35.7055556 0.010000 35.7083333 0.010000 35.7111111 0.010000 35.7138889 0.010000 35.7166667 0.010000 35.7194444 0.010000 35.7222222 0.010000 35.7250000 0.010000 35.7277778 0.010000 35.7305556 0.010000 35.7333333 0.010000 35.7361111 0.010000 35.7388889 0.010000 35.7416667 0.010000 35.7444444 0.010000 35.7472222 0.010000 35.7500000 0.010000 35.7527778 0.010000 35.7555556 0.010000 35.7583333 0.010000 35.7611111 0.010000 35.7638889 0.010000 35.7666667 0.010000 35.7694444 0.010000 35.7722222 0.010000 35.7750000 0.010000 35.7777778 0.010000 35.7805556 0.010000 35.7833333 0.010000 35.7861111 0.010000 35.7888889 0.010000 35.7916667 0.011224 35.7944444 0.039610 35.7972222 0.062987 35.8000000 0.088033 35.8027778 0.093043 35.8055556 0.103061 35.8083333 0.104731 35.8111111 0.111410 35.8138889 0.113080 35.8166667 0.113080 35.8194444 0.118089 35.8222222 0.118089 35.8250000 0.121429 35.8277778 0.126438 35.8305556 0.129777 35.8333333 0.136456 35.8361111 0.138126 35.8388889 0.149814 35.8416667 0.151484 35.8444444 0.153154 35.8472222 0.158163 35.8500000 0.153154 35.8527778 0.158163 35.8555556 0.159833 35.8583333 0.156494 35.8611111 0.163173 35.8638889 0.169852 35.8666667 0.171521 35.8694444 0.181540 35.8722222 0.186549 35.8750000 0.189889 35.8777778 0.194898 35.8805556 0.198237 35.8833333 0.194898 35.8861111 0.199907 35.8888889 0.203247 35.8916667 0.206586 35.8944444 0.216605 35.8972222 0.221614 35.9000000 0.233302 35.9027778 0.238312 35.9055556 0.248330 35.9083333 0.255009 35.9111111 0.261688 35.9138889 0.261688 35.9166667 0.260019 35.9194444 0.255009 35.9222222 0.251670 35.9250000 0.244991 35.9277778 0.246660 35.9305556 0.251670 35.9333333 0.261688 35.9361111 0.266698 35.9388889 0.275046 35.9416667 0.291744 35.9444444 0.291744 35.9472222 0.298423 35.9500000 0.298423 35.9527778 0.300093 35.9555556 0.306772 35.9583333 0.315121 35.9611111 0.325139 35.9638889 0.328479 35.9666667 0.348516 35.9694444 0.358534 35.9722222 0.366883 35.9750000 0.376902 35.9777778 0.371892 35.9805556 0.378571 35.9833333 0.378571 35.9861111 0.380241 35.9888889 0.370223 35.9916667 0.378571 35.9944444 0.370223 35.9972222 0.371892 36.0000000 0.371892 36.0027778 0.375232 36.0055556 0.373562 36.0083333 0.370223 36.0111111 0.361874 36.0138889 0.353525 36.0166667 0.341837 36.0194444 0.331818 36.2222222 0.250000)
Vrpeak rpeak_trigger 0 PWL(0.0000000 0.000000 0.4990000 0.000000 0.5000000 0.900000 0.5010000 0.900000 0.5020000 0.000000 1.4378889 0.000000 1.4388889 0.900000 1.4398889 0.900000 1.4408889 0.000000 2.3712222 0.000000 2.3722222 0.900000 2.3732222 0.900000 2.3742222 0.000000 3.2601111 0.000000 3.2611111 0.900000 3.2621111 0.900000 3.2631111 0.000000 4.1573333 0.000000 4.1583333 0.900000 4.1593333 0.900000 4.1603333 0.000000 4.6962222 0.000000 4.6972222 0.900000 4.6982222 0.900000 4.6992222 0.000000 5.9962222 0.000000 5.9972222 0.900000 5.9982222 0.900000 5.9992222 0.000000 6.9406667 0.000000 6.9416667 0.900000 6.9426667 0.900000 6.9436667 0.000000 7.8212222 0.000000 7.8222222 0.900000 7.8232222 0.900000 7.8242222 0.000000 8.6823333 0.000000 8.6833333 0.900000 8.6843333 0.900000 8.6853333 0.000000 9.6101111 0.000000 9.6111111 0.900000 9.6121111 0.900000 9.6131111 0.000000 10.1406667 0.000000 10.1416667 0.900000 10.1426667 0.900000 10.1436667 0.000000 11.4128889 0.000000 11.4138889 0.900000 11.4148889 0.900000 11.4158889 0.000000 12.3378889 0.000000 12.3388889 0.900000 12.3398889 0.900000 12.3408889 0.000000 13.2073333 0.000000 13.2083333 0.900000 13.2093333 0.900000 13.2103333 0.000000 14.1240000 0.000000 14.1250000 0.900000 14.1260000 0.900000 14.1270000 0.000000 15.0351111 0.000000 15.0361111 0.900000 15.0371111 0.900000 15.0381111 0.000000 15.8990000 0.000000 15.9000000 0.900000 15.9010000 0.900000 15.9020000 0.000000 16.8517778 0.000000 16.8527778 0.900000 16.8537778 0.900000 16.8547778 0.000000 17.7851111 0.000000 17.7861111 0.900000 17.7871111 0.900000 17.7881111 0.000000 18.6517778 0.000000 18.6527778 0.900000 18.6537778 0.900000 18.6547778 0.000000 19.1990000 0.000000 19.2000000 0.900000 19.2010000 0.900000 19.2020000 0.000000 20.5017778 0.000000 20.5027778 0.900000 20.5037778 0.900000 20.5047778 0.000000 21.0545556 0.000000 21.0555556 0.900000 21.0565556 0.900000 21.0575556 0.000000 22.3962222 0.000000 22.3972222 0.900000 22.3982222 0.900000 22.3992222 0.000000 22.9295556 0.000000 22.9305556 0.900000 22.9315556 0.900000 22.9325556 0.000000 24.2601111 0.000000 24.2611111 0.900000 24.2621111 0.900000 24.2631111 0.000000 24.8295556 0.000000 24.8305556 0.900000 24.8315556 0.900000 24.8325556 0.000000 26.1017778 0.000000 26.1027778 0.900000 26.1037778 0.900000 26.1047778 0.000000 26.7323333 0.000000 26.7333333 0.900000 26.7343333 0.900000 26.7353333 0.000000 27.9712222 0.000000 27.9722222 0.900000 27.9732222 0.900000 27.9742222 0.000000 28.5212222 0.000000 28.5222222 0.900000 28.5232222 0.900000 28.5242222 0.000000 29.8545556 0.000000 29.8555556 0.900000 29.8565556 0.900000 29.8575556 0.000000 30.7378889 0.000000 30.7388889 0.900000 30.7398889 0.900000 30.7408889 0.000000 31.6351111 0.000000 31.6361111 0.900000 31.6371111 0.900000 31.6381111 0.000000 32.5128889 0.000000 32.5138889 0.900000 32.5148889 0.900000 32.5158889 0.000000 33.3517778 0.000000 33.3527778 0.900000 33.3537778 0.900000 33.3547778 0.000000 33.8934444 0.000000 33.8944444 0.900000 33.8954444 0.900000 33.8964444 0.000000 35.1795556 0.000000 35.1805556 0.900000 35.1815556 0.900000 35.1825556 0.000000 35.7212222 0.000000 35.7222222 0.900000 35.7232222 0.900000 35.7242222 0.000000 36.2222222 0.000000)
Vqrs qrs_gate 0 PWL(0.0000000 0.000000 0.4384444 0.000000 0.4394444 0.900000 0.6133333 0.900000 0.6143333 0.000000 1.3773333 0.000000 1.3783333 0.900000 1.5522222 0.900000 1.5532222 0.000000 2.3106667 0.000000 2.3116667 0.900000 2.4855556 0.900000 2.4865556 0.000000 3.1995556 0.000000 3.2005556 0.900000 3.3744444 0.900000 3.3754444 0.000000 4.0967778 0.000000 4.0977778 0.900000 4.2716667 0.900000 4.2726667 0.000000 4.6356667 0.000000 4.6366667 0.900000 4.8105556 0.900000 4.8115556 0.000000 5.9356667 0.000000 5.9366667 0.900000 6.1105556 0.900000 6.1115556 0.000000 6.8801111 0.000000 6.8811111 0.900000 7.0550000 0.900000 7.0560000 0.000000 7.7606667 0.000000 7.7616667 0.900000 7.9355556 0.900000 7.9365556 0.000000 8.6217778 0.000000 8.6227778 0.900000 8.7966667 0.900000 8.7976667 0.000000 9.5495556 0.000000 9.5505556 0.900000 9.7244444 0.900000 9.7254444 0.000000 10.0801111 0.000000 10.0811111 0.900000 10.2550000 0.900000 10.2560000 0.000000 11.3523333 0.000000 11.3533333 0.900000 11.5272222 0.900000 11.5282222 0.000000 12.2773333 0.000000 12.2783333 0.900000 12.4522222 0.900000 12.4532222 0.000000 13.1467778 0.000000 13.1477778 0.900000 13.3216667 0.900000 13.3226667 0.000000 14.0634444 0.000000 14.0644444 0.900000 14.2383333 0.900000 14.2393333 0.000000 14.9745556 0.000000 14.9755556 0.900000 15.1494444 0.900000 15.1504444 0.000000 15.8384444 0.000000 15.8394444 0.900000 16.0133333 0.900000 16.0143333 0.000000 16.7912222 0.000000 16.7922222 0.900000 16.9661111 0.900000 16.9671111 0.000000 17.7245556 0.000000 17.7255556 0.900000 17.8994444 0.900000 17.9004444 0.000000 18.5912222 0.000000 18.5922222 0.900000 18.7661111 0.900000 18.7671111 0.000000 19.1384444 0.000000 19.1394444 0.900000 19.3133333 0.900000 19.3143333 0.000000 20.4412222 0.000000 20.4422222 0.900000 20.6161111 0.900000 20.6171111 0.000000 20.9940000 0.000000 20.9950000 0.900000 21.1688889 0.900000 21.1698889 0.000000 22.3356667 0.000000 22.3366667 0.900000 22.5105556 0.900000 22.5115556 0.000000 22.8690000 0.000000 22.8700000 0.900000 23.0438889 0.900000 23.0448889 0.000000 24.1995556 0.000000 24.2005556 0.900000 24.3744444 0.900000 24.3754444 0.000000 24.7690000 0.000000 24.7700000 0.900000 24.9438889 0.900000 24.9448889 0.000000 26.0412222 0.000000 26.0422222 0.900000 26.2161111 0.900000 26.2171111 0.000000 26.6717778 0.000000 26.6727778 0.900000 26.8466667 0.900000 26.8476667 0.000000 27.9106667 0.000000 27.9116667 0.900000 28.0855556 0.900000 28.0865556 0.000000 28.4940000 0.000000 28.4950000 0.900000 28.6355556 0.900000 28.6365556 0.000000 29.7940000 0.000000 29.7950000 0.900000 29.9688889 0.900000 29.9698889 0.000000 30.6773333 0.000000 30.6783333 0.900000 30.8522222 0.900000 30.8532222 0.000000 31.5745556 0.000000 31.5755556 0.900000 31.7494444 0.900000 31.7504444 0.000000 32.4523333 0.000000 32.4533333 0.900000 32.6272222 0.900000 32.6282222 0.000000 33.2912222 0.000000 33.2922222 0.900000 33.4661111 0.900000 33.4671111 0.000000 33.8328889 0.000000 33.8338889 0.900000 34.0077778 0.900000 34.0087778 0.000000 35.1190000 0.000000 35.1200000 0.900000 35.2938889 0.900000 35.2948889 0.000000 35.6606667 0.000000 35.6616667 0.900000 35.8355556 0.900000 35.8365556 0.000000 36.2222222 0.000000)
Vsym qrs_sym_gate 0 PWL(0.0000000 0.000000 0.4414444 0.000000 0.4424444 0.900000 0.6103333 0.900000 0.6113333 0.000000 1.3803333 0.000000 1.3813333 0.900000 1.5492222 0.900000 1.5502222 0.000000 2.3136667 0.000000 2.3146667 0.900000 2.4825556 0.900000 2.4835556 0.000000 3.2025556 0.000000 3.2035556 0.900000 3.3714444 0.900000 3.3724444 0.000000 4.0997778 0.000000 4.1007778 0.900000 4.2686667 0.900000 4.2696667 0.000000 4.6803333 0.000000 4.6813333 0.900000 4.8075556 0.900000 4.8085556 0.000000 5.9608889 0.000000 5.9618889 0.900000 6.1075556 0.900000 6.1085556 0.000000 6.8831111 0.000000 6.8841111 0.900000 7.0520000 0.900000 7.0530000 0.000000 7.7636667 0.000000 7.7646667 0.900000 7.9325556 0.900000 7.9335556 0.000000 8.6247778 0.000000 8.6257778 0.900000 8.7936667 0.900000 8.7946667 0.000000 9.5525556 0.000000 9.5535556 0.900000 9.7214444 0.900000 9.7224444 0.000000 10.1247778 0.000000 10.1257778 0.900000 10.1825556 0.900000 10.1835556 0.000000 11.3775556 0.000000 11.3785556 0.900000 11.5158889 0.900000 11.5168889 0.000000 12.3025556 0.000000 12.3035556 0.900000 12.4492222 0.900000 12.4502222 0.000000 13.1497778 0.000000 13.1507778 0.900000 13.3186667 0.900000 13.3196667 0.000000 14.0664444 0.000000 14.0674444 0.900000 14.2353333 0.900000 14.2363333 0.000000 14.9775556 0.000000 14.9785556 0.900000 15.1464444 0.900000 15.1474444 0.000000 15.8414444 0.000000 15.8424444 0.900000 16.0103333 0.900000 16.0113333 0.000000 16.7942222 0.000000 16.7952222 0.900000 16.9631111 0.900000 16.9641111 0.000000 17.7275556 0.000000 17.7285556 0.900000 17.8964444 0.900000 17.8974444 0.000000 18.6136667 0.000000 18.6146667 0.900000 18.6825556 0.900000 18.6835556 0.000000 19.1831111 0.000000 19.1841111 0.900000 19.2408889 0.900000 19.2418889 0.000000 20.4442222 0.000000 20.4452222 0.900000 20.6131111 0.900000 20.6141111 0.000000 21.0414444 0.000000 21.0424444 0.900000 21.1020000 0.900000 21.1030000 0.000000 22.3886667 0.000000 22.3896667 0.900000 22.4214444 0.900000 22.4224444 0.000000 22.9136667 0.000000 22.9146667 0.900000 22.9714444 0.900000 22.9724444 0.000000 24.2525556 0.000000 24.2535556 0.900000 24.2686667 0.900000 24.2696667 0.000000 24.8136667 0.000000 24.8146667 0.900000 24.8714444 0.900000 24.8724444 0.000000 26.0942222 0.000000 26.0952222 0.900000 26.1103333 0.900000 26.1113333 0.000000 26.6803333 0.000000 26.6813333 0.900000 26.7436667 0.900000 26.7446667 0.000000 27.9664444 0.000000 27.9674444 0.900000 27.9825556 0.900000 27.9835556 0.000000 28.5081111 0.000000 28.5091111 0.900000 28.5714444 0.900000 28.5724444 0.000000 29.8470000 0.000000 29.8480000 0.900000 29.8631111 0.900000 29.8641111 0.000000 30.7303333 0.000000 30.7313333 0.900000 30.7492222 0.900000 30.7502222 0.000000 31.6303333 0.000000 31.6313333 0.900000 31.6631111 0.900000 31.6641111 0.000000 32.4553333 0.000000 32.4563333 0.900000 32.6242222 0.900000 32.6252222 0.000000 33.2942222 0.000000 33.2952222 0.900000 33.4631111 0.900000 33.4641111 0.000000 33.8803333 0.000000 33.8813333 0.900000 33.9381111 0.900000 33.9391111 0.000000 35.1220000 0.000000 35.1230000 0.900000 35.2908889 0.900000 35.2918889 0.000000 35.7053333 0.000000 35.7063333 0.900000 35.7631111 0.900000 35.7641111 0.000000 36.2222222 0.000000)
Vpwave pwave_gate 0 PWL(0.0000000 0.000000 0.2934444 0.000000 0.2944444 0.900000 0.4444444 0.900000 0.4454444 0.000000 1.2323333 0.000000 1.2333333 0.900000 1.3833333 0.900000 1.3843333 0.000000 2.1656667 0.000000 2.1666667 0.900000 2.3166667 0.900000 2.3176667 0.000000 3.0545556 0.000000 3.0555556 0.900000 3.2055556 0.900000 3.2065556 0.000000 3.9517778 0.000000 3.9527778 0.900000 4.1027778 0.900000 4.1037778 0.000000 4.4906667 0.000000 4.4916667 0.900000 4.6416667 0.900000 4.6426667 0.000000 5.7906667 0.000000 5.7916667 0.900000 5.9416667 0.900000 5.9426667 0.000000 6.7351111 0.000000 6.7361111 0.900000 6.8861111 0.900000 6.8871111 0.000000 7.6156667 0.000000 7.6166667 0.900000 7.7666667 0.900000 7.7676667 0.000000 8.4767778 0.000000 8.4777778 0.900000 8.6277778 0.900000 8.6287778 0.000000 9.4045556 0.000000 9.4055556 0.900000 9.5555556 0.900000 9.5565556 0.000000 9.9351111 0.000000 9.9361111 0.900000 10.0861111 0.900000 10.0871111 0.000000 11.2073333 0.000000 11.2083333 0.900000 11.3583333 0.900000 11.3593333 0.000000 12.1323333 0.000000 12.1333333 0.900000 12.2833333 0.900000 12.2843333 0.000000 13.0017778 0.000000 13.0027778 0.900000 13.1527778 0.900000 13.1537778 0.000000 13.9184444 0.000000 13.9194444 0.900000 14.0694444 0.900000 14.0704444 0.000000 14.8295556 0.000000 14.8305556 0.900000 14.9805556 0.900000 14.9815556 0.000000 15.6934444 0.000000 15.6944444 0.900000 15.8444444 0.900000 15.8454444 0.000000 16.6462222 0.000000 16.6472222 0.900000 16.7972222 0.900000 16.7982222 0.000000 17.5795556 0.000000 17.5805556 0.900000 17.7305556 0.900000 17.7315556 0.000000 18.4462222 0.000000 18.4472222 0.900000 18.5972222 0.900000 18.5982222 0.000000 18.9934444 0.000000 18.9944444 0.900000 19.1444444 0.900000 19.1454444 0.000000 20.2962222 0.000000 20.2972222 0.900000 20.4472222 0.900000 20.4482222 0.000000 20.8490000 0.000000 20.8500000 0.900000 21.0000000 0.900000 21.0010000 0.000000 22.1906667 0.000000 22.1916667 0.900000 22.3416667 0.900000 22.3426667 0.000000 22.7240000 0.000000 22.7250000 0.900000 22.8750000 0.900000 22.8760000 0.000000 24.0545556 0.000000 24.0555556 0.900000 24.2055556 0.900000 24.2065556 0.000000 24.6240000 0.000000 24.6250000 0.900000 24.7750000 0.900000 24.7760000 0.000000 25.8962222 0.000000 25.8972222 0.900000 26.0472222 0.900000 26.0482222 0.000000 26.5267778 0.000000 26.5277778 0.900000 26.6777778 0.900000 26.6787778 0.000000 27.7656667 0.000000 27.7666667 0.900000 27.9166667 0.900000 27.9176667 0.000000 28.3156667 0.000000 28.3166667 0.900000 28.4666667 0.900000 28.4676667 0.000000 29.6490000 0.000000 29.6500000 0.900000 29.8000000 0.900000 29.8010000 0.000000 30.5323333 0.000000 30.5333333 0.900000 30.6833333 0.900000 30.6843333 0.000000 31.4295556 0.000000 31.4305556 0.900000 31.5805556 0.900000 31.5815556 0.000000 32.3073333 0.000000 32.3083333 0.900000 32.4583333 0.900000 32.4593333 0.000000 33.1462222 0.000000 33.1472222 0.900000 33.2972222 0.900000 33.2982222 0.000000 33.6878889 0.000000 33.6888889 0.900000 33.8388889 0.900000 33.8398889 0.000000 34.9740000 0.000000 34.9750000 0.900000 35.1250000 0.900000 35.1260000 0.000000 35.5156667 0.000000 35.5166667 0.900000 35.6666667 0.900000 35.6676667 0.000000 36.2222222 0.000000)

Xrr rpeak_trigger f_rr_ratio f_rr_asym vdd vss vbias rr_timing
Xinstab0 ecg_in qrs_gate rpeak_trigger f_instab_l0 peak_out_l0 vdd vss vbias vref beat_instability
Xinstab1 ecg_in_l1 qrs_gate rpeak_trigger f_instab_l1 peak_out_l1 vdd vss vbias vref beat_instability
Xpwave ecg_in_l1 pwave_gate rpeak_trigger f_pwave vdd vss vbias vref pwave_energy
Xwidth vref ecg_in qrs_gate rpeak_trigger f_width vdd vss vbias qrs_width
Xsym qrs_sym_gate rpeak_trigger f_sym rise_timer_out fall_timer_out vdd vss vbias qrs_symmetry
Xslope rise_timer_out fall_timer_out f_slope vdd vss vbias slope_ratio

* No IC seeding needed - amplitude deviation uses fixed VREF reference

.tran 0.5m 36.2222

.meas tran f_rr_ratio_b0 FIND V(f_rr_ratio) AT=0.4950000
.meas tran f_rr_asym_b0 FIND V(f_rr_asym) AT=0.4950000
.meas tran f_instab_l0_b0 FIND V(f_instab_l0) AT=0.4950000
.meas tran f_instab_l1_b0 FIND V(f_instab_l1) AT=0.4950000
.meas tran f_pwave_b0 FIND V(f_pwave) AT=0.4950000
.meas tran f_width_b0 FIND V(f_width) AT=0.4950000
.meas tran f_sym_b0 FIND V(f_sym) AT=0.6093333
.meas tran f_slope_b0 FIND V(f_slope) AT=0.6093333
.meas tran rise_timer_b0 FIND V(rise_timer_out) AT=0.6093333
.meas tran fall_timer_b0 FIND V(fall_timer_out) AT=0.6093333
.meas tran peak_out_b0 FIND V(peak_out_l0) AT=0.4950000
.meas tran peak_l1_b0 FIND V(peak_out_l1) AT=0.4950000
.meas tran f_rr_ratio_b1 FIND V(f_rr_ratio) AT=1.4338889
.meas tran f_rr_asym_b1 FIND V(f_rr_asym) AT=1.4338889
.meas tran f_instab_l0_b1 FIND V(f_instab_l0) AT=1.4338889
.meas tran f_instab_l1_b1 FIND V(f_instab_l1) AT=1.4338889
.meas tran f_pwave_b1 FIND V(f_pwave) AT=1.4338889
.meas tran f_width_b1 FIND V(f_width) AT=1.4338889
.meas tran f_sym_b1 FIND V(f_sym) AT=1.5482222
.meas tran f_slope_b1 FIND V(f_slope) AT=1.5482222
.meas tran rise_timer_b1 FIND V(rise_timer_out) AT=1.5482222
.meas tran fall_timer_b1 FIND V(fall_timer_out) AT=1.5482222
.meas tran peak_out_b1 FIND V(peak_out_l0) AT=1.4338889
.meas tran peak_l1_b1 FIND V(peak_out_l1) AT=1.4338889
.meas tran f_rr_ratio_b2 FIND V(f_rr_ratio) AT=2.3672222
.meas tran f_rr_asym_b2 FIND V(f_rr_asym) AT=2.3672222
.meas tran f_instab_l0_b2 FIND V(f_instab_l0) AT=2.3672222
.meas tran f_instab_l1_b2 FIND V(f_instab_l1) AT=2.3672222
.meas tran f_pwave_b2 FIND V(f_pwave) AT=2.3672222
.meas tran f_width_b2 FIND V(f_width) AT=2.3672222
.meas tran f_sym_b2 FIND V(f_sym) AT=2.4815556
.meas tran f_slope_b2 FIND V(f_slope) AT=2.4815556
.meas tran rise_timer_b2 FIND V(rise_timer_out) AT=2.4815556
.meas tran fall_timer_b2 FIND V(fall_timer_out) AT=2.4815556
.meas tran peak_out_b2 FIND V(peak_out_l0) AT=2.3672222
.meas tran peak_l1_b2 FIND V(peak_out_l1) AT=2.3672222
.meas tran f_rr_ratio_b3 FIND V(f_rr_ratio) AT=3.2561111
.meas tran f_rr_asym_b3 FIND V(f_rr_asym) AT=3.2561111
.meas tran f_instab_l0_b3 FIND V(f_instab_l0) AT=3.2561111
.meas tran f_instab_l1_b3 FIND V(f_instab_l1) AT=3.2561111
.meas tran f_pwave_b3 FIND V(f_pwave) AT=3.2561111
.meas tran f_width_b3 FIND V(f_width) AT=3.2561111
.meas tran f_sym_b3 FIND V(f_sym) AT=3.3704444
.meas tran f_slope_b3 FIND V(f_slope) AT=3.3704444
.meas tran rise_timer_b3 FIND V(rise_timer_out) AT=3.3704444
.meas tran fall_timer_b3 FIND V(fall_timer_out) AT=3.3704444
.meas tran peak_out_b3 FIND V(peak_out_l0) AT=3.2561111
.meas tran peak_l1_b3 FIND V(peak_out_l1) AT=3.2561111
.meas tran f_rr_ratio_b4 FIND V(f_rr_ratio) AT=4.1533333
.meas tran f_rr_asym_b4 FIND V(f_rr_asym) AT=4.1533333
.meas tran f_instab_l0_b4 FIND V(f_instab_l0) AT=4.1533333
.meas tran f_instab_l1_b4 FIND V(f_instab_l1) AT=4.1533333
.meas tran f_pwave_b4 FIND V(f_pwave) AT=4.1533333
.meas tran f_width_b4 FIND V(f_width) AT=4.1533333
.meas tran f_sym_b4 FIND V(f_sym) AT=4.2676667
.meas tran f_slope_b4 FIND V(f_slope) AT=4.2676667
.meas tran rise_timer_b4 FIND V(rise_timer_out) AT=4.2676667
.meas tran fall_timer_b4 FIND V(fall_timer_out) AT=4.2676667
.meas tran peak_out_b4 FIND V(peak_out_l0) AT=4.1533333
.meas tran peak_l1_b4 FIND V(peak_out_l1) AT=4.1533333
.meas tran f_rr_ratio_b5 FIND V(f_rr_ratio) AT=4.6922222
.meas tran f_rr_asym_b5 FIND V(f_rr_asym) AT=4.6922222
.meas tran f_instab_l0_b5 FIND V(f_instab_l0) AT=4.6922222
.meas tran f_instab_l1_b5 FIND V(f_instab_l1) AT=4.6922222
.meas tran f_pwave_b5 FIND V(f_pwave) AT=4.6922222
.meas tran f_width_b5 FIND V(f_width) AT=4.6922222
.meas tran f_sym_b5 FIND V(f_sym) AT=4.8065556
.meas tran f_slope_b5 FIND V(f_slope) AT=4.8065556
.meas tran rise_timer_b5 FIND V(rise_timer_out) AT=4.8065556
.meas tran fall_timer_b5 FIND V(fall_timer_out) AT=4.8065556
.meas tran peak_out_b5 FIND V(peak_out_l0) AT=4.6922222
.meas tran peak_l1_b5 FIND V(peak_out_l1) AT=4.6922222
.meas tran f_rr_ratio_b6 FIND V(f_rr_ratio) AT=5.9922222
.meas tran f_rr_asym_b6 FIND V(f_rr_asym) AT=5.9922222
.meas tran f_instab_l0_b6 FIND V(f_instab_l0) AT=5.9922222
.meas tran f_instab_l1_b6 FIND V(f_instab_l1) AT=5.9922222
.meas tran f_pwave_b6 FIND V(f_pwave) AT=5.9922222
.meas tran f_width_b6 FIND V(f_width) AT=5.9922222
.meas tran f_sym_b6 FIND V(f_sym) AT=6.1065556
.meas tran f_slope_b6 FIND V(f_slope) AT=6.1065556
.meas tran rise_timer_b6 FIND V(rise_timer_out) AT=6.1065556
.meas tran fall_timer_b6 FIND V(fall_timer_out) AT=6.1065556
.meas tran peak_out_b6 FIND V(peak_out_l0) AT=5.9922222
.meas tran peak_l1_b6 FIND V(peak_out_l1) AT=5.9922222
.meas tran f_rr_ratio_b7 FIND V(f_rr_ratio) AT=6.9366667
.meas tran f_rr_asym_b7 FIND V(f_rr_asym) AT=6.9366667
.meas tran f_instab_l0_b7 FIND V(f_instab_l0) AT=6.9366667
.meas tran f_instab_l1_b7 FIND V(f_instab_l1) AT=6.9366667
.meas tran f_pwave_b7 FIND V(f_pwave) AT=6.9366667
.meas tran f_width_b7 FIND V(f_width) AT=6.9366667
.meas tran f_sym_b7 FIND V(f_sym) AT=7.0510000
.meas tran f_slope_b7 FIND V(f_slope) AT=7.0510000
.meas tran rise_timer_b7 FIND V(rise_timer_out) AT=7.0510000
.meas tran fall_timer_b7 FIND V(fall_timer_out) AT=7.0510000
.meas tran peak_out_b7 FIND V(peak_out_l0) AT=6.9366667
.meas tran peak_l1_b7 FIND V(peak_out_l1) AT=6.9366667
.meas tran f_rr_ratio_b8 FIND V(f_rr_ratio) AT=7.8172222
.meas tran f_rr_asym_b8 FIND V(f_rr_asym) AT=7.8172222
.meas tran f_instab_l0_b8 FIND V(f_instab_l0) AT=7.8172222
.meas tran f_instab_l1_b8 FIND V(f_instab_l1) AT=7.8172222
.meas tran f_pwave_b8 FIND V(f_pwave) AT=7.8172222
.meas tran f_width_b8 FIND V(f_width) AT=7.8172222
.meas tran f_sym_b8 FIND V(f_sym) AT=7.9315556
.meas tran f_slope_b8 FIND V(f_slope) AT=7.9315556
.meas tran rise_timer_b8 FIND V(rise_timer_out) AT=7.9315556
.meas tran fall_timer_b8 FIND V(fall_timer_out) AT=7.9315556
.meas tran peak_out_b8 FIND V(peak_out_l0) AT=7.8172222
.meas tran peak_l1_b8 FIND V(peak_out_l1) AT=7.8172222
.meas tran f_rr_ratio_b9 FIND V(f_rr_ratio) AT=8.6783333
.meas tran f_rr_asym_b9 FIND V(f_rr_asym) AT=8.6783333
.meas tran f_instab_l0_b9 FIND V(f_instab_l0) AT=8.6783333
.meas tran f_instab_l1_b9 FIND V(f_instab_l1) AT=8.6783333
.meas tran f_pwave_b9 FIND V(f_pwave) AT=8.6783333
.meas tran f_width_b9 FIND V(f_width) AT=8.6783333
.meas tran f_sym_b9 FIND V(f_sym) AT=8.7926667
.meas tran f_slope_b9 FIND V(f_slope) AT=8.7926667
.meas tran rise_timer_b9 FIND V(rise_timer_out) AT=8.7926667
.meas tran fall_timer_b9 FIND V(fall_timer_out) AT=8.7926667
.meas tran peak_out_b9 FIND V(peak_out_l0) AT=8.6783333
.meas tran peak_l1_b9 FIND V(peak_out_l1) AT=8.6783333
.meas tran f_rr_ratio_b10 FIND V(f_rr_ratio) AT=9.6061111
.meas tran f_rr_asym_b10 FIND V(f_rr_asym) AT=9.6061111
.meas tran f_instab_l0_b10 FIND V(f_instab_l0) AT=9.6061111
.meas tran f_instab_l1_b10 FIND V(f_instab_l1) AT=9.6061111
.meas tran f_pwave_b10 FIND V(f_pwave) AT=9.6061111
.meas tran f_width_b10 FIND V(f_width) AT=9.6061111
.meas tran f_sym_b10 FIND V(f_sym) AT=9.7204444
.meas tran f_slope_b10 FIND V(f_slope) AT=9.7204444
.meas tran rise_timer_b10 FIND V(rise_timer_out) AT=9.7204444
.meas tran fall_timer_b10 FIND V(fall_timer_out) AT=9.7204444
.meas tran peak_out_b10 FIND V(peak_out_l0) AT=9.6061111
.meas tran peak_l1_b10 FIND V(peak_out_l1) AT=9.6061111
.meas tran f_rr_ratio_b11 FIND V(f_rr_ratio) AT=10.1366667
.meas tran f_rr_asym_b11 FIND V(f_rr_asym) AT=10.1366667
.meas tran f_instab_l0_b11 FIND V(f_instab_l0) AT=10.1366667
.meas tran f_instab_l1_b11 FIND V(f_instab_l1) AT=10.1366667
.meas tran f_pwave_b11 FIND V(f_pwave) AT=10.1366667
.meas tran f_width_b11 FIND V(f_width) AT=10.1366667
.meas tran f_sym_b11 FIND V(f_sym) AT=10.1815556
.meas tran f_slope_b11 FIND V(f_slope) AT=10.1815556
.meas tran rise_timer_b11 FIND V(rise_timer_out) AT=10.1815556
.meas tran fall_timer_b11 FIND V(fall_timer_out) AT=10.1815556
.meas tran peak_out_b11 FIND V(peak_out_l0) AT=10.1366667
.meas tran peak_l1_b11 FIND V(peak_out_l1) AT=10.1366667
.meas tran f_rr_ratio_b12 FIND V(f_rr_ratio) AT=11.4088889
.meas tran f_rr_asym_b12 FIND V(f_rr_asym) AT=11.4088889
.meas tran f_instab_l0_b12 FIND V(f_instab_l0) AT=11.4088889
.meas tran f_instab_l1_b12 FIND V(f_instab_l1) AT=11.4088889
.meas tran f_pwave_b12 FIND V(f_pwave) AT=11.4088889
.meas tran f_width_b12 FIND V(f_width) AT=11.4088889
.meas tran f_sym_b12 FIND V(f_sym) AT=11.5148889
.meas tran f_slope_b12 FIND V(f_slope) AT=11.5148889
.meas tran rise_timer_b12 FIND V(rise_timer_out) AT=11.5148889
.meas tran fall_timer_b12 FIND V(fall_timer_out) AT=11.5148889
.meas tran peak_out_b12 FIND V(peak_out_l0) AT=11.4088889
.meas tran peak_l1_b12 FIND V(peak_out_l1) AT=11.4088889
.meas tran f_rr_ratio_b13 FIND V(f_rr_ratio) AT=12.3338889
.meas tran f_rr_asym_b13 FIND V(f_rr_asym) AT=12.3338889
.meas tran f_instab_l0_b13 FIND V(f_instab_l0) AT=12.3338889
.meas tran f_instab_l1_b13 FIND V(f_instab_l1) AT=12.3338889
.meas tran f_pwave_b13 FIND V(f_pwave) AT=12.3338889
.meas tran f_width_b13 FIND V(f_width) AT=12.3338889
.meas tran f_sym_b13 FIND V(f_sym) AT=12.4482222
.meas tran f_slope_b13 FIND V(f_slope) AT=12.4482222
.meas tran rise_timer_b13 FIND V(rise_timer_out) AT=12.4482222
.meas tran fall_timer_b13 FIND V(fall_timer_out) AT=12.4482222
.meas tran peak_out_b13 FIND V(peak_out_l0) AT=12.3338889
.meas tran peak_l1_b13 FIND V(peak_out_l1) AT=12.3338889
.meas tran f_rr_ratio_b14 FIND V(f_rr_ratio) AT=13.2033333
.meas tran f_rr_asym_b14 FIND V(f_rr_asym) AT=13.2033333
.meas tran f_instab_l0_b14 FIND V(f_instab_l0) AT=13.2033333
.meas tran f_instab_l1_b14 FIND V(f_instab_l1) AT=13.2033333
.meas tran f_pwave_b14 FIND V(f_pwave) AT=13.2033333
.meas tran f_width_b14 FIND V(f_width) AT=13.2033333
.meas tran f_sym_b14 FIND V(f_sym) AT=13.3176667
.meas tran f_slope_b14 FIND V(f_slope) AT=13.3176667
.meas tran rise_timer_b14 FIND V(rise_timer_out) AT=13.3176667
.meas tran fall_timer_b14 FIND V(fall_timer_out) AT=13.3176667
.meas tran peak_out_b14 FIND V(peak_out_l0) AT=13.2033333
.meas tran peak_l1_b14 FIND V(peak_out_l1) AT=13.2033333
.meas tran f_rr_ratio_b15 FIND V(f_rr_ratio) AT=14.1200000
.meas tran f_rr_asym_b15 FIND V(f_rr_asym) AT=14.1200000
.meas tran f_instab_l0_b15 FIND V(f_instab_l0) AT=14.1200000
.meas tran f_instab_l1_b15 FIND V(f_instab_l1) AT=14.1200000
.meas tran f_pwave_b15 FIND V(f_pwave) AT=14.1200000
.meas tran f_width_b15 FIND V(f_width) AT=14.1200000
.meas tran f_sym_b15 FIND V(f_sym) AT=14.2343333
.meas tran f_slope_b15 FIND V(f_slope) AT=14.2343333
.meas tran rise_timer_b15 FIND V(rise_timer_out) AT=14.2343333
.meas tran fall_timer_b15 FIND V(fall_timer_out) AT=14.2343333
.meas tran peak_out_b15 FIND V(peak_out_l0) AT=14.1200000
.meas tran peak_l1_b15 FIND V(peak_out_l1) AT=14.1200000
.meas tran f_rr_ratio_b16 FIND V(f_rr_ratio) AT=15.0311111
.meas tran f_rr_asym_b16 FIND V(f_rr_asym) AT=15.0311111
.meas tran f_instab_l0_b16 FIND V(f_instab_l0) AT=15.0311111
.meas tran f_instab_l1_b16 FIND V(f_instab_l1) AT=15.0311111
.meas tran f_pwave_b16 FIND V(f_pwave) AT=15.0311111
.meas tran f_width_b16 FIND V(f_width) AT=15.0311111
.meas tran f_sym_b16 FIND V(f_sym) AT=15.1454444
.meas tran f_slope_b16 FIND V(f_slope) AT=15.1454444
.meas tran rise_timer_b16 FIND V(rise_timer_out) AT=15.1454444
.meas tran fall_timer_b16 FIND V(fall_timer_out) AT=15.1454444
.meas tran peak_out_b16 FIND V(peak_out_l0) AT=15.0311111
.meas tran peak_l1_b16 FIND V(peak_out_l1) AT=15.0311111
.meas tran f_rr_ratio_b17 FIND V(f_rr_ratio) AT=15.8950000
.meas tran f_rr_asym_b17 FIND V(f_rr_asym) AT=15.8950000
.meas tran f_instab_l0_b17 FIND V(f_instab_l0) AT=15.8950000
.meas tran f_instab_l1_b17 FIND V(f_instab_l1) AT=15.8950000
.meas tran f_pwave_b17 FIND V(f_pwave) AT=15.8950000
.meas tran f_width_b17 FIND V(f_width) AT=15.8950000
.meas tran f_sym_b17 FIND V(f_sym) AT=16.0093333
.meas tran f_slope_b17 FIND V(f_slope) AT=16.0093333
.meas tran rise_timer_b17 FIND V(rise_timer_out) AT=16.0093333
.meas tran fall_timer_b17 FIND V(fall_timer_out) AT=16.0093333
.meas tran peak_out_b17 FIND V(peak_out_l0) AT=15.8950000
.meas tran peak_l1_b17 FIND V(peak_out_l1) AT=15.8950000
.meas tran f_rr_ratio_b18 FIND V(f_rr_ratio) AT=16.8477778
.meas tran f_rr_asym_b18 FIND V(f_rr_asym) AT=16.8477778
.meas tran f_instab_l0_b18 FIND V(f_instab_l0) AT=16.8477778
.meas tran f_instab_l1_b18 FIND V(f_instab_l1) AT=16.8477778
.meas tran f_pwave_b18 FIND V(f_pwave) AT=16.8477778
.meas tran f_width_b18 FIND V(f_width) AT=16.8477778
.meas tran f_sym_b18 FIND V(f_sym) AT=16.9621111
.meas tran f_slope_b18 FIND V(f_slope) AT=16.9621111
.meas tran rise_timer_b18 FIND V(rise_timer_out) AT=16.9621111
.meas tran fall_timer_b18 FIND V(fall_timer_out) AT=16.9621111
.meas tran peak_out_b18 FIND V(peak_out_l0) AT=16.8477778
.meas tran peak_l1_b18 FIND V(peak_out_l1) AT=16.8477778
.meas tran f_rr_ratio_b19 FIND V(f_rr_ratio) AT=17.7811111
.meas tran f_rr_asym_b19 FIND V(f_rr_asym) AT=17.7811111
.meas tran f_instab_l0_b19 FIND V(f_instab_l0) AT=17.7811111
.meas tran f_instab_l1_b19 FIND V(f_instab_l1) AT=17.7811111
.meas tran f_pwave_b19 FIND V(f_pwave) AT=17.7811111
.meas tran f_width_b19 FIND V(f_width) AT=17.7811111
.meas tran f_sym_b19 FIND V(f_sym) AT=17.8954444
.meas tran f_slope_b19 FIND V(f_slope) AT=17.8954444
.meas tran rise_timer_b19 FIND V(rise_timer_out) AT=17.8954444
.meas tran fall_timer_b19 FIND V(fall_timer_out) AT=17.8954444
.meas tran peak_out_b19 FIND V(peak_out_l0) AT=17.7811111
.meas tran peak_l1_b19 FIND V(peak_out_l1) AT=17.7811111
.meas tran f_rr_ratio_b20 FIND V(f_rr_ratio) AT=18.6477778
.meas tran f_rr_asym_b20 FIND V(f_rr_asym) AT=18.6477778
.meas tran f_instab_l0_b20 FIND V(f_instab_l0) AT=18.6477778
.meas tran f_instab_l1_b20 FIND V(f_instab_l1) AT=18.6477778
.meas tran f_pwave_b20 FIND V(f_pwave) AT=18.6477778
.meas tran f_width_b20 FIND V(f_width) AT=18.6477778
.meas tran f_sym_b20 FIND V(f_sym) AT=18.6815556
.meas tran f_slope_b20 FIND V(f_slope) AT=18.6815556
.meas tran rise_timer_b20 FIND V(rise_timer_out) AT=18.6815556
.meas tran fall_timer_b20 FIND V(fall_timer_out) AT=18.6815556
.meas tran peak_out_b20 FIND V(peak_out_l0) AT=18.6477778
.meas tran peak_l1_b20 FIND V(peak_out_l1) AT=18.6477778
.meas tran f_rr_ratio_b21 FIND V(f_rr_ratio) AT=19.1950000
.meas tran f_rr_asym_b21 FIND V(f_rr_asym) AT=19.1950000
.meas tran f_instab_l0_b21 FIND V(f_instab_l0) AT=19.1950000
.meas tran f_instab_l1_b21 FIND V(f_instab_l1) AT=19.1950000
.meas tran f_pwave_b21 FIND V(f_pwave) AT=19.1950000
.meas tran f_width_b21 FIND V(f_width) AT=19.1950000
.meas tran f_sym_b21 FIND V(f_sym) AT=19.2398889
.meas tran f_slope_b21 FIND V(f_slope) AT=19.2398889
.meas tran rise_timer_b21 FIND V(rise_timer_out) AT=19.2398889
.meas tran fall_timer_b21 FIND V(fall_timer_out) AT=19.2398889
.meas tran peak_out_b21 FIND V(peak_out_l0) AT=19.1950000
.meas tran peak_l1_b21 FIND V(peak_out_l1) AT=19.1950000
.meas tran f_rr_ratio_b22 FIND V(f_rr_ratio) AT=20.4977778
.meas tran f_rr_asym_b22 FIND V(f_rr_asym) AT=20.4977778
.meas tran f_instab_l0_b22 FIND V(f_instab_l0) AT=20.4977778
.meas tran f_instab_l1_b22 FIND V(f_instab_l1) AT=20.4977778
.meas tran f_pwave_b22 FIND V(f_pwave) AT=20.4977778
.meas tran f_width_b22 FIND V(f_width) AT=20.4977778
.meas tran f_sym_b22 FIND V(f_sym) AT=20.6121111
.meas tran f_slope_b22 FIND V(f_slope) AT=20.6121111
.meas tran rise_timer_b22 FIND V(rise_timer_out) AT=20.6121111
.meas tran fall_timer_b22 FIND V(fall_timer_out) AT=20.6121111
.meas tran peak_out_b22 FIND V(peak_out_l0) AT=20.4977778
.meas tran peak_l1_b22 FIND V(peak_out_l1) AT=20.4977778
.meas tran f_rr_ratio_b23 FIND V(f_rr_ratio) AT=21.0505556
.meas tran f_rr_asym_b23 FIND V(f_rr_asym) AT=21.0505556
.meas tran f_instab_l0_b23 FIND V(f_instab_l0) AT=21.0505556
.meas tran f_instab_l1_b23 FIND V(f_instab_l1) AT=21.0505556
.meas tran f_pwave_b23 FIND V(f_pwave) AT=21.0505556
.meas tran f_width_b23 FIND V(f_width) AT=21.0505556
.meas tran f_sym_b23 FIND V(f_sym) AT=21.1010000
.meas tran f_slope_b23 FIND V(f_slope) AT=21.1010000
.meas tran rise_timer_b23 FIND V(rise_timer_out) AT=21.1010000
.meas tran fall_timer_b23 FIND V(fall_timer_out) AT=21.1010000
.meas tran peak_out_b23 FIND V(peak_out_l0) AT=21.0505556
.meas tran peak_l1_b23 FIND V(peak_out_l1) AT=21.0505556
.meas tran f_rr_ratio_b24 FIND V(f_rr_ratio) AT=22.3922222
.meas tran f_rr_asym_b24 FIND V(f_rr_asym) AT=22.3922222
.meas tran f_instab_l0_b24 FIND V(f_instab_l0) AT=22.3922222
.meas tran f_instab_l1_b24 FIND V(f_instab_l1) AT=22.3922222
.meas tran f_pwave_b24 FIND V(f_pwave) AT=22.3922222
.meas tran f_width_b24 FIND V(f_width) AT=22.3922222
.meas tran f_sym_b24 FIND V(f_sym) AT=22.4204444
.meas tran f_slope_b24 FIND V(f_slope) AT=22.4204444
.meas tran rise_timer_b24 FIND V(rise_timer_out) AT=22.4204444
.meas tran fall_timer_b24 FIND V(fall_timer_out) AT=22.4204444
.meas tran peak_out_b24 FIND V(peak_out_l0) AT=22.3922222
.meas tran peak_l1_b24 FIND V(peak_out_l1) AT=22.3922222
.meas tran f_rr_ratio_b25 FIND V(f_rr_ratio) AT=22.9255556
.meas tran f_rr_asym_b25 FIND V(f_rr_asym) AT=22.9255556
.meas tran f_instab_l0_b25 FIND V(f_instab_l0) AT=22.9255556
.meas tran f_instab_l1_b25 FIND V(f_instab_l1) AT=22.9255556
.meas tran f_pwave_b25 FIND V(f_pwave) AT=22.9255556
.meas tran f_width_b25 FIND V(f_width) AT=22.9255556
.meas tran f_sym_b25 FIND V(f_sym) AT=22.9704444
.meas tran f_slope_b25 FIND V(f_slope) AT=22.9704444
.meas tran rise_timer_b25 FIND V(rise_timer_out) AT=22.9704444
.meas tran fall_timer_b25 FIND V(fall_timer_out) AT=22.9704444
.meas tran peak_out_b25 FIND V(peak_out_l0) AT=22.9255556
.meas tran peak_l1_b25 FIND V(peak_out_l1) AT=22.9255556
.meas tran f_rr_ratio_b26 FIND V(f_rr_ratio) AT=24.2561111
.meas tran f_rr_asym_b26 FIND V(f_rr_asym) AT=24.2561111
.meas tran f_instab_l0_b26 FIND V(f_instab_l0) AT=24.2561111
.meas tran f_instab_l1_b26 FIND V(f_instab_l1) AT=24.2561111
.meas tran f_pwave_b26 FIND V(f_pwave) AT=24.2561111
.meas tran f_width_b26 FIND V(f_width) AT=24.2561111
.meas tran f_sym_b26 FIND V(f_sym) AT=24.2676667
.meas tran f_slope_b26 FIND V(f_slope) AT=24.2676667
.meas tran rise_timer_b26 FIND V(rise_timer_out) AT=24.2676667
.meas tran fall_timer_b26 FIND V(fall_timer_out) AT=24.2676667
.meas tran peak_out_b26 FIND V(peak_out_l0) AT=24.2561111
.meas tran peak_l1_b26 FIND V(peak_out_l1) AT=24.2561111
.meas tran f_rr_ratio_b27 FIND V(f_rr_ratio) AT=24.8255556
.meas tran f_rr_asym_b27 FIND V(f_rr_asym) AT=24.8255556
.meas tran f_instab_l0_b27 FIND V(f_instab_l0) AT=24.8255556
.meas tran f_instab_l1_b27 FIND V(f_instab_l1) AT=24.8255556
.meas tran f_pwave_b27 FIND V(f_pwave) AT=24.8255556
.meas tran f_width_b27 FIND V(f_width) AT=24.8255556
.meas tran f_sym_b27 FIND V(f_sym) AT=24.8704444
.meas tran f_slope_b27 FIND V(f_slope) AT=24.8704444
.meas tran rise_timer_b27 FIND V(rise_timer_out) AT=24.8704444
.meas tran fall_timer_b27 FIND V(fall_timer_out) AT=24.8704444
.meas tran peak_out_b27 FIND V(peak_out_l0) AT=24.8255556
.meas tran peak_l1_b27 FIND V(peak_out_l1) AT=24.8255556
.meas tran f_rr_ratio_b28 FIND V(f_rr_ratio) AT=26.0977778
.meas tran f_rr_asym_b28 FIND V(f_rr_asym) AT=26.0977778
.meas tran f_instab_l0_b28 FIND V(f_instab_l0) AT=26.0977778
.meas tran f_instab_l1_b28 FIND V(f_instab_l1) AT=26.0977778
.meas tran f_pwave_b28 FIND V(f_pwave) AT=26.0977778
.meas tran f_width_b28 FIND V(f_width) AT=26.0977778
.meas tran f_sym_b28 FIND V(f_sym) AT=26.1093333
.meas tran f_slope_b28 FIND V(f_slope) AT=26.1093333
.meas tran rise_timer_b28 FIND V(rise_timer_out) AT=26.1093333
.meas tran fall_timer_b28 FIND V(fall_timer_out) AT=26.1093333
.meas tran peak_out_b28 FIND V(peak_out_l0) AT=26.0977778
.meas tran peak_l1_b28 FIND V(peak_out_l1) AT=26.0977778
.meas tran f_rr_ratio_b29 FIND V(f_rr_ratio) AT=26.7283333
.meas tran f_rr_asym_b29 FIND V(f_rr_asym) AT=26.7283333
.meas tran f_instab_l0_b29 FIND V(f_instab_l0) AT=26.7283333
.meas tran f_instab_l1_b29 FIND V(f_instab_l1) AT=26.7283333
.meas tran f_pwave_b29 FIND V(f_pwave) AT=26.7283333
.meas tran f_width_b29 FIND V(f_width) AT=26.7283333
.meas tran f_sym_b29 FIND V(f_sym) AT=26.7426667
.meas tran f_slope_b29 FIND V(f_slope) AT=26.7426667
.meas tran rise_timer_b29 FIND V(rise_timer_out) AT=26.7426667
.meas tran fall_timer_b29 FIND V(fall_timer_out) AT=26.7426667
.meas tran peak_out_b29 FIND V(peak_out_l0) AT=26.7283333
.meas tran peak_l1_b29 FIND V(peak_out_l1) AT=26.7283333
.meas tran f_rr_ratio_b30 FIND V(f_rr_ratio) AT=27.9672222
.meas tran f_rr_asym_b30 FIND V(f_rr_asym) AT=27.9672222
.meas tran f_instab_l0_b30 FIND V(f_instab_l0) AT=27.9672222
.meas tran f_instab_l1_b30 FIND V(f_instab_l1) AT=27.9672222
.meas tran f_pwave_b30 FIND V(f_pwave) AT=27.9672222
.meas tran f_width_b30 FIND V(f_width) AT=27.9672222
.meas tran f_sym_b30 FIND V(f_sym) AT=27.9815556
.meas tran f_slope_b30 FIND V(f_slope) AT=27.9815556
.meas tran rise_timer_b30 FIND V(rise_timer_out) AT=27.9815556
.meas tran fall_timer_b30 FIND V(fall_timer_out) AT=27.9815556
.meas tran peak_out_b30 FIND V(peak_out_l0) AT=27.9672222
.meas tran peak_l1_b30 FIND V(peak_out_l1) AT=27.9672222
.meas tran f_rr_ratio_b31 FIND V(f_rr_ratio) AT=28.5172222
.meas tran f_rr_asym_b31 FIND V(f_rr_asym) AT=28.5172222
.meas tran f_instab_l0_b31 FIND V(f_instab_l0) AT=28.5172222
.meas tran f_instab_l1_b31 FIND V(f_instab_l1) AT=28.5172222
.meas tran f_pwave_b31 FIND V(f_pwave) AT=28.5172222
.meas tran f_width_b31 FIND V(f_width) AT=28.5172222
.meas tran f_sym_b31 FIND V(f_sym) AT=28.5704444
.meas tran f_slope_b31 FIND V(f_slope) AT=28.5704444
.meas tran rise_timer_b31 FIND V(rise_timer_out) AT=28.5704444
.meas tran fall_timer_b31 FIND V(fall_timer_out) AT=28.5704444
.meas tran peak_out_b31 FIND V(peak_out_l0) AT=28.5172222
.meas tran peak_l1_b31 FIND V(peak_out_l1) AT=28.5172222
.meas tran f_rr_ratio_b32 FIND V(f_rr_ratio) AT=29.8505556
.meas tran f_rr_asym_b32 FIND V(f_rr_asym) AT=29.8505556
.meas tran f_instab_l0_b32 FIND V(f_instab_l0) AT=29.8505556
.meas tran f_instab_l1_b32 FIND V(f_instab_l1) AT=29.8505556
.meas tran f_pwave_b32 FIND V(f_pwave) AT=29.8505556
.meas tran f_width_b32 FIND V(f_width) AT=29.8505556
.meas tran f_sym_b32 FIND V(f_sym) AT=29.8621111
.meas tran f_slope_b32 FIND V(f_slope) AT=29.8621111
.meas tran rise_timer_b32 FIND V(rise_timer_out) AT=29.8621111
.meas tran fall_timer_b32 FIND V(fall_timer_out) AT=29.8621111
.meas tran peak_out_b32 FIND V(peak_out_l0) AT=29.8505556
.meas tran peak_l1_b32 FIND V(peak_out_l1) AT=29.8505556
.meas tran f_rr_ratio_b33 FIND V(f_rr_ratio) AT=30.7338889
.meas tran f_rr_asym_b33 FIND V(f_rr_asym) AT=30.7338889
.meas tran f_instab_l0_b33 FIND V(f_instab_l0) AT=30.7338889
.meas tran f_instab_l1_b33 FIND V(f_instab_l1) AT=30.7338889
.meas tran f_pwave_b33 FIND V(f_pwave) AT=30.7338889
.meas tran f_width_b33 FIND V(f_width) AT=30.7338889
.meas tran f_sym_b33 FIND V(f_sym) AT=30.7482222
.meas tran f_slope_b33 FIND V(f_slope) AT=30.7482222
.meas tran rise_timer_b33 FIND V(rise_timer_out) AT=30.7482222
.meas tran fall_timer_b33 FIND V(fall_timer_out) AT=30.7482222
.meas tran peak_out_b33 FIND V(peak_out_l0) AT=30.7338889
.meas tran peak_l1_b33 FIND V(peak_out_l1) AT=30.7338889
.meas tran f_rr_ratio_b34 FIND V(f_rr_ratio) AT=31.6311111
.meas tran f_rr_asym_b34 FIND V(f_rr_asym) AT=31.6311111
.meas tran f_instab_l0_b34 FIND V(f_instab_l0) AT=31.6311111
.meas tran f_instab_l1_b34 FIND V(f_instab_l1) AT=31.6311111
.meas tran f_pwave_b34 FIND V(f_pwave) AT=31.6311111
.meas tran f_width_b34 FIND V(f_width) AT=31.6311111
.meas tran f_sym_b34 FIND V(f_sym) AT=31.6621111
.meas tran f_slope_b34 FIND V(f_slope) AT=31.6621111
.meas tran rise_timer_b34 FIND V(rise_timer_out) AT=31.6621111
.meas tran fall_timer_b34 FIND V(fall_timer_out) AT=31.6621111
.meas tran peak_out_b34 FIND V(peak_out_l0) AT=31.6311111
.meas tran peak_l1_b34 FIND V(peak_out_l1) AT=31.6311111
.meas tran f_rr_ratio_b35 FIND V(f_rr_ratio) AT=32.5088889
.meas tran f_rr_asym_b35 FIND V(f_rr_asym) AT=32.5088889
.meas tran f_instab_l0_b35 FIND V(f_instab_l0) AT=32.5088889
.meas tran f_instab_l1_b35 FIND V(f_instab_l1) AT=32.5088889
.meas tran f_pwave_b35 FIND V(f_pwave) AT=32.5088889
.meas tran f_width_b35 FIND V(f_width) AT=32.5088889
.meas tran f_sym_b35 FIND V(f_sym) AT=32.6232222
.meas tran f_slope_b35 FIND V(f_slope) AT=32.6232222
.meas tran rise_timer_b35 FIND V(rise_timer_out) AT=32.6232222
.meas tran fall_timer_b35 FIND V(fall_timer_out) AT=32.6232222
.meas tran peak_out_b35 FIND V(peak_out_l0) AT=32.5088889
.meas tran peak_l1_b35 FIND V(peak_out_l1) AT=32.5088889
.meas tran f_rr_ratio_b36 FIND V(f_rr_ratio) AT=33.3477778
.meas tran f_rr_asym_b36 FIND V(f_rr_asym) AT=33.3477778
.meas tran f_instab_l0_b36 FIND V(f_instab_l0) AT=33.3477778
.meas tran f_instab_l1_b36 FIND V(f_instab_l1) AT=33.3477778
.meas tran f_pwave_b36 FIND V(f_pwave) AT=33.3477778
.meas tran f_width_b36 FIND V(f_width) AT=33.3477778
.meas tran f_sym_b36 FIND V(f_sym) AT=33.4621111
.meas tran f_slope_b36 FIND V(f_slope) AT=33.4621111
.meas tran rise_timer_b36 FIND V(rise_timer_out) AT=33.4621111
.meas tran fall_timer_b36 FIND V(fall_timer_out) AT=33.4621111
.meas tran peak_out_b36 FIND V(peak_out_l0) AT=33.3477778
.meas tran peak_l1_b36 FIND V(peak_out_l1) AT=33.3477778
.meas tran f_rr_ratio_b37 FIND V(f_rr_ratio) AT=33.8894444
.meas tran f_rr_asym_b37 FIND V(f_rr_asym) AT=33.8894444
.meas tran f_instab_l0_b37 FIND V(f_instab_l0) AT=33.8894444
.meas tran f_instab_l1_b37 FIND V(f_instab_l1) AT=33.8894444
.meas tran f_pwave_b37 FIND V(f_pwave) AT=33.8894444
.meas tran f_width_b37 FIND V(f_width) AT=33.8894444
.meas tran f_sym_b37 FIND V(f_sym) AT=33.9371111
.meas tran f_slope_b37 FIND V(f_slope) AT=33.9371111
.meas tran rise_timer_b37 FIND V(rise_timer_out) AT=33.9371111
.meas tran fall_timer_b37 FIND V(fall_timer_out) AT=33.9371111
.meas tran peak_out_b37 FIND V(peak_out_l0) AT=33.8894444
.meas tran peak_l1_b37 FIND V(peak_out_l1) AT=33.8894444
.meas tran f_rr_ratio_b38 FIND V(f_rr_ratio) AT=35.1755556
.meas tran f_rr_asym_b38 FIND V(f_rr_asym) AT=35.1755556
.meas tran f_instab_l0_b38 FIND V(f_instab_l0) AT=35.1755556
.meas tran f_instab_l1_b38 FIND V(f_instab_l1) AT=35.1755556
.meas tran f_pwave_b38 FIND V(f_pwave) AT=35.1755556
.meas tran f_width_b38 FIND V(f_width) AT=35.1755556
.meas tran f_sym_b38 FIND V(f_sym) AT=35.2898889
.meas tran f_slope_b38 FIND V(f_slope) AT=35.2898889
.meas tran rise_timer_b38 FIND V(rise_timer_out) AT=35.2898889
.meas tran fall_timer_b38 FIND V(fall_timer_out) AT=35.2898889
.meas tran peak_out_b38 FIND V(peak_out_l0) AT=35.1755556
.meas tran peak_l1_b38 FIND V(peak_out_l1) AT=35.1755556
.meas tran f_rr_ratio_b39 FIND V(f_rr_ratio) AT=35.7172222
.meas tran f_rr_asym_b39 FIND V(f_rr_asym) AT=35.7172222
.meas tran f_instab_l0_b39 FIND V(f_instab_l0) AT=35.7172222
.meas tran f_instab_l1_b39 FIND V(f_instab_l1) AT=35.7172222
.meas tran f_pwave_b39 FIND V(f_pwave) AT=35.7172222
.meas tran f_width_b39 FIND V(f_width) AT=35.7172222
.meas tran f_sym_b39 FIND V(f_sym) AT=35.7621111
.meas tran f_slope_b39 FIND V(f_slope) AT=35.7621111
.meas tran rise_timer_b39 FIND V(rise_timer_out) AT=35.7621111
.meas tran fall_timer_b39 FIND V(fall_timer_out) AT=35.7621111
.meas tran peak_out_b39 FIND V(peak_out_l0) AT=35.7172222
.meas tran peak_l1_b39 FIND V(peak_out_l1) AT=35.7172222

.end
