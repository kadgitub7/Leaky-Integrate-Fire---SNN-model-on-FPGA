* ============================================================
* FEATURE 6: QRS Width v1
*
* Python: width = duration where |QRS| > 0.3 * peak (in ms)
* Analog: comparator (ECG vs 0.3*prev_peak) gates a timer
*
* Uses prev_peak from beat_instability circuit (already available).
* Threshold = 0.3 * prev_peak generated by charge-sharing:
*   Sample prev_peak onto C_num (3pF), then share with C_den (7pF)
*   V_thresh = prev_peak * 3/(3+7) = 0.3 * prev_peak
*
* Comparator: diff pair (ECG vs threshold)
*   - When ECG > threshold: comp_out goes HIGH
*   - Mirror loads for sharp switching
*
* Timer: current source charges cap while comp_out is HIGH
*   - V_width = I_timer * t_above / C_timer
*   - I_timer = ~150 pA, C_timer = ~5pF
*   - For 100ms QRS: V_width = 150e-12 * 0.1 / 5e-12 = 3V (too high)
*   - Scale: I_timer = ~15 pA, C_timer = ~50pF
*   - For 100ms QRS: V_width = 15e-12 * 0.1 / 50e-12 = 30mV
*   - For 30ms QRS: V_width = 9mV
*   - Need larger range. I=150pA, C=500pF?
*   - 100ms: 150e-12*0.1/500e-12 = 30mV. Still small.
*   Actually: use I=150pA, C=5pF:
*   - 30ms: 0.9V, 100ms: 3V (clips at VDD)
*   - Better: I=50pA, C=5pF:
*   - 30ms: 0.3V, 100ms: 1V (clips slightly)
*   - I=30pA, C=5pF: 30ms->0.18V, 100ms->0.6V. Good range!
*
* Pin: ecg_abs thresh_sample_trig thresh_share_trig
*      width_reset_trig width_out vdd vss vbias prev_peak_in
* ============================================================

.subckt qrs_width_v1 ecg_abs thresh_sample_trig thresh_share_trig width_reset_trig width_out vdd vss vbias prev_peak_in

* === THRESHOLD GENERATOR: 0.3 * prev_peak ===
* Step 1: Sample prev_peak onto C_num (W=12 L=12 -> 288fF ≈ 0.3pF)
XMts prev_peak_in thresh_sample_trig thresh_samp vss sky130_fd_pr__nfet_01v8 L=0.5 W=2 nf=1
XCts thresh_samp vss sky130_fd_pr__cap_mim_m3_1 W=12 L=12

* Step 2: Share with C_den (W=17 L=17 -> 578fF ≈ 0.6pF, but need 7:3 ratio)
* Actually: C_num=3, C_den=7 units. Total = 10 units.
* MIM: 2fF/um². For 3 units = 300fF: W=12.2 L=12.2
* For 7 units = 700fF: W=18.7 L=18.7
* After sharing: V = 300/(300+700) * V_samp = 0.3 * V_samp
* Share switch connects thresh_samp to thresh_node (which has C_den)
XMtsh thresh_samp thresh_share_trig thresh_node vss sky130_fd_pr__nfet_01v8 L=0.5 W=2 nf=1
XCtd thresh_node vss sky130_fd_pr__cap_mim_m3_1 W=19 L=19

* === COMPARATOR: ECG vs threshold ===
* Mirror-load diff pair for sharp switching
* When ecg_abs > thresh_node: comp_out goes HIGH (toward VDD)
XMc_tail ctail vbias vss vss sky130_fd_pr__nfet_01v8 L=8 W=0.42 nf=1
XMc1 cnet ecg_abs ctail vss sky130_fd_pr__nfet_01v8 L=2 W=2 nf=1
XMc2 comp_out thresh_node ctail vss sky130_fd_pr__nfet_01v8 L=2 W=2 nf=1
XMc3 cnet cnet vdd vdd sky130_fd_pr__pfet_01v8 L=4 W=2 nf=1
XMc4 comp_out cnet vdd vdd sky130_fd_pr__pfet_01v8 L=4 W=2 nf=1

* === TIMER: charges while comp_out is HIGH ===
* Timer capacitor: 5pF (W=50 L=50)
* Current source: PMOS controlled by comp_out (inverted logic)
* When comp_out=HIGH (ECG>thresh): timer PMOS gate is LOW via inverter? No.
* Simpler: use comp_out to gate an NFET current source
* When comp_out is HIGH: NFET conducts, charges timer cap UP
* Timer current: ~30pA for good range
XMtimer_sw timer_node comp_out vss vss sky130_fd_pr__nfet_01v8 L=8 W=0.42 nf=1
XCtimer width_out vss sky130_fd_pr__cap_mim_m3_1 W=50 L=50

* Timer charge path: when comp_out HIGH, current flows through switch to cap
* Actually need a proper current source gated by comparator.
* Use: PMOS current mirror as source, NFET switch gated by comparator
* When comp_out=HIGH: switch closes, current charges cap
XMt_src timer_node timer_node vdd vdd sky130_fd_pr__pfet_01v8 L=8 W=0.42 nf=1

* Reset switch: discharge timer cap before each QRS
XMreset width_out width_reset_trig vss vss sky130_fd_pr__nfet_01v8 L=0.5 W=2 nf=1

.ends qrs_width_v1
