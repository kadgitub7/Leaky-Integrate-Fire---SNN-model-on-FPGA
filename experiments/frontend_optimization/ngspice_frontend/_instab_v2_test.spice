.title instab_v2_test
.lib "sky130_minimal.lib.spice" tt
.option scale=1.0u method=gear gmin=1e-15 abstol=1e-15 reltol=0.005
.temp 27
.include "beat_instability_v2.spice"

Vdd vdd 0 0.9
Vss vss 0 0
Vbias vbias 0 0.35

Vecg ecg_in 0 PWL(0.0000000 0.250000 0.2500000 0.350000 0.2527778 0.342105 0.2555556 0.339474 0.2583333 0.336842 0.2611111 0.342105 0.2638889 0.344737 0.2666667 0.342105 0.2694444 0.336842 0.2722222 0.331579 0.2750000 0.334211 0.2777778 0.331579 0.2805556 0.336842 0.2833333 0.334211 0.2861111 0.331579 0.2888889 0.318421 0.2916667 0.336842 0.2944444 0.334211 0.2972222 0.339474 0.3000000 0.326316 0.3027778 0.321053 0.3055556 0.318421 0.3083333 0.321053 0.3111111 0.326316 0.3138889 0.321053 0.3166667 0.318421 0.3194444 0.318421 0.3222222 0.321053 0.3250000 0.321053 0.3277778 0.328947 0.3305556 0.323684 0.3333333 0.315789 0.3361111 0.318421 0.3388889 0.323684 0.3416667 0.331579 0.3444444 0.336842 0.3472222 0.339474 0.3500000 0.336842 0.3527778 0.328947 0.3555556 0.336842 0.3583333 0.336842 0.3611111 0.342105 0.3638889 0.339474 0.3666667 0.328947 0.3694444 0.336842 0.3722222 0.334211 0.3750000 0.342105 0.3777778 0.352632 0.3805556 0.357895 0.3833333 0.352632 0.3861111 0.350000 0.3888889 0.357895 0.3916667 0.360526 0.3944444 0.368421 0.3972222 0.371053 0.4000000 0.371053 0.4027778 0.365789 0.4055556 0.376316 0.4083333 0.384211 0.4111111 0.394737 0.4138889 0.392105 0.4166667 0.384211 0.4194444 0.373684 0.4222222 0.365789 0.4250000 0.376316 0.4277778 0.371053 0.4305556 0.360526 0.4333333 0.334211 0.4361111 0.328947 0.4388889 0.334211 0.4416667 0.334211 0.4444444 0.347368 0.4472222 0.342105 0.4500000 0.326316 0.4527778 0.318421 0.4555556 0.318421 0.4583333 0.323684 0.4611111 0.331579 0.4638889 0.328947 0.4666667 0.302632 0.4694444 0.268421 0.4722222 0.210526 0.4750000 0.147368 0.4777778 0.086842 0.4805556 0.031579 0.4833333 0.010000 0.4861111 0.010000 0.4888889 0.010000 0.4916667 0.010000 0.4944444 0.010000 0.4972222 0.010000 0.5000000 0.010000 0.5027778 0.010000 0.5055556 0.010000 0.5083333 0.010000 0.5111111 0.010000 0.5138889 0.010000 0.5166667 0.010000 0.5194444 0.010000 0.5222222 0.010000 0.5250000 0.010000 0.5277778 0.010000 0.5305556 0.010000 0.5333333 0.010000 0.5361111 0.010000 0.5388889 0.010000 0.5416667 0.010000 0.5444444 0.010000 0.5472222 0.010000 0.5500000 0.010000 0.5527778 0.010000 0.5555556 0.010000 0.5583333 0.010000 0.5611111 0.010000 0.5638889 0.010000 0.5666667 0.010000 0.5694444 0.010000 0.5722222 0.010000 0.5750000 0.010000 0.5777778 0.010000 0.5805556 0.010000 0.5833333 0.010000 0.5861111 0.010000 0.5888889 0.010000 0.5916667 0.010000 0.5944444 0.010000 0.5972222 0.010000 0.6000000 0.010000 0.6027778 0.010000 0.6055556 0.010000 0.6083333 0.010000 0.6111111 0.010000 0.6138889 0.010000 0.6166667 0.010000 0.6194444 0.010000 0.6222222 0.010000 0.6250000 0.010000 0.6277778 0.010000 0.6305556 0.010000 0.6333333 0.010000 0.6361111 0.010000 0.6388889 0.010000 0.6416667 0.010000 0.6444444 0.010000 0.6472222 0.010000 0.6500000 0.010000 0.6527778 0.010000 0.6555556 0.010000 0.6583333 0.010000 0.6611111 0.010000 0.6638889 0.010000 0.6666667 0.010000 0.6694444 0.010000 0.6722222 0.010000 0.6750000 0.010000 0.6777778 0.010000 0.6805556 0.010000 0.6833333 0.010000 0.6861111 0.010000 0.6888889 0.010000 0.6916667 0.010000 0.6944444 0.010000 0.6972222 0.010000 0.7000000 0.010000 0.7027778 0.010000 0.7055556 0.010000 0.7083333 0.010000 0.7111111 0.010000 0.7138889 0.010000 0.7166667 0.010000 0.7194444 0.010000 0.7222222 0.010000 0.7250000 0.010000 0.7277778 0.010000 0.7305556 0.010000 0.7333333 0.010000 0.7361111 0.010000 0.7388889 0.010000 0.7416667 0.010000 0.7444444 0.010000 0.7472222 0.010000 0.7500000 0.010000 0.7527778 0.010000 0.7555556 0.010000 0.7583333 0.010526 0.7611111 0.021053 0.7638889 0.015789 0.7666667 0.010526 0.7694444 0.021053 0.7722222 0.026316 0.7750000 0.034211 0.7777778 0.047368 0.7805556 0.050000 0.7833333 0.055263 0.7861111 0.057895 0.7888889 0.060526 0.7916667 0.073684 0.7944444 0.086842 0.7972222 0.081579 1.6666667 0.157895 1.6694444 0.160526 1.6722222 0.160526 1.6750000 0.168421 1.6777778 0.173684 1.6805556 0.168421 1.6833333 0.168421 1.6861111 0.165789 1.6888889 0.171053 1.6916667 0.173684 1.6944444 0.176316 1.6972222 0.171053 1.7000000 0.160526 1.7027778 0.155263 1.7055556 0.155263 1.7083333 0.163158 1.7111111 0.173684 1.7138889 0.168421 1.7166667 0.155263 1.7194444 0.160526 1.7222222 0.163158 1.7250000 0.163158 1.7277778 0.173684 1.7305556 0.165789 1.7333333 0.152632 1.7361111 0.160526 1.7388889 0.168421 1.7416667 0.173684 1.7444444 0.181579 1.7472222 0.178947 1.7500000 0.171053 1.7527778 0.165789 1.7555556 0.168421 1.7583333 0.176316 1.7611111 0.173684 1.7638889 0.173684 1.7666667 0.171053 1.7694444 0.165789 1.7722222 0.168421 1.7750000 0.173684 1.7777778 0.176316 1.7805556 0.168421 1.7833333 0.168421 1.7861111 0.163158 1.7888889 0.171053 1.7916667 0.173684 1.7944444 0.176316 1.7972222 0.171053 1.8000000 0.163158 1.8027778 0.157895 1.8055556 0.163158 1.8083333 0.178947 1.8111111 0.178947 1.8138889 0.173684 1.8166667 0.165789 1.8194444 0.165789 1.8222222 0.168421 1.8250000 0.176316 1.8277778 0.181579 1.8305556 0.178947 1.8333333 0.173684 1.8361111 0.171053 1.8388889 0.168421 1.8416667 0.173684 1.8444444 0.184211 1.8472222 0.186842 1.8500000 0.181579 1.8527778 0.178947 1.8555556 0.181579 1.8583333 0.189474 1.8611111 0.192105 1.8638889 0.184211 1.8666667 0.163158 1.8694444 0.147368 1.8722222 0.131579 1.8750000 0.123684 1.8777778 0.128947 1.8805556 0.123684 1.8833333 0.134211 1.8861111 0.163158 1.8888889 0.221053 1.8916667 0.292105 1.8944444 0.360526 1.8972222 0.407895 1.9000000 0.423684 1.9027778 0.436842 1.9055556 0.465789 1.9083333 0.534211 1.9111111 0.613158 1.9138889 0.657895 1.9166667 0.657895 1.9194444 0.628947 1.9222222 0.600000 1.9250000 0.573684 1.9277778 0.534211 1.9305556 0.468421 1.9333333 0.378947 1.9361111 0.271053 1.9388889 0.186842 1.9416667 0.134211 1.9444444 0.113158 1.9472222 0.100000 1.9500000 0.073684 1.9527778 0.060526 1.9555556 0.042105 1.9583333 0.026316 1.9611111 0.031579 1.9638889 0.047368 1.9666667 0.060526 1.9694444 0.073684 1.9722222 0.092105 1.9750000 0.121053 1.9777778 0.155263 1.9805556 0.176316 1.9833333 0.178947 1.9861111 0.184211 1.9888889 0.176316 1.9916667 0.155263 1.9944444 0.142105 1.9972222 0.128947 2.0000000 0.118421 2.0027778 0.121053 2.0055556 0.123684 2.0083333 0.128947 2.0111111 0.139474 2.0138889 0.134211 2.0166667 0.128947 2.0194444 0.128947 2.0222222 0.128947 2.0250000 0.134211 2.0277778 0.139474 2.0305556 0.134211 2.0333333 0.131579 2.0361111 0.126316 2.0388889 0.128947 2.0416667 0.131579 2.0444444 0.128947 2.0472222 0.126316 2.0500000 0.121053 2.0527778 0.118421 2.0555556 0.121053 2.0583333 0.134211 2.0611111 0.136842 2.0638889 0.134211 2.0666667 0.131579 2.0694444 0.118421 2.0722222 0.128947 2.0750000 0.142105 2.0777778 0.147368 2.0805556 0.147368 2.0833333 0.139474 2.0861111 0.134211 2.0888889 0.139474 2.0916667 0.150000 2.0944444 0.147368 2.0972222 0.144737 2.1000000 0.136842 2.1027778 0.144737 2.1055556 0.150000 2.1083333 0.152632 2.1111111 0.157895 2.1138889 0.155263 2.1166667 0.144737 2.1194444 0.147368 2.1222222 0.155263 2.1250000 0.165789 2.1277778 0.171053 2.1305556 0.171053 2.1333333 0.171053 2.1361111 0.168421 2.1388889 0.176316 2.1416667 0.184211 2.1444444 0.186842 2.1472222 0.181579 2.1500000 0.176316 2.1527778 0.173684 2.1555556 0.181579 2.1583333 0.189474 2.1611111 0.194737 2.1638889 0.186842 2.1666667 0.181579 2.1694444 0.186842 2.1722222 0.197368 2.1750000 0.207895 2.1777778 0.210526 2.1805556 0.213158 2.1833333 0.213158 2.1861111 0.210526 2.1888889 0.215789 2.1916667 0.228947 2.1944444 0.234211 2.1972222 0.236842 2.2000000 0.231579 2.2027778 0.226316 2.2055556 0.226316 2.2083333 0.231579 2.2111111 0.244737 2.2138889 0.244737 2.3138889 0.310526 2.3166667 0.302632 2.3194444 0.300000 2.3222222 0.300000 2.3250000 0.302632 2.3277778 0.300000 2.3305556 0.300000 2.3333333 0.297368 2.3361111 0.289474 2.3388889 0.294737 2.3416667 0.302632 2.3444444 0.302632 2.3472222 0.292105 2.3500000 0.289474 2.3527778 0.289474 2.3555556 0.294737 2.3583333 0.297368 2.3611111 0.286842 2.3638889 0.286842 2.3666667 0.281579 2.3694444 0.278947 2.3722222 0.278947 2.3750000 0.284211 2.3777778 0.281579 2.3805556 0.276316 2.3833333 0.276316 2.3861111 0.265789 2.3888889 0.273684 2.3916667 0.271053 2.3944444 0.273684 2.3972222 0.271053 2.4000000 0.273684 2.4027778 0.271053 2.4055556 0.281579 2.4083333 0.286842 2.4111111 0.286842 2.4138889 0.278947 2.4166667 0.276316 2.4194444 0.273684 2.4222222 0.271053 2.4250000 0.278947 2.4277778 0.284211 2.4305556 0.276316 2.4333333 0.278947 2.4361111 0.276316 2.4388889 0.286842 2.4416667 0.294737 2.4444444 0.297368 2.4472222 0.297368 2.4500000 0.297368 2.4527778 0.302632 2.4555556 0.305263 2.4583333 0.315789 2.4611111 0.318421 2.4638889 0.321053 2.4666667 0.323684 2.4694444 0.318421 2.4722222 0.321053 2.4750000 0.323684 2.4777778 0.331579 2.4805556 0.339474 2.4833333 0.336842 2.4861111 0.331579 2.4888889 0.331579 2.4916667 0.326316 2.4944444 0.321053 2.4972222 0.318421 2.5000000 0.307895 2.5027778 0.307895 2.5055556 0.323684 2.5083333 0.334211 2.5111111 0.347368 2.5138889 0.360526 2.5166667 0.352632 2.5194444 0.363158 2.5222222 0.365789 2.5250000 0.368421 2.5277778 0.357895 2.5305556 0.328947 2.5333333 0.292105 2.5361111 0.250000 2.5388889 0.210526 2.5416667 0.152632 2.5444444 0.102632 2.5472222 0.042105 2.5500000 0.010000 2.5527778 0.010000 2.5555556 0.010000 2.5583333 0.010000 2.5611111 0.010000 2.5638889 0.010000 2.5666667 0.010000 2.5694444 0.010000 2.5722222 0.010000 2.5750000 0.010000 2.5777778 0.010000 2.5805556 0.010000 2.5833333 0.010000 2.5861111 0.010000 2.5888889 0.010000 2.5916667 0.010000 2.5944444 0.010000 2.5972222 0.010000 2.6000000 0.010000 2.6027778 0.010000 2.6055556 0.010000 2.6083333 0.010000 2.6111111 0.010000 2.6138889 0.010000 2.6166667 0.010000 2.6194444 0.010000 2.6222222 0.010000 2.6250000 0.010000 2.6277778 0.010000 2.6305556 0.010000 2.6333333 0.010000 2.6361111 0.010000 2.6388889 0.010000 2.6416667 0.010000 2.6444444 0.010000 2.6472222 0.010000 2.6500000 0.010000 2.6527778 0.010000 2.6555556 0.010000 2.6583333 0.010000 2.6611111 0.010000 2.6638889 0.010000 2.6666667 0.010000 2.6694444 0.010000 2.6722222 0.010000 2.6750000 0.010000 2.6777778 0.010000 2.6805556 0.010000 2.6833333 0.010000 2.6861111 0.010000 2.6888889 0.010000 2.6916667 0.010000 2.6944444 0.010000 2.6972222 0.010000 2.7000000 0.010000 2.7027778 0.010000 2.7055556 0.010000 2.7083333 0.010000 2.7111111 0.010000 2.7138889 0.010000 2.7166667 0.010000 2.7194444 0.010000 2.7222222 0.010000 2.7250000 0.010000 2.7277778 0.010000 2.7305556 0.010000 2.7333333 0.010000 2.7361111 0.010000 2.7388889 0.010000 2.7416667 0.010000 2.7444444 0.010000 2.7472222 0.010000 2.7500000 0.010000 2.7527778 0.010000 2.7555556 0.010000 2.7583333 0.010000 2.7611111 0.010000 2.7638889 0.010000 2.7666667 0.010000 2.7694444 0.010000 2.7722222 0.010000 2.7750000 0.010000 2.7777778 0.010000 2.7805556 0.010000 2.7833333 0.010000 2.7861111 0.010000 2.7888889 0.010000 2.7916667 0.010000 2.7944444 0.010000 2.7972222 0.010000 2.8000000 0.010000 2.8027778 0.010000 2.8055556 0.010000 2.8083333 0.010000 2.8111111 0.010000 2.8138889 0.010000 2.8166667 0.010000 2.8194444 0.010000 2.8222222 0.010000 2.8250000 0.010000 2.8277778 0.010000 2.8305556 0.010000 2.8333333 0.010000 2.8361111 0.010000 2.8388889 0.010000 2.8416667 0.010000 2.8444444 0.010000 2.8472222 0.010000 2.8500000 0.010000 2.8527778 0.010000 2.8555556 0.010000 2.8583333 0.010000 2.8611111 0.010000 3.7611111 0.173684 3.7638889 0.173684 3.7666667 0.171053 3.7694444 0.163158 3.7722222 0.160526 3.7750000 0.173684 3.7777778 0.176316 3.7805556 0.173684 3.7833333 0.160526 3.7861111 0.165789 3.7888889 0.168421 3.7916667 0.171053 3.7944444 0.176316 3.7972222 0.160526 3.8000000 0.155263 3.8027778 0.157895 3.8055556 0.160526 3.8083333 0.171053 3.8111111 0.173684 3.8138889 0.160526 3.8166667 0.157895 3.8194444 0.160526 3.8222222 0.173684 3.8250000 0.178947 3.8277778 0.178947 3.8305556 0.176316 3.8333333 0.171053 3.8361111 0.163158 3.8388889 0.160526 3.8416667 0.163158 3.8444444 0.171053 3.8472222 0.163158 3.8500000 0.160526 3.8527778 0.157895 3.8555556 0.163158 3.8583333 0.171053 3.8611111 0.173684 3.8638889 0.168421 3.8666667 0.163158 3.8694444 0.160526 3.8722222 0.168421 3.8750000 0.176316 3.8777778 0.178947 3.8805556 0.171053 3.8833333 0.171053 3.8861111 0.168421 3.8888889 0.176316 3.8916667 0.178947 3.8944444 0.178947 3.8972222 0.171053 3.9000000 0.163158 3.9027778 0.157895 3.9055556 0.163158 3.9083333 0.173684 3.9111111 0.171053 3.9138889 0.160526 3.9166667 0.160526 3.9194444 0.165789 3.9222222 0.176316 3.9250000 0.181579 3.9277778 0.189474 3.9305556 0.186842 3.9333333 0.184211 3.9361111 0.178947 3.9388889 0.189474 3.9416667 0.200000 3.9444444 0.197368 3.9472222 0.184211 3.9500000 0.178947 3.9527778 0.181579 3.9555556 0.178947 3.9583333 0.176316 3.9611111 0.173684 3.9638889 0.152632 3.9666667 0.131579 3.9694444 0.128947 3.9722222 0.126316 3.9750000 0.134211 3.9777778 0.147368 3.9805556 0.163158 3.9833333 0.207895 3.9861111 0.268421 3.9888889 0.334211 3.9916667 0.386842 3.9944444 0.418421 3.9972222 0.439474 4.0000000 0.450000 4.0027778 0.489474 4.0055556 0.565789 4.0083333 0.628947 4.0111111 0.655263 4.0138889 0.636842 4.0166667 0.597368 4.0194444 0.565789 4.0222222 0.536842 4.0250000 0.497368 4.0277778 0.434211 4.0305556 0.331579 4.0333333 0.226316 4.0361111 0.152632 4.0388889 0.121053 4.0416667 0.113158 4.0444444 0.097368 4.0472222 0.089474 4.0500000 0.060526 4.0527778 0.036842 4.0555556 0.031579 4.0583333 0.047368 4.0611111 0.065789 4.0638889 0.081579 4.0666667 0.086842 4.0694444 0.107895 4.0722222 0.136842 4.0750000 0.173684 4.0777778 0.186842 4.0805556 0.186842 4.0833333 0.173684 4.0861111 0.150000 4.0888889 0.142105 4.0916667 0.134211 4.0944444 0.131579 4.0972222 0.126316 4.1000000 0.123684 4.1027778 0.131579 4.1055556 0.131579 4.1083333 0.139474 4.1111111 0.142105 4.1138889 0.142105 4.1166667 0.134211 4.1194444 0.136842 4.1222222 0.139474 4.1250000 0.139474 4.1277778 0.136842 4.1305556 0.131579 4.1333333 0.121053 4.1361111 0.126316 4.1388889 0.134211 4.1416667 0.136842 4.1444444 0.134211 4.1472222 0.134211 4.1500000 0.131579 4.1527778 0.134211 4.1555556 0.142105 4.1583333 0.139474 4.1611111 0.150000 4.1638889 0.144737 4.1666667 0.139474 4.1694444 0.144737 4.1722222 0.147368 4.1750000 0.157895 4.1777778 0.150000 4.1805556 0.147368 4.1833333 0.142105 4.1861111 0.142105 4.1888889 0.150000 4.1916667 0.157895 4.1944444 0.163158 4.1972222 0.157895 4.2000000 0.152632 4.2027778 0.150000 4.2055556 0.163158 4.2083333 0.171053 4.2111111 0.173684 4.2138889 0.171053 4.2166667 0.171053 4.2194444 0.168421 4.2222222 0.173684 4.2250000 0.184211 4.2277778 0.184211 4.2305556 0.178947 4.2333333 0.173684 4.2361111 0.181579 4.2388889 0.173684 4.2416667 0.189474 4.2444444 0.192105 4.2472222 0.186842 4.2500000 0.178947 4.2527778 0.186842 4.2555556 0.192105 4.2583333 0.200000 4.2611111 0.200000 4.2638889 0.200000 4.2666667 0.194737 4.2694444 0.197368 4.2722222 0.210526 4.2750000 0.218421 4.2777778 0.221053 4.2805556 0.210526 4.2833333 0.213158 4.2861111 0.223684 4.2888889 0.226316 4.2916667 0.234211 4.2944444 0.228947 4.2972222 0.228947 4.3000000 0.218421 4.3027778 0.223684 4.3055556 0.231579 4.3083333 0.242105 4.4583333 0.305263 4.4611111 0.302632 4.4638889 0.297368 4.4666667 0.286842 4.4694444 0.289474 4.4722222 0.289474 4.4750000 0.294737 4.4777778 0.297368 4.4805556 0.286842 4.4833333 0.273684 4.4861111 0.268421 4.4888889 0.278947 4.4916667 0.286842 4.4944444 0.286842 4.4972222 0.276316 4.5000000 0.265789 4.5027778 0.268421 4.5055556 0.273684 4.5083333 0.281579 4.5111111 0.281579 4.5138889 0.281579 4.5166667 0.265789 4.5194444 0.276316 4.5222222 0.281579 4.5250000 0.289474 4.5277778 0.289474 4.5305556 0.286842 4.5333333 0.281579 4.5361111 0.284211 4.5388889 0.284211 4.5416667 0.284211 4.5444444 0.292105 4.5472222 0.284211 4.5500000 0.284211 4.5527778 0.284211 4.5555556 0.286842 4.5583333 0.284211 4.5611111 0.294737 4.5638889 0.292105 4.5666667 0.286842 4.5694444 0.292105 4.5722222 0.297368 4.5750000 0.305263 4.5777778 0.307895 4.5805556 0.307895 4.5833333 0.300000 4.5861111 0.305263 4.5888889 0.318421 4.5916667 0.318421 4.5944444 0.326316 4.5972222 0.326316 4.6000000 0.318421 4.6027778 0.318421 4.6055556 0.331579 4.6083333 0.331579 4.6111111 0.347368 4.6138889 0.344737 4.6166667 0.339474 4.6194444 0.342105 4.6222222 0.347368 4.6250000 0.355263 4.6277778 0.347368 4.6305556 0.336842 4.6333333 0.326316 4.6361111 0.331579 4.6388889 0.336842 4.6416667 0.350000 4.6444444 0.350000 4.6472222 0.342105 4.6500000 0.336842 4.6527778 0.339474 4.6555556 0.342105 4.6583333 0.347368 4.6611111 0.336842 4.6638889 0.321053 4.6666667 0.313158 4.6694444 0.292105 4.6722222 0.276316 4.6750000 0.252632 4.6777778 0.223684 4.6805556 0.184211 4.6833333 0.121053 4.6861111 0.060526 4.6888889 0.010000 4.6916667 0.010000 4.6944444 0.010000 4.6972222 0.010000 4.7000000 0.010000 4.7027778 0.010000 4.7055556 0.010000 4.7083333 0.010000 4.7111111 0.010000 4.7138889 0.010000 4.7166667 0.010000 4.7194444 0.010000 4.7222222 0.010000 4.7250000 0.010000 4.7277778 0.010000 4.7305556 0.010000 4.7333333 0.010000 4.7361111 0.010000 4.7388889 0.010000 4.7416667 0.010000 4.7444444 0.010000 4.7472222 0.010000 4.7500000 0.010000 4.7527778 0.010000 4.7555556 0.010000 4.7583333 0.010000 4.7611111 0.010000 4.7638889 0.010000 4.7666667 0.010000 4.7694444 0.010000 4.7722222 0.010000 4.7750000 0.010000 4.7777778 0.010000 4.7805556 0.010000 4.7833333 0.010000 4.7861111 0.010000 4.7888889 0.010000 4.7916667 0.010000 4.7944444 0.010000 4.7972222 0.010000 4.8000000 0.010000 4.8027778 0.010000 4.8055556 0.010000 4.8083333 0.010000 4.8111111 0.010000 4.8138889 0.010000 4.8166667 0.010000 4.8194444 0.010000 4.8222222 0.010000 4.8250000 0.010000 4.8277778 0.010000 4.8305556 0.010000 4.8333333 0.010000 4.8361111 0.010000 4.8388889 0.010000 4.8416667 0.010000 4.8444444 0.010000 4.8472222 0.010000 4.8500000 0.010000 4.8527778 0.010000 4.8555556 0.010000 4.8583333 0.010000 4.8611111 0.010000 4.8638889 0.010000 4.8666667 0.010000 4.8694444 0.010000 4.8722222 0.010000 4.8750000 0.010000 4.8777778 0.010000 4.8805556 0.010000 4.8833333 0.010000 4.8861111 0.010000 4.8888889 0.010000 4.8916667 0.010000 4.8944444 0.010000 4.8972222 0.010000 4.9000000 0.010000 4.9027778 0.010000 4.9055556 0.010000 4.9083333 0.010000 4.9111111 0.010000 4.9138889 0.010000 4.9166667 0.010000 4.9194444 0.010000 4.9222222 0.010000 4.9250000 0.010000 4.9277778 0.010000 4.9305556 0.010000 4.9333333 0.010000 4.9361111 0.010000 4.9388889 0.010000 4.9416667 0.010000 4.9444444 0.010000 4.9472222 0.010000 4.9500000 0.010000 4.9527778 0.010000 4.9555556 0.010000 4.9583333 0.010000 4.9611111 0.010000 4.9638889 0.010000 4.9666667 0.010000 4.9694444 0.010000 4.9722222 0.010000 4.9750000 0.010000 4.9777778 0.010000 4.9805556 0.010000 4.9833333 0.010000 4.9861111 0.010000 4.9888889 0.010000 4.9916667 0.010000 4.9944444 0.010000 4.9972222 0.010000 5.0000000 0.010000 5.0027778 0.010000 5.0055556 0.013158 5.8972222 0.160526 5.9000000 0.160526 5.9027778 0.163158 5.9055556 0.163158 5.9083333 0.168421 5.9111111 0.173684 5.9138889 0.165789 5.9166667 0.147368 5.9194444 0.150000 5.9222222 0.157895 5.9250000 0.165789 5.9277778 0.163158 5.9305556 0.160526 5.9333333 0.157895 5.9361111 0.157895 5.9388889 0.160526 5.9416667 0.168421 5.9444444 0.163158 5.9472222 0.160526 5.9500000 0.163158 5.9527778 0.155263 5.9555556 0.165789 5.9583333 0.173684 5.9611111 0.173684 5.9638889 0.165789 5.9666667 0.163158 5.9694444 0.152632 5.9722222 0.155263 5.9750000 0.157895 5.9777778 0.163158 5.9805556 0.168421 5.9833333 0.152632 5.9861111 0.152632 5.9888889 0.157895 5.9916667 0.168421 5.9944444 0.165789 5.9972222 0.152632 6.0000000 0.147368 6.0027778 0.152632 6.0055556 0.163158 6.0083333 0.168421 6.0111111 0.171053 6.0138889 0.165789 6.0166667 0.152632 6.0194444 0.160526 6.0222222 0.168421 6.0250000 0.168421 6.0277778 0.160526 6.0305556 0.157895 6.0333333 0.155263 6.0361111 0.155263 6.0388889 0.160526 6.0416667 0.165789 6.0444444 0.165789 6.0472222 0.163158 6.0500000 0.157895 6.0527778 0.144737 6.0555556 0.165789 6.0583333 0.168421 6.0611111 0.171053 6.0638889 0.168421 6.0666667 0.165789 6.0694444 0.171053 6.0722222 0.181579 6.0750000 0.184211 6.0777778 0.186842 6.0805556 0.181579 6.0833333 0.178947 6.0861111 0.176316 6.0888889 0.181579 6.0916667 0.194737 6.0944444 0.194737 6.0972222 0.181579 6.1000000 0.163158 6.1027778 0.147368 6.1055556 0.144737 6.1083333 0.155263 6.1111111 0.165789 6.1138889 0.160526 6.1166667 0.178947 6.1194444 0.221053 6.1222222 0.289474 6.1250000 0.355263 6.1277778 0.407895 6.1305556 0.428947 6.1333333 0.434211 6.1361111 0.447368 6.1388889 0.492105 6.1416667 0.560526 6.1444444 0.626316 6.1472222 0.644737 6.1500000 0.631579 6.1527778 0.597368 6.1555556 0.571053 6.1583333 0.547368 6.1611111 0.502632 6.1638889 0.423684 6.1666667 0.326316 6.1694444 0.223684 6.1722222 0.157895 6.1750000 0.134211 6.1777778 0.123684 6.1805556 0.110526 6.1833333 0.089474 6.1861111 0.073684 6.1888889 0.057895 6.1916667 0.050000 6.1944444 0.050000 6.1972222 0.055263 6.2000000 0.071053 6.2027778 0.086842 6.2055556 0.113158 6.2083333 0.147368 6.2111111 0.168421 6.2138889 0.178947 6.2166667 0.168421 6.2194444 0.152632 6.2222222 0.144737 6.2250000 0.131579 6.2277778 0.126316 6.2305556 0.121053 6.2333333 0.115789 6.2361111 0.121053 6.2388889 0.126316 6.2416667 0.131579 6.2444444 0.131579 6.2472222 0.121053 6.2500000 0.113158 6.2527778 0.113158 6.2555556 0.118421 6.2583333 0.121053 6.2611111 0.126316 6.2638889 0.118421 6.2666667 0.110526 6.2694444 0.110526 6.2722222 0.113158 6.2750000 0.126316 6.2777778 0.123684 6.2805556 0.115789 6.2833333 0.121053 6.2861111 0.121053 6.2888889 0.131579 6.2916667 0.136842 6.2944444 0.134211 6.2972222 0.131579 6.3000000 0.126316 6.3027778 0.118421 6.3055556 0.118421 6.3083333 0.126316 6.3111111 0.134211 6.3138889 0.128947 6.3166667 0.121053 6.3194444 0.123684 6.3222222 0.131579 6.3250000 0.142105 6.3277778 0.136842 6.3305556 0.131579 6.3333333 0.134211 6.3361111 0.136842 6.3388889 0.144737 6.3416667 0.147368 6.3444444 0.155263 6.3472222 0.155263 6.3500000 0.152632 6.3527778 0.155263 6.3555556 0.157895 6.3583333 0.165789 6.3611111 0.165789 6.3638889 0.160526 6.3666667 0.152632 6.3694444 0.157895 6.3722222 0.165789 6.3750000 0.173684 6.3777778 0.173684 6.3805556 0.168421 6.3833333 0.168421 6.3861111 0.165789 6.3888889 0.178947 6.3916667 0.189474 6.3944444 0.189474 6.3972222 0.181579 6.4000000 0.181579 6.4027778 0.178947 6.4055556 0.186842 6.4083333 0.202632 6.4111111 0.205263 6.4138889 0.194737 6.4166667 0.200000 6.4194444 0.197368 6.4222222 0.213158 6.4250000 0.218421 6.4277778 0.213158 6.4305556 0.213158 6.4333333 0.205263 6.4361111 0.205263 6.4388889 0.221053 6.4416667 0.231579 6.4444444 0.228947 6.5805556 0.297368 6.5833333 0.292105 6.5861111 0.289474 6.5888889 0.292105 6.5916667 0.297368 6.5944444 0.289474 6.5972222 0.281579 6.6000000 0.276316 6.6027778 0.276316 6.6055556 0.278947 6.6083333 0.281579 6.6111111 0.286842 6.6138889 0.281579 6.6166667 0.276316 6.6194444 0.278947 6.6222222 0.281579 6.6250000 0.281579 6.6277778 0.289474 6.6305556 0.281579 6.6333333 0.281579 6.6361111 0.278947 6.6388889 0.281579 6.6416667 0.297368 6.6444444 0.297368 6.6472222 0.286842 6.6500000 0.268421 6.6527778 0.278947 6.6555556 0.286842 6.6583333 0.294737 6.6611111 0.297368 6.6638889 0.289474 6.6666667 0.281579 6.6694444 0.289474 6.6722222 0.294737 6.6750000 0.305263 6.6777778 0.305263 6.6805556 0.302632 6.6833333 0.297368 6.6861111 0.302632 6.6888889 0.305263 6.6916667 0.318421 6.6944444 0.318421 6.6972222 0.318421 6.7000000 0.313158 6.7027778 0.313158 6.7055556 0.326316 6.7083333 0.331579 6.7111111 0.334211 6.7138889 0.326316 6.7166667 0.328947 6.7194444 0.331579 6.7222222 0.339474 6.7250000 0.350000 6.7277778 0.352632 6.7305556 0.352632 6.7333333 0.347368 6.7361111 0.350000 6.7388889 0.365789 6.7416667 0.368421 6.7444444 0.378947 6.7472222 0.363158 6.7500000 0.357895 6.7527778 0.355263 6.7555556 0.350000 6.7583333 0.347368 6.7611111 0.342105 6.7638889 0.328947 6.7666667 0.326316 6.7694444 0.321053 6.7722222 0.331579 6.7750000 0.334211 6.7777778 0.328947 6.7805556 0.318421 6.7833333 0.294737 6.7861111 0.276316 6.7888889 0.260526 6.7916667 0.252632 6.7944444 0.228947 6.7972222 0.207895 6.8000000 0.189474 6.8027778 0.171053 6.8055556 0.139474 6.8083333 0.086842 6.8111111 0.021053 6.8138889 0.010000 6.8166667 0.010000 6.8194444 0.010000 6.8222222 0.010000 6.8250000 0.010000 6.8277778 0.010000 6.8305556 0.010000 6.8333333 0.010000 6.8361111 0.010000 6.8388889 0.010000 6.8416667 0.010000 6.8444444 0.010000 6.8472222 0.010000 6.8500000 0.010000 6.8527778 0.010000 6.8555556 0.010000 6.8583333 0.010000 6.8611111 0.010000 6.8638889 0.010000 6.8666667 0.010000 6.8694444 0.010000 6.8722222 0.010000 6.8750000 0.010000 6.8777778 0.010000 6.8805556 0.010000 6.8833333 0.010000 6.8861111 0.010000 6.8888889 0.010000 6.8916667 0.010000 6.8944444 0.010000 6.8972222 0.010000 6.9000000 0.010000 6.9027778 0.010000 6.9055556 0.010000 6.9083333 0.010000 6.9111111 0.010000 6.9138889 0.010000 6.9166667 0.010000 6.9194444 0.010000 6.9222222 0.010000 6.9250000 0.010000 6.9277778 0.010000 6.9305556 0.010000 6.9333333 0.010000 6.9361111 0.010000 6.9388889 0.010000 6.9416667 0.010000 6.9444444 0.010000 6.9472222 0.010000 6.9500000 0.010000 6.9527778 0.010000 6.9555556 0.010000 6.9583333 0.010000 6.9611111 0.010000 6.9638889 0.010000 6.9666667 0.010000 6.9694444 0.010000 6.9722222 0.010000 6.9750000 0.010000 6.9777778 0.010000 6.9805556 0.010000 6.9833333 0.010000 6.9861111 0.010000 6.9888889 0.010000 6.9916667 0.010000 6.9944444 0.010000 6.9972222 0.010000 7.0000000 0.010000 7.0027778 0.010000 7.0055556 0.010000 7.0083333 0.010000 7.0111111 0.010000 7.0138889 0.010000 7.0166667 0.010000 7.0194444 0.010000 7.0222222 0.010000 7.0250000 0.010000 7.0277778 0.010000 7.0305556 0.010000 7.0333333 0.010000 7.0361111 0.010000 7.0388889 0.010000 7.0416667 0.010000 7.0444444 0.010000 7.0472222 0.010000 7.0500000 0.010000 7.0527778 0.010000 7.0555556 0.010000 7.0583333 0.010000 7.0611111 0.010000 7.0638889 0.010000 7.0666667 0.010000 7.0694444 0.010000 7.0722222 0.010000 7.0750000 0.010000 7.0777778 0.010000 7.0805556 0.010000 7.0833333 0.010000 7.0861111 0.010000 7.0888889 0.010000 7.0916667 0.010526 7.0944444 0.010526 7.0972222 0.013158 7.1000000 0.010000 7.1027778 0.010000 7.1055556 0.021053 7.1083333 0.031579 7.1111111 0.034211 7.1138889 0.036842 7.1166667 0.039474 7.1194444 0.044737 7.1222222 0.055263 7.1250000 0.065789 7.1277778 0.071053 7.9694444 0.192105 7.9722222 0.192105 7.9750000 0.197368 7.9777778 0.192105 7.9805556 0.186842 7.9833333 0.184211 7.9861111 0.178947 7.9888889 0.186842 7.9916667 0.202632 7.9944444 0.194737 7.9972222 0.189474 8.0000000 0.184211 8.0027778 0.186842 8.0055556 0.197368 8.0083333 0.197368 8.0111111 0.197368 8.0138889 0.192105 8.0166667 0.189474 8.0194444 0.189474 8.0222222 0.200000 8.0250000 0.202632 8.0277778 0.194737 8.0305556 0.184211 8.0333333 0.181579 8.0361111 0.184211 8.0388889 0.200000 8.0416667 0.197368 8.0444444 0.194737 8.0472222 0.186842 8.0500000 0.186842 8.0527778 0.192105 8.0555556 0.197368 8.0583333 0.194737 8.0611111 0.189474 8.0638889 0.192105 8.0666667 0.192105 8.0694444 0.194737 8.0722222 0.205263 8.0750000 0.207895 8.0777778 0.200000 8.0805556 0.192105 8.0833333 0.189474 8.0861111 0.194737 8.0888889 0.194737 8.0916667 0.197368 8.0944444 0.194737 8.0972222 0.192105 8.1000000 0.184211 8.1027778 0.189474 8.1055556 0.197368 8.1083333 0.200000 8.1111111 0.197368 8.1138889 0.192105 8.1166667 0.181579 8.1194444 0.192105 8.1222222 0.197368 8.1250000 0.207895 8.1277778 0.202632 8.1305556 0.197368 8.1333333 0.192105 8.1361111 0.189474 8.1388889 0.197368 8.1416667 0.200000 8.1444444 0.197368 8.1472222 0.197368 8.1500000 0.189474 8.1527778 0.186842 8.1555556 0.192105 8.1583333 0.202632 8.1611111 0.197368 8.1638889 0.189474 8.1666667 0.186842 8.1694444 0.194737 8.1722222 0.200000 8.1750000 0.200000 8.1777778 0.184211 8.1805556 0.171053 8.1833333 0.165789 8.1861111 0.171053 8.1888889 0.176316 8.1916667 0.194737 8.1944444 0.223684 8.1972222 0.276316 8.2000000 0.339474 8.2027778 0.400000 8.2055556 0.442105 8.2083333 0.455263 8.2111111 0.473684 8.2138889 0.523684 8.2166667 0.597368 8.2194444 0.652632 8.2222222 0.663158 8.2250000 0.644737 8.2277778 0.597368 8.2305556 0.557895 8.2333333 0.492105 8.2361111 0.407895 8.2388889 0.297368 8.2416667 0.207895 8.2444444 0.168421 8.2472222 0.144737 8.2500000 0.131579 8.2527778 0.107895 8.2555556 0.086842 8.2583333 0.097368 8.2611111 0.128947 8.2638889 0.144737 8.2666667 0.168421 8.2694444 0.200000 8.2722222 0.221053 8.2750000 0.226316 8.2777778 0.210526 8.2805556 0.181579 8.2833333 0.157895 8.2861111 0.147368 8.2888889 0.147368 8.2916667 0.155263 8.2944444 0.160526 8.2972222 0.150000 8.3000000 0.150000 8.3027778 0.147368 8.3055556 0.157895 8.3083333 0.163158 8.3111111 0.157895 8.3138889 0.157895 8.3166667 0.152632 8.3194444 0.160526 8.3222222 0.160526 8.3250000 0.165789 8.3277778 0.163158 8.3305556 0.155263 8.3333333 0.157895 8.3361111 0.157895 8.3388889 0.152632 8.3416667 0.165789 8.3444444 0.160526 8.3472222 0.160526 8.3500000 0.155263 8.3527778 0.155263 8.3555556 0.160526 8.3583333 0.165789 8.3611111 0.165789 8.3638889 0.160526 8.3666667 0.155263 8.3694444 0.163158 8.3722222 0.171053 8.3750000 0.173684 8.3777778 0.173684 8.3805556 0.171053 8.3833333 0.165789 8.3861111 0.163158 8.3888889 0.171053 8.3916667 0.173684 8.3944444 0.173684 8.3972222 0.173684 8.4000000 0.171053 8.4027778 0.171053 8.4055556 0.186842 8.4083333 0.186842 8.4111111 0.186842 8.4138889 0.181579 8.4166667 0.178947 8.4194444 0.186842 8.4222222 0.197368 8.4250000 0.205263 8.4277778 0.205263 8.4305556 0.202632 8.4333333 0.202632 8.4361111 0.207895 8.4388889 0.205263 8.4416667 0.218421 8.4444444 0.213158 8.4472222 0.202632 8.4500000 0.202632 8.4527778 0.207895 8.4555556 0.218421 8.4583333 0.223684 8.4611111 0.226316 8.4638889 0.221053 8.4666667 0.221053 8.4694444 0.223684 8.4722222 0.236842 8.4750000 0.236842 8.4777778 0.239474 8.4805556 0.247368 8.4833333 0.236842 8.4861111 0.239474 8.4888889 0.252632 8.4916667 0.260526 8.4944444 0.260526 8.4972222 0.247368 8.5000000 0.242105 8.5027778 0.252632 8.5055556 0.257895 8.5083333 0.265789 8.5111111 0.263158 8.5138889 0.257895 8.5166667 0.255263 8.6222222 0.305263 8.6250000 0.305263 8.6277778 0.307895 8.6305556 0.297368 8.6333333 0.292105 8.6361111 0.294737 8.6388889 0.300000 8.6416667 0.302632 8.6444444 0.307895 8.6472222 0.302632 8.6500000 0.297368 8.6527778 0.294737 8.6555556 0.294737 8.6583333 0.302632 8.6611111 0.294737 8.6638889 0.289474 8.6666667 0.286842 8.6694444 0.286842 8.6722222 0.297368 8.6750000 0.297368 8.6777778 0.292105 8.6805556 0.284211 8.6833333 0.289474 8.6861111 0.292105 8.6888889 0.300000 8.6916667 0.305263 8.6944444 0.305263 8.6972222 0.302632 8.7000000 0.302632 8.7027778 0.307895 8.7055556 0.313158 8.7083333 0.315789 8.7111111 0.310526 8.7138889 0.307895 8.7166667 0.307895 8.7194444 0.305263 8.7222222 0.313158 8.7250000 0.321053 8.7277778 0.323684 8.7305556 0.321053 8.7333333 0.313158 8.7361111 0.318421 8.7388889 0.331579 8.7416667 0.336842 8.7444444 0.336842 8.7472222 0.339474 8.7500000 0.336842 8.7527778 0.339474 8.7555556 0.357895 8.7583333 0.357895 8.7611111 0.355263 8.7638889 0.350000 8.7666667 0.352632 8.7694444 0.365789 8.7722222 0.376316 8.7750000 0.376316 8.7777778 0.373684 8.7805556 0.378947 8.7833333 0.373684 8.7861111 0.376316 8.7888889 0.365789 8.7916667 0.360526 8.7944444 0.347368 8.7972222 0.334211 8.8000000 0.331579 8.8027778 0.334211 8.8055556 0.323684 8.8083333 0.331579 8.8111111 0.321053 8.8138889 0.310526 8.8166667 0.305263 8.8194444 0.302632 8.8222222 0.300000 8.8250000 0.284211 8.8277778 0.268421 8.8305556 0.257895 8.8333333 0.250000 8.8361111 0.239474 8.8388889 0.231579 8.8416667 0.194737 8.8444444 0.131579 8.8472222 0.081579 8.8500000 0.047368 8.8527778 0.010526 8.8555556 0.010000 8.8583333 0.010000 8.8611111 0.010000 8.8638889 0.010000 8.8666667 0.010000 8.8694444 0.010000 8.8722222 0.010000 8.8750000 0.010000 8.8777778 0.010000 8.8805556 0.010000 8.8833333 0.010000 8.8861111 0.010000 8.8888889 0.010000 8.8916667 0.010000 8.8944444 0.010000 8.8972222 0.010000 8.9000000 0.010000 8.9027778 0.010000 8.9055556 0.010000 8.9083333 0.010000 8.9111111 0.010000 8.9138889 0.010000 8.9166667 0.010000 8.9194444 0.010000 8.9222222 0.010000 8.9250000 0.010000 8.9277778 0.010000 8.9305556 0.010000 8.9333333 0.010000 8.9361111 0.010000 8.9388889 0.010000 8.9416667 0.010000 8.9444444 0.010000 8.9472222 0.010000 8.9500000 0.010000 8.9527778 0.010000 8.9555556 0.010000 8.9583333 0.010000 8.9611111 0.010000 8.9638889 0.010000 8.9666667 0.010000 8.9694444 0.010000 8.9722222 0.010000 8.9750000 0.010000 8.9777778 0.010000 8.9805556 0.010000 8.9833333 0.010000 8.9861111 0.010000 8.9888889 0.010000 8.9916667 0.010000 8.9944444 0.010000 8.9972222 0.010000 9.0000000 0.010000 9.0027778 0.010000 9.0055556 0.010000 9.0083333 0.010000 9.0111111 0.010000 9.0138889 0.010000 9.0166667 0.010000 9.0194444 0.010000 9.0222222 0.010000 9.0250000 0.010000 9.0277778 0.010000 9.0305556 0.010000 9.0333333 0.010000 9.0361111 0.010000 9.0388889 0.010000 9.0416667 0.010000 9.0444444 0.010000 9.0472222 0.010000 9.0500000 0.010000 9.0527778 0.010000 9.0555556 0.010000 9.0583333 0.010000 9.0611111 0.010000 9.0638889 0.010000 9.0666667 0.010000 9.0694444 0.010000 9.0722222 0.010000 9.0750000 0.010000 9.0777778 0.010000 9.0805556 0.010000 9.0833333 0.010000 9.0861111 0.010000 9.0888889 0.010000 9.0916667 0.010000 9.0944444 0.010000 9.0972222 0.010000 9.1000000 0.010000 9.1027778 0.010000 9.1055556 0.010000 9.1083333 0.010000 9.1111111 0.010000 9.1138889 0.010000 9.1166667 0.010000 9.1194444 0.010000 9.1222222 0.010000 9.1250000 0.010000 9.1277778 0.010000 9.1305556 0.010000 9.1333333 0.010000 9.1361111 0.010000 9.1388889 0.010000 9.1416667 0.021053 9.1444444 0.021053 9.1472222 0.026316 9.1500000 0.021053 9.1527778 0.031579 9.1555556 0.039474 9.1583333 0.050000 9.1611111 0.052632 9.1638889 0.055263 9.1666667 0.052632 9.1694444 0.063158 10.1361111 0.207895 10.1388889 0.213158 10.1416667 0.215789 10.1444444 0.210526 10.1472222 0.205263 10.1500000 0.205263 10.1527778 0.207895 10.1555556 0.213158 10.1583333 0.218421 10.1611111 0.207895 10.1638889 0.202632 10.1666667 0.205263 10.1694444 0.210526 10.1722222 0.210526 10.1750000 0.215789 10.1777778 0.215789 10.1805556 0.218421 10.1833333 0.205263 10.1861111 0.213158 10.1888889 0.218421 10.1916667 0.215789 10.1944444 0.207895 10.1972222 0.205263 10.2000000 0.202632 10.2027778 0.210526 10.2055556 0.210526 10.2083333 0.213158 10.2111111 0.207895 10.2138889 0.197368 10.2166667 0.200000 10.2194444 0.207895 10.2222222 0.213158 10.2250000 0.210526 10.2277778 0.207895 10.2305556 0.210526 10.2333333 0.210526 10.2361111 0.215789 10.2388889 0.213158 10.2416667 0.218421 10.2444444 0.215789 10.2472222 0.210526 10.2500000 0.205263 10.2527778 0.205263 10.2555556 0.218421 10.2583333 0.213158 10.2611111 0.205263 10.2638889 0.207895 10.2666667 0.205263 10.2694444 0.207895 10.2722222 0.215789 10.2750000 0.215789 10.2777778 0.218421 10.2805556 0.207895 10.2833333 0.202632 10.2861111 0.210526 10.2888889 0.218421 10.2916667 0.221053 10.2944444 0.221053 10.2972222 0.213158 10.3000000 0.213158 10.3027778 0.218421 10.3055556 0.231579 10.3083333 0.226316 10.3111111 0.221053 10.3138889 0.210526 10.3166667 0.202632 10.3194444 0.213158 10.3222222 0.223684 10.3250000 0.221053 10.3277778 0.221053 10.3305556 0.210526 10.3333333 0.213158 10.3361111 0.210526 10.3388889 0.200000 10.3416667 0.197368 10.3444444 0.192105 10.3472222 0.189474 10.3500000 0.197368 10.3527778 0.210526 10.3555556 0.244737 10.3583333 0.286842 10.3611111 0.334211 10.3638889 0.384211 10.3666667 0.423684 10.3694444 0.457895 10.3722222 0.473684 10.3750000 0.484211 10.3777778 0.534211 10.3805556 0.602632 10.3833333 0.655263 10.3861111 0.681579 10.3888889 0.673684 10.3916667 0.642105 10.3944444 0.607895 10.3972222 0.571053 10.4000000 0.539474 10.4027778 0.494737 10.4055556 0.431579 10.4083333 0.342105 10.4111111 0.260526 10.4138889 0.218421 10.4166667 0.194737 10.4194444 0.178947 10.4222222 0.171053 10.4250000 0.160526 10.4277778 0.144737 10.4305556 0.118421 10.4333333 0.105263 10.4361111 0.118421 10.4388889 0.142105 10.4416667 0.165789 10.4444444 0.178947 10.4472222 0.192105 10.4500000 0.210526 10.4527778 0.234211 10.4555556 0.250000 10.4583333 0.247368 10.4611111 0.223684 10.4638889 0.210526 10.4666667 0.192105 10.4694444 0.192105 10.4722222 0.186842 10.4750000 0.184211 10.4777778 0.181579 10.4805556 0.181579 10.4833333 0.160526 10.4861111 0.171053 10.4888889 0.181579 10.4916667 0.176316 10.4944444 0.178947 10.4972222 0.165789 10.5000000 0.171053 10.5027778 0.173684 10.5055556 0.176316 10.5083333 0.178947 10.5111111 0.176316 10.5138889 0.171053 10.5166667 0.168421 10.5194444 0.173684 10.5222222 0.176316 10.5250000 0.178947 10.5277778 0.181579 10.5305556 0.173684 10.5333333 0.178947 10.5361111 0.181579 10.5388889 0.184211 10.5416667 0.184211 10.5444444 0.184211 10.5472222 0.171053 10.5500000 0.168421 10.5527778 0.178947 10.5555556 0.178947 10.5583333 0.184211 10.5611111 0.181579 10.5638889 0.173684 10.5666667 0.171053 10.5694444 0.184211 10.5722222 0.189474 10.5750000 0.194737 10.5777778 0.194737 10.5805556 0.178947 10.5833333 0.181579 10.5861111 0.194737 10.5888889 0.200000 10.5916667 0.202632 10.5944444 0.202632 10.5972222 0.200000 10.6000000 0.200000 10.6027778 0.197368 10.6055556 0.207895 10.6083333 0.205263 10.6111111 0.207895 10.6138889 0.205263 10.6166667 0.200000 10.6194444 0.210526 10.6222222 0.218421 10.6250000 0.213158 10.6277778 0.215789 10.6305556 0.210526 10.6333333 0.215789 10.6361111 0.218421 10.6388889 0.236842 10.6416667 0.231579 10.6444444 0.234211 10.6472222 0.228947 10.6500000 0.236842 10.6527778 0.242105 10.6555556 0.242105 10.6583333 0.242105 10.6611111 0.242105 10.6638889 0.242105 10.6666667 0.244737 10.6694444 0.247368 10.6722222 0.255263 10.6750000 0.257895 10.6777778 0.260526 10.6805556 0.252632 10.6833333 0.250000 10.8361111 0.313158 10.8388889 0.315789 10.8416667 0.318421 10.8444444 0.313158 10.8472222 0.302632 10.8500000 0.294737 10.8527778 0.300000 10.8555556 0.300000 10.8583333 0.310526 10.8611111 0.302632 10.8638889 0.302632 10.8666667 0.305263 10.8694444 0.307895 10.8722222 0.318421 10.8750000 0.321053 10.8777778 0.315789 10.8805556 0.307895 10.8833333 0.297368 10.8861111 0.302632 10.8888889 0.313158 10.8916667 0.313158 10.8944444 0.305263 10.8972222 0.305263 10.9000000 0.305263 10.9027778 0.307895 10.9055556 0.313158 10.9083333 0.313158 10.9111111 0.313158 10.9138889 0.300000 10.9166667 0.305263 10.9194444 0.315789 10.9222222 0.328947 10.9250000 0.326316 10.9277778 0.323684 10.9305556 0.326316 10.9333333 0.321053 10.9361111 0.336842 10.9388889 0.339474 10.9416667 0.347368 10.9444444 0.344737 10.9472222 0.347368 10.9500000 0.344737 10.9527778 0.350000 10.9555556 0.352632 10.9583333 0.342105 10.9611111 0.347368 10.9638889 0.350000 10.9666667 0.355263 10.9694444 0.355263 10.9722222 0.363158 10.9750000 0.363158 10.9777778 0.365789 10.9805556 0.363158 10.9833333 0.363158 10.9861111 0.376316 10.9888889 0.381579 10.9916667 0.386842 10.9944444 0.389474 10.9972222 0.384211 11.0000000 0.381579 11.0027778 0.378947 11.0055556 0.376316 11.0083333 0.368421 11.0111111 0.355263 11.0138889 0.339474 11.0166667 0.336842 11.0194444 0.331579 11.0222222 0.328947 11.0250000 0.323684 11.0277778 0.318421 11.0305556 0.305263 11.0333333 0.302632 11.0361111 0.292105 11.0388889 0.281579 11.0416667 0.276316 11.0444444 0.271053 11.0472222 0.260526 11.0500000 0.263158 11.0527778 0.260526 11.0555556 0.242105 11.0583333 0.197368 11.0611111 0.139474 11.0638889 0.100000 11.0666667 0.052632 11.0694444 0.015789 11.0722222 0.010000 11.0750000 0.010000 11.0777778 0.010000 11.0805556 0.010000 11.0833333 0.010000 11.0861111 0.010000 11.0888889 0.010000 11.0916667 0.010000 11.0944444 0.010000 11.0972222 0.010000 11.1000000 0.010000 11.1027778 0.010000 11.1055556 0.010000 11.1083333 0.010000 11.1111111 0.010000 11.1138889 0.010000 11.1166667 0.010000 11.1194444 0.010000 11.1222222 0.010000 11.1250000 0.010000 11.1277778 0.010000 11.1305556 0.010000 11.1333333 0.010000 11.1361111 0.010000 11.1388889 0.010000 11.1416667 0.010000 11.1444444 0.010000 11.1472222 0.010000 11.1500000 0.010000 11.1527778 0.010000 11.1555556 0.010000 11.1583333 0.010000 11.1611111 0.010000 11.1638889 0.010000 11.1666667 0.010000 11.1694444 0.010000 11.1722222 0.010000 11.1750000 0.010000 11.1777778 0.010000 11.1805556 0.010000 11.1833333 0.010000 11.1861111 0.010000 11.1888889 0.010000 11.1916667 0.010000 11.1944444 0.010000 11.1972222 0.010000 11.2000000 0.010000 11.2027778 0.010000 11.2055556 0.010000 11.2083333 0.010000 11.2111111 0.010000 11.2138889 0.010000 11.2166667 0.010000 11.2194444 0.010000 11.2222222 0.010000 11.2250000 0.010000 11.2277778 0.010000 11.2305556 0.010000 11.2333333 0.010000 11.2361111 0.010000 11.2388889 0.010000 11.2416667 0.010000 11.2444444 0.010000 11.2472222 0.010000 11.2500000 0.010000 11.2527778 0.010000 11.2555556 0.010000 11.2583333 0.010000 11.2611111 0.010000 11.2638889 0.010000 11.2666667 0.010000 11.2694444 0.010000 11.2722222 0.010000 11.2750000 0.010000 11.2777778 0.010000 11.2805556 0.010000 11.2833333 0.010000 11.2861111 0.010000 11.2888889 0.010000 11.2916667 0.010000 11.2944444 0.010000 11.2972222 0.010000 11.3000000 0.010000 11.3027778 0.010000 11.3055556 0.010000 11.3083333 0.010000 11.3111111 0.010000 11.3138889 0.010000 11.3166667 0.010000 11.3194444 0.010000 11.3222222 0.010000 11.3250000 0.010000 11.3277778 0.010000 11.3305556 0.010000 11.3333333 0.010000 11.3361111 0.010000 11.3388889 0.010000 11.3416667 0.010000 11.3444444 0.010000 11.3472222 0.010000 11.3500000 0.010000 11.3527778 0.010526 11.3555556 0.021053 11.3583333 0.023684 11.3611111 0.026316 11.3638889 0.028947 11.3666667 0.028947 11.3694444 0.039474 11.3722222 0.057895 11.3750000 0.057895 11.3777778 0.065789 11.3805556 0.065789 11.3833333 0.065789 12.2805556 0.213158 12.2833333 0.213158 12.2861111 0.218421 12.2888889 0.228947 12.2916667 0.223684 12.2944444 0.215789 12.2972222 0.213158 12.3000000 0.210526 12.3027778 0.215789 12.3055556 0.215789 12.3083333 0.218421 12.3111111 0.218421 12.3138889 0.202632 12.3166667 0.207895 12.3194444 0.213158 12.3222222 0.221053 12.3250000 0.223684 12.3277778 0.215789 12.3305556 0.215789 12.3333333 0.213158 12.3361111 0.215789 12.3388889 0.226316 12.3416667 0.226316 12.3444444 0.223684 12.3472222 0.223684 12.3500000 0.221053 12.3527778 0.223684 12.3555556 0.228947 12.3583333 0.221053 12.3611111 0.221053 12.3638889 0.210526 12.3666667 0.210526 12.3694444 0.213158 12.3722222 0.210526 12.3750000 0.213158 12.3777778 0.210526 12.3805556 0.210526 12.3833333 0.210526 12.3861111 0.213158 12.3888889 0.221053 12.3916667 0.221053 12.3944444 0.218421 12.3972222 0.205263 12.4000000 0.210526 12.4027778 0.218421 12.4055556 0.223684 12.4083333 0.223684 12.4111111 0.215789 12.4138889 0.210526 12.4166667 0.207895 12.4194444 0.205263 12.4222222 0.215789 12.4250000 0.218421 12.4277778 0.207895 12.4305556 0.202632 12.4333333 0.202632 12.4361111 0.215789 12.4388889 0.223684 12.4416667 0.218421 12.4444444 0.215789 12.4472222 0.215789 12.4500000 0.210526 12.4527778 0.215789 12.4555556 0.221053 12.4583333 0.226316 12.4611111 0.223684 12.4638889 0.221053 12.4666667 0.207895 12.4694444 0.213158 12.4722222 0.228947 12.4750000 0.221053 12.4777778 0.213158 12.4805556 0.207895 12.4833333 0.192105 12.4861111 0.189474 12.4888889 0.200000 12.4916667 0.205263 12.4944444 0.202632 12.4972222 0.202632 12.5000000 0.223684 12.5027778 0.284211 12.5055556 0.344737 12.5083333 0.400000 12.5111111 0.434211 12.5138889 0.452632 12.5166667 0.465789 12.5194444 0.500000 12.5222222 0.563158 12.5250000 0.642105 12.5277778 0.673684 12.5305556 0.671053 12.5333333 0.647368 12.5361111 0.621053 12.5388889 0.597368 12.5416667 0.563158 12.5444444 0.505263 12.5472222 0.434211 12.5500000 0.342105 12.5527778 0.263158 12.5555556 0.218421 12.5583333 0.197368 12.5611111 0.176316 12.5638889 0.165789 12.5666667 0.150000 12.5694444 0.136842 12.5722222 0.126316 12.5750000 0.118421 12.5777778 0.126316 12.5805556 0.136842 12.5833333 0.147368 12.5861111 0.176316 12.5888889 0.202632 12.5916667 0.226316 12.5944444 0.239474 12.5972222 0.236842 12.6000000 0.226316 12.6027778 0.215789 12.6055556 0.200000 12.6083333 0.192105 12.6111111 0.181579 12.6138889 0.168421 12.6166667 0.165789 12.6194444 0.186842 12.6222222 0.192105 12.6250000 0.197368 12.6277778 0.186842 12.6305556 0.181579 12.6333333 0.173684 12.6361111 0.181579 12.6388889 0.189474 12.6416667 0.184211 12.6444444 0.173684 12.6472222 0.173684 12.6500000 0.176316 12.6527778 0.178947 12.6555556 0.184211 12.6583333 0.184211 12.6611111 0.178947 12.6638889 0.165789 12.6666667 0.165789 12.6694444 0.178947 12.6722222 0.181579 12.6750000 0.186842 12.6777778 0.184211 12.6805556 0.184211 12.6833333 0.173684 12.6861111 0.184211 12.6888889 0.189474 12.6916667 0.186842 12.6944444 0.186842 12.6972222 0.176316 12.7000000 0.173684 12.7027778 0.178947 12.7055556 0.186842 12.7083333 0.192105 12.7111111 0.192105 12.7138889 0.181579 12.7166667 0.176316 12.7194444 0.189474 12.7222222 0.200000 12.7250000 0.202632 12.7277778 0.197368 12.7305556 0.192105 12.7333333 0.192105 12.7361111 0.202632 12.7388889 0.210526 12.7416667 0.210526 12.7444444 0.202632 12.7472222 0.207895 12.7500000 0.205263 12.7527778 0.207895 12.7555556 0.215789 12.7583333 0.221053 12.7611111 0.218421 12.7638889 0.210526 12.7666667 0.210526 12.7694444 0.215789 12.7722222 0.228947 12.7750000 0.234211 12.7777778 0.221053 12.7805556 0.228947 12.7833333 0.226316 12.7861111 0.228947 12.7888889 0.242105 12.7916667 0.242105 12.7944444 0.244737 12.7972222 0.239474 12.8000000 0.239474 12.8027778 0.242105 12.8055556 0.252632 12.8083333 0.260526 12.8111111 0.250000 12.8138889 0.247368 12.8166667 0.244737 12.8194444 0.255263 12.8222222 0.263158 12.8250000 0.265789 12.8277778 0.260526 12.9444444 0.307895 12.9472222 0.300000 12.9500000 0.302632 12.9527778 0.313158 12.9555556 0.313158 12.9583333 0.315789 12.9611111 0.313158 12.9638889 0.307895 12.9666667 0.307895 12.9694444 0.307895 12.9722222 0.315789 12.9750000 0.310526 12.9777778 0.302632 12.9805556 0.294737 12.9833333 0.289474 12.9861111 0.300000 12.9888889 0.310526 12.9916667 0.302632 12.9944444 0.300000 12.9972222 0.300000 13.0000000 0.297368 13.0027778 0.307895 13.0055556 0.313158 13.0083333 0.310526 13.0111111 0.307895 13.0138889 0.305263 13.0166667 0.305263 13.0194444 0.310526 13.0222222 0.315789 13.0250000 0.318421 13.0277778 0.313158 13.0305556 0.302632 13.0333333 0.302632 13.0361111 0.315789 13.0388889 0.318421 13.0416667 0.321053 13.0444444 0.321053 13.0472222 0.323684 13.0500000 0.321053 13.0527778 0.334211 13.0555556 0.339474 13.0583333 0.339474 13.0611111 0.342105 13.0638889 0.336842 13.0666667 0.336842 13.0694444 0.347368 13.0722222 0.355263 13.0750000 0.352632 13.0777778 0.357895 13.0805556 0.350000 13.0833333 0.355263 13.0861111 0.365789 13.0888889 0.371053 13.0916667 0.368421 13.0944444 0.363158 13.0972222 0.365789 13.1000000 0.365789 13.1027778 0.376316 13.1055556 0.386842 13.1083333 0.384211 13.1111111 0.386842 13.1138889 0.378947 13.1166667 0.368421 13.1194444 0.368421 13.1222222 0.365789 13.1250000 0.357895 13.1277778 0.347368 13.1305556 0.326316 13.1333333 0.323684 13.1361111 0.318421 13.1388889 0.323684 13.1416667 0.315789 13.1444444 0.292105 13.1472222 0.278947 13.1500000 0.268421 13.1527778 0.281579 13.1555556 0.289474 13.1583333 0.281579 13.1611111 0.271053 13.1638889 0.244737 13.1666667 0.202632 13.1694444 0.160526 13.1722222 0.126316 13.1750000 0.084211 13.1777778 0.042105 13.1805556 0.010000 13.1833333 0.010000 13.1861111 0.010000 13.1888889 0.010000 13.1916667 0.010000 13.1944444 0.010000 13.1972222 0.010000 13.2000000 0.010000 13.2027778 0.010000 13.2055556 0.010000 13.2083333 0.010000 13.2111111 0.010000 13.2138889 0.010000 13.2166667 0.010000 13.2194444 0.010000 13.2222222 0.010000 13.2250000 0.010000 13.2277778 0.010000 13.2305556 0.010000 13.2333333 0.010000 13.2361111 0.010000 13.2388889 0.010000 13.2416667 0.010000 13.2444444 0.010000 13.2472222 0.010000 13.2500000 0.010000 13.2527778 0.010000 13.2555556 0.010000 13.2583333 0.010000 13.2611111 0.010000 13.2638889 0.010000 13.2666667 0.010000 13.2694444 0.010000 13.2722222 0.010000 13.2750000 0.010000 13.2777778 0.010000 13.2805556 0.010000 13.2833333 0.010000 13.2861111 0.010000 13.2888889 0.010000 13.2916667 0.010000 13.2944444 0.010000 13.2972222 0.010000 13.3000000 0.010000 13.3027778 0.010000 13.3055556 0.010000 13.3083333 0.010000 13.3111111 0.010000 13.3138889 0.010000 13.3166667 0.010000 13.3194444 0.010000 13.3222222 0.010000 13.3250000 0.010000 13.3277778 0.010000 13.3305556 0.010000 13.3333333 0.010000 13.3361111 0.010000 13.3388889 0.010000 13.3416667 0.010000 13.3444444 0.010000 13.3472222 0.010000 13.3500000 0.010000 13.3527778 0.010000 13.3555556 0.010000 13.3583333 0.010000 13.3611111 0.010000 13.3638889 0.010000 13.3666667 0.010000 13.3694444 0.010000 13.3722222 0.010000 13.3750000 0.010000 13.3777778 0.010000 13.3805556 0.010000 13.3833333 0.010000 13.3861111 0.010000 13.3888889 0.010000 13.3916667 0.010000 13.3944444 0.010000 13.3972222 0.010000 13.4000000 0.010000 13.4027778 0.010000 13.4055556 0.010000 13.4083333 0.010000 13.4111111 0.010000 13.4138889 0.010000 13.4166667 0.010000 13.4194444 0.010000 13.4222222 0.010000 13.4250000 0.010000 13.4277778 0.010000 13.4305556 0.010000 13.4333333 0.010000 13.4361111 0.010000 13.4388889 0.010000 13.4416667 0.010000 13.4444444 0.010000 13.4472222 0.010000 13.4500000 0.010000 13.4527778 0.015789 13.4555556 0.031579 13.4583333 0.031579 13.4611111 0.023684 13.4638889 0.026316 13.4666667 0.028947 13.4694444 0.039474 13.4722222 0.050000 13.4750000 0.050000 13.4777778 0.052632 13.4805556 0.052632 13.4833333 0.052632 13.4861111 0.065789 13.4888889 0.078947 13.4916667 0.086842 14.3666667 0.200000 14.3694444 0.207895 14.3722222 0.213158 14.3750000 0.221053 14.3777778 0.210526 14.3805556 0.207895 14.3833333 0.210526 14.3861111 0.221053 14.3888889 0.226316 14.3916667 0.226316 14.3944444 0.215789 14.3972222 0.215789 14.4000000 0.210526 14.4027778 0.221053 14.4055556 0.218421 14.4083333 0.205263 14.4111111 0.207895 14.4138889 0.205263 14.4166667 0.207895 14.4194444 0.218421 14.4222222 0.223684 14.4250000 0.210526 14.4277778 0.213158 14.4305556 0.210526 14.4333333 0.210526 14.4361111 0.213158 14.4388889 0.215789 14.4416667 0.218421 14.4444444 0.213158 14.4472222 0.210526 14.4500000 0.213158 14.4527778 0.218421 14.4555556 0.221053 14.4583333 0.221053 14.4611111 0.213158 14.4638889 0.207895 14.4666667 0.210526 14.4694444 0.215789 14.4722222 0.215789 14.4750000 0.215789 14.4777778 0.213158 14.4805556 0.205263 14.4833333 0.207895 14.4861111 0.218421 14.4888889 0.215789 14.4916667 0.218421 14.4944444 0.210526 14.4972222 0.210526 14.5000000 0.215789 14.5027778 0.223684 14.5055556 0.221053 14.5083333 0.223684 14.5111111 0.210526 14.5138889 0.210526 14.5166667 0.213158 14.5194444 0.218421 14.5222222 0.215789 14.5250000 0.213158 14.5277778 0.213158 14.5305556 0.207895 14.5333333 0.205263 14.5361111 0.215789 14.5388889 0.221053 14.5416667 0.226316 14.5444444 0.223684 14.5472222 0.221053 14.5500000 0.226316 14.5527778 0.228947 14.5555556 0.242105 14.5583333 0.231579 14.5611111 0.221053 14.5638889 0.213158 14.5666667 0.197368 14.5694444 0.192105 14.5722222 0.189474 14.5750000 0.192105 14.5777778 0.186842 14.5805556 0.186842 14.5833333 0.218421 14.5861111 0.263158 14.5888889 0.318421 14.5916667 0.376316 14.5944444 0.415789 14.5972222 0.436842 14.6000000 0.457895 14.6027778 0.478947 14.6055556 0.507895 14.6083333 0.560526 14.6111111 0.621053 14.6138889 0.668421 14.6166667 0.678947 14.6194444 0.665789 14.6222222 0.647368 14.6250000 0.615789 14.6277778 0.584211 14.6305556 0.531579 14.6333333 0.473684 14.6361111 0.386842 14.6388889 0.294737 14.6416667 0.215789 14.6444444 0.173684 14.6472222 0.155263 14.6500000 0.150000 14.6527778 0.150000 14.6555556 0.144737 14.6583333 0.123684 14.6611111 0.105263 14.6638889 0.110526 14.6666667 0.128947 14.6694444 0.144737 14.6722222 0.173684 14.6750000 0.184211 14.6777778 0.213158 14.6805556 0.228947 14.6833333 0.239474 14.6861111 0.236842 14.6888889 0.223684 14.6916667 0.200000 14.6944444 0.184211 14.6972222 0.165789 14.7000000 0.168421 14.7027778 0.171053 14.7055556 0.178947 14.7083333 0.178947 14.7111111 0.168421 14.7138889 0.171053 14.7166667 0.176316 14.7194444 0.184211 14.7222222 0.176316 14.7250000 0.176316 14.7277778 0.173684 14.7305556 0.176316 14.7333333 0.178947 14.7361111 0.186842 14.7388889 0.192105 14.7416667 0.189474 14.7444444 0.181579 14.7472222 0.165789 14.7500000 0.176316 14.7527778 0.181579 14.7555556 0.186842 14.7583333 0.178947 14.7611111 0.181579 14.7638889 0.176316 14.7666667 0.176316 14.7694444 0.184211 14.7722222 0.184211 14.7750000 0.186842 14.7777778 0.178947 14.7805556 0.181579 14.7833333 0.189474 14.7861111 0.194737 14.7888889 0.200000 14.7916667 0.197368 14.7944444 0.186842 14.7972222 0.189474 14.8000000 0.192105 14.8027778 0.200000 14.8055556 0.200000 14.8083333 0.197368 14.8111111 0.189474 14.8138889 0.194737 14.8166667 0.197368 14.8194444 0.205263 14.8222222 0.200000 14.8250000 0.205263 14.8277778 0.200000 14.8305556 0.202632 14.8333333 0.205263 14.8361111 0.215789 14.8388889 0.221053 14.8416667 0.223684 14.8444444 0.218421 14.8472222 0.221053 14.8500000 0.218421 14.8527778 0.234211 14.8555556 0.231579 14.8583333 0.234211 14.8611111 0.234211 14.8638889 0.226316 14.8666667 0.231579 14.8694444 0.234211 14.8722222 0.244737 14.8750000 0.244737 14.8777778 0.239474 14.8805556 0.239474 14.8833333 0.244737 14.8861111 0.252632 14.8888889 0.255263 14.8916667 0.263158 14.8944444 0.257895 14.8972222 0.260526 14.9000000 0.257895 14.9027778 0.263158 14.9055556 0.271053 14.9083333 0.268421 14.9111111 0.263158 14.9138889 0.257895 15.0555556 0.321053 15.0583333 0.318421 15.0611111 0.315789 15.0638889 0.310526 15.0666667 0.310526 15.0694444 0.310526 15.0722222 0.315789 15.0750000 0.315789 15.0777778 0.307895 15.0805556 0.302632 15.0833333 0.307895 15.0861111 0.307895 15.0888889 0.305263 15.0916667 0.305263 15.0944444 0.302632 15.0972222 0.300000 15.1000000 0.302632 15.1027778 0.302632 15.1055556 0.315789 15.1083333 0.313158 15.1111111 0.305263 15.1138889 0.302632 15.1166667 0.305263 15.1194444 0.313158 15.1222222 0.323684 15.1250000 0.323684 15.1277778 0.315789 15.1305556 0.315789 15.1333333 0.321053 15.1361111 0.318421 15.1388889 0.323684 15.1416667 0.318421 15.1444444 0.313158 15.1472222 0.318421 15.1500000 0.321053 15.1527778 0.326316 15.1555556 0.331579 15.1583333 0.339474 15.1611111 0.334211 15.1638889 0.334211 15.1666667 0.339474 15.1694444 0.347368 15.1722222 0.357895 15.1750000 0.355263 15.1777778 0.355263 15.1805556 0.352632 15.1833333 0.357895 15.1861111 0.365789 15.1888889 0.373684 15.1916667 0.373684 15.1944444 0.365789 15.1972222 0.357895 15.2000000 0.363158 15.2027778 0.376316 15.2055556 0.381579 15.2083333 0.386842 15.2111111 0.381579 15.2138889 0.386842 15.2166667 0.384211 15.2194444 0.394737 15.2222222 0.394737 15.2250000 0.386842 15.2277778 0.376316 15.2305556 0.360526 15.2333333 0.360526 15.2361111 0.352632 15.2388889 0.350000 15.2416667 0.350000 15.2444444 0.355263 15.2472222 0.360526 15.2500000 0.357895 15.2527778 0.347368 15.2555556 0.336842 15.2583333 0.321053 15.2611111 0.328947 15.2638889 0.323684 15.2666667 0.315789 15.2694444 0.302632 15.2722222 0.286842 15.2750000 0.250000 15.2777778 0.202632 15.2805556 0.157895 15.2833333 0.121053 15.2861111 0.078947 15.2888889 0.044737 15.2916667 0.010000 15.2944444 0.010000 15.2972222 0.010000 15.3000000 0.010000 15.3027778 0.010000 15.3055556 0.010000 15.3083333 0.010000 15.3111111 0.010000 15.3138889 0.010000 15.3166667 0.010000 15.3194444 0.010000 15.3222222 0.010000 15.3250000 0.010000 15.3277778 0.010000 15.3305556 0.010000 15.3333333 0.010000 15.3361111 0.010000 15.3388889 0.010000 15.3416667 0.010000 15.3444444 0.010000 15.3472222 0.010000 15.3500000 0.010000 15.3527778 0.010000 15.3555556 0.010000 15.3583333 0.010000 15.3611111 0.010000 15.3638889 0.010000 15.3666667 0.010000 15.3694444 0.010000 15.3722222 0.010000 15.3750000 0.010000 15.3777778 0.010000 15.3805556 0.010000 15.3833333 0.010000 15.3861111 0.010000 15.3888889 0.010000 15.3916667 0.010000 15.3944444 0.010000 15.3972222 0.010000 15.4000000 0.010000 15.4027778 0.010000 15.4055556 0.010000 15.4083333 0.010000 15.4111111 0.010000 15.4138889 0.010000 15.4166667 0.010000 15.4194444 0.010000 15.4222222 0.010000 15.4250000 0.010000 15.4277778 0.010000 15.4305556 0.010000 15.4333333 0.010000 15.4361111 0.010000 15.4388889 0.010000 15.4416667 0.010000 15.4444444 0.010000 15.4472222 0.010000 15.4500000 0.010000 15.4527778 0.010000 15.4555556 0.010000 15.4583333 0.010000 15.4611111 0.010000 15.4638889 0.010000 15.4666667 0.010000 15.4694444 0.010000 15.4722222 0.010000 15.4750000 0.010000 15.4777778 0.010000 15.4805556 0.010000 15.4833333 0.010000 15.4861111 0.010000 15.4888889 0.010000 15.4916667 0.010000 15.4944444 0.010000 15.4972222 0.010000 15.5000000 0.010000 15.5027778 0.010000 15.5055556 0.010000 15.5083333 0.010000 15.5111111 0.010000 15.5138889 0.010000 15.5166667 0.010000 15.5194444 0.010000 15.5222222 0.010000 15.5250000 0.010000 15.5277778 0.010000 15.5305556 0.010000 15.5333333 0.010000 15.5361111 0.010000 15.5388889 0.010000 15.5416667 0.010000 15.5444444 0.010000 15.5472222 0.010000 15.5500000 0.010000 15.5527778 0.010000 15.5555556 0.010000 15.5583333 0.010000 15.5611111 0.010000 15.5638889 0.010000 15.5666667 0.010000 15.5694444 0.010000 15.5722222 0.010000 15.5750000 0.010000 15.5777778 0.010000 15.5805556 0.010000 15.5833333 0.010000 15.5861111 0.015789 15.5888889 0.021053 15.5916667 0.031579 15.5944444 0.026316 15.5972222 0.028947 15.6000000 0.026316 15.6027778 0.039474 15.8055556 0.250000)
Vqrs qrs_gate 0 PWL(0.0000000 0.000000 0.4695556 0.000000 0.4705556 0.900000 0.6183333 0.900000 0.6193333 0.000000 1.8640000 0.000000 1.8650000 0.900000 2.0155556 0.900000 2.0165556 0.000000 2.5362222 0.000000 2.5372222 0.900000 2.6822222 0.900000 2.6832222 0.000000 3.9612222 0.000000 3.9622222 0.900000 4.1100000 0.900000 4.1110000 0.000000 4.6751111 0.000000 4.6761111 0.900000 4.8266667 0.900000 4.8276667 0.000000 6.1167778 0.000000 6.1177778 0.900000 6.2655556 0.900000 6.2665556 0.000000 6.8001111 0.000000 6.8011111 0.900000 6.9488889 0.900000 6.9498889 0.000000 8.1917778 0.000000 8.1927778 0.900000 8.2683333 0.900000 8.2693333 0.000000 8.8362222 0.000000 8.8372222 0.900000 8.9905556 0.900000 8.9915556 0.000000 10.3528889 0.000000 10.3538889 0.900000 10.4461111 0.900000 10.4471111 0.000000 11.0556667 0.000000 11.0566667 0.900000 11.2044444 0.900000 11.2054444 0.000000 12.4973333 0.000000 12.4983333 0.900000 12.5850000 0.900000 12.5860000 0.000000 13.1640000 0.000000 13.1650000 0.900000 13.3127778 0.900000 13.3137778 0.000000 14.5834444 0.000000 14.5844444 0.900000 14.6738889 0.900000 14.6748889 0.000000 15.2751111 0.000000 15.2761111 0.900000 15.4238889 0.900000 15.4248889 0.000000 15.8055556 0.000000)
Vrpeak rpeak_trigger 0 PWL(0.0000000 0.000000 0.4990000 0.000000 0.5000000 0.900000 0.5020000 0.900000 0.5030000 0.000000 1.9156667 0.000000 1.9166667 0.900000 1.9186667 0.900000 1.9196667 0.000000 2.5628889 0.000000 2.5638889 0.900000 2.5658889 0.900000 2.5668889 0.000000 4.0101111 0.000000 4.0111111 0.900000 4.0131111 0.900000 4.0141111 0.000000 4.7073333 0.000000 4.7083333 0.900000 4.7103333 0.900000 4.7113333 0.000000 6.1462222 0.000000 6.1472222 0.900000 6.1492222 0.900000 6.1502222 0.000000 6.8295556 0.000000 6.8305556 0.900000 6.8325556 0.900000 6.8335556 0.000000 8.2184444 0.000000 8.2194444 0.900000 8.2214444 0.900000 8.2224444 0.000000 8.8712222 0.000000 8.8722222 0.900000 8.8742222 0.900000 8.8752222 0.000000 10.3851111 0.000000 10.3861111 0.900000 10.3881111 0.900000 10.3891111 0.000000 11.0851111 0.000000 11.0861111 0.900000 11.0881111 0.900000 11.0891111 0.000000 12.5295556 0.000000 12.5305556 0.900000 12.5325556 0.900000 12.5335556 0.000000 13.1934444 0.000000 13.1944444 0.900000 13.1964444 0.900000 13.1974444 0.000000 14.6156667 0.000000 14.6166667 0.900000 14.6186667 0.900000 14.6196667 0.000000 15.3045556 0.000000 15.3055556 0.900000 15.3075556 0.900000 15.3085556 0.000000 15.8055556 0.000000)

Xinstab ecg_in qrs_gate rpeak_trigger instab_out peak_out vdd vss vbias beat_instability_v2

.tran 0.2m 15.8056

.meas tran peak_b0 FIND V(Xinstab.peak_node) AT=0.6233333
.meas tran ewma_b0 FIND V(Xinstab.ewma_node) AT=0.6233333
.meas tran instab_b0 FIND V(instab_out) AT=0.6233333
.meas tran peakrp_b0 FIND V(Xinstab.peak_node) AT=0.5000000
.meas tran peak_b1 FIND V(Xinstab.peak_node) AT=2.0205556
.meas tran ewma_b1 FIND V(Xinstab.ewma_node) AT=2.0205556
.meas tran instab_b1 FIND V(instab_out) AT=2.0205556
.meas tran peakrp_b1 FIND V(Xinstab.peak_node) AT=1.9166667
.meas tran peak_b2 FIND V(Xinstab.peak_node) AT=2.6872222
.meas tran ewma_b2 FIND V(Xinstab.ewma_node) AT=2.6872222
.meas tran instab_b2 FIND V(instab_out) AT=2.6872222
.meas tran peakrp_b2 FIND V(Xinstab.peak_node) AT=2.5638889
.meas tran peak_b3 FIND V(Xinstab.peak_node) AT=4.1150000
.meas tran ewma_b3 FIND V(Xinstab.ewma_node) AT=4.1150000
.meas tran instab_b3 FIND V(instab_out) AT=4.1150000
.meas tran peakrp_b3 FIND V(Xinstab.peak_node) AT=4.0111111
.meas tran peak_b4 FIND V(Xinstab.peak_node) AT=4.8316667
.meas tran ewma_b4 FIND V(Xinstab.ewma_node) AT=4.8316667
.meas tran instab_b4 FIND V(instab_out) AT=4.8316667
.meas tran peakrp_b4 FIND V(Xinstab.peak_node) AT=4.7083333
.meas tran peak_b5 FIND V(Xinstab.peak_node) AT=6.2705556
.meas tran ewma_b5 FIND V(Xinstab.ewma_node) AT=6.2705556
.meas tran instab_b5 FIND V(instab_out) AT=6.2705556
.meas tran peakrp_b5 FIND V(Xinstab.peak_node) AT=6.1472222
.meas tran peak_b6 FIND V(Xinstab.peak_node) AT=6.9538889
.meas tran ewma_b6 FIND V(Xinstab.ewma_node) AT=6.9538889
.meas tran instab_b6 FIND V(instab_out) AT=6.9538889
.meas tran peakrp_b6 FIND V(Xinstab.peak_node) AT=6.8305556
.meas tran peak_b7 FIND V(Xinstab.peak_node) AT=8.2733333
.meas tran ewma_b7 FIND V(Xinstab.ewma_node) AT=8.2733333
.meas tran instab_b7 FIND V(instab_out) AT=8.2733333
.meas tran peakrp_b7 FIND V(Xinstab.peak_node) AT=8.2194444
.meas tran peak_b8 FIND V(Xinstab.peak_node) AT=8.9955556
.meas tran ewma_b8 FIND V(Xinstab.ewma_node) AT=8.9955556
.meas tran instab_b8 FIND V(instab_out) AT=8.9955556
.meas tran peakrp_b8 FIND V(Xinstab.peak_node) AT=8.8722222
.meas tran peak_b9 FIND V(Xinstab.peak_node) AT=10.4511111
.meas tran ewma_b9 FIND V(Xinstab.ewma_node) AT=10.4511111
.meas tran instab_b9 FIND V(instab_out) AT=10.4511111
.meas tran peakrp_b9 FIND V(Xinstab.peak_node) AT=10.3861111
.meas tran peak_b10 FIND V(Xinstab.peak_node) AT=11.2094444
.meas tran ewma_b10 FIND V(Xinstab.ewma_node) AT=11.2094444
.meas tran instab_b10 FIND V(instab_out) AT=11.2094444
.meas tran peakrp_b10 FIND V(Xinstab.peak_node) AT=11.0861111
.meas tran peak_b11 FIND V(Xinstab.peak_node) AT=12.5900000
.meas tran ewma_b11 FIND V(Xinstab.ewma_node) AT=12.5900000
.meas tran instab_b11 FIND V(instab_out) AT=12.5900000
.meas tran peakrp_b11 FIND V(Xinstab.peak_node) AT=12.5305556
.meas tran peak_b12 FIND V(Xinstab.peak_node) AT=13.3177778
.meas tran ewma_b12 FIND V(Xinstab.ewma_node) AT=13.3177778
.meas tran instab_b12 FIND V(instab_out) AT=13.3177778
.meas tran peakrp_b12 FIND V(Xinstab.peak_node) AT=13.1944444
.meas tran peak_b13 FIND V(Xinstab.peak_node) AT=14.6788889
.meas tran ewma_b13 FIND V(Xinstab.ewma_node) AT=14.6788889
.meas tran instab_b13 FIND V(instab_out) AT=14.6788889
.meas tran peakrp_b13 FIND V(Xinstab.peak_node) AT=14.6166667
.meas tran peak_b14 FIND V(Xinstab.peak_node) AT=15.4288889
.meas tran ewma_b14 FIND V(Xinstab.ewma_node) AT=15.4288889
.meas tran instab_b14 FIND V(instab_out) AT=15.4288889
.meas tran peakrp_b14 FIND V(Xinstab.peak_node) AT=15.3055556

.end
