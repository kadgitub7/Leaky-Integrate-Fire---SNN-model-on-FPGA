* ============================================================
* nA-Range Self-Biased Current Reference (Beta Multiplier)
* Generates Vbias for all OTA tail transistors
* SKY130 transistor-level
*
* Pin order: vbias vdd vss
* Output: vbias drives all OTA tail gates
* ============================================================

.subckt bias_gen vbias vdd vss

* --- Startup circuit ---
* Ensures the loop doesn't stay at the zero-current state
XMs1 vbias ns1 vdd vdd sky130_fd_pr__pfet_01v8_hvt L=4 W=1 nf=1
XMs2 ns1 ns1 vss vss sky130_fd_pr__nfet_01v8 L=1 W=0.42 nf=1
XCs ns1 vss sky130_fd_pr__cap_mim_m3_1 W=3 L=3

* --- PMOS current mirror (sets equal current in both branches) ---
* Extra-long channel for matching at nA currents
XMp1 net_a net_a vdd vdd sky130_fd_pr__pfet_01v8_hvt L=8 W=2 nf=1
XMp2 vbias net_a vdd vdd sky130_fd_pr__pfet_01v8_hvt L=8 W=2 nf=1

* --- NMOS branch A: diode-connected ---
XMn1 net_a net_a vss vss sky130_fd_pr__nfet_01v8 L=8 W=1 nf=1

* --- NMOS branch B: source-degenerated ---
* W ratio Mn2/Mn1 = 4, combined with Rs sets current
* Id = (1/Rs) * n*Vt * ln(K), K = (W/L)_n2 / (W/L)_n1 = 4
XMn2 vbias vbias net_rs vss sky130_fd_pr__nfet_01v8 L=8 W=4 nf=1

* --- Degeneration pseudo-resistor ---
* Subthreshold HVT PMOS as multi-GOhm resistor
* R ~ Vt / (Id * exp(-Vth/nVt)) ~ 100 GOhm at nA range
* This sets the nA-level operating current
XMrs net_rs net_rs vss vdd sky130_fd_pr__pfet_01v8_hvt L=10 W=0.42 nf=1

.ends bias_gen
