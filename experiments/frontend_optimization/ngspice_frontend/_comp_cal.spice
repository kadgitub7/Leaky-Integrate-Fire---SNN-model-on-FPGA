.title compensated_threshold_calibration
.lib "sky130_minimal.lib.spice" tt
.option scale=1.0u method=gear reltol=0.01 gmin=1e-15
.temp 27
Vdd vdd 0 0.9
Vss vss 0 0
Vbias vbias 0 0.300
Vrpk rpk 0 PWL(0 0 0.0496 0 0.0500 0.9 0.0550 0.9 0.0554 0 0.5 0)

.include "C:/Users/kadhi/OneDrive/Desktop/amux/verilogLearning/Leaky-Integrate-Fire---SNN-model-on-FPGA/experiments/frontend_optimization/complete_frontend_v9b/inverter.spice"
.include "C:/Users/kadhi/OneDrive/Desktop/amux/verilogLearning/Leaky-Integrate-Fire---SNN-model-on-FPGA/experiments/frontend_optimization/complete_frontend_v9b/delay_timer.spice"

Xdt rpk ts14 ts69 twid tbi trr trpk sf_out
+ vdd vss vbias 0.200 0.200 0.200 0.200 0.200 0.200 delay_timer

.tran 0.01m 0.5

.meas tran sf_10.0ms FIND V(sf_out) AT=0.0660000
.meas tran sf_14.0ms FIND V(sf_out) AT=0.0700000
.meas tran sf_16.0ms FIND V(sf_out) AT=0.0720000
.meas tran sf_20.0ms FIND V(sf_out) AT=0.0760000
.meas tran sf_58.5ms FIND V(sf_out) AT=0.1145000
.meas tran sf_69.0ms FIND V(sf_out) AT=0.1250000
.meas tran sf_72.5ms FIND V(sf_out) AT=0.1285000
.meas tran sf_83.0ms FIND V(sf_out) AT=0.1390000
.meas tran sf_289.5ms FIND V(sf_out) AT=0.3455000
.meas tran sf_300.0ms FIND V(sf_out) AT=0.3560000
.meas tran sff_14ms FIND V(xdt.sf_timer2) AT=0.0700000
.meas tran sff_20ms FIND V(xdt.sf_timer2) AT=0.0760000
.meas tran sff_10ms FIND V(xdt.sf_timer2) AT=0.0660000
.meas tran sff_16ms FIND V(xdt.sf_timer2) AT=0.0720000

.end
