.title analog_diagnostic
.lib "C:/Users/kadhi/OneDrive/Desktop/amux/verilogLearning/Leaky-Integrate-Fire---SNN-model-on-FPGA/experiments/frontend_optimization/ngspice_frontend/sky130_minimal.lib.spice" tt
.option scale=1.0u method=gear reltol=0.01 gmin=1e-15 itl4=200
.temp 27
Vdd vdd 0 0.9
Vss vss 0 0
Vecg0 ecg_l0 0 PWL(0.0000000 0.300000 0.2470000 0.300000 0.2500000 0.249691 0.2527778 0.248866 0.2555556 0.250515 0.2583333 0.249691 0.2611111 0.252165 0.2638889 0.250515 0.2666667 0.250515 0.2694444 0.249691 0.2722222 0.249691 0.2750000 0.252165 0.2777778 0.253814 0.2805556 0.251340 0.2833333 0.249691 0.2861111 0.248041 0.2888889 0.249691 0.2916667 0.251340 0.2944444 0.252165 0.2972222 0.253814 0.3000000 0.255464 0.3027778 0.254639 0.3055556 0.254639 0.3083333 0.255464 0.3111111 0.258763 0.3138889 0.258763 0.3166667 0.257938 0.3194444 0.262887 0.3222222 0.263711 0.3250000 0.266186 0.3277778 0.267010 0.3305556 0.266186 0.3333333 0.264536 0.3361111 0.262062 0.3388889 0.263711 0.3416667 0.262887 0.3444444 0.262887 0.3472222 0.262887 0.3500000 0.262062 0.3527778 0.261237 0.3555556 0.260412 0.3583333 0.261237 0.3611111 0.263711 0.3638889 0.265361 0.3666667 0.266186 0.3694444 0.259588 0.3722222 0.252990 0.3750000 0.252990 0.3777778 0.250515 0.3805556 0.248866 0.3833333 0.245567 0.3861111 0.245567 0.3888889 0.246392 0.3916667 0.248041 0.3944444 0.247216 0.3972222 0.248041 0.4000000 0.246392 0.4027778 0.243918 0.4055556 0.243093 0.4083333 0.243918 0.4111111 0.243918 0.4138889 0.242268 0.4166667 0.243093 0.4194444 0.241443 0.4222222 0.245567 0.4250000 0.244742 0.4277778 0.245567 0.4305556 0.247216 0.4333333 0.243093 0.4361111 0.241443 0.4388889 0.243918 0.4416667 0.245567 0.4444444 0.246392 0.4472222 0.245567 0.4500000 0.242268 0.4527778 0.239794 0.4555556 0.240619 0.4583333 0.237320 0.4611111 0.229897 0.4638889 0.226598 0.4666667 0.221649 0.4694444 0.215876 0.4722222 0.211753 0.4750000 0.216701 0.4777778 0.231546 0.4805556 0.250515 0.4833333 0.273608 0.4861111 0.297526 0.4888889 0.338763 0.4916667 0.380825 0.4944444 0.418763 0.4972222 0.444330 0.5000000 0.455052 0.5027778 0.449278 0.5055556 0.424536 0.5083333 0.380825 0.5111111 0.327216 0.5138889 0.281856 0.5166667 0.255464 0.5194444 0.235670 0.5222222 0.225773 0.5250000 0.221649 0.5277778 0.224948 0.5305556 0.229897 0.5333333 0.235670 0.5361111 0.235670 0.5388889 0.236495 0.5416667 0.235670 0.5444444 0.237320 0.5472222 0.237320 0.5500000 0.237320 0.5527778 0.234845 0.5555556 0.236495 0.5583333 0.236495 0.5611111 0.236495 0.5638889 0.238144 0.5666667 0.234845 0.5694444 0.232371 0.5722222 0.232371 0.5750000 0.234021 0.5777778 0.234845 0.5805556 0.235670 0.5833333 0.233196 0.5861111 0.234845 0.5888889 0.236495 0.5916667 0.238144 0.5944444 0.235670 0.5972222 0.235670 0.6000000 0.233196 0.6027778 0.232371 0.6055556 0.232371 0.6083333 0.235670 0.6111111 0.235670 0.6138889 0.234845 0.6166667 0.233196 0.6194444 0.231546 0.6222222 0.234021 0.6250000 0.232371 0.6277778 0.233196 0.6305556 0.232371 0.6333333 0.231546 0.6361111 0.232371 0.6388889 0.234021 0.6416667 0.234021 0.6444444 0.234845 0.6472222 0.235670 0.6500000 0.233196 0.6527778 0.232371 0.6555556 0.235670 0.6583333 0.235670 0.6611111 0.236495 0.6638889 0.236495 0.6666667 0.232371 0.6694444 0.233196 0.6722222 0.234845 0.6750000 0.235670 0.6777778 0.238144 0.6805556 0.235670 0.6833333 0.234845 0.6861111 0.232371 0.6888889 0.234021 0.6916667 0.235670 0.6944444 0.235670 0.6972222 0.236495 0.7000000 0.233196 0.7027778 0.231546 0.7055556 0.231546 0.7083333 0.234021 0.7111111 0.234845 0.7138889 0.233196 0.7166667 0.231546 0.7194444 0.230722 0.7222222 0.230722 0.7250000 0.232371 0.7277778 0.231546 0.7305556 0.229897 0.7333333 0.230722 0.7361111 0.228247 0.7388889 0.229072 0.7416667 0.229072 0.7444444 0.230722 0.7472222 0.229072 0.7500000 0.225773 0.7527778 0.224948 0.7555556 0.225773 0.7583333 0.228247 0.7611111 0.226598 0.7638889 0.225773 0.7666667 0.224948 0.7694444 0.222474 0.7722222 0.224124 0.7750000 0.224948 0.7777778 0.225773 0.7805556 0.224948 0.7833333 0.222474 0.7861111 0.221649 0.7888889 0.224124 0.7916667 0.225773 0.7944444 0.226598 0.7972222 0.227423 0.8030000 0.300000 1.0581111 0.300000 1.0611111 0.245567 1.0638889 0.243093 1.0666667 0.243093 1.0694444 0.241443 1.0722222 0.242268 1.0750000 0.243918 1.0777778 0.245567 1.0805556 0.243918 1.0833333 0.243918 1.0861111 0.243918 1.0888889 0.245567 1.0916667 0.244742 1.0944444 0.245567 1.0972222 0.244742 1.1000000 0.243093 1.1027778 0.243093 1.1055556 0.243918 1.1083333 0.245567 1.1111111 0.248041 1.1138889 0.251340 1.1166667 0.250515 1.1194444 0.251340 1.1222222 0.252990 1.1250000 0.254639 1.1277778 0.256289 1.1305556 0.256289 1.1333333 0.256289 1.1361111 0.257938 1.1388889 0.258763 1.1416667 0.260412 1.1444444 0.262887 1.1472222 0.264536 1.1500000 0.260412 1.1527778 0.259588 1.1555556 0.260412 1.1583333 0.259588 1.1611111 0.261237 1.1638889 0.259588 1.1666667 0.258763 1.1694444 0.254639 1.1722222 0.254639 1.1750000 0.256289 1.1777778 0.258763 1.1805556 0.262887 1.1833333 0.263711 1.1861111 0.262062 1.1888889 0.256289 1.1916667 0.255464 1.1944444 0.253814 1.1972222 0.252990 1.2000000 0.249691 1.2027778 0.247216 1.2055556 0.243918 1.2083333 0.245567 1.2111111 0.244742 1.2138889 0.244742 1.2166667 0.241443 1.2194444 0.238969 1.2222222 0.240619 1.2250000 0.243093 1.2277778 0.242268 1.2305556 0.241443 1.2333333 0.239794 1.2361111 0.238144 1.2388889 0.237320 1.2416667 0.238969 1.2444444 0.239794 1.2472222 0.239794 1.2500000 0.237320 1.2527778 0.236495 1.2555556 0.237320 1.2583333 0.238144 1.2611111 0.241443 1.2638889 0.238969 1.2666667 0.235670 1.2694444 0.233196 1.2722222 0.232371 1.2750000 0.228247 1.2777778 0.223299 1.2805556 0.219175 1.2833333 0.214227 1.2861111 0.208454 1.2888889 0.205979 1.2916667 0.213402 1.2944444 0.233196 1.2972222 0.258763 1.3000000 0.285155 1.3027778 0.319794 1.3055556 0.367629 1.3083333 0.413814 1.3111111 0.445979 1.3138889 0.458351 1.3166667 0.440206 1.3194444 0.385773 1.3222222 0.308247 1.3250000 0.247216 1.3277778 0.217526 1.3305556 0.216701 1.3333333 0.226598 1.3361111 0.231546 1.3388889 0.234845 1.3416667 0.235670 1.3444444 0.234845 1.3472222 0.235670 1.3500000 0.234845 1.3527778 0.233196 1.3555556 0.234845 1.3583333 0.233196 1.3611111 0.235670 1.3638889 0.234845 1.3666667 0.234845 1.3694444 0.232371 1.3722222 0.233196 1.3750000 0.234021 1.3777778 0.234021 1.3805556 0.231546 1.3833333 0.233196 1.3861111 0.230722 1.3888889 0.231546 1.3916667 0.233196 1.3944444 0.233196 1.3972222 0.230722 1.4000000 0.230722 1.4027778 0.228247 1.4055556 0.230722 1.4083333 0.232371 1.4111111 0.232371 1.4138889 0.233196 1.4166667 0.229897 1.4194444 0.229072 1.4222222 0.230722 1.4250000 0.231546 1.4277778 0.232371 1.4305556 0.232371 1.4333333 0.229897 1.4361111 0.230722 1.4388889 0.234021 1.4416667 0.234845 1.4444444 0.234021 1.4472222 0.234021 1.4500000 0.234845 1.4527778 0.231546 1.4555556 0.233196 1.4583333 0.235670 1.4611111 0.234021 1.4638889 0.234021 1.4666667 0.231546 1.4694444 0.229897 1.4722222 0.229897 1.4750000 0.231546 1.4777778 0.231546 1.4805556 0.232371 1.4833333 0.229897 1.4861111 0.229897 1.4888889 0.230722 1.4916667 0.231546 1.4944444 0.234021 1.4972222 0.234021 1.5000000 0.232371 1.5027778 0.229897 1.5055556 0.232371 1.5083333 0.233196 1.5111111 0.234845 1.5138889 0.234021 1.5166667 0.234021 1.5194444 0.233196 1.5222222 0.236495 1.5250000 0.234021 1.5277778 0.235670 1.5305556 0.235670 1.5333333 0.234021 1.5361111 0.231546 1.5388889 0.233196 1.5416667 0.233196 1.5444444 0.232371 1.5472222 0.231546 1.5500000 0.230722 1.5527778 0.230722 1.5555556 0.229897 1.5583333 0.231546 1.5611111 0.231546 1.5638889 0.232371 1.5666667 0.228247 1.5694444 0.229072 1.5722222 0.228247 1.5750000 0.230722 1.5777778 0.230722 1.5805556 0.230722 1.5833333 0.230722 1.5861111 0.229897 1.5888889 0.229897 1.5916667 0.231546 1.5944444 0.234845 1.5972222 0.234845 1.6000000 0.235670 1.6027778 0.238144 1.6055556 0.240619 1.6083333 0.243918 1.6141111 0.300000 1.8470000 0.300000 1.8500000 0.238144 1.8527778 0.236495 1.8555556 0.241443 1.8583333 0.240619 1.8611111 0.241443 1.8638889 0.240619 1.8666667 0.240619 1.8694444 0.238969 1.8722222 0.240619 1.8750000 0.243093 1.8777778 0.241443 1.8805556 0.243093 1.8833333 0.243093 1.8861111 0.243093 1.8888889 0.243918 1.8916667 0.248866 1.8944444 0.249691 1.8972222 0.249691 1.9000000 0.248866 1.9027778 0.249691 1.9055556 0.252165 1.9083333 0.252990 1.9111111 0.254639 1.9138889 0.253814 1.9166667 0.253814 1.9194444 0.254639 1.9222222 0.256289 1.9250000 0.257938 1.9277778 0.259588 1.9305556 0.257113 1.9333333 0.256289 1.9361111 0.254639 1.9388889 0.253814 1.9416667 0.256289 1.9444444 0.255464 1.9472222 0.254639 1.9500000 0.253814 1.9527778 0.254639 1.9555556 0.253814 1.9583333 0.254639 1.9611111 0.256289 1.9638889 0.257938 1.9666667 0.260412 1.9694444 0.257113 1.9722222 0.253814 1.9750000 0.248866 1.9777778 0.248866 1.9805556 0.243093 1.9833333 0.240619 1.9861111 0.237320 1.9888889 0.236495 1.9916667 0.237320 1.9944444 0.238969 1.9972222 0.238144 2.0000000 0.236495 2.0027778 0.235670 2.0055556 0.234845 2.0083333 0.236495 2.0111111 0.236495 2.0138889 0.236495 2.0166667 0.234845 2.0194444 0.233196 2.0222222 0.234021 2.0250000 0.238144 2.0277778 0.238144 2.0305556 0.235670 2.0333333 0.234845 2.0361111 0.231546 2.0388889 0.233196 2.0416667 0.234021 2.0444444 0.235670 2.0472222 0.233196 2.0500000 0.229897 2.0527778 0.224124 2.0555556 0.221649 2.0583333 0.216701 2.0611111 0.215876 2.0638889 0.213402 2.0666667 0.210928 2.0694444 0.201031 2.0722222 0.193608 2.0750000 0.196082 2.0777778 0.205155 2.0805556 0.218351 2.0833333 0.236495 2.0861111 0.255464 2.0888889 0.281031 2.0916667 0.314845 2.0944444 0.361031 2.0972222 0.404742 2.1000000 0.433608 2.1027778 0.441856 2.1055556 0.427010 2.1083333 0.378351 2.1111111 0.310722 2.1138889 0.249691 2.1166667 0.217526 2.1194444 0.214227 2.1222222 0.221649 2.1250000 0.232371 2.1277778 0.235670 2.1305556 0.235670 2.1333333 0.234021 2.1361111 0.232371 2.1388889 0.233196 2.1416667 0.236495 2.1444444 0.235670 2.1472222 0.234845 2.1500000 0.233196 2.1527778 0.232371 2.1555556 0.233196 2.1583333 0.234021 2.1611111 0.235670 2.1638889 0.234845 2.1666667 0.232371 2.1694444 0.231546 2.1722222 0.232371 2.1750000 0.234845 2.1777778 0.233196 2.1805556 0.232371 2.1833333 0.233196 2.1861111 0.233196 2.1888889 0.232371 2.1916667 0.235670 2.1944444 0.236495 2.1972222 0.235670 2.2000000 0.234845 2.2027778 0.234021 2.2055556 0.234021 2.2083333 0.234021 2.2111111 0.234845 2.2138889 0.234845 2.2166667 0.233196 2.2194444 0.233196 2.2222222 0.234021 2.2250000 0.234845 2.2277778 0.236495 2.2305556 0.238144 2.2333333 0.236495 2.2361111 0.234845 2.2388889 0.235670 2.2416667 0.236495 2.2444444 0.238144 2.2472222 0.236495 2.2500000 0.234845 2.2527778 0.234845 2.2555556 0.236495 2.2583333 0.238144 2.2611111 0.238144 2.2638889 0.236495 2.2666667 0.234845 2.2694444 0.235670 2.2722222 0.235670 2.2750000 0.239794 2.2777778 0.238144 2.2805556 0.236495 2.2833333 0.234845 2.2861111 0.237320 2.2888889 0.236495 2.2916667 0.238144 2.2944444 0.237320 2.2972222 0.235670 2.3000000 0.237320 2.3027778 0.238144 2.3055556 0.238144 2.3083333 0.238144 2.3111111 0.238144 2.3138889 0.237320 2.3166667 0.235670 2.3194444 0.235670 2.3222222 0.239794 2.3250000 0.238969 2.3277778 0.238144 2.3305556 0.236495 2.3333333 0.235670 2.3361111 0.235670 2.3388889 0.238144 2.3416667 0.239794 2.3444444 0.236495 2.3472222 0.237320 2.3500000 0.235670 2.3527778 0.238144 2.3555556 0.238144 2.3583333 0.239794 2.3611111 0.238969 2.3638889 0.236495 2.3666667 0.234845 2.3694444 0.236495 2.3722222 0.236495 2.3750000 0.238969 2.3777778 0.239794 2.3805556 0.238969 2.3833333 0.238144 2.3861111 0.242268 2.3888889 0.244742 2.3916667 0.247216 2.3944444 0.248041 2.3972222 0.247216 2.4030000 0.300000 2.6386667 0.300000 2.6416667 0.243093 2.6444444 0.243093 2.6472222 0.242268 2.6500000 0.241443 2.6527778 0.243093 2.6555556 0.245567 2.6583333 0.245567 2.6611111 0.244742 2.6638889 0.244742 2.6666667 0.243918 2.6694444 0.245567 2.6722222 0.247216 2.6750000 0.252165 2.6777778 0.252165 2.6805556 0.250515 2.6833333 0.249691 2.6861111 0.252990 2.6888889 0.253814 2.6916667 0.254639 2.6944444 0.253814 2.6972222 0.254639 2.7000000 0.255464 2.7027778 0.256289 2.7055556 0.258763 2.7083333 0.262062 2.7111111 0.259588 2.7138889 0.260412 2.7166667 0.257938 2.7194444 0.257938 2.7222222 0.259588 2.7250000 0.261237 2.7277778 0.257938 2.7305556 0.256289 2.7333333 0.257113 2.7361111 0.257938 2.7388889 0.255464 2.7416667 0.256289 2.7444444 0.253814 2.7472222 0.257938 2.7500000 0.258763 2.7527778 0.259588 2.7555556 0.256289 2.7583333 0.253814 2.7611111 0.250515 2.7638889 0.248041 2.7666667 0.246392 2.7694444 0.244742 2.7722222 0.243093 2.7750000 0.245567 2.7777778 0.244742 2.7805556 0.243093 2.7833333 0.240619 2.7861111 0.242268 2.7888889 0.243918 2.7916667 0.244742 2.7944444 0.243093 2.7972222 0.240619 2.8000000 0.239794 2.8027778 0.238144 2.8055556 0.238969 2.8083333 0.239794 2.8111111 0.239794 2.8138889 0.237320 2.8166667 0.238144 2.8194444 0.238144 2.8222222 0.239794 2.8250000 0.238969 2.8277778 0.240619 2.8305556 0.238969 2.8333333 0.237320 2.8361111 0.239794 2.8388889 0.240619 2.8416667 0.242268 2.8444444 0.241443 2.8472222 0.238969 2.8500000 0.236495 2.8527778 0.234845 2.8555556 0.229072 2.8583333 0.226598 2.8611111 0.220000 2.8638889 0.215052 2.8666667 0.206804 2.8694444 0.208454 2.8722222 0.221649 2.8750000 0.241443 2.8777778 0.263711 2.8805556 0.290928 2.8833333 0.330515 2.8861111 0.378351 2.8888889 0.416289 2.8916667 0.435258 2.8944444 0.428660 2.8972222 0.388247 2.9000000 0.323918 2.9027778 0.267010 2.9055556 0.230722 2.9083333 0.217526 2.9111111 0.220825 2.9138889 0.225773 2.9166667 0.232371 2.9194444 0.234021 2.9222222 0.235670 2.9250000 0.235670 2.9277778 0.234021 2.9305556 0.233196 2.9333333 0.229897 2.9361111 0.229897 2.9388889 0.233196 2.9416667 0.234845 2.9444444 0.233196 2.9472222 0.233196 2.9500000 0.231546 2.9527778 0.233196 2.9555556 0.236495 2.9583333 0.235670 2.9611111 0.234845 2.9638889 0.234845 2.9666667 0.234845 2.9694444 0.234845 2.9722222 0.236495 2.9750000 0.235670 2.9777778 0.235670 2.9805556 0.234021 2.9833333 0.229897 2.9861111 0.232371 2.9888889 0.234021 2.9916667 0.234845 2.9944444 0.234021 2.9972222 0.233196 3.0000000 0.229897 3.0027778 0.231546 3.0055556 0.233196 3.0083333 0.233196 3.0111111 0.233196 3.0138889 0.232371 3.0166667 0.231546 3.0194444 0.233196 3.0222222 0.230722 3.0250000 0.233196 3.0277778 0.232371 3.0305556 0.232371 3.0333333 0.230722 3.0361111 0.231546 3.0388889 0.233196 3.0416667 0.234845 3.0444444 0.234845 3.0472222 0.234845 3.0500000 0.234021 3.0527778 0.234845 3.0555556 0.234845 3.0583333 0.233196 3.0611111 0.233196 3.0638889 0.230722 3.0666667 0.228247 3.0694444 0.231546 3.0722222 0.233196 3.0750000 0.234845 3.0777778 0.235670 3.0805556 0.231546 3.0833333 0.233196 3.0861111 0.233196 3.0888889 0.234021 3.0916667 0.234845 3.0944444 0.234845 3.0972222 0.233196 3.1000000 0.230722 3.1027778 0.231546 3.1055556 0.234021 3.1083333 0.234845 3.1111111 0.234021 3.1138889 0.233196 3.1166667 0.229897 3.1194444 0.229897 3.1222222 0.229897 3.1250000 0.230722 3.1277778 0.229897 3.1305556 0.225773 3.1333333 0.226598 3.1361111 0.225773 3.1388889 0.228247 3.1416667 0.226598 3.1444444 0.222474 3.1472222 0.224948 3.1500000 0.224124 3.1527778 0.227423 3.1555556 0.228247 3.1583333 0.229897 3.1611111 0.229072 3.1638889 0.226598 3.1666667 0.225773 3.1694444 0.226598 3.1722222 0.229072 3.1750000 0.230722 3.1777778 0.232371 3.1805556 0.229897 3.1833333 0.230722 3.1861111 0.233196 3.1888889 0.237320 3.1946667 0.300000 3.4275556 0.300000 3.4305556 0.243918 3.4333333 0.243918 3.4361111 0.243918 3.4388889 0.246392 3.4416667 0.246392 3.4444444 0.246392 3.4472222 0.243093 3.4500000 0.242268 3.4527778 0.243918 3.4555556 0.245567 3.4583333 0.247216 3.4611111 0.248866 3.4638889 0.249691 3.4666667 0.249691 3.4694444 0.254639 3.4722222 0.255464 3.4750000 0.257938 3.4777778 0.257113 3.4805556 0.256289 3.4833333 0.257113 3.4861111 0.258763 3.4888889 0.261237 3.4916667 0.261237 3.4944444 0.263711 3.4972222 0.261237 3.5000000 0.261237 3.5027778 0.263711 3.5055556 0.262062 3.5083333 0.262887 3.5111111 0.261237 3.5138889 0.259588 3.5166667 0.257938 3.5194444 0.260412 3.5222222 0.262062 3.5250000 0.262062 3.5277778 0.258763 3.5305556 0.257938 3.5333333 0.258763 3.5361111 0.262062 3.5388889 0.266186 3.5416667 0.267835 3.5444444 0.265361 3.5472222 0.262062 3.5500000 0.255464 3.5527778 0.255464 3.5555556 0.252990 3.5583333 0.252990 3.5611111 0.248866 3.5638889 0.245567 3.5666667 0.243918 3.5694444 0.243918 3.5722222 0.243093 3.5750000 0.242268 3.5777778 0.242268 3.5805556 0.243918 3.5833333 0.241443 3.5861111 0.243093 3.5888889 0.243918 3.5916667 0.243918 3.5944444 0.243093 3.5972222 0.241443 3.6000000 0.238969 3.6027778 0.241443 3.6055556 0.238969 3.6083333 0.243093 3.6111111 0.243918 3.6138889 0.240619 3.6166667 0.237320 3.6194444 0.240619 3.6222222 0.243093 3.6250000 0.242268 3.6277778 0.242268 3.6305556 0.241443 3.6333333 0.237320 3.6361111 0.235670 3.6388889 0.234845 3.6416667 0.229897 3.6444444 0.224948 3.6472222 0.221649 3.6500000 0.215876 3.6527778 0.210103 3.6555556 0.210928 3.6583333 0.218351 3.6611111 0.233196 3.6638889 0.251340 3.6666667 0.273608 3.6694444 0.306598 3.6722222 0.351959 3.6750000 0.398144 3.6777778 0.431959 3.6805556 0.445979 3.6833333 0.431134 3.6861111 0.385773 3.6888889 0.321443 3.6916667 0.264536 3.6944444 0.229897 3.6972222 0.217526 3.7000000 0.219175 3.7027778 0.225773 3.7055556 0.234021 3.7083333 0.235670 3.7111111 0.234845 3.7138889 0.234845 3.7166667 0.234021 3.7194444 0.235670 3.7222222 0.237320 3.7250000 0.236495 3.7277778 0.236495 3.7305556 0.234021 3.7333333 0.232371 3.7361111 0.232371 3.7388889 0.235670 3.7416667 0.235670 3.7444444 0.233196 3.7472222 0.233196 3.7500000 0.231546 3.7527778 0.232371 3.7555556 0.234845 3.7583333 0.234845 3.7611111 0.234021 3.7638889 0.231546 3.7666667 0.231546 3.7694444 0.231546 3.7722222 0.234021 3.7750000 0.235670 3.7777778 0.235670 3.7805556 0.232371 3.7833333 0.231546 3.7861111 0.233196 3.7888889 0.234845 3.7916667 0.234845 3.7944444 0.234845 3.7972222 0.233196 3.8000000 0.232371 3.8027778 0.232371 3.8055556 0.234021 3.8083333 0.235670 3.8111111 0.234845 3.8138889 0.232371 3.8166667 0.229897 3.8194444 0.231546 3.8222222 0.233196 3.8250000 0.232371 3.8277778 0.233196 3.8305556 0.231546 3.8333333 0.229897 3.8361111 0.229897 3.8388889 0.232371 3.8416667 0.234845 3.8444444 0.235670 3.8472222 0.234021 3.8500000 0.232371 3.8527778 0.232371 3.8555556 0.234021 3.8583333 0.235670 3.8611111 0.232371 3.8638889 0.230722 3.8666667 0.230722 3.8694444 0.231546 3.8722222 0.231546 3.8750000 0.233196 3.8777778 0.230722 3.8805556 0.231546 3.8833333 0.229897 3.8861111 0.232371 3.8888889 0.234021 3.8916667 0.233196 3.8944444 0.234021 3.8972222 0.234021 3.9000000 0.232371 3.9027778 0.234021 3.9055556 0.234845 3.9083333 0.234845 3.9111111 0.233196 3.9138889 0.232371 3.9166667 0.229897 3.9194444 0.229897 3.9222222 0.232371 3.9250000 0.232371 3.9277778 0.230722 3.9305556 0.229072 3.9333333 0.226598 3.9361111 0.227423 3.9388889 0.228247 3.9416667 0.229072 3.9444444 0.229072 3.9472222 0.225773 3.9500000 0.226598 3.9527778 0.226598 3.9555556 0.228247 3.9583333 0.228247 3.9611111 0.226598 3.9638889 0.227423 3.9666667 0.225773 3.9694444 0.229072 3.9722222 0.229072 3.9750000 0.231546 3.9777778 0.234021 3.9835556 0.300000 4.2442222 0.300000 4.2472222 0.245567 4.2500000 0.245567 4.2527778 0.246392 4.2555556 0.248041 4.2583333 0.248041 4.2611111 0.248041 4.2638889 0.245567 4.2666667 0.245567 4.2694444 0.247216 4.2722222 0.248041 4.2750000 0.249691 4.2777778 0.249691 4.2805556 0.251340 4.2833333 0.248041 4.2861111 0.250515 4.2888889 0.254639 4.2916667 0.257938 4.2944444 0.257938 4.2972222 0.257113 4.3000000 0.256289 4.3027778 0.257938 4.3055556 0.261237 4.3083333 0.262062 4.3111111 0.262887 4.3138889 0.263711 4.3166667 0.263711 4.3194444 0.264536 4.3222222 0.267010 4.3250000 0.266186 4.3277778 0.266186 4.3305556 0.262887 4.3333333 0.261237 4.3361111 0.260412 4.3388889 0.262062 4.3416667 0.264536 4.3444444 0.260412 4.3472222 0.260412 4.3500000 0.258763 4.3527778 0.261237 4.3555556 0.265361 4.3583333 0.267010 4.3611111 0.263711 4.3638889 0.257938 4.3666667 0.254639 4.3694444 0.252990 4.3722222 0.250515 4.3750000 0.249691 4.3777778 0.247216 4.3805556 0.245567 4.3833333 0.246392 4.3861111 0.247216 4.3888889 0.245567 4.3916667 0.245567 4.3944444 0.244742 4.3972222 0.243918 4.4000000 0.243093 4.4027778 0.243918 4.4055556 0.244742 4.4083333 0.247216 4.4111111 0.246392 4.4138889 0.244742 4.4166667 0.243093 4.4194444 0.243093 4.4222222 0.243093 4.4250000 0.244742 4.4277778 0.243918 4.4305556 0.243093 4.4333333 0.241443 4.4361111 0.243918 4.4388889 0.243918 4.4416667 0.243918 4.4444444 0.243918 4.4472222 0.243093 4.4500000 0.241443 4.4527778 0.239794 4.4555556 0.238969 4.4583333 0.233196 4.4611111 0.226598 4.4638889 0.220825 4.4666667 0.218351 4.4694444 0.214227 4.4722222 0.211753 4.4750000 0.216701 4.4777778 0.231546 4.4805556 0.253814 4.4833333 0.277732 4.4861111 0.310722 4.4888889 0.349485 4.4916667 0.395670 4.4944444 0.433608 4.4972222 0.455876 4.5000000 0.451753 4.5027778 0.427835 4.5055556 0.373402 4.5083333 0.303299 4.5111111 0.251340 4.5138889 0.226598 4.5166667 0.222474 4.5194444 0.229897 4.5222222 0.237320 4.5250000 0.240619 4.5277778 0.240619 4.5305556 0.238969 4.5333333 0.237320 4.5361111 0.237320 4.5388889 0.238144 4.5416667 0.238969 4.5444444 0.239794 4.5472222 0.238969 4.5500000 0.236495 4.5527778 0.236495 4.5555556 0.238144 4.5583333 0.238969 4.5611111 0.238969 4.5638889 0.236495 4.5666667 0.234845 4.5694444 0.236495 4.5722222 0.236495 4.5750000 0.235670 4.5777778 0.236495 4.5805556 0.234845 4.5833333 0.232371 4.5861111 0.234021 4.5888889 0.234845 4.5916667 0.237320 4.5944444 0.234845 4.5972222 0.234845 4.6000000 0.234021 4.6027778 0.234021 4.6055556 0.234845 4.6083333 0.235670 4.6111111 0.235670 4.6138889 0.234845 4.6166667 0.233196 4.6194444 0.235670 4.6222222 0.236495 4.6250000 0.238144 4.6277778 0.238144 4.6305556 0.237320 4.6333333 0.235670 4.6361111 0.236495 4.6388889 0.238969 4.6416667 0.238969 4.6444444 0.238969 4.6472222 0.238144 4.6500000 0.236495 4.6527778 0.238969 4.6555556 0.235670 4.6583333 0.238144 4.6611111 0.238969 4.6638889 0.237320 4.6666667 0.235670 4.6694444 0.235670 4.6722222 0.236495 4.6750000 0.238144 4.6777778 0.238144 4.6805556 0.236495 4.6833333 0.234845 4.6861111 0.235670 4.6888889 0.236495 4.6916667 0.238144 4.6944444 0.237320 4.6972222 0.236495 4.7000000 0.235670 4.7027778 0.237320 4.7055556 0.237320 4.7083333 0.238969 4.7111111 0.238969 4.7138889 0.239794 4.7166667 0.235670 4.7194444 0.239794 4.7222222 0.239794 4.7250000 0.240619 4.7277778 0.238144 4.7305556 0.237320 4.7333333 0.234021 4.7361111 0.235670 4.7388889 0.238144 4.7416667 0.238144 4.7444444 0.238969 4.7472222 0.236495 4.7500000 0.235670 4.7527778 0.235670 4.7555556 0.235670 4.7583333 0.235670 4.7611111 0.238144 4.7638889 0.236495 4.7666667 0.234845 4.7694444 0.237320 4.7722222 0.238969 4.7750000 0.238144 4.7777778 0.238144 4.7805556 0.235670 4.7833333 0.233196 4.7861111 0.238144 4.7888889 0.238969 4.7916667 0.240619 4.7944444 0.238144 4.8002222 0.300000 4.8970000 0.300000 4.9000000 0.251340 4.9027778 0.252990 4.9055556 0.253814 4.9083333 0.254639 4.9111111 0.253814 4.9138889 0.252165 4.9166667 0.248866 4.9194444 0.249691 4.9222222 0.252990 4.9250000 0.255464 4.9277778 0.255464 4.9305556 0.254639 4.9333333 0.252990 4.9361111 0.252990 4.9388889 0.255464 4.9416667 0.256289 4.9444444 0.256289 4.9472222 0.256289 4.9500000 0.253814 4.9527778 0.256289 4.9555556 0.259588 4.9583333 0.261237 4.9611111 0.261237 4.9638889 0.258763 4.9666667 0.258763 4.9694444 0.259588 4.9722222 0.264536 4.9750000 0.263711 4.9777778 0.259588 4.9805556 0.257938 4.9833333 0.262062 4.9861111 0.266186 4.9888889 0.265361 4.9916667 0.263711 4.9944444 0.262062 4.9972222 0.260412 5.0000000 0.260412 5.0027778 0.259588 5.0055556 0.258763 5.0083333 0.255464 5.0111111 0.252990 5.0138889 0.248041 5.0166667 0.247216 5.0194444 0.247216 5.0222222 0.248866 5.0250000 0.245567 5.0277778 0.243918 5.0305556 0.243093 5.0333333 0.240619 5.0361111 0.239794 5.0388889 0.240619 5.0416667 0.242268 5.0444444 0.241443 5.0472222 0.238144 5.0500000 0.236495 5.0527778 0.238144 5.0555556 0.238969 5.0583333 0.239794 5.0611111 0.239794 5.0638889 0.238969 5.0666667 0.237320 5.0694444 0.240619 5.0722222 0.242268 5.0750000 0.241443 5.0777778 0.241443 5.0805556 0.242268 5.0833333 0.239794 5.0861111 0.242268 5.0888889 0.242268 5.0916667 0.243918 5.0944444 0.241443 5.0972222 0.242268 5.1000000 0.238144 5.1027778 0.239794 5.1055556 0.238144 5.1083333 0.234021 5.1111111 0.229072 5.1138889 0.221649 5.1166667 0.214227 5.1194444 0.214227 5.1222222 0.209278 5.1250000 0.205979 5.1277778 0.210928 5.1305556 0.226598 5.1333333 0.249691 5.1361111 0.276907 5.1388889 0.304124 5.1416667 0.342887 5.1444444 0.384124 5.1472222 0.421237 5.1500000 0.439381 5.1527778 0.444330 5.1555556 0.421237 5.1583333 0.365979 5.1611111 0.295876 5.1638889 0.244742 5.1666667 0.220825 5.1694444 0.222474 5.1722222 0.231546 5.1750000 0.238144 5.1777778 0.239794 5.1805556 0.236495 5.1833333 0.234021 5.1861111 0.237320 5.1888889 0.235670 5.1916667 0.238144 5.1944444 0.236495 5.1972222 0.234845 5.2000000 0.233196 5.2027778 0.235670 5.2055556 0.237320 5.2083333 0.236495 5.2111111 0.236495 5.2138889 0.234845 5.2166667 0.234021 5.2194444 0.233196 5.2222222 0.234021 5.2250000 0.235670 5.2277778 0.235670 5.2305556 0.234845 5.2333333 0.234021 5.2361111 0.235670 5.2388889 0.236495 5.2416667 0.235670 5.2444444 0.236495 5.2472222 0.232371 5.2500000 0.230722 5.2527778 0.233196 5.2555556 0.232371 5.2583333 0.235670 5.2611111 0.235670 5.2638889 0.235670 5.2666667 0.234021 5.2694444 0.234021 5.2722222 0.235670 5.2750000 0.238144 5.2777778 0.237320 5.2805556 0.234845 5.2833333 0.234021 5.2861111 0.235670 5.2888889 0.234021 5.2916667 0.235670 5.2944444 0.234845 5.2972222 0.232371 5.3000000 0.231546 5.3027778 0.233196 5.3055556 0.236495 5.3083333 0.236495 5.3111111 0.237320 5.3138889 0.234021 5.3166667 0.234021 5.3194444 0.234845 5.3222222 0.235670 5.3250000 0.237320 5.3277778 0.238144 5.3305556 0.234845 5.3333333 0.234845 5.3361111 0.236495 5.3388889 0.237320 5.3416667 0.238144 5.3444444 0.236495 5.3472222 0.235670 5.3500000 0.234021 5.3527778 0.234021 5.3555556 0.236495 5.3583333 0.237320 5.3611111 0.234845 5.3638889 0.235670 5.3666667 0.234021 5.3694444 0.234845 5.3722222 0.236495 5.3750000 0.237320 5.3777778 0.236495 5.3805556 0.234845 5.3833333 0.233196 5.3861111 0.234021 5.3888889 0.235670 5.3916667 0.237320 5.3944444 0.237320 5.3972222 0.236495 5.4000000 0.233196 5.4027778 0.234845 5.4055556 0.234021 5.4083333 0.235670 5.4111111 0.234021 5.4138889 0.233196 5.4166667 0.229897 5.4194444 0.230722 5.4222222 0.233196 5.4250000 0.234021 5.4277778 0.233196 5.4305556 0.233196 5.4333333 0.231546 5.4361111 0.234021 5.4388889 0.235670 5.4416667 0.237320 5.4444444 0.236495 5.4472222 0.234845 5.4530000 0.300000 5.8914444 0.300000 5.8944444 0.243093 5.8972222 0.241443 5.9000000 0.240619 5.9027778 0.240619 5.9055556 0.239794 5.9083333 0.243093 5.9111111 0.241443 5.9138889 0.242268 5.9166667 0.240619 5.9194444 0.241443 5.9222222 0.240619 5.9250000 0.243093 5.9277778 0.244742 5.9305556 0.245567 5.9333333 0.245567 5.9361111 0.248866 5.9388889 0.249691 5.9416667 0.250515 5.9444444 0.249691 5.9472222 0.251340 5.9500000 0.249691 5.9527778 0.252990 5.9555556 0.254639 5.9583333 0.256289 5.9611111 0.257938 5.9638889 0.257938 5.9666667 0.257113 5.9694444 0.256289 5.9722222 0.257938 5.9750000 0.257938 5.9777778 0.257113 5.9805556 0.253814 5.9833333 0.252165 5.9861111 0.253814 5.9888889 0.255464 5.9916667 0.257938 5.9944444 0.254639 5.9972222 0.252165 6.0000000 0.247216 6.0027778 0.250515 6.0055556 0.251340 6.0083333 0.255464 6.0111111 0.256289 6.0138889 0.255464 6.0166667 0.252990 6.0194444 0.250515 6.0222222 0.248866 6.0250000 0.248041 6.0277778 0.247216 6.0305556 0.242268 6.0333333 0.238969 6.0361111 0.239794 6.0388889 0.239794 6.0416667 0.239794 6.0444444 0.238969 6.0472222 0.238969 6.0500000 0.238969 6.0527778 0.237320 6.0555556 0.240619 6.0583333 0.238144 6.0611111 0.238144 6.0638889 0.234021 6.0666667 0.230722 6.0694444 0.233196 6.0722222 0.234021 6.0750000 0.236495 6.0777778 0.237320 6.0805556 0.234021 6.0833333 0.231546 6.0861111 0.233196 6.0888889 0.234845 6.0916667 0.234845 6.0944444 0.234845 6.0972222 0.232371 6.1000000 0.229072 6.1027778 0.227423 6.1055556 0.224948 6.1083333 0.219175 6.1111111 0.220000 6.1138889 0.214227 6.1166667 0.205979 6.1194444 0.205155 6.1222222 0.213402 6.1250000 0.230722 6.1277778 0.249691 6.1305556 0.268660 6.1333333 0.296701 6.1361111 0.336289 6.1388889 0.380000 6.1416667 0.417938 6.1444444 0.439381 6.1472222 0.445979 6.1500000 0.430309 6.1527778 0.392371 6.1555556 0.337113 6.1583333 0.288454 6.1611111 0.252990 6.1638889 0.229897 6.1666667 0.217526 6.1694444 0.209278 6.1722222 0.211753 6.1750000 0.217526 6.1777778 0.223299 6.1805556 0.225773 6.1833333 0.225773 6.1861111 0.228247 6.1888889 0.230722 6.1916667 0.232371 6.1944444 0.232371 6.1972222 0.231546 6.2000000 0.230722 6.2027778 0.229897 6.2055556 0.230722 6.2083333 0.229072 6.2111111 0.229072 6.2138889 0.227423 6.2166667 0.225773 6.2194444 0.225773 6.2222222 0.229072 6.2250000 0.229072 6.2277778 0.229072 6.2305556 0.226598 6.2333333 0.226598 6.2361111 0.227423 6.2388889 0.229897 6.2416667 0.229072 6.2444444 0.229072 6.2472222 0.229897 6.2500000 0.226598 6.2527778 0.226598 6.2555556 0.229072 6.2583333 0.228247 6.2611111 0.228247 6.2638889 0.226598 6.2666667 0.226598 6.2694444 0.228247 6.2722222 0.229072 6.2750000 0.229897 6.2777778 0.229072 6.2805556 0.229072 6.2833333 0.227423 6.2861111 0.230722 6.2888889 0.229072 6.2916667 0.229897 6.2944444 0.229072 6.2972222 0.227423 6.3000000 0.227423 6.3027778 0.229072 6.3055556 0.229072 6.3083333 0.231546 6.3111111 0.229897 6.3138889 0.229072 6.3166667 0.224948 6.3194444 0.226598 6.3222222 0.226598 6.3250000 0.229072 6.3277778 0.229072 6.3305556 0.227423 6.3333333 0.227423 6.3361111 0.228247 6.3388889 0.229072 6.3416667 0.231546 6.3444444 0.231546 6.3472222 0.229897 6.3500000 0.229897 6.3527778 0.230722 6.3555556 0.233196 6.3583333 0.233196 6.3611111 0.231546 6.3638889 0.231546 6.3666667 0.229897 6.3694444 0.229072 6.3722222 0.233196 6.3750000 0.233196 6.3777778 0.233196 6.3805556 0.233196 6.3833333 0.229072 6.3861111 0.231546 6.3888889 0.232371 6.3916667 0.231546 6.3944444 0.229072 6.3972222 0.226598 6.4000000 0.223299 6.4027778 0.224124 6.4055556 0.225773 6.4083333 0.224948 6.4111111 0.224124 6.4138889 0.223299 6.4166667 0.220000 6.4194444 0.218351 6.4222222 0.221649 6.4250000 0.219175 6.4277778 0.217526 6.4305556 0.218351 6.4333333 0.215052 6.4361111 0.217526 6.4388889 0.220000 6.4416667 0.219175 6.4474444 0.300000 6.7358889 0.300000 6.7388889 0.241443 6.7416667 0.243918 6.7444444 0.243093 6.7472222 0.241443 6.7500000 0.241443 6.7527778 0.241443 6.7555556 0.243918 6.7583333 0.243918 6.7611111 0.243093 6.7638889 0.239794 6.7666667 0.238969 6.7694444 0.242268 6.7722222 0.245567 6.7750000 0.247216 6.7777778 0.248041 6.7805556 0.251340 6.7833333 0.249691 6.7861111 0.251340 6.7888889 0.250515 6.7916667 0.252990 6.7944444 0.254639 6.7972222 0.257113 6.8000000 0.254639 6.8027778 0.256289 6.8055556 0.257113 6.8083333 0.258763 6.8111111 0.259588 6.8138889 0.257938 6.8166667 0.256289 6.8194444 0.257113 6.8222222 0.257113 6.8250000 0.258763 6.8277778 0.257113 6.8305556 0.253814 6.8333333 0.253814 6.8361111 0.254639 6.8388889 0.252990 6.8416667 0.253814 6.8444444 0.257938 6.8472222 0.259588 6.8500000 0.259588 6.8527778 0.257113 6.8555556 0.252990 6.8583333 0.252165 6.8611111 0.250515 6.8638889 0.247216 6.8666667 0.244742 6.8694444 0.241443 6.8722222 0.242268 6.8750000 0.241443 6.8777778 0.241443 6.8805556 0.238144 6.8833333 0.236495 6.8861111 0.237320 6.8888889 0.240619 6.8916667 0.242268 6.8944444 0.240619 6.8972222 0.239794 6.9000000 0.238969 6.9027778 0.238969 6.9055556 0.239794 6.9083333 0.240619 6.9111111 0.239794 6.9138889 0.238969 6.9166667 0.236495 6.9194444 0.236495 6.9222222 0.239794 6.9250000 0.240619 6.9277778 0.237320 6.9305556 0.236495 6.9333333 0.234845 6.9361111 0.234845 6.9388889 0.236495 6.9416667 0.237320 6.9444444 0.234845 6.9472222 0.229897 6.9500000 0.223299 6.9527778 0.217526 6.9555556 0.215052 6.9583333 0.212577 6.9611111 0.207629 6.9638889 0.203505 6.9666667 0.212577 6.9694444 0.232371 6.9722222 0.257938 6.9750000 0.282680 6.9777778 0.317320 6.9805556 0.358557 6.9833333 0.398969 6.9861111 0.433608 6.9888889 0.446804 6.9916667 0.436907 6.9944444 0.395670 6.9972222 0.330515 7.0000000 0.266186 7.0027778 0.225773 7.0055556 0.213402 7.0083333 0.218351 7.0111111 0.223299 7.0138889 0.228247 7.0166667 0.231546 7.0194444 0.231546 7.0222222 0.231546 7.0250000 0.234021 7.0277778 0.234845 7.0305556 0.233196 7.0333333 0.229897 7.0361111 0.228247 7.0388889 0.231546 7.0416667 0.231546 7.0444444 0.231546 7.0472222 0.231546 7.0500000 0.229072 7.0527778 0.230722 7.0555556 0.232371 7.0583333 0.233196 7.0611111 0.230722 7.0638889 0.232371 7.0666667 0.230722 7.0694444 0.234021 7.0722222 0.234845 7.0750000 0.236495 7.0777778 0.234021 7.0805556 0.234021 7.0833333 0.234021 7.0861111 0.234021 7.0888889 0.234845 7.0916667 0.234021 7.0944444 0.234021 7.0972222 0.234021 7.1000000 0.232371 7.1027778 0.234845 7.1055556 0.232371 7.1083333 0.234021 7.1111111 0.234845 7.1138889 0.233196 7.1166667 0.232371 7.1194444 0.231546 7.1222222 0.233196 7.1250000 0.234021 7.1277778 0.234845 7.1305556 0.233196 7.1333333 0.231546 7.1361111 0.233196 7.1388889 0.231546 7.1416667 0.232371 7.1444444 0.233196 7.1472222 0.233196 7.1500000 0.232371 7.1527778 0.233196 7.1555556 0.234021 7.1583333 0.234845 7.1611111 0.233196 7.1638889 0.233196 7.1666667 0.234021 7.1694444 0.234845 7.1722222 0.235670 7.1750000 0.234845 7.1777778 0.235670 7.1805556 0.234845 7.1833333 0.230722 7.1861111 0.231546 7.1888889 0.233196 7.1916667 0.234021 7.1944444 0.234021 7.1972222 0.231546 7.2000000 0.230722 7.2027778 0.232371 7.2055556 0.234845 7.2083333 0.234021 7.2111111 0.233196 7.2138889 0.231546 7.2166667 0.228247 7.2194444 0.231546 7.2222222 0.231546 7.2250000 0.234021 7.2277778 0.233196 7.2305556 0.230722 7.2333333 0.229072 7.2361111 0.229897 7.2388889 0.232371 7.2416667 0.232371 7.2444444 0.233196 7.2472222 0.231546 7.2500000 0.229897 7.2527778 0.229897 7.2555556 0.230722 7.2583333 0.232371 7.2611111 0.232371 7.2638889 0.230722 7.2666667 0.229072 7.2694444 0.229897 7.2722222 0.230722 7.2750000 0.233196 7.2777778 0.231546 7.2805556 0.232371 7.2833333 0.232371 7.2861111 0.236495 7.2918889 0.300000 7.5470000 0.300000 7.5500000 0.244742 7.5527778 0.247216 7.5555556 0.246392 7.5583333 0.248041 7.5611111 0.247216 7.5638889 0.247216 7.5666667 0.243093 7.5694444 0.244742 7.5722222 0.247216 7.5750000 0.248866 7.5777778 0.247216 7.5805556 0.247216 7.5833333 0.243918 7.5861111 0.245567 7.5888889 0.247216 7.5916667 0.248866 7.5944444 0.248866 7.5972222 0.248866 7.6000000 0.251340 7.6027778 0.253814 7.6055556 0.257938 7.6083333 0.258763 7.6111111 0.258763 7.6138889 0.257938 7.6166667 0.257113 7.6194444 0.260412 7.6222222 0.263711 7.6250000 0.262062 7.6277778 0.262062 7.6305556 0.264536 7.6333333 0.263711 7.6361111 0.262887 7.6388889 0.262062 7.6416667 0.262062 7.6444444 0.261237 7.6472222 0.259588 7.6500000 0.257938 7.6527778 0.260412 7.6555556 0.261237 7.6583333 0.259588 7.6611111 0.261237 7.6638889 0.262062 7.6666667 0.263711 7.6694444 0.267835 7.6722222 0.263711 7.6750000 0.259588 7.6777778 0.257113 7.6805556 0.255464 7.6833333 0.252165 7.6861111 0.250515 7.6888889 0.249691 7.6916667 0.249691 7.6944444 0.247216 7.6972222 0.245567 7.7000000 0.242268 7.7027778 0.242268 7.7055556 0.244742 7.7083333 0.244742 7.7111111 0.244742 7.7138889 0.243918 7.7166667 0.242268 7.7194444 0.242268 7.7222222 0.243093 7.7250000 0.244742 7.7277778 0.243093 7.7305556 0.241443 7.7333333 0.238969 7.7361111 0.242268 7.7388889 0.243093 7.7416667 0.244742 7.7444444 0.244742 7.7472222 0.244742 7.7500000 0.241443 7.7527778 0.241443 7.7555556 0.243093 7.7583333 0.241443 7.7611111 0.234845 7.7638889 0.225773 7.7666667 0.220825 7.7694444 0.216701 7.7722222 0.213402 7.7750000 0.210103 7.7777778 0.217526 7.7805556 0.234845 7.7833333 0.257938 7.7861111 0.288454 7.7888889 0.323918 7.7916667 0.370103 7.7944444 0.412990 7.7972222 0.444330 7.8000000 0.452577 7.8027778 0.431134 7.8055556 0.377526 7.8083333 0.303299 7.8111111 0.246392 7.8138889 0.222474 7.8166667 0.220000 7.8194444 0.232371 7.8222222 0.239794 7.8250000 0.241443 7.8277778 0.239794 7.8305556 0.237320 7.8333333 0.236495 7.8361111 0.237320 7.8388889 0.238969 7.8416667 0.238969 7.8444444 0.238144 7.8472222 0.236495 7.8500000 0.234845 7.8527778 0.236495 7.8555556 0.237320 7.8583333 0.236495 7.8611111 0.238144 7.8638889 0.235670 7.8666667 0.233196 7.8694444 0.233196 7.8722222 0.235670 7.8750000 0.236495 7.8777778 0.236495 7.8805556 0.235670 7.8833333 0.232371 7.8861111 0.234021 7.8888889 0.235670 7.8916667 0.236495 7.8944444 0.236495 7.8972222 0.234845 7.9000000 0.235670 7.9027778 0.234845 7.9055556 0.237320 7.9083333 0.238144 7.9111111 0.237320 7.9138889 0.236495 7.9166667 0.234021 7.9194444 0.236495 7.9222222 0.237320 7.9250000 0.238144 7.9277778 0.237320 7.9305556 0.234845 7.9333333 0.234845 7.9361111 0.236495 7.9388889 0.238144 7.9416667 0.238969 7.9444444 0.239794 7.9472222 0.236495 7.9500000 0.234845 7.9527778 0.236495 7.9555556 0.236495 7.9583333 0.238969 7.9611111 0.238144 7.9638889 0.238969 7.9666667 0.238144 7.9694444 0.238144 7.9722222 0.238969 7.9750000 0.241443 7.9777778 0.239794 7.9805556 0.237320 7.9833333 0.238144 7.9861111 0.238969 7.9888889 0.237320 7.9916667 0.239794 7.9944444 0.238969 7.9972222 0.238144 8.0000000 0.235670 8.0027778 0.237320 8.0055556 0.238144 8.0083333 0.237320 8.0111111 0.238969 8.0138889 0.238144 8.0166667 0.237320 8.0194444 0.236495 8.0222222 0.236495 8.0250000 0.238969 8.0277778 0.238144 8.0305556 0.238144 8.0333333 0.237320 8.0361111 0.237320 8.0388889 0.237320 8.0416667 0.237320 8.0444444 0.238144 8.0472222 0.235670 8.0500000 0.234845 8.0527778 0.236495 8.0555556 0.236495 8.0583333 0.238144 8.0611111 0.238144 8.0638889 0.236495 8.0666667 0.236495 8.0694444 0.235670 8.0722222 0.238969 8.0750000 0.239794 8.0777778 0.239794 8.0805556 0.238144 8.0833333 0.236495 8.0861111 0.242268 8.0888889 0.243093 8.0916667 0.246392 8.0944444 0.246392 8.0972222 0.245567 8.1030000 0.300000 8.3358889 0.300000 8.3388889 0.249691 8.3416667 0.252165 8.3444444 0.252990 8.3472222 0.252165 8.3500000 0.249691 8.3527778 0.248866 8.3555556 0.250515 8.3583333 0.250515 8.3611111 0.248866 8.3638889 0.248041 8.3666667 0.248041 8.3694444 0.248866 8.3722222 0.251340 8.3750000 0.250515 8.3777778 0.251340 8.3805556 0.248041 8.3833333 0.248866 8.3861111 0.252165 8.3888889 0.256289 8.3916667 0.260412 8.3944444 0.257938 8.3972222 0.260412 8.4000000 0.258763 8.4027778 0.262887 8.4055556 0.262887 8.4083333 0.264536 8.4111111 0.265361 8.4138889 0.267010 8.4166667 0.267835 8.4194444 0.267835 8.4222222 0.270309 8.4250000 0.271134 8.4277778 0.270309 8.4305556 0.266186 8.4333333 0.264536 8.4361111 0.265361 8.4388889 0.265361 8.4416667 0.265361 8.4444444 0.265361 8.4472222 0.264536 8.4500000 0.262887 8.4527778 0.265361 8.4555556 0.270309 8.4583333 0.271959 8.4611111 0.269485 8.4638889 0.260412 8.4666667 0.257938 8.4694444 0.257938 8.4722222 0.255464 8.4750000 0.254639 8.4777778 0.252990 8.4805556 0.250515 8.4833333 0.250515 8.4861111 0.248041 8.4888889 0.249691 8.4916667 0.250515 8.4944444 0.251340 8.4972222 0.250515 8.5000000 0.248041 8.5027778 0.248866 8.5055556 0.248866 8.5083333 0.250515 8.5111111 0.250515 8.5138889 0.249691 8.5166667 0.248041 8.5194444 0.246392 8.5222222 0.247216 8.5250000 0.247216 8.5277778 0.247216 8.5305556 0.246392 8.5333333 0.243918 8.5361111 0.244742 8.5388889 0.246392 8.5416667 0.248041 8.5444444 0.247216 8.5472222 0.243093 8.5500000 0.238969 8.5527778 0.234845 8.5555556 0.229897 8.5583333 0.226598 8.5611111 0.223299 8.5638889 0.215876 8.5666667 0.212577 8.5694444 0.220000 8.5722222 0.238969 8.5750000 0.261237 8.5777778 0.285155 8.5805556 0.317320 8.5833333 0.361856 8.5861111 0.408041 8.5888889 0.435258 8.5916667 0.442680 8.5944444 0.421237 8.5972222 0.374227 8.6000000 0.309897 8.6027778 0.255464 8.6055556 0.229072 8.6083333 0.224124 8.6111111 0.231546 8.6138889 0.236495 8.6166667 0.239794 8.6194444 0.241443 8.6222222 0.241443 8.6250000 0.243093 8.6277778 0.242268 8.6305556 0.242268 8.6333333 0.240619 8.6361111 0.243093 8.6388889 0.243918 8.6416667 0.243918 8.6444444 0.244742 8.6472222 0.244742 8.6500000 0.241443 8.6527778 0.243093 8.6555556 0.243918 8.6583333 0.244742 8.6611111 0.243918 8.6638889 0.242268 8.6666667 0.239794 8.6694444 0.240619 8.6722222 0.239794 8.6750000 0.242268 8.6777778 0.243093 8.6805556 0.239794 8.6833333 0.240619 8.6861111 0.242268 8.6888889 0.241443 8.6916667 0.242268 8.6944444 0.241443 8.6972222 0.242268 8.7000000 0.240619 8.7027778 0.244742 8.7055556 0.244742 8.7083333 0.245567 8.7111111 0.243918 8.7138889 0.242268 8.7166667 0.242268 8.7194444 0.243093 8.7222222 0.244742 8.7250000 0.243093 8.7277778 0.241443 8.7305556 0.241443 8.7333333 0.238969 8.7361111 0.241443 8.7388889 0.242268 8.7416667 0.243093 8.7444444 0.239794 8.7472222 0.239794 8.7500000 0.238969 8.7527778 0.239794 8.7555556 0.241443 8.7583333 0.243093 8.7611111 0.243093 8.7638889 0.243093 8.7666667 0.243918 8.7694444 0.244742 8.7722222 0.246392 8.7750000 0.244742 8.7777778 0.243093 8.7805556 0.242268 8.7833333 0.242268 8.7861111 0.241443 8.7888889 0.241443 8.7916667 0.240619 8.7944444 0.242268 8.7972222 0.240619 8.8000000 0.239794 8.8027778 0.243093 8.8055556 0.243093 8.8083333 0.245567 8.8111111 0.242268 8.8138889 0.243093 8.8166667 0.241443 8.8194444 0.242268 8.8222222 0.243918 8.8250000 0.244742 8.8277778 0.242268 8.8305556 0.239794 8.8333333 0.237320 8.8361111 0.236495 8.8388889 0.241443 8.8416667 0.240619 8.8444444 0.241443 8.8472222 0.238969 8.8500000 0.236495 8.8527778 0.238969 8.8555556 0.238969 8.8583333 0.242268 8.8611111 0.243093 8.8638889 0.239794 8.8666667 0.239794 8.8694444 0.240619 8.8722222 0.243093 8.8750000 0.245567 8.8777778 0.245567 8.8805556 0.245567 8.8833333 0.244742 8.8861111 0.248041 8.8918889 0.300000 9.1081111 0.300000 9.1111111 0.249691 9.1138889 0.248866 9.1166667 0.247216 9.1194444 0.248866 9.1222222 0.250515 9.1250000 0.251340 9.1277778 0.250515 9.1305556 0.248041 9.1333333 0.246392 9.1361111 0.246392 9.1388889 0.249691 9.1416667 0.248866 9.1444444 0.252165 9.1472222 0.248041 9.1500000 0.246392 9.1527778 0.247216 9.1555556 0.252165 9.1583333 0.253814 9.1611111 0.257113 9.1638889 0.257113 9.1666667 0.256289 9.1694444 0.257113 9.1722222 0.258763 9.1750000 0.262062 9.1777778 0.263711 9.1805556 0.263711 9.1833333 0.261237 9.1861111 0.263711 9.1888889 0.266186 9.1916667 0.266186 9.1944444 0.265361 9.1972222 0.265361 9.2000000 0.262062 9.2027778 0.260412 9.2055556 0.262062 9.2083333 0.262887 9.2111111 0.261237 9.2138889 0.258763 9.2166667 0.256289 9.2194444 0.257113 9.2222222 0.259588 9.2250000 0.264536 9.2277778 0.264536 9.2305556 0.259588 9.2333333 0.253814 9.2361111 0.254639 9.2388889 0.254639 9.2416667 0.251340 9.2444444 0.248866 9.2472222 0.246392 9.2500000 0.243918 9.2527778 0.243918 9.2555556 0.246392 9.2583333 0.248041 9.2611111 0.248866 9.2638889 0.248041 9.2666667 0.245567 9.2694444 0.245567 9.2722222 0.246392 9.2750000 0.246392 9.2777778 0.244742 9.2805556 0.243093 9.2833333 0.242268 9.2861111 0.242268 9.2888889 0.242268 9.2916667 0.243093 9.2944444 0.242268 9.2972222 0.239794 9.3000000 0.240619 9.3027778 0.242268 9.3055556 0.241443 9.3083333 0.243093 9.3111111 0.243093 9.3138889 0.242268 9.3166667 0.239794 9.3194444 0.237320 9.3222222 0.233196 9.3250000 0.229897 9.3277778 0.227423 9.3305556 0.222474 9.3333333 0.214227 9.3361111 0.210928 9.3388889 0.219175 9.3416667 0.235670 9.3444444 0.257113 9.3472222 0.281031 9.3500000 0.314021 9.3527778 0.359381 9.3555556 0.401443 9.3583333 0.428660 9.3611111 0.437732 9.3638889 0.418763 9.3666667 0.367629 9.3694444 0.304948 9.3722222 0.257938 9.3750000 0.231546 9.3777778 0.222474 9.3805556 0.223299 9.3833333 0.228247 9.3861111 0.234845 9.3888889 0.238144 9.3916667 0.238969 9.3944444 0.238144 9.3972222 0.238144 9.4000000 0.235670 9.4027778 0.234021 9.4055556 0.237320 9.4083333 0.236495 9.4111111 0.236495 9.4138889 0.236495 9.4166667 0.236495 9.4194444 0.238969 9.4222222 0.238969 9.4250000 0.240619 9.4277778 0.237320 9.4305556 0.237320 9.4333333 0.236495 9.4361111 0.238969 9.4388889 0.238969 9.4416667 0.239794 9.4444444 0.238144 9.4472222 0.236495 9.4500000 0.235670 9.4527778 0.235670 9.4555556 0.236495 9.4583333 0.236495 9.4611111 0.234845 9.4638889 0.235670 9.4666667 0.234021 9.4694444 0.233196 9.4722222 0.235670 9.4750000 0.234845 9.4777778 0.235670 9.4805556 0.233196 9.4833333 0.233196 9.4861111 0.234021 9.4888889 0.238144 9.4916667 0.237320 9.4944444 0.235670 9.4972222 0.234845 9.5000000 0.234845 9.5027778 0.235670 9.5055556 0.235670 9.5083333 0.236495 9.5111111 0.233196 9.5138889 0.234021 9.5166667 0.233196 9.5194444 0.234845 9.5222222 0.235670 9.5250000 0.234845 9.5277778 0.235670 9.5305556 0.234021 9.5333333 0.233196 9.5361111 0.233196 9.5388889 0.235670 9.5416667 0.235670 9.5444444 0.234845 9.5472222 0.234021 9.5500000 0.234021 9.5527778 0.234845 9.5555556 0.237320 9.5583333 0.238969 9.5611111 0.237320 9.5638889 0.236495 9.5666667 0.234845 9.5694444 0.235670 9.5722222 0.237320 9.5750000 0.237320 9.5777778 0.236495 9.5805556 0.235670 9.5833333 0.235670 9.5861111 0.234021 9.5888889 0.234021 9.5916667 0.233196 9.5944444 0.231546 9.5972222 0.230722 9.6000000 0.229072 9.6027778 0.229072 9.6055556 0.229897 9.6083333 0.230722 9.6111111 0.229072 9.6138889 0.226598 9.6166667 0.223299 9.6194444 0.224948 9.6222222 0.227423 9.6250000 0.229897 9.6277778 0.228247 9.6305556 0.225773 9.6333333 0.227423 9.6361111 0.226598 9.6388889 0.229897 9.6416667 0.229897 9.6444444 0.229897 9.6472222 0.229072 9.6500000 0.229072 9.6527778 0.231546 9.6555556 0.231546 9.6583333 0.236495 9.6641111 0.300000 9.9470000 0.300000 9.9500000 0.247216 9.9527778 0.248041 9.9555556 0.248866 9.9583333 0.251340 9.9611111 0.251340 9.9638889 0.249691 9.9666667 0.248866 9.9694444 0.250515 9.9722222 0.253814 9.9750000 0.254639 9.9777778 0.256289 9.9805556 0.254639 9.9833333 0.254639 9.9861111 0.257113 9.9888889 0.260412 9.9916667 0.260412 9.9944444 0.261237 9.9972222 0.260412 10.0000000 0.261237 10.0027778 0.262887 10.0055556 0.264536 10.0083333 0.266186 10.0111111 0.266186 10.0138889 0.265361 10.0166667 0.264536 10.0194444 0.263711 10.0222222 0.263711 10.0250000 0.264536 10.0277778 0.263711 10.0305556 0.263711 10.0333333 0.262062 10.0361111 0.262062 10.0388889 0.260412 10.0416667 0.265361 10.0444444 0.263711 10.0472222 0.262062 10.0500000 0.257938 10.0527778 0.261237 10.0555556 0.265361 10.0583333 0.268660 10.0611111 0.266186 10.0638889 0.262887 10.0666667 0.257113 10.0694444 0.254639 10.0722222 0.253814 10.0750000 0.252990 10.0777778 0.249691 10.0805556 0.247216 10.0833333 0.248041 10.0861111 0.244742 10.0888889 0.246392 10.0916667 0.244742 10.0944444 0.247216 10.0972222 0.246392 10.1000000 0.247216 10.1027778 0.246392 10.1055556 0.246392 10.1083333 0.248866 10.1111111 0.249691 10.1138889 0.247216 10.1166667 0.247216 10.1194444 0.245567 10.1222222 0.247216 10.1250000 0.247216 10.1277778 0.245567 10.1305556 0.245567 10.1333333 0.240619 10.1361111 0.241443 10.1388889 0.245567 10.1416667 0.246392 10.1444444 0.246392 10.1472222 0.244742 10.1500000 0.242268 10.1527778 0.243918 10.1555556 0.243093 10.1583333 0.241443 10.1611111 0.236495 10.1638889 0.229897 10.1666667 0.225773 10.1694444 0.222474 10.1722222 0.220000 10.1750000 0.215876 10.1777778 0.215052 10.1805556 0.224948 10.1833333 0.246392 10.1861111 0.272784 10.1888889 0.301649 10.1916667 0.341237 10.1944444 0.384948 10.1972222 0.422062 10.2000000 0.445979 10.2027778 0.454227 10.2055556 0.437732 10.2083333 0.386598 10.2111111 0.319794 10.2138889 0.262062 10.2166667 0.229897 10.2194444 0.224948 10.2222222 0.230722 10.2250000 0.237320 10.2277778 0.240619 10.2305556 0.239794 10.2333333 0.238144 10.2361111 0.237320 10.2388889 0.241443 10.2416667 0.241443 10.2444444 0.238969 10.2472222 0.238144 10.2500000 0.236495 10.2527778 0.237320 10.2555556 0.239794 10.2583333 0.238969 10.2611111 0.238969 10.2638889 0.239794 10.2666667 0.237320 10.2694444 0.238969 10.2722222 0.238144 10.2750000 0.239794 10.2777778 0.238969 10.2805556 0.237320 10.2833333 0.238144 10.2861111 0.239794 10.2888889 0.240619 10.2916667 0.240619 10.2944444 0.241443 10.2972222 0.241443 10.3000000 0.238969 10.3027778 0.239794 10.3055556 0.241443 10.3083333 0.242268 10.3111111 0.242268 10.3138889 0.242268 10.3166667 0.240619 10.3194444 0.240619 10.3222222 0.240619 10.3250000 0.242268 10.3277778 0.241443 10.3305556 0.239794 10.3333333 0.238969 10.3361111 0.240619 10.3388889 0.242268 10.3416667 0.241443 10.3444444 0.242268 10.3472222 0.241443 10.3500000 0.238969 10.3527778 0.238144 10.3555556 0.240619 10.3583333 0.242268 10.3611111 0.243093 10.3638889 0.242268 10.3666667 0.238969 10.3694444 0.238969 10.3722222 0.241443 10.3750000 0.242268 10.3777778 0.243093 10.3805556 0.240619 10.3833333 0.238969 10.3861111 0.239794 10.3888889 0.240619 10.3916667 0.242268 10.3944444 0.241443 10.3972222 0.239794 10.4000000 0.239794 10.4027778 0.238969 10.4055556 0.239794 10.4083333 0.242268 10.4111111 0.242268 10.4138889 0.240619 10.4166667 0.240619 10.4194444 0.241443 10.4222222 0.243093 10.4250000 0.242268 10.4277778 0.243093 10.4305556 0.241443 10.4333333 0.238969 10.4361111 0.239794 10.4388889 0.241443 10.4416667 0.240619 10.4444444 0.239794 10.4472222 0.239794 10.4500000 0.237320 10.4527778 0.236495 10.4555556 0.238144 10.4583333 0.238969 10.4611111 0.238144 10.4638889 0.236495 10.4666667 0.234845 10.4694444 0.238144 10.4722222 0.236495 10.4750000 0.237320 10.4777778 0.238969 10.4805556 0.236495 10.4833333 0.236495 10.4861111 0.237320 10.4888889 0.238969 10.4916667 0.240619 10.4944444 0.242268 10.4972222 0.244742 10.5030000 0.300000 10.8025556 0.300000 10.8055556 0.251340 10.8083333 0.252990 10.8111111 0.251340 10.8138889 0.251340 10.8166667 0.248866 10.8194444 0.250515 10.8222222 0.252990 10.8250000 0.253814 10.8277778 0.254639 10.8305556 0.253814 10.8333333 0.256289 10.8361111 0.259588 10.8388889 0.262062 10.8416667 0.260412 10.8444444 0.260412 10.8472222 0.260412 10.8500000 0.259588 10.8527778 0.263711 10.8555556 0.263711 10.8583333 0.264536 10.8611111 0.267010 10.8638889 0.267010 10.8666667 0.265361 10.8694444 0.266186 10.8722222 0.267835 10.8750000 0.266186 10.8777778 0.265361 10.8805556 0.264536 10.8833333 0.262887 10.8861111 0.262887 10.8888889 0.267010 10.8916667 0.267010 10.8944444 0.265361 10.8972222 0.262887 10.9000000 0.263711 10.9027778 0.267835 10.9055556 0.270309 10.9083333 0.271134 10.9111111 0.266186 10.9138889 0.259588 10.9166667 0.256289 10.9194444 0.254639 10.9222222 0.253814 10.9250000 0.252990 10.9277778 0.250515 10.9305556 0.248866 10.9333333 0.246392 10.9361111 0.247216 10.9388889 0.246392 10.9416667 0.248866 10.9444444 0.246392 10.9472222 0.245567 10.9500000 0.243918 10.9527778 0.244742 10.9555556 0.245567 10.9583333 0.246392 10.9611111 0.247216 10.9638889 0.243918 10.9666667 0.243093 10.9694444 0.243918 10.9722222 0.245567 10.9750000 0.244742 10.9777778 0.245567 10.9805556 0.243918 10.9833333 0.243918 10.9861111 0.244742 10.9888889 0.244742 10.9916667 0.245567 10.9944444 0.244742 10.9972222 0.243093 11.0000000 0.238144 11.0027778 0.234845 11.0055556 0.229072 11.0083333 0.227423 11.0111111 0.225773 11.0138889 0.225773 11.0166667 0.221649 11.0194444 0.220825 11.0222222 0.215876 11.0250000 0.209278 11.0277778 0.205155 11.0305556 0.210103 11.0333333 0.219175 11.0361111 0.238144 11.0388889 0.258763 11.0416667 0.280206 11.0444444 0.309897 11.0472222 0.347010 11.0500000 0.386598 11.0527778 0.422062 11.0555556 0.441856 11.0583333 0.446804 11.0611111 0.420412 11.0638889 0.370103 11.0666667 0.302474 11.0694444 0.252990 11.0722222 0.228247 11.0750000 0.225773 11.0777778 0.228247 11.0805556 0.236495 11.0833333 0.237320 11.0861111 0.238969 11.0888889 0.238969 11.0916667 0.238969 11.0944444 0.240619 11.0972222 0.240619 11.1000000 0.238969 11.1027778 0.236495 11.1055556 0.239794 11.1083333 0.240619 11.1111111 0.239794 11.1138889 0.239794 11.1166667 0.238144 11.1194444 0.236495 11.1222222 0.240619 11.1250000 0.239794 11.1277778 0.241443 11.1305556 0.238144 11.1333333 0.237320 11.1361111 0.238144 11.1388889 0.241443 11.1416667 0.241443 11.1444444 0.240619 11.1472222 0.239794 11.1500000 0.237320 11.1527778 0.238969 11.1555556 0.241443 11.1583333 0.242268 11.1611111 0.241443 11.1638889 0.239794 11.1666667 0.237320 11.1694444 0.239794 11.1722222 0.241443 11.1750000 0.241443 11.1777778 0.239794 11.1805556 0.236495 11.1833333 0.235670 11.1861111 0.238144 11.1888889 0.241443 11.1916667 0.239794 11.1944444 0.240619 11.1972222 0.241443 11.2000000 0.239794 11.2027778 0.239794 11.2055556 0.241443 11.2083333 0.243093 11.2111111 0.243093 11.2138889 0.239794 11.2166667 0.240619 11.2194444 0.238144 11.2222222 0.241443 11.2250000 0.240619 11.2277778 0.239794 11.2305556 0.239794 11.2333333 0.238969 11.2361111 0.240619 11.2388889 0.241443 11.2416667 0.240619 11.2444444 0.239794 11.2472222 0.236495 11.2500000 0.237320 11.2527778 0.239794 11.2555556 0.241443 11.2583333 0.244742 11.2611111 0.240619 11.2638889 0.240619 11.2666667 0.236495 11.2694444 0.237320 11.2722222 0.238144 11.2750000 0.240619 11.2777778 0.240619 11.2805556 0.239794 11.2833333 0.238144 11.2861111 0.239794 11.2888889 0.241443 11.2916667 0.240619 11.2944444 0.242268 11.2972222 0.240619 11.3000000 0.238969 11.3027778 0.238969 11.3055556 0.239794 11.3083333 0.238969 11.3111111 0.237320 11.3138889 0.235670 11.3166667 0.236495 11.3194444 0.237320 11.3222222 0.238969 11.3250000 0.238969 11.3277778 0.239794 11.3305556 0.239794 11.3333333 0.235670 11.3361111 0.238144 11.3388889 0.238969 11.3416667 0.241443 11.3444444 0.239794 11.3472222 0.240619 11.3500000 0.238969 11.3527778 0.242268 11.3585556 0.300000 11.6247778 0.300000 11.6277778 0.248041 11.6305556 0.244742 11.6333333 0.244742 11.6361111 0.245567 11.6388889 0.248866 11.6416667 0.248866 11.6444444 0.248041 11.6472222 0.245567 11.6500000 0.247216 11.6527778 0.248041 11.6555556 0.250515 11.6583333 0.252990 11.6611111 0.253814 11.6638889 0.256289 11.6666667 0.257113 11.6694444 0.256289 11.6722222 0.257113 11.6750000 0.257938 11.6777778 0.257113 11.6805556 0.258763 11.6833333 0.257938 11.6861111 0.260412 11.6888889 0.262062 11.6916667 0.266186 11.6944444 0.265361 11.6972222 0.262887 11.7000000 0.261237 11.7027778 0.262887 11.7055556 0.262887 11.7083333 0.262062 11.7111111 0.262887 11.7138889 0.260412 11.7166667 0.260412 11.7194444 0.262062 11.7222222 0.261237 11.7250000 0.258763 11.7277778 0.258763 11.7305556 0.257938 11.7333333 0.261237 11.7361111 0.263711 11.7388889 0.266186 11.7416667 0.264536 11.7444444 0.260412 11.7472222 0.256289 11.7500000 0.253814 11.7527778 0.253814 11.7555556 0.255464 11.7583333 0.255464 11.7611111 0.252165 11.7638889 0.247216 11.7666667 0.244742 11.7694444 0.243918 11.7722222 0.245567 11.7750000 0.245567 11.7777778 0.244742 11.7805556 0.242268 11.7833333 0.240619 11.7861111 0.242268 11.7888889 0.242268 11.7916667 0.243093 11.7944444 0.242268 11.7972222 0.241443 11.8000000 0.239794 11.8027778 0.240619 11.8055556 0.241443 11.8083333 0.242268 11.8111111 0.243918 11.8138889 0.240619 11.8166667 0.238969 11.8194444 0.238969 11.8222222 0.241443 11.8250000 0.243093 11.8277778 0.242268 11.8305556 0.238969 11.8333333 0.236495 11.8361111 0.232371 11.8388889 0.227423 11.8416667 0.224124 11.8444444 0.219175 11.8472222 0.210928 11.8500000 0.206804 11.8527778 0.209278 11.8555556 0.220000 11.8583333 0.239794 11.8611111 0.257938 11.8638889 0.279381 11.8666667 0.314845 11.8694444 0.359381 11.8722222 0.398969 11.8750000 0.423711 11.8777778 0.431134 11.8805556 0.415464 11.8833333 0.372577 11.8861111 0.315670 11.8888889 0.269485 11.8916667 0.238969 11.8944444 0.222474 11.8972222 0.219175 11.9000000 0.222474 11.9027778 0.227423 11.9055556 0.229897 11.9083333 0.232371 11.9111111 0.232371 11.9138889 0.232371 11.9166667 0.230722 11.9194444 0.234021 11.9222222 0.234845 11.9250000 0.233196 11.9277778 0.232371 11.9305556 0.233196 11.9333333 0.230722 11.9361111 0.234845 11.9388889 0.234845 11.9416667 0.235670 11.9444444 0.234845 11.9472222 0.234845 11.9500000 0.232371 11.9527778 0.234021 11.9555556 0.234021 11.9583333 0.232371 11.9611111 0.234021 11.9638889 0.233196 11.9666667 0.232371 11.9694444 0.232371 11.9722222 0.234021 11.9750000 0.235670 11.9777778 0.235670 11.9805556 0.234021 11.9833333 0.234021 11.9861111 0.234845 11.9888889 0.235670 11.9916667 0.236495 11.9944444 0.235670 11.9972222 0.232371 12.0000000 0.232371 12.0027778 0.232371 12.0055556 0.231546 12.0083333 0.232371 12.0111111 0.233196 12.0138889 0.230722 12.0166667 0.230722 12.0194444 0.230722 12.0222222 0.231546 12.0250000 0.232371 12.0277778 0.231546 12.0305556 0.229897 12.0333333 0.229897 12.0361111 0.230722 12.0388889 0.229897 12.0416667 0.230722 12.0444444 0.232371 12.0472222 0.232371 12.0500000 0.231546 12.0527778 0.232371 12.0555556 0.232371 12.0583333 0.234021 12.0611111 0.233196 12.0638889 0.233196 12.0666667 0.229897 12.0694444 0.230722 12.0722222 0.232371 12.0750000 0.234021 12.0777778 0.233196 12.0805556 0.231546 12.0833333 0.230722 12.0861111 0.232371 12.0888889 0.232371 12.0916667 0.234021 12.0944444 0.232371 12.0972222 0.231546 12.1000000 0.230722 12.1027778 0.232371 12.1055556 0.234021 12.1083333 0.235670 12.1111111 0.234021 12.1138889 0.231546 12.1166667 0.230722 12.1194444 0.231546 12.1222222 0.231546 12.1250000 0.234021 12.1277778 0.231546 12.1305556 0.229072 12.1333333 0.225773 12.1361111 0.227423 12.1388889 0.227423 12.1416667 0.228247 12.1444444 0.228247 12.1472222 0.227423 12.1500000 0.225773 12.1527778 0.228247 12.1555556 0.227423 12.1583333 0.229072 12.1611111 0.227423 12.1638889 0.226598 12.1666667 0.226598 12.1694444 0.227423 12.1722222 0.228247 12.1750000 0.230722 12.1807778 0.300000 12.4525556 0.300000 12.4555556 0.242268 12.4583333 0.244742 12.4611111 0.243093 12.4638889 0.242268 12.4666667 0.242268 12.4694444 0.241443 12.4722222 0.243918 12.4750000 0.244742 12.4777778 0.245567 12.4805556 0.243918 12.4833333 0.241443 12.4861111 0.241443 12.4888889 0.245567 12.4916667 0.248041 12.4944444 0.248041 12.4972222 0.248041 12.5000000 0.247216 12.5027778 0.250515 12.5055556 0.250515 12.5083333 0.253814 12.5111111 0.256289 12.5138889 0.253814 12.5166667 0.252990 12.5194444 0.256289 12.5222222 0.261237 12.5250000 0.262062 12.5277778 0.262062 12.5305556 0.259588 12.5333333 0.257938 12.5361111 0.258763 12.5388889 0.259588 12.5416667 0.258763 12.5444444 0.257938 12.5472222 0.256289 12.5500000 0.255464 12.5527778 0.252165 12.5555556 0.253814 12.5583333 0.254639 12.5611111 0.257113 12.5638889 0.257938 12.5666667 0.257113 12.5694444 0.254639 12.5722222 0.251340 12.5750000 0.250515 12.5777778 0.249691 12.5805556 0.244742 12.5833333 0.241443 12.5861111 0.242268 12.5888889 0.242268 12.5916667 0.242268 12.5944444 0.241443 12.5972222 0.238969 12.6000000 0.238969 12.6027778 0.240619 12.6055556 0.239794 12.6083333 0.241443 12.6111111 0.239794 12.6138889 0.238144 12.6166667 0.236495 12.6194444 0.237320 12.6222222 0.238144 12.6250000 0.241443 12.6277778 0.238969 12.6305556 0.236495 12.6333333 0.235670 12.6361111 0.235670 12.6388889 0.238969 12.6416667 0.240619 12.6444444 0.238969 12.6472222 0.237320 12.6500000 0.236495 12.6527778 0.237320 12.6555556 0.238144 12.6583333 0.238969 12.6611111 0.237320 12.6638889 0.233196 12.6666667 0.226598 12.6694444 0.223299 12.6722222 0.220825 12.6750000 0.220000 12.6777778 0.213402 12.6805556 0.208454 12.6833333 0.211753 12.6861111 0.225773 12.6888889 0.246392 12.6916667 0.269485 12.6944444 0.295876 12.6972222 0.330515 12.7000000 0.370928 12.7027778 0.408866 12.7055556 0.434433 12.7083333 0.440206 12.7111111 0.423711 12.7138889 0.380000 12.7166667 0.318144 12.7194444 0.265361 12.7222222 0.235670 12.7250000 0.224124 12.7277778 0.220000 12.7305556 0.222474 12.7333333 0.225773 12.7361111 0.229897 12.7388889 0.231546 12.7416667 0.233196 12.7444444 0.231546 12.7472222 0.231546 12.7500000 0.230722 12.7527778 0.234021 12.7555556 0.234845 12.7583333 0.236495 12.7611111 0.234845 12.7638889 0.234021 12.7666667 0.230722 12.7694444 0.232371 12.7722222 0.234021 12.7750000 0.234021 12.7777778 0.233196 12.7805556 0.233196 12.7833333 0.228247 12.7861111 0.230722 12.7888889 0.232371 12.7916667 0.233196 12.7944444 0.231546 12.7972222 0.229072 12.8000000 0.227423 12.8027778 0.228247 12.8055556 0.231546 12.8083333 0.230722 12.8111111 0.229072 12.8138889 0.231546 12.8166667 0.229072 12.8194444 0.229897 12.8222222 0.230722 12.8250000 0.230722 12.8277778 0.231546 12.8305556 0.229897 12.8333333 0.229897 12.8361111 0.230722 12.8388889 0.232371 12.8416667 0.232371 12.8444444 0.232371 12.8472222 0.230722 12.8500000 0.229072 12.8527778 0.230722 12.8555556 0.231546 12.8583333 0.234845 12.8611111 0.233196 12.8638889 0.231546 12.8666667 0.229072 12.8694444 0.230722 12.8722222 0.230722 12.8750000 0.231546 12.8777778 0.230722 12.8805556 0.229897 12.8833333 0.227423 12.8861111 0.229072 12.8888889 0.229897 12.8916667 0.231546 12.8944444 0.230722 12.8972222 0.229897 12.9000000 0.227423 12.9027778 0.229072 12.9055556 0.229072 12.9083333 0.229897 12.9111111 0.230722 12.9138889 0.231546 12.9166667 0.229897 12.9194444 0.229072 12.9222222 0.229897 12.9250000 0.231546 12.9277778 0.233196 12.9305556 0.233196 12.9333333 0.229897 12.9361111 0.231546 12.9388889 0.230722 12.9416667 0.230722 12.9444444 0.230722 12.9472222 0.228247 12.9500000 0.228247 12.9527778 0.227423 12.9555556 0.230722 12.9583333 0.229072 12.9611111 0.225773 12.9638889 0.224948 12.9666667 0.223299 12.9694444 0.223299 12.9722222 0.223299 12.9750000 0.223299 12.9777778 0.223299 12.9805556 0.222474 12.9833333 0.219175 12.9861111 0.220000 12.9888889 0.224124 12.9916667 0.224948 12.9944444 0.224124 12.9972222 0.224948 13.0000000 0.224948 13.0027778 0.227423 13.0085556 0.300000 13.2747778 0.300000 13.2777778 0.244742 13.2805556 0.241443 13.2833333 0.243093 13.2861111 0.243918 13.2888889 0.245567 13.2916667 0.243918 13.2944444 0.243093 13.2972222 0.242268 13.3000000 0.241443 13.3027778 0.242268 13.3055556 0.244742 13.3083333 0.245567 13.3111111 0.245567 13.3138889 0.245567 13.3166667 0.245567 13.3194444 0.249691 13.3222222 0.252990 13.3250000 0.254639 13.3277778 0.253814 13.3305556 0.252990 13.3333333 0.252165 13.3361111 0.254639 13.3388889 0.257113 13.3416667 0.259588 13.3444444 0.260412 13.3472222 0.260412 13.3500000 0.260412 13.3527778 0.261237 13.3555556 0.262887 13.3583333 0.263711 13.3611111 0.262062 13.3638889 0.260412 13.3666667 0.257938 13.3694444 0.257938 13.3722222 0.260412 13.3750000 0.260412 13.3777778 0.258763 13.3805556 0.255464 13.3833333 0.255464 13.3861111 0.260412 13.3888889 0.262062 13.3916667 0.262887 13.3944444 0.256289 13.3972222 0.251340 13.4000000 0.249691 13.4027778 0.246392 13.4055556 0.248041 13.4083333 0.246392 13.4111111 0.245567 13.4138889 0.243093 13.4166667 0.240619 13.4194444 0.239794 13.4222222 0.241443 13.4250000 0.243093 13.4277778 0.243918 13.4305556 0.244742 13.4333333 0.240619 13.4361111 0.241443 13.4388889 0.243093 13.4416667 0.244742 13.4444444 0.241443 13.4472222 0.242268 13.4500000 0.238144 13.4527778 0.238144 13.4555556 0.239794 13.4583333 0.239794 13.4611111 0.242268 13.4638889 0.238969 13.4666667 0.237320 13.4694444 0.239794 13.4722222 0.238969 13.4750000 0.241443 13.4777778 0.238969 13.4805556 0.237320 13.4833333 0.236495 13.4861111 0.236495 13.4888889 0.234021 13.4916667 0.229072 13.4944444 0.223299 13.4972222 0.220000 13.5000000 0.214227 13.5027778 0.208454 13.5055556 0.213402 13.5083333 0.228247 13.5111111 0.249691 13.5138889 0.274433 13.5166667 0.301649 13.5194444 0.342887 13.5222222 0.388247 13.5250000 0.425361 13.5277778 0.446804 13.5305556 0.449278 13.5333333 0.416289 13.5361111 0.359381 13.5388889 0.295052 13.5416667 0.247216 13.5444444 0.224948 13.5472222 0.221649 13.5500000 0.227423 13.5527778 0.234845 13.5555556 0.237320 13.5583333 0.237320 13.5611111 0.236495 13.5638889 0.234845 13.5666667 0.234021 13.5694444 0.233196 13.5722222 0.234845 13.5750000 0.232371 13.5777778 0.235670 13.5805556 0.234845 13.5833333 0.233196 13.5861111 0.233196 13.5888889 0.234845 13.5916667 0.236495 13.5944444 0.236495 13.5972222 0.233196 13.6000000 0.233196 13.6027778 0.234021 13.6055556 0.236495 13.6083333 0.237320 13.6111111 0.236495 13.6138889 0.233196 13.6166667 0.232371 13.6194444 0.234021 13.6222222 0.234845 13.6250000 0.236495 13.6277778 0.234845 13.6305556 0.232371 13.6333333 0.233196 13.6361111 0.233196 13.6388889 0.234845 13.6416667 0.235670 13.6444444 0.234845 13.6472222 0.234845 13.6500000 0.233196 13.6527778 0.232371 13.6555556 0.234021 13.6583333 0.236495 13.6611111 0.234845 13.6638889 0.234021 13.6666667 0.234845 13.6694444 0.236495 13.6722222 0.236495 13.6750000 0.238144 13.6777778 0.238144 13.6805556 0.237320 13.6833333 0.234845 13.6861111 0.236495 13.6888889 0.235670 13.6916667 0.236495 13.6944444 0.237320 13.6972222 0.235670 13.7000000 0.234021 13.7027778 0.234021 13.7055556 0.235670 13.7083333 0.239794 13.7111111 0.238144 13.7138889 0.236495 13.7166667 0.234021 13.7194444 0.234021 13.7222222 0.235670 13.7250000 0.237320 13.7277778 0.238144 13.7305556 0.236495 13.7333333 0.234845 13.7361111 0.237320 13.7388889 0.238969 13.7416667 0.239794 13.7444444 0.239794 13.7472222 0.238144 13.7500000 0.236495 13.7527778 0.238144 13.7555556 0.238144 13.7583333 0.239794 13.7611111 0.238969 13.7638889 0.238144 13.7666667 0.234021 13.7694444 0.234845 13.7722222 0.233196 13.7750000 0.238969 13.7777778 0.236495 13.7805556 0.234021 13.7833333 0.232371 13.7861111 0.234021 13.7888889 0.234845 13.7916667 0.238144 13.7944444 0.237320 13.7972222 0.236495 13.8000000 0.233196 13.8027778 0.236495 13.8055556 0.238144 13.8083333 0.238969 13.8111111 0.239794 13.8138889 0.239794 13.8166667 0.242268 13.8194444 0.241443 13.8222222 0.247216 13.8250000 0.248866 13.8307778 0.300000 14.0692222 0.300000 14.0722222 0.247216 14.0750000 0.248866 14.0777778 0.249691 14.0805556 0.248041 14.0833333 0.245567 14.0861111 0.247216 14.0888889 0.248866 14.0916667 0.249691 14.0944444 0.250515 14.0972222 0.251340 14.1000000 0.247216 14.1027778 0.248866 14.1055556 0.250515 14.1083333 0.254639 14.1111111 0.255464 14.1138889 0.257113 14.1166667 0.258763 14.1194444 0.261237 14.1222222 0.262062 14.1250000 0.262887 14.1277778 0.262062 14.1305556 0.262062 14.1333333 0.260412 14.1361111 0.262062 14.1388889 0.262887 14.1416667 0.266186 14.1444444 0.266186 14.1472222 0.267010 14.1500000 0.265361 14.1527778 0.267835 14.1555556 0.267010 14.1583333 0.268660 14.1611111 0.267010 14.1638889 0.265361 14.1666667 0.262887 14.1694444 0.262887 14.1722222 0.263711 14.1750000 0.263711 14.1777778 0.263711 14.1805556 0.262062 14.1833333 0.258763 14.1861111 0.259588 14.1888889 0.262062 14.1916667 0.266186 14.1944444 0.269485 14.1972222 0.267835 14.2000000 0.262887 14.2027778 0.258763 14.2055556 0.257938 14.2083333 0.256289 14.2111111 0.254639 14.2138889 0.249691 14.2166667 0.247216 14.2194444 0.246392 14.2222222 0.246392 14.2250000 0.245567 14.2277778 0.245567 14.2305556 0.246392 14.2333333 0.244742 14.2361111 0.243918 14.2388889 0.244742 14.2416667 0.247216 14.2444444 0.244742 14.2472222 0.243093 14.2500000 0.241443 14.2527778 0.242268 14.2555556 0.241443 14.2583333 0.242268 14.2611111 0.243093 14.2638889 0.243918 14.2666667 0.241443 14.2694444 0.242268 14.2722222 0.243918 14.2750000 0.243918 14.2777778 0.243918 14.2805556 0.241443 14.2833333 0.234021 14.2861111 0.228247 14.2888889 0.224948 14.2916667 0.222474 14.2944444 0.217526 14.2972222 0.210928 14.3000000 0.210103 14.3027778 0.223299 14.3055556 0.241443 14.3083333 0.265361 14.3111111 0.294227 14.3138889 0.330515 14.3166667 0.371753 14.3194444 0.411340 14.3222222 0.435258 14.3250000 0.436082 14.3277778 0.405567 14.3305556 0.352784 14.3333333 0.288454 14.3361111 0.243918 14.3388889 0.226598 14.3416667 0.226598 14.3444444 0.232371 14.3472222 0.237320 14.3500000 0.238144 14.3527778 0.238144 14.3555556 0.238969 14.3583333 0.239794 14.3611111 0.240619 14.3638889 0.238969 14.3666667 0.238144 14.3694444 0.238969 14.3722222 0.240619 14.3750000 0.242268 14.3777778 0.241443 14.3805556 0.239794 14.3833333 0.237320 14.3861111 0.237320 14.3888889 0.238969 14.3916667 0.239794 14.3944444 0.239794 14.3972222 0.237320 14.4000000 0.236495 14.4027778 0.235670 14.4055556 0.237320 14.4083333 0.238144 14.4111111 0.238144 14.4138889 0.237320 14.4166667 0.235670 14.4194444 0.237320 14.4222222 0.238144 14.4250000 0.238969 14.4277778 0.239794 14.4305556 0.238144 14.4333333 0.236495 14.4361111 0.239794 14.4388889 0.240619 14.4416667 0.242268 14.4444444 0.241443 14.4472222 0.241443 14.4500000 0.238969 14.4527778 0.239794 14.4555556 0.242268 14.4583333 0.240619 14.4611111 0.239794 14.4638889 0.239794 14.4666667 0.238144 14.4694444 0.238144 14.4722222 0.241443 14.4750000 0.241443 14.4777778 0.238969 14.4805556 0.238144 14.4833333 0.237320 14.4861111 0.236495 14.4888889 0.238969 14.4916667 0.238969 14.4944444 0.240619 14.4972222 0.238969 14.5000000 0.238144 14.5027778 0.239794 14.5055556 0.241443 14.5083333 0.243093 14.5111111 0.240619 14.5138889 0.241443 14.5166667 0.239794 14.5194444 0.240619 14.5222222 0.243093 14.5250000 0.244742 14.5277778 0.244742 14.5305556 0.241443 14.5333333 0.241443 14.5361111 0.242268 14.5388889 0.243918 14.5416667 0.242268 14.5444444 0.242268 14.5472222 0.241443 14.5500000 0.239794 14.5527778 0.240619 14.5555556 0.239794 14.5583333 0.239794 14.5611111 0.239794 14.5638889 0.238969 14.5666667 0.238144 14.5694444 0.237320 14.5722222 0.239794 14.5750000 0.242268 14.5777778 0.240619 14.5805556 0.239794 14.5833333 0.237320 14.5861111 0.238144 14.5888889 0.238969 14.5916667 0.240619 14.5944444 0.239794 14.5972222 0.238144 14.6000000 0.237320 14.6027778 0.238144 14.6055556 0.240619 14.6083333 0.241443 14.6111111 0.241443 14.6138889 0.241443 14.6166667 0.242268 14.6194444 0.242268 14.6252222 0.300000 14.8664444 0.300000 14.8694444 0.244742 14.8722222 0.246392 14.8750000 0.246392 14.8777778 0.247216 14.8805556 0.246392 14.8833333 0.244742 14.8861111 0.247216 14.8888889 0.247216 14.8916667 0.248866 14.8944444 0.248866 14.8972222 0.247216 14.9000000 0.245567 14.9027778 0.243918 14.9055556 0.246392 14.9083333 0.249691 14.9111111 0.249691 14.9138889 0.252165 14.9166667 0.252165 14.9194444 0.255464 14.9222222 0.256289 14.9250000 0.256289 14.9277778 0.257113 14.9305556 0.257113 14.9333333 0.255464 14.9361111 0.254639 14.9388889 0.257113 14.9416667 0.259588 14.9444444 0.261237 14.9472222 0.262062 14.9500000 0.259588 14.9527778 0.260412 14.9555556 0.262062 14.9583333 0.260412 14.9611111 0.262887 14.9638889 0.260412 14.9666667 0.259588 14.9694444 0.260412 14.9722222 0.263711 14.9750000 0.263711 14.9777778 0.262062 14.9805556 0.259588 14.9833333 0.257938 14.9861111 0.260412 14.9888889 0.264536 14.9916667 0.262887 14.9944444 0.257938 14.9972222 0.252990 15.0000000 0.248866 15.0027778 0.248866 15.0055556 0.245567 15.0083333 0.244742 15.0111111 0.242268 15.0138889 0.242268 15.0166667 0.240619 15.0194444 0.241443 15.0222222 0.243918 15.0250000 0.243918 15.0277778 0.244742 15.0305556 0.242268 15.0333333 0.240619 15.0361111 0.240619 15.0388889 0.243093 15.0416667 0.243093 15.0444444 0.242268 15.0472222 0.242268 15.0500000 0.240619 15.0527778 0.242268 15.0555556 0.242268 15.0583333 0.243093 15.0611111 0.241443 15.0638889 0.241443 15.0666667 0.238969 15.0694444 0.238144 15.0722222 0.235670 15.0750000 0.229897 15.0777778 0.224948 15.0805556 0.221649 15.0833333 0.217526 15.0861111 0.210928 15.0888889 0.205979 15.0916667 0.215876 15.0944444 0.231546 15.0972222 0.244742 15.1000000 0.257113 15.1027778 0.275258 15.1055556 0.299175 15.1083333 0.333814 15.1111111 0.377526 15.1138889 0.412165 15.1166667 0.436082 15.1194444 0.452577 15.1222222 0.460000 15.1250000 0.445979 15.1277778 0.413814 15.1305556 0.368454 15.1333333 0.317320 15.1361111 0.275258 15.1388889 0.243093 15.1416667 0.228247 15.1444444 0.223299 15.1472222 0.224948 15.1500000 0.229897 15.1527778 0.231546 15.1555556 0.234845 15.1583333 0.238144 15.1611111 0.238969 15.1638889 0.234845 15.1666667 0.234021 15.1694444 0.234021 15.1722222 0.232371 15.1750000 0.234021 15.1777778 0.233196 15.1805556 0.234021 15.1833333 0.233196 15.1861111 0.234845 15.1888889 0.235670 15.1916667 0.237320 15.1944444 0.236495 15.1972222 0.233196 15.2000000 0.230722 15.2027778 0.233196 15.2055556 0.234021 15.2083333 0.235670 15.2111111 0.237320 15.2138889 0.234845 15.2166667 0.234845 15.2194444 0.234021 15.2222222 0.235670 15.2250000 0.232371 15.2277778 0.233196 15.2305556 0.232371 15.2333333 0.232371 15.2361111 0.234845 15.2388889 0.236495 15.2416667 0.234845 15.2444444 0.233196 15.2472222 0.230722 15.2500000 0.228247 15.2527778 0.231546 15.2555556 0.233196 15.2583333 0.232371 15.2611111 0.234021 15.2638889 0.232371 15.2666667 0.231546 15.2694444 0.232371 15.2722222 0.234021 15.2750000 0.233196 15.2777778 0.235670 15.2805556 0.235670 15.2833333 0.234021 15.2861111 0.235670 15.2888889 0.235670 15.2916667 0.235670 15.2944444 0.234845 15.2972222 0.230722 15.3000000 0.230722 15.3027778 0.231546 15.3055556 0.232371 15.3083333 0.234845 15.3111111 0.234845 15.3138889 0.234021 15.3166667 0.231546 15.3194444 0.231546 15.3222222 0.234021 15.3250000 0.234021 15.3277778 0.236495 15.3305556 0.235670 15.3333333 0.232371 15.3361111 0.234845 15.3388889 0.235670 15.3416667 0.237320 15.3444444 0.238144 15.3472222 0.235670 15.3500000 0.233196 15.3527778 0.230722 15.3555556 0.231546 15.3583333 0.231546 15.3611111 0.231546 15.3638889 0.228247 15.3666667 0.223299 15.3694444 0.224948 15.3722222 0.223299 15.3750000 0.224124 15.3777778 0.226598 15.3805556 0.224948 15.3833333 0.223299 15.3861111 0.221649 15.3888889 0.224948 15.3916667 0.224124 15.3944444 0.225773 15.3972222 0.224948 15.4000000 0.222474 15.4027778 0.224948 15.4055556 0.227423 15.4083333 0.230722 15.4111111 0.231546 15.4138889 0.230722 15.4166667 0.232371 15.4224444 0.300000 15.6581111 0.300000 15.6611111 0.242268 15.6638889 0.239794 15.6666667 0.241443 15.6694444 0.242268 15.6722222 0.243918 15.6750000 0.243918 15.6777778 0.241443 15.6805556 0.241443 15.6833333 0.242268 15.6861111 0.242268 15.6888889 0.244742 15.6916667 0.243918 15.6944444 0.243918 15.6972222 0.245567 15.7000000 0.242268 15.7027778 0.248041 15.7055556 0.250515 15.7083333 0.252165 15.7111111 0.254639 15.7138889 0.253814 15.7166667 0.252990 15.7194444 0.254639 15.7222222 0.255464 15.7250000 0.257938 15.7277778 0.260412 15.7305556 0.258763 15.7333333 0.257938 15.7361111 0.260412 15.7388889 0.262887 15.7416667 0.262887 15.7444444 0.260412 15.7472222 0.257938 15.7500000 0.257113 15.7527778 0.254639 15.7555556 0.257113 15.7583333 0.259588 15.7611111 0.257938 15.7638889 0.256289 15.7666667 0.253814 15.7694444 0.255464 15.7722222 0.258763 15.7750000 0.261237 15.7777778 0.262062 15.7805556 0.259588 15.7833333 0.255464 15.7861111 0.253814 15.7888889 0.253814 15.7916667 0.252165 15.7944444 0.248041 15.7972222 0.244742 15.8000000 0.241443 15.8027778 0.241443 15.8055556 0.241443 15.8083333 0.240619 15.8111111 0.240619 15.8138889 0.238144 15.8166667 0.237320 15.8194444 0.240619 15.8222222 0.241443 15.8250000 0.242268 15.8277778 0.243093 15.8305556 0.238969 15.8333333 0.238969 15.8361111 0.241443 15.8388889 0.241443 15.8416667 0.242268 15.8444444 0.243093 15.8472222 0.241443 15.8500000 0.241443 15.8527778 0.240619 15.8555556 0.241443 15.8583333 0.241443 15.8611111 0.241443 15.8638889 0.240619 15.8666667 0.238144 15.8694444 0.238969 15.8722222 0.235670 15.8750000 0.229897 15.8777778 0.223299 15.8805556 0.219175 15.8833333 0.213402 15.8861111 0.207629 15.8888889 0.207629 15.8916667 0.218351 15.8944444 0.240619 15.8972222 0.263711 15.9000000 0.292577 15.9027778 0.331340 15.9055556 0.378351 15.9083333 0.419588 15.9111111 0.447629 15.9138889 0.447629 15.9166667 0.417113 15.9194444 0.357732 15.9222222 0.290928 15.9250000 0.242268 15.9277778 0.220825 15.9305556 0.219175 15.9333333 0.223299 15.9361111 0.231546 15.9388889 0.233196 15.9416667 0.234845 15.9444444 0.233196 15.9472222 0.230722 15.9500000 0.234845 15.9527778 0.231546 15.9555556 0.234021 15.9583333 0.235670 15.9611111 0.236495 15.9638889 0.234845 15.9666667 0.233196 15.9694444 0.234845 15.9722222 0.234021 15.9750000 0.235670 15.9777778 0.235670 15.9805556 0.234021 15.9833333 0.231546 15.9861111 0.233196 15.9888889 0.235670 15.9916667 0.237320 15.9944444 0.237320 15.9972222 0.233196 16.0000000 0.235670 16.0027778 0.234021 16.0055556 0.235670 16.0083333 0.237320 16.0111111 0.237320 16.0138889 0.233196 16.0166667 0.234021 16.0194444 0.232371 16.0222222 0.234021 16.0250000 0.234845 16.0277778 0.234021 16.0305556 0.234021 16.0333333 0.233196 16.0361111 0.235670 16.0388889 0.237320 16.0416667 0.236495 16.0444444 0.236495 16.0472222 0.235670 16.0500000 0.233196 16.0527778 0.234021 16.0555556 0.234021 16.0583333 0.235670 16.0611111 0.235670 16.0638889 0.232371 16.0666667 0.232371 16.0694444 0.233196 16.0722222 0.234021 16.0750000 0.232371 16.0777778 0.233196 16.0805556 0.232371 16.0833333 0.231546 16.0861111 0.232371 16.0888889 0.233196 16.0916667 0.234845 16.0944444 0.233196 16.0972222 0.234021 16.1000000 0.234021 16.1027778 0.234845 16.1055556 0.233196 16.1083333 0.237320 16.1111111 0.236495 16.1138889 0.235670 16.1166667 0.232371 16.1194444 0.234845 16.1222222 0.235670 16.1250000 0.237320 16.1277778 0.236495 16.1305556 0.233196 16.1333333 0.233196 16.1361111 0.233196 16.1388889 0.234021 16.1416667 0.232371 16.1444444 0.232371 16.1472222 0.231546 16.1500000 0.228247 16.1527778 0.229072 16.1555556 0.231546 16.1583333 0.230722 16.1611111 0.230722 16.1638889 0.227423 16.1666667 0.227423 16.1694444 0.228247 16.1722222 0.228247 16.1750000 0.228247 16.1777778 0.229072 16.1805556 0.226598 16.1833333 0.226598 16.1861111 0.230722 16.1888889 0.229897 16.1916667 0.232371 16.1944444 0.233196 16.1972222 0.234021 16.2000000 0.232371 16.2027778 0.237320 16.2055556 0.238969 16.2083333 0.242268 16.2141111 0.300000 16.4111111 0.300000)
Vecg1 ecg_l1 0 PWL(0.0000000 0.300000 0.2470000 0.300000 0.2500000 0.264536 0.2527778 0.262887 0.2555556 0.264536 0.2583333 0.264536 0.2611111 0.264536 0.2638889 0.262887 0.2666667 0.262887 0.2694444 0.262887 0.2722222 0.266186 0.2750000 0.267835 0.2777778 0.265361 0.2805556 0.265361 0.2833333 0.264536 0.2861111 0.261237 0.2888889 0.262062 0.2916667 0.263711 0.2944444 0.263711 0.2972222 0.262062 0.3000000 0.262887 0.3027778 0.262062 0.3055556 0.264536 0.3083333 0.267835 0.3111111 0.267835 0.3138889 0.268660 0.3166667 0.267010 0.3194444 0.267835 0.3222222 0.270309 0.3250000 0.271959 0.3277778 0.270309 0.3305556 0.271134 0.3333333 0.267835 0.3361111 0.267835 0.3388889 0.271959 0.3416667 0.271134 0.3444444 0.271134 0.3472222 0.270309 0.3500000 0.269485 0.3527778 0.269485 0.3555556 0.271134 0.3583333 0.271134 0.3611111 0.271134 0.3638889 0.268660 0.3666667 0.266186 0.3694444 0.267010 0.3722222 0.266186 0.3750000 0.266186 0.3777778 0.264536 0.3805556 0.264536 0.3833333 0.262887 0.3861111 0.264536 0.3888889 0.265361 0.3916667 0.267010 0.3944444 0.264536 0.3972222 0.262887 0.4000000 0.259588 0.4027778 0.259588 0.4055556 0.258763 0.4083333 0.262887 0.4111111 0.262062 0.4138889 0.261237 0.4166667 0.260412 0.4194444 0.261237 0.4222222 0.261237 0.4250000 0.263711 0.4277778 0.262062 0.4305556 0.260412 0.4333333 0.260412 0.4361111 0.259588 0.4388889 0.262887 0.4416667 0.262887 0.4444444 0.261237 0.4472222 0.258763 0.4500000 0.255464 0.4527778 0.253814 0.4555556 0.252165 0.4583333 0.250515 0.4611111 0.245567 0.4638889 0.240619 0.4666667 0.241443 0.4694444 0.249691 0.4722222 0.266186 0.4750000 0.286804 0.4777778 0.302474 0.4805556 0.310722 0.4833333 0.318969 0.4861111 0.331340 0.4888889 0.349485 0.4916667 0.367629 0.4944444 0.381649 0.4972222 0.380000 0.5000000 0.359381 0.5027778 0.317320 0.5055556 0.272784 0.5083333 0.242268 0.5111111 0.225773 0.5138889 0.222474 0.5166667 0.225773 0.5194444 0.234845 0.5222222 0.243093 0.5250000 0.248866 0.5277778 0.251340 0.5305556 0.252990 0.5333333 0.251340 0.5361111 0.251340 0.5388889 0.253814 0.5416667 0.252990 0.5444444 0.252990 0.5472222 0.252990 0.5500000 0.252165 0.5527778 0.254639 0.5555556 0.254639 0.5583333 0.254639 0.5611111 0.255464 0.5638889 0.252990 0.5666667 0.251340 0.5694444 0.252165 0.5722222 0.254639 0.5750000 0.256289 0.5777778 0.256289 0.5805556 0.254639 0.5833333 0.251340 0.5861111 0.252165 0.5888889 0.252990 0.5916667 0.255464 0.5944444 0.256289 0.5972222 0.254639 0.6000000 0.253814 0.6027778 0.253814 0.6055556 0.255464 0.6083333 0.256289 0.6111111 0.255464 0.6138889 0.255464 0.6166667 0.253814 0.6194444 0.255464 0.6222222 0.256289 0.6250000 0.256289 0.6277778 0.256289 0.6305556 0.255464 0.6333333 0.252990 0.6361111 0.252990 0.6388889 0.256289 0.6416667 0.256289 0.6444444 0.257938 0.6472222 0.254639 0.6500000 0.254639 0.6527778 0.253814 0.6555556 0.255464 0.6583333 0.256289 0.6611111 0.254639 0.6638889 0.252990 0.6666667 0.253814 0.6694444 0.253814 0.6722222 0.254639 0.6750000 0.254639 0.6777778 0.254639 0.6805556 0.252990 0.6833333 0.251340 0.6861111 0.251340 0.6888889 0.254639 0.6916667 0.254639 0.6944444 0.252990 0.6972222 0.252165 0.7000000 0.248041 0.7027778 0.248041 0.7055556 0.249691 0.7083333 0.252165 0.7111111 0.248866 0.7138889 0.247216 0.7166667 0.247216 0.7194444 0.244742 0.7222222 0.245567 0.7250000 0.246392 0.7277778 0.243093 0.7305556 0.242268 0.7333333 0.239794 0.7361111 0.238969 0.7388889 0.241443 0.7416667 0.240619 0.7444444 0.238969 0.7472222 0.235670 0.7500000 0.234845 0.7527778 0.234021 0.7555556 0.235670 0.7583333 0.236495 0.7611111 0.235670 0.7638889 0.234021 0.7666667 0.232371 0.7694444 0.230722 0.7722222 0.233196 0.7750000 0.232371 0.7777778 0.232371 0.7805556 0.234021 0.7833333 0.233196 0.7861111 0.235670 0.7888889 0.236495 0.7916667 0.239794 0.7944444 0.241443 0.7972222 0.243093 0.8030000 0.300000 1.0581111 0.300000 1.0611111 0.267010 1.0638889 0.262062 1.0666667 0.263711 1.0694444 0.264536 1.0722222 0.266186 1.0750000 0.267010 1.0777778 0.266186 1.0805556 0.263711 1.0833333 0.263711 1.0861111 0.262887 1.0888889 0.266186 1.0916667 0.267010 1.0944444 0.267010 1.0972222 0.265361 1.1000000 0.262062 1.1027778 0.264536 1.1055556 0.267010 1.1083333 0.267010 1.1111111 0.266186 1.1138889 0.265361 1.1166667 0.264536 1.1194444 0.263711 1.1222222 0.266186 1.1250000 0.267010 1.1277778 0.267835 1.1305556 0.266186 1.1333333 0.266186 1.1361111 0.266186 1.1388889 0.270309 1.1416667 0.271959 1.1444444 0.268660 1.1472222 0.268660 1.1500000 0.267010 1.1527778 0.269485 1.1555556 0.272784 1.1583333 0.276082 1.1611111 0.276082 1.1638889 0.271959 1.1666667 0.271134 1.1694444 0.271959 1.1722222 0.272784 1.1750000 0.275258 1.1777778 0.273608 1.1805556 0.271134 1.1833333 0.268660 1.1861111 0.268660 1.1888889 0.269485 1.1916667 0.269485 1.1944444 0.271134 1.1972222 0.267835 1.2000000 0.264536 1.2027778 0.266186 1.2055556 0.267010 1.2083333 0.267835 1.2111111 0.266186 1.2138889 0.265361 1.2166667 0.263711 1.2194444 0.264536 1.2222222 0.265361 1.2250000 0.266186 1.2277778 0.267010 1.2305556 0.265361 1.2333333 0.263711 1.2361111 0.263711 1.2388889 0.263711 1.2416667 0.267010 1.2444444 0.266186 1.2472222 0.264536 1.2500000 0.262887 1.2527778 0.263711 1.2555556 0.264536 1.2583333 0.266186 1.2611111 0.263711 1.2638889 0.262887 1.2666667 0.260412 1.2694444 0.257113 1.2722222 0.253814 1.2750000 0.250515 1.2777778 0.243093 1.2805556 0.238144 1.2833333 0.243093 1.2861111 0.257113 1.2888889 0.279381 1.2916667 0.304124 1.2944444 0.323918 1.2972222 0.342887 1.3000000 0.361856 1.3027778 0.383299 1.3055556 0.404742 1.3083333 0.416289 1.3111111 0.400619 1.3138889 0.352784 1.3166667 0.292577 1.3194444 0.258763 1.3222222 0.255464 1.3250000 0.260412 1.3277778 0.260412 1.3305556 0.258763 1.3333333 0.257938 1.3361111 0.259588 1.3388889 0.259588 1.3416667 0.259588 1.3444444 0.257938 1.3472222 0.257113 1.3500000 0.257113 1.3527778 0.255464 1.3555556 0.259588 1.3583333 0.259588 1.3611111 0.258763 1.3638889 0.256289 1.3666667 0.255464 1.3694444 0.255464 1.3722222 0.256289 1.3750000 0.257113 1.3777778 0.257113 1.3805556 0.255464 1.3833333 0.253814 1.3861111 0.253814 1.3888889 0.255464 1.3916667 0.257938 1.3944444 0.256289 1.3972222 0.253814 1.4000000 0.252165 1.4027778 0.254639 1.4055556 0.256289 1.4083333 0.257938 1.4111111 0.257113 1.4138889 0.257113 1.4166667 0.253814 1.4194444 0.253814 1.4222222 0.256289 1.4250000 0.257113 1.4277778 0.257938 1.4305556 0.257113 1.4333333 0.254639 1.4361111 0.255464 1.4388889 0.254639 1.4416667 0.256289 1.4444444 0.256289 1.4472222 0.255464 1.4500000 0.253814 1.4527778 0.252990 1.4555556 0.253814 1.4583333 0.257938 1.4611111 0.255464 1.4638889 0.253814 1.4666667 0.252165 1.4694444 0.252165 1.4722222 0.255464 1.4750000 0.255464 1.4777778 0.252990 1.4805556 0.250515 1.4833333 0.250515 1.4861111 0.250515 1.4888889 0.251340 1.4916667 0.254639 1.4944444 0.251340 1.4972222 0.250515 1.5000000 0.248866 1.5027778 0.248866 1.5055556 0.248041 1.5083333 0.248866 1.5111111 0.248866 1.5138889 0.244742 1.5166667 0.243093 1.5194444 0.241443 1.5222222 0.242268 1.5250000 0.243093 1.5277778 0.240619 1.5305556 0.238969 1.5333333 0.238144 1.5361111 0.236495 1.5388889 0.238969 1.5416667 0.238969 1.5444444 0.236495 1.5472222 0.234021 1.5500000 0.231546 1.5527778 0.233196 1.5555556 0.232371 1.5583333 0.235670 1.5611111 0.233196 1.5638889 0.232371 1.5666667 0.229897 1.5694444 0.230722 1.5722222 0.232371 1.5750000 0.233196 1.5777778 0.234021 1.5805556 0.234021 1.5833333 0.233196 1.5861111 0.236495 1.5888889 0.239794 1.5916667 0.243093 1.5944444 0.244742 1.5972222 0.246392 1.6000000 0.248866 1.6027778 0.251340 1.6055556 0.254639 1.6083333 0.257938 1.6141111 0.300000 1.8470000 0.300000 1.8500000 0.261237 1.8527778 0.262062 1.8555556 0.262887 1.8583333 0.262887 1.8611111 0.262887 1.8638889 0.262887 1.8666667 0.262062 1.8694444 0.262062 1.8722222 0.264536 1.8750000 0.265361 1.8777778 0.262887 1.8805556 0.260412 1.8833333 0.261237 1.8861111 0.260412 1.8888889 0.262887 1.8916667 0.264536 1.8944444 0.263711 1.8972222 0.263711 1.9000000 0.262062 1.9027778 0.262062 1.9055556 0.266186 1.9083333 0.267010 1.9111111 0.266186 1.9138889 0.267835 1.9166667 0.265361 1.9194444 0.266186 1.9222222 0.268660 1.9250000 0.269485 1.9277778 0.267010 1.9305556 0.267835 1.9333333 0.267010 1.9361111 0.268660 1.9388889 0.271959 1.9416667 0.276907 1.9444444 0.272784 1.9472222 0.272784 1.9500000 0.269485 1.9527778 0.270309 1.9555556 0.271959 1.9583333 0.275258 1.9611111 0.272784 1.9638889 0.270309 1.9666667 0.267010 1.9694444 0.265361 1.9722222 0.265361 1.9750000 0.269485 1.9777778 0.268660 1.9805556 0.267010 1.9833333 0.264536 1.9861111 0.263711 1.9888889 0.265361 1.9916667 0.267835 1.9944444 0.266186 1.9972222 0.263711 2.0000000 0.262887 2.0027778 0.262062 2.0055556 0.263711 2.0083333 0.265361 2.0111111 0.265361 2.0138889 0.262062 2.0166667 0.261237 2.0194444 0.262062 2.0222222 0.262887 2.0250000 0.264536 2.0277778 0.263711 2.0305556 0.263711 2.0333333 0.262062 2.0361111 0.260412 2.0388889 0.263711 2.0416667 0.262887 2.0444444 0.261237 2.0472222 0.258763 2.0500000 0.253814 2.0527778 0.249691 2.0555556 0.246392 2.0583333 0.243093 2.0611111 0.238144 2.0638889 0.231546 2.0666667 0.229897 2.0694444 0.236495 2.0722222 0.251340 2.0750000 0.270309 2.0777778 0.289278 2.0805556 0.305773 2.0833333 0.321443 2.0861111 0.339588 2.0888889 0.361031 2.0916667 0.381649 2.0944444 0.400619 2.0972222 0.408041 2.1000000 0.389897 2.1027778 0.337938 2.1055556 0.282680 2.1083333 0.253814 2.1111111 0.252990 2.1138889 0.257938 2.1166667 0.257938 2.1194444 0.257113 2.1222222 0.262062 2.1250000 0.263711 2.1277778 0.259588 2.1305556 0.257938 2.1333333 0.257113 2.1361111 0.258763 2.1388889 0.261237 2.1416667 0.259588 2.1444444 0.259588 2.1472222 0.257113 2.1500000 0.256289 2.1527778 0.256289 2.1555556 0.257113 2.1583333 0.260412 2.1611111 0.259588 2.1638889 0.257113 2.1666667 0.255464 2.1694444 0.255464 2.1722222 0.257938 2.1750000 0.257938 2.1777778 0.258763 2.1805556 0.256289 2.1833333 0.255464 2.1861111 0.255464 2.1888889 0.256289 2.1916667 0.258763 2.1944444 0.259588 2.1972222 0.256289 2.2000000 0.255464 2.2027778 0.257113 2.2055556 0.257938 2.2083333 0.259588 2.2111111 0.258763 2.2138889 0.257113 2.2166667 0.255464 2.2194444 0.257113 2.2222222 0.257938 2.2250000 0.258763 2.2277778 0.257938 2.2305556 0.257938 2.2333333 0.254639 2.2361111 0.255464 2.2388889 0.256289 2.2416667 0.257113 2.2444444 0.257113 2.2472222 0.254639 2.2500000 0.255464 2.2527778 0.257113 2.2555556 0.259588 2.2583333 0.257938 2.2611111 0.256289 2.2638889 0.256289 2.2666667 0.255464 2.2694444 0.256289 2.2722222 0.257113 2.2750000 0.255464 2.2777778 0.256289 2.2805556 0.255464 2.2833333 0.253814 2.2861111 0.252990 2.2888889 0.253814 2.2916667 0.252990 2.2944444 0.252165 2.2972222 0.248866 2.3000000 0.249691 2.3027778 0.250515 2.3055556 0.250515 2.3083333 0.248866 2.3111111 0.246392 2.3138889 0.243918 2.3166667 0.243918 2.3194444 0.246392 2.3222222 0.247216 2.3250000 0.241443 2.3277778 0.240619 2.3305556 0.237320 2.3333333 0.236495 2.3361111 0.238144 2.3388889 0.239794 2.3416667 0.238144 2.3444444 0.236495 2.3472222 0.235670 2.3500000 0.234845 2.3527778 0.236495 2.3555556 0.238144 2.3583333 0.238144 2.3611111 0.238144 2.3638889 0.237320 2.3666667 0.239794 2.3694444 0.243093 2.3722222 0.244742 2.3750000 0.248041 2.3777778 0.248866 2.3805556 0.249691 2.3833333 0.252165 2.3861111 0.255464 2.3888889 0.257938 2.3916667 0.258763 2.3944444 0.259588 2.3972222 0.261237 2.4030000 0.300000 2.6386667 0.300000 2.6416667 0.262062 2.6444444 0.261237 2.6472222 0.259588 2.6500000 0.258763 2.6527778 0.259588 2.6555556 0.262062 2.6583333 0.262062 2.6611111 0.261237 2.6638889 0.258763 2.6666667 0.258763 2.6694444 0.260412 2.6722222 0.262887 2.6750000 0.262062 2.6777778 0.261237 2.6805556 0.260412 2.6833333 0.259588 2.6861111 0.260412 2.6888889 0.262887 2.6916667 0.262887 2.6944444 0.262062 2.6972222 0.262062 2.7000000 0.262887 2.7027778 0.266186 2.7055556 0.265361 2.7083333 0.263711 2.7111111 0.266186 2.7138889 0.263711 2.7166667 0.263711 2.7194444 0.265361 2.7222222 0.268660 2.7250000 0.270309 2.7277778 0.270309 2.7305556 0.269485 2.7333333 0.268660 2.7361111 0.268660 2.7388889 0.269485 2.7416667 0.266186 2.7444444 0.267010 2.7472222 0.263711 2.7500000 0.263711 2.7527778 0.263711 2.7555556 0.265361 2.7583333 0.262887 2.7611111 0.263711 2.7638889 0.260412 2.7666667 0.259588 2.7694444 0.261237 2.7722222 0.262062 2.7750000 0.259588 2.7777778 0.259588 2.7805556 0.258763 2.7833333 0.257938 2.7861111 0.262062 2.7888889 0.262887 2.7916667 0.262062 2.7944444 0.259588 2.7972222 0.257938 2.8000000 0.256289 2.8027778 0.257938 2.8055556 0.259588 2.8083333 0.257113 2.8111111 0.258763 2.8138889 0.257113 2.8166667 0.255464 2.8194444 0.260412 2.8222222 0.259588 2.8250000 0.258763 2.8277778 0.258763 2.8305556 0.258763 2.8333333 0.256289 2.8361111 0.257938 2.8388889 0.259588 2.8416667 0.257938 2.8444444 0.256289 2.8472222 0.253814 2.8500000 0.249691 2.8527778 0.247216 2.8555556 0.242268 2.8583333 0.237320 2.8611111 0.235670 2.8638889 0.243093 2.8666667 0.260412 2.8694444 0.281856 2.8722222 0.296701 2.8750000 0.306598 2.8777778 0.318144 2.8805556 0.336289 2.8833333 0.357732 2.8861111 0.372577 2.8888889 0.365155 2.8916667 0.325567 2.8944444 0.271959 2.8972222 0.237320 2.9000000 0.232371 2.9027778 0.241443 2.9055556 0.247216 2.9083333 0.249691 2.9111111 0.250515 2.9138889 0.251340 2.9166667 0.251340 2.9194444 0.252990 2.9222222 0.250515 2.9250000 0.248866 2.9277778 0.249691 2.9305556 0.249691 2.9333333 0.251340 2.9361111 0.255464 2.9388889 0.255464 2.9416667 0.252990 2.9444444 0.249691 2.9472222 0.248866 2.9500000 0.250515 2.9527778 0.252165 2.9555556 0.254639 2.9583333 0.252990 2.9611111 0.252990 2.9638889 0.249691 2.9666667 0.252165 2.9694444 0.252165 2.9722222 0.252990 2.9750000 0.252990 2.9777778 0.252165 2.9805556 0.250515 2.9833333 0.251340 2.9861111 0.252990 2.9888889 0.254639 2.9916667 0.252165 2.9944444 0.251340 2.9972222 0.254639 3.0000000 0.252990 3.0027778 0.252990 3.0055556 0.257113 3.0083333 0.255464 3.0111111 0.256289 3.0138889 0.252990 3.0166667 0.252165 3.0194444 0.251340 3.0222222 0.253814 3.0250000 0.252165 3.0277778 0.251340 3.0305556 0.250515 3.0333333 0.248866 3.0361111 0.249691 3.0388889 0.251340 3.0416667 0.250515 3.0444444 0.253814 3.0472222 0.252165 3.0500000 0.249691 3.0527778 0.252165 3.0555556 0.252990 3.0583333 0.249691 3.0611111 0.248866 3.0638889 0.248041 3.0666667 0.249691 3.0694444 0.251340 3.0722222 0.252165 3.0750000 0.251340 3.0777778 0.250515 3.0805556 0.249691 3.0833333 0.246392 3.0861111 0.248866 3.0888889 0.250515 3.0916667 0.248866 3.0944444 0.244742 3.0972222 0.243918 3.1000000 0.242268 3.1027778 0.241443 3.1055556 0.243918 3.1083333 0.242268 3.1111111 0.239794 3.1138889 0.237320 3.1166667 0.234021 3.1194444 0.236495 3.1222222 0.237320 3.1250000 0.235670 3.1277778 0.234021 3.1305556 0.233196 3.1333333 0.233196 3.1361111 0.233196 3.1388889 0.231546 3.1416667 0.231546 3.1444444 0.230722 3.1472222 0.231546 3.1500000 0.229897 3.1527778 0.232371 3.1555556 0.234845 3.1583333 0.236495 3.1611111 0.233196 3.1638889 0.234845 3.1666667 0.234845 3.1694444 0.238144 3.1722222 0.238969 3.1750000 0.238144 3.1777778 0.238144 3.1805556 0.238969 3.1833333 0.240619 3.1861111 0.243093 3.1888889 0.247216 3.1946667 0.300000 3.4275556 0.300000 3.4305556 0.255464 3.4333333 0.256289 3.4361111 0.257938 3.4388889 0.259588 3.4416667 0.257938 3.4444444 0.254639 3.4472222 0.254639 3.4500000 0.254639 3.4527778 0.257938 3.4555556 0.257938 3.4583333 0.257113 3.4611111 0.256289 3.4638889 0.252990 3.4666667 0.253814 3.4694444 0.256289 3.4722222 0.257113 3.4750000 0.257938 3.4777778 0.258763 3.4805556 0.257938 3.4833333 0.258763 3.4861111 0.260412 3.4888889 0.262062 3.4916667 0.261237 3.4944444 0.262887 3.4972222 0.261237 3.5000000 0.260412 3.5027778 0.262887 3.5055556 0.264536 3.5083333 0.261237 3.5111111 0.262062 3.5138889 0.262887 3.5166667 0.264536 3.5194444 0.266186 3.5222222 0.267010 3.5250000 0.265361 3.5277778 0.262887 3.5305556 0.262062 3.5333333 0.262887 3.5361111 0.264536 3.5388889 0.265361 3.5416667 0.261237 3.5444444 0.260412 3.5472222 0.257938 3.5500000 0.259588 3.5527778 0.261237 3.5555556 0.262062 3.5583333 0.261237 3.5611111 0.259588 3.5638889 0.255464 3.5666667 0.257113 3.5694444 0.258763 3.5722222 0.260412 3.5750000 0.260412 3.5777778 0.257938 3.5805556 0.257113 3.5833333 0.256289 3.5861111 0.257938 3.5888889 0.259588 3.5916667 0.259588 3.5944444 0.257113 3.5972222 0.257938 3.6000000 0.257113 3.6027778 0.257938 3.6055556 0.260412 3.6083333 0.260412 3.6111111 0.257113 3.6138889 0.257113 3.6166667 0.258763 3.6194444 0.260412 3.6222222 0.261237 3.6250000 0.260412 3.6277778 0.257938 3.6305556 0.255464 3.6333333 0.252990 3.6361111 0.252165 3.6388889 0.248866 3.6416667 0.245567 3.6444444 0.239794 3.6472222 0.238969 3.6500000 0.242268 3.6527778 0.257113 3.6555556 0.277732 3.6583333 0.296701 3.6611111 0.305773 3.6638889 0.315670 3.6666667 0.330515 3.6694444 0.351959 3.6722222 0.374227 3.6750000 0.384948 3.6777778 0.374227 3.6805556 0.328866 3.6833333 0.270309 3.6861111 0.236495 3.6888889 0.234845 3.6916667 0.243093 3.6944444 0.248866 3.6972222 0.252165 3.7000000 0.254639 3.7027778 0.256289 3.7055556 0.261237 3.7083333 0.258763 3.7111111 0.256289 3.7138889 0.257938 3.7166667 0.259588 3.7194444 0.260412 3.7222222 0.260412 3.7250000 0.258763 3.7277778 0.257113 3.7305556 0.256289 3.7333333 0.254639 3.7361111 0.257938 3.7388889 0.260412 3.7416667 0.259588 3.7444444 0.257113 3.7472222 0.257113 3.7500000 0.256289 3.7527778 0.258763 3.7555556 0.258763 3.7583333 0.259588 3.7611111 0.258763 3.7638889 0.256289 3.7666667 0.257938 3.7694444 0.258763 3.7722222 0.259588 3.7750000 0.259588 3.7777778 0.257938 3.7805556 0.257113 3.7833333 0.258763 3.7861111 0.260412 3.7888889 0.264536 3.7916667 0.262062 3.7944444 0.258763 3.7972222 0.258763 3.8000000 0.257938 3.8027778 0.260412 3.8055556 0.263711 3.8083333 0.261237 3.8111111 0.261237 3.8138889 0.260412 3.8166667 0.257938 3.8194444 0.259588 3.8222222 0.262887 3.8250000 0.262062 3.8277778 0.261237 3.8305556 0.260412 3.8333333 0.260412 3.8361111 0.260412 3.8388889 0.262062 3.8416667 0.259588 3.8444444 0.257938 3.8472222 0.258763 3.8500000 0.258763 3.8527778 0.261237 3.8555556 0.260412 3.8583333 0.261237 3.8611111 0.257938 3.8638889 0.257938 3.8666667 0.257938 3.8694444 0.258763 3.8722222 0.261237 3.8750000 0.257113 3.8777778 0.257938 3.8805556 0.255464 3.8833333 0.252990 3.8861111 0.252990 3.8888889 0.253814 3.8916667 0.252990 3.8944444 0.252990 3.8972222 0.249691 3.9000000 0.251340 3.9027778 0.252990 3.9055556 0.252165 3.9083333 0.249691 3.9111111 0.247216 3.9138889 0.244742 3.9166667 0.243918 3.9194444 0.248041 3.9222222 0.248041 3.9250000 0.245567 3.9277778 0.243093 3.9305556 0.242268 3.9333333 0.241443 3.9361111 0.239794 3.9388889 0.241443 3.9416667 0.239794 3.9444444 0.238969 3.9472222 0.238144 3.9500000 0.238144 3.9527778 0.238969 3.9555556 0.241443 3.9583333 0.240619 3.9611111 0.243918 3.9638889 0.243918 3.9666667 0.245567 3.9694444 0.248041 3.9722222 0.252165 3.9750000 0.254639 3.9777778 0.256289 3.9835556 0.300000 4.2442222 0.300000 4.2472222 0.272784 4.2500000 0.273608 4.2527778 0.273608 4.2555556 0.276082 4.2583333 0.275258 4.2611111 0.275258 4.2638889 0.273608 4.2666667 0.273608 4.2694444 0.275258 4.2722222 0.275258 4.2750000 0.275258 4.2777778 0.274433 4.2805556 0.273608 4.2833333 0.273608 4.2861111 0.275258 4.2888889 0.278557 4.2916667 0.275258 4.2944444 0.274433 4.2972222 0.273608 4.3000000 0.275258 4.3027778 0.279381 4.3055556 0.280206 4.3083333 0.281031 4.3111111 0.279381 4.3138889 0.277732 4.3166667 0.276907 4.3194444 0.278557 4.3222222 0.282680 4.3250000 0.282680 4.3277778 0.283505 4.3305556 0.282680 4.3333333 0.285155 4.3361111 0.286804 4.3388889 0.287629 4.3416667 0.285155 4.3444444 0.285155 4.3472222 0.283505 4.3500000 0.283505 4.3527778 0.284330 4.3555556 0.285155 4.3583333 0.281856 4.3611111 0.279381 4.3638889 0.278557 4.3666667 0.280206 4.3694444 0.280206 4.3722222 0.281856 4.3750000 0.281856 4.3777778 0.280206 4.3805556 0.278557 4.3833333 0.276907 4.3861111 0.276082 4.3888889 0.279381 4.3916667 0.278557 4.3944444 0.275258 4.3972222 0.276082 4.4000000 0.276907 4.4027778 0.276907 4.4055556 0.280206 4.4083333 0.277732 4.4111111 0.276082 4.4138889 0.273608 4.4166667 0.275258 4.4194444 0.277732 4.4222222 0.279381 4.4250000 0.277732 4.4277778 0.276082 4.4305556 0.275258 4.4333333 0.273608 4.4361111 0.276082 4.4388889 0.277732 4.4416667 0.277732 4.4444444 0.279381 4.4472222 0.273608 4.4500000 0.271134 4.4527778 0.267835 4.4555556 0.265361 4.4583333 0.262062 4.4611111 0.255464 4.4638889 0.252165 4.4666667 0.253814 4.4694444 0.267835 4.4722222 0.291753 4.4750000 0.314021 4.4777778 0.332165 4.4805556 0.350309 4.4833333 0.369278 4.4861111 0.393196 4.4888889 0.416289 4.4916667 0.431959 4.4944444 0.431134 4.4972222 0.398144 4.5000000 0.338763 4.5027778 0.287629 4.5055556 0.268660 4.5083333 0.269485 4.5111111 0.274433 4.5138889 0.271959 4.5166667 0.272784 4.5194444 0.274433 4.5222222 0.276082 4.5250000 0.274433 4.5277778 0.268660 4.5305556 0.267010 4.5333333 0.267835 4.5361111 0.271134 4.5388889 0.271134 4.5416667 0.270309 4.5444444 0.269485 4.5472222 0.267010 4.5500000 0.267835 4.5527778 0.267010 4.5555556 0.267835 4.5583333 0.268660 4.5611111 0.267835 4.5638889 0.267010 4.5666667 0.267010 4.5694444 0.268660 4.5722222 0.270309 4.5750000 0.269485 4.5777778 0.267835 4.5805556 0.265361 4.5833333 0.265361 4.5861111 0.271134 4.5888889 0.268660 4.5916667 0.269485 4.5944444 0.269485 4.5972222 0.267835 4.6000000 0.267010 4.6027778 0.267835 4.6055556 0.270309 4.6083333 0.268660 4.6111111 0.267835 4.6138889 0.268660 4.6166667 0.267835 4.6194444 0.271134 4.6222222 0.271134 4.6250000 0.269485 4.6277778 0.268660 4.6305556 0.267835 4.6333333 0.268660 4.6361111 0.269485 4.6388889 0.271959 4.6416667 0.271959 4.6444444 0.268660 4.6472222 0.267010 4.6500000 0.267010 4.6527778 0.270309 4.6555556 0.271134 4.6583333 0.267835 4.6611111 0.271134 4.6638889 0.268660 4.6666667 0.268660 4.6694444 0.268660 4.6722222 0.270309 4.6750000 0.268660 4.6777778 0.265361 4.6805556 0.266186 4.6833333 0.267010 4.6861111 0.265361 4.6888889 0.267835 4.6916667 0.266186 4.6944444 0.264536 4.6972222 0.262062 4.7000000 0.264536 4.7027778 0.262887 4.7055556 0.266186 4.7083333 0.264536 4.7111111 0.261237 4.7138889 0.259588 4.7166667 0.259588 4.7194444 0.260412 4.7222222 0.259588 4.7250000 0.261237 4.7277778 0.257113 4.7305556 0.256289 4.7333333 0.255464 4.7361111 0.256289 4.7388889 0.256289 4.7416667 0.255464 4.7444444 0.252990 4.7472222 0.250515 4.7500000 0.251340 4.7527778 0.251340 4.7555556 0.251340 4.7583333 0.249691 4.7611111 0.248866 4.7638889 0.247216 4.7666667 0.246392 4.7694444 0.247216 4.7722222 0.248866 4.7750000 0.247216 4.7777778 0.247216 4.7805556 0.246392 4.7833333 0.248866 4.7861111 0.253814 4.7888889 0.253814 4.7916667 0.253814 4.7944444 0.256289 4.8002222 0.300000 4.8970000 0.300000 4.9000000 0.280206 4.9027778 0.281031 4.9055556 0.282680 4.9083333 0.281856 4.9111111 0.279381 4.9138889 0.281031 4.9166667 0.278557 4.9194444 0.281031 4.9222222 0.284330 4.9250000 0.283505 4.9277778 0.281856 4.9305556 0.281031 4.9333333 0.281031 4.9361111 0.282680 4.9388889 0.283505 4.9416667 0.281856 4.9444444 0.283505 4.9472222 0.283505 4.9500000 0.282680 4.9527778 0.284330 4.9555556 0.284330 4.9583333 0.284330 4.9611111 0.281856 4.9638889 0.281031 4.9666667 0.281856 4.9694444 0.282680 4.9722222 0.282680 4.9750000 0.281031 4.9777778 0.281031 4.9805556 0.277732 4.9833333 0.279381 4.9861111 0.277732 4.9888889 0.279381 4.9916667 0.278557 4.9944444 0.275258 4.9972222 0.274433 5.0000000 0.272784 5.0027778 0.272784 5.0055556 0.271959 5.0083333 0.271134 5.0111111 0.271959 5.0138889 0.271134 5.0166667 0.271959 5.0194444 0.272784 5.0222222 0.273608 5.0250000 0.273608 5.0277778 0.271959 5.0305556 0.270309 5.0333333 0.271959 5.0361111 0.274433 5.0388889 0.274433 5.0416667 0.273608 5.0444444 0.273608 5.0472222 0.271134 5.0500000 0.271959 5.0527778 0.274433 5.0555556 0.275258 5.0583333 0.273608 5.0611111 0.274433 5.0638889 0.272784 5.0666667 0.273608 5.0694444 0.275258 5.0722222 0.275258 5.0750000 0.276082 5.0777778 0.274433 5.0805556 0.272784 5.0833333 0.274433 5.0861111 0.277732 5.0888889 0.278557 5.0916667 0.276082 5.0944444 0.274433 5.0972222 0.273608 5.1000000 0.273608 5.1027778 0.271134 5.1055556 0.268660 5.1083333 0.261237 5.1111111 0.258763 5.1138889 0.251340 5.1166667 0.248041 5.1194444 0.251340 5.1222222 0.268660 5.1250000 0.285979 5.1277778 0.309897 5.1305556 0.328866 5.1333333 0.343711 5.1361111 0.362680 5.1388889 0.380000 5.1416667 0.397320 5.1444444 0.409691 5.1472222 0.409691 5.1500000 0.382474 5.1527778 0.333814 5.1555556 0.287629 5.1583333 0.264536 5.1611111 0.266186 5.1638889 0.270309 5.1666667 0.271134 5.1694444 0.272784 5.1722222 0.276082 5.1750000 0.276082 5.1777778 0.273608 5.1805556 0.272784 5.1833333 0.271959 5.1861111 0.274433 5.1888889 0.274433 5.1916667 0.274433 5.1944444 0.271959 5.1972222 0.271134 5.2000000 0.271959 5.2027778 0.274433 5.2055556 0.274433 5.2083333 0.273608 5.2111111 0.272784 5.2138889 0.270309 5.2166667 0.271134 5.2194444 0.271959 5.2222222 0.273608 5.2250000 0.273608 5.2277778 0.271959 5.2305556 0.270309 5.2333333 0.270309 5.2361111 0.271959 5.2388889 0.272784 5.2416667 0.272784 5.2444444 0.271134 5.2472222 0.270309 5.2500000 0.269485 5.2527778 0.271959 5.2555556 0.273608 5.2583333 0.272784 5.2611111 0.271134 5.2638889 0.271134 5.2666667 0.271134 5.2694444 0.270309 5.2722222 0.271959 5.2750000 0.273608 5.2777778 0.271959 5.2805556 0.270309 5.2833333 0.269485 5.2861111 0.271959 5.2888889 0.273608 5.2916667 0.270309 5.2944444 0.270309 5.2972222 0.269485 5.3000000 0.269485 5.3027778 0.272784 5.3055556 0.274433 5.3083333 0.271959 5.3111111 0.271134 5.3138889 0.267835 5.3166667 0.267835 5.3194444 0.268660 5.3222222 0.271134 5.3250000 0.271134 5.3277778 0.268660 5.3305556 0.268660 5.3333333 0.268660 5.3361111 0.269485 5.3388889 0.268660 5.3416667 0.264536 5.3444444 0.263711 5.3472222 0.264536 5.3500000 0.262887 5.3527778 0.264536 5.3555556 0.267010 5.3583333 0.262062 5.3611111 0.262887 5.3638889 0.259588 5.3666667 0.260412 5.3694444 0.259588 5.3722222 0.263711 5.3750000 0.259588 5.3777778 0.257113 5.3805556 0.253814 5.3833333 0.253814 5.3861111 0.252990 5.3888889 0.255464 5.3916667 0.252990 5.3944444 0.251340 5.3972222 0.249691 5.4000000 0.249691 5.4027778 0.248041 5.4055556 0.249691 5.4083333 0.248866 5.4111111 0.245567 5.4138889 0.246392 5.4166667 0.245567 5.4194444 0.248041 5.4222222 0.248866 5.4250000 0.248041 5.4277778 0.248866 5.4305556 0.247216 5.4333333 0.249691 5.4361111 0.252165 5.4388889 0.254639 5.4416667 0.255464 5.4444444 0.256289 5.4472222 0.256289 5.4530000 0.300000 5.8914444 0.300000 5.8944444 0.263711 5.8972222 0.262887 5.9000000 0.262887 5.9027778 0.266186 5.9055556 0.267010 5.9083333 0.266186 5.9111111 0.266186 5.9138889 0.265361 5.9166667 0.265361 5.9194444 0.267835 5.9222222 0.267835 5.9250000 0.267835 5.9277778 0.267010 5.9305556 0.262887 5.9333333 0.262887 5.9361111 0.266186 5.9388889 0.268660 5.9416667 0.267835 5.9444444 0.268660 5.9472222 0.267010 5.9500000 0.269485 5.9527778 0.270309 5.9555556 0.272784 5.9583333 0.271959 5.9611111 0.270309 5.9638889 0.271134 5.9666667 0.271959 5.9694444 0.272784 5.9722222 0.275258 5.9750000 0.274433 5.9777778 0.272784 5.9805556 0.271959 5.9833333 0.272784 5.9861111 0.272784 5.9888889 0.274433 5.9916667 0.271959 5.9944444 0.270309 5.9972222 0.271959 6.0000000 0.272784 6.0027778 0.273608 6.0055556 0.273608 6.0083333 0.270309 6.0111111 0.268660 6.0138889 0.266186 6.0166667 0.268660 6.0194444 0.268660 6.0222222 0.271959 6.0250000 0.269485 6.0277778 0.268660 6.0305556 0.267835 6.0333333 0.262887 6.0361111 0.264536 6.0388889 0.267010 6.0416667 0.266186 6.0444444 0.266186 6.0472222 0.266186 6.0500000 0.263711 6.0527778 0.265361 6.0555556 0.265361 6.0583333 0.265361 6.0611111 0.264536 6.0638889 0.262887 6.0666667 0.261237 6.0694444 0.262062 6.0722222 0.266186 6.0750000 0.264536 6.0777778 0.262887 6.0805556 0.262887 6.0833333 0.263711 6.0861111 0.263711 6.0888889 0.264536 6.0916667 0.262887 6.0944444 0.262887 6.0972222 0.257938 6.1000000 0.254639 6.1027778 0.252165 6.1055556 0.252165 6.1083333 0.248041 6.1111111 0.245567 6.1138889 0.249691 6.1166667 0.259588 6.1194444 0.281031 6.1222222 0.295876 6.1250000 0.304948 6.1277778 0.313196 6.1305556 0.325567 6.1333333 0.343711 6.1361111 0.363505 6.1388889 0.382474 6.1416667 0.389897 6.1444444 0.374227 6.1472222 0.335464 6.1500000 0.285155 6.1527778 0.246392 6.1555556 0.235670 6.1583333 0.236495 6.1611111 0.239794 6.1638889 0.244742 6.1666667 0.251340 6.1694444 0.252990 6.1722222 0.255464 6.1750000 0.256289 6.1777778 0.255464 6.1805556 0.254639 6.1833333 0.252990 6.1861111 0.256289 6.1888889 0.258763 6.1916667 0.257113 6.1944444 0.257113 6.1972222 0.256289 6.2000000 0.255464 6.2027778 0.256289 6.2055556 0.259588 6.2083333 0.257113 6.2111111 0.257938 6.2138889 0.253814 6.2166667 0.257113 6.2194444 0.258763 6.2222222 0.258763 6.2250000 0.257938 6.2277778 0.257938 6.2305556 0.257113 6.2333333 0.257113 6.2361111 0.257938 6.2388889 0.262887 6.2416667 0.260412 6.2444444 0.259588 6.2472222 0.256289 6.2500000 0.254639 6.2527778 0.258763 6.2555556 0.259588 6.2583333 0.262062 6.2611111 0.260412 6.2638889 0.257938 6.2666667 0.258763 6.2694444 0.258763 6.2722222 0.259588 6.2750000 0.261237 6.2777778 0.260412 6.2805556 0.258763 6.2833333 0.258763 6.2861111 0.259588 6.2888889 0.263711 6.2916667 0.259588 6.2944444 0.259588 6.2972222 0.260412 6.3000000 0.257938 6.3027778 0.259588 6.3055556 0.262887 6.3083333 0.260412 6.3111111 0.258763 6.3138889 0.257113 6.3166667 0.256289 6.3194444 0.257938 6.3222222 0.260412 6.3250000 0.258763 6.3277778 0.258763 6.3305556 0.256289 6.3333333 0.257113 6.3361111 0.257113 6.3388889 0.256289 6.3416667 0.254639 6.3444444 0.255464 6.3472222 0.255464 6.3500000 0.255464 6.3527778 0.255464 6.3555556 0.259588 6.3583333 0.256289 6.3611111 0.256289 6.3638889 0.255464 6.3666667 0.252990 6.3694444 0.257113 6.3722222 0.259588 6.3750000 0.257938 6.3777778 0.256289 6.3805556 0.252990 6.3833333 0.251340 6.3861111 0.250515 6.3888889 0.251340 6.3916667 0.252990 6.3944444 0.247216 6.3972222 0.246392 6.4000000 0.244742 6.4027778 0.244742 6.4055556 0.245567 6.4083333 0.242268 6.4111111 0.243093 6.4138889 0.239794 6.4166667 0.237320 6.4194444 0.238144 6.4222222 0.238144 6.4250000 0.236495 6.4277778 0.236495 6.4305556 0.234021 6.4333333 0.234021 6.4361111 0.234845 6.4388889 0.235670 6.4416667 0.235670 6.4474444 0.300000 6.7358889 0.300000 6.7388889 0.269485 6.7416667 0.267835 6.7444444 0.267010 6.7472222 0.267010 6.7500000 0.266186 6.7527778 0.267835 6.7555556 0.269485 6.7583333 0.268660 6.7611111 0.267835 6.7638889 0.267010 6.7666667 0.267010 6.7694444 0.267010 6.7722222 0.268660 6.7750000 0.267010 6.7777778 0.268660 6.7805556 0.267010 6.7833333 0.267835 6.7861111 0.270309 6.7888889 0.273608 6.7916667 0.270309 6.7944444 0.270309 6.7972222 0.269485 6.8000000 0.270309 6.8027778 0.273608 6.8055556 0.276082 6.8083333 0.274433 6.8111111 0.271959 6.8138889 0.271959 6.8166667 0.274433 6.8194444 0.276082 6.8222222 0.278557 6.8250000 0.277732 6.8277778 0.276907 6.8305556 0.277732 6.8333333 0.276907 6.8361111 0.276907 6.8388889 0.279381 6.8416667 0.278557 6.8444444 0.275258 6.8472222 0.272784 6.8500000 0.272784 6.8527778 0.272784 6.8555556 0.274433 6.8583333 0.275258 6.8611111 0.272784 6.8638889 0.270309 6.8666667 0.267835 6.8694444 0.271134 6.8722222 0.271959 6.8750000 0.271134 6.8777778 0.269485 6.8805556 0.267835 6.8833333 0.268660 6.8861111 0.271134 6.8888889 0.269485 6.8916667 0.268660 6.8944444 0.266186 6.8972222 0.264536 6.9000000 0.264536 6.9027778 0.267835 6.9055556 0.270309 6.9083333 0.268660 6.9111111 0.267010 6.9138889 0.267010 6.9166667 0.264536 6.9194444 0.267010 6.9222222 0.270309 6.9250000 0.267835 6.9277778 0.267010 6.9305556 0.266186 6.9333333 0.265361 6.9361111 0.267010 6.9388889 0.266186 6.9416667 0.261237 6.9444444 0.257113 6.9472222 0.252990 6.9500000 0.250515 6.9527778 0.246392 6.9555556 0.247216 6.9583333 0.252165 6.9611111 0.268660 6.9638889 0.290928 6.9666667 0.308247 6.9694444 0.324742 6.9722222 0.340412 6.9750000 0.356907 6.9777778 0.373402 6.9805556 0.387423 6.9833333 0.398144 6.9861111 0.385773 6.9888889 0.345361 6.9916667 0.285979 6.9944444 0.250515 6.9972222 0.244742 7.0000000 0.252990 7.0027778 0.258763 7.0055556 0.259588 7.0083333 0.261237 7.0111111 0.264536 7.0138889 0.262062 7.0166667 0.262062 7.0194444 0.260412 7.0222222 0.261237 7.0250000 0.261237 7.0277778 0.259588 7.0305556 0.257938 7.0333333 0.258763 7.0361111 0.260412 7.0388889 0.262887 7.0416667 0.262062 7.0444444 0.258763 7.0472222 0.260412 7.0500000 0.257938 7.0527778 0.262062 7.0555556 0.262887 7.0583333 0.262887 7.0611111 0.262887 7.0638889 0.262062 7.0666667 0.260412 7.0694444 0.262887 7.0722222 0.264536 7.0750000 0.264536 7.0777778 0.262887 7.0805556 0.261237 7.0833333 0.260412 7.0861111 0.262887 7.0888889 0.266186 7.0916667 0.265361 7.0944444 0.262887 7.0972222 0.262062 7.1000000 0.261237 7.1027778 0.262887 7.1055556 0.264536 7.1083333 0.263711 7.1111111 0.262062 7.1138889 0.261237 7.1166667 0.262062 7.1194444 0.264536 7.1222222 0.264536 7.1250000 0.264536 7.1277778 0.262887 7.1305556 0.261237 7.1333333 0.261237 7.1361111 0.262062 7.1388889 0.264536 7.1416667 0.262887 7.1444444 0.262887 7.1472222 0.261237 7.1500000 0.259588 7.1527778 0.260412 7.1555556 0.262887 7.1583333 0.265361 7.1611111 0.262062 7.1638889 0.262062 7.1666667 0.259588 7.1694444 0.263711 7.1722222 0.262887 7.1750000 0.261237 7.1777778 0.259588 7.1805556 0.258763 7.1833333 0.258763 7.1861111 0.260412 7.1888889 0.260412 7.1916667 0.259588 7.1944444 0.258763 7.1972222 0.255464 7.2000000 0.255464 7.2027778 0.256289 7.2055556 0.257113 7.2083333 0.253814 7.2111111 0.251340 7.2138889 0.251340 7.2166667 0.248041 7.2194444 0.248866 7.2222222 0.249691 7.2250000 0.248866 7.2277778 0.246392 7.2305556 0.245567 7.2333333 0.242268 7.2361111 0.243918 7.2388889 0.244742 7.2416667 0.242268 7.2444444 0.242268 7.2472222 0.238969 7.2500000 0.239794 7.2527778 0.241443 7.2555556 0.244742 7.2583333 0.241443 7.2611111 0.239794 7.2638889 0.238969 7.2666667 0.240619 7.2694444 0.244742 7.2722222 0.248041 7.2750000 0.248041 7.2777778 0.249691 7.2805556 0.252990 7.2833333 0.252990 7.2861111 0.255464 7.2918889 0.300000 7.5470000 0.300000 7.5500000 0.266186 7.5527778 0.269485 7.5555556 0.273608 7.5583333 0.271959 7.5611111 0.268660 7.5638889 0.268660 7.5666667 0.268660 7.5694444 0.270309 7.5722222 0.271959 7.5750000 0.273608 7.5777778 0.271959 7.5805556 0.269485 7.5833333 0.267835 7.5861111 0.270309 7.5888889 0.271134 7.5916667 0.271959 7.5944444 0.271959 7.5972222 0.267835 7.6000000 0.267010 7.6027778 0.270309 7.6055556 0.271959 7.6083333 0.271134 7.6111111 0.270309 7.6138889 0.270309 7.6166667 0.271959 7.6194444 0.274433 7.6222222 0.277732 7.6250000 0.276082 7.6277778 0.273608 7.6305556 0.273608 7.6333333 0.273608 7.6361111 0.276907 7.6388889 0.280206 7.6416667 0.280206 7.6444444 0.278557 7.6472222 0.278557 7.6500000 0.279381 7.6527778 0.279381 7.6555556 0.281031 7.6583333 0.281856 7.6611111 0.278557 7.6638889 0.276082 7.6666667 0.274433 7.6694444 0.276907 7.6722222 0.276907 7.6750000 0.276082 7.6777778 0.275258 7.6805556 0.273608 7.6833333 0.272784 7.6861111 0.273608 7.6888889 0.275258 7.6916667 0.272784 7.6944444 0.269485 7.6972222 0.270309 7.7000000 0.269485 7.7027778 0.271959 7.7055556 0.274433 7.7083333 0.271134 7.7111111 0.268660 7.7138889 0.267835 7.7166667 0.267835 7.7194444 0.270309 7.7222222 0.271134 7.7250000 0.270309 7.7277778 0.270309 7.7305556 0.268660 7.7333333 0.271959 7.7361111 0.270309 7.7388889 0.271134 7.7416667 0.270309 7.7444444 0.269485 7.7472222 0.267010 7.7500000 0.267835 7.7527778 0.267010 7.7555556 0.262887 7.7583333 0.257938 7.7611111 0.251340 7.7638889 0.245567 7.7666667 0.243918 7.7694444 0.249691 7.7722222 0.267835 7.7750000 0.289278 7.7777778 0.311546 7.7805556 0.329691 7.7833333 0.347010 7.7861111 0.368454 7.7888889 0.391546 7.7916667 0.410515 7.7944444 0.415464 7.7972222 0.391546 7.8000000 0.334639 7.8027778 0.279381 7.8055556 0.256289 7.8083333 0.260412 7.8111111 0.264536 7.8138889 0.264536 7.8166667 0.262062 7.8194444 0.263711 7.8222222 0.265361 7.8250000 0.261237 7.8277778 0.261237 7.8305556 0.261237 7.8333333 0.262062 7.8361111 0.262887 7.8388889 0.265361 7.8416667 0.264536 7.8444444 0.262887 7.8472222 0.260412 7.8500000 0.258763 7.8527778 0.262062 7.8555556 0.262062 7.8583333 0.262887 7.8611111 0.262062 7.8638889 0.260412 7.8666667 0.261237 7.8694444 0.262062 7.8722222 0.262887 7.8750000 0.262062 7.8777778 0.259588 7.8805556 0.261237 7.8833333 0.261237 7.8861111 0.263711 7.8888889 0.263711 7.8916667 0.262887 7.8944444 0.262062 7.8972222 0.259588 7.9000000 0.262887 7.9027778 0.263711 7.9055556 0.265361 7.9083333 0.265361 7.9111111 0.263711 7.9138889 0.260412 7.9166667 0.261237 7.9194444 0.262887 7.9222222 0.265361 7.9250000 0.267010 7.9277778 0.262887 7.9305556 0.262887 7.9333333 0.262887 7.9361111 0.262887 7.9388889 0.264536 7.9416667 0.264536 7.9444444 0.261237 7.9472222 0.260412 7.9500000 0.260412 7.9527778 0.261237 7.9555556 0.263711 7.9583333 0.262887 7.9611111 0.261237 7.9638889 0.259588 7.9666667 0.259588 7.9694444 0.262062 7.9722222 0.262887 7.9750000 0.263711 7.9777778 0.259588 7.9805556 0.258763 7.9833333 0.257938 7.9861111 0.257938 7.9888889 0.260412 7.9916667 0.258763 7.9944444 0.257113 7.9972222 0.254639 8.0000000 0.252990 8.0027778 0.254639 8.0055556 0.253814 8.0083333 0.252165 8.0111111 0.250515 8.0138889 0.249691 8.0166667 0.248041 8.0194444 0.248866 8.0222222 0.248041 8.0250000 0.246392 8.0277778 0.244742 8.0305556 0.242268 8.0333333 0.243093 8.0361111 0.243918 8.0388889 0.244742 8.0416667 0.242268 8.0444444 0.240619 8.0472222 0.238969 8.0500000 0.239794 8.0527778 0.240619 8.0555556 0.243093 8.0583333 0.243918 8.0611111 0.242268 8.0638889 0.241443 8.0666667 0.243093 8.0694444 0.246392 8.0722222 0.249691 8.0750000 0.250515 8.0777778 0.252990 8.0805556 0.252990 8.0833333 0.253814 8.0861111 0.256289 8.0888889 0.262062 8.0916667 0.261237 8.0944444 0.260412 8.0972222 0.259588 8.1030000 0.300000 8.3358889 0.300000 8.3388889 0.275258 8.3416667 0.273608 8.3444444 0.272784 8.3472222 0.270309 8.3500000 0.270309 8.3527778 0.272784 8.3555556 0.275258 8.3583333 0.274433 8.3611111 0.274433 8.3638889 0.271959 8.3666667 0.271134 8.3694444 0.272784 8.3722222 0.274433 8.3750000 0.275258 8.3777778 0.274433 8.3805556 0.272784 8.3833333 0.272784 8.3861111 0.273608 8.3888889 0.273608 8.3916667 0.272784 8.3944444 0.271959 8.3972222 0.271134 8.4000000 0.273608 8.4027778 0.277732 8.4055556 0.276907 8.4083333 0.276082 8.4111111 0.276907 8.4138889 0.276082 8.4166667 0.277732 8.4194444 0.279381 8.4222222 0.281031 8.4250000 0.281031 8.4277778 0.279381 8.4305556 0.278557 8.4333333 0.282680 8.4361111 0.284330 8.4388889 0.284330 8.4416667 0.284330 8.4444444 0.284330 8.4472222 0.284330 8.4500000 0.281031 8.4527778 0.280206 8.4555556 0.280206 8.4583333 0.278557 8.4611111 0.277732 8.4638889 0.279381 8.4666667 0.276907 8.4694444 0.277732 8.4722222 0.280206 8.4750000 0.275258 8.4777778 0.275258 8.4805556 0.274433 8.4833333 0.273608 8.4861111 0.276082 8.4888889 0.276907 8.4916667 0.276082 8.4944444 0.276082 8.4972222 0.273608 8.5000000 0.272784 8.5027778 0.274433 8.5055556 0.276082 8.5083333 0.274433 8.5111111 0.274433 8.5138889 0.271959 8.5166667 0.272784 8.5194444 0.273608 8.5222222 0.274433 8.5250000 0.273608 8.5277778 0.271959 8.5305556 0.271959 8.5333333 0.272784 8.5361111 0.272784 8.5388889 0.276082 8.5416667 0.271959 8.5444444 0.268660 8.5472222 0.262887 8.5500000 0.258763 8.5527778 0.255464 8.5555556 0.253814 8.5583333 0.249691 8.5611111 0.252165 8.5638889 0.267010 8.5666667 0.287629 8.5694444 0.306598 8.5722222 0.322268 8.5750000 0.335464 8.5777778 0.352784 8.5805556 0.371753 8.5833333 0.389072 8.5861111 0.395670 8.5888889 0.376701 8.5916667 0.323918 8.5944444 0.274433 8.5972222 0.252990 8.6000000 0.258763 8.6027778 0.267010 8.6055556 0.270309 8.6083333 0.268660 8.6111111 0.268660 8.6138889 0.269485 8.6166667 0.267835 8.6194444 0.269485 8.6222222 0.271134 8.6250000 0.268660 8.6277778 0.267835 8.6305556 0.266186 8.6333333 0.266186 8.6361111 0.269485 8.6388889 0.272784 8.6416667 0.269485 8.6444444 0.268660 8.6472222 0.265361 8.6500000 0.265361 8.6527778 0.267010 8.6555556 0.268660 8.6583333 0.269485 8.6611111 0.267835 8.6638889 0.265361 8.6666667 0.265361 8.6694444 0.268660 8.6722222 0.270309 8.6750000 0.268660 8.6777778 0.267835 8.6805556 0.264536 8.6833333 0.264536 8.6861111 0.267835 8.6888889 0.269485 8.6916667 0.270309 8.6944444 0.269485 8.6972222 0.267010 8.7000000 0.266186 8.7027778 0.268660 8.7055556 0.270309 8.7083333 0.269485 8.7111111 0.267835 8.7138889 0.267835 8.7166667 0.267835 8.7194444 0.268660 8.7222222 0.269485 8.7250000 0.267835 8.7277778 0.267835 8.7305556 0.266186 8.7333333 0.267010 8.7361111 0.268660 8.7388889 0.269485 8.7416667 0.267835 8.7444444 0.265361 8.7472222 0.264536 8.7500000 0.264536 8.7527778 0.266186 8.7555556 0.268660 8.7583333 0.268660 8.7611111 0.266186 8.7638889 0.263711 8.7666667 0.264536 8.7694444 0.266186 8.7722222 0.265361 8.7750000 0.263711 8.7777778 0.262062 8.7805556 0.260412 8.7833333 0.257938 8.7861111 0.260412 8.7888889 0.262887 8.7916667 0.262062 8.7944444 0.258763 8.7972222 0.258763 8.8000000 0.257113 8.8027778 0.257113 8.8055556 0.257938 8.8083333 0.257113 8.8111111 0.252990 8.8138889 0.251340 8.8166667 0.250515 8.8194444 0.252990 8.8222222 0.253814 8.8250000 0.252165 8.8277778 0.249691 8.8305556 0.248041 8.8333333 0.247216 8.8361111 0.248866 8.8388889 0.249691 8.8416667 0.248866 8.8444444 0.247216 8.8472222 0.246392 8.8500000 0.244742 8.8527778 0.247216 8.8555556 0.250515 8.8583333 0.250515 8.8611111 0.250515 8.8638889 0.252990 8.8666667 0.253814 8.8694444 0.257113 8.8722222 0.260412 8.8750000 0.261237 8.8777778 0.262887 8.8805556 0.262062 8.8833333 0.262887 8.8861111 0.268660 8.8918889 0.300000 9.1081111 0.300000 9.1111111 0.266186 9.1138889 0.265361 9.1166667 0.264536 9.1194444 0.263711 9.1222222 0.266186 9.1250000 0.263711 9.1277778 0.262062 9.1305556 0.262887 9.1333333 0.262887 9.1361111 0.267835 9.1388889 0.267835 9.1416667 0.263711 9.1444444 0.262062 9.1472222 0.258763 9.1500000 0.260412 9.1527778 0.262887 9.1555556 0.265361 9.1583333 0.265361 9.1611111 0.262062 9.1638889 0.261237 9.1666667 0.260412 9.1694444 0.265361 9.1722222 0.267835 9.1750000 0.267835 9.1777778 0.268660 9.1805556 0.267010 9.1833333 0.267835 9.1861111 0.270309 9.1888889 0.270309 9.1916667 0.268660 9.1944444 0.268660 9.1972222 0.270309 9.2000000 0.269485 9.2027778 0.272784 9.2055556 0.272784 9.2083333 0.271134 9.2111111 0.269485 9.2138889 0.267010 9.2166667 0.267835 9.2194444 0.269485 9.2222222 0.270309 9.2250000 0.267835 9.2277778 0.267835 9.2305556 0.264536 9.2333333 0.267010 9.2361111 0.265361 9.2388889 0.267835 9.2416667 0.262887 9.2444444 0.261237 9.2472222 0.259588 9.2500000 0.259588 9.2527778 0.263711 9.2555556 0.262062 9.2583333 0.263711 9.2611111 0.262887 9.2638889 0.260412 9.2666667 0.262887 9.2694444 0.265361 9.2722222 0.263711 9.2750000 0.262062 9.2777778 0.262062 9.2805556 0.260412 9.2833333 0.259588 9.2861111 0.259588 9.2888889 0.260412 9.2916667 0.261237 9.2944444 0.260412 9.2972222 0.257938 9.3000000 0.257938 9.3027778 0.258763 9.3055556 0.262062 9.3083333 0.260412 9.3111111 0.258763 9.3138889 0.256289 9.3166667 0.252165 9.3194444 0.248866 9.3222222 0.249691 9.3250000 0.244742 9.3277778 0.241443 9.3305556 0.244742 9.3333333 0.255464 9.3361111 0.273608 9.3388889 0.291753 9.3416667 0.301649 9.3444444 0.310722 9.3472222 0.322268 9.3500000 0.339588 9.3527778 0.358557 9.3555556 0.365155 9.3583333 0.342062 9.3611111 0.297526 9.3638889 0.251340 9.3666667 0.233196 9.3694444 0.235670 9.3722222 0.243918 9.3750000 0.249691 9.3777778 0.248866 9.3805556 0.251340 9.3833333 0.251340 9.3861111 0.253814 9.3888889 0.255464 9.3916667 0.256289 9.3944444 0.252990 9.3972222 0.252165 9.4000000 0.252165 9.4027778 0.252165 9.4055556 0.252990 9.4083333 0.252165 9.4111111 0.252165 9.4138889 0.252990 9.4166667 0.252990 9.4194444 0.252990 9.4222222 0.256289 9.4250000 0.256289 9.4277778 0.254639 9.4305556 0.252990 9.4333333 0.253814 9.4361111 0.255464 9.4388889 0.255464 9.4416667 0.254639 9.4444444 0.255464 9.4472222 0.252990 9.4500000 0.250515 9.4527778 0.253814 9.4555556 0.254639 9.4583333 0.252990 9.4611111 0.252990 9.4638889 0.251340 9.4666667 0.252165 9.4694444 0.252990 9.4722222 0.254639 9.4750000 0.256289 9.4777778 0.252990 9.4805556 0.250515 9.4833333 0.249691 9.4861111 0.252990 9.4888889 0.255464 9.4916667 0.253814 9.4944444 0.254639 9.4972222 0.252165 9.5000000 0.253814 9.5027778 0.252165 9.5055556 0.253814 9.5083333 0.253814 9.5111111 0.252990 9.5138889 0.252990 9.5166667 0.252990 9.5194444 0.251340 9.5222222 0.254639 9.5250000 0.253814 9.5277778 0.252165 9.5305556 0.251340 9.5333333 0.251340 9.5361111 0.252990 9.5388889 0.254639 9.5416667 0.251340 9.5444444 0.249691 9.5472222 0.249691 9.5500000 0.247216 9.5527778 0.249691 9.5555556 0.251340 9.5583333 0.250515 9.5611111 0.250515 9.5638889 0.247216 9.5666667 0.247216 9.5694444 0.248866 9.5722222 0.249691 9.5750000 0.248041 9.5777778 0.245567 9.5805556 0.243093 9.5833333 0.241443 9.5861111 0.243918 9.5888889 0.244742 9.5916667 0.242268 9.5944444 0.238969 9.5972222 0.237320 9.6000000 0.237320 9.6027778 0.238144 9.6055556 0.236495 9.6083333 0.233196 9.6111111 0.233196 9.6138889 0.230722 9.6166667 0.229072 9.6194444 0.231546 9.6222222 0.232371 9.6250000 0.231546 9.6277778 0.229897 9.6305556 0.229897 9.6333333 0.229897 9.6361111 0.233196 9.6388889 0.236495 9.6416667 0.235670 9.6444444 0.236495 9.6472222 0.236495 9.6500000 0.237320 9.6527778 0.242268 9.6555556 0.247216 9.6583333 0.248041 9.6641111 0.300000 9.9470000 0.300000 9.9500000 0.260412 9.9527778 0.262887 9.9555556 0.266186 9.9583333 0.264536 9.9611111 0.264536 9.9638889 0.263711 9.9666667 0.262062 9.9694444 0.262887 9.9722222 0.264536 9.9750000 0.262887 9.9777778 0.263711 9.9805556 0.263711 9.9833333 0.262887 9.9861111 0.267835 9.9888889 0.267835 9.9916667 0.266186 9.9944444 0.267010 9.9972222 0.267010 10.0000000 0.267835 10.0027778 0.268660 10.0055556 0.271959 10.0083333 0.271959 10.0111111 0.270309 10.0138889 0.270309 10.0166667 0.269485 10.0194444 0.271959 10.0222222 0.272784 10.0250000 0.270309 10.0277778 0.271134 10.0305556 0.269485 10.0333333 0.271134 10.0361111 0.271959 10.0388889 0.275258 10.0416667 0.275258 10.0444444 0.274433 10.0472222 0.270309 10.0500000 0.270309 10.0527778 0.271959 10.0555556 0.271134 10.0583333 0.270309 10.0611111 0.268660 10.0638889 0.267835 10.0666667 0.267010 10.0694444 0.268660 10.0722222 0.269485 10.0750000 0.267010 10.0777778 0.267835 10.0805556 0.264536 10.0833333 0.265361 10.0861111 0.267010 10.0888889 0.267835 10.0916667 0.266186 10.0944444 0.263711 10.0972222 0.264536 10.1000000 0.262887 10.1027778 0.262887 10.1055556 0.265361 10.1083333 0.266186 10.1111111 0.265361 10.1138889 0.262887 10.1166667 0.262062 10.1194444 0.264536 10.1222222 0.267010 10.1250000 0.264536 10.1277778 0.263711 10.1305556 0.262887 10.1333333 0.265361 10.1361111 0.265361 10.1388889 0.267010 10.1416667 0.265361 10.1444444 0.264536 10.1472222 0.262887 10.1500000 0.261237 10.1527778 0.260412 10.1555556 0.257938 10.1583333 0.252165 10.1611111 0.248866 10.1638889 0.244742 10.1666667 0.240619 10.1694444 0.242268 10.1722222 0.252990 10.1750000 0.271134 10.1777778 0.291753 10.1805556 0.312371 10.1833333 0.331340 10.1861111 0.351959 10.1888889 0.370928 10.1916667 0.389897 10.1944444 0.408041 10.1972222 0.408041 10.2000000 0.383299 10.2027778 0.334639 10.2055556 0.285155 10.2083333 0.254639 10.2111111 0.252165 10.2138889 0.256289 10.2166667 0.258763 10.2194444 0.257938 10.2222222 0.262062 10.2250000 0.262062 10.2277778 0.258763 10.2305556 0.257938 10.2333333 0.257938 10.2361111 0.258763 10.2388889 0.261237 10.2416667 0.258763 10.2444444 0.258763 10.2472222 0.256289 10.2500000 0.257938 10.2527778 0.258763 10.2555556 0.260412 10.2583333 0.259588 10.2611111 0.257938 10.2638889 0.257938 10.2666667 0.256289 10.2694444 0.260412 10.2722222 0.260412 10.2750000 0.257938 10.2777778 0.257938 10.2805556 0.256289 10.2833333 0.257113 10.2861111 0.258763 10.2888889 0.257938 10.2916667 0.257938 10.2944444 0.257938 10.2972222 0.257938 10.3000000 0.258763 10.3027778 0.259588 10.3055556 0.262887 10.3083333 0.262062 10.3111111 0.259588 10.3138889 0.257938 10.3166667 0.257113 10.3194444 0.259588 10.3222222 0.259588 10.3250000 0.259588 10.3277778 0.260412 10.3305556 0.258763 10.3333333 0.259588 10.3361111 0.259588 10.3388889 0.260412 10.3416667 0.260412 10.3444444 0.258763 10.3472222 0.256289 10.3500000 0.257938 10.3527778 0.260412 10.3555556 0.260412 10.3583333 0.260412 10.3611111 0.257938 10.3638889 0.257113 10.3666667 0.257113 10.3694444 0.257938 10.3722222 0.257938 10.3750000 0.258763 10.3777778 0.257113 10.3805556 0.254639 10.3833333 0.253814 10.3861111 0.253814 10.3888889 0.255464 10.3916667 0.256289 10.3944444 0.252990 10.3972222 0.252165 10.4000000 0.253814 10.4027778 0.253814 10.4055556 0.254639 10.4083333 0.251340 10.4111111 0.249691 10.4138889 0.248866 10.4166667 0.248866 10.4194444 0.247216 10.4222222 0.249691 10.4250000 0.247216 10.4277778 0.243093 10.4305556 0.242268 10.4333333 0.241443 10.4361111 0.241443 10.4388889 0.242268 10.4416667 0.242268 10.4444444 0.240619 10.4472222 0.237320 10.4500000 0.236495 10.4527778 0.237320 10.4555556 0.237320 10.4583333 0.238144 10.4611111 0.236495 10.4638889 0.234845 10.4666667 0.237320 10.4694444 0.235670 10.4722222 0.237320 10.4750000 0.236495 10.4777778 0.237320 10.4805556 0.238144 10.4833333 0.238969 10.4861111 0.244742 10.4888889 0.248041 10.4916667 0.248866 10.4944444 0.250515 10.4972222 0.248866 10.5030000 0.300000 10.8025556 0.300000 10.8055556 0.265361 10.8083333 0.266186 10.8111111 0.265361 10.8138889 0.262062 10.8166667 0.262887 10.8194444 0.264536 10.8222222 0.265361 10.8250000 0.265361 10.8277778 0.262887 10.8305556 0.262887 10.8333333 0.262887 10.8361111 0.266186 10.8388889 0.267010 10.8416667 0.265361 10.8444444 0.263711 10.8472222 0.265361 10.8500000 0.264536 10.8527778 0.268660 10.8555556 0.268660 10.8583333 0.269485 10.8611111 0.269485 10.8638889 0.269485 10.8666667 0.267010 10.8694444 0.269485 10.8722222 0.271959 10.8750000 0.271959 10.8777778 0.274433 10.8805556 0.273608 10.8833333 0.273608 10.8861111 0.271134 10.8888889 0.272784 10.8916667 0.273608 10.8944444 0.273608 10.8972222 0.272784 10.9000000 0.271959 10.9027778 0.272784 10.9055556 0.273608 10.9083333 0.271134 10.9111111 0.267835 10.9138889 0.267010 10.9166667 0.266186 10.9194444 0.267835 10.9222222 0.267835 10.9250000 0.266186 10.9277778 0.267010 10.9305556 0.263711 10.9333333 0.262887 10.9361111 0.263711 10.9388889 0.265361 10.9416667 0.264536 10.9444444 0.263711 10.9472222 0.262062 10.9500000 0.260412 10.9527778 0.264536 10.9555556 0.264536 10.9583333 0.262887 10.9611111 0.261237 10.9638889 0.260412 10.9666667 0.258763 10.9694444 0.262062 10.9722222 0.266186 10.9750000 0.262887 10.9777778 0.262062 10.9805556 0.260412 10.9833333 0.258763 10.9861111 0.262062 10.9888889 0.264536 10.9916667 0.262062 10.9944444 0.257938 10.9972222 0.253814 11.0000000 0.249691 11.0027778 0.248041 11.0055556 0.246392 11.0083333 0.245567 11.0111111 0.242268 11.0138889 0.238144 11.0166667 0.231546 11.0194444 0.231546 11.0222222 0.238144 11.0250000 0.247216 11.0277778 0.261237 11.0305556 0.279381 11.0333333 0.300000 11.0361111 0.318969 11.0388889 0.333814 11.0416667 0.351959 11.0444444 0.369278 11.0472222 0.386598 11.0500000 0.400619 11.0527778 0.401443 11.0555556 0.377526 11.0583333 0.322268 11.0611111 0.272784 11.0638889 0.246392 11.0666667 0.249691 11.0694444 0.255464 11.0722222 0.257113 11.0750000 0.257113 11.0777778 0.258763 11.0805556 0.255464 11.0833333 0.254639 11.0861111 0.257113 11.0888889 0.257113 11.0916667 0.254639 11.0944444 0.255464 11.0972222 0.255464 11.1000000 0.255464 11.1027778 0.256289 11.1055556 0.257113 11.1083333 0.255464 11.1111111 0.255464 11.1138889 0.253814 11.1166667 0.252990 11.1194444 0.256289 11.1222222 0.257938 11.1250000 0.257113 11.1277778 0.255464 11.1305556 0.254639 11.1333333 0.252990 11.1361111 0.255464 11.1388889 0.256289 11.1416667 0.256289 11.1444444 0.257113 11.1472222 0.254639 11.1500000 0.255464 11.1527778 0.256289 11.1555556 0.257938 11.1583333 0.257113 11.1611111 0.257938 11.1638889 0.254639 11.1666667 0.256289 11.1694444 0.257113 11.1722222 0.257938 11.1750000 0.257938 11.1777778 0.257113 11.1805556 0.256289 11.1833333 0.253814 11.1861111 0.257113 11.1888889 0.260412 11.1916667 0.258763 11.1944444 0.256289 11.1972222 0.255464 11.2000000 0.253814 11.2027778 0.256289 11.2055556 0.258763 11.2083333 0.257938 11.2111111 0.257113 11.2138889 0.255464 11.2166667 0.253814 11.2194444 0.254639 11.2222222 0.257113 11.2250000 0.255464 11.2277778 0.252990 11.2305556 0.253814 11.2333333 0.253814 11.2361111 0.254639 11.2388889 0.253814 11.2416667 0.254639 11.2444444 0.255464 11.2472222 0.251340 11.2500000 0.249691 11.2527778 0.251340 11.2555556 0.253814 11.2583333 0.250515 11.2611111 0.248866 11.2638889 0.248866 11.2666667 0.248041 11.2694444 0.248041 11.2722222 0.248866 11.2750000 0.248041 11.2777778 0.245567 11.2805556 0.242268 11.2833333 0.242268 11.2861111 0.241443 11.2888889 0.244742 11.2916667 0.243093 11.2944444 0.241443 11.2972222 0.238969 11.3000000 0.238144 11.3027778 0.236495 11.3055556 0.237320 11.3083333 0.235670 11.3111111 0.235670 11.3138889 0.233196 11.3166667 0.232371 11.3194444 0.234845 11.3222222 0.234845 11.3250000 0.234845 11.3277778 0.234021 11.3305556 0.232371 11.3333333 0.233196 11.3361111 0.236495 11.3388889 0.238144 11.3416667 0.239794 11.3444444 0.239794 11.3472222 0.239794 11.3500000 0.241443 11.3527778 0.246392 11.3585556 0.300000 11.6247778 0.300000 11.6277778 0.259588 11.6305556 0.260412 11.6333333 0.260412 11.6361111 0.259588 11.6388889 0.261237 11.6416667 0.261237 11.6444444 0.259588 11.6472222 0.255464 11.6500000 0.257113 11.6527778 0.258763 11.6555556 0.258763 11.6583333 0.257938 11.6611111 0.258763 11.6638889 0.255464 11.6666667 0.255464 11.6694444 0.258763 11.6722222 0.262062 11.6750000 0.261237 11.6777778 0.260412 11.6805556 0.261237 11.6833333 0.261237 11.6861111 0.262062 11.6888889 0.262887 11.6916667 0.264536 11.6944444 0.261237 11.6972222 0.262887 11.7000000 0.263711 11.7027778 0.266186 11.7055556 0.266186 11.7083333 0.266186 11.7111111 0.266186 11.7138889 0.265361 11.7166667 0.262887 11.7194444 0.265361 11.7222222 0.267835 11.7250000 0.267010 11.7277778 0.264536 11.7305556 0.261237 11.7333333 0.262062 11.7361111 0.262887 11.7388889 0.262887 11.7416667 0.259588 11.7444444 0.258763 11.7472222 0.257113 11.7500000 0.256289 11.7527778 0.262062 11.7555556 0.261237 11.7583333 0.260412 11.7611111 0.258763 11.7638889 0.253814 11.7666667 0.255464 11.7694444 0.256289 11.7722222 0.257938 11.7750000 0.256289 11.7777778 0.254639 11.7805556 0.253814 11.7833333 0.252165 11.7861111 0.254639 11.7888889 0.256289 11.7916667 0.255464 11.7944444 0.255464 11.7972222 0.253814 11.8000000 0.253814 11.8027778 0.255464 11.8055556 0.256289 11.8083333 0.253814 11.8111111 0.252990 11.8138889 0.251340 11.8166667 0.251340 11.8194444 0.253814 11.8222222 0.256289 11.8250000 0.253814 11.8277778 0.250515 11.8305556 0.246392 11.8333333 0.241443 11.8361111 0.240619 11.8388889 0.241443 11.8416667 0.236495 11.8444444 0.234021 11.8472222 0.241443 11.8500000 0.255464 11.8527778 0.271959 11.8555556 0.287629 11.8583333 0.298351 11.8611111 0.308247 11.8638889 0.322268 11.8666667 0.342062 11.8694444 0.359381 11.8722222 0.364330 11.8750000 0.345361 11.8777778 0.306598 11.8805556 0.262887 11.8833333 0.234021 11.8861111 0.232371 11.8888889 0.240619 11.8916667 0.243093 11.8944444 0.243918 11.8972222 0.243093 11.9000000 0.243093 11.9027778 0.245567 11.9055556 0.249691 11.9083333 0.248041 11.9111111 0.248041 11.9138889 0.246392 11.9166667 0.244742 11.9194444 0.245567 11.9222222 0.248866 11.9250000 0.248041 11.9277778 0.247216 11.9305556 0.247216 11.9333333 0.247216 11.9361111 0.247216 11.9388889 0.248866 11.9416667 0.246392 11.9444444 0.245567 11.9472222 0.243093 11.9500000 0.243918 11.9527778 0.247216 11.9555556 0.248866 11.9583333 0.248866 11.9611111 0.247216 11.9638889 0.246392 11.9666667 0.246392 11.9694444 0.248041 11.9722222 0.248866 11.9750000 0.248866 11.9777778 0.248041 11.9805556 0.245567 11.9833333 0.247216 11.9861111 0.248041 11.9888889 0.252165 11.9916667 0.249691 11.9944444 0.249691 11.9972222 0.247216 12.0000000 0.247216 12.0027778 0.246392 12.0055556 0.247216 12.0083333 0.248041 12.0111111 0.247216 12.0138889 0.246392 12.0166667 0.245567 12.0194444 0.248041 12.0222222 0.248866 12.0250000 0.248041 12.0277778 0.245567 12.0305556 0.243918 12.0333333 0.244742 12.0361111 0.248041 12.0388889 0.249691 12.0416667 0.247216 12.0444444 0.246392 12.0472222 0.247216 12.0500000 0.246392 12.0527778 0.245567 12.0555556 0.247216 12.0583333 0.248866 12.0611111 0.246392 12.0638889 0.246392 12.0666667 0.245567 12.0694444 0.246392 12.0722222 0.245567 12.0750000 0.245567 12.0777778 0.244742 12.0805556 0.244742 12.0833333 0.243093 12.0861111 0.244742 12.0888889 0.243918 12.0916667 0.243093 12.0944444 0.242268 12.0972222 0.240619 12.1000000 0.237320 12.1027778 0.239794 12.1055556 0.240619 12.1083333 0.238969 12.1111111 0.237320 12.1138889 0.233196 12.1166667 0.229897 12.1194444 0.230722 12.1222222 0.233196 12.1250000 0.232371 12.1277778 0.229897 12.1305556 0.227423 12.1333333 0.226598 12.1361111 0.227423 12.1388889 0.229072 12.1416667 0.229072 12.1444444 0.227423 12.1472222 0.225773 12.1500000 0.223299 12.1527778 0.227423 12.1555556 0.228247 12.1583333 0.226598 12.1611111 0.223299 12.1638889 0.225773 12.1666667 0.226598 12.1694444 0.230722 12.1722222 0.234021 12.1750000 0.236495 12.1807778 0.300000 12.4525556 0.300000 12.4555556 0.247216 12.4583333 0.246392 12.4611111 0.243093 12.4638889 0.242268 12.4666667 0.242268 12.4694444 0.243093 12.4722222 0.245567 12.4750000 0.248041 12.4777778 0.245567 12.4805556 0.243918 12.4833333 0.243093 12.4861111 0.243918 12.4888889 0.247216 12.4916667 0.245567 12.4944444 0.243918 12.4972222 0.242268 12.5000000 0.244742 12.5027778 0.246392 12.5055556 0.248866 12.5083333 0.249691 12.5111111 0.247216 12.5138889 0.248041 12.5166667 0.247216 12.5194444 0.248866 12.5222222 0.252165 12.5250000 0.251340 12.5277778 0.249691 12.5305556 0.249691 12.5333333 0.248866 12.5361111 0.251340 12.5388889 0.253814 12.5416667 0.253814 12.5444444 0.252990 12.5472222 0.252165 12.5500000 0.251340 12.5527778 0.252165 12.5555556 0.252990 12.5583333 0.251340 12.5611111 0.250515 12.5638889 0.248041 12.5666667 0.248041 12.5694444 0.249691 12.5722222 0.251340 12.5750000 0.249691 12.5777778 0.248866 12.5805556 0.243093 12.5833333 0.244742 12.5861111 0.243918 12.5888889 0.244742 12.5916667 0.245567 12.5944444 0.245567 12.5972222 0.243093 12.6000000 0.243093 12.6027778 0.243918 12.6055556 0.244742 12.6083333 0.245567 12.6111111 0.244742 12.6138889 0.244742 12.6166667 0.245567 12.6194444 0.246392 12.6222222 0.248866 12.6250000 0.246392 12.6277778 0.246392 12.6305556 0.245567 12.6333333 0.244742 12.6361111 0.244742 12.6388889 0.248041 12.6416667 0.247216 12.6444444 0.245567 12.6472222 0.246392 12.6500000 0.244742 12.6527778 0.246392 12.6555556 0.245567 12.6583333 0.242268 12.6611111 0.238144 12.6638889 0.234845 12.6666667 0.229897 12.6694444 0.229897 12.6722222 0.229072 12.6750000 0.229897 12.6777778 0.239794 12.6805556 0.255464 12.6833333 0.272784 12.6861111 0.289278 12.6888889 0.302474 12.6916667 0.313196 12.6944444 0.329691 12.6972222 0.348660 12.7000000 0.364330 12.7027778 0.366804 12.7055556 0.351959 12.7083333 0.304124 12.7111111 0.257113 12.7138889 0.227423 12.7166667 0.223299 12.7194444 0.231546 12.7222222 0.238144 12.7250000 0.240619 12.7277778 0.242268 12.7305556 0.242268 12.7333333 0.242268 12.7361111 0.244742 12.7388889 0.246392 12.7416667 0.246392 12.7444444 0.243918 12.7472222 0.245567 12.7500000 0.244742 12.7527778 0.246392 12.7555556 0.246392 12.7583333 0.244742 12.7611111 0.246392 12.7638889 0.242268 12.7666667 0.243918 12.7694444 0.243918 12.7722222 0.248866 12.7750000 0.247216 12.7777778 0.246392 12.7805556 0.243093 12.7833333 0.243918 12.7861111 0.245567 12.7888889 0.248041 12.7916667 0.248866 12.7944444 0.247216 12.7972222 0.244742 12.8000000 0.244742 12.8027778 0.246392 12.8055556 0.248041 12.8083333 0.246392 12.8111111 0.245567 12.8138889 0.246392 12.8166667 0.245567 12.8194444 0.248041 12.8222222 0.247216 12.8250000 0.248866 12.8277778 0.247216 12.8305556 0.244742 12.8333333 0.245567 12.8361111 0.248041 12.8388889 0.248041 12.8416667 0.248041 12.8444444 0.247216 12.8472222 0.245567 12.8500000 0.245567 12.8527778 0.248041 12.8555556 0.248866 12.8583333 0.249691 12.8611111 0.247216 12.8638889 0.244742 12.8666667 0.244742 12.8694444 0.243093 12.8722222 0.246392 12.8750000 0.245567 12.8777778 0.245567 12.8805556 0.244742 12.8833333 0.244742 12.8861111 0.245567 12.8888889 0.246392 12.8916667 0.245567 12.8944444 0.244742 12.8972222 0.241443 12.9000000 0.241443 12.9027778 0.242268 12.9055556 0.245567 12.9083333 0.243918 12.9111111 0.240619 12.9138889 0.239794 12.9166667 0.239794 12.9194444 0.238969 12.9222222 0.242268 12.9250000 0.241443 12.9277778 0.238969 12.9305556 0.237320 12.9333333 0.235670 12.9361111 0.236495 12.9388889 0.237320 12.9416667 0.235670 12.9444444 0.234845 12.9472222 0.230722 12.9500000 0.229072 12.9527778 0.230722 12.9555556 0.232371 12.9583333 0.229897 12.9611111 0.229072 12.9638889 0.225773 12.9666667 0.224124 12.9694444 0.226598 12.9722222 0.224948 12.9750000 0.225773 12.9777778 0.225773 12.9805556 0.222474 12.9833333 0.223299 12.9861111 0.224124 12.9888889 0.227423 12.9916667 0.226598 12.9944444 0.228247 12.9972222 0.230722 13.0000000 0.234021 13.0027778 0.237320 13.0085556 0.300000 13.2747778 0.300000 13.2777778 0.255464 13.2805556 0.255464 13.2833333 0.254639 13.2861111 0.256289 13.2888889 0.258763 13.2916667 0.258763 13.2944444 0.257113 13.2972222 0.256289 13.3000000 0.254639 13.3027778 0.256289 13.3055556 0.257938 13.3083333 0.258763 13.3111111 0.256289 13.3138889 0.257113 13.3166667 0.256289 13.3194444 0.258763 13.3222222 0.261237 13.3250000 0.257113 13.3277778 0.257113 13.3305556 0.258763 13.3333333 0.258763 13.3361111 0.260412 13.3388889 0.263711 13.3416667 0.264536 13.3444444 0.262062 13.3472222 0.260412 13.3500000 0.262887 13.3527778 0.263711 13.3555556 0.267835 13.3583333 0.267010 13.3611111 0.265361 13.3638889 0.267010 13.3666667 0.264536 13.3694444 0.268660 13.3722222 0.267835 13.3750000 0.267835 13.3777778 0.268660 13.3805556 0.265361 13.3833333 0.265361 13.3861111 0.267010 13.3888889 0.265361 13.3916667 0.262887 13.3944444 0.263711 13.3972222 0.262062 13.4000000 0.261237 13.4027778 0.262887 13.4055556 0.263711 13.4083333 0.261237 13.4111111 0.260412 13.4138889 0.262062 13.4166667 0.258763 13.4194444 0.257938 13.4222222 0.259588 13.4250000 0.260412 13.4277778 0.259588 13.4305556 0.258763 13.4333333 0.257938 13.4361111 0.260412 13.4388889 0.261237 13.4416667 0.260412 13.4444444 0.259588 13.4472222 0.257938 13.4500000 0.257113 13.4527778 0.257938 13.4555556 0.262062 13.4583333 0.260412 13.4611111 0.259588 13.4638889 0.257938 13.4666667 0.256289 13.4694444 0.256289 13.4722222 0.258763 13.4750000 0.259588 13.4777778 0.258763 13.4805556 0.255464 13.4833333 0.250515 13.4861111 0.247216 13.4888889 0.245567 13.4916667 0.241443 13.4944444 0.236495 13.4972222 0.238969 13.5000000 0.247216 13.5027778 0.268660 13.5055556 0.291753 13.5083333 0.312371 13.5111111 0.331340 13.5138889 0.350309 13.5166667 0.371753 13.5194444 0.394021 13.5222222 0.408866 13.5250000 0.406392 13.5277778 0.375052 13.5305556 0.319794 13.5333333 0.271134 13.5361111 0.251340 13.5388889 0.257113 13.5416667 0.257938 13.5444444 0.254639 13.5472222 0.253814 13.5500000 0.253814 13.5527778 0.254639 13.5555556 0.253814 13.5583333 0.253814 13.5611111 0.252990 13.5638889 0.251340 13.5666667 0.250515 13.5694444 0.252165 13.5722222 0.252990 13.5750000 0.251340 13.5777778 0.250515 13.5805556 0.248866 13.5833333 0.251340 13.5861111 0.249691 13.5888889 0.252165 13.5916667 0.252990 13.5944444 0.250515 13.5972222 0.249691 13.6000000 0.250515 13.6027778 0.252165 13.6055556 0.252990 13.6083333 0.252165 13.6111111 0.252165 13.6138889 0.251340 13.6166667 0.252165 13.6194444 0.252165 13.6222222 0.252990 13.6250000 0.252990 13.6277778 0.252165 13.6305556 0.248866 13.6333333 0.249691 13.6361111 0.252990 13.6388889 0.253814 13.6416667 0.253814 13.6444444 0.252990 13.6472222 0.251340 13.6500000 0.249691 13.6527778 0.252165 13.6555556 0.255464 13.6583333 0.253814 13.6611111 0.253814 13.6638889 0.251340 13.6666667 0.249691 13.6694444 0.251340 13.6722222 0.253814 13.6750000 0.253814 13.6777778 0.252990 13.6805556 0.251340 13.6833333 0.251340 13.6861111 0.251340 13.6888889 0.252165 13.6916667 0.251340 13.6944444 0.250515 13.6972222 0.248866 13.7000000 0.250515 13.7027778 0.250515 13.7055556 0.251340 13.7083333 0.249691 13.7111111 0.248041 13.7138889 0.245567 13.7166667 0.246392 13.7194444 0.246392 13.7222222 0.248041 13.7250000 0.246392 13.7277778 0.245567 13.7305556 0.243093 13.7333333 0.242268 13.7361111 0.243093 13.7388889 0.244742 13.7416667 0.241443 13.7444444 0.237320 13.7472222 0.238144 13.7500000 0.236495 13.7527778 0.238144 13.7555556 0.238969 13.7583333 0.237320 13.7611111 0.234845 13.7638889 0.232371 13.7666667 0.232371 13.7694444 0.233196 13.7722222 0.234021 13.7750000 0.233196 13.7777778 0.230722 13.7805556 0.229072 13.7833333 0.229072 13.7861111 0.230722 13.7888889 0.232371 13.7916667 0.233196 13.7944444 0.233196 13.7972222 0.232371 13.8000000 0.233196 13.8027778 0.236495 13.8055556 0.238969 13.8083333 0.241443 13.8111111 0.243093 13.8138889 0.244742 13.8166667 0.247216 13.8194444 0.250515 13.8222222 0.253814 13.8250000 0.255464 13.8307778 0.300000 14.0692222 0.300000 14.0722222 0.262062 14.0750000 0.261237 14.0777778 0.259588 14.0805556 0.260412 14.0833333 0.262062 14.0861111 0.262887 14.0888889 0.261237 14.0916667 0.262062 14.0944444 0.262062 14.0972222 0.260412 14.1000000 0.259588 14.1027778 0.262062 14.1055556 0.262887 14.1083333 0.262887 14.1111111 0.262062 14.1138889 0.259588 14.1166667 0.260412 14.1194444 0.262062 14.1222222 0.264536 14.1250000 0.265361 14.1277778 0.262887 14.1305556 0.262887 14.1333333 0.262062 14.1361111 0.264536 14.1388889 0.267010 14.1416667 0.266186 14.1444444 0.265361 14.1472222 0.265361 14.1500000 0.267010 14.1527778 0.268660 14.1555556 0.270309 14.1583333 0.269485 14.1611111 0.267835 14.1638889 0.267010 14.1666667 0.267835 14.1694444 0.269485 14.1722222 0.274433 14.1750000 0.272784 14.1777778 0.271959 14.1805556 0.270309 14.1833333 0.271134 14.1861111 0.270309 14.1888889 0.273608 14.1916667 0.269485 14.1944444 0.268660 14.1972222 0.266186 14.2000000 0.266186 14.2027778 0.267835 14.2055556 0.268660 14.2083333 0.267010 14.2111111 0.266186 14.2138889 0.262887 14.2166667 0.262062 14.2194444 0.262887 14.2222222 0.267010 14.2250000 0.264536 14.2277778 0.262887 14.2305556 0.262062 14.2333333 0.259588 14.2361111 0.261237 14.2388889 0.264536 14.2416667 0.262887 14.2444444 0.261237 14.2472222 0.262062 14.2500000 0.261237 14.2527778 0.263711 14.2555556 0.263711 14.2583333 0.262887 14.2611111 0.262887 14.2638889 0.262887 14.2666667 0.262062 14.2694444 0.262887 14.2722222 0.262887 14.2750000 0.259588 14.2777778 0.253814 14.2805556 0.249691 14.2833333 0.244742 14.2861111 0.242268 14.2888889 0.240619 14.2916667 0.240619 14.2944444 0.248041 14.2972222 0.263711 14.3000000 0.284330 14.3027778 0.304124 14.3055556 0.323093 14.3083333 0.340412 14.3111111 0.360206 14.3138889 0.376701 14.3166667 0.393196 14.3194444 0.395670 14.3222222 0.368454 14.3250000 0.312371 14.3277778 0.265361 14.3305556 0.245567 14.3333333 0.250515 14.3361111 0.255464 14.3388889 0.257113 14.3416667 0.257113 14.3444444 0.257938 14.3472222 0.256289 14.3500000 0.256289 14.3527778 0.257938 14.3555556 0.258763 14.3583333 0.257113 14.3611111 0.256289 14.3638889 0.257113 14.3666667 0.254639 14.3694444 0.257938 14.3722222 0.257938 14.3750000 0.257113 14.3777778 0.254639 14.3805556 0.254639 14.3833333 0.254639 14.3861111 0.257113 14.3888889 0.257113 14.3916667 0.257938 14.3944444 0.254639 14.3972222 0.252990 14.4000000 0.253814 14.4027778 0.256289 14.4055556 0.258763 14.4083333 0.258763 14.4111111 0.257113 14.4138889 0.254639 14.4166667 0.252990 14.4194444 0.254639 14.4222222 0.258763 14.4250000 0.257938 14.4277778 0.257938 14.4305556 0.255464 14.4333333 0.255464 14.4361111 0.257938 14.4388889 0.258763 14.4416667 0.258763 14.4444444 0.257938 14.4472222 0.257938 14.4500000 0.258763 14.4527778 0.257938 14.4555556 0.261237 14.4583333 0.260412 14.4611111 0.257938 14.4638889 0.257938 14.4666667 0.256289 14.4694444 0.257113 14.4722222 0.258763 14.4750000 0.258763 14.4777778 0.257113 14.4805556 0.254639 14.4833333 0.253814 14.4861111 0.254639 14.4888889 0.257938 14.4916667 0.256289 14.4944444 0.252990 14.4972222 0.253814 14.5000000 0.251340 14.5027778 0.251340 14.5055556 0.254639 14.5083333 0.252990 14.5111111 0.251340 14.5138889 0.249691 14.5166667 0.249691 14.5194444 0.249691 14.5222222 0.249691 14.5250000 0.248866 14.5277778 0.248041 14.5305556 0.245567 14.5333333 0.245567 14.5361111 0.248041 14.5388889 0.248041 14.5416667 0.247216 14.5444444 0.243918 14.5472222 0.239794 14.5500000 0.240619 14.5527778 0.240619 14.5555556 0.243093 14.5583333 0.239794 14.5611111 0.239794 14.5638889 0.236495 14.5666667 0.236495 14.5694444 0.235670 14.5722222 0.238144 14.5750000 0.239794 14.5777778 0.236495 14.5805556 0.234021 14.5833333 0.234845 14.5861111 0.235670 14.5888889 0.237320 14.5916667 0.236495 14.5944444 0.234021 14.5972222 0.233196 14.6000000 0.234021 14.6027778 0.234845 14.6055556 0.238969 14.6083333 0.238969 14.6111111 0.239794 14.6138889 0.238969 14.6166667 0.242268 14.6194444 0.244742 14.6252222 0.300000 14.8664444 0.300000 14.8694444 0.252990 14.8722222 0.252990 14.8750000 0.252990 14.8777778 0.252165 14.8805556 0.250515 14.8833333 0.251340 14.8861111 0.251340 14.8888889 0.254639 14.8916667 0.253814 14.8944444 0.253814 14.8972222 0.250515 14.9000000 0.250515 14.9027778 0.252990 14.9055556 0.254639 14.9083333 0.255464 14.9111111 0.251340 14.9138889 0.251340 14.9166667 0.249691 14.9194444 0.252165 14.9222222 0.255464 14.9250000 0.253814 14.9277778 0.252165 14.9305556 0.252165 14.9333333 0.254639 14.9361111 0.257938 14.9388889 0.258763 14.9416667 0.257113 14.9444444 0.255464 14.9472222 0.253814 14.9500000 0.255464 14.9527778 0.256289 14.9555556 0.259588 14.9583333 0.259588 14.9611111 0.257938 14.9638889 0.258763 14.9666667 0.260412 14.9694444 0.261237 14.9722222 0.262062 14.9750000 0.262062 14.9777778 0.258763 14.9805556 0.256289 14.9833333 0.254639 14.9861111 0.254639 14.9888889 0.257113 14.9916667 0.257938 14.9944444 0.256289 14.9972222 0.252165 15.0000000 0.251340 15.0027778 0.251340 15.0055556 0.253814 15.0083333 0.255464 15.0111111 0.252165 15.0138889 0.250515 15.0166667 0.251340 15.0194444 0.250515 15.0222222 0.250515 15.0250000 0.250515 15.0277778 0.249691 15.0305556 0.251340 15.0333333 0.251340 15.0361111 0.251340 15.0388889 0.250515 15.0416667 0.250515 15.0444444 0.250515 15.0472222 0.250515 15.0500000 0.248041 15.0527778 0.249691 15.0555556 0.253814 15.0583333 0.252165 15.0611111 0.251340 15.0638889 0.246392 15.0666667 0.243918 15.0694444 0.240619 15.0722222 0.239794 15.0750000 0.237320 15.0777778 0.231546 15.0805556 0.225773 15.0833333 0.230722 15.0861111 0.243093 15.0888889 0.259588 15.0916667 0.273608 15.0944444 0.285155 15.0972222 0.290103 15.1000000 0.299175 15.1027778 0.308247 15.1055556 0.327216 15.1083333 0.343711 15.1111111 0.362680 15.1138889 0.375876 15.1166667 0.381649 15.1194444 0.380000 15.1222222 0.355258 15.1250000 0.307423 15.1277778 0.259588 15.1305556 0.229072 15.1333333 0.220825 15.1361111 0.229072 15.1388889 0.234021 15.1416667 0.237320 15.1444444 0.239794 15.1472222 0.241443 15.1500000 0.239794 15.1527778 0.243093 15.1555556 0.243093 15.1583333 0.243918 15.1611111 0.243093 15.1638889 0.239794 15.1666667 0.240619 15.1694444 0.240619 15.1722222 0.243918 15.1750000 0.242268 15.1777778 0.243093 15.1805556 0.239794 15.1833333 0.240619 15.1861111 0.240619 15.1888889 0.243093 15.1916667 0.243093 15.1944444 0.240619 15.1972222 0.240619 15.2000000 0.238969 15.2027778 0.241443 15.2055556 0.243093 15.2083333 0.243093 15.2111111 0.241443 15.2138889 0.240619 15.2166667 0.240619 15.2194444 0.241443 15.2222222 0.242268 15.2250000 0.243918 15.2277778 0.243093 15.2305556 0.240619 15.2333333 0.243093 15.2361111 0.241443 15.2388889 0.244742 15.2416667 0.242268 15.2444444 0.239794 15.2472222 0.240619 15.2500000 0.238969 15.2527778 0.240619 15.2555556 0.243093 15.2583333 0.243918 15.2611111 0.241443 15.2638889 0.238144 15.2666667 0.237320 15.2694444 0.239794 15.2722222 0.240619 15.2750000 0.241443 15.2777778 0.241443 15.2805556 0.242268 15.2833333 0.239794 15.2861111 0.241443 15.2888889 0.240619 15.2916667 0.239794 15.2944444 0.236495 15.2972222 0.235670 15.3000000 0.237320 15.3027778 0.238969 15.3055556 0.239794 15.3083333 0.236495 15.3111111 0.236495 15.3138889 0.230722 15.3166667 0.233196 15.3194444 0.235670 15.3222222 0.235670 15.3250000 0.236495 15.3277778 0.234845 15.3305556 0.233196 15.3333333 0.234021 15.3361111 0.234845 15.3388889 0.234845 15.3416667 0.233196 15.3444444 0.229897 15.3472222 0.227423 15.3500000 0.224948 15.3527778 0.224948 15.3555556 0.226598 15.3583333 0.223299 15.3611111 0.223299 15.3638889 0.220825 15.3666667 0.220000 15.3694444 0.220000 15.3722222 0.220000 15.3750000 0.219175 15.3777778 0.217526 15.3805556 0.215876 15.3833333 0.213402 15.3861111 0.215876 15.3888889 0.218351 15.3916667 0.217526 15.3944444 0.215052 15.3972222 0.215876 15.4000000 0.219175 15.4027778 0.221649 15.4055556 0.225773 15.4083333 0.225773 15.4111111 0.225773 15.4138889 0.227423 15.4166667 0.229072 15.4224444 0.300000 15.6581111 0.300000 15.6611111 0.243918 15.6638889 0.242268 15.6666667 0.240619 15.6694444 0.243918 15.6722222 0.243918 15.6750000 0.244742 15.6777778 0.243918 15.6805556 0.242268 15.6833333 0.242268 15.6861111 0.243918 15.6888889 0.245567 15.6916667 0.245567 15.6944444 0.243918 15.6972222 0.243093 15.7000000 0.243093 15.7027778 0.243093 15.7055556 0.244742 15.7083333 0.247216 15.7111111 0.244742 15.7138889 0.243918 15.7166667 0.243093 15.7194444 0.246392 15.7222222 0.250515 15.7250000 0.248041 15.7277778 0.248041 15.7305556 0.249691 15.7333333 0.250515 15.7361111 0.253814 15.7388889 0.255464 15.7416667 0.252165 15.7444444 0.252165 15.7472222 0.251340 15.7500000 0.252165 15.7527778 0.254639 15.7555556 0.257938 15.7583333 0.256289 15.7611111 0.254639 15.7638889 0.253814 15.7666667 0.252990 15.7694444 0.253814 15.7722222 0.255464 15.7750000 0.252990 15.7777778 0.249691 15.7805556 0.249691 15.7833333 0.249691 15.7861111 0.251340 15.7888889 0.251340 15.7916667 0.251340 15.7944444 0.248041 15.7972222 0.246392 15.8000000 0.246392 15.8027778 0.248866 15.8055556 0.249691 15.8083333 0.250515 15.8111111 0.248866 15.8138889 0.246392 15.8166667 0.246392 15.8194444 0.246392 15.8222222 0.249691 15.8250000 0.249691 15.8277778 0.246392 15.8305556 0.247216 15.8333333 0.246392 15.8361111 0.248866 15.8388889 0.248866 15.8416667 0.248041 15.8444444 0.247216 15.8472222 0.246392 15.8500000 0.247216 15.8527778 0.248041 15.8555556 0.249691 15.8583333 0.250515 15.8611111 0.246392 15.8638889 0.244742 15.8666667 0.242268 15.8694444 0.241443 15.8722222 0.237320 15.8750000 0.231546 15.8777778 0.229072 15.8805556 0.224948 15.8833333 0.232371 15.8861111 0.249691 15.8888889 0.273608 15.8916667 0.292577 15.8944444 0.305773 15.8972222 0.319794 15.9000000 0.340412 15.9027778 0.363505 15.9055556 0.381649 15.9083333 0.378351 15.9111111 0.348660 15.9138889 0.293402 15.9166667 0.242268 15.9194444 0.227423 15.9222222 0.231546 15.9250000 0.237320 15.9277778 0.240619 15.9305556 0.239794 15.9333333 0.241443 15.9361111 0.243918 15.9388889 0.243918 15.9416667 0.244742 15.9444444 0.242268 15.9472222 0.238969 15.9500000 0.240619 15.9527778 0.241443 15.9555556 0.241443 15.9583333 0.242268 15.9611111 0.242268 15.9638889 0.241443 15.9666667 0.242268 15.9694444 0.242268 15.9722222 0.243918 15.9750000 0.243093 15.9777778 0.243093 15.9805556 0.242268 15.9833333 0.243093 15.9861111 0.244742 15.9888889 0.244742 15.9916667 0.245567 15.9944444 0.243093 15.9972222 0.243093 16.0000000 0.243918 16.0027778 0.244742 16.0055556 0.247216 16.0083333 0.244742 16.0111111 0.245567 16.0138889 0.243918 16.0166667 0.243918 16.0194444 0.244742 16.0222222 0.246392 16.0250000 0.246392 16.0277778 0.243918 16.0305556 0.243093 16.0333333 0.243093 16.0361111 0.247216 16.0388889 0.247216 16.0416667 0.245567 16.0444444 0.243093 16.0472222 0.244742 16.0500000 0.243918 16.0527778 0.245567 16.0555556 0.246392 16.0583333 0.245567 16.0611111 0.243918 16.0638889 0.243093 16.0666667 0.242268 16.0694444 0.244742 16.0722222 0.246392 16.0750000 0.243918 16.0777778 0.244742 16.0805556 0.241443 16.0833333 0.240619 16.0861111 0.241443 16.0888889 0.242268 16.0916667 0.243093 16.0944444 0.241443 16.0972222 0.238144 16.1000000 0.239794 16.1027778 0.238144 16.1055556 0.238144 16.1083333 0.239794 16.1111111 0.238144 16.1138889 0.236495 16.1166667 0.235670 16.1194444 0.237320 16.1222222 0.238969 16.1250000 0.237320 16.1277778 0.235670 16.1305556 0.233196 16.1333333 0.229897 16.1361111 0.230722 16.1388889 0.229897 16.1416667 0.229897 16.1444444 0.228247 16.1472222 0.226598 16.1500000 0.225773 16.1527778 0.224124 16.1555556 0.224948 16.1583333 0.222474 16.1611111 0.221649 16.1638889 0.219175 16.1666667 0.219175 16.1694444 0.221649 16.1722222 0.223299 16.1750000 0.222474 16.1777778 0.220825 16.1805556 0.220000 16.1833333 0.222474 16.1861111 0.223299 16.1888889 0.229072 16.1916667 0.229072 16.1944444 0.230722 16.1972222 0.230722 16.2000000 0.235670 16.2027778 0.238144 16.2055556 0.239794 16.2083333 0.242268 16.2141111 0.300000 16.4111111 0.300000)
.include "C:/Users/kadhi/OneDrive/Desktop/amux/verilogLearning/Leaky-Integrate-Fire---SNN-model-on-FPGA/experiments/frontend_optimization/complete_frontend_v9b/inverter.spice"
.include "C:/Users/kadhi/OneDrive/Desktop/amux/verilogLearning/Leaky-Integrate-Fire---SNN-model-on-FPGA/experiments/frontend_optimization/complete_frontend_v9b/bias_gen.spice"
.include "C:/Users/kadhi/OneDrive/Desktop/amux/verilogLearning/Leaky-Integrate-Fire---SNN-model-on-FPGA/experiments/frontend_optimization/complete_frontend_v9b/rpeak_detector.spice"
.include "C:/Users/kadhi/OneDrive/Desktop/amux/verilogLearning/Leaky-Integrate-Fire---SNN-model-on-FPGA/experiments/frontend_optimization/complete_frontend_v9b/rpeak_hold.spice"
.include "C:/Users/kadhi/OneDrive/Desktop/amux/verilogLearning/Leaky-Integrate-Fire---SNN-model-on-FPGA/experiments/frontend_optimization/complete_frontend_v9b/pulse_gen.spice"
.include "C:/Users/kadhi/OneDrive/Desktop/amux/verilogLearning/Leaky-Integrate-Fire---SNN-model-on-FPGA/experiments/frontend_optimization/complete_frontend_v9b/delay_timer.spice"
.include "C:/Users/kadhi/OneDrive/Desktop/amux/verilogLearning/Leaky-Integrate-Fire---SNN-model-on-FPGA/experiments/frontend_optimization/complete_frontend_v9b/edge_buffer.spice"
.include "C:/Users/kadhi/OneDrive/Desktop/amux/verilogLearning/Leaky-Integrate-Fire---SNN-model-on-FPGA/experiments/frontend_optimization/complete_frontend_v9b/pwave_predictor.spice"
.include "C:/Users/kadhi/OneDrive/Desktop/amux/verilogLearning/Leaky-Integrate-Fire---SNN-model-on-FPGA/experiments/frontend_optimization/complete_frontend_v9b/rr_timing.spice"
.include "C:/Users/kadhi/OneDrive/Desktop/amux/verilogLearning/Leaky-Integrate-Fire---SNN-model-on-FPGA/experiments/frontend_optimization/complete_frontend_v9b/beat_instability.spice"
.include "C:/Users/kadhi/OneDrive/Desktop/amux/verilogLearning/Leaky-Integrate-Fire---SNN-model-on-FPGA/experiments/frontend_optimization/complete_frontend_v9b/pwave_diff.spice"
.include "C:/Users/kadhi/OneDrive/Desktop/amux/verilogLearning/Leaky-Integrate-Fire---SNN-model-on-FPGA/experiments/frontend_optimization/complete_frontend_v9b/qrs_width.spice"
.include "C:/Users/kadhi/OneDrive/Desktop/amux/verilogLearning/Leaky-Integrate-Fire---SNN-model-on-FPGA/experiments/frontend_optimization/complete_frontend_v9b/qrs_slope.spice"
.include "C:/Users/kadhi/OneDrive/Desktop/amux/verilogLearning/Leaky-Integrate-Fire---SNN-model-on-FPGA/experiments/frontend_optimization/complete_frontend_v9b/qrs_symmetry.spice"

Xbias vbias vref vdd vss bias_gen
.ic V(xbias.iref)=0.3
Vthresh rpeak_threshold 0 0.373196
Xrpk ecg_l0 rpeak_threshold rpeak_level vdd vss vbias rpeak_detector
Xhold rpeak_level rpeak_level_held vdd vss vbias rpeak_hold
.ic V(xhold.hold_cap)=0
Xeb_rpk_in rpeak_level_held rpeak_level_sharp vdd vss edge_buffer
Xpg_rpk rpeak_level_sharp rpeak_pulse_raw vdd vss vbias pulse_gen
Xeb_rpk rpeak_pulse_raw rpeak_pulse vdd vss edge_buffer

Vth14 vth_14_node 0 0.334355
Vth69 vth_69_node 0 0.449812
Vth83 vth_83_node 0 0.442616
Vth300 vth_300_node 0 0.331528
Vth10 vth_10_node 0 0.384313
Vth_rpk_del vth_rpk_del_node 0 0.481000
Xdt rpeak_pulse trig_s14_level trig_s69_level trig_wid_level trig_bi_level trig_rr_level trig_rpk_del_level dt_sf_out vdd vss vbias vth_14_node vth_69_node vth_83_node vth_300_node vth_10_node vth_rpk_del_node delay_timer

Xeb_s14 trig_s14_level s14_sharp vdd vss edge_buffer
Xpg_s14 s14_sharp trig_s14 vdd vss vbias pulse_gen
Xeb_s69 trig_s69_level s69_sharp vdd vss edge_buffer
Xpg_s69 s69_sharp trig_s69 vdd vss vbias pulse_gen
Xeb_wid trig_wid_level wid_sharp vdd vss edge_buffer
Xpg_wid wid_sharp trig_wid vdd vss vbias pulse_gen
Xeb_bi trig_bi_level bi_sharp vdd vss edge_buffer
Xpg_bi bi_sharp trig_bi_copy vdd vss vbias pulse_gen
Xeb_rr trig_rr_level rr_sharp vdd vss edge_buffer
Xpg_rr rr_sharp trig_rr_copy vdd vss vbias pulse_gen

Bvb vth_pw_base_node 0 V = V(rr_ewma) + 0.0454
Bvp vth_pw_peak_node 0 V = V(rr_ewma) + 0.037
Bvc vth_rr_cap_node 0 V = V(rr_ewma) + 0.022
Xpw_pred rr_timer rr_ewma trig_pw_base_cmp trig_pw_peak_cmp trig_rr_cap_cmp vth_pw_base_node vth_pw_peak_node vth_rr_cap_node vdd vss vbias pwave_predictor

Xeb_pwb trig_pw_base_cmp pwb_sharp vdd vss edge_buffer
Xpg_pwb pwb_sharp trig_pw_base vdd vss vbias pulse_gen
Xeb_pwp trig_pw_peak_cmp pwp_sharp vdd vss edge_buffer
Xpg_pwp pwp_sharp trig_pw_peak vdd vss vbias pulse_gen
Xeb_rrc trig_rr_cap_cmp rrc_sharp vdd vss edge_buffer
Xpg_rrc rrc_sharp trig_rr_cap vdd vss vbias pulse_gen

Xrr ecg_l0 trig_rr_cap rpeak_pulse trig_rr_copy f1 f2 rr_timer rr_ewma vdd vss vbias rr_timing
Xbi0 ecg_l0 rpeak_pulse trig_bi_copy f3 vdd vss vbias beat_instability
Xbi1 ecg_l1 rpeak_pulse trig_bi_copy f4 vdd vss vbias beat_instability
Xpw ecg_l0 trig_pw_base trig_pw_peak f5 vdd vss vbias pwave_diff
Xwid ecg_l0 trig_wid f6 vdd vss qrs_width
Xslp ecg_l0 trig_s14 trig_s69 f7 vdd vss vbias qrs_slope
Xsym ecg_l0 rpeak_pulse f8 vdd vss qrs_symmetry

.ic V(xrr.ewma_node)=0.371240
.ic V(xrr.esamp_node)=0.371240
.ic V(xrr.prev_node)=0.371240
.ic V(xbi0.prev_node)=0.3
.ic V(xbi0.esamp_node)=0.3
.ic V(xbi1.prev_node)=0.3
.ic V(xbi1.esamp_node)=0.3
.ic V(xdt.timer_node)=0
.ic V(xdt.timer2)=0
.ic V(rpeak_pulse_raw)=0

.tran 0.5m 16.4111 UIC
.meas tran trpk_0 WHEN V(rpeak_pulse)=0.45 RISE=1 TD=0.4500000
.meas tran trpk_1 WHEN V(rpeak_pulse)=0.45 RISE=1 TD=1.2611111
.meas tran trpk_2 WHEN V(rpeak_pulse)=0.45 RISE=1 TD=2.0500000
.meas tran trpk_3 WHEN V(rpeak_pulse)=0.45 RISE=1 TD=2.8416667
.meas tran trpk_4 WHEN V(rpeak_pulse)=0.45 RISE=1 TD=3.6305556
.meas tran trpk_5 WHEN V(rpeak_pulse)=0.45 RISE=1 TD=4.4472222
.meas tran trpk_6 WHEN V(rpeak_pulse)=0.45 RISE=1 TD=5.1000000
.meas tran trpk_7 WHEN V(rpeak_pulse)=0.45 RISE=1 TD=6.0944444
.meas tran trpk_8 WHEN V(rpeak_pulse)=0.45 RISE=1 TD=6.9388889
.meas tran trpk_9 WHEN V(rpeak_pulse)=0.45 RISE=1 TD=7.7500000
.meas tran trpk_10 WHEN V(rpeak_pulse)=0.45 RISE=1 TD=8.5388889
.meas tran trpk_11 WHEN V(rpeak_pulse)=0.45 RISE=1 TD=9.3111111
.meas tran trpk_12 WHEN V(rpeak_pulse)=0.45 RISE=1 TD=10.1500000
.meas tran trpk_13 WHEN V(rpeak_pulse)=0.45 RISE=1 TD=11.0055556
.meas tran trpk_14 WHEN V(rpeak_pulse)=0.45 RISE=1 TD=11.8277778
.meas tran trpk_15 WHEN V(rpeak_pulse)=0.45 RISE=1 TD=12.6555556
.meas tran trpk_16 WHEN V(rpeak_pulse)=0.45 RISE=1 TD=13.4777778
.meas tran trpk_17 WHEN V(rpeak_pulse)=0.45 RISE=1 TD=14.2722222
.meas tran trpk_18 WHEN V(rpeak_pulse)=0.45 RISE=1 TD=15.0694444
.meas tran trpk_19 WHEN V(rpeak_pulse)=0.45 RISE=1 TD=15.8611111
.meas tran tpwb_5 WHEN V(trig_pw_base)=0.45 RISE=1 TD=4.0972222
.meas tran tpwp_5 WHEN V(trig_pw_peak)=0.45 RISE=1 TD=4.0972222
.meas tran trrc_5 WHEN V(trig_rr_cap)=0.45 RISE=1 TD=4.0972222
.meas tran ewma_5 FIND V(rr_ewma) AT=4.4772222
.meas tran tmr_5 FIND V(rr_timer) AT=4.4772222
.meas tran ecg_at_rpk_5 FIND V(ecg_l0) AT=4.4972222
.meas tran tmr_pwb_5 FIND V(rr_timer) AT=4.9440000
.meas tran thr_pwb_5 FIND V(vth_pw_base_node) AT=4.9440000
.meas tran f5_5 FIND V(f5) AT=4.5972222
.meas tran f3_5 FIND V(f3) AT=4.5972222
.meas tran f8_5 FIND V(f8) AT=4.5972222
.meas tran tpwb_6 WHEN V(trig_pw_base)=0.45 RISE=1 TD=4.7500000
.meas tran tpwp_6 WHEN V(trig_pw_peak)=0.45 RISE=1 TD=4.7500000
.meas tran trrc_6 WHEN V(trig_rr_cap)=0.45 RISE=1 TD=4.7500000
.meas tran ewma_6 FIND V(rr_ewma) AT=5.1300000
.meas tran tmr_6 FIND V(rr_timer) AT=5.1300000
.meas tran ecg_at_rpk_6 FIND V(ecg_l0) AT=5.1500000
.meas tran tmr_pwb_6 FIND V(rr_timer) AT=5.9384444
.meas tran thr_pwb_6 FIND V(vth_pw_base_node) AT=5.9384444
.meas tran f5_6 FIND V(f5) AT=5.2500000
.meas tran f3_6 FIND V(f3) AT=5.2500000
.meas tran f8_6 FIND V(f8) AT=5.2500000
.meas tran tpwb_7 WHEN V(trig_pw_base)=0.45 RISE=1 TD=5.7444444
.meas tran tpwp_7 WHEN V(trig_pw_peak)=0.45 RISE=1 TD=5.7444444
.meas tran trrc_7 WHEN V(trig_rr_cap)=0.45 RISE=1 TD=5.7444444
.meas tran ewma_7 FIND V(rr_ewma) AT=6.1244444
.meas tran tmr_7 FIND V(rr_timer) AT=6.1244444
.meas tran ecg_at_rpk_7 FIND V(ecg_l0) AT=6.1444444
.meas tran tmr_pwb_7 FIND V(rr_timer) AT=6.7828889
.meas tran thr_pwb_7 FIND V(vth_pw_base_node) AT=6.7828889
.meas tran f5_7 FIND V(f5) AT=6.2444444
.meas tran f3_7 FIND V(f3) AT=6.2444444
.meas tran f8_7 FIND V(f8) AT=6.2444444
.meas tran tpwb_8 WHEN V(trig_pw_base)=0.45 RISE=1 TD=6.5888889
.meas tran tpwp_8 WHEN V(trig_pw_peak)=0.45 RISE=1 TD=6.5888889
.meas tran trrc_8 WHEN V(trig_rr_cap)=0.45 RISE=1 TD=6.5888889
.meas tran ewma_8 FIND V(rr_ewma) AT=6.9688889
.meas tran tmr_8 FIND V(rr_timer) AT=6.9688889
.meas tran ecg_at_rpk_8 FIND V(ecg_l0) AT=6.9888889
.meas tran tmr_pwb_8 FIND V(rr_timer) AT=7.5940000
.meas tran thr_pwb_8 FIND V(vth_pw_base_node) AT=7.5940000
.meas tran f5_8 FIND V(f5) AT=7.0888889
.meas tran f3_8 FIND V(f3) AT=7.0888889
.meas tran f8_8 FIND V(f8) AT=7.0888889
.meas tran tpwb_9 WHEN V(trig_pw_base)=0.45 RISE=1 TD=7.4000000
.meas tran tpwp_9 WHEN V(trig_pw_peak)=0.45 RISE=1 TD=7.4000000
.meas tran trrc_9 WHEN V(trig_rr_cap)=0.45 RISE=1 TD=7.4000000
.meas tran ewma_9 FIND V(rr_ewma) AT=7.7800000
.meas tran tmr_9 FIND V(rr_timer) AT=7.7800000
.meas tran ecg_at_rpk_9 FIND V(ecg_l0) AT=7.8000000
.meas tran tmr_pwb_9 FIND V(rr_timer) AT=8.3828889
.meas tran thr_pwb_9 FIND V(vth_pw_base_node) AT=8.3828889
.meas tran f5_9 FIND V(f5) AT=7.9000000
.meas tran f3_9 FIND V(f3) AT=7.9000000
.meas tran f8_9 FIND V(f8) AT=7.9000000
.meas tran tpwb_10 WHEN V(trig_pw_base)=0.45 RISE=1 TD=8.1888889
.meas tran tpwp_10 WHEN V(trig_pw_peak)=0.45 RISE=1 TD=8.1888889
.meas tran trrc_10 WHEN V(trig_rr_cap)=0.45 RISE=1 TD=8.1888889
.meas tran ewma_10 FIND V(rr_ewma) AT=8.5688889
.meas tran tmr_10 FIND V(rr_timer) AT=8.5688889
.meas tran ecg_at_rpk_10 FIND V(ecg_l0) AT=8.5888889
.meas tran tmr_pwb_10 FIND V(rr_timer) AT=9.1551111
.meas tran thr_pwb_10 FIND V(vth_pw_base_node) AT=9.1551111
.meas tran f5_10 FIND V(f5) AT=8.6888889
.meas tran f3_10 FIND V(f3) AT=8.6888889
.meas tran f8_10 FIND V(f8) AT=8.6888889
.meas tran tpwb_11 WHEN V(trig_pw_base)=0.45 RISE=1 TD=8.9611111
.meas tran tpwp_11 WHEN V(trig_pw_peak)=0.45 RISE=1 TD=8.9611111
.meas tran trrc_11 WHEN V(trig_rr_cap)=0.45 RISE=1 TD=8.9611111
.meas tran ewma_11 FIND V(rr_ewma) AT=9.3411111
.meas tran tmr_11 FIND V(rr_timer) AT=9.3411111
.meas tran ecg_at_rpk_11 FIND V(ecg_l0) AT=9.3611111
.meas tran tmr_pwb_11 FIND V(rr_timer) AT=9.9940000
.meas tran thr_pwb_11 FIND V(vth_pw_base_node) AT=9.9940000
.meas tran f5_11 FIND V(f5) AT=9.4611111
.meas tran f3_11 FIND V(f3) AT=9.4611111
.meas tran f8_11 FIND V(f8) AT=9.4611111
.meas tran tpwb_12 WHEN V(trig_pw_base)=0.45 RISE=1 TD=9.8000000
.meas tran tpwp_12 WHEN V(trig_pw_peak)=0.45 RISE=1 TD=9.8000000
.meas tran trrc_12 WHEN V(trig_rr_cap)=0.45 RISE=1 TD=9.8000000
.meas tran ewma_12 FIND V(rr_ewma) AT=10.1800000
.meas tran tmr_12 FIND V(rr_timer) AT=10.1800000
.meas tran ecg_at_rpk_12 FIND V(ecg_l0) AT=10.2000000
.meas tran tmr_pwb_12 FIND V(rr_timer) AT=10.8495556
.meas tran thr_pwb_12 FIND V(vth_pw_base_node) AT=10.8495556
.meas tran f5_12 FIND V(f5) AT=10.3000000
.meas tran f3_12 FIND V(f3) AT=10.3000000
.meas tran f8_12 FIND V(f8) AT=10.3000000
.meas tran tpwb_13 WHEN V(trig_pw_base)=0.45 RISE=1 TD=10.6555556
.meas tran tpwp_13 WHEN V(trig_pw_peak)=0.45 RISE=1 TD=10.6555556
.meas tran trrc_13 WHEN V(trig_rr_cap)=0.45 RISE=1 TD=10.6555556
.meas tran ewma_13 FIND V(rr_ewma) AT=11.0355556
.meas tran tmr_13 FIND V(rr_timer) AT=11.0355556
.meas tran ecg_at_rpk_13 FIND V(ecg_l0) AT=11.0555556
.meas tran tmr_pwb_13 FIND V(rr_timer) AT=11.6717778
.meas tran thr_pwb_13 FIND V(vth_pw_base_node) AT=11.6717778
.meas tran f5_13 FIND V(f5) AT=11.1555556
.meas tran f3_13 FIND V(f3) AT=11.1555556
.meas tran f8_13 FIND V(f8) AT=11.1555556
.meas tran tpwb_14 WHEN V(trig_pw_base)=0.45 RISE=1 TD=11.4777778
.meas tran tpwp_14 WHEN V(trig_pw_peak)=0.45 RISE=1 TD=11.4777778
.meas tran trrc_14 WHEN V(trig_rr_cap)=0.45 RISE=1 TD=11.4777778
.meas tran ewma_14 FIND V(rr_ewma) AT=11.8577778
.meas tran tmr_14 FIND V(rr_timer) AT=11.8577778
.meas tran ecg_at_rpk_14 FIND V(ecg_l0) AT=11.8777778
.meas tran tmr_pwb_14 FIND V(rr_timer) AT=12.4995556
.meas tran thr_pwb_14 FIND V(vth_pw_base_node) AT=12.4995556
.meas tran f5_14 FIND V(f5) AT=11.9777778
.meas tran f3_14 FIND V(f3) AT=11.9777778
.meas tran f8_14 FIND V(f8) AT=11.9777778
.meas tran tpwb_15 WHEN V(trig_pw_base)=0.45 RISE=1 TD=12.3055556
.meas tran tpwp_15 WHEN V(trig_pw_peak)=0.45 RISE=1 TD=12.3055556
.meas tran trrc_15 WHEN V(trig_rr_cap)=0.45 RISE=1 TD=12.3055556
.meas tran ewma_15 FIND V(rr_ewma) AT=12.6855556
.meas tran tmr_15 FIND V(rr_timer) AT=12.6855556
.meas tran ecg_at_rpk_15 FIND V(ecg_l0) AT=12.7055556
.meas tran tmr_pwb_15 FIND V(rr_timer) AT=13.3217778
.meas tran thr_pwb_15 FIND V(vth_pw_base_node) AT=13.3217778
.meas tran f5_15 FIND V(f5) AT=12.8055556
.meas tran f3_15 FIND V(f3) AT=12.8055556
.meas tran f8_15 FIND V(f8) AT=12.8055556
.meas tran tpwb_16 WHEN V(trig_pw_base)=0.45 RISE=1 TD=13.1277778
.meas tran tpwp_16 WHEN V(trig_pw_peak)=0.45 RISE=1 TD=13.1277778
.meas tran trrc_16 WHEN V(trig_rr_cap)=0.45 RISE=1 TD=13.1277778
.meas tran ewma_16 FIND V(rr_ewma) AT=13.5077778
.meas tran tmr_16 FIND V(rr_timer) AT=13.5077778
.meas tran ecg_at_rpk_16 FIND V(ecg_l0) AT=13.5277778
.meas tran tmr_pwb_16 FIND V(rr_timer) AT=14.1162222
.meas tran thr_pwb_16 FIND V(vth_pw_base_node) AT=14.1162222
.meas tran f5_16 FIND V(f5) AT=13.6277778
.meas tran f3_16 FIND V(f3) AT=13.6277778
.meas tran f8_16 FIND V(f8) AT=13.6277778
.meas tran tpwb_17 WHEN V(trig_pw_base)=0.45 RISE=1 TD=13.9222222
.meas tran tpwp_17 WHEN V(trig_pw_peak)=0.45 RISE=1 TD=13.9222222
.meas tran trrc_17 WHEN V(trig_rr_cap)=0.45 RISE=1 TD=13.9222222
.meas tran ewma_17 FIND V(rr_ewma) AT=14.3022222
.meas tran tmr_17 FIND V(rr_timer) AT=14.3022222
.meas tran ecg_at_rpk_17 FIND V(ecg_l0) AT=14.3222222
.meas tran tmr_pwb_17 FIND V(rr_timer) AT=14.9134444
.meas tran thr_pwb_17 FIND V(vth_pw_base_node) AT=14.9134444
.meas tran f5_17 FIND V(f5) AT=14.4222222
.meas tran f3_17 FIND V(f3) AT=14.4222222
.meas tran f8_17 FIND V(f8) AT=14.4222222
.meas tran tpwb_18 WHEN V(trig_pw_base)=0.45 RISE=1 TD=14.7194444
.meas tran tpwp_18 WHEN V(trig_pw_peak)=0.45 RISE=1 TD=14.7194444
.meas tran trrc_18 WHEN V(trig_rr_cap)=0.45 RISE=1 TD=14.7194444
.meas tran ewma_18 FIND V(rr_ewma) AT=15.0994444
.meas tran tmr_18 FIND V(rr_timer) AT=15.0994444
.meas tran ecg_at_rpk_18 FIND V(ecg_l0) AT=15.1194444
.meas tran tmr_pwb_18 FIND V(rr_timer) AT=15.7051111
.meas tran thr_pwb_18 FIND V(vth_pw_base_node) AT=15.7051111
.meas tran f5_18 FIND V(f5) AT=15.2194444
.meas tran f3_18 FIND V(f3) AT=15.2194444
.meas tran f8_18 FIND V(f8) AT=15.2194444
.meas tran tpwb_19 WHEN V(trig_pw_base)=0.45 RISE=1 TD=15.5111111
.meas tran tpwp_19 WHEN V(trig_pw_peak)=0.45 RISE=1 TD=15.5111111
.meas tran trrc_19 WHEN V(trig_rr_cap)=0.45 RISE=1 TD=15.5111111
.meas tran ewma_19 FIND V(rr_ewma) AT=15.8911111
.meas tran tmr_19 FIND V(rr_timer) AT=15.8911111
.meas tran ecg_at_rpk_19 FIND V(ecg_l0) AT=15.9111111
.meas tran f5_19 FIND V(f5) AT=16.0111111
.meas tran f3_19 FIND V(f3) AT=16.0111111
.meas tran f8_19 FIND V(f8) AT=16.0111111

.end
