* ============================================================
* TEST: P-wave Energy v2 — Pure Analog MIN Detector
*
* Pure SKY130 analog. No ideal components in DUT.
* VDD = 0.9V, subthreshold operation.
*
* ECG lead 1 from 10 MIT-BIH records, gain=0.15 V/mV,
* centered at vref=0.45V. Beat spacing=2.0s for BPF settling.
*
* Beat timing (from pwave_timing.json):
*  B1  rec100: pw=[1.794,1.944]s  rpeak=2.000s  E=2.911e-04
*  B2  rec103: pw=[3.531,3.681]s  rpeak=3.736s  E=1.183e-03
*  B3  rec105: pw=[5.342,5.492]s  rpeak=5.547s  E=3.656e-04
*  B4  rec111: pw=[7.342,7.492]s  rpeak=7.547s  E=4.980e-03
*  B5  rec200: pw=[9.794,9.944]s  rpeak=10.000s E=6.740e-06
*  B6  rec210: pw=[11.489,11.639]s rpeak=11.694s E=1.581e-04
*  B7  rec212: pw=[13.389,13.539]s rpeak=13.594s E=3.223e-03
*  B8  rec219: pw=[15.628,15.778]s rpeak=15.833s E=5.426e-04
*  B9  rec221: pw=[17.406,17.556]s rpeak=17.611s E=6.837e-05
*  B10 rec231: pw=[19.294,19.444]s rpeak=19.500s E=5.180e-04
*
* MIN detector: pw_energy_out tracks minimum BPF during P-wave.
* Lower value = more P-wave energy. Inversely correlated.
* ============================================================

.title test_pwave_v2

.lib "sky130_minimal.lib.spice" tt
.option scale=1.0u
.option method=gear
.option gmin=1e-15
.option abstol=1e-15
.option reltol=0.005
.temp 27

Vdd vdd 0 0.9
Vss vss 0 0
Vbias vbias 0 0.35
Vref vref 0 0.45

* ================================================================
* Instantiate pwave_energy v2 subcircuit
* ================================================================

.include "pwave_energy_v2.spice"

Xpw ecg_in pwave_gate rpeak_trigger pw_energy_out vdd vss vbias vref pwave_energy_v2

* ================================================================
* ECG input: real MIT-BIH data via PWL
* ================================================================

.include "pwave_ecg_pwl.inc"

* ================================================================
* P-wave gate: HIGH during P-wave window for each beat
* ================================================================

.include "pwave_gate_pwl.inc"

* ================================================================
* R-peak trigger: 2ms pulse at each R-peak
* ================================================================

.include "pwave_rpeak_pwl.inc"

* ================================================================
* TRANSIENT ANALYSIS — 21.1s total
* ================================================================

.tran 0.1m 21.1

* Measure pw_energy_out 1ms before each rpeak
.meas tran V1pw FIND V(pw_energy_out) AT=1.999
.meas tran V2pw FIND V(pw_energy_out) AT=3.735
.meas tran V3pw FIND V(pw_energy_out) AT=5.546
.meas tran V4pw FIND V(pw_energy_out) AT=7.546
.meas tran V5pw FIND V(pw_energy_out) AT=9.999
.meas tran V6pw FIND V(pw_energy_out) AT=11.693
.meas tran V7pw FIND V(pw_energy_out) AT=13.593
.meas tran V8pw FIND V(pw_energy_out) AT=15.832
.meas tran V9pw FIND V(pw_energy_out) AT=17.610
.meas tran V10pw FIND V(pw_energy_out) AT=19.499

* Measure BPF output MAX and MIN during P-wave windows
.meas tran V1bpf_max MAX V(xpw.bpf_out) FROM=1.794 TO=1.944
.meas tran V2bpf_max MAX V(xpw.bpf_out) FROM=3.531 TO=3.681
.meas tran V3bpf_max MAX V(xpw.bpf_out) FROM=5.342 TO=5.492
.meas tran V4bpf_max MAX V(xpw.bpf_out) FROM=7.342 TO=7.492
.meas tran V5bpf_max MAX V(xpw.bpf_out) FROM=9.794 TO=9.944
.meas tran V6bpf_max MAX V(xpw.bpf_out) FROM=11.489 TO=11.639
.meas tran V7bpf_max MAX V(xpw.bpf_out) FROM=13.389 TO=13.539
.meas tran V8bpf_max MAX V(xpw.bpf_out) FROM=15.628 TO=15.778
.meas tran V9bpf_max MAX V(xpw.bpf_out) FROM=17.406 TO=17.556
.meas tran V10bpf_max MAX V(xpw.bpf_out) FROM=19.294 TO=19.444

.meas tran V1bpf_min MIN V(xpw.bpf_out) FROM=1.794 TO=1.944
.meas tran V2bpf_min MIN V(xpw.bpf_out) FROM=3.531 TO=3.681
.meas tran V3bpf_min MIN V(xpw.bpf_out) FROM=5.342 TO=5.492
.meas tran V4bpf_min MIN V(xpw.bpf_out) FROM=7.342 TO=7.492
.meas tran V5bpf_min MIN V(xpw.bpf_out) FROM=9.794 TO=9.944
.meas tran V6bpf_min MIN V(xpw.bpf_out) FROM=11.489 TO=11.639
.meas tran V7bpf_min MIN V(xpw.bpf_out) FROM=13.389 TO=13.539
.meas tran V8bpf_min MIN V(xpw.bpf_out) FROM=15.628 TO=15.778
.meas tran V9bpf_min MIN V(xpw.bpf_out) FROM=17.406 TO=17.556
.meas tran V10bpf_min MIN V(xpw.bpf_out) FROM=19.294 TO=19.444

* Measure supply current for power
.meas tran Idd AVG I(Vdd) FROM=1.0 TO=21.0

.control
  run
  echo ""
  echo "============================================================"
  echo "P-WAVE ENERGY v2 — MIN DETECTOR — ALL 10 BEATS"
  echo "============================================================"
  echo ""
  quit
.endc

.end
