.title accuracy_batch_7
.lib "sky130_minimal.lib.spice" tt
.option scale=1.0u method=gear gmin=1e-15 abstol=1e-15 reltol=0.005
.temp 27
.include "ota_5t_subthreshold.spice"
.include "inverter.spice"
.include "resistor_div.spice"
.include "rr_timing.spice"
.include "beat_instability.spice"
.include "pwave_energy.spice"
.include "qrs_width.spice"
.include "slope_ratio.spice"
.include "qrs_symmetry.spice"

Vdd vdd 0 0.9
Vss vss 0 0
Vbias vbias 0 0.35
Vref vref 0 0.45

Vecg ecg_in 0 PWL(0.0000000 0.250000 0.2500000 0.185163 0.2527778 0.183619 0.2555556 0.183619 0.2583333 0.180532 0.2611111 0.175901 0.2638889 0.177444 0.2666667 0.177444 0.2694444 0.175901 0.2722222 0.178988 0.2750000 0.182075 0.2777778 0.183619 0.2805556 0.178988 0.2833333 0.185163 0.2861111 0.185163 0.2888889 0.182075 0.2916667 0.175901 0.2944444 0.178988 0.2972222 0.180532 0.3000000 0.182075 0.3027778 0.185163 0.3055556 0.186707 0.3083333 0.194425 0.3111111 0.197513 0.3138889 0.197513 0.3166667 0.194425 0.3194444 0.194425 0.3222222 0.199057 0.3250000 0.200600 0.3277778 0.203688 0.3305556 0.206775 0.3333333 0.211407 0.3361111 0.219125 0.3388889 0.226844 0.3416667 0.234563 0.3444444 0.242281 0.3472222 0.240738 0.3500000 0.243825 0.3527778 0.234563 0.3555556 0.229931 0.3583333 0.223756 0.3611111 0.222213 0.3638889 0.214494 0.3666667 0.209863 0.3694444 0.205232 0.3722222 0.205232 0.3750000 0.202144 0.3777778 0.199057 0.3805556 0.191338 0.3833333 0.188250 0.3861111 0.182075 0.3888889 0.174357 0.3916667 0.169726 0.3944444 0.171269 0.3972222 0.169726 0.4000000 0.171269 0.4027778 0.171269 0.4055556 0.172813 0.4083333 0.172813 0.4111111 0.174357 0.4138889 0.171269 0.4166667 0.171269 0.4194444 0.169726 0.4222222 0.168182 0.4250000 0.165094 0.4277778 0.165094 0.4305556 0.166638 0.4333333 0.165094 0.4361111 0.166638 0.4388889 0.168182 0.4416667 0.171269 0.4444444 0.172813 0.4472222 0.168182 0.4500000 0.169726 0.4527778 0.166638 0.4555556 0.166638 0.4583333 0.162007 0.4611111 0.158919 0.4638889 0.154288 0.4666667 0.148113 0.4694444 0.137307 0.4722222 0.118782 0.4750000 0.097170 0.4777778 0.089451 0.4805556 0.098714 0.4833333 0.149657 0.4861111 0.231475 0.4888889 0.337993 0.4916667 0.459949 0.4944444 0.581904 0.4972222 0.680703 0.5000000 0.723928 0.5027778 0.697684 0.5055556 0.600429 0.5083333 0.450686 0.5111111 0.290137 0.5138889 0.175901 0.5166667 0.112607 0.5194444 0.087907 0.5222222 0.087907 0.5250000 0.086364 0.5277778 0.072470 0.5305556 0.047770 0.5333333 0.010000 0.5361111 0.010000 0.5388889 0.010000 0.5416667 0.010000 0.5444444 0.010000 0.5472222 0.010000 0.5500000 0.010000 0.5527778 0.010000 0.5555556 0.010000 0.5583333 0.023070 0.5611111 0.053945 0.5638889 0.080189 0.5666667 0.104889 0.5694444 0.123413 0.5722222 0.140395 0.5750000 0.149657 0.5777778 0.155832 0.5805556 0.157376 0.5833333 0.160463 0.5861111 0.163551 0.5888889 0.162007 0.5916667 0.162007 0.5944444 0.166638 0.5972222 0.166638 0.6000000 0.169726 0.6027778 0.169726 0.6055556 0.172813 0.6083333 0.178988 0.6111111 0.178988 0.6138889 0.182075 0.6166667 0.183619 0.6194444 0.182075 0.6222222 0.182075 0.6250000 0.182075 0.6277778 0.177444 0.6305556 0.177444 0.6333333 0.177444 0.6361111 0.182075 0.6388889 0.188250 0.6416667 0.189794 0.6444444 0.191338 0.6472222 0.192882 0.6500000 0.192882 0.6527778 0.194425 0.6555556 0.194425 0.6583333 0.188250 0.6611111 0.191338 0.6638889 0.191338 0.6666667 0.191338 0.6694444 0.199057 0.6722222 0.202144 0.6750000 0.203688 0.6777778 0.208319 0.6805556 0.205232 0.6833333 0.206775 0.6861111 0.206775 0.6888889 0.209863 0.6916667 0.211407 0.6944444 0.211407 0.6972222 0.214494 0.7000000 0.217581 0.7027778 0.217581 0.7055556 0.220669 0.7083333 0.228388 0.7111111 0.228388 0.7138889 0.231475 0.7166667 0.233019 0.7194444 0.236106 0.7222222 0.236106 0.7250000 0.237650 0.7277778 0.237650 0.7305556 0.240738 0.7333333 0.245369 0.7361111 0.248456 0.7388889 0.253087 0.7416667 0.254631 0.7444444 0.260806 0.7472222 0.260806 0.7500000 0.263894 0.7527778 0.270069 0.7555556 0.266981 0.7583333 0.271612 0.7611111 0.273156 0.7638889 0.279331 0.7666667 0.285506 0.7694444 0.288593 0.7722222 0.296312 0.7750000 0.299400 0.7777778 0.305575 0.7805556 0.308662 0.7833333 0.310206 0.7861111 0.316381 0.7888889 0.311750 0.7916667 0.316381 0.7944444 0.319468 0.7972222 0.324099 1.2111111 0.188250 1.2138889 0.186707 1.2166667 0.191338 1.2194444 0.182075 1.2222222 0.185163 1.2250000 0.183619 1.2277778 0.183619 1.2305556 0.182075 1.2333333 0.182075 1.2361111 0.183619 1.2388889 0.188250 1.2416667 0.191338 1.2444444 0.194425 1.2472222 0.195969 1.2500000 0.195969 1.2527778 0.197513 1.2555556 0.200600 1.2583333 0.200600 1.2611111 0.200600 1.2638889 0.202144 1.2666667 0.203688 1.2694444 0.206775 1.2722222 0.211407 1.2750000 0.214494 1.2777778 0.220669 1.2805556 0.226844 1.2833333 0.233019 1.2861111 0.236106 1.2888889 0.240738 1.2916667 0.240738 1.2944444 0.239194 1.2972222 0.234563 1.3000000 0.234563 1.3027778 0.231475 1.3055556 0.229931 1.3083333 0.231475 1.3111111 0.228388 1.3138889 0.223756 1.3166667 0.223756 1.3194444 0.217581 1.3222222 0.212950 1.3250000 0.203688 1.3277778 0.195969 1.3305556 0.194425 1.3333333 0.185163 1.3361111 0.180532 1.3388889 0.178988 1.3416667 0.174357 1.3444444 0.180532 1.3472222 0.178988 1.3500000 0.178988 1.3527778 0.177444 1.3555556 0.175901 1.3583333 0.174357 1.3611111 0.172813 1.3638889 0.172813 1.3666667 0.172813 1.3694444 0.174357 1.3722222 0.171269 1.3750000 0.175901 1.3777778 0.177444 1.3805556 0.177444 1.3833333 0.178988 1.3861111 0.174357 1.3888889 0.172813 1.3916667 0.174357 1.3944444 0.171269 1.3972222 0.171269 1.4000000 0.169726 1.4027778 0.174357 1.4055556 0.175901 1.4083333 0.177444 1.4111111 0.177444 1.4138889 0.177444 1.4166667 0.177444 1.4194444 0.172813 1.4222222 0.163551 1.4250000 0.149657 1.4277778 0.134220 1.4305556 0.117238 1.4333333 0.097170 1.4361111 0.087907 1.4388889 0.098714 1.4416667 0.138851 1.4444444 0.208319 1.4472222 0.299400 1.4500000 0.409005 1.4527778 0.524786 1.4555556 0.626672 1.4583333 0.702316 1.4611111 0.727015 1.4638889 0.691509 1.4666667 0.586535 1.4694444 0.441424 1.4722222 0.299400 1.4750000 0.189794 1.4777778 0.132676 1.4805556 0.111063 1.4833333 0.112607 1.4861111 0.118782 1.4888889 0.114151 1.4916667 0.089451 1.4944444 0.055489 1.4972222 0.013808 1.5000000 0.010000 1.5027778 0.010000 1.5055556 0.010000 1.5083333 0.010000 1.5111111 0.010000 1.5138889 0.010000 1.5166667 0.010000 1.5194444 0.010000 1.5222222 0.010000 1.5250000 0.033877 1.5277778 0.058576 1.5305556 0.084820 1.5333333 0.109520 1.5361111 0.128045 1.5388889 0.145026 1.5416667 0.155832 1.5444444 0.166638 1.5472222 0.166638 1.5500000 0.171269 1.5527778 0.172813 1.5555556 0.175901 1.5583333 0.174357 1.5611111 0.174357 1.5638889 0.172813 1.5666667 0.175901 1.5694444 0.177444 1.5722222 0.180532 1.5750000 0.183619 1.5777778 0.186707 1.5805556 0.186707 1.5833333 0.192882 1.5861111 0.186707 1.5888889 0.186707 1.5916667 0.186707 1.5944444 0.183619 1.5972222 0.182075 1.6000000 0.185163 1.6027778 0.191338 1.6055556 0.197513 1.6083333 0.202144 1.6111111 0.208319 1.6138889 0.203688 1.6166667 0.205232 1.6194444 0.206775 1.6222222 0.208319 1.6250000 0.205232 1.6277778 0.205232 1.6305556 0.205232 1.6333333 0.208319 1.6361111 0.205232 1.6388889 0.208319 1.6416667 0.211407 1.6444444 0.212950 1.6472222 0.212950 1.6500000 0.214494 1.6527778 0.217581 1.6555556 0.219125 1.6583333 0.219125 1.6611111 0.222213 1.6638889 0.226844 1.6666667 0.228388 1.6694444 0.226844 1.6722222 0.229931 1.6750000 0.236106 1.6777778 0.237650 1.6805556 0.237650 1.6833333 0.239194 1.6861111 0.239194 1.6888889 0.240738 1.6916667 0.242281 1.6944444 0.245369 1.6972222 0.248456 1.7000000 0.251544 1.7027778 0.251544 1.7055556 0.259262 1.7083333 0.268525 1.7111111 0.271612 1.7138889 0.273156 1.7166667 0.279331 1.7194444 0.279331 1.7222222 0.280875 1.7250000 0.287050 1.7277778 0.283962 1.7305556 0.288593 1.7333333 0.293225 1.7361111 0.300943 1.7388889 0.304031 1.7416667 0.310206 1.7444444 0.314837 1.7472222 0.317925 1.7500000 0.321012 1.7527778 0.314837 1.7555556 0.319468 1.7583333 0.327187 2.1027778 0.180532 2.1055556 0.182075 2.1083333 0.183619 2.1111111 0.183619 2.1138889 0.185163 2.1166667 0.188250 2.1194444 0.186707 2.1222222 0.189794 2.1250000 0.189794 2.1277778 0.192882 2.1305556 0.192882 2.1333333 0.188250 2.1361111 0.189794 2.1388889 0.186707 2.1416667 0.188250 2.1444444 0.191338 2.1472222 0.189794 2.1500000 0.188250 2.1527778 0.189794 2.1555556 0.192882 2.1583333 0.194425 2.1611111 0.200600 2.1638889 0.208319 2.1666667 0.208319 2.1694444 0.212950 2.1722222 0.214494 2.1750000 0.212950 2.1777778 0.214494 2.1805556 0.216038 2.1833333 0.216038 2.1861111 0.222213 2.1888889 0.226844 2.1916667 0.233019 2.1944444 0.233019 2.1972222 0.237650 2.2000000 0.237650 2.2027778 0.240738 2.2055556 0.243825 2.2083333 0.243825 2.2111111 0.239194 2.2138889 0.231475 2.2166667 0.226844 2.2194444 0.223756 2.2222222 0.217581 2.2250000 0.212950 2.2277778 0.203688 2.2305556 0.195969 2.2333333 0.192882 2.2361111 0.186707 2.2388889 0.180532 2.2416667 0.178988 2.2444444 0.178988 2.2472222 0.183619 2.2500000 0.183619 2.2527778 0.186707 2.2555556 0.185163 2.2583333 0.180532 2.2611111 0.175901 2.2638889 0.168182 2.2666667 0.168182 2.2694444 0.168182 2.2722222 0.169726 2.2750000 0.174357 2.2777778 0.182075 2.2805556 0.180532 2.2833333 0.180532 2.2861111 0.177444 2.2888889 0.171269 2.2916667 0.168182 2.2944444 0.166638 2.2972222 0.166638 2.3000000 0.171269 2.3027778 0.174357 2.3055556 0.177444 2.3083333 0.182075 2.3111111 0.183619 2.3138889 0.178988 2.3166667 0.182075 2.3194444 0.172813 2.3222222 0.160463 2.3250000 0.140395 2.3277778 0.115695 2.3305556 0.101801 2.3333333 0.104889 2.3361111 0.149657 2.3388889 0.225300 2.3416667 0.337993 2.3444444 0.466123 2.3472222 0.588079 2.3500000 0.686878 2.3527778 0.734734 2.3555556 0.706947 2.3583333 0.597341 2.3611111 0.422899 2.3638889 0.253087 2.3666667 0.121870 2.3694444 0.057033 2.3722222 0.046226 2.3750000 0.060120 2.3777778 0.075557 2.3805556 0.072470 2.3833333 0.063208 2.3861111 0.033877 2.3888889 0.010000 2.3916667 0.010000 2.3944444 0.010000 2.3972222 0.010000 2.4000000 0.010000 2.4027778 0.010000 2.4055556 0.010000 2.4083333 0.010000 2.4111111 0.038508 2.4138889 0.069383 2.4166667 0.095626 2.4194444 0.117238 2.4222222 0.134220 2.4250000 0.151201 2.4277778 0.158919 2.4305556 0.168182 2.4333333 0.174357 2.4361111 0.178988 2.4388889 0.185163 2.4416667 0.186707 2.4444444 0.191338 2.4472222 0.194425 2.4500000 0.192882 2.4527778 0.191338 2.4555556 0.189794 2.4583333 0.188250 2.4611111 0.189794 2.4638889 0.194425 2.4666667 0.199057 2.4694444 0.203688 2.4722222 0.212950 2.4750000 0.211407 2.4777778 0.216038 2.4805556 0.212950 2.4833333 0.208319 2.4861111 0.205232 2.4888889 0.202144 2.4916667 0.197513 2.4944444 0.199057 2.4972222 0.205232 2.5000000 0.212950 2.5027778 0.220669 2.5055556 0.225300 2.5083333 0.226844 2.5111111 0.229931 2.5138889 0.225300 2.5166667 0.222213 2.5194444 0.216038 2.5222222 0.214494 2.5250000 0.212950 2.5277778 0.212950 2.5305556 0.219125 2.5333333 0.223756 2.5361111 0.226844 2.5388889 0.234563 2.5416667 0.242281 2.5444444 0.246913 2.5472222 0.246913 2.5500000 0.245369 2.5527778 0.242281 2.5555556 0.243825 2.5583333 0.240738 2.5611111 0.242281 2.5638889 0.246913 2.5666667 0.248456 2.5694444 0.248456 2.5722222 0.251544 2.5750000 0.256175 2.5777778 0.265437 2.5805556 0.270069 2.5833333 0.277787 2.5861111 0.279331 2.5888889 0.276244 2.5916667 0.273156 2.5944444 0.270069 2.5972222 0.271612 2.6000000 0.273156 2.6027778 0.274700 2.6055556 0.280875 2.6083333 0.283962 2.6111111 0.293225 2.6138889 0.296312 2.6166667 0.300943 2.6194444 0.304031 2.6222222 0.307118 2.6250000 0.308662 2.6277778 0.310206 2.6305556 0.311750 2.6333333 0.313293 2.6361111 0.316381 2.6388889 0.321012 2.6416667 0.325643 2.6444444 0.331818 2.6472222 0.336449 2.6500000 0.337993 3.8444444 0.219125 3.8472222 0.220669 3.8500000 0.220669 3.8527778 0.222213 3.8555556 0.220669 3.8583333 0.220669 3.8611111 0.217581 3.8638889 0.216038 3.8666667 0.219125 3.8694444 0.216038 3.8722222 0.219125 3.8750000 0.219125 3.8777778 0.223756 3.8805556 0.223756 3.8833333 0.223756 3.8861111 0.226844 3.8888889 0.225300 3.8916667 0.225300 3.8944444 0.226844 3.8972222 0.229931 3.9000000 0.231475 3.9027778 0.237650 3.9055556 0.237650 3.9083333 0.239194 3.9111111 0.246913 3.9138889 0.248456 3.9166667 0.248456 3.9194444 0.251544 3.9222222 0.254631 3.9250000 0.260806 3.9277778 0.263894 3.9305556 0.265437 3.9333333 0.277787 3.9361111 0.280875 3.9388889 0.280875 3.9416667 0.282419 3.9444444 0.282419 3.9472222 0.280875 3.9500000 0.276244 3.9527778 0.270069 3.9555556 0.262350 3.9583333 0.259262 3.9611111 0.257719 3.9638889 0.248456 3.9666667 0.243825 3.9694444 0.242281 3.9722222 0.240738 3.9750000 0.233019 3.9777778 0.231475 3.9805556 0.223756 3.9833333 0.223756 3.9861111 0.222213 3.9888889 0.220669 3.9916667 0.214494 3.9944444 0.214494 3.9972222 0.211407 4.0000000 0.212950 4.0027778 0.214494 4.0055556 0.216038 4.0083333 0.212950 4.0111111 0.216038 4.0138889 0.211407 4.0166667 0.211407 4.0194444 0.216038 4.0222222 0.216038 4.0250000 0.211407 4.0277778 0.211407 4.0305556 0.212950 4.0333333 0.211407 4.0361111 0.211407 4.0388889 0.214494 4.0416667 0.212950 4.0444444 0.219125 4.0472222 0.217581 4.0500000 0.216038 4.0527778 0.212950 4.0555556 0.205232 4.0583333 0.191338 4.0611111 0.178988 4.0638889 0.157376 4.0666667 0.137307 4.0694444 0.132676 4.0722222 0.152744 4.0750000 0.203688 4.0777778 0.287050 4.0805556 0.390480 4.0833333 0.504717 4.0861111 0.620497 4.0888889 0.719297 4.0916667 0.791852 4.0944444 0.819640 4.0972222 0.791852 4.1000000 0.699228 4.1027778 0.568010 4.1055556 0.435249 4.1083333 0.333362 4.1111111 0.276244 4.1138889 0.256175 4.1166667 0.256175 4.1194444 0.273156 4.1222222 0.280875 4.1250000 0.283962 4.1277778 0.274700 4.1305556 0.259262 4.1333333 0.245369 4.1361111 0.228388 4.1388889 0.217581 4.1416667 0.214494 4.1444444 0.219125 4.1472222 0.216038 4.1500000 0.217581 4.1527778 0.216038 4.1555556 0.214494 4.1583333 0.209863 4.1611111 0.206775 4.1638889 0.203688 4.1666667 0.202144 4.1694444 0.200600 4.1722222 0.202144 4.1750000 0.202144 4.1777778 0.205232 4.1805556 0.205232 4.1833333 0.203688 4.1861111 0.200600 4.1888889 0.197513 4.1916667 0.199057 4.1944444 0.195969 4.1972222 0.194425 4.2000000 0.194425 4.2027778 0.194425 4.2055556 0.199057 4.2083333 0.202144 4.2111111 0.205232 4.2138889 0.205232 4.2166667 0.208319 4.2194444 0.208319 4.2222222 0.203688 4.2250000 0.202144 4.2277778 0.199057 4.2305556 0.200600 4.2333333 0.202144 4.2361111 0.203688 4.2388889 0.205232 4.2416667 0.208319 4.2444444 0.206775 4.2472222 0.208319 4.2500000 0.206775 4.2527778 0.209863 4.2555556 0.209863 4.2583333 0.208319 4.2611111 0.208319 4.2638889 0.208319 4.2666667 0.206775 4.2694444 0.205232 4.2722222 0.206775 4.2750000 0.211407 4.2777778 0.214494 4.2805556 0.216038 4.2833333 0.212950 4.2861111 0.211407 4.2888889 0.211407 4.2916667 0.209863 4.2944444 0.209863 4.2972222 0.214494 4.3000000 0.217581 4.3027778 0.219125 4.3055556 0.219125 4.3083333 0.220669 4.3111111 0.225300 4.3138889 0.228388 4.3166667 0.226844 4.3194444 0.228388 4.3222222 0.225300 4.3250000 0.228388 4.3277778 0.223756 4.3305556 0.226844 4.3333333 0.226844 4.3361111 0.226844 4.3388889 0.233019 4.3416667 0.231475 4.3444444 0.236106 4.3472222 0.239194 4.3500000 0.240738 4.3527778 0.239194 4.3555556 0.236106 4.3583333 0.237650 4.3611111 0.237650 4.3638889 0.233019 4.3666667 0.233019 4.3694444 0.233019 4.3722222 0.234563 4.3750000 0.237650 4.3777778 0.240738 4.3805556 0.246913 4.3833333 0.246913 4.3861111 0.246913 4.3888889 0.245369 4.3916667 0.246913 4.7583333 0.220669 4.7611111 0.220669 4.7638889 0.212950 4.7666667 0.219125 4.7694444 0.217581 4.7722222 0.217581 4.7750000 0.217581 4.7777778 0.216038 4.7805556 0.217581 4.7833333 0.212950 4.7861111 0.216038 4.7888889 0.216038 4.7916667 0.216038 4.7944444 0.217581 4.7972222 0.214494 4.8000000 0.211407 4.8027778 0.211407 4.8055556 0.219125 4.8083333 0.220669 4.8111111 0.228388 4.8138889 0.236106 4.8166667 0.240738 4.8194444 0.248456 4.8222222 0.245369 4.8250000 0.242281 4.8277778 0.240738 4.8305556 0.239194 4.8333333 0.243825 4.8361111 0.251544 4.8388889 0.257719 4.8416667 0.268525 4.8444444 0.273156 4.8472222 0.277787 4.8500000 0.276244 4.8527778 0.268525 4.8555556 0.260806 4.8583333 0.253087 4.8611111 0.246913 4.8638889 0.242281 4.8666667 0.237650 4.8694444 0.236106 4.8722222 0.239194 4.8750000 0.236106 4.8777778 0.234563 4.8805556 0.231475 4.8833333 0.223756 4.8861111 0.219125 4.8888889 0.208319 4.8916667 0.205232 4.8944444 0.202144 4.8972222 0.197513 4.9000000 0.194425 4.9027778 0.194425 4.9055556 0.194425 4.9083333 0.197513 4.9111111 0.195969 4.9138889 0.199057 4.9166667 0.195969 4.9194444 0.199057 4.9222222 0.194425 4.9250000 0.192882 4.9277778 0.188250 4.9305556 0.186707 4.9333333 0.185163 4.9361111 0.183619 4.9388889 0.186707 4.9416667 0.192882 4.9444444 0.194425 4.9472222 0.199057 4.9500000 0.200600 4.9527778 0.200600 4.9555556 0.197513 4.9583333 0.191338 4.9611111 0.192882 4.9638889 0.186707 4.9666667 0.191338 4.9694444 0.189794 4.9722222 0.188250 4.9750000 0.182075 4.9777778 0.169726 4.9805556 0.146569 4.9833333 0.124957 4.9861111 0.111063 4.9888889 0.126501 4.9916667 0.169726 4.9944444 0.243825 4.9972222 0.348799 5.0000000 0.470755 5.0027778 0.598885 5.0055556 0.699228 5.0083333 0.756346 5.0111111 0.743997 5.0138889 0.648285 5.0166667 0.489280 5.0194444 0.316381 5.0222222 0.177444 5.0250000 0.098714 5.0277778 0.072470 5.0305556 0.075557 5.0333333 0.087907 5.0361111 0.092539 5.0388889 0.084820 5.0416667 0.063208 5.0444444 0.038508 5.0472222 0.010000 5.0500000 0.010000 5.0527778 0.010000 5.0555556 0.010000 5.0583333 0.010000 5.0611111 0.010000 5.0638889 0.010000 5.0666667 0.012264 5.0694444 0.040051 5.0722222 0.072470 5.0750000 0.103345 5.0777778 0.126501 5.0805556 0.149657 5.0833333 0.160463 5.0861111 0.178988 5.0888889 0.186707 5.0916667 0.188250 5.0944444 0.191338 5.0972222 0.191338 5.1000000 0.188250 5.1027778 0.192882 5.1055556 0.194425 5.1083333 0.199057 5.1111111 0.205232 5.1138889 0.208319 5.1166667 0.209863 5.1194444 0.212950 5.1222222 0.209863 5.1250000 0.209863 5.1277778 0.211407 5.1305556 0.209863 5.1333333 0.211407 5.1361111 0.216038 5.1388889 0.220669 5.1416667 0.222213 5.1444444 0.222213 5.1472222 0.225300 5.1500000 0.223756 5.1527778 0.225300 5.1555556 0.225300 5.1583333 0.220669 5.1611111 0.223756 5.1638889 0.220669 5.1666667 0.223756 5.1694444 0.223756 5.1722222 0.226844 5.1750000 0.234563 5.1777778 0.237650 5.1805556 0.236106 5.1833333 0.240738 5.1861111 0.240738 5.1888889 0.239194 5.1916667 0.233019 5.1944444 0.225300 5.1972222 0.231475 5.2000000 0.236106 5.2027778 0.240738 5.2055556 0.243825 5.2083333 0.248456 5.2111111 0.256175 5.2138889 0.257719 5.2166667 0.263894 5.2194444 0.262350 5.2222222 0.265437 5.2250000 0.266981 5.2277778 0.265437 5.2305556 0.262350 5.2333333 0.268525 5.2361111 0.265437 5.2388889 0.271612 5.2416667 0.280875 5.2444444 0.288593 5.2472222 0.291681 5.2500000 0.294768 5.2527778 0.302487 5.2555556 0.299400 5.2583333 0.299400 5.2611111 0.299400 5.2638889 0.296312 5.2666667 0.304031 5.2694444 0.307118 5.2722222 0.316381 5.2750000 0.317925 5.2777778 0.327187 5.2805556 0.333362 5.2833333 0.339537 5.2861111 0.342624 5.2888889 0.347256 5.2916667 0.350343 5.2944444 0.348799 5.2972222 0.342624 5.3000000 0.347256 5.3027778 0.348799 5.3055556 0.351887 5.5888889 0.209863 5.5916667 0.206775 5.5944444 0.209863 5.5972222 0.208319 5.6000000 0.206775 5.6027778 0.205232 5.6055556 0.208319 5.6083333 0.206775 5.6111111 0.209863 5.6138889 0.209863 5.6166667 0.206775 5.6194444 0.205232 5.6222222 0.203688 5.6250000 0.203688 5.6277778 0.205232 5.6305556 0.199057 5.6333333 0.202144 5.6361111 0.205232 5.6388889 0.205232 5.6416667 0.209863 5.6444444 0.214494 5.6472222 0.217581 5.6500000 0.220669 5.6527778 0.223756 5.6555556 0.225300 5.6583333 0.225300 5.6611111 0.223756 5.6638889 0.225300 5.6666667 0.228388 5.6694444 0.233019 5.6722222 0.239194 5.6750000 0.245369 5.6777778 0.251544 5.6805556 0.257719 5.6833333 0.260806 5.6861111 0.260806 5.6888889 0.260806 5.6916667 0.253087 5.6944444 0.248456 5.6972222 0.243825 5.7000000 0.242281 5.7027778 0.239194 5.7055556 0.237650 5.7083333 0.234563 5.7111111 0.231475 5.7138889 0.223756 5.7166667 0.217581 5.7194444 0.212950 5.7222222 0.206775 5.7250000 0.197513 5.7277778 0.194425 5.7305556 0.189794 5.7333333 0.188250 5.7361111 0.188250 5.7388889 0.188250 5.7416667 0.186707 5.7444444 0.191338 5.7472222 0.189794 5.7500000 0.188250 5.7527778 0.185163 5.7555556 0.183619 5.7583333 0.185163 5.7611111 0.180532 5.7638889 0.178988 5.7666667 0.180532 5.7694444 0.177444 5.7722222 0.182075 5.7750000 0.180532 5.7777778 0.185163 5.7805556 0.185163 5.7833333 0.188250 5.7861111 0.185163 5.7888889 0.182075 5.7916667 0.183619 5.7944444 0.182075 5.7972222 0.180532 5.8000000 0.180532 5.8027778 0.175901 5.8055556 0.168182 5.8083333 0.158919 5.8111111 0.138851 5.8138889 0.117238 5.8166667 0.107976 5.8194444 0.123413 5.8222222 0.178988 5.8250000 0.262350 5.8277778 0.381218 5.8305556 0.507804 5.8333333 0.629760 5.8361111 0.711578 5.8388889 0.725472 5.8416667 0.656003 5.8444444 0.507804 5.8472222 0.345712 5.8500000 0.209863 5.8527778 0.129588 5.8555556 0.095626 5.8583333 0.090995 5.8611111 0.092539 5.8638889 0.081732 5.8666667 0.061664 5.8694444 0.033877 5.8722222 0.010000 5.8750000 0.010000 5.8777778 0.010000 5.8805556 0.010000 5.8833333 0.010000 5.8861111 0.010000 5.8888889 0.010000 5.8916667 0.019983 5.8944444 0.047770 5.8972222 0.078645 5.9000000 0.106432 5.9027778 0.123413 5.9055556 0.146569 5.9083333 0.158919 5.9111111 0.169726 5.9138889 0.177444 5.9166667 0.178988 5.9194444 0.182075 5.9222222 0.180532 5.9250000 0.186707 5.9277778 0.185163 5.9305556 0.186707 5.9333333 0.191338 5.9361111 0.189794 5.9388889 0.194425 5.9416667 0.195969 5.9444444 0.199057 5.9472222 0.202144 5.9500000 0.202144 5.9527778 0.202144 5.9555556 0.199057 5.9583333 0.203688 5.9611111 0.202144 5.9638889 0.197513 5.9666667 0.200600 5.9694444 0.200600 5.9722222 0.206775 5.9750000 0.212950 5.9777778 0.211407 5.9805556 0.211407 5.9833333 0.209863 5.9861111 0.216038 5.9888889 0.214494 5.9916667 0.216038 5.9944444 0.216038 5.9972222 0.214494 6.0000000 0.209863 6.0027778 0.212950 6.0055556 0.217581 6.0083333 0.228388 6.0111111 0.229931 6.0138889 0.233019 6.0166667 0.229931 6.0194444 0.231475 6.0222222 0.234563 6.0250000 0.234563 6.0277778 0.236106 6.0305556 0.237650 6.0333333 0.236106 6.0361111 0.240738 6.0388889 0.243825 6.0416667 0.246913 6.0444444 0.251544 6.0472222 0.254631 6.0500000 0.260806 6.0527778 0.259262 6.0555556 0.260806 6.0583333 0.259262 6.0611111 0.262350 6.0638889 0.265437 6.0666667 0.268525 6.0694444 0.266981 6.0722222 0.276244 6.0750000 0.279331 6.0777778 0.283962 6.0805556 0.288593 6.0833333 0.285506 6.0861111 0.291681 6.0888889 0.293225 6.0916667 0.293225 6.0944444 0.296312 6.0972222 0.299400 6.1000000 0.300943 6.1027778 0.307118 6.1055556 0.311750 6.1083333 0.316381 6.1111111 0.322556 6.1138889 0.327187 6.1166667 0.330274 6.1194444 0.331818 6.1222222 0.334906 6.1250000 0.334906 6.1277778 0.331818 6.1305556 0.328731 6.1333333 0.336449 6.1361111 0.339537 6.5111111 0.202144 6.5138889 0.206775 6.5166667 0.203688 6.5194444 0.205232 6.5222222 0.205232 6.5250000 0.205232 6.5277778 0.199057 6.5305556 0.200600 6.5333333 0.199057 6.5361111 0.202144 6.5388889 0.199057 6.5416667 0.202144 6.5444444 0.205232 6.5472222 0.208319 6.5500000 0.208319 6.5527778 0.209863 6.5555556 0.214494 6.5583333 0.214494 6.5611111 0.212950 6.5638889 0.214494 6.5666667 0.217581 6.5694444 0.219125 6.5722222 0.222213 6.5750000 0.225300 6.5777778 0.229931 6.5805556 0.233019 6.5833333 0.234563 6.5861111 0.237650 6.5888889 0.242281 6.5916667 0.245369 6.5944444 0.251544 6.5972222 0.256175 6.6000000 0.256175 6.6027778 0.260806 6.6055556 0.257719 6.6083333 0.254631 6.6111111 0.253087 6.6138889 0.253087 6.6166667 0.246913 6.6194444 0.243825 6.6222222 0.240738 6.6250000 0.234563 6.6277778 0.234563 6.6305556 0.229931 6.6333333 0.220669 6.6361111 0.214494 6.6388889 0.212950 6.6416667 0.208319 6.6444444 0.203688 6.6472222 0.203688 6.6500000 0.203688 6.6527778 0.199057 6.6555556 0.194425 6.6583333 0.186707 6.6611111 0.191338 6.6638889 0.186707 6.6666667 0.185163 6.6694444 0.183619 6.6722222 0.185163 6.6750000 0.189794 6.6777778 0.188250 6.6805556 0.191338 6.6833333 0.191338 6.6861111 0.192882 6.6888889 0.185163 6.6916667 0.188250 6.6944444 0.186707 6.6972222 0.186707 6.7000000 0.185163 6.7027778 0.185163 6.7055556 0.188250 6.7083333 0.188250 6.7111111 0.189794 6.7138889 0.194425 6.7166667 0.189794 6.7194444 0.189794 6.7222222 0.183619 6.7250000 0.175901 6.7277778 0.158919 6.7305556 0.140395 6.7333333 0.117238 6.7361111 0.107976 6.7388889 0.118782 6.7416667 0.158919 6.7444444 0.236106 6.7472222 0.339537 6.7500000 0.459949 6.7527778 0.580360 6.7555556 0.679160 6.7583333 0.740909 6.7611111 0.745540 6.7638889 0.676072 6.7666667 0.546398 6.7694444 0.388937 6.7722222 0.253087 6.7750000 0.163551 6.7777778 0.123413 6.7805556 0.114151 6.7833333 0.117238 6.7861111 0.114151 6.7888889 0.097170 6.7916667 0.066295 6.7944444 0.024614 6.7972222 0.010000 6.8000000 0.010000 6.8027778 0.010000 6.8055556 0.010000 6.8083333 0.010000 6.8111111 0.010000 6.8138889 0.010000 6.8166667 0.023070 6.8194444 0.052401 6.8222222 0.084820 6.8250000 0.104889 6.8277778 0.129588 6.8305556 0.141938 6.8333333 0.155832 6.8361111 0.166638 6.8388889 0.174357 6.8416667 0.180532 6.8444444 0.183619 6.8472222 0.185163 6.8500000 0.185163 6.8527778 0.189794 6.8555556 0.192882 6.8583333 0.189794 6.8611111 0.192882 6.8638889 0.189794 6.8666667 0.192882 6.8694444 0.195969 6.8722222 0.197513 6.8750000 0.200600 6.8777778 0.200600 6.8805556 0.206775 6.8833333 0.205232 6.8861111 0.206775 6.8888889 0.205232 6.8916667 0.202144 6.8944444 0.205232 6.8972222 0.200600 6.9000000 0.197513 6.9027778 0.202144 6.9055556 0.206775 6.9083333 0.208319 6.9111111 0.208319 6.9138889 0.212950 6.9166667 0.216038 6.9194444 0.214494 6.9222222 0.211407 6.9250000 0.216038 6.9277778 0.212950 6.9305556 0.212950 6.9333333 0.216038 6.9361111 0.216038 6.9388889 0.219125 6.9416667 0.222213 6.9444444 0.223756 6.9472222 0.229931 6.9500000 0.228388 6.9527778 0.228388 6.9555556 0.226844 6.9583333 0.225300 6.9611111 0.226844 6.9638889 0.231475 6.9666667 0.234563 6.9694444 0.237650 6.9722222 0.239194 6.9750000 0.243825 6.9777778 0.245369 6.9805556 0.251544 6.9833333 0.254631 6.9861111 0.257719 6.9888889 0.254631 6.9916667 0.257719 6.9944444 0.259262 6.9972222 0.259262 7.0000000 0.260806 7.0027778 0.265437 7.0055556 0.266981 7.0083333 0.270069 7.0111111 0.276244 7.0138889 0.283962 7.0166667 0.285506 7.0194444 0.288593 7.0222222 0.290137 7.0250000 0.290137 7.0277778 0.291681 7.0305556 0.293225 7.0333333 0.297856 7.0361111 0.302487 7.0388889 0.307118 7.0416667 0.311750 7.0444444 0.319468 7.0472222 0.322556 7.0500000 0.325643 7.0527778 0.331818 7.0555556 0.331818 7.0583333 0.331818 7.4388889 0.195969 7.4416667 0.192882 7.4444444 0.197513 7.4472222 0.195969 7.4500000 0.194425 7.4527778 0.199057 7.4555556 0.199057 7.4583333 0.199057 7.4611111 0.199057 7.4638889 0.195969 7.4666667 0.195969 7.4694444 0.195969 7.4722222 0.199057 7.4750000 0.199057 7.4777778 0.195969 7.4805556 0.199057 7.4833333 0.200600 7.4861111 0.208319 7.4888889 0.205232 7.4916667 0.209863 7.4944444 0.209863 7.4972222 0.206775 7.5000000 0.209863 7.5027778 0.209863 7.5055556 0.209863 7.5083333 0.214494 7.5111111 0.226844 7.5138889 0.231475 7.5166667 0.237650 7.5194444 0.243825 7.5222222 0.246913 7.5250000 0.248456 7.5277778 0.248456 7.5305556 0.243825 7.5333333 0.245369 7.5361111 0.243825 7.5388889 0.245369 7.5416667 0.248456 7.5444444 0.246913 7.5472222 0.248456 7.5500000 0.242281 7.5527778 0.236106 7.5555556 0.226844 7.5583333 0.222213 7.5611111 0.212950 7.5638889 0.211407 7.5666667 0.206775 7.5694444 0.197513 7.5722222 0.195969 7.5750000 0.192882 7.5777778 0.194425 7.5805556 0.195969 7.5833333 0.195969 7.5861111 0.194425 7.5888889 0.191338 7.5916667 0.185163 7.5944444 0.183619 7.5972222 0.183619 7.6000000 0.180532 7.6027778 0.182075 7.6055556 0.183619 7.6083333 0.186707 7.6111111 0.188250 7.6138889 0.185163 7.6166667 0.185163 7.6194444 0.182075 7.6222222 0.175901 7.6250000 0.178988 7.6277778 0.177444 7.6305556 0.182075 7.6333333 0.180532 7.6361111 0.186707 7.6388889 0.189794 7.6416667 0.192882 7.6444444 0.191338 7.6472222 0.191338 7.6500000 0.188250 7.6527778 0.182075 7.6555556 0.171269 7.6583333 0.152744 7.6611111 0.135763 7.6638889 0.115695 7.6666667 0.109520 7.6694444 0.128045 7.6722222 0.183619 7.6750000 0.266981 7.6777778 0.378130 7.6805556 0.503173 7.6833333 0.614322 7.6861111 0.700772 7.6888889 0.736278 7.6916667 0.702316 7.6944444 0.591166 7.6972222 0.429074 7.7000000 0.273156 7.7027778 0.152744 7.7055556 0.092539 7.7083333 0.080189 7.7111111 0.090995 7.7138889 0.098714 7.7166667 0.095626 7.7194444 0.077101 7.7222222 0.047770 7.7250000 0.012264 7.7277778 0.010000 7.7305556 0.010000 7.7333333 0.010000 7.7361111 0.010000 7.7388889 0.010000 7.7416667 0.010000 7.7444444 0.010000 7.7472222 0.024614 7.7500000 0.049314 7.7527778 0.072470 7.7555556 0.097170 7.7583333 0.118782 7.7611111 0.138851 7.7638889 0.149657 7.7666667 0.163551 7.7694444 0.174357 7.7722222 0.178988 7.7750000 0.185163 7.7777778 0.186707 7.7805556 0.189794 7.7833333 0.191338 7.7861111 0.194425 7.7888889 0.194425 7.7916667 0.194425 7.7944444 0.195969 7.7972222 0.195969 7.8000000 0.194425 7.8027778 0.197513 7.8055556 0.199057 7.8083333 0.206775 7.8111111 0.211407 7.8138889 0.209863 7.8166667 0.211407 7.8194444 0.214494 7.8222222 0.212950 7.8250000 0.209863 7.8277778 0.211407 7.8305556 0.206775 7.8333333 0.206775 7.8361111 0.208319 7.8388889 0.208319 7.8416667 0.209863 7.8444444 0.216038 7.8472222 0.217581 7.8500000 0.220669 7.8527778 0.226844 7.8555556 0.228388 7.8583333 0.225300 7.8611111 0.226844 7.8638889 0.223756 7.8666667 0.228388 7.8694444 0.225300 7.8722222 0.228388 7.8750000 0.226844 7.8777778 0.226844 7.8805556 0.231475 7.8833333 0.234563 7.8861111 0.240738 7.8888889 0.240738 7.8916667 0.242281 7.8944444 0.245369 7.8972222 0.246913 7.9000000 0.248456 7.9027778 0.248456 7.9055556 0.251544 7.9083333 0.254631 7.9111111 0.259262 7.9138889 0.265437 7.9166667 0.266981 7.9194444 0.270069 7.9222222 0.270069 7.9250000 0.268525 7.9277778 0.265437 7.9305556 0.266981 7.9333333 0.270069 7.9361111 0.274700 7.9388889 0.277787 7.9416667 0.280875 7.9444444 0.285506 7.9472222 0.294768 7.9500000 0.296312 7.9527778 0.304031 7.9555556 0.304031 7.9583333 0.305575 7.9611111 0.305575 7.9638889 0.307118 7.9666667 0.308662 7.9694444 0.310206 7.9722222 0.314837 7.9750000 0.316381 7.9777778 0.324099 7.9805556 0.328731 7.9833333 0.331818 7.9861111 0.339537 8.2833333 0.217581 8.2861111 0.217581 8.2888889 0.216038 8.2916667 0.212950 8.2944444 0.209863 8.2972222 0.206775 8.3000000 0.208319 8.3027778 0.205232 8.3055556 0.206775 8.3083333 0.206775 8.3111111 0.209863 8.3138889 0.211407 8.3166667 0.212950 8.3194444 0.214494 8.3222222 0.216038 8.3250000 0.212950 8.3277778 0.216038 8.3305556 0.214494 8.3333333 0.212950 8.3361111 0.219125 8.3388889 0.220669 8.3416667 0.226844 8.3444444 0.229931 8.3472222 0.234563 8.3500000 0.236106 8.3527778 0.237650 8.3555556 0.237650 8.3583333 0.239194 8.3611111 0.242281 8.3638889 0.246913 8.3666667 0.253087 8.3694444 0.257719 8.3722222 0.260806 8.3750000 0.263894 8.3777778 0.265437 8.3805556 0.263894 8.3833333 0.262350 8.3861111 0.257719 8.3888889 0.254631 8.3916667 0.248456 8.3944444 0.243825 8.3972222 0.234563 8.4000000 0.229931 8.4027778 0.220669 8.4055556 0.216038 8.4083333 0.212950 8.4111111 0.211407 8.4138889 0.208319 8.4166667 0.205232 8.4194444 0.200600 8.4222222 0.194425 8.4250000 0.192882 8.4277778 0.186707 8.4305556 0.186707 8.4333333 0.186707 8.4361111 0.186707 8.4388889 0.183619 8.4416667 0.185163 8.4444444 0.189794 8.4472222 0.191338 8.4500000 0.188250 8.4527778 0.189794 8.4555556 0.188250 8.4583333 0.185163 8.4611111 0.182075 8.4638889 0.178988 8.4666667 0.175901 8.4694444 0.178988 8.4722222 0.180532 8.4750000 0.185163 8.4777778 0.183619 8.4805556 0.185163 8.4833333 0.183619 8.4861111 0.185163 8.4888889 0.188250 8.4916667 0.185163 8.4944444 0.182075 8.4972222 0.175901 8.5000000 0.163551 8.5027778 0.149657 8.5055556 0.132676 8.5083333 0.111063 8.5111111 0.112607 8.5138889 0.134220 8.5166667 0.195969 8.5194444 0.288593 8.5222222 0.409005 8.5250000 0.535592 8.5277778 0.648285 8.5305556 0.719297 8.5333333 0.720840 8.5361111 0.631304 8.5388889 0.478473 8.5416667 0.311750 8.5444444 0.178988 8.5472222 0.101801 8.5500000 0.078645 8.5527778 0.080189 8.5555556 0.089451 8.5583333 0.086364 8.5611111 0.069383 8.5638889 0.040051 8.5666667 0.010000 8.5694444 0.010000 8.5722222 0.010000 8.5750000 0.010000 8.5777778 0.010000 8.5805556 0.010000 8.5833333 0.010000 8.5861111 0.010000 8.5888889 0.036964 8.5916667 0.064751 8.5944444 0.089451 8.5972222 0.109520 8.6000000 0.131132 8.6027778 0.148113 8.6055556 0.160463 8.6083333 0.168182 8.6111111 0.174357 8.6138889 0.182075 8.6166667 0.185163 8.6194444 0.183619 8.6222222 0.183619 8.6250000 0.185163 8.6277778 0.189794 8.6305556 0.191338 8.6333333 0.191338 8.6361111 0.189794 8.6388889 0.191338 8.6416667 0.195969 8.6444444 0.202144 8.6472222 0.205232 8.6500000 0.205232 8.6527778 0.203688 8.6555556 0.206775 8.6583333 0.205232 8.6611111 0.202144 8.6638889 0.199057 8.6666667 0.199057 8.6694444 0.199057 8.6722222 0.203688 8.6750000 0.203688 8.6777778 0.206775 8.6805556 0.209863 8.6833333 0.212950 8.6861111 0.212950 8.6888889 0.212950 8.6916667 0.209863 8.6944444 0.212950 8.6972222 0.212950 8.7000000 0.212950 8.7027778 0.212950 8.7055556 0.217581 8.7083333 0.219125 8.7111111 0.220669 8.7138889 0.226844 8.7166667 0.229931 8.7194444 0.231475 8.7222222 0.233019 8.7250000 0.229931 8.7277778 0.231475 8.7305556 0.231475 8.7333333 0.228388 8.7361111 0.233019 8.7388889 0.237650 8.7416667 0.240738 8.7444444 0.239194 8.7472222 0.251544 8.7500000 0.250000 8.7527778 0.248456 8.7555556 0.251544 8.7583333 0.253087 8.7611111 0.256175 8.7638889 0.257719 8.7666667 0.259262 8.7694444 0.259262 8.7722222 0.262350 8.7750000 0.266981 8.7777778 0.271612 8.7805556 0.279331 8.7833333 0.280875 8.7861111 0.282419 8.7888889 0.285506 8.7916667 0.285506 8.7944444 0.287050 8.7972222 0.290137 8.8000000 0.290137 8.8027778 0.293225 8.8055556 0.296312 8.8083333 0.304031 8.8111111 0.304031 8.8138889 0.308662 8.8166667 0.314837 8.8194444 0.322556 8.8222222 0.322556 8.8250000 0.325643 8.8277778 0.324099 8.8305556 0.322556 9.1944444 0.199057 9.1972222 0.194425 9.2000000 0.197513 9.2027778 0.194425 9.2055556 0.197513 9.2083333 0.199057 9.2111111 0.199057 9.2138889 0.200600 9.2166667 0.197513 9.2194444 0.202144 9.2222222 0.203688 9.2250000 0.197513 9.2277778 0.200600 9.2305556 0.194425 9.2333333 0.194425 9.2361111 0.194425 9.2388889 0.194425 9.2416667 0.199057 9.2444444 0.200600 9.2472222 0.203688 9.2500000 0.203688 9.2527778 0.206775 9.2555556 0.206775 9.2583333 0.208319 9.2611111 0.209863 9.2638889 0.209863 9.2666667 0.209863 9.2694444 0.211407 9.2722222 0.214494 9.2750000 0.220669 9.2777778 0.225300 9.2805556 0.231475 9.2833333 0.231475 9.2861111 0.237650 9.2888889 0.246913 9.2916667 0.251544 9.2944444 0.256175 9.2972222 0.257719 9.3000000 0.254631 9.3027778 0.253087 9.3055556 0.248456 9.3083333 0.243825 9.3111111 0.243825 9.3138889 0.237650 9.3166667 0.237650 9.3194444 0.234563 9.3222222 0.231475 9.3250000 0.223756 9.3277778 0.216038 9.3305556 0.205232 9.3333333 0.197513 9.3361111 0.192882 9.3388889 0.191338 9.3416667 0.189794 9.3444444 0.194425 9.3472222 0.194425 9.3500000 0.191338 9.3527778 0.192882 9.3555556 0.192882 9.3583333 0.188250 9.3611111 0.185163 9.3638889 0.180532 9.3666667 0.177444 9.3694444 0.180532 9.3722222 0.177444 9.3750000 0.182075 9.3777778 0.185163 9.3805556 0.186707 9.3833333 0.185163 9.3861111 0.188250 9.3888889 0.186707 9.3916667 0.185163 9.3944444 0.186707 9.3972222 0.185163 9.4000000 0.185163 9.4027778 0.182075 9.4055556 0.178988 9.4083333 0.172813 9.4111111 0.162007 9.4138889 0.143482 9.4166667 0.121870 9.4194444 0.107976 9.4222222 0.117238 9.4250000 0.149657 9.4277778 0.225300 9.4305556 0.327187 9.4333333 0.450686 9.4361111 0.577273 9.4388889 0.680703 9.4416667 0.737822 9.4444444 0.731647 9.4472222 0.649828 9.4500000 0.504717 9.4527778 0.342624 9.4555556 0.217581 9.4583333 0.140395 9.4611111 0.112607 9.4638889 0.111063 9.4666667 0.109520 9.4694444 0.104889 9.4722222 0.083276 9.4750000 0.057033 9.4777778 0.013808 9.4805556 0.010000 9.4833333 0.010000 9.4861111 0.010000 9.4888889 0.010000 9.4916667 0.010000 9.4944444 0.010000 9.4972222 0.010000 9.5000000 0.018439 9.5027778 0.047770 9.5055556 0.075557 9.5083333 0.104889 9.5111111 0.129588 9.5138889 0.149657 9.5166667 0.162007 9.5194444 0.169726 9.5222222 0.174357 9.5250000 0.174357 9.5277778 0.178988 9.5305556 0.177444 9.5333333 0.178988 9.5361111 0.180532 9.5388889 0.182075 9.5416667 0.188250 9.5444444 0.188250 9.5472222 0.192882 9.5500000 0.197513 9.5527778 0.195969 9.5555556 0.197513 9.5583333 0.195969 9.5611111 0.195969 9.5638889 0.192882 9.5666667 0.192882 9.5694444 0.191338 9.5722222 0.195969 9.5750000 0.197513 9.5777778 0.199057 9.5805556 0.203688 9.5833333 0.205232 9.5861111 0.205232 9.5888889 0.203688 9.5916667 0.205232 9.5944444 0.202144 9.5972222 0.205232 9.6000000 0.205232 9.6027778 0.200600 9.6055556 0.203688 9.6083333 0.205232 9.6111111 0.208319 9.6138889 0.212950 9.6166667 0.214494 9.6194444 0.212950 9.6222222 0.214494 9.6250000 0.219125 9.6277778 0.219125 9.6305556 0.217581 9.6333333 0.214494 9.6361111 0.216038 9.6388889 0.217581 9.6416667 0.226844 9.6444444 0.226844 9.6472222 0.233019 9.6500000 0.237650 9.6527778 0.236106 9.6555556 0.237650 9.6583333 0.239194 9.6611111 0.242281 9.6638889 0.239194 9.6666667 0.239194 9.6694444 0.243825 9.6722222 0.248456 9.6750000 0.250000 9.6777778 0.253087 9.6805556 0.259262 9.6833333 0.265437 9.6861111 0.262350 9.6888889 0.270069 9.6916667 0.266981 9.6944444 0.271612 9.6972222 0.268525 9.7000000 0.268525 9.7027778 0.273156 9.7055556 0.271612 9.7083333 0.274700 9.7111111 0.279331 9.7138889 0.288593 9.7166667 0.291681 9.7194444 0.302487 9.7222222 0.305575 9.7250000 0.310206 9.7277778 0.311750 9.7305556 0.311750 9.7333333 0.313293 9.7361111 0.317925 9.7388889 0.321012 9.7416667 0.327187 10.1222222 0.192882 10.1250000 0.189794 10.1277778 0.188250 10.1305556 0.183619 10.1333333 0.185163 10.1361111 0.183619 10.1388889 0.188250 10.1416667 0.186707 10.1444444 0.185163 10.1472222 0.185163 10.1500000 0.185163 10.1527778 0.175901 10.1555556 0.178988 10.1583333 0.183619 10.1611111 0.188250 10.1638889 0.194425 10.1666667 0.200600 10.1694444 0.205232 10.1722222 0.205232 10.1750000 0.202144 10.1777778 0.206775 10.1805556 0.209863 10.1833333 0.212950 10.1861111 0.212950 10.1888889 0.214494 10.1916667 0.212950 10.1944444 0.212950 10.1972222 0.211407 10.2000000 0.219125 10.2027778 0.226844 10.2055556 0.231475 10.2083333 0.239194 10.2111111 0.243825 10.2138889 0.248456 10.2166667 0.251544 10.2194444 0.243825 10.2222222 0.239194 10.2250000 0.236106 10.2277778 0.229931 10.2305556 0.222213 10.2333333 0.212950 10.2361111 0.211407 10.2388889 0.200600 10.2416667 0.197513 10.2444444 0.194425 10.2472222 0.195969 10.2500000 0.192882 10.2527778 0.191338 10.2555556 0.188250 10.2583333 0.183619 10.2611111 0.177444 10.2638889 0.175901 10.2666667 0.177444 10.2694444 0.178988 10.2722222 0.178988 10.2750000 0.182075 10.2777778 0.178988 10.2805556 0.177444 10.2833333 0.177444 10.2861111 0.175901 10.2888889 0.169726 10.2916667 0.171269 10.2944444 0.172813 10.2972222 0.172813 10.3000000 0.171269 10.3027778 0.171269 10.3055556 0.171269 10.3083333 0.172813 10.3111111 0.171269 10.3138889 0.174357 10.3166667 0.172813 10.3194444 0.169726 10.3222222 0.169726 10.3250000 0.172813 10.3277778 0.171269 10.3305556 0.174357 10.3333333 0.166638 10.3361111 0.157376 10.3388889 0.145026 10.3416667 0.132676 10.3444444 0.115695 10.3472222 0.100257 10.3500000 0.104889 10.3527778 0.138851 10.3555556 0.208319 10.3583333 0.300943 10.3611111 0.415180 10.3638889 0.530961 10.3666667 0.634391 10.3694444 0.706947 10.3722222 0.727015 10.3750000 0.676072 10.3777778 0.557204 10.3805556 0.395111 10.3833333 0.236106 10.3861111 0.128045 10.3888889 0.070926 10.3916667 0.066295 10.3944444 0.072470 10.3972222 0.083276 10.4000000 0.083276 10.4027778 0.070926 10.4055556 0.041595 10.4083333 0.013808 10.4111111 0.010000 10.4138889 0.010000 10.4166667 0.010000 10.4194444 0.010000 10.4222222 0.010000 10.4250000 0.010000 10.4277778 0.010000 10.4305556 0.010000 10.4333333 0.010000 10.4361111 0.018439 10.4388889 0.047770 10.4416667 0.077101 10.4444444 0.104889 10.4472222 0.124957 10.4500000 0.143482 10.4527778 0.148113 10.4555556 0.155832 10.4583333 0.158919 10.4611111 0.162007 10.4638889 0.162007 10.4666667 0.166638 10.4694444 0.169726 10.4722222 0.169726 10.4750000 0.175901 10.4777778 0.180532 10.4805556 0.186707 10.4833333 0.191338 10.4861111 0.194425 10.4888889 0.195969 10.4916667 0.192882 10.4944444 0.189794 10.4972222 0.188250 10.5000000 0.183619 10.5027778 0.183619 10.5055556 0.180532 10.5083333 0.186707 10.5111111 0.185163 10.5138889 0.194425 10.5166667 0.199057 10.5194444 0.202144 10.5222222 0.205232 10.5250000 0.203688 10.5277778 0.202144 10.5305556 0.203688 10.5333333 0.199057 10.5361111 0.202144 10.5388889 0.200600 10.5416667 0.203688 10.5444444 0.202144 10.5472222 0.197513 10.5500000 0.199057 10.5527778 0.200600 10.5555556 0.205232 10.5583333 0.211407 10.5611111 0.216038 10.5638889 0.222213 10.5666667 0.225300 10.5694444 0.223756 10.5722222 0.223756 10.5750000 0.222213 10.5777778 0.222213 10.5805556 0.220669 10.5833333 0.220669 10.5861111 0.222213 10.5888889 0.225300 10.5916667 0.223756 10.5944444 0.225300 10.5972222 0.228388 10.6000000 0.234563 10.6027778 0.240738 10.6055556 0.243825 10.6083333 0.248456 10.6111111 0.250000 10.6138889 0.250000 10.6166667 0.256175 10.6194444 0.253087 10.6222222 0.259262 10.6250000 0.259262 10.6277778 0.260806 10.6305556 0.259262 10.6333333 0.265437 10.6361111 0.265437 10.6388889 0.271612 10.6416667 0.277787 10.6444444 0.282419 10.6472222 0.285506 10.6500000 0.290137 10.6527778 0.288593 10.6555556 0.293225 10.6583333 0.291681 10.6611111 0.296312 10.6638889 0.297856 10.6666667 0.297856 10.6694444 0.304031 10.9972222 0.183619 11.0000000 0.178988 11.0027778 0.183619 11.0055556 0.174357 11.0083333 0.178988 11.0111111 0.180532 11.0138889 0.185163 11.0166667 0.183619 11.0194444 0.182075 11.0222222 0.180532 11.0250000 0.178988 11.0277778 0.178988 11.0305556 0.175901 11.0333333 0.174357 11.0361111 0.180532 11.0388889 0.182075 11.0416667 0.183619 11.0444444 0.183619 11.0472222 0.189794 11.0500000 0.195969 11.0527778 0.199057 11.0555556 0.199057 11.0583333 0.200600 11.0611111 0.199057 11.0638889 0.202144 11.0666667 0.200600 11.0694444 0.203688 11.0722222 0.212950 11.0750000 0.220669 11.0777778 0.226844 11.0805556 0.236106 11.0833333 0.239194 11.0861111 0.240738 11.0888889 0.236106 11.0916667 0.233019 11.0944444 0.229931 11.0972222 0.223756 11.1000000 0.219125 11.1027778 0.217581 11.1055556 0.214494 11.1083333 0.211407 11.1111111 0.209863 11.1138889 0.208319 11.1166667 0.206775 11.1194444 0.195969 11.1222222 0.195969 11.1250000 0.183619 11.1277778 0.175901 11.1305556 0.169726 11.1333333 0.166638 11.1361111 0.165094 11.1388889 0.163551 11.1416667 0.162007 11.1444444 0.166638 11.1472222 0.168182 11.1500000 0.168182 11.1527778 0.168182 11.1555556 0.166638 11.1583333 0.165094 11.1611111 0.166638 11.1638889 0.163551 11.1666667 0.162007 11.1694444 0.160463 11.1722222 0.158919 11.1750000 0.158919 11.1777778 0.162007 11.1805556 0.166638 11.1833333 0.166638 11.1861111 0.171269 11.1888889 0.168182 11.1916667 0.162007 11.1944444 0.163551 11.1972222 0.162007 11.2000000 0.160463 11.2027778 0.158919 11.2055556 0.162007 11.2083333 0.160463 11.2111111 0.157376 11.2138889 0.152744 11.2166667 0.138851 11.2194444 0.114151 11.2222222 0.092539 11.2250000 0.083276 11.2277778 0.100257 11.2305556 0.143482 11.2333333 0.223756 11.2361111 0.336449 11.2388889 0.461492 11.2416667 0.583448 11.2444444 0.672985 11.2472222 0.710034 11.2500000 0.686878 11.2527778 0.578816 11.2555556 0.427530 11.2583333 0.276244 11.2611111 0.169726 11.2638889 0.109520 11.2666667 0.087907 11.2694444 0.084820 11.2722222 0.083276 11.2750000 0.075557 11.2777778 0.049314 11.2805556 0.016895 11.2833333 0.010000 11.2861111 0.010000 11.2888889 0.010000 11.2916667 0.010000 11.2944444 0.010000 11.2972222 0.010000 11.3000000 0.010000 11.3027778 0.010000 11.3055556 0.016895 11.3083333 0.046226 11.3111111 0.075557 11.3138889 0.100257 11.3166667 0.120326 11.3194444 0.134220 11.3222222 0.145026 11.3250000 0.148113 11.3277778 0.149657 11.3305556 0.149657 11.3333333 0.151201 11.3361111 0.152744 11.3388889 0.157376 11.3416667 0.163551 11.3444444 0.163551 11.3472222 0.166638 11.3500000 0.171269 11.3527778 0.172813 11.3555556 0.174357 11.3583333 0.172813 11.3611111 0.174357 11.3638889 0.172813 11.3666667 0.172813 11.3694444 0.174357 11.3722222 0.175901 11.3750000 0.172813 11.3777778 0.178988 11.3805556 0.182075 11.3833333 0.178988 11.3861111 0.182075 11.3888889 0.183619 11.3916667 0.183619 11.3944444 0.186707 11.3972222 0.183619 11.4000000 0.178988 11.4027778 0.180532 11.4055556 0.186707 11.4083333 0.188250 11.4111111 0.191338 11.4138889 0.195969 11.4166667 0.199057 11.4194444 0.200600 11.4222222 0.199057 11.4250000 0.200600 11.4277778 0.203688 11.4305556 0.202144 11.4333333 0.203688 11.4361111 0.203688 11.4388889 0.206775 11.4416667 0.209863 11.4444444 0.216038 11.4472222 0.219125 11.4500000 0.223756 11.4527778 0.228388 11.4555556 0.228388 11.4583333 0.228388 11.4611111 0.233019 11.4638889 0.231475 11.4666667 0.233019 11.4694444 0.236106 11.4722222 0.239194 11.4750000 0.245369 11.4777778 0.248456 11.4805556 0.251544 11.4833333 0.256175 11.4861111 0.260806 11.4888889 0.265437 11.4916667 0.270069 11.4944444 0.268525 11.4972222 0.273156 11.5000000 0.274700 11.5027778 0.279331 11.5055556 0.283962 11.5083333 0.288593 11.5111111 0.294768 11.5138889 0.299400 11.5166667 0.304031 11.5194444 0.307118 11.5222222 0.311750 11.5250000 0.311750 11.5277778 0.316381 11.5305556 0.319468 11.5333333 0.321012 11.5361111 0.324099 11.5388889 0.328731 11.5416667 0.333362 11.5444444 0.334906 11.9500000 0.171269 11.9527778 0.174357 11.9555556 0.174357 11.9583333 0.172813 11.9611111 0.171269 11.9638889 0.165094 11.9666667 0.166638 11.9694444 0.165094 11.9722222 0.166638 11.9750000 0.168182 11.9777778 0.171269 11.9805556 0.168182 11.9833333 0.168182 11.9861111 0.174357 11.9888889 0.174357 11.9916667 0.175901 11.9944444 0.178988 11.9972222 0.177444 12.0000000 0.177444 12.0027778 0.178988 12.0055556 0.183619 12.0083333 0.180532 12.0111111 0.191338 12.0138889 0.191338 12.0166667 0.197513 12.0194444 0.203688 12.0222222 0.206775 12.0250000 0.209863 12.0277778 0.214494 12.0305556 0.219125 12.0333333 0.219125 12.0361111 0.220669 12.0388889 0.219125 12.0416667 0.219125 12.0444444 0.216038 12.0472222 0.214494 12.0500000 0.216038 12.0527778 0.211407 12.0555556 0.212950 12.0583333 0.206775 12.0611111 0.199057 12.0638889 0.195969 12.0666667 0.189794 12.0694444 0.185163 12.0722222 0.180532 12.0750000 0.174357 12.0777778 0.171269 12.0805556 0.166638 12.0833333 0.166638 12.0861111 0.160463 12.0888889 0.160463 12.0916667 0.157376 12.0944444 0.157376 12.0972222 0.155832 12.1000000 0.155832 12.1027778 0.154288 12.1055556 0.152744 12.1083333 0.154288 12.1111111 0.157376 12.1138889 0.154288 12.1166667 0.154288 12.1194444 0.155832 12.1222222 0.155832 12.1250000 0.157376 12.1277778 0.155832 12.1305556 0.152744 12.1333333 0.152744 12.1361111 0.152744 12.1388889 0.152744 12.1416667 0.154288 12.1444444 0.157376 12.1472222 0.160463 12.1500000 0.162007 12.1527778 0.160463 12.1555556 0.160463 12.1583333 0.155832 12.1611111 0.148113 12.1638889 0.132676 12.1666667 0.115695 12.1694444 0.094082 12.1722222 0.078645 12.1750000 0.072470 12.1777778 0.098714 12.1805556 0.145026 12.1833333 0.229931 12.1861111 0.330274 12.1888889 0.442967 12.1916667 0.549485 12.1944444 0.643654 12.1972222 0.702316 12.2000000 0.700772 12.2027778 0.631304 12.2055556 0.500086 12.2083333 0.347256 12.2111111 0.217581 12.2138889 0.135763 12.2166667 0.098714 12.2194444 0.092539 12.2222222 0.094082 12.2250000 0.090995 12.2277778 0.072470 12.2305556 0.040051 12.2333333 0.010000 12.2361111 0.010000 12.2388889 0.010000 12.2416667 0.010000 12.2444444 0.010000 12.2472222 0.010000 12.2500000 0.010000 12.2527778 0.010000 12.2555556 0.010000 12.2583333 0.010720 12.2611111 0.033877 12.2638889 0.061664 12.2666667 0.081732 12.2694444 0.101801 12.2722222 0.117238 12.2750000 0.132676 12.2777778 0.138851 12.2805556 0.145026 12.2833333 0.152744 12.2861111 0.154288 12.2888889 0.155832 12.2916667 0.158919 12.2944444 0.154288 12.2972222 0.157376 12.3000000 0.155832 12.3027778 0.158919 12.3055556 0.160463 12.3083333 0.160463 12.3111111 0.166638 12.3138889 0.168182 12.3166667 0.169726 12.3194444 0.169726 12.3222222 0.172813 12.3250000 0.174357 12.3277778 0.169726 12.3305556 0.168182 12.3333333 0.166638 12.3361111 0.169726 12.3388889 0.171269 12.3416667 0.169726 12.3444444 0.172813 12.3472222 0.177444 12.3500000 0.180532 12.3527778 0.182075 12.3555556 0.183619 12.3583333 0.182075 12.3611111 0.182075 12.3638889 0.177444 12.3666667 0.178988 12.3694444 0.180532 12.3722222 0.180532 12.3750000 0.180532 12.3777778 0.182075 12.3805556 0.188250 12.3833333 0.191338 12.3861111 0.194425 12.3888889 0.194425 12.3916667 0.197513 12.3944444 0.195969 12.3972222 0.194425 12.4000000 0.195969 12.4027778 0.195969 12.4055556 0.200600 12.4083333 0.200600 12.4111111 0.203688 12.4138889 0.208319 12.4166667 0.211407 12.4194444 0.211407 12.4222222 0.211407 12.4250000 0.209863 12.4277778 0.214494 12.4305556 0.212950 12.4333333 0.214494 12.4361111 0.217581 12.4388889 0.219125 12.4416667 0.225300 12.4444444 0.231475 12.4472222 0.231475 12.4500000 0.236106 12.4527778 0.242281 12.4555556 0.243825 12.4583333 0.243825 12.4611111 0.242281 12.4638889 0.245369 12.4666667 0.248456 12.4694444 0.246913 12.4722222 0.251544 12.4750000 0.253087 12.4777778 0.259262 12.4805556 0.263894 12.4833333 0.276244 12.4861111 0.276244 12.4888889 0.282419 12.4916667 0.285506 12.4944444 0.290137 12.4972222 0.291681 12.9555556 0.162007 12.9583333 0.163551 12.9611111 0.157376 12.9638889 0.155832 12.9666667 0.155832 12.9694444 0.157376 12.9722222 0.157376 12.9750000 0.160463 12.9777778 0.160463 12.9805556 0.157376 12.9833333 0.163551 12.9861111 0.158919 12.9888889 0.160463 12.9916667 0.158919 12.9944444 0.155832 12.9972222 0.157376 13.0000000 0.157376 13.0027778 0.155832 13.0055556 0.160463 13.0083333 0.168182 13.0111111 0.171269 13.0138889 0.178988 13.0166667 0.182075 13.0194444 0.185163 13.0222222 0.182075 13.0250000 0.180532 13.0277778 0.183619 13.0305556 0.189794 13.0333333 0.191338 13.0361111 0.203688 13.0388889 0.211407 13.0416667 0.214494 13.0444444 0.216038 13.0472222 0.212950 13.0500000 0.211407 13.0527778 0.208319 13.0555556 0.203688 13.0583333 0.200600 13.0611111 0.199057 13.0638889 0.192882 13.0666667 0.189794 13.0694444 0.186707 13.0722222 0.182075 13.0750000 0.174357 13.0777778 0.169726 13.0805556 0.163551 13.0833333 0.162007 13.0861111 0.155832 13.0888889 0.155832 13.0916667 0.155832 13.0944444 0.160463 13.0972222 0.155832 13.1000000 0.149657 13.1027778 0.146569 13.1055556 0.148113 13.1083333 0.140395 13.1111111 0.140395 13.1138889 0.141938 13.1166667 0.145026 13.1194444 0.146569 13.1222222 0.146569 13.1250000 0.149657 13.1277778 0.148113 13.1305556 0.145026 13.1333333 0.148113 13.1361111 0.146569 13.1388889 0.145026 13.1416667 0.146569 13.1444444 0.148113 13.1472222 0.149657 13.1500000 0.148113 13.1527778 0.143482 13.1555556 0.140395 13.1583333 0.143482 13.1611111 0.140395 13.1638889 0.145026 13.1666667 0.145026 13.1694444 0.146569 13.1722222 0.137307 13.1750000 0.120326 13.1777778 0.100257 13.1805556 0.084820 13.1833333 0.081732 13.1861111 0.106432 13.1888889 0.162007 13.1916667 0.250000 13.1944444 0.359605 13.1972222 0.486192 13.2000000 0.597341 13.2027778 0.672985 13.2055556 0.697684 13.2083333 0.648285 13.2111111 0.524786 13.2138889 0.364237 13.2166667 0.209863 13.2194444 0.100257 13.2222222 0.052401 13.2250000 0.044683 13.2277778 0.052401 13.2305556 0.061664 13.2333333 0.060120 13.2361111 0.040051 13.2388889 0.013808 13.2416667 0.010000 13.2444444 0.010000 13.2472222 0.010000 13.2500000 0.010000 13.2527778 0.010000 13.2555556 0.010000 13.2583333 0.010000 13.2611111 0.010000 13.2638889 0.010000 13.2666667 0.010000 13.2694444 0.013808 13.2722222 0.032333 13.2750000 0.053945 13.2777778 0.078645 13.2805556 0.098714 13.2833333 0.117238 13.2861111 0.129588 13.2888889 0.135763 13.2916667 0.141938 13.2944444 0.140395 13.2972222 0.145026 13.3000000 0.146569 13.3027778 0.152744 13.3055556 0.152744 13.3083333 0.157376 13.3111111 0.162007 13.3138889 0.162007 13.3166667 0.163551 13.3194444 0.163551 13.3222222 0.163551 13.3250000 0.166638 13.3277778 0.166638 13.3305556 0.168182 13.3333333 0.166638 13.3361111 0.169726 13.3388889 0.169726 13.3416667 0.165094 13.3444444 0.172813 13.3472222 0.172813 13.3500000 0.174357 13.3527778 0.177444 13.3555556 0.178988 13.3583333 0.178988 13.3611111 0.177444 13.3638889 0.175901 13.3666667 0.171269 13.3694444 0.177444 13.3722222 0.178988 13.3750000 0.178988 13.3777778 0.180532 13.3805556 0.183619 13.3833333 0.188250 13.3861111 0.194425 13.3888889 0.197513 13.3916667 0.195969 13.3944444 0.192882 13.3972222 0.188250 13.4000000 0.188250 13.4027778 0.185163 13.4055556 0.189794 13.4083333 0.194425 13.4111111 0.195969 13.4138889 0.195969 13.4166667 0.195969 13.4194444 0.202144 13.4222222 0.202144 13.4250000 0.205232 13.4277778 0.214494 13.4305556 0.216038 13.4333333 0.214494 13.4361111 0.216038 13.4388889 0.212950 13.4416667 0.214494 13.4444444 0.217581 13.4472222 0.220669 13.4500000 0.226844 13.4527778 0.231475 13.4555556 0.231475 13.4583333 0.236106 13.4611111 0.237650 13.4638889 0.233019 13.4666667 0.234563 13.4694444 0.239194 13.4722222 0.243825 13.4750000 0.248456 13.4777778 0.254631 13.4805556 0.259262 13.4833333 0.263894 13.4861111 0.265437 13.4888889 0.263894 13.4916667 0.262350 13.4944444 0.265437 13.4972222 0.266981 13.5000000 0.270069 13.5027778 0.277787 13.8444444 0.155832 13.8472222 0.155832 13.8500000 0.158919 13.8527778 0.160463 13.8555556 0.157376 13.8583333 0.160463 13.8611111 0.154288 13.8638889 0.154288 13.8666667 0.152744 13.8694444 0.148113 13.8722222 0.146569 13.8750000 0.152744 13.8777778 0.154288 13.8805556 0.155832 13.8833333 0.160463 13.8861111 0.162007 13.8888889 0.166638 13.8916667 0.166638 13.8944444 0.166638 13.8972222 0.169726 13.9000000 0.166638 13.9027778 0.166638 13.9055556 0.169726 13.9083333 0.178988 13.9111111 0.182075 13.9138889 0.182075 13.9166667 0.188250 13.9194444 0.191338 13.9222222 0.194425 13.9250000 0.200600 13.9277778 0.203688 13.9305556 0.209863 13.9333333 0.211407 13.9361111 0.206775 13.9388889 0.208319 13.9416667 0.208319 13.9444444 0.206775 13.9472222 0.202144 13.9500000 0.200600 13.9527778 0.203688 13.9555556 0.200600 13.9583333 0.194425 13.9611111 0.189794 13.9638889 0.178988 13.9666667 0.174357 13.9694444 0.171269 13.9722222 0.165094 13.9750000 0.160463 13.9777778 0.155832 13.9805556 0.157376 13.9833333 0.154288 13.9861111 0.155832 13.9888889 0.155832 13.9916667 0.152744 13.9944444 0.152744 13.9972222 0.148113 14.0000000 0.146569 14.0027778 0.143482 14.0055556 0.143482 14.0083333 0.143482 14.0111111 0.146569 14.0138889 0.148113 14.0166667 0.151201 14.0194444 0.148113 14.0222222 0.149657 14.0250000 0.146569 14.0277778 0.145026 14.0305556 0.141938 14.0333333 0.140395 14.0361111 0.138851 14.0388889 0.140395 14.0416667 0.143482 14.0444444 0.143482 14.0472222 0.143482 14.0500000 0.148113 14.0527778 0.145026 14.0555556 0.143482 14.0583333 0.138851 14.0611111 0.129588 14.0638889 0.114151 14.0666667 0.090995 14.0694444 0.072470 14.0722222 0.064751 14.0750000 0.080189 14.0777778 0.135763 14.0805556 0.223756 14.0833333 0.337993 14.0861111 0.463036 14.0888889 0.578816 14.0916667 0.668353 14.0944444 0.696141 14.0972222 0.645197 14.1000000 0.523242 14.1027778 0.367324 14.1055556 0.223756 14.1083333 0.126501 14.1111111 0.078645 14.1138889 0.067839 14.1166667 0.066295 14.1194444 0.064751 14.1222222 0.047770 14.1250000 0.019983 14.1277778 0.010000 14.1305556 0.010000 14.1333333 0.010000 14.1361111 0.010000 14.1388889 0.010000 14.1416667 0.010000 14.1444444 0.010000 14.1472222 0.010000 14.1500000 0.010000 14.1527778 0.015352 14.1555556 0.043139 14.1583333 0.070926 14.1611111 0.089451 14.1638889 0.107976 14.1666667 0.114151 14.1694444 0.120326 14.1722222 0.126501 14.1750000 0.134220 14.1777778 0.138851 14.1805556 0.138851 14.1833333 0.146569 14.1861111 0.152744 14.1888889 0.152744 14.1916667 0.151201 14.1944444 0.151201 14.1972222 0.152744 14.2000000 0.149657 14.2027778 0.149657 14.2055556 0.149657 14.2083333 0.152744 14.2111111 0.155832 14.2138889 0.160463 14.2166667 0.163551 14.2194444 0.162007 14.2222222 0.160463 14.2250000 0.162007 14.2277778 0.165094 14.2305556 0.165094 14.2333333 0.162007 14.2361111 0.160463 14.2388889 0.165094 14.2416667 0.158919 14.2444444 0.165094 14.2472222 0.166638 14.2500000 0.171269 14.2527778 0.175901 14.2555556 0.175901 14.2583333 0.178988 14.2611111 0.175901 14.2638889 0.177444 14.2666667 0.174357 14.2694444 0.174357 14.2722222 0.174357 14.2750000 0.178988 14.2777778 0.182075 14.2805556 0.186707 14.2833333 0.191338 14.2861111 0.192882 14.2888889 0.192882 14.2916667 0.194425 14.2944444 0.192882 14.2972222 0.195969 14.3000000 0.194425 14.3027778 0.197513 14.3055556 0.199057 14.3083333 0.205232 14.3111111 0.206775 14.3138889 0.211407 14.3166667 0.219125 14.3194444 0.222213 14.3222222 0.223756 14.3250000 0.223756 14.3277778 0.223756 14.3305556 0.228388 14.3333333 0.229931 14.3361111 0.229931 14.3388889 0.231475 14.3416667 0.237650 14.3444444 0.239194 14.3472222 0.245369 14.3500000 0.256175 14.3527778 0.256175 14.3555556 0.262350 14.3583333 0.262350 14.3611111 0.265437 14.3638889 0.268525 14.3666667 0.270069 14.3694444 0.274700 14.3722222 0.276244 14.3750000 0.283962 14.3777778 0.285506 14.3805556 0.288593 14.3833333 0.294768 14.3861111 0.296312 14.3888889 0.302487 14.3916667 0.299400 14.8305556 0.154288 14.8333333 0.151201 14.8361111 0.152744 14.8388889 0.155832 14.8416667 0.157376 14.8444444 0.157376 14.8472222 0.158919 14.8500000 0.160463 14.8527778 0.162007 14.8555556 0.158919 14.8583333 0.158919 14.8611111 0.155832 14.8638889 0.155832 14.8666667 0.154288 14.8694444 0.151201 14.8722222 0.152744 14.8750000 0.154288 14.8777778 0.157376 14.8805556 0.157376 14.8833333 0.163551 14.8861111 0.166638 14.8888889 0.169726 14.8916667 0.172813 14.8944444 0.171269 14.8972222 0.172813 14.9000000 0.171269 14.9027778 0.172813 14.9055556 0.177444 14.9083333 0.178988 14.9111111 0.178988 14.9138889 0.183619 14.9166667 0.194425 14.9194444 0.200600 14.9222222 0.205232 14.9250000 0.209863 14.9277778 0.208319 14.9305556 0.211407 14.9333333 0.212950 14.9361111 0.208319 14.9388889 0.205232 14.9416667 0.203688 14.9444444 0.200600 14.9472222 0.195969 14.9500000 0.195969 14.9527778 0.194425 14.9555556 0.186707 14.9583333 0.183619 14.9611111 0.175901 14.9638889 0.169726 14.9666667 0.160463 14.9694444 0.158919 14.9722222 0.154288 14.9750000 0.154288 14.9777778 0.148113 14.9805556 0.149657 14.9833333 0.152744 14.9861111 0.154288 14.9888889 0.152744 14.9916667 0.152744 14.9944444 0.151201 14.9972222 0.148113 15.0000000 0.143482 15.0027778 0.143482 15.0055556 0.146569 15.0083333 0.146569 15.0111111 0.148113 15.0138889 0.146569 15.0166667 0.152744 15.0194444 0.155832 15.0222222 0.152744 15.0250000 0.154288 15.0277778 0.151201 15.0305556 0.151201 15.0333333 0.146569 15.0361111 0.146569 15.0388889 0.146569 15.0416667 0.141938 15.0444444 0.137307 15.0472222 0.128045 15.0500000 0.109520 15.0527778 0.094082 15.0555556 0.074014 15.0583333 0.080189 15.0611111 0.114151 15.0638889 0.183619 15.0666667 0.279331 15.0694444 0.399743 15.0722222 0.521698 15.0750000 0.631304 15.0777778 0.702316 15.0805556 0.716209 15.0833333 0.659091 15.0861111 0.529417 15.0888889 0.375043 15.0916667 0.234563 15.0944444 0.137307 15.0972222 0.090995 15.1000000 0.081732 15.1027778 0.081732 15.1055556 0.083276 15.1083333 0.075557 15.1111111 0.047770 15.1138889 0.013808 15.1166667 0.010000 15.1194444 0.010000 15.1222222 0.010000 15.1250000 0.010000 15.1277778 0.010000 15.1305556 0.010000 15.1333333 0.010000 15.1361111 0.010000 15.1388889 0.010000 15.1416667 0.010000 15.1444444 0.035420 15.1472222 0.067839 15.1500000 0.090995 15.1527778 0.112607 15.1555556 0.121870 15.1583333 0.128045 15.1611111 0.135763 15.1638889 0.138851 15.1666667 0.138851 15.1694444 0.140395 15.1722222 0.141938 15.1750000 0.141938 15.1777778 0.148113 15.1805556 0.148113 15.1833333 0.155832 15.1861111 0.157376 15.1888889 0.160463 15.1916667 0.160463 15.1944444 0.160463 15.1972222 0.158919 15.2000000 0.157376 15.2027778 0.157376 15.2055556 0.157376 15.2083333 0.160463 15.2111111 0.162007 15.2138889 0.165094 15.2166667 0.168182 15.2194444 0.172813 15.2222222 0.171269 15.2250000 0.169726 15.2277778 0.171269 15.2305556 0.168182 15.2333333 0.169726 15.2361111 0.168182 15.2388889 0.168182 15.2416667 0.171269 15.2444444 0.172813 15.2472222 0.172813 15.2500000 0.178988 15.2527778 0.180532 15.2555556 0.180532 15.2583333 0.182075 15.2611111 0.178988 15.2638889 0.178988 15.2666667 0.178988 15.2694444 0.175901 15.2722222 0.180532 15.2750000 0.182075 15.2777778 0.185163 15.2805556 0.185163 15.2833333 0.189794 15.2861111 0.195969 15.2888889 0.195969 15.2916667 0.199057 15.2944444 0.197513 15.2972222 0.197513 15.3000000 0.197513 15.3027778 0.200600 15.3055556 0.199057 15.3083333 0.202144 15.3111111 0.211407 15.3138889 0.212950 15.3166667 0.214494 15.3194444 0.219125 15.3222222 0.222213 15.3250000 0.226844 15.3277778 0.226844 15.3305556 0.229931 15.3333333 0.229931 15.3361111 0.233019 15.3388889 0.234563 15.3416667 0.236106 15.3444444 0.239194 15.3472222 0.245369 15.3500000 0.248456 15.3527778 0.256175 15.3555556 0.259262 15.3583333 0.262350 15.3611111 0.263894 15.3638889 0.268525 15.3666667 0.268525 15.3694444 0.270069 15.3722222 0.274700 15.3750000 0.282419 15.3777778 0.283962 15.8972222 0.149657 15.9000000 0.149657 15.9027778 0.148113 15.9055556 0.149657 15.9083333 0.146569 15.9111111 0.149657 15.9138889 0.151201 15.9166667 0.154288 15.9194444 0.151201 15.9222222 0.151201 15.9250000 0.152744 15.9277778 0.152744 15.9305556 0.149657 15.9333333 0.143482 15.9361111 0.148113 15.9388889 0.149657 15.9416667 0.157376 15.9444444 0.163551 15.9472222 0.169726 15.9500000 0.172813 15.9527778 0.175901 15.9555556 0.171269 15.9583333 0.171269 15.9611111 0.172813 15.9638889 0.168182 15.9666667 0.165094 15.9694444 0.171269 15.9722222 0.177444 15.9750000 0.185163 15.9777778 0.194425 15.9805556 0.202144 15.9833333 0.211407 15.9861111 0.212950 15.9888889 0.211407 15.9916667 0.209863 15.9944444 0.203688 15.9972222 0.199057 16.0000000 0.199057 16.0027778 0.188250 16.0055556 0.185163 16.0083333 0.182075 16.0111111 0.180532 16.0138889 0.177444 16.0166667 0.174357 16.0194444 0.175901 16.0222222 0.174357 16.0250000 0.168182 16.0277778 0.160463 16.0305556 0.151201 16.0333333 0.146569 16.0361111 0.143482 16.0388889 0.141938 16.0416667 0.140395 16.0444444 0.141938 16.0472222 0.140395 16.0500000 0.141938 16.0527778 0.141938 16.0555556 0.140395 16.0583333 0.141938 16.0611111 0.140395 16.0638889 0.140395 16.0666667 0.137307 16.0694444 0.137307 16.0722222 0.134220 16.0750000 0.135763 16.0777778 0.141938 16.0805556 0.143482 16.0833333 0.145026 16.0861111 0.148113 16.0888889 0.143482 16.0916667 0.143482 16.0944444 0.140395 16.0972222 0.140395 16.1000000 0.135763 16.1027778 0.134220 16.1055556 0.134220 16.1083333 0.132676 16.1111111 0.131132 16.1138889 0.124957 16.1166667 0.121870 16.1194444 0.103345 16.1222222 0.081732 16.1250000 0.072470 16.1277778 0.086364 16.1305556 0.131132 16.1333333 0.212950 16.1361111 0.317925 16.1388889 0.446055 16.1416667 0.564923 16.1444444 0.660635 16.1472222 0.705403 16.1500000 0.677616 16.1527778 0.569554 16.1555556 0.404374 16.1583333 0.236106 16.1611111 0.111063 16.1638889 0.043139 16.1666667 0.023070 16.1694444 0.033877 16.1722222 0.043139 16.1750000 0.043139 16.1777778 0.030789 16.1805556 0.010000 16.1833333 0.010000 16.1861111 0.010000 16.1888889 0.010000 16.1916667 0.010000 16.1944444 0.010000 16.1972222 0.010000 16.2000000 0.010000 16.2027778 0.010000 16.2055556 0.010000 16.2083333 0.018439 16.2111111 0.047770 16.2138889 0.074014 16.2166667 0.097170 16.2194444 0.118782 16.2222222 0.135763 16.2250000 0.140395 16.2277778 0.141938 16.2305556 0.140395 16.2333333 0.135763 16.2361111 0.137307 16.2388889 0.138851 16.2416667 0.145026 16.2444444 0.152744 16.2472222 0.158919 16.2500000 0.160463 16.2527778 0.158919 16.2555556 0.162007 16.2583333 0.160463 16.2611111 0.163551 16.2638889 0.160463 16.2666667 0.157376 16.2694444 0.160463 16.2722222 0.158919 16.2750000 0.160463 16.2777778 0.160463 16.2805556 0.163551 16.2833333 0.166638 16.2861111 0.169726 16.2888889 0.172813 16.2916667 0.177444 16.2944444 0.177444 16.2972222 0.174357 16.3000000 0.169726 16.3027778 0.169726 16.3055556 0.171269 16.3083333 0.172813 16.3111111 0.177444 16.3138889 0.182075 16.3166667 0.183619 16.3194444 0.182075 16.3222222 0.183619 16.3250000 0.185163 16.3277778 0.185163 16.3305556 0.189794 16.3333333 0.191338 16.3361111 0.191338 16.3388889 0.194425 16.3416667 0.192882 16.3444444 0.197513 16.3472222 0.202144 16.3500000 0.205232 16.3527778 0.206775 16.3555556 0.209863 16.3583333 0.212950 16.3611111 0.209863 16.3638889 0.206775 16.3666667 0.206775 16.3694444 0.206775 16.3722222 0.211407 16.3750000 0.214494 16.3777778 0.223756 16.3805556 0.225300 16.3833333 0.229931 16.3861111 0.234563 16.3888889 0.236106 16.3916667 0.237650 16.3944444 0.236106 16.3972222 0.234563 16.4000000 0.237650 16.4027778 0.234563 16.4055556 0.239194 16.4083333 0.243825 16.4111111 0.250000 16.4138889 0.256175 16.4166667 0.262350 16.4194444 0.263894 16.4222222 0.271612 16.4250000 0.274700 16.4277778 0.274700 16.4305556 0.274700 16.4333333 0.277787 16.4361111 0.277787 16.4388889 0.277787 16.4416667 0.279331 16.4444444 0.283962 16.7944444 0.146569 16.7972222 0.148113 16.8000000 0.145026 16.8027778 0.141938 16.8055556 0.137307 16.8083333 0.135763 16.8111111 0.137307 16.8138889 0.140395 16.8166667 0.148113 16.8194444 0.149657 16.8222222 0.149657 16.8250000 0.148113 16.8277778 0.146569 16.8305556 0.145026 16.8333333 0.141938 16.8361111 0.140395 16.8388889 0.140395 16.8416667 0.140395 16.8444444 0.138851 16.8472222 0.146569 16.8500000 0.151201 16.8527778 0.155832 16.8555556 0.157376 16.8583333 0.162007 16.8611111 0.163551 16.8638889 0.163551 16.8666667 0.160463 16.8694444 0.160463 16.8722222 0.162007 16.8750000 0.165094 16.8777778 0.171269 16.8805556 0.174357 16.8833333 0.183619 16.8861111 0.189794 16.8888889 0.195969 16.8916667 0.200600 16.8944444 0.202144 16.8972222 0.195969 16.9000000 0.192882 16.9027778 0.188250 16.9055556 0.182075 16.9083333 0.180532 16.9111111 0.175901 16.9138889 0.175901 16.9166667 0.174357 16.9194444 0.172813 16.9222222 0.169726 16.9250000 0.165094 16.9277778 0.151201 16.9305556 0.145026 16.9333333 0.140395 16.9361111 0.134220 16.9388889 0.131132 16.9416667 0.131132 16.9444444 0.129588 16.9472222 0.134220 16.9500000 0.134220 16.9527778 0.137307 16.9555556 0.134220 16.9583333 0.134220 16.9611111 0.132676 16.9638889 0.128045 16.9666667 0.123413 16.9694444 0.121870 16.9722222 0.121870 16.9750000 0.123413 16.9777778 0.121870 16.9805556 0.123413 16.9833333 0.128045 16.9861111 0.128045 16.9888889 0.128045 16.9916667 0.132676 16.9944444 0.132676 16.9972222 0.131132 17.0000000 0.129588 17.0027778 0.124957 17.0055556 0.126501 17.0083333 0.123413 17.0111111 0.118782 17.0138889 0.104889 17.0166667 0.089451 17.0194444 0.067839 17.0222222 0.055489 17.0250000 0.074014 17.0277778 0.129588 17.0305556 0.220669 17.0333333 0.345712 17.0361111 0.473842 17.0388889 0.589623 17.0416667 0.666810 17.0444444 0.674528 17.0472222 0.595798 17.0500000 0.453774 17.0527778 0.294768 17.0555556 0.165094 17.0583333 0.089451 17.0611111 0.053945 17.0638889 0.043139 17.0666667 0.040051 17.0694444 0.029245 17.0722222 0.010000 17.0750000 0.010000 17.0777778 0.010000 17.0805556 0.010000 17.0833333 0.010000 17.0861111 0.010000 17.0888889 0.010000 17.0916667 0.010000 17.0944444 0.010000 17.0972222 0.010000 17.1000000 0.010000 17.1027778 0.019983 17.1055556 0.049314 17.1083333 0.069383 17.1111111 0.087907 17.1138889 0.104889 17.1166667 0.114151 17.1194444 0.121870 17.1222222 0.126501 17.1250000 0.128045 17.1277778 0.129588 17.1305556 0.131132 17.1333333 0.131132 17.1361111 0.132676 17.1388889 0.132676 17.1416667 0.135763 17.1444444 0.138851 17.1472222 0.140395 17.1500000 0.143482 17.1527778 0.151201 17.1555556 0.151201 17.1583333 0.149657 17.1611111 0.145026 17.1638889 0.146569 17.1666667 0.141938 17.1694444 0.145026 17.1722222 0.146569 17.1750000 0.148113 17.1777778 0.148113 17.1805556 0.149657 17.1833333 0.154288 17.1861111 0.155832 17.1888889 0.157376 17.1916667 0.157376 17.1944444 0.157376 17.1972222 0.157376 17.2000000 0.155832 17.2027778 0.152744 17.2055556 0.155832 17.2083333 0.155832 17.2111111 0.160463 17.2138889 0.166638 17.2166667 0.166638 17.2194444 0.169726 17.2222222 0.172813 17.2250000 0.175901 17.2277778 0.177444 17.2305556 0.171269 17.2333333 0.174357 17.2361111 0.171269 17.2388889 0.171269 17.2416667 0.174357 17.2444444 0.180532 17.2472222 0.185163 17.2500000 0.189794 17.2527778 0.194425 17.2555556 0.195969 17.2583333 0.195969 17.2611111 0.195969 17.2638889 0.197513 17.2666667 0.200600 17.2694444 0.199057 17.2722222 0.202144 17.2750000 0.208319 17.2777778 0.211407 17.2805556 0.217581 17.2833333 0.219125 17.2861111 0.223756 17.2888889 0.229931 17.2916667 0.231475 17.2944444 0.233019 17.2972222 0.236106 17.3000000 0.237650 17.3027778 0.240738 17.3055556 0.242281 17.3083333 0.243825 17.3111111 0.246913 17.3138889 0.253087 17.3166667 0.260806 17.3194444 0.260806 17.3222222 0.268525 17.3250000 0.273156 17.3277778 0.274700 17.3305556 0.280875 17.3333333 0.282419 17.3361111 0.282419 17.3388889 0.280875 17.3416667 0.287050 17.7888889 0.145026 17.7916667 0.149657 17.7944444 0.143482 17.7972222 0.143482 17.8000000 0.143482 17.8027778 0.146569 17.8055556 0.141938 17.8083333 0.141938 17.8111111 0.146569 17.8138889 0.148113 17.8166667 0.141938 17.8194444 0.151201 17.8222222 0.152744 17.8250000 0.152744 17.8277778 0.154288 17.8305556 0.155832 17.8333333 0.154288 17.8361111 0.155832 17.8388889 0.158919 17.8416667 0.160463 17.8444444 0.165094 17.8472222 0.168182 17.8500000 0.169726 17.8527778 0.172813 17.8555556 0.180532 17.8583333 0.183619 17.8611111 0.186707 17.8638889 0.188250 17.8666667 0.192882 17.8694444 0.195969 17.8722222 0.197513 17.8750000 0.199057 17.8777778 0.202144 17.8805556 0.203688 17.8833333 0.197513 17.8861111 0.199057 17.8888889 0.195969 17.8916667 0.194425 17.8944444 0.189794 17.8972222 0.185163 17.9000000 0.185163 17.9027778 0.177444 17.9055556 0.172813 17.9083333 0.169726 17.9111111 0.166638 17.9138889 0.162007 17.9166667 0.154288 17.9194444 0.154288 17.9222222 0.152744 17.9250000 0.149657 17.9277778 0.149657 17.9305556 0.143482 17.9333333 0.143482 17.9361111 0.138851 17.9388889 0.135763 17.9416667 0.132676 17.9444444 0.137307 17.9472222 0.137307 17.9500000 0.145026 17.9527778 0.143482 17.9555556 0.138851 17.9583333 0.140395 17.9611111 0.141938 17.9638889 0.138851 17.9666667 0.138851 17.9694444 0.138851 17.9722222 0.138851 17.9750000 0.137307 17.9777778 0.140395 17.9805556 0.141938 17.9833333 0.141938 17.9861111 0.146569 17.9888889 0.145026 17.9916667 0.145026 17.9944444 0.149657 17.9972222 0.143482 18.0000000 0.141938 18.0027778 0.129588 18.0055556 0.115695 18.0083333 0.098714 18.0111111 0.078645 18.0138889 0.064751 18.0166667 0.066295 18.0194444 0.098714 18.0222222 0.157376 18.0250000 0.245369 18.0277778 0.358062 18.0305556 0.478473 18.0333333 0.584991 18.0361111 0.662178 18.0388889 0.699228 18.0416667 0.672985 18.0444444 0.575729 18.0472222 0.436792 18.0500000 0.288593 18.0527778 0.175901 18.0555556 0.109520 18.0583333 0.084820 18.0611111 0.086364 18.0638889 0.084820 18.0666667 0.075557 18.0694444 0.055489 18.0722222 0.021527 18.0750000 0.010000 18.0777778 0.010000 18.0805556 0.010000 18.0833333 0.010000 18.0861111 0.010000 18.0888889 0.010000 18.0916667 0.010000 18.0944444 0.010000 18.0972222 0.010000 18.1000000 0.010000 18.1027778 0.010000 18.1055556 0.033877 18.1083333 0.058576 18.1111111 0.081732 18.1138889 0.098714 18.1166667 0.115695 18.1194444 0.128045 18.1222222 0.131132 18.1250000 0.140395 18.1277778 0.141938 18.1305556 0.145026 18.1333333 0.140395 18.1361111 0.138851 18.1388889 0.138851 18.1416667 0.143482 18.1444444 0.148113 18.1472222 0.148113 18.1500000 0.154288 18.1527778 0.158919 18.1555556 0.163551 18.1583333 0.162007 18.1611111 0.160463 18.1638889 0.160463 18.1666667 0.160463 18.1694444 0.158919 18.1722222 0.158919 18.1750000 0.160463 18.1777778 0.162007 18.1805556 0.163551 18.1833333 0.165094 18.1861111 0.168182 18.1888889 0.168182 18.1916667 0.169726 18.1944444 0.171269 18.1972222 0.171269 18.2000000 0.166638 18.2027778 0.166638 18.2055556 0.171269 18.2083333 0.172813 18.2111111 0.174357 18.2138889 0.174357 18.2166667 0.178988 18.2194444 0.182075 18.2222222 0.178988 18.2250000 0.177444 18.2277778 0.182075 18.2305556 0.177444 18.2333333 0.180532 18.2361111 0.177444 18.2388889 0.182075 18.2416667 0.182075 18.2444444 0.185163 18.2472222 0.186707 18.2500000 0.191338 18.2527778 0.191338 18.2555556 0.194425 18.2583333 0.197513 18.2611111 0.197513 18.2638889 0.199057 18.2666667 0.206775 18.2694444 0.205232 18.2722222 0.208319 18.2750000 0.209863 18.2777778 0.211407 18.2805556 0.220669 18.2833333 0.223756 18.2861111 0.222213 18.2888889 0.229931 18.2916667 0.234563 18.2944444 0.237650 18.2972222 0.237650 18.3000000 0.242281 18.3027778 0.239194 18.3055556 0.242281 18.3083333 0.240738 18.3111111 0.248456 18.3138889 0.250000 18.3166667 0.257719 18.3194444 0.266981 18.3222222 0.271612 18.3250000 0.279331 18.3277778 0.276244 18.3305556 0.280875 18.3333333 0.280875 18.3361111 0.279331 18.7527778 0.158919 18.7555556 0.158919 18.7583333 0.163551 18.7611111 0.168182 18.7638889 0.166638 18.7666667 0.168182 18.7694444 0.165094 18.7722222 0.160463 18.7750000 0.160463 18.7777778 0.155832 18.7805556 0.160463 18.7833333 0.158919 18.7861111 0.163551 18.7888889 0.163551 18.7916667 0.168182 18.7944444 0.169726 18.7972222 0.166638 18.8000000 0.166638 18.8027778 0.168182 18.8055556 0.165094 18.8083333 0.166638 18.8111111 0.168182 18.8138889 0.174357 18.8166667 0.175901 18.8194444 0.188250 18.8222222 0.188250 18.8250000 0.195969 18.8277778 0.197513 18.8305556 0.199057 18.8333333 0.199057 18.8361111 0.200600 18.8388889 0.200600 18.8416667 0.202144 18.8444444 0.203688 18.8472222 0.209863 18.8500000 0.208319 18.8527778 0.211407 18.8555556 0.206775 18.8583333 0.203688 18.8611111 0.205232 18.8638889 0.202144 18.8666667 0.199057 18.8694444 0.191338 18.8722222 0.183619 18.8750000 0.177444 18.8777778 0.169726 18.8805556 0.168182 18.8833333 0.163551 18.8861111 0.160463 18.8888889 0.157376 18.8916667 0.151201 18.8944444 0.152744 18.8972222 0.146569 18.9000000 0.149657 18.9027778 0.148113 18.9055556 0.151201 18.9083333 0.146569 18.9111111 0.145026 18.9138889 0.151201 18.9166667 0.146569 18.9194444 0.148113 18.9222222 0.149657 18.9250000 0.151201 18.9277778 0.152744 18.9305556 0.154288 18.9333333 0.154288 18.9361111 0.151201 18.9388889 0.145026 18.9416667 0.145026 18.9444444 0.143482 18.9472222 0.143482 18.9500000 0.148113 18.9527778 0.146569 18.9555556 0.151201 18.9583333 0.152744 18.9611111 0.149657 18.9638889 0.145026 18.9666667 0.143482 18.9694444 0.132676 18.9722222 0.118782 18.9750000 0.098714 18.9777778 0.084820 18.9805556 0.074014 18.9833333 0.097170 18.9861111 0.154288 18.9888889 0.243825 18.9916667 0.364237 18.9944444 0.495455 18.9972222 0.608148 19.0000000 0.685334 19.0027778 0.697684 19.0055556 0.620497 19.0083333 0.467667 19.0111111 0.293225 19.0138889 0.146569 19.0166667 0.053945 19.0194444 0.027702 19.0222222 0.030789 19.0250000 0.044683 19.0277778 0.047770 19.0305556 0.036964 19.0333333 0.012264 19.0361111 0.010000 19.0388889 0.010000 19.0416667 0.010000 19.0444444 0.010000 19.0472222 0.010000 19.0500000 0.010000 19.0527778 0.010000 19.0555556 0.010000 19.0583333 0.010000 19.0611111 0.021527 19.0638889 0.046226 19.0666667 0.067839 19.0694444 0.094082 19.0722222 0.115695 19.0750000 0.129588 19.0777778 0.137307 19.0805556 0.141938 19.0833333 0.141938 19.0861111 0.143482 19.0888889 0.149657 19.0916667 0.155832 19.0944444 0.160463 19.0972222 0.158919 19.1000000 0.155832 19.1027778 0.154288 19.1055556 0.154288 19.1083333 0.151201 19.1111111 0.152744 19.1138889 0.162007 19.1166667 0.160463 19.1194444 0.166638 19.1222222 0.166638 19.1250000 0.162007 19.1277778 0.172813 19.1305556 0.174357 19.1333333 0.174357 19.1361111 0.174357 19.1388889 0.171269 19.1416667 0.171269 19.1444444 0.168182 19.1472222 0.171269 19.1500000 0.175901 19.1527778 0.178988 19.1555556 0.180532 19.1583333 0.180532 19.1611111 0.183619 19.1638889 0.178988 19.1666667 0.180532 19.1694444 0.180532 19.1722222 0.180532 19.1750000 0.182075 19.1777778 0.182075 19.1805556 0.183619 19.1833333 0.186707 19.1861111 0.192882 19.1888889 0.194425 19.1916667 0.199057 19.1944444 0.203688 19.1972222 0.202144 19.2000000 0.202144 19.2027778 0.202144 19.2055556 0.203688 19.2083333 0.205232 19.2111111 0.202144 19.2138889 0.211407 19.2166667 0.214494 19.2194444 0.219125 19.2222222 0.222213 19.2250000 0.220669 19.2277778 0.225300 19.2305556 0.231475 19.2333333 0.229931 19.2361111 0.233019 19.2388889 0.234563 19.2416667 0.233019 19.2444444 0.237650 19.2472222 0.242281 19.2500000 0.246913 19.2527778 0.254631 19.2555556 0.265437 19.2583333 0.268525 19.2611111 0.271612 19.2638889 0.270069 19.2666667 0.270069 19.2694444 0.273156 19.2722222 0.276244 19.2750000 0.279331 19.2777778 0.282419 19.2805556 0.287050 19.2833333 0.291681 19.2861111 0.293225 19.2888889 0.296312 19.2916667 0.299400 19.2944444 0.305575 19.2972222 0.300943 19.3000000 0.302487 19.6166667 0.148113 19.6194444 0.149657 19.6222222 0.152744 19.6250000 0.148113 19.6277778 0.152744 19.6305556 0.151201 19.6333333 0.151201 19.6361111 0.145026 19.6388889 0.143482 19.6416667 0.145026 19.6444444 0.145026 19.6472222 0.148113 19.6500000 0.146569 19.6527778 0.146569 19.6555556 0.141938 19.6583333 0.145026 19.6611111 0.141938 19.6638889 0.146569 19.6666667 0.149657 19.6694444 0.146569 19.6722222 0.151201 19.6750000 0.152744 19.6777778 0.152744 19.6805556 0.157376 19.6833333 0.163551 19.6861111 0.168182 19.6888889 0.168182 19.6916667 0.169726 19.6944444 0.174357 19.6972222 0.174357 19.7000000 0.175901 19.7027778 0.182075 19.7055556 0.186707 19.7083333 0.192882 19.7111111 0.192882 19.7138889 0.199057 19.7166667 0.197513 19.7194444 0.202144 19.7222222 0.195969 19.7250000 0.188250 19.7277778 0.182075 19.7305556 0.178988 19.7333333 0.174357 19.7361111 0.171269 19.7388889 0.165094 19.7416667 0.160463 19.7444444 0.155832 19.7472222 0.151201 19.7500000 0.148113 19.7527778 0.146569 19.7555556 0.141938 19.7583333 0.137307 19.7611111 0.137307 19.7638889 0.131132 19.7666667 0.131132 19.7694444 0.131132 19.7722222 0.129588 19.7750000 0.123413 19.7777778 0.124957 19.7805556 0.124957 19.7833333 0.124957 19.7861111 0.131132 19.7888889 0.128045 19.7916667 0.124957 19.7944444 0.129588 19.7972222 0.123413 19.8000000 0.124957 19.8027778 0.121870 19.8055556 0.123413 19.8083333 0.118782 19.8111111 0.120326 19.8138889 0.123413 19.8166667 0.124957 19.8194444 0.128045 19.8222222 0.131132 19.8250000 0.128045 19.8277778 0.126501 19.8305556 0.121870 19.8333333 0.109520 19.8361111 0.090995 19.8388889 0.066295 19.8416667 0.047770 19.8444444 0.050858 19.8472222 0.078645 19.8500000 0.145026 19.8527778 0.245369 19.8555556 0.368868 19.8583333 0.501630 19.8611111 0.611235 19.8638889 0.674528 19.8666667 0.660635 19.8694444 0.563379 19.8722222 0.413636 19.8750000 0.256175 19.8777778 0.138851 19.8805556 0.074014 19.8833333 0.046226 19.8861111 0.047770 19.8888889 0.049314 19.8916667 0.040051 19.8944444 0.016895 19.8972222 0.010000 19.9000000 0.010000 19.9027778 0.010000 19.9055556 0.010000 19.9083333 0.010000 19.9111111 0.010000 19.9138889 0.010000 19.9166667 0.010000 19.9194444 0.010000 19.9222222 0.010000 19.9250000 0.010000 19.9277778 0.027702 19.9305556 0.049314 19.9333333 0.070926 19.9361111 0.083276 19.9388889 0.094082 19.9416667 0.104889 19.9444444 0.106432 19.9472222 0.112607 19.9500000 0.117238 19.9527778 0.121870 19.9555556 0.128045 19.9583333 0.128045 19.9611111 0.132676 19.9638889 0.132676 19.9666667 0.131132 19.9694444 0.131132 19.9722222 0.131132 19.9750000 0.132676 19.9777778 0.129588 19.9805556 0.135763 19.9833333 0.140395 19.9861111 0.140395 19.9888889 0.145026 19.9916667 0.141938 19.9944444 0.143482 19.9972222 0.141938 20.0000000 0.141938 20.0027778 0.141938 20.0055556 0.141938 20.0083333 0.138851 20.0111111 0.140395 20.0138889 0.143482 20.0166667 0.143482 20.0194444 0.151201 20.0222222 0.154288 20.0250000 0.154288 20.0277778 0.157376 20.0305556 0.154288 20.0333333 0.157376 20.0361111 0.154288 20.0388889 0.152744 20.0416667 0.155832 20.0444444 0.155832 20.0472222 0.157376 20.0500000 0.160463 20.0527778 0.162007 20.0555556 0.166638 20.0583333 0.165094 20.0611111 0.163551 20.0638889 0.166638 20.0666667 0.163551 20.0694444 0.166638 20.0722222 0.168182 20.0750000 0.171269 20.0777778 0.175901 20.0805556 0.177444 20.0833333 0.183619 20.0861111 0.188250 20.0888889 0.188250 20.0916667 0.189794 20.0944444 0.191338 20.0972222 0.191338 20.1000000 0.192882 20.1027778 0.192882 20.1055556 0.189794 20.1083333 0.192882 20.1111111 0.197513 20.1138889 0.203688 20.1166667 0.206775 20.1194444 0.212950 20.1222222 0.216038 20.1250000 0.217581 20.1277778 0.222213 20.1305556 0.222213 20.1333333 0.226844 20.1361111 0.225300 20.1388889 0.228388 20.1416667 0.233019 20.1444444 0.236106 20.1472222 0.239194 20.1500000 0.245369 20.1527778 0.253087 20.1555556 0.257719 20.1583333 0.259262 20.1611111 0.262350 20.1638889 0.263894 20.5611111 0.141938 20.5638889 0.140395 20.5666667 0.135763 20.5694444 0.135763 20.5722222 0.135763 20.5750000 0.132676 20.5777778 0.134220 20.5805556 0.138851 20.5833333 0.137307 20.5861111 0.140395 20.5888889 0.143482 20.5916667 0.138851 20.5944444 0.140395 20.5972222 0.141938 20.6000000 0.141938 20.6027778 0.143482 20.6055556 0.143482 20.6083333 0.146569 20.6111111 0.151201 20.6138889 0.155832 20.6166667 0.158919 20.6194444 0.162007 20.6222222 0.168182 20.6250000 0.168182 20.6277778 0.171269 20.6305556 0.175901 20.6333333 0.177444 20.6361111 0.183619 20.6388889 0.185163 20.6416667 0.188250 20.6444444 0.195969 20.6472222 0.197513 20.6500000 0.197513 20.6527778 0.195969 20.6555556 0.194425 20.6583333 0.191338 20.6611111 0.189794 20.6638889 0.178988 20.6666667 0.177444 20.6694444 0.171269 20.6722222 0.168182 20.6750000 0.162007 20.6777778 0.160463 20.6805556 0.158919 20.6833333 0.151201 20.6861111 0.148113 20.6888889 0.140395 20.6916667 0.140395 20.6944444 0.137307 20.6972222 0.137307 20.7000000 0.137307 20.7027778 0.131132 20.7055556 0.131132 20.7083333 0.128045 20.7111111 0.126501 20.7138889 0.128045 20.7166667 0.128045 20.7194444 0.126501 20.7222222 0.131132 20.7250000 0.129588 20.7277778 0.132676 20.7305556 0.132676 20.7333333 0.129588 20.7361111 0.126501 20.7388889 0.126501 20.7416667 0.128045 20.7444444 0.128045 20.7472222 0.132676 20.7500000 0.132676 20.7527778 0.131132 20.7555556 0.132676 20.7583333 0.135763 20.7611111 0.135763 20.7638889 0.132676 20.7666667 0.132676 20.7694444 0.126501 20.7722222 0.123413 20.7750000 0.112607 20.7777778 0.097170 20.7805556 0.080189 20.7833333 0.064751 20.7861111 0.052401 20.7888889 0.060120 20.7916667 0.100257 20.7944444 0.168182 20.7972222 0.266981 20.8000000 0.376587 20.8027778 0.492367 20.8055556 0.586535 20.8083333 0.657547 20.8111111 0.683791 20.8138889 0.648285 20.8166667 0.543310 20.8194444 0.399743 20.8222222 0.253087 20.8250000 0.146569 20.8277778 0.084820 20.8305556 0.063208 20.8333333 0.066295 20.8361111 0.069383 20.8388889 0.067839 20.8416667 0.047770 20.8444444 0.016895 20.8472222 0.010000 20.8500000 0.010000 20.8527778 0.010000 20.8555556 0.010000 20.8583333 0.010000 20.8611111 0.010000 20.8638889 0.010000 20.8666667 0.010000 20.8694444 0.010000 20.8722222 0.010000 20.8750000 0.010000 20.8777778 0.027702 20.8805556 0.052401 20.8833333 0.075557 20.8861111 0.090995 20.8888889 0.106432 20.8916667 0.111063 20.8944444 0.115695 20.8972222 0.117238 20.9000000 0.120326 20.9027778 0.121870 20.9055556 0.121870 20.9083333 0.126501 20.9111111 0.129588 20.9138889 0.131132 20.9166667 0.134220 20.9194444 0.132676 20.9222222 0.138851 20.9250000 0.140395 20.9277778 0.138851 20.9305556 0.141938 20.9333333 0.143482 20.9361111 0.141938 20.9388889 0.141938 20.9416667 0.141938 20.9444444 0.143482 20.9472222 0.145026 20.9500000 0.146569 20.9527778 0.149657 20.9555556 0.154288 20.9583333 0.154288 20.9611111 0.151201 20.9638889 0.152744 20.9666667 0.146569 20.9694444 0.149657 20.9722222 0.148113 20.9750000 0.151201 20.9777778 0.154288 20.9805556 0.151201 20.9833333 0.154288 20.9861111 0.158919 20.9888889 0.163551 20.9916667 0.160463 20.9944444 0.162007 20.9972222 0.168182 21.0000000 0.166638 21.0027778 0.169726 21.0055556 0.168182 21.0083333 0.171269 21.0111111 0.172813 21.0138889 0.177444 21.0166667 0.180532 21.0194444 0.183619 21.0222222 0.192882 21.0250000 0.194425 21.0277778 0.194425 21.0305556 0.194425 21.0333333 0.191338 21.0361111 0.191338 21.0388889 0.192882 21.0416667 0.197513 21.0444444 0.199057 21.0472222 0.203688 21.0500000 0.208319 21.0527778 0.211407 21.0555556 0.214494 21.0583333 0.217581 21.0611111 0.220669 21.0638889 0.223756 21.0666667 0.229931 21.0694444 0.231475 21.0722222 0.231475 21.0750000 0.236106 21.0777778 0.239194 21.0805556 0.243825 21.0833333 0.251544 21.0861111 0.254631 21.0888889 0.262350 21.0916667 0.268525 21.0944444 0.273156 21.0972222 0.273156 21.1000000 0.274700 21.1027778 0.273156 21.1055556 0.274700 21.1083333 0.280875 21.5055556 0.140395 21.5083333 0.135763 21.5111111 0.134220 21.5138889 0.138851 21.5166667 0.141938 21.5194444 0.145026 21.5222222 0.149657 21.5250000 0.152744 21.5277778 0.149657 21.5305556 0.149657 21.5333333 0.146569 21.5361111 0.143482 21.5388889 0.141938 21.5416667 0.141938 21.5444444 0.146569 21.5472222 0.146569 21.5500000 0.148113 21.5527778 0.149657 21.5555556 0.152744 21.5583333 0.157376 21.5611111 0.160463 21.5638889 0.162007 21.5666667 0.165094 21.5694444 0.166638 21.5722222 0.166638 21.5750000 0.172813 21.5777778 0.172813 21.5805556 0.175901 21.5833333 0.177444 21.5861111 0.180532 21.5888889 0.183619 21.5916667 0.185163 21.5944444 0.192882 21.5972222 0.197513 21.6000000 0.202144 21.6027778 0.203688 21.6055556 0.205232 21.6083333 0.203688 21.6111111 0.203688 21.6138889 0.199057 21.6166667 0.197513 21.6194444 0.195969 21.6222222 0.192882 21.6250000 0.189794 21.6277778 0.183619 21.6305556 0.175901 21.6333333 0.168182 21.6361111 0.158919 21.6388889 0.151201 21.6416667 0.143482 21.6444444 0.143482 21.6472222 0.143482 21.6500000 0.145026 21.6527778 0.145026 21.6555556 0.146569 21.6583333 0.140395 21.6611111 0.138851 21.6638889 0.140395 21.6666667 0.141938 21.6694444 0.137307 21.6722222 0.135763 21.6750000 0.137307 21.6777778 0.140395 21.6805556 0.140395 21.6833333 0.138851 21.6861111 0.141938 21.6888889 0.145026 21.6916667 0.143482 21.6944444 0.143482 21.6972222 0.143482 21.7000000 0.141938 21.7027778 0.138851 21.7055556 0.138851 21.7083333 0.137307 21.7111111 0.135763 21.7138889 0.134220 21.7166667 0.138851 21.7194444 0.135763 21.7222222 0.138851 21.7250000 0.128045 21.7277778 0.111063 21.7305556 0.089451 21.7333333 0.070926 21.7361111 0.069383 21.7388889 0.103345 21.7416667 0.178988 21.7444444 0.287050 21.7472222 0.416724 21.7500000 0.546398 21.7527778 0.649828 21.7555556 0.691509 21.7583333 0.649828 21.7611111 0.524786 21.7638889 0.350343 21.7666667 0.188250 21.7694444 0.083276 21.7722222 0.035420 21.7750000 0.021527 21.7777778 0.032333 21.7805556 0.041595 21.7833333 0.036964 21.7861111 0.016895 21.7888889 0.010000 21.7916667 0.010000 21.7944444 0.010000 21.7972222 0.010000 21.8000000 0.010000 21.8027778 0.010000 21.8055556 0.010000 21.8083333 0.010000 21.8111111 0.010000 21.8138889 0.010720 21.8166667 0.040051 21.8194444 0.064751 21.8222222 0.090995 21.8250000 0.107976 21.8277778 0.121870 21.8305556 0.132676 21.8333333 0.135763 21.8361111 0.137307 21.8388889 0.134220 21.8416667 0.137307 21.8444444 0.138851 21.8472222 0.145026 21.8500000 0.152744 21.8527778 0.157376 21.8555556 0.162007 21.8583333 0.162007 21.8611111 0.162007 21.8638889 0.157376 21.8666667 0.155832 21.8694444 0.152744 21.8722222 0.154288 21.8750000 0.157376 21.8777778 0.162007 21.8805556 0.165094 21.8833333 0.168182 21.8861111 0.169726 21.8888889 0.174357 21.8916667 0.175901 21.8944444 0.175901 21.8972222 0.172813 21.9000000 0.168182 21.9027778 0.172813 21.9055556 0.163551 21.9083333 0.171269 21.9111111 0.175901 21.9138889 0.178988 21.9166667 0.178988 21.9194444 0.186707 21.9222222 0.188250 21.9250000 0.185163 21.9277778 0.183619 21.9305556 0.185163 21.9333333 0.183619 21.9361111 0.183619 21.9388889 0.183619 21.9416667 0.185163 21.9444444 0.188250 21.9472222 0.194425 21.9500000 0.199057 21.9527778 0.200600 21.9555556 0.208319 21.9583333 0.212950 21.9611111 0.211407 21.9638889 0.214494 21.9666667 0.211407 21.9694444 0.211407 21.9722222 0.212950 21.9750000 0.216038 21.9777778 0.216038 21.9805556 0.217581 21.9833333 0.220669 21.9861111 0.222213 21.9888889 0.229931 21.9916667 0.237650 21.9944444 0.242281 21.9972222 0.246913 22.0000000 0.251544 22.0027778 0.251544 22.0055556 0.251544 22.0083333 0.251544 22.0111111 0.251544 22.0138889 0.257719 22.0166667 0.260806 22.0194444 0.270069 22.0222222 0.273156 22.0250000 0.276244 22.0277778 0.277787 22.0305556 0.276244 22.0333333 0.280875 22.0361111 0.280875 22.0388889 0.282419 22.0416667 0.288593 22.0444444 0.290137 22.0472222 0.293225 22.0500000 0.297856 22.0527778 0.300943 22.3916667 0.166638 22.3944444 0.163551 22.3972222 0.158919 22.4000000 0.160463 22.4027778 0.160463 22.4055556 0.157376 22.4083333 0.154288 22.4111111 0.151201 22.4138889 0.154288 22.4166667 0.157376 22.4194444 0.162007 22.4222222 0.163551 22.4250000 0.160463 22.4277778 0.157376 22.4305556 0.158919 22.4333333 0.157376 22.4361111 0.158919 22.4388889 0.157376 22.4416667 0.160463 22.4444444 0.160463 22.4472222 0.165094 22.4500000 0.168182 22.4527778 0.178988 22.4555556 0.182075 22.4583333 0.183619 22.4611111 0.180532 22.4638889 0.185163 22.4666667 0.183619 22.4694444 0.186707 22.4722222 0.189794 22.4750000 0.195969 22.4777778 0.202144 22.4805556 0.208319 22.4833333 0.216038 22.4861111 0.217581 22.4888889 0.217581 22.4916667 0.216038 22.4944444 0.211407 22.4972222 0.208319 22.5000000 0.202144 22.5027778 0.197513 22.5055556 0.194425 22.5083333 0.189794 22.5111111 0.183619 22.5138889 0.182075 22.5166667 0.178988 22.5194444 0.172813 22.5222222 0.172813 22.5250000 0.165094 22.5277778 0.162007 22.5305556 0.158919 22.5333333 0.152744 22.5361111 0.149657 22.5388889 0.148113 22.5416667 0.146569 22.5444444 0.146569 22.5472222 0.149657 22.5500000 0.146569 22.5527778 0.146569 22.5555556 0.145026 22.5583333 0.148113 22.5611111 0.143482 22.5638889 0.146569 22.5666667 0.141938 22.5694444 0.140395 22.5722222 0.138851 22.5750000 0.138851 22.5777778 0.138851 22.5805556 0.140395 22.5833333 0.140395 22.5861111 0.141938 22.5888889 0.146569 22.5916667 0.149657 22.5944444 0.151201 22.5972222 0.151201 22.6000000 0.148113 22.6027778 0.145026 22.6055556 0.140395 22.6083333 0.129588 22.6111111 0.114151 22.6138889 0.097170 22.6166667 0.075557 22.6194444 0.070926 22.6222222 0.097170 22.6250000 0.157376 22.6277778 0.251544 22.6305556 0.378130 22.6333333 0.503173 22.6361111 0.618954 22.6388889 0.685334 22.6416667 0.682247 22.6444444 0.603516 22.6472222 0.458405 22.6500000 0.305575 22.6527778 0.177444 22.6555556 0.104889 22.6583333 0.072470 22.6611111 0.066295 22.6638889 0.064751 22.6666667 0.055489 22.6694444 0.032333 22.6722222 0.010000 22.6750000 0.010000 22.6777778 0.010000 22.6805556 0.010000 22.6833333 0.010000 22.6861111 0.010000 22.6888889 0.010000 22.6916667 0.010000 22.6944444 0.010000 22.6972222 0.024614 22.7000000 0.052401 22.7027778 0.078645 22.7055556 0.098714 22.7083333 0.111063 22.7111111 0.121870 22.7138889 0.132676 22.7166667 0.141938 22.7194444 0.141938 22.7222222 0.148113 22.7250000 0.151201 22.7277778 0.152744 22.7305556 0.154288 22.7333333 0.154288 22.7361111 0.154288 22.7388889 0.155832 22.7416667 0.157376 22.7444444 0.157376 22.7472222 0.157376 22.7500000 0.162007 22.7527778 0.162007 22.7555556 0.162007 22.7583333 0.163551 22.7611111 0.162007 22.7638889 0.165094 22.7666667 0.165094 22.7694444 0.163551 22.7722222 0.160463 22.7750000 0.163551 22.7777778 0.168182 22.7805556 0.168182 22.7833333 0.171269 22.7861111 0.175901 22.7888889 0.178988 22.7916667 0.177444 22.7944444 0.180532 22.7972222 0.180532 22.8000000 0.178988 22.8027778 0.178988 22.8055556 0.182075 22.8083333 0.178988 22.8111111 0.183619 22.8138889 0.182075 22.8166667 0.185163 22.8194444 0.186707 22.8222222 0.191338 22.8250000 0.191338 22.8277778 0.197513 22.8305556 0.197513 22.8333333 0.195969 22.8361111 0.199057 22.8388889 0.197513 22.8416667 0.194425 22.8444444 0.197513 22.8472222 0.203688 22.8500000 0.209863 22.8527778 0.212950 22.8555556 0.217581 22.8583333 0.219125 22.8611111 0.220669 22.8638889 0.223756 22.8666667 0.226844 22.8694444 0.225300 22.8722222 0.226844 22.8750000 0.228388 22.8777778 0.233019 22.8805556 0.236106 22.8833333 0.240738 22.8861111 0.240738 22.8888889 0.246913 22.8916667 0.251544 22.8944444 0.254631 22.8972222 0.257719 22.9000000 0.260806 22.9027778 0.265437 22.9055556 0.268525 22.9083333 0.271612 22.9111111 0.279331 22.9138889 0.280875 22.9166667 0.288593 22.9194444 0.294768 22.9222222 0.299400 22.9250000 0.299400 22.9277778 0.302487 22.9305556 0.310206 22.9333333 0.313293 22.9361111 0.313293 22.9388889 0.311750 23.3916667 0.171269 23.3944444 0.168182 23.3972222 0.171269 23.4000000 0.168182 23.4027778 0.168182 23.4055556 0.163551 23.4083333 0.160463 23.4111111 0.162007 23.4138889 0.162007 23.4166667 0.165094 23.4194444 0.169726 23.4222222 0.174357 23.4250000 0.177444 23.4277778 0.177444 23.4305556 0.178988 23.4333333 0.182075 23.4361111 0.182075 23.4388889 0.185163 23.4416667 0.182075 23.4444444 0.186707 23.4472222 0.191338 23.4500000 0.194425 23.4527778 0.195969 23.4555556 0.199057 23.4583333 0.203688 23.4611111 0.206775 23.4638889 0.214494 23.4666667 0.216038 23.4694444 0.217581 23.4722222 0.222213 23.4750000 0.222213 23.4777778 0.222213 23.4805556 0.220669 23.4833333 0.220669 23.4861111 0.219125 23.4888889 0.220669 23.4916667 0.212950 23.4944444 0.211407 23.4972222 0.209863 23.5000000 0.202144 23.5027778 0.195969 23.5055556 0.191338 23.5083333 0.185163 23.5111111 0.180532 23.5138889 0.177444 23.5166667 0.172813 23.5194444 0.169726 23.5222222 0.169726 23.5250000 0.168182 23.5277778 0.166638 23.5305556 0.166638 23.5333333 0.162007 23.5361111 0.160463 23.5388889 0.160463 23.5416667 0.162007 23.5444444 0.160463 23.5472222 0.162007 23.5500000 0.163551 23.5527778 0.166638 23.5555556 0.165094 23.5583333 0.165094 23.5611111 0.165094 23.5638889 0.163551 23.5666667 0.163551 23.5694444 0.162007 23.5722222 0.157376 23.5750000 0.162007 23.5777778 0.162007 23.5805556 0.157376 23.5833333 0.163551 23.5861111 0.165094 23.5888889 0.165094 23.5916667 0.169726 23.5944444 0.169726 23.5972222 0.166638 23.6000000 0.162007 23.6027778 0.154288 23.6055556 0.138851 23.6083333 0.120326 23.6111111 0.103345 23.6138889 0.084820 23.6166667 0.081732 23.6194444 0.100257 23.6222222 0.148113 23.6250000 0.223756 23.6277778 0.325643 23.6305556 0.439880 23.6333333 0.552573 23.6361111 0.645197 23.6388889 0.696141 23.6416667 0.703859 23.6444444 0.640566 23.6472222 0.520154 23.6500000 0.373499 23.6527778 0.242281 23.6555556 0.155832 23.6583333 0.111063 23.6611111 0.104889 23.6638889 0.106432 23.6666667 0.107976 23.6694444 0.094082 23.6722222 0.066295 23.6750000 0.029245 23.6777778 0.010000 23.6805556 0.010000 23.6833333 0.010000 23.6861111 0.010000 23.6888889 0.010000 23.6916667 0.010000 23.6944444 0.010000 23.6972222 0.010000 23.7000000 0.010000 23.7027778 0.027702 23.7055556 0.049314 23.7083333 0.074014 23.7111111 0.095626 23.7138889 0.114151 23.7166667 0.128045 23.7194444 0.138851 23.7222222 0.149657 23.7250000 0.154288 23.7277778 0.157376 23.7305556 0.158919 23.7333333 0.158919 23.7361111 0.162007 23.7388889 0.160463 23.7416667 0.162007 23.7444444 0.163551 23.7472222 0.171269 23.7500000 0.172813 23.7527778 0.174357 23.7555556 0.178988 23.7583333 0.180532 23.7611111 0.180532 23.7638889 0.180532 23.7666667 0.182075 23.7694444 0.180532 23.7722222 0.180532 23.7750000 0.182075 23.7777778 0.178988 23.7805556 0.180532 23.7833333 0.185163 23.7861111 0.185163 23.7888889 0.188250 23.7916667 0.189794 23.7944444 0.188250 23.7972222 0.191338 23.8000000 0.188250 23.8027778 0.186707 23.8055556 0.188250 23.8083333 0.188250 23.8111111 0.188250 23.8138889 0.189794 23.8166667 0.194425 23.8194444 0.200600 23.8222222 0.203688 23.8250000 0.203688 23.8277778 0.202144 23.8305556 0.205232 23.8333333 0.203688 23.8361111 0.203688 23.8388889 0.206775 23.8416667 0.206775 23.8444444 0.206775 23.8472222 0.209863 23.8500000 0.211407 23.8527778 0.216038 23.8555556 0.219125 23.8583333 0.220669 23.8611111 0.220669 23.8638889 0.231475 23.8666667 0.226844 23.8694444 0.229931 23.8722222 0.226844 23.8750000 0.229931 23.8777778 0.229931 23.8805556 0.234563 23.8833333 0.239194 23.8861111 0.246913 23.8888889 0.250000 23.8916667 0.253087 23.8944444 0.257719 23.8972222 0.259262 23.9000000 0.262350 23.9027778 0.262350 23.9055556 0.262350 23.9083333 0.263894 23.9111111 0.270069 23.9138889 0.271612 23.9166667 0.277787 23.9194444 0.285506 23.9222222 0.290137 23.9250000 0.293225 23.9277778 0.293225 23.9305556 0.300943 23.9333333 0.305575 23.9361111 0.305575 23.9388889 0.308662 24.3805556 0.177444 24.3833333 0.178988 24.3861111 0.178988 24.3888889 0.177444 24.3916667 0.178988 24.3944444 0.174357 24.3972222 0.172813 24.4000000 0.169726 24.4027778 0.168182 24.4055556 0.168182 24.4083333 0.169726 24.4111111 0.171269 24.4138889 0.175901 24.4166667 0.180532 24.4194444 0.180532 24.4222222 0.186707 24.4250000 0.189794 24.4277778 0.189794 24.4305556 0.192882 24.4333333 0.192882 24.4361111 0.191338 24.4388889 0.188250 24.4416667 0.189794 24.4444444 0.191338 24.4472222 0.192882 24.4500000 0.195969 24.4527778 0.200600 24.4555556 0.209863 24.4583333 0.212950 24.4611111 0.214494 24.4638889 0.217581 24.4666667 0.220669 24.4694444 0.226844 24.4722222 0.226844 24.4750000 0.231475 24.4777778 0.226844 24.4805556 0.231475 24.4833333 0.229931 24.4861111 0.226844 24.4888889 0.223756 24.4916667 0.217581 24.4944444 0.208319 24.4972222 0.202144 24.5000000 0.199057 24.5027778 0.200600 24.5055556 0.195969 24.5083333 0.189794 24.5111111 0.189794 24.5138889 0.183619 24.5166667 0.177444 24.5194444 0.169726 24.5222222 0.166638 24.5250000 0.163551 24.5277778 0.165094 24.5305556 0.163551 24.5333333 0.163551 24.5361111 0.163551 24.5388889 0.166638 24.5416667 0.163551 24.5444444 0.163551 24.5472222 0.166638 24.5500000 0.165094 24.5527778 0.168182 24.5555556 0.168182 24.5583333 0.165094 24.5611111 0.160463 24.5638889 0.158919 24.5666667 0.163551 24.5694444 0.162007 24.5722222 0.162007 24.5750000 0.157376 24.5777778 0.160463 24.5805556 0.160463 24.5833333 0.162007 24.5861111 0.168182 24.5888889 0.171269 24.5916667 0.169726 24.5944444 0.168182 24.5972222 0.158919 24.6000000 0.145026 24.6027778 0.124957 24.6055556 0.104889 24.6083333 0.090995 24.6111111 0.097170 24.6138889 0.137307 24.6166667 0.212950 24.6194444 0.321012 24.6222222 0.449142 24.6250000 0.574185 24.6277778 0.674528 24.6305556 0.720840 24.6333333 0.683791 24.6361111 0.566467 24.6388889 0.396655 24.6416667 0.234563 24.6444444 0.115695 24.6472222 0.060120 24.6500000 0.046226 24.6527778 0.055489 24.6555556 0.066295 24.6583333 0.066295 24.6611111 0.044683 24.6638889 0.016895 24.6666667 0.010000 24.6694444 0.010000 24.6722222 0.010000 24.6750000 0.010000 24.6777778 0.010000 24.6805556 0.010000 24.6833333 0.010000 24.6861111 0.010000 24.6888889 0.027702 24.6916667 0.055489 24.6944444 0.089451 24.6972222 0.114151 24.7000000 0.131132 24.7027778 0.141938 24.7055556 0.151201 24.7083333 0.157376 24.7111111 0.162007 24.7138889 0.169726 24.7166667 0.168182 24.7194444 0.169726 24.7222222 0.174357 24.7250000 0.174357 24.7277778 0.178988 24.7305556 0.182075 24.7333333 0.188250 24.7361111 0.188250 24.7388889 0.192882 24.7416667 0.188250 24.7444444 0.188250 24.7472222 0.185163 24.7500000 0.191338 24.7527778 0.192882 24.7555556 0.197513 24.7583333 0.200600 24.7611111 0.200600 24.7638889 0.200600 24.7666667 0.200600 24.7694444 0.197513 24.7722222 0.194425 24.7750000 0.191338 24.7777778 0.194425 24.7805556 0.191338 24.7833333 0.199057 24.7861111 0.205232 24.7888889 0.212950 24.7916667 0.212950 24.7944444 0.212950 24.7972222 0.214494 24.8000000 0.214494 24.8027778 0.211407 24.8055556 0.211407 24.8083333 0.212950 24.8111111 0.214494 24.8138889 0.219125 24.8166667 0.222213 24.8194444 0.225300 24.8222222 0.231475 24.8250000 0.228388 24.8277778 0.228388 24.8305556 0.226844 24.8333333 0.229931 24.8361111 0.233019 24.8388889 0.239194 24.8416667 0.243825 24.8444444 0.242281 24.8472222 0.248456 24.8500000 0.245369 24.8527778 0.243825 24.8555556 0.251544 24.8583333 0.251544 24.8611111 0.253087 24.8638889 0.254631 24.8666667 0.256175 24.8694444 0.254631 24.8722222 0.256175 24.8750000 0.262350 24.8777778 0.271612 24.8805556 0.277787 24.8833333 0.287050 24.8861111 0.296312 24.8888889 0.294768 24.8916667 0.293225 24.8944444 0.291681 24.8972222 0.290137 24.9000000 0.291681 24.9027778 0.294768 24.9055556 0.296312 24.9083333 0.297856 24.9111111 0.305575 24.9138889 0.313293 24.9166667 0.313293 24.9194444 0.314837 24.9222222 0.321012 24.9250000 0.325643 24.9277778 0.322556 25.2944444 0.180532 25.2972222 0.180532 25.3000000 0.180532 25.3027778 0.180532 25.3055556 0.178988 25.3083333 0.175901 25.3111111 0.177444 25.3138889 0.172813 25.3166667 0.174357 25.3194444 0.175901 25.3222222 0.177444 25.3250000 0.175901 25.3277778 0.172813 25.3305556 0.175901 25.3333333 0.178988 25.3361111 0.175901 25.3388889 0.174357 25.3416667 0.174357 25.3444444 0.177444 25.3472222 0.177444 25.3500000 0.180532 25.3527778 0.188250 25.3555556 0.197513 25.3583333 0.199057 25.3611111 0.202144 25.3638889 0.200600 25.3666667 0.203688 25.3694444 0.206775 25.3722222 0.206775 25.3750000 0.212950 25.3777778 0.216038 25.3805556 0.222213 25.3833333 0.223756 25.3861111 0.226844 25.3888889 0.223756 25.3916667 0.219125 25.3944444 0.220669 25.3972222 0.219125 25.4000000 0.209863 25.4027778 0.203688 25.4055556 0.200600 25.4083333 0.194425 25.4111111 0.191338 25.4138889 0.185163 25.4166667 0.180532 25.4194444 0.177444 25.4222222 0.174357 25.4250000 0.169726 25.4277778 0.168182 25.4305556 0.165094 25.4333333 0.162007 25.4361111 0.163551 25.4388889 0.157376 25.4416667 0.157376 25.4444444 0.155832 25.4472222 0.155832 25.4500000 0.157376 25.4527778 0.157376 25.4555556 0.162007 25.4583333 0.158919 25.4611111 0.158919 25.4638889 0.157376 25.4666667 0.154288 25.4694444 0.157376 25.4722222 0.155832 25.4750000 0.149657 25.4777778 0.149657 25.4805556 0.146569 25.4833333 0.146569 25.4861111 0.152744 25.4888889 0.152744 25.4916667 0.152744 25.4944444 0.155832 25.4972222 0.158919 25.5000000 0.157376 25.5027778 0.155832 25.5055556 0.151201 25.5083333 0.141938 25.5111111 0.131132 25.5138889 0.114151 25.5166667 0.094082 25.5194444 0.077101 25.5222222 0.075557 25.5250000 0.103345 25.5277778 0.162007 25.5305556 0.253087 25.5333333 0.368868 25.5361111 0.492367 25.5388889 0.603516 25.5416667 0.688422 25.5444444 0.708491 25.5472222 0.652916 25.5500000 0.529417 25.5527778 0.373499 25.5555556 0.234563 25.5583333 0.138851 25.5611111 0.092539 25.5638889 0.081732 25.5666667 0.078645 25.5694444 0.080189 25.5722222 0.063208 25.5750000 0.033877 25.5777778 0.010000 25.5805556 0.010000 25.5833333 0.010000 25.5861111 0.010000 25.5888889 0.010000 25.5916667 0.010000 25.5944444 0.010000 25.5972222 0.010000 25.6000000 0.010000 25.6027778 0.010000 25.6055556 0.010720 25.6083333 0.035420 25.6111111 0.061664 25.6138889 0.083276 25.6166667 0.109520 25.6194444 0.121870 25.6222222 0.132676 25.6250000 0.143482 25.6277778 0.149657 25.6305556 0.151201 25.6333333 0.152744 25.6361111 0.151201 25.6388889 0.154288 25.6416667 0.154288 25.6444444 0.158919 25.6472222 0.162007 25.6500000 0.163551 25.6527778 0.168182 25.6555556 0.169726 25.6583333 0.171269 25.6611111 0.174357 25.6638889 0.172813 25.6666667 0.174357 25.6694444 0.175901 25.6722222 0.175901 25.6750000 0.171269 25.6777778 0.172813 25.6805556 0.174357 25.6833333 0.177444 25.6861111 0.178988 25.6888889 0.180532 25.6916667 0.183619 25.6944444 0.182075 25.6972222 0.189794 25.7000000 0.185163 25.7027778 0.183619 25.7055556 0.182075 25.7083333 0.182075 25.7111111 0.185163 25.7138889 0.180532 25.7166667 0.186707 25.7194444 0.189794 25.7222222 0.194425 25.7250000 0.195969 25.7277778 0.194425 25.7305556 0.199057 25.7333333 0.195969 25.7361111 0.195969 25.7388889 0.199057 25.7416667 0.199057 25.7444444 0.199057 25.7472222 0.200600 25.7500000 0.203688 25.7527778 0.203688 25.7555556 0.206775 25.7583333 0.214494 25.7611111 0.214494 25.7638889 0.216038 25.7666667 0.217581 25.7694444 0.219125 25.7722222 0.217581 25.7750000 0.220669 25.7777778 0.220669 25.7805556 0.222213 25.7833333 0.225300 25.7861111 0.229931 25.7888889 0.231475 25.7916667 0.234563 25.7944444 0.242281 25.7972222 0.242281 25.8000000 0.243825 25.8027778 0.240738 25.8055556 0.246913 25.8083333 0.248456 25.8111111 0.251544 25.8138889 0.254631 25.8166667 0.262350 25.8194444 0.265437 25.8222222 0.273156 25.8250000 0.277787 25.8277778 0.279331 25.8305556 0.283962 25.8333333 0.287050 25.8361111 0.290137 25.8388889 0.290137 25.8416667 0.291681 26.2833333 0.155832 26.2861111 0.157376 26.2888889 0.160463 26.2916667 0.163551 26.2944444 0.162007 26.2972222 0.160463 26.3000000 0.160463 26.3027778 0.158919 26.3055556 0.158919 26.3083333 0.155832 26.3111111 0.154288 26.3138889 0.158919 26.3166667 0.157376 26.3194444 0.165094 26.3222222 0.169726 26.3250000 0.174357 26.3277778 0.175901 26.3305556 0.178988 26.3333333 0.182075 26.3361111 0.180532 26.3388889 0.178988 26.3416667 0.180532 26.3444444 0.182075 26.3472222 0.185163 26.3500000 0.188250 26.3527778 0.195969 26.3555556 0.199057 26.3583333 0.203688 26.3611111 0.209863 26.3638889 0.216038 26.3666667 0.216038 26.3694444 0.217581 26.3722222 0.211407 26.3750000 0.211407 26.3777778 0.206775 26.3805556 0.203688 26.3833333 0.200600 26.3861111 0.199057 26.3888889 0.200600 26.3916667 0.199057 26.3944444 0.195969 26.3972222 0.191338 26.4000000 0.182075 26.4027778 0.172813 26.4055556 0.168182 26.4083333 0.163551 26.4111111 0.157376 26.4138889 0.155832 26.4166667 0.154288 26.4194444 0.152744 26.4222222 0.149657 26.4250000 0.152744 26.4277778 0.152744 26.4305556 0.154288 26.4333333 0.151201 26.4361111 0.145026 26.4388889 0.149657 26.4416667 0.146569 26.4444444 0.148113 26.4472222 0.143482 26.4500000 0.141938 26.4527778 0.146569 26.4555556 0.152744 26.4583333 0.154288 26.4611111 0.152744 26.4638889 0.151201 26.4666667 0.148113 26.4694444 0.146569 26.4722222 0.145026 26.4750000 0.148113 26.4777778 0.146569 26.4805556 0.141938 26.4833333 0.148113 26.4861111 0.148113 26.4888889 0.149657 26.4916667 0.149657 26.4944444 0.145026 26.4972222 0.137307 26.5000000 0.123413 26.5027778 0.103345 26.5055556 0.080189 26.5083333 0.063208 26.5111111 0.063208 26.5138889 0.094082 26.5166667 0.163551 26.5194444 0.257719 26.5222222 0.376587 26.5250000 0.501630 26.5277778 0.612779 26.5305556 0.694597 26.5333333 0.720840 26.5361111 0.677616 26.5388889 0.560292 26.5416667 0.404374 26.5444444 0.257719 26.5472222 0.143482 26.5500000 0.089451 26.5527778 0.070926 26.5555556 0.069383 26.5583333 0.074014 26.5611111 0.061664 26.5638889 0.035420 26.5666667 0.010000 26.5694444 0.010000 26.5722222 0.010000 26.5750000 0.010000 26.5777778 0.010000 26.5805556 0.010000 26.5833333 0.010000 26.5861111 0.010000 26.5888889 0.010000 26.5916667 0.010000 26.5944444 0.026158 26.5972222 0.053945 26.6000000 0.078645 26.6027778 0.098714 26.6055556 0.114151 26.6083333 0.126501 26.6111111 0.132676 26.6138889 0.135763 26.6166667 0.138851 26.6194444 0.143482 26.6222222 0.151201 26.6250000 0.155832 26.6277778 0.157376 26.6305556 0.160463 26.6333333 0.157376 26.6361111 0.160463 26.6388889 0.158919 26.6416667 0.158919 26.6444444 0.154288 26.6472222 0.158919 26.6500000 0.163551 26.6527778 0.166638 26.6555556 0.168182 26.6583333 0.168182 26.6611111 0.171269 26.6638889 0.169726 26.6666667 0.168182 26.6694444 0.171269 26.6722222 0.168182 26.6750000 0.168182 26.6777778 0.172813 26.6805556 0.172813 26.6833333 0.178988 26.6861111 0.185163 26.6888889 0.183619 26.6916667 0.186707 26.6944444 0.186707 26.6972222 0.186707 26.7000000 0.185163 26.7027778 0.186707 26.7055556 0.188250 26.7083333 0.188250 26.7111111 0.189794 26.7138889 0.189794 26.7166667 0.194425 26.7194444 0.197513 26.7222222 0.203688 26.7250000 0.205232 26.7277778 0.205232 26.7305556 0.205232 26.7333333 0.205232 26.7361111 0.205232 26.7388889 0.206775 26.7416667 0.205232 26.7444444 0.211407 26.7472222 0.214494 26.7500000 0.219125 26.7527778 0.223756 26.7555556 0.228388 26.7583333 0.231475 26.7611111 0.236106 26.7638889 0.237650 26.7666667 0.240738 26.7694444 0.239194 26.7722222 0.242281 26.7750000 0.243825 26.7777778 0.248456 26.7805556 0.250000 26.7833333 0.253087 26.7861111 0.257719 26.7888889 0.262350 26.7916667 0.270069 26.7944444 0.273156 26.7972222 0.282419 26.8000000 0.280875 26.8027778 0.283962 26.8055556 0.287050 26.8083333 0.285506 26.8111111 0.294768 26.8138889 0.299400 26.8166667 0.302487 26.8194444 0.307118 26.8222222 0.311750 26.8250000 0.317925 26.8277778 0.325643 26.8305556 0.327187 27.2694444 0.157376 27.2722222 0.160463 27.2750000 0.157376 27.2777778 0.160463 27.2805556 0.163551 27.2833333 0.163551 27.2861111 0.163551 27.2888889 0.165094 27.2916667 0.165094 27.2944444 0.168182 27.2972222 0.169726 27.3000000 0.171269 27.3027778 0.172813 27.3055556 0.166638 27.3083333 0.163551 27.3111111 0.160463 27.3138889 0.160463 27.3166667 0.162007 27.3194444 0.165094 27.3222222 0.169726 27.3250000 0.174357 27.3277778 0.174357 27.3305556 0.180532 27.3333333 0.180532 27.3361111 0.188250 27.3388889 0.186707 27.3416667 0.185163 27.3444444 0.185163 27.3472222 0.189794 27.3500000 0.195969 27.3527778 0.199057 27.3555556 0.206775 27.3583333 0.214494 27.3611111 0.217581 27.3638889 0.225300 27.3666667 0.223756 27.3694444 0.222213 27.3722222 0.216038 27.3750000 0.208319 27.3777778 0.208319 27.3805556 0.206775 27.3833333 0.206775 27.3861111 0.205232 27.3888889 0.203688 27.3916667 0.197513 27.3944444 0.192882 27.3972222 0.186707 27.4000000 0.180532 27.4027778 0.171269 27.4055556 0.165094 27.4083333 0.158919 27.4111111 0.154288 27.4138889 0.149657 27.4166667 0.151201 27.4194444 0.152744 27.4222222 0.158919 27.4250000 0.165094 27.4277778 0.162007 27.4305556 0.160463 27.4333333 0.157376 27.4361111 0.152744 27.4388889 0.151201 27.4416667 0.146569 27.4444444 0.151201 27.4472222 0.154288 27.4500000 0.155832 27.4527778 0.157376 27.4555556 0.157376 27.4583333 0.157376 27.4611111 0.155832 27.4638889 0.155832 27.4666667 0.152744 27.4694444 0.154288 27.4722222 0.154288 27.4750000 0.154288 27.4777778 0.158919 27.4805556 0.155832 27.4833333 0.151201 27.4861111 0.141938 27.4888889 0.129588 27.4916667 0.107976 27.4944444 0.092539 27.4972222 0.089451 27.5000000 0.115695 27.5027778 0.180532 27.5055556 0.274700 27.5083333 0.393568 27.5111111 0.520154 27.5138889 0.634391 27.5166667 0.700772 27.5194444 0.696141 27.5222222 0.612779 27.5250000 0.464580 27.5277778 0.299400 27.5305556 0.158919 27.5333333 0.077101 27.5361111 0.043139 27.5388889 0.044683 27.5416667 0.055489 27.5444444 0.063208 27.5472222 0.049314 27.5500000 0.027702 27.5527778 0.010000 27.5555556 0.010000 27.5583333 0.010000 27.5611111 0.010000 27.5638889 0.010000 27.5666667 0.010000 27.5694444 0.010000 27.5722222 0.010000 27.5750000 0.010000 27.5777778 0.010000 27.5805556 0.023070 27.5833333 0.053945 27.5861111 0.081732 27.5888889 0.104889 27.5916667 0.131132 27.5944444 0.143482 27.5972222 0.151201 27.6000000 0.151201 27.6027778 0.154288 27.6055556 0.149657 27.6083333 0.151201 27.6111111 0.155832 27.6138889 0.160463 27.6166667 0.165094 27.6194444 0.169726 27.6222222 0.171269 27.6250000 0.169726 27.6277778 0.169726 27.6305556 0.168182 27.6333333 0.169726 27.6361111 0.168182 27.6388889 0.172813 27.6416667 0.172813 27.6444444 0.177444 27.6472222 0.178988 27.6500000 0.174357 27.6527778 0.174357 27.6555556 0.180532 27.6583333 0.185163 27.6611111 0.183619 27.6638889 0.183619 27.6666667 0.183619 27.6694444 0.183619 27.6722222 0.180532 27.6750000 0.182075 27.6777778 0.185163 27.6805556 0.188250 27.6833333 0.192882 27.6861111 0.194425 27.6888889 0.195969 27.6916667 0.197513 27.6944444 0.199057 27.6972222 0.197513 27.7000000 0.200600 27.7027778 0.203688 27.7055556 0.202144 27.7083333 0.199057 27.7111111 0.202144 27.7138889 0.200600 27.7166667 0.203688 27.7194444 0.208319 27.7222222 0.211407 27.7250000 0.214494 27.7277778 0.212950 27.7305556 0.216038 27.7333333 0.217581 27.7361111 0.216038 27.7388889 0.217581 27.7416667 0.222213 27.7444444 0.219125 27.7472222 0.222213 27.7500000 0.231475 27.7527778 0.234563 27.7555556 0.240738 27.7583333 0.248456 27.7611111 0.250000 27.7638889 0.250000 27.7666667 0.246913 27.7694444 0.246913 27.7722222 0.243825 27.7750000 0.243825 27.7777778 0.250000 27.7805556 0.253087 27.7833333 0.254631 27.7861111 0.259262 27.7888889 0.263894 27.7916667 0.265437 27.7944444 0.268525 27.7972222 0.273156 27.8000000 0.282419 27.8027778 0.287050 27.8055556 0.287050 27.8083333 0.288593 27.8111111 0.293225 27.8138889 0.297856 27.8166667 0.299400 28.1888889 0.162007 28.1916667 0.166638 28.1944444 0.165094 28.1972222 0.166638 28.2000000 0.165094 28.2027778 0.162007 28.2055556 0.162007 28.2083333 0.158919 28.2111111 0.158919 28.2138889 0.157376 28.2166667 0.160463 28.2194444 0.163551 28.2222222 0.162007 28.2250000 0.165094 28.2277778 0.163551 28.2305556 0.166638 28.2333333 0.165094 28.2361111 0.163551 28.2388889 0.163551 28.2416667 0.162007 28.2444444 0.163551 28.2472222 0.165094 28.2500000 0.169726 28.2527778 0.172813 28.2555556 0.177444 28.2583333 0.182075 28.2611111 0.186707 28.2638889 0.188250 28.2666667 0.186707 28.2694444 0.183619 28.2722222 0.188250 28.2750000 0.188250 28.2777778 0.197513 28.2805556 0.200600 28.2833333 0.206775 28.2861111 0.212950 28.2888889 0.214494 28.2916667 0.219125 28.2944444 0.214494 28.2972222 0.209863 28.3000000 0.206775 28.3027778 0.200600 28.3055556 0.194425 28.3083333 0.189794 28.3111111 0.182075 28.3138889 0.177444 28.3166667 0.172813 28.3194444 0.166638 28.3222222 0.162007 28.3250000 0.162007 28.3277778 0.154288 28.3305556 0.154288 28.3333333 0.148113 28.3361111 0.146569 28.3388889 0.141938 28.3416667 0.140395 28.3444444 0.140395 28.3472222 0.138851 28.3500000 0.138851 28.3527778 0.141938 28.3555556 0.143482 28.3583333 0.141938 28.3611111 0.140395 28.3638889 0.137307 28.3666667 0.137307 28.3694444 0.135763 28.3722222 0.134220 28.3750000 0.132676 28.3777778 0.128045 28.3805556 0.129588 28.3833333 0.135763 28.3861111 0.135763 28.3888889 0.134220 28.3916667 0.137307 28.3944444 0.135763 28.3972222 0.135763 28.4000000 0.134220 28.4027778 0.129588 28.4055556 0.115695 28.4083333 0.098714 28.4111111 0.077101 28.4138889 0.058576 28.4166667 0.050858 28.4194444 0.072470 28.4222222 0.123413 28.4250000 0.203688 28.4277778 0.314837 28.4305556 0.438336 28.4333333 0.558748 28.4361111 0.642110 28.4388889 0.679160 28.4416667 0.646741 28.4444444 0.544854 28.4472222 0.395111 28.4500000 0.248456 28.4527778 0.137307 28.4555556 0.075557 28.4583333 0.057033 28.4611111 0.055489 28.4638889 0.053945 28.4666667 0.041595 28.4694444 0.012264 28.4722222 0.010000 28.4750000 0.010000 28.4777778 0.010000 28.4805556 0.010000 28.4833333 0.010000 28.4861111 0.010000 28.4888889 0.010000 28.4916667 0.010000 28.4944444 0.010000 28.4972222 0.010000 28.5000000 0.012264 28.5027778 0.038508 28.5055556 0.060120 28.5083333 0.078645 28.5111111 0.092539 28.5138889 0.101801 28.5166667 0.107976 28.5194444 0.112607 28.5222222 0.117238 28.5250000 0.124957 28.5277778 0.124957 28.5305556 0.123413 28.5333333 0.126501 28.5361111 0.128045 28.5388889 0.131132 28.5416667 0.128045 28.5444444 0.129588 28.5472222 0.131132 28.5500000 0.128045 28.5527778 0.131132 28.5555556 0.134220 28.5583333 0.137307 28.5611111 0.138851 28.5638889 0.140395 28.5666667 0.143482 28.5694444 0.141938 28.5722222 0.140395 28.5750000 0.138851 28.5777778 0.143482 28.5805556 0.137307 28.5833333 0.143482 28.5861111 0.145026 28.5888889 0.146569 28.5916667 0.148113 28.5944444 0.148113 28.5972222 0.149657 28.6000000 0.148113 28.6027778 0.149657 28.6055556 0.148113 28.6083333 0.149657 28.6111111 0.151201 28.6138889 0.151201 28.6166667 0.152744 28.6194444 0.155832 28.6222222 0.160463 28.6250000 0.163551 28.6277778 0.163551 28.6305556 0.165094 28.6333333 0.168182 28.6361111 0.166638 28.6388889 0.166638 28.6416667 0.165094 28.6444444 0.166638 28.6472222 0.174357 28.6500000 0.174357 28.6527778 0.177444 28.6555556 0.177444 28.6583333 0.185163 28.6611111 0.188250 28.6638889 0.182075 28.6666667 0.191338 28.6694444 0.192882 28.6722222 0.191338 28.6750000 0.192882 28.6777778 0.191338 28.6805556 0.192882 28.6833333 0.199057 28.6861111 0.200600 28.6888889 0.209863 28.6916667 0.216038 28.6944444 0.216038 28.6972222 0.220669 28.7000000 0.222213 28.7027778 0.223756 28.7055556 0.225300 28.7083333 0.231475 28.7111111 0.228388 28.7138889 0.234563 28.7166667 0.237650 28.7194444 0.240738 28.7222222 0.248456 28.7250000 0.254631 28.7277778 0.254631 28.7305556 0.257719 28.7333333 0.259262 28.7361111 0.262350 29.1833333 0.126501 29.1861111 0.129588 29.1888889 0.129588 29.1916667 0.131132 29.1944444 0.131132 29.1972222 0.131132 29.2000000 0.131132 29.2027778 0.128045 29.2055556 0.124957 29.2083333 0.124957 29.2111111 0.128045 29.2138889 0.126501 29.2166667 0.129588 29.2194444 0.132676 29.2222222 0.138851 29.2250000 0.140395 29.2277778 0.140395 29.2305556 0.143482 29.2333333 0.143482 29.2361111 0.148113 29.2388889 0.149657 29.2416667 0.149657 29.2444444 0.143482 29.2472222 0.146569 29.2500000 0.152744 29.2527778 0.157376 29.2555556 0.162007 29.2583333 0.168182 29.2611111 0.174357 29.2638889 0.178988 29.2666667 0.182075 29.2694444 0.182075 29.2722222 0.185163 29.2750000 0.180532 29.2777778 0.172813 29.2805556 0.171269 29.2833333 0.171269 29.2861111 0.171269 29.2888889 0.171269 29.2916667 0.169726 29.2944444 0.166638 29.2972222 0.162007 29.3000000 0.157376 29.3027778 0.151201 29.3055556 0.146569 29.3083333 0.138851 29.3111111 0.132676 29.3138889 0.124957 29.3166667 0.124957 29.3194444 0.126501 29.3222222 0.123413 29.3250000 0.126501 29.3277778 0.121870 29.3305556 0.126501 29.3333333 0.124957 29.3361111 0.120326 29.3388889 0.118782 29.3416667 0.115695 29.3444444 0.117238 29.3472222 0.117238 29.3500000 0.118782 29.3527778 0.118782 29.3555556 0.117238 29.3583333 0.120326 29.3611111 0.121870 29.3638889 0.123413 29.3666667 0.121870 29.3694444 0.121870 29.3722222 0.118782 29.3750000 0.115695 29.3777778 0.117238 29.3805556 0.115695 29.3833333 0.121870 29.3861111 0.120326 29.3888889 0.121870 29.3916667 0.126501 29.3944444 0.124957 29.3972222 0.115695 29.4000000 0.103345 29.4027778 0.084820 29.4055556 0.063208 29.4083333 0.043139 29.4111111 0.041595 29.4138889 0.074014 29.4166667 0.140395 29.4194444 0.236106 29.4222222 0.351887 29.4250000 0.473842 29.4277778 0.580360 29.4305556 0.656003 29.4333333 0.672985 29.4361111 0.618954 29.4388889 0.498542 29.4416667 0.347256 29.4444444 0.203688 29.4472222 0.111063 29.4500000 0.061664 29.4527778 0.050858 29.4555556 0.055489 29.4583333 0.060120 29.4611111 0.052401 29.4638889 0.024614 29.4666667 0.010000 29.4694444 0.010000 29.4722222 0.010000 29.4750000 0.010000 29.4777778 0.010000 29.4805556 0.010000 29.4833333 0.010000 29.4861111 0.010000 29.4888889 0.010000 29.4916667 0.010000 29.4944444 0.010000 29.4972222 0.023070 29.5000000 0.047770 29.5027778 0.066295 29.5055556 0.080189 29.5083333 0.090995 29.5111111 0.098714 29.5138889 0.104889 29.5166667 0.107976 29.5194444 0.109520 29.5222222 0.117238 29.5250000 0.118782 29.5277778 0.123413 29.5305556 0.126501 29.5333333 0.126501 29.5361111 0.121870 29.5388889 0.120326 29.5416667 0.124957 29.5444444 0.120326 29.5472222 0.121870 29.5500000 0.124957 29.5527778 0.126501 29.5555556 0.132676 29.5583333 0.137307 29.5611111 0.137307 29.5638889 0.137307 29.5666667 0.137307 29.5694444 0.137307 29.5722222 0.135763 29.5750000 0.137307 29.5777778 0.135763 29.5805556 0.135763 29.5833333 0.135763 29.5861111 0.137307 29.5888889 0.141938 29.5916667 0.141938 29.5944444 0.146569 29.5972222 0.143482 29.6000000 0.148113 29.6027778 0.145026 29.6055556 0.148113 29.6083333 0.146569 29.6111111 0.146569 29.6138889 0.154288 29.6166667 0.152744 29.6194444 0.158919 29.6222222 0.158919 29.6250000 0.160463 29.6277778 0.165094 29.6305556 0.163551 29.6333333 0.169726 29.6361111 0.169726 29.6388889 0.168182 29.6416667 0.171269 29.6444444 0.174357 29.6472222 0.174357 29.6500000 0.177444 29.6527778 0.183619 29.6555556 0.189794 29.6583333 0.191338 29.6611111 0.191338 29.6638889 0.197513 29.6666667 0.200600 29.6694444 0.199057 29.6722222 0.203688 29.6750000 0.203688 29.6777778 0.206775 29.6805556 0.212950 29.6833333 0.217581 29.6861111 0.223756 29.6888889 0.233019 29.6916667 0.237650 29.6944444 0.246913 29.6972222 0.250000 29.7000000 0.250000 29.7027778 0.251544 29.7055556 0.254631 29.7083333 0.256175 29.7111111 0.260806 29.7138889 0.266981 29.7166667 0.271612 29.7194444 0.279331 29.7222222 0.282419 29.7250000 0.288593 29.7277778 0.293225 29.7305556 0.296312 30.1138889 0.135763 30.1166667 0.135763 30.1194444 0.140395 30.1222222 0.140395 30.1250000 0.138851 30.1277778 0.138851 30.1305556 0.137307 30.1333333 0.138851 30.1361111 0.141938 30.1388889 0.138851 30.1416667 0.135763 30.1444444 0.132676 30.1472222 0.126501 30.1500000 0.126501 30.1527778 0.131132 30.1555556 0.132676 30.1583333 0.138851 30.1611111 0.138851 30.1638889 0.140395 30.1666667 0.143482 30.1694444 0.140395 30.1722222 0.138851 30.1750000 0.141938 30.1777778 0.140395 30.1805556 0.141938 30.1833333 0.146569 30.1861111 0.145026 30.1888889 0.152744 30.1916667 0.157376 30.1944444 0.165094 30.1972222 0.168182 30.2000000 0.169726 30.2027778 0.171269 30.2055556 0.172813 30.2083333 0.175901 30.2111111 0.178988 30.2138889 0.182075 30.2166667 0.185163 30.2194444 0.191338 30.2222222 0.191338 30.2250000 0.192882 30.2277778 0.183619 30.2305556 0.182075 30.2333333 0.175901 30.2361111 0.169726 30.2388889 0.166638 30.2416667 0.158919 30.2444444 0.152744 30.2472222 0.148113 30.2500000 0.145026 30.2527778 0.138851 30.2555556 0.137307 30.2583333 0.137307 30.2611111 0.135763 30.2638889 0.134220 30.2666667 0.132676 30.2694444 0.128045 30.2722222 0.126501 30.2750000 0.128045 30.2777778 0.126501 30.2805556 0.126501 30.2833333 0.126501 30.2861111 0.124957 30.2888889 0.123413 30.2916667 0.121870 30.2944444 0.126501 30.2972222 0.123413 30.3000000 0.126501 30.3027778 0.126501 30.3055556 0.126501 30.3083333 0.128045 30.3111111 0.128045 30.3138889 0.129588 30.3166667 0.134220 30.3194444 0.131132 30.3222222 0.129588 30.3250000 0.131132 30.3277778 0.129588 30.3305556 0.123413 30.3333333 0.114151 30.3361111 0.098714 30.3388889 0.078645 30.3416667 0.060120 30.3444444 0.063208 30.3472222 0.100257 30.3500000 0.177444 30.3527778 0.291681 30.3555556 0.427530 30.3583333 0.555660 30.3611111 0.652916 30.3638889 0.677616 30.3666667 0.623585 30.3694444 0.478473 30.3722222 0.296312 30.3750000 0.143482 30.3777778 0.041595 30.3805556 0.010000 30.3833333 0.010000 30.3861111 0.013808 30.3888889 0.024614 30.3916667 0.018439 30.3944444 0.010000 30.3972222 0.010000 30.4000000 0.010000 30.4027778 0.010000 30.4055556 0.010000 30.4083333 0.010000 30.4111111 0.010000 30.4138889 0.010000 30.4166667 0.010000 30.4194444 0.010000 30.4222222 0.026158 30.4250000 0.052401 30.4277778 0.077101 30.4305556 0.100257 30.4333333 0.114151 30.4361111 0.121870 30.4388889 0.129588 30.4416667 0.134220 30.4444444 0.135763 30.4472222 0.134220 30.4500000 0.131132 30.4527778 0.132676 30.4555556 0.131132 30.4583333 0.140395 30.4611111 0.141938 30.4638889 0.148113 30.4666667 0.154288 30.4694444 0.157376 30.4722222 0.155832 30.4750000 0.158919 30.4777778 0.154288 30.4805556 0.151201 30.4833333 0.154288 30.4861111 0.154288 30.4888889 0.151201 30.4916667 0.155832 30.4944444 0.157376 30.4972222 0.157376 30.5000000 0.160463 30.5027778 0.158919 30.5055556 0.165094 30.5083333 0.166638 30.5111111 0.168182 30.5138889 0.169726 30.5166667 0.168182 30.5194444 0.172813 30.5222222 0.172813 30.5250000 0.177444 30.5277778 0.178988 30.5305556 0.175901 30.5333333 0.178988 30.5361111 0.177444 30.5388889 0.175901 30.5416667 0.175901 30.5444444 0.174357 30.5472222 0.177444 30.5500000 0.177444 30.5527778 0.183619 30.5555556 0.192882 30.5583333 0.197513 30.5611111 0.203688 30.5638889 0.200600 30.5666667 0.200600 30.5694444 0.197513 30.5722222 0.194425 30.5750000 0.192882 30.5777778 0.189794 30.5805556 0.195969 30.5833333 0.199057 30.5861111 0.208319 30.5888889 0.211407 30.5916667 0.217581 30.5944444 0.223756 30.5972222 0.220669 30.6000000 0.220669 30.6027778 0.219125 30.6055556 0.217581 30.6083333 0.225300 30.6111111 0.226844 30.6138889 0.233019 30.6166667 0.240738 30.6194444 0.245369 30.6222222 0.246913 30.6250000 0.246913 30.6277778 0.243825 30.6305556 0.250000 30.6333333 0.250000 30.6361111 0.254631 30.6388889 0.259262 30.6416667 0.263894 30.6444444 0.265437 30.6472222 0.268525 30.6500000 0.270069 30.6527778 0.277787 30.6555556 0.280875 30.6583333 0.287050 30.6611111 0.293225 31.0000000 0.148113 31.0027778 0.143482 31.0055556 0.138851 31.0083333 0.140395 31.0111111 0.140395 31.0138889 0.135763 31.0166667 0.138851 31.0194444 0.141938 31.0222222 0.141938 31.0250000 0.141938 31.0277778 0.145026 31.0305556 0.145026 31.0333333 0.145026 31.0361111 0.146569 31.0388889 0.148113 31.0416667 0.146569 31.0444444 0.146569 31.0472222 0.152744 31.0500000 0.155832 31.0527778 0.158919 31.0555556 0.162007 31.0583333 0.165094 31.0611111 0.163551 31.0638889 0.166638 31.0666667 0.168182 31.0694444 0.169726 31.0722222 0.177444 31.0750000 0.182075 31.0777778 0.185163 31.0805556 0.188250 31.0833333 0.188250 31.0861111 0.194425 31.0888889 0.192882 31.0916667 0.194425 31.0944444 0.189794 31.0972222 0.186707 31.1000000 0.185163 31.1027778 0.178988 31.1055556 0.174357 31.1083333 0.171269 31.1111111 0.162007 31.1138889 0.157376 31.1166667 0.154288 31.1194444 0.148113 31.1222222 0.145026 31.1250000 0.143482 31.1277778 0.143482 31.1305556 0.137307 31.1333333 0.134220 31.1361111 0.129588 31.1388889 0.129588 31.1416667 0.126501 31.1444444 0.124957 31.1472222 0.124957 31.1500000 0.123413 31.1527778 0.128045 31.1555556 0.126501 31.1583333 0.128045 31.1611111 0.129588 31.1638889 0.128045 31.1666667 0.126501 31.1694444 0.123413 31.1722222 0.121870 31.1750000 0.120326 31.1777778 0.120326 31.1805556 0.120326 31.1833333 0.120326 31.1861111 0.123413 31.1888889 0.126501 31.1916667 0.126501 31.1944444 0.126501 31.1972222 0.129588 31.2000000 0.128045 31.2027778 0.126501 31.2055556 0.126501 31.2083333 0.123413 31.2111111 0.118782 31.2138889 0.101801 31.2166667 0.090995 31.2194444 0.078645 31.2222222 0.058576 31.2250000 0.052401 31.2277778 0.067839 31.2305556 0.114151 31.2333333 0.191338 31.2361111 0.297856 31.2388889 0.416724 31.2416667 0.534048 31.2444444 0.623585 31.2472222 0.672985 31.2500000 0.662178 31.2527778 0.578816 31.2555556 0.444511 31.2583333 0.293225 31.2611111 0.172813 31.2638889 0.095626 31.2666667 0.064751 31.2694444 0.057033 31.2722222 0.057033 31.2750000 0.053945 31.2777778 0.030789 31.2805556 0.010000 31.2833333 0.010000 31.2861111 0.010000 31.2888889 0.010000 31.2916667 0.010000 31.2944444 0.010000 31.2972222 0.010000 31.3000000 0.010000 31.3027778 0.010000 31.3055556 0.010000 31.3083333 0.010000 31.3111111 0.013808 31.3138889 0.040051 31.3166667 0.064751 31.3194444 0.083276 31.3222222 0.098714 31.3250000 0.111063 31.3277778 0.118782 31.3305556 0.120326 31.3333333 0.121870 31.3361111 0.123413 31.3388889 0.123413 31.3416667 0.123413 31.3444444 0.124957 31.3472222 0.128045 31.3500000 0.128045 31.3527778 0.131132 31.3555556 0.129588 31.3583333 0.137307 31.3611111 0.138851 31.3638889 0.141938 31.3666667 0.143482 31.3694444 0.140395 31.3722222 0.138851 31.3750000 0.140395 31.3777778 0.137307 31.3805556 0.137307 31.3833333 0.137307 31.3861111 0.140395 31.3888889 0.146569 31.3916667 0.146569 31.3944444 0.149657 31.3972222 0.149657 31.4000000 0.152744 31.4027778 0.152744 31.4055556 0.151201 31.4083333 0.151201 31.4111111 0.143482 31.4138889 0.148113 31.4166667 0.151201 31.4194444 0.155832 31.4222222 0.158919 31.4250000 0.163551 31.4277778 0.163551 31.4305556 0.166638 31.4333333 0.163551 31.4361111 0.163551 31.4388889 0.169726 31.4416667 0.169726 31.4444444 0.172813 31.4472222 0.171269 31.4500000 0.177444 31.4527778 0.177444 31.4555556 0.180532 31.4583333 0.186707 31.4611111 0.191338 31.4638889 0.192882 31.4666667 0.194425 31.4694444 0.195969 31.4722222 0.197513 31.4750000 0.197513 31.4777778 0.197513 31.4805556 0.200600 31.4833333 0.205232 31.4861111 0.212950 31.4888889 0.216038 31.4916667 0.225300 31.4944444 0.225300 31.4972222 0.229931 31.5000000 0.231475 31.5027778 0.234563 31.5055556 0.242281 31.5083333 0.245369 31.5111111 0.245369 31.5138889 0.253087 31.5166667 0.257719 31.5194444 0.266981 31.5222222 0.265437 31.5250000 0.273156 31.5277778 0.279331 31.5305556 0.283962 31.5333333 0.290137 31.5361111 0.293225 31.5388889 0.293225 31.5416667 0.294768 31.5444444 0.296312 31.5472222 0.300943 31.9805556 0.132676 31.9833333 0.140395 31.9861111 0.138851 31.9888889 0.137307 31.9916667 0.138851 31.9944444 0.143482 31.9972222 0.143482 32.0000000 0.145026 32.0027778 0.146569 32.0055556 0.141938 32.0083333 0.141938 32.0111111 0.140395 32.0138889 0.137307 32.0166667 0.140395 32.0194444 0.140395 32.0222222 0.141938 32.0250000 0.146569 32.0277778 0.148113 32.0305556 0.151201 32.0333333 0.155832 32.0361111 0.157376 32.0388889 0.158919 32.0416667 0.160463 32.0444444 0.158919 32.0472222 0.158919 32.0500000 0.162007 32.0527778 0.165094 32.0555556 0.174357 32.0583333 0.175901 32.0611111 0.182075 32.0638889 0.185163 32.0666667 0.189794 32.0694444 0.195969 32.0722222 0.195969 32.0750000 0.194425 32.0777778 0.192882 32.0805556 0.192882 32.0833333 0.192882 32.0861111 0.189794 32.0888889 0.188250 32.0916667 0.186707 32.0944444 0.182075 32.0972222 0.178988 32.1000000 0.177444 32.1027778 0.169726 32.1055556 0.166638 32.1083333 0.158919 32.1111111 0.152744 32.1138889 0.146569 32.1166667 0.141938 32.1194444 0.135763 32.1222222 0.137307 32.1250000 0.137307 32.1277778 0.137307 32.1305556 0.135763 32.1333333 0.137307 32.1361111 0.134220 32.1388889 0.131132 32.1416667 0.131132 32.1444444 0.129588 32.1472222 0.126501 32.1500000 0.128045 32.1527778 0.131132 32.1555556 0.131132 32.1583333 0.132676 32.1611111 0.134220 32.1638889 0.131132 32.1666667 0.128045 32.1694444 0.129588 32.1722222 0.131132 32.1750000 0.129588 32.1777778 0.124957 32.1805556 0.129588 32.1833333 0.129588 32.1861111 0.129588 32.1888889 0.132676 32.1916667 0.128045 32.1944444 0.128045 32.1972222 0.117238 32.2000000 0.104889 32.2027778 0.083276 32.2055556 0.060120 32.2083333 0.050858 32.2111111 0.067839 32.2138889 0.120326 32.2166667 0.203688 32.2194444 0.314837 32.2222222 0.444511 32.2250000 0.566467 32.2277778 0.657547 32.2305556 0.697684 32.2333333 0.669897 32.2361111 0.563379 32.2388889 0.410549 32.2416667 0.257719 32.2444444 0.140395 32.2472222 0.075557 32.2500000 0.053945 32.2527778 0.055489 32.2555556 0.060120 32.2583333 0.057033 32.2611111 0.033877 32.2638889 0.010000 32.2666667 0.010000 32.2694444 0.010000 32.2722222 0.010000 32.2750000 0.010000 32.2777778 0.010000 32.2805556 0.010000 32.2833333 0.010000 32.2861111 0.010000 32.2888889 0.010000 32.2916667 0.010000 32.2944444 0.032333 32.2972222 0.057033 32.3000000 0.077101 32.3027778 0.094082 32.3055556 0.106432 32.3083333 0.112607 32.3111111 0.115695 32.3138889 0.118782 32.3166667 0.120326 32.3194444 0.126501 32.3222222 0.129588 32.3250000 0.135763 32.3277778 0.137307 32.3305556 0.138851 32.3333333 0.138851 32.3361111 0.141938 32.3388889 0.140395 32.3416667 0.137307 32.3444444 0.137307 32.3472222 0.138851 32.3500000 0.137307 32.3527778 0.140395 32.3555556 0.141938 32.3583333 0.149657 32.3611111 0.152744 32.3638889 0.151201 32.3666667 0.152744 32.3694444 0.149657 32.3722222 0.151201 32.3750000 0.149657 32.3777778 0.151201 32.3805556 0.151201 32.3833333 0.149657 32.3861111 0.154288 32.3888889 0.152744 32.3916667 0.158919 32.3944444 0.158919 32.3972222 0.160463 32.4000000 0.165094 32.4027778 0.162007 32.4055556 0.162007 32.4083333 0.163551 32.4111111 0.165094 32.4138889 0.169726 32.4166667 0.171269 32.4194444 0.174357 32.4222222 0.178988 32.4250000 0.178988 32.4277778 0.178988 32.4305556 0.178988 32.4333333 0.185163 32.4361111 0.182075 32.4388889 0.183619 32.4416667 0.183619 32.4444444 0.188250 32.4472222 0.188250 32.4500000 0.194425 32.4527778 0.197513 32.4555556 0.200600 32.4583333 0.202144 32.4611111 0.205232 32.4638889 0.206775 32.4666667 0.209863 32.4694444 0.211407 32.4722222 0.211407 32.4750000 0.206775 32.4777778 0.203688 32.4805556 0.211407 32.4833333 0.222213 32.4861111 0.228388 32.4888889 0.237650 32.4916667 0.245369 32.4944444 0.251544 32.4972222 0.250000 32.5000000 0.253087 32.5027778 0.253087 32.5055556 0.254631 32.5083333 0.250000 32.5111111 0.256175 32.5138889 0.257719 32.5166667 0.260806 32.5194444 0.266981 32.5222222 0.270069 32.5250000 0.279331 32.5277778 0.288593 32.9583333 0.145026 32.9611111 0.149657 32.9638889 0.143482 32.9666667 0.141938 32.9694444 0.138851 32.9722222 0.138851 32.9750000 0.140395 32.9777778 0.140395 32.9805556 0.143482 32.9833333 0.141938 32.9861111 0.145026 32.9888889 0.149657 32.9916667 0.149657 32.9944444 0.148113 32.9972222 0.146569 33.0000000 0.146569 33.0027778 0.145026 33.0055556 0.145026 33.0083333 0.146569 33.0111111 0.148113 33.0138889 0.151201 33.0166667 0.155832 33.0194444 0.157376 33.0222222 0.162007 33.0250000 0.166638 33.0277778 0.168182 33.0305556 0.174357 33.0333333 0.178988 33.0361111 0.180532 33.0388889 0.182075 33.0416667 0.185163 33.0444444 0.188250 33.0472222 0.191338 33.0500000 0.194425 33.0527778 0.200600 33.0555556 0.199057 33.0583333 0.202144 33.0611111 0.199057 33.0638889 0.195969 33.0666667 0.194425 33.0694444 0.188250 33.0722222 0.182075 33.0750000 0.177444 33.0777778 0.172813 33.0805556 0.165094 33.0833333 0.157376 33.0861111 0.154288 33.0888889 0.146569 33.0916667 0.143482 33.0944444 0.141938 33.0972222 0.141938 33.1000000 0.141938 33.1027778 0.143482 33.1055556 0.146569 33.1083333 0.141938 33.1111111 0.138851 33.1138889 0.134220 33.1166667 0.132676 33.1194444 0.134220 33.1222222 0.135763 33.1250000 0.135763 33.1277778 0.145026 33.1305556 0.140395 33.1333333 0.143482 33.1361111 0.140395 33.1388889 0.140395 33.1416667 0.134220 33.1444444 0.131132 33.1472222 0.132676 33.1500000 0.128045 33.1527778 0.134220 33.1555556 0.135763 33.1583333 0.137307 33.1611111 0.141938 33.1638889 0.138851 33.1666667 0.137307 33.1694444 0.138851 33.1722222 0.134220 33.1750000 0.128045 33.1777778 0.117238 33.1805556 0.100257 33.1833333 0.080189 33.1861111 0.066295 33.1888889 0.070926 33.1916667 0.106432 33.1944444 0.174357 33.1972222 0.276244 33.2000000 0.399743 33.2027778 0.526329 33.2055556 0.631304 33.2083333 0.691509 33.2111111 0.683791 33.2138889 0.594254 33.2166667 0.442967 33.2194444 0.271612 33.2222222 0.132676 33.2250000 0.049314 33.2277778 0.015352 33.2305556 0.016895 33.2333333 0.027702 33.2361111 0.038508 33.2388889 0.029245 33.2416667 0.010000 33.2444444 0.010000 33.2472222 0.010000 33.2500000 0.010000 33.2527778 0.010000 33.2555556 0.010000 33.2583333 0.010000 33.2611111 0.010000 33.2638889 0.010000 33.2666667 0.010000 33.2694444 0.010000 33.2722222 0.010000 33.2750000 0.038508 33.2777778 0.057033 33.2805556 0.077101 33.2833333 0.097170 33.2861111 0.109520 33.2888889 0.126501 33.2916667 0.135763 33.2944444 0.143482 33.2972222 0.145026 33.3000000 0.146569 33.3027778 0.146569 33.3055556 0.146569 33.3083333 0.148113 33.3111111 0.149657 33.3138889 0.152744 33.3166667 0.151201 33.3194444 0.152744 33.3222222 0.152744 33.3250000 0.157376 33.3277778 0.158919 33.3305556 0.162007 33.3333333 0.165094 33.3361111 0.165094 33.3388889 0.163551 33.3416667 0.157376 33.3444444 0.155832 33.3472222 0.151201 33.3500000 0.152744 33.3527778 0.155832 33.3555556 0.163551 33.3583333 0.169726 33.3611111 0.174357 33.3638889 0.177444 33.3666667 0.177444 33.3694444 0.178988 33.3722222 0.174357 33.3750000 0.172813 33.3777778 0.172813 33.3805556 0.171269 33.3833333 0.172813 33.3861111 0.172813 33.3888889 0.174357 33.3916667 0.175901 33.3944444 0.180532 33.3972222 0.180532 33.4000000 0.186707 33.4027778 0.186707 33.4055556 0.192882 33.4083333 0.195969 33.4111111 0.199057 33.4138889 0.195969 33.4166667 0.200600 33.4194444 0.199057 33.4222222 0.197513 33.4250000 0.199057 33.4277778 0.200600 33.4305556 0.205232 33.4333333 0.206775 33.4361111 0.206775 33.4388889 0.209863 33.4416667 0.209863 33.4444444 0.209863 33.4472222 0.212950 33.4500000 0.211407 33.4527778 0.216038 33.4555556 0.222213 33.4583333 0.233019 33.4611111 0.237650 33.4638889 0.239194 33.4666667 0.239194 33.4694444 0.239194 33.4722222 0.239194 33.4750000 0.239194 33.4777778 0.240738 33.4805556 0.243825 33.4833333 0.248456 33.4861111 0.254631 33.4888889 0.260806 33.4916667 0.263894 33.4944444 0.268525 33.4972222 0.271612 33.5000000 0.274700 33.5027778 0.274700 33.5055556 0.277787 33.8472222 0.140395 33.8500000 0.143482 33.8527778 0.143482 33.8555556 0.140395 33.8583333 0.138851 33.8611111 0.143482 33.8638889 0.143482 33.8666667 0.141938 33.8694444 0.143482 33.8722222 0.138851 33.8750000 0.140395 33.8777778 0.135763 33.8805556 0.138851 33.8833333 0.138851 33.8861111 0.138851 33.8888889 0.143482 33.8916667 0.146569 33.8944444 0.152744 33.8972222 0.152744 33.9000000 0.154288 33.9027778 0.155832 33.9055556 0.157376 33.9083333 0.158919 33.9111111 0.160463 33.9138889 0.160463 33.9166667 0.162007 33.9194444 0.166638 33.9222222 0.169726 33.9250000 0.174357 33.9277778 0.177444 33.9305556 0.183619 33.9333333 0.188250 33.9361111 0.191338 33.9388889 0.195969 33.9416667 0.195969 33.9444444 0.192882 33.9472222 0.192882 33.9500000 0.185163 33.9527778 0.183619 33.9555556 0.178988 33.9583333 0.180532 33.9611111 0.178988 33.9638889 0.177444 33.9666667 0.171269 33.9694444 0.165094 33.9722222 0.157376 33.9750000 0.148113 33.9777778 0.143482 33.9805556 0.138851 33.9833333 0.134220 33.9861111 0.134220 33.9888889 0.135763 33.9916667 0.129588 33.9944444 0.134220 33.9972222 0.134220 34.0000000 0.131132 34.0027778 0.129588 34.0055556 0.126501 34.0083333 0.126501 34.0111111 0.124957 34.0138889 0.120326 34.0166667 0.124957 34.0194444 0.123413 34.0222222 0.126501 34.0250000 0.124957 34.0277778 0.128045 34.0305556 0.128045 34.0333333 0.129588 34.0361111 0.131132 34.0388889 0.126501 34.0416667 0.126501 34.0444444 0.126501 34.0472222 0.126501 34.0500000 0.126501 34.0527778 0.126501 34.0555556 0.129588 34.0583333 0.126501 34.0611111 0.120326 34.0638889 0.111063 34.0666667 0.092539 34.0694444 0.070926 34.0722222 0.050858 34.0750000 0.050858 34.0777778 0.077101 34.0805556 0.138851 34.0833333 0.236106 34.0861111 0.354974 34.0888889 0.481561 34.0916667 0.595798 34.0944444 0.672985 34.0972222 0.686878 34.1000000 0.626672 34.1027778 0.500086 34.1055556 0.339537 34.1083333 0.202144 34.1111111 0.104889 34.1138889 0.060120 34.1166667 0.046226 34.1194444 0.050858 34.1222222 0.050858 34.1250000 0.035420 34.1277778 0.010000 34.1305556 0.010000 34.1333333 0.010000 34.1361111 0.010000 34.1388889 0.010000 34.1416667 0.010000 34.1444444 0.010000 34.1472222 0.010000 34.1500000 0.010000 34.1527778 0.010000 34.1555556 0.010000 34.1583333 0.010000 34.1611111 0.021527 34.1638889 0.046226 34.1666667 0.069383 34.1694444 0.084820 34.1722222 0.095626 34.1750000 0.106432 34.1777778 0.104889 34.1805556 0.109520 34.1833333 0.112607 34.1861111 0.115695 34.1888889 0.115695 34.1916667 0.115695 34.1944444 0.126501 34.1972222 0.128045 34.2000000 0.128045 34.2027778 0.129588 34.2055556 0.129588 34.2083333 0.128045 34.2111111 0.126501 34.2138889 0.129588 34.2166667 0.131132 34.2194444 0.137307 34.2222222 0.138851 34.2250000 0.137307 34.2277778 0.135763 34.2305556 0.140395 34.2333333 0.141938 34.2361111 0.143482 34.2388889 0.140395 34.2416667 0.140395 34.2444444 0.138851 34.2472222 0.138851 34.2500000 0.137307 34.2527778 0.137307 34.2555556 0.143482 34.2583333 0.145026 34.2611111 0.148113 34.2638889 0.151201 34.2666667 0.154288 34.2694444 0.152744 34.2722222 0.149657 34.2750000 0.149657 34.2777778 0.151201 34.2805556 0.152744 34.2833333 0.155832 34.2861111 0.155832 34.2888889 0.162007 34.2916667 0.163551 34.2944444 0.163551 34.2972222 0.163551 34.3000000 0.166638 34.3027778 0.168182 34.3055556 0.171269 34.3083333 0.169726 34.3111111 0.174357 34.3138889 0.175901 34.3166667 0.172813 34.3194444 0.175901 34.3222222 0.182075 34.3250000 0.182075 34.3277778 0.188250 34.3305556 0.191338 34.3333333 0.189794 34.3361111 0.195969 34.3388889 0.199057 34.3416667 0.200600 34.3444444 0.202144 34.3472222 0.203688 34.3500000 0.205232 34.3527778 0.214494 34.3555556 0.216038 34.3583333 0.222213 34.3611111 0.228388 34.3638889 0.233019 34.3666667 0.233019 34.3694444 0.234563 34.3722222 0.234563 34.3750000 0.239194 34.3777778 0.239194 34.3805556 0.246913 34.3833333 0.250000 34.3861111 0.254631 34.3888889 0.260806 34.3916667 0.266981 34.3944444 0.274700 34.8388889 0.135763 34.8416667 0.132676 34.8444444 0.134220 34.8472222 0.128045 34.8500000 0.131132 34.8527778 0.131132 34.8555556 0.137307 34.8583333 0.137307 34.8611111 0.138851 34.8638889 0.137307 34.8666667 0.135763 34.8694444 0.137307 34.8722222 0.137307 34.8750000 0.135763 34.8777778 0.135763 34.8805556 0.135763 34.8833333 0.135763 34.8861111 0.138851 34.8888889 0.145026 34.8916667 0.148113 34.8944444 0.151201 34.8972222 0.152744 34.9000000 0.160463 34.9027778 0.158919 34.9055556 0.162007 34.9083333 0.158919 34.9111111 0.157376 34.9138889 0.160463 34.9166667 0.165094 34.9194444 0.168182 34.9222222 0.178988 34.9250000 0.182075 34.9277778 0.188250 34.9305556 0.191338 34.9333333 0.195969 34.9361111 0.192882 34.9388889 0.191338 34.9416667 0.183619 34.9444444 0.182075 34.9472222 0.175901 34.9500000 0.172813 34.9527778 0.169726 34.9555556 0.172813 34.9583333 0.169726 34.9611111 0.168182 34.9638889 0.162007 34.9666667 0.154288 34.9694444 0.149657 34.9722222 0.138851 34.9750000 0.137307 34.9777778 0.128045 34.9805556 0.126501 34.9833333 0.121870 34.9861111 0.126501 34.9888889 0.129588 34.9916667 0.126501 34.9944444 0.132676 34.9972222 0.134220 35.0000000 0.132676 35.0027778 0.128045 35.0055556 0.128045 35.0083333 0.126501 35.0111111 0.124957 35.0138889 0.121870 35.0166667 0.123413 35.0194444 0.120326 35.0222222 0.123413 35.0250000 0.128045 35.0277778 0.129588 35.0305556 0.131132 35.0333333 0.132676 35.0361111 0.129588 35.0388889 0.131132 35.0416667 0.128045 35.0444444 0.124957 35.0472222 0.123413 35.0500000 0.121870 35.0527778 0.117238 35.0555556 0.106432 35.0583333 0.090995 35.0611111 0.070926 35.0638889 0.055489 35.0666667 0.058576 35.0694444 0.090995 35.0722222 0.158919 35.0750000 0.262350 35.0777778 0.382762 35.0805556 0.509348 35.0833333 0.615866 35.0861111 0.677616 35.0888889 0.665266 35.0916667 0.580360 35.0944444 0.438336 35.0972222 0.279331 35.1000000 0.151201 35.1027778 0.075557 35.1055556 0.047770 35.1083333 0.043139 35.1111111 0.047770 35.1138889 0.040051 35.1166667 0.021527 35.1194444 0.010000 35.1222222 0.010000 35.1250000 0.010000 35.1277778 0.010000 35.1305556 0.010000 35.1333333 0.010000 35.1361111 0.010000 35.1388889 0.010000 35.1416667 0.010000 35.1444444 0.010000 35.1472222 0.010000 35.1500000 0.027702 35.1527778 0.052401 35.1555556 0.074014 35.1583333 0.092539 35.1611111 0.106432 35.1638889 0.115695 35.1666667 0.117238 35.1694444 0.121870 35.1722222 0.120326 35.1750000 0.123413 35.1777778 0.124957 35.1805556 0.131132 35.1833333 0.132676 35.1861111 0.131132 35.1888889 0.132676 35.1916667 0.129588 35.1944444 0.132676 35.1972222 0.131132 35.2000000 0.134220 35.2027778 0.137307 35.2055556 0.143482 35.2083333 0.146569 35.2111111 0.146569 35.2138889 0.145026 35.2166667 0.145026 35.2194444 0.148113 35.2222222 0.146569 35.2250000 0.149657 35.2277778 0.152744 35.2305556 0.152744 35.2333333 0.152744 35.2361111 0.152744 35.2388889 0.152744 35.2416667 0.152744 35.2444444 0.152744 35.2472222 0.157376 35.2500000 0.158919 35.2527778 0.157376 35.2555556 0.162007 35.2583333 0.163551 35.2611111 0.166638 35.2638889 0.172813 35.2666667 0.174357 35.2694444 0.172813 35.2722222 0.171269 35.2750000 0.174357 35.2777778 0.169726 35.2805556 0.166638 35.2833333 0.171269 35.2861111 0.175901 35.2888889 0.178988 35.2916667 0.186707 35.2944444 0.191338 35.2972222 0.191338 35.3000000 0.195969 35.3027778 0.192882 35.3055556 0.194425 35.3083333 0.194425 35.3111111 0.197513 35.3138889 0.197513 35.3166667 0.200600 35.3194444 0.206775 35.3222222 0.206775 35.3250000 0.214494 35.3277778 0.223756 35.3305556 0.225300 35.3333333 0.229931 35.3361111 0.231475 35.3388889 0.233019 35.3416667 0.234563 35.3444444 0.234563 35.3472222 0.237650 35.3500000 0.243825 35.3527778 0.248456 35.3555556 0.254631 35.3583333 0.262350 35.3611111 0.271612 35.3638889 0.280875 35.3666667 0.283962 35.3694444 0.290137 35.3722222 0.290137 35.3750000 0.290137 35.3777778 0.288593 35.3805556 0.290137 35.3833333 0.297856 35.3861111 0.299400 35.7583333 0.141938 35.7611111 0.140395 35.7638889 0.143482 35.7666667 0.146569 35.7694444 0.145026 35.7722222 0.141938 35.7750000 0.138851 35.7777778 0.135763 35.7805556 0.131132 35.7833333 0.134220 35.7861111 0.137307 35.7888889 0.143482 35.7916667 0.146569 35.7944444 0.151201 35.7972222 0.151201 35.8000000 0.146569 35.8027778 0.145026 35.8055556 0.143482 35.8083333 0.140395 35.8111111 0.140395 35.8138889 0.141938 35.8166667 0.145026 35.8194444 0.143482 35.8222222 0.146569 35.8250000 0.146569 35.8277778 0.152744 35.8305556 0.155832 35.8333333 0.163551 35.8361111 0.168182 35.8388889 0.174357 35.8416667 0.171269 35.8444444 0.168182 35.8472222 0.169726 35.8500000 0.171269 35.8527778 0.171269 35.8555556 0.178988 35.8583333 0.188250 35.8611111 0.194425 35.8638889 0.199057 35.8666667 0.199057 35.8694444 0.195969 35.8722222 0.188250 35.8750000 0.185163 35.8777778 0.182075 35.8805556 0.177444 35.8833333 0.172813 35.8861111 0.165094 35.8888889 0.158919 35.8916667 0.152744 35.8944444 0.148113 35.8972222 0.145026 35.9000000 0.141938 35.9027778 0.140395 35.9055556 0.138851 35.9083333 0.138851 35.9111111 0.131132 35.9138889 0.126501 35.9166667 0.126501 35.9194444 0.124957 35.9222222 0.128045 35.9250000 0.126501 35.9277778 0.131132 35.9305556 0.131132 35.9333333 0.129588 35.9361111 0.131132 35.9388889 0.128045 35.9416667 0.128045 35.9444444 0.123413 35.9472222 0.118782 35.9500000 0.120326 35.9527778 0.121870 35.9555556 0.121870 35.9583333 0.124957 35.9611111 0.128045 35.9638889 0.129588 35.9666667 0.128045 35.9694444 0.126501 35.9722222 0.131132 35.9750000 0.121870 35.9777778 0.111063 35.9805556 0.092539 35.9833333 0.075557 35.9861111 0.061664 35.9888889 0.067839 35.9916667 0.112607 35.9944444 0.195969 35.9972222 0.313293 36.0000000 0.447599 36.0027778 0.574185 36.0055556 0.665266 36.0083333 0.685334 36.0111111 0.628216 36.0138889 0.484648 36.0166667 0.310206 36.0194444 0.146569 36.0222222 0.049314 36.0250000 0.010000 36.0277778 0.010720 36.0305556 0.023070 36.0333333 0.032333 36.0361111 0.030789 36.0388889 0.010000 36.0416667 0.010000 36.0444444 0.010000 36.0472222 0.010000 36.0500000 0.010000 36.0527778 0.010000 36.0555556 0.010000 36.0583333 0.010000 36.0611111 0.010000 36.0638889 0.010000 36.0666667 0.010000 36.0694444 0.010000 36.0722222 0.010000 36.0750000 0.030789 36.0777778 0.052401 36.0805556 0.077101 36.0833333 0.095626 36.0861111 0.111063 36.0888889 0.121870 36.0916667 0.124957 36.0944444 0.128045 36.0972222 0.131132 36.1000000 0.135763 36.1027778 0.137307 36.1055556 0.137307 36.1083333 0.132676 36.1111111 0.131132 36.1138889 0.131132 36.1166667 0.132676 36.1194444 0.138851 36.1222222 0.141938 36.1250000 0.143482 36.1277778 0.143482 36.1305556 0.146569 36.1333333 0.151201 36.1361111 0.152744 36.1388889 0.155832 36.1416667 0.154288 36.1444444 0.154288 36.1472222 0.149657 36.1500000 0.146569 36.1527778 0.145026 36.1555556 0.141938 36.1583333 0.146569 36.1611111 0.151201 36.1638889 0.154288 36.1666667 0.158919 36.1694444 0.163551 36.1722222 0.166638 36.1750000 0.165094 36.1777778 0.162007 36.1805556 0.162007 36.1833333 0.160463 36.1861111 0.160463 36.1888889 0.158919 36.1916667 0.160463 36.1944444 0.163551 36.1972222 0.172813 36.2000000 0.172813 36.2027778 0.175901 36.2055556 0.172813 36.2083333 0.172813 36.2111111 0.171269 36.2138889 0.172813 36.2166667 0.174357 36.2194444 0.175901 36.2222222 0.180532 36.2250000 0.185163 36.2277778 0.188250 36.2305556 0.194425 36.2333333 0.194425 36.2361111 0.195969 36.2388889 0.195969 36.2416667 0.194425 36.2444444 0.199057 36.2472222 0.200600 36.2500000 0.200600 36.2527778 0.205232 36.2555556 0.206775 36.2583333 0.212950 36.2611111 0.216038 36.2638889 0.217581 36.2666667 0.219125 36.2694444 0.222213 36.2722222 0.225300 36.2750000 0.223756 36.2777778 0.225300 36.2805556 0.228388 36.2833333 0.228388 36.2861111 0.231475 36.2888889 0.239194 36.2916667 0.243825 36.2944444 0.245369 36.2972222 0.253087 36.3000000 0.256175 36.3027778 0.259262 36.3055556 0.259262 36.6861111 0.132676 36.6888889 0.135763 36.6916667 0.137307 36.6944444 0.138851 36.6972222 0.140395 36.7000000 0.134220 36.7027778 0.137307 36.7055556 0.135763 36.7083333 0.134220 36.7111111 0.132676 36.7138889 0.132676 36.7166667 0.131132 36.7194444 0.137307 36.7222222 0.138851 36.7250000 0.141938 36.7277778 0.146569 36.7305556 0.152744 36.7333333 0.154288 36.7361111 0.155832 36.7388889 0.155832 36.7416667 0.155832 36.7444444 0.152744 36.7472222 0.154288 36.7500000 0.155832 36.7527778 0.160463 36.7555556 0.165094 36.7583333 0.174357 36.7611111 0.182075 36.7638889 0.182075 36.7666667 0.191338 36.7694444 0.192882 36.7722222 0.188250 36.7750000 0.180532 36.7777778 0.183619 36.7805556 0.178988 36.7833333 0.175901 36.7861111 0.174357 36.7888889 0.172813 36.7916667 0.171269 36.7944444 0.171269 36.7972222 0.165094 36.8000000 0.158919 36.8027778 0.154288 36.8055556 0.145026 36.8083333 0.143482 36.8111111 0.134220 36.8138889 0.128045 36.8166667 0.129588 36.8194444 0.126501 36.8222222 0.123413 36.8250000 0.120326 36.8277778 0.126501 36.8305556 0.126501 36.8333333 0.128045 36.8361111 0.123413 36.8388889 0.123413 36.8416667 0.118782 36.8444444 0.117238 36.8472222 0.115695 36.8500000 0.115695 36.8527778 0.115695 36.8555556 0.118782 36.8583333 0.118782 36.8611111 0.121870 36.8638889 0.120326 36.8666667 0.121870 36.8694444 0.123413 36.8722222 0.118782 36.8750000 0.121870 36.8777778 0.120326 36.8805556 0.120326 36.8833333 0.118782 36.8861111 0.121870 36.8888889 0.121870 36.8916667 0.124957 36.8944444 0.123413 36.8972222 0.124957 36.9000000 0.117238 36.9027778 0.111063 36.9055556 0.092539 36.9083333 0.069383 36.9111111 0.049314 36.9138889 0.040051 36.9166667 0.066295 36.9194444 0.118782 36.9222222 0.214494 36.9250000 0.330274 36.9277778 0.459949 36.9305556 0.575729 36.9333333 0.654460 36.9361111 0.671441 36.9388889 0.608148 36.9416667 0.480017 36.9444444 0.325643 36.9472222 0.188250 36.9500000 0.098714 36.9527778 0.055489 36.9555556 0.044683 36.9583333 0.049314 36.9611111 0.043139 36.9638889 0.029245 36.9666667 0.010000 36.9694444 0.010000 36.9722222 0.010000 36.9750000 0.010000 36.9777778 0.010000 36.9805556 0.010000 36.9833333 0.010000 36.9861111 0.010000 36.9888889 0.010000 36.9916667 0.010000 36.9944444 0.010000 36.9972222 0.027702 37.0000000 0.049314 37.0027778 0.075557 37.0055556 0.092539 37.0083333 0.100257 37.0111111 0.109520 37.0138889 0.112607 37.0166667 0.112607 37.0194444 0.118782 37.0222222 0.120326 37.0250000 0.123413 37.0277778 0.129588 37.0305556 0.129588 37.0333333 0.129588 37.0361111 0.134220 37.0388889 0.134220 37.0416667 0.132676 37.0444444 0.131132 37.0472222 0.132676 37.0500000 0.132676 37.0527778 0.131132 37.0555556 0.135763 37.0583333 0.138851 37.0611111 0.138851 37.0638889 0.143482 37.0666667 0.141938 37.0694444 0.140395 37.0722222 0.143482 37.0750000 0.141938 37.0777778 0.143482 37.0805556 0.143482 37.0833333 0.137307 37.0861111 0.141938 37.0888889 0.146569 37.0916667 0.148113 37.0944444 0.148113 37.0972222 0.152744 37.1000000 0.155832 37.1027778 0.157376 37.1055556 0.157376 37.1083333 0.157376 37.1111111 0.158919 37.1138889 0.158919 37.1166667 0.158919 37.1194444 0.162007 37.1222222 0.166638 37.1250000 0.168182 37.1277778 0.174357 37.1305556 0.177444 37.1333333 0.180532 37.1361111 0.183619 37.1388889 0.183619 37.1416667 0.183619 37.1444444 0.177444 37.1472222 0.180532 37.1500000 0.186707 37.1527778 0.188250 37.1555556 0.192882 37.1583333 0.194425 37.1611111 0.200600 37.1638889 0.205232 37.1666667 0.208319 37.1694444 0.209863 37.1722222 0.212950 37.1750000 0.212950 37.1777778 0.217581 37.1805556 0.216038 37.1833333 0.220669 37.1861111 0.226844 37.1888889 0.233019 37.1916667 0.236106 37.1944444 0.243825 37.1972222 0.248456 37.2000000 0.254631 37.2027778 0.254631 37.2055556 0.259262 37.2083333 0.262350 37.2111111 0.265437 37.2138889 0.270069 37.2166667 0.270069 37.2194444 0.277787 37.2222222 0.279331 37.2250000 0.287050 37.2277778 0.290137 37.2305556 0.293225 37.2333333 0.299400 37.6388889 0.137307 37.6416667 0.134220 37.6444444 0.134220 37.6472222 0.134220 37.6500000 0.134220 37.6527778 0.135763 37.6555556 0.138851 37.6583333 0.138851 37.6611111 0.138851 37.6638889 0.140395 37.6666667 0.141938 37.6694444 0.143482 37.6722222 0.145026 37.6750000 0.141938 37.6777778 0.138851 37.6805556 0.141938 37.6833333 0.140395 37.6861111 0.143482 37.6888889 0.148113 37.6916667 0.154288 37.6944444 0.157376 37.6972222 0.160463 37.7000000 0.158919 37.7027778 0.162007 37.7055556 0.166638 37.7083333 0.163551 37.7111111 0.166638 37.7138889 0.163551 37.7166667 0.166638 37.7194444 0.174357 37.7222222 0.183619 37.7250000 0.189794 37.7277778 0.195969 37.7305556 0.200600 37.7333333 0.202144 37.7361111 0.199057 37.7388889 0.195969 37.7416667 0.188250 37.7444444 0.185163 37.7472222 0.178988 37.7500000 0.174357 37.7527778 0.171269 37.7555556 0.171269 37.7583333 0.169726 37.7611111 0.168182 37.7638889 0.165094 37.7666667 0.155832 37.7694444 0.151201 37.7722222 0.145026 37.7750000 0.138851 37.7777778 0.135763 37.7805556 0.134220 37.7833333 0.131132 37.7861111 0.134220 37.7888889 0.137307 37.7916667 0.134220 37.7944444 0.137307 37.7972222 0.137307 37.8000000 0.137307 37.8027778 0.137307 37.8055556 0.138851 37.8083333 0.134220 37.8111111 0.132676 37.8138889 0.129588 37.8166667 0.129588 37.8194444 0.129588 37.8222222 0.128045 37.8250000 0.126501 37.8277778 0.132676 37.8305556 0.135763 37.8333333 0.135763 37.8361111 0.137307 37.8388889 0.132676 37.8416667 0.132676 37.8444444 0.131132 37.8472222 0.131132 37.8500000 0.124957 37.8527778 0.117238 37.8555556 0.109520 37.8583333 0.090995 37.8611111 0.072470 37.8638889 0.058576 37.8666667 0.061664 37.8694444 0.095626 37.8722222 0.162007 37.8750000 0.248456 37.8777778 0.365780 37.8805556 0.487736 37.8833333 0.595798 37.8861111 0.674528 37.8888889 0.697684 37.8916667 0.648285 37.8944444 0.532504 37.8972222 0.379674 37.9000000 0.234563 37.9027778 0.131132 37.9055556 0.077101 37.9083333 0.063208 37.9111111 0.061664 37.9138889 0.058576 37.9166667 0.047770 37.9194444 0.023070 37.9222222 0.010000 37.9250000 0.010000 37.9277778 0.010000 37.9305556 0.010000 37.9333333 0.010000 37.9361111 0.010000 37.9388889 0.010000 37.9416667 0.010000 37.9444444 0.010000 37.9472222 0.010000 37.9500000 0.010000 37.9527778 0.024614 37.9555556 0.050858 37.9583333 0.072470 37.9611111 0.094082 37.9638889 0.111063 37.9666667 0.115695 37.9694444 0.120326 37.9722222 0.124957 37.9750000 0.128045 37.9777778 0.129588 37.9805556 0.124957 37.9833333 0.132676 37.9861111 0.134220 37.9888889 0.137307 37.9916667 0.138851 37.9944444 0.141938 37.9972222 0.145026 38.0000000 0.146569 38.0027778 0.148113 38.0055556 0.146569 38.0083333 0.146569 38.0111111 0.141938 38.0138889 0.143482 38.0166667 0.145026 38.0194444 0.148113 38.0222222 0.149657 38.0250000 0.152744 38.0277778 0.154288 38.0305556 0.157376 38.0333333 0.154288 38.0361111 0.155832 38.0388889 0.155832 38.0416667 0.152744 38.0444444 0.152744 38.0472222 0.152744 38.0500000 0.151201 38.0527778 0.154288 38.0555556 0.155832 38.0583333 0.162007 38.0611111 0.163551 38.0638889 0.168182 38.0666667 0.168182 38.0694444 0.169726 38.0722222 0.174357 38.0750000 0.171269 38.0777778 0.168182 38.0805556 0.166638 38.0833333 0.168182 38.0861111 0.169726 38.0888889 0.174357 38.0916667 0.178988 38.0944444 0.183619 38.0972222 0.186707 38.1000000 0.186707 38.1027778 0.185163 38.1055556 0.188250 38.1083333 0.191338 38.1111111 0.186707 38.1138889 0.188250 38.1166667 0.191338 38.1194444 0.194425 38.1222222 0.200600 38.1250000 0.206775 38.1277778 0.211407 38.1305556 0.216038 38.1333333 0.216038 38.1361111 0.219125 38.1388889 0.219125 38.1416667 0.225300 38.1444444 0.223756 38.1472222 0.225300 38.1500000 0.228388 38.1527778 0.231475 38.1555556 0.237650 38.1583333 0.240738 38.1611111 0.246913 38.1638889 0.251544 38.1666667 0.259262 38.1694444 0.259262 38.1722222 0.262350 38.1750000 0.266981 38.1777778 0.266981 38.1805556 0.270069 38.1833333 0.271612 38.1861111 0.274700 38.3888889 0.250000)
Vecg2 ecg_in_l1 0 PWL(0.0000000 0.250000 0.2500000 0.271612 0.2527778 0.266981 0.2555556 0.266981 0.2583333 0.268525 0.2611111 0.266981 0.2638889 0.270069 0.2666667 0.268525 0.2694444 0.270069 0.2722222 0.270069 0.2750000 0.273156 0.2777778 0.270069 0.2805556 0.266981 0.2833333 0.270069 0.2861111 0.268525 0.2888889 0.270069 0.2916667 0.270069 0.2944444 0.274700 0.2972222 0.274700 0.3000000 0.280875 0.3027778 0.288593 0.3055556 0.291681 0.3083333 0.297856 0.3111111 0.302487 0.3138889 0.300943 0.3166667 0.294768 0.3194444 0.297856 0.3222222 0.290137 0.3250000 0.288593 0.3277778 0.280875 0.3305556 0.279331 0.3333333 0.279331 0.3361111 0.277787 0.3388889 0.277787 0.3416667 0.276244 0.3444444 0.276244 0.3472222 0.274700 0.3500000 0.274700 0.3527778 0.271612 0.3555556 0.265437 0.3583333 0.260806 0.3611111 0.259262 0.3638889 0.265437 0.3666667 0.270069 0.3694444 0.273156 0.3722222 0.271612 0.3750000 0.270069 0.3777778 0.265437 0.3805556 0.265437 0.3833333 0.260806 0.3861111 0.257719 0.3888889 0.256175 0.3916667 0.256175 0.3944444 0.253087 0.3972222 0.259262 0.4000000 0.259262 0.4027778 0.257719 0.4055556 0.259262 0.4083333 0.262350 0.4111111 0.262350 0.4138889 0.263894 0.4166667 0.262350 0.4194444 0.262350 0.4222222 0.259262 0.4250000 0.256175 0.4277778 0.260806 0.4305556 0.260806 0.4333333 0.262350 0.4361111 0.270069 0.4388889 0.265437 0.4416667 0.273156 0.4444444 0.266981 0.4472222 0.268525 0.4500000 0.265437 0.4527778 0.268525 0.4555556 0.270069 0.4583333 0.273156 0.4611111 0.285506 0.4638889 0.294768 0.4666667 0.310206 0.4694444 0.317925 0.4722222 0.319468 0.4750000 0.313293 0.4777778 0.299400 0.4805556 0.282419 0.4833333 0.263894 0.4861111 0.243825 0.4888889 0.225300 0.4916667 0.216038 0.4944444 0.211407 0.4972222 0.209863 0.5000000 0.217581 0.5027778 0.219125 0.5055556 0.222213 0.5083333 0.234563 0.5111111 0.257719 0.5138889 0.300943 0.5166667 0.358062 0.5194444 0.409005 0.5222222 0.455317 0.5250000 0.493911 0.5277778 0.517067 0.5305556 0.532504 0.5333333 0.544854 0.5361111 0.552573 0.5388889 0.561835 0.5416667 0.555660 0.5444444 0.544854 0.5472222 0.524786 0.5500000 0.498542 0.5527778 0.469211 0.5555556 0.435249 0.5583333 0.401286 0.5611111 0.367324 0.5638889 0.337993 0.5666667 0.317925 0.5694444 0.302487 0.5722222 0.296312 0.5750000 0.293225 0.5777778 0.285506 0.5805556 0.285506 0.5833333 0.283962 0.5861111 0.276244 0.5888889 0.273156 0.5916667 0.266981 0.5944444 0.266981 0.5972222 0.262350 0.6000000 0.266981 0.6027778 0.265437 0.6055556 0.266981 0.6083333 0.266981 0.6111111 0.262350 0.6138889 0.263894 0.6166667 0.260806 0.6194444 0.257719 0.6222222 0.259262 0.6250000 0.259262 0.6277778 0.254631 0.6305556 0.256175 0.6333333 0.260806 0.6361111 0.260806 0.6388889 0.265437 0.6416667 0.263894 0.6444444 0.260806 0.6472222 0.260806 0.6500000 0.259262 0.6527778 0.257719 0.6555556 0.256175 0.6583333 0.254631 0.6611111 0.251544 0.6638889 0.253087 0.6666667 0.254631 0.6694444 0.256175 0.6722222 0.257719 0.6750000 0.259262 0.6777778 0.256175 0.6805556 0.256175 0.6833333 0.253087 0.6861111 0.251544 0.6888889 0.248456 0.6916667 0.248456 0.6944444 0.246913 0.6972222 0.246913 0.7000000 0.250000 0.7027778 0.250000 0.7055556 0.250000 0.7083333 0.251544 0.7111111 0.248456 0.7138889 0.250000 0.7166667 0.246913 0.7194444 0.245369 0.7222222 0.243825 0.7250000 0.237650 0.7277778 0.237650 0.7305556 0.239194 0.7333333 0.237650 0.7361111 0.240738 0.7388889 0.242281 0.7416667 0.242281 0.7444444 0.239194 0.7472222 0.237650 0.7500000 0.239194 0.7527778 0.231475 0.7555556 0.228388 0.7583333 0.231475 0.7611111 0.225300 0.7638889 0.228388 0.7666667 0.225300 0.7694444 0.228388 0.7722222 0.223756 0.7750000 0.228388 0.7777778 0.225300 0.7805556 0.225300 0.7833333 0.222213 0.7861111 0.219125 0.7888889 0.216038 0.7916667 0.212950 0.7944444 0.214494 0.7972222 0.211407 1.2111111 0.283962 1.2138889 0.291681 1.2166667 0.287050 1.2194444 0.283962 1.2222222 0.283962 1.2250000 0.282419 1.2277778 0.287050 1.2305556 0.288593 1.2333333 0.293225 1.2361111 0.294768 1.2388889 0.302487 1.2416667 0.305575 1.2444444 0.310206 1.2472222 0.310206 1.2500000 0.313293 1.2527778 0.313293 1.2555556 0.314837 1.2583333 0.313293 1.2611111 0.311750 1.2638889 0.308662 1.2666667 0.308662 1.2694444 0.311750 1.2722222 0.305575 1.2750000 0.305575 1.2777778 0.304031 1.2805556 0.302487 1.2833333 0.294768 1.2861111 0.291681 1.2888889 0.285506 1.2916667 0.288593 1.2944444 0.285506 1.2972222 0.285506 1.3000000 0.288593 1.3027778 0.283962 1.3055556 0.282419 1.3083333 0.285506 1.3111111 0.282419 1.3138889 0.287050 1.3166667 0.288593 1.3194444 0.287050 1.3222222 0.285506 1.3250000 0.280875 1.3277778 0.277787 1.3305556 0.279331 1.3333333 0.277787 1.3361111 0.280875 1.3388889 0.282419 1.3416667 0.282419 1.3444444 0.282419 1.3472222 0.280875 1.3500000 0.279331 1.3527778 0.282419 1.3555556 0.277787 1.3583333 0.274700 1.3611111 0.277787 1.3638889 0.276244 1.3666667 0.280875 1.3694444 0.283962 1.3722222 0.283962 1.3750000 0.285506 1.3777778 0.287050 1.3805556 0.285506 1.3833333 0.282419 1.3861111 0.282419 1.3888889 0.280875 1.3916667 0.277787 1.3944444 0.279331 1.3972222 0.277787 1.4000000 0.282419 1.4027778 0.282419 1.4055556 0.287050 1.4083333 0.291681 1.4111111 0.293225 1.4138889 0.294768 1.4166667 0.300943 1.4194444 0.310206 1.4222222 0.321012 1.4250000 0.324099 1.4277778 0.327187 1.4305556 0.325643 1.4333333 0.322556 1.4361111 0.314837 1.4388889 0.300943 1.4416667 0.290137 1.4444444 0.268525 1.4472222 0.253087 1.4500000 0.242281 1.4527778 0.231475 1.4555556 0.231475 1.4583333 0.226844 1.4611111 0.229931 1.4638889 0.228388 1.4666667 0.234563 1.4694444 0.248456 1.4722222 0.268525 1.4750000 0.307118 1.4777778 0.356518 1.4805556 0.407461 1.4833333 0.453774 1.4861111 0.489280 1.4888889 0.513979 1.4916667 0.529417 1.4944444 0.541767 1.4972222 0.552573 1.5000000 0.561835 1.5027778 0.569554 1.5055556 0.574185 1.5083333 0.569554 1.5111111 0.555660 1.5138889 0.538679 1.5166667 0.509348 1.5194444 0.487736 1.5222222 0.455317 1.5250000 0.421355 1.5277778 0.390480 1.5305556 0.362693 1.5333333 0.341081 1.5361111 0.324099 1.5388889 0.311750 1.5416667 0.307118 1.5444444 0.305575 1.5472222 0.300943 1.5500000 0.300943 1.5527778 0.296312 1.5555556 0.291681 1.5583333 0.287050 1.5611111 0.283962 1.5638889 0.283962 1.5666667 0.283962 1.5694444 0.285506 1.5722222 0.283962 1.5750000 0.287050 1.5777778 0.285506 1.5805556 0.280875 1.5833333 0.280875 1.5861111 0.279331 1.5888889 0.276244 1.5916667 0.271612 1.5944444 0.266981 1.5972222 0.273156 1.6000000 0.273156 1.6027778 0.276244 1.6055556 0.276244 1.6083333 0.279331 1.6111111 0.276244 1.6138889 0.277787 1.6166667 0.273156 1.6194444 0.270069 1.6222222 0.270069 1.6250000 0.266981 1.6277778 0.268525 1.6305556 0.268525 1.6333333 0.266981 1.6361111 0.268525 1.6388889 0.268525 1.6416667 0.271612 1.6444444 0.268525 1.6472222 0.265437 1.6500000 0.265437 1.6527778 0.263894 1.6555556 0.260806 1.6583333 0.257719 1.6611111 0.259262 1.6638889 0.262350 1.6666667 0.260806 1.6694444 0.262350 1.6722222 0.263894 1.6750000 0.265437 1.6777778 0.262350 1.6805556 0.260806 1.6833333 0.259262 1.6861111 0.257719 1.6888889 0.254631 1.6916667 0.253087 1.6944444 0.253087 1.6972222 0.254631 1.7000000 0.251544 1.7027778 0.251544 1.7055556 0.251544 1.7083333 0.253087 1.7111111 0.251544 1.7138889 0.251544 1.7166667 0.250000 1.7194444 0.245369 1.7222222 0.239194 1.7250000 0.237650 1.7277778 0.233019 1.7305556 0.233019 1.7333333 0.231475 1.7361111 0.237650 1.7388889 0.233019 1.7416667 0.229931 1.7444444 0.229931 1.7472222 0.229931 1.7500000 0.226844 1.7527778 0.226844 1.7555556 0.223756 1.7583333 0.219125 2.1027778 0.296312 2.1055556 0.294768 2.1083333 0.297856 2.1111111 0.297856 2.1138889 0.296312 2.1166667 0.293225 2.1194444 0.293225 2.1222222 0.288593 2.1250000 0.288593 2.1277778 0.288593 2.1305556 0.288593 2.1333333 0.293225 2.1361111 0.299400 2.1388889 0.304031 2.1416667 0.308662 2.1444444 0.310206 2.1472222 0.308662 2.1500000 0.314837 2.1527778 0.313293 2.1555556 0.311750 2.1583333 0.313293 2.1611111 0.313293 2.1638889 0.311750 2.1666667 0.310206 2.1694444 0.305575 2.1722222 0.310206 2.1750000 0.310206 2.1777778 0.313293 2.1805556 0.308662 2.1833333 0.310206 2.1861111 0.305575 2.1888889 0.297856 2.1916667 0.294768 2.1944444 0.293225 2.1972222 0.297856 2.2000000 0.296312 2.2027778 0.296312 2.2055556 0.297856 2.2083333 0.297856 2.2111111 0.294768 2.2138889 0.291681 2.2166667 0.291681 2.2194444 0.294768 2.2222222 0.291681 2.2250000 0.291681 2.2277778 0.288593 2.2305556 0.291681 2.2333333 0.290137 2.2361111 0.290137 2.2388889 0.290137 2.2416667 0.293225 2.2444444 0.293225 2.2472222 0.291681 2.2500000 0.291681 2.2527778 0.287050 2.2555556 0.287050 2.2583333 0.283962 2.2611111 0.285506 2.2638889 0.287050 2.2666667 0.285506 2.2694444 0.288593 2.2722222 0.293225 2.2750000 0.293225 2.2777778 0.293225 2.2805556 0.296312 2.2833333 0.296312 2.2861111 0.291681 2.2888889 0.290137 2.2916667 0.288593 2.2944444 0.290137 2.2972222 0.288593 2.3000000 0.291681 2.3027778 0.294768 2.3055556 0.294768 2.3083333 0.297856 2.3111111 0.302487 2.3138889 0.307118 2.3166667 0.314837 2.3194444 0.324099 2.3222222 0.325643 2.3250000 0.324099 2.3277778 0.322556 2.3305556 0.313293 2.3333333 0.297856 2.3361111 0.274700 2.3388889 0.259262 2.3416667 0.248456 2.3444444 0.240738 2.3472222 0.248456 2.3500000 0.260806 2.3527778 0.270069 2.3555556 0.277787 2.3583333 0.279331 2.3611111 0.279331 2.3638889 0.300943 2.3666667 0.333362 2.3694444 0.373499 2.3722222 0.424443 2.3750000 0.469211 2.3777778 0.503173 2.3805556 0.527873 2.3833333 0.544854 2.3861111 0.555660 2.3888889 0.563379 2.3916667 0.568010 2.3944444 0.569554 2.3972222 0.566467 2.4000000 0.555660 2.4027778 0.537136 2.4055556 0.521698 2.4083333 0.501630 2.4111111 0.470755 2.4138889 0.433705 2.4166667 0.401286 2.4194444 0.365780 2.4222222 0.333362 2.4250000 0.310206 2.4277778 0.299400 2.4305556 0.296312 2.4333333 0.300943 2.4361111 0.302487 2.4388889 0.304031 2.4416667 0.299400 2.4444444 0.296312 2.4472222 0.297856 2.4500000 0.293225 2.4527778 0.282419 2.4555556 0.277787 2.4583333 0.277787 2.4611111 0.277787 2.4638889 0.280875 2.4666667 0.282419 2.4694444 0.283962 2.4722222 0.282419 2.4750000 0.282419 2.4777778 0.283962 2.4805556 0.285506 2.4833333 0.283962 2.4861111 0.277787 2.4888889 0.274700 2.4916667 0.271612 2.4944444 0.266981 2.4972222 0.270069 2.5000000 0.270069 2.5027778 0.273156 2.5055556 0.276244 2.5083333 0.276244 2.5111111 0.282419 2.5138889 0.279331 2.5166667 0.277787 2.5194444 0.271612 2.5222222 0.271612 2.5250000 0.268525 2.5277778 0.266981 2.5305556 0.270069 2.5333333 0.273156 2.5361111 0.274700 2.5388889 0.273156 2.5416667 0.276244 2.5444444 0.276244 2.5472222 0.274700 2.5500000 0.271612 2.5527778 0.266981 2.5555556 0.265437 2.5583333 0.262350 2.5611111 0.260806 2.5638889 0.262350 2.5666667 0.260806 2.5694444 0.260806 2.5722222 0.260806 2.5750000 0.266981 2.5777778 0.263894 2.5805556 0.262350 2.5833333 0.257719 2.5861111 0.257719 2.5888889 0.251544 2.5916667 0.248456 2.5944444 0.248456 2.5972222 0.245369 2.6000000 0.248456 2.6027778 0.248456 2.6055556 0.248456 2.6083333 0.250000 2.6111111 0.248456 2.6138889 0.246913 2.6166667 0.242281 2.6194444 0.240738 2.6222222 0.236106 2.6250000 0.233019 2.6277778 0.231475 2.6305556 0.228388 2.6333333 0.226844 2.6361111 0.228388 2.6388889 0.231475 2.6416667 0.233019 2.6444444 0.236106 2.6472222 0.231475 2.6500000 0.233019 3.8444444 0.283962 3.8472222 0.282419 3.8500000 0.280875 3.8527778 0.283962 3.8555556 0.279331 3.8583333 0.276244 3.8611111 0.273156 3.8638889 0.276244 3.8666667 0.274700 3.8694444 0.277787 3.8722222 0.279331 3.8750000 0.283962 3.8777778 0.288593 3.8805556 0.288593 3.8833333 0.290137 3.8861111 0.288593 3.8888889 0.293225 3.8916667 0.293225 3.8944444 0.299400 3.8972222 0.304031 3.9000000 0.310206 3.9027778 0.314837 3.9055556 0.311750 3.9083333 0.310206 3.9111111 0.311750 3.9138889 0.305575 3.9166667 0.302487 3.9194444 0.291681 3.9222222 0.290137 3.9250000 0.287050 3.9277778 0.283962 3.9305556 0.285506 3.9333333 0.285506 3.9361111 0.283962 3.9388889 0.283962 3.9416667 0.285506 3.9444444 0.287050 3.9472222 0.279331 3.9500000 0.283962 3.9527778 0.274700 3.9555556 0.277787 3.9583333 0.277787 3.9611111 0.274700 3.9638889 0.279331 3.9666667 0.277787 3.9694444 0.277787 3.9722222 0.277787 3.9750000 0.277787 3.9777778 0.276244 3.9805556 0.279331 3.9833333 0.276244 3.9861111 0.276244 3.9888889 0.276244 3.9916667 0.270069 3.9944444 0.273156 3.9972222 0.268525 4.0000000 0.273156 4.0027778 0.276244 4.0055556 0.276244 4.0083333 0.279331 4.0111111 0.279331 4.0138889 0.277787 4.0166667 0.276244 4.0194444 0.274700 4.0222222 0.276244 4.0250000 0.273156 4.0277778 0.276244 4.0305556 0.273156 4.0333333 0.274700 4.0361111 0.276244 4.0388889 0.276244 4.0416667 0.280875 4.0444444 0.287050 4.0472222 0.287050 4.0500000 0.294768 4.0527778 0.299400 4.0555556 0.305575 4.0583333 0.311750 4.0611111 0.313293 4.0638889 0.310206 4.0666667 0.307118 4.0694444 0.302487 4.0722222 0.296312 4.0750000 0.282419 4.0777778 0.266981 4.0805556 0.256175 4.0833333 0.243825 4.0861111 0.229931 4.0888889 0.217581 4.0916667 0.203688 4.0944444 0.189794 4.0972222 0.182075 4.1000000 0.169726 4.1027778 0.169726 4.1055556 0.172813 4.1083333 0.183619 4.1111111 0.194425 4.1138889 0.211407 4.1166667 0.226844 4.1194444 0.236106 4.1222222 0.245369 4.1250000 0.240738 4.1277778 0.245369 4.1305556 0.254631 4.1333333 0.266981 4.1361111 0.276244 4.1388889 0.288593 4.1416667 0.294768 4.1444444 0.296312 4.1472222 0.297856 4.1500000 0.294768 4.1527778 0.291681 4.1555556 0.288593 4.1583333 0.287050 4.1611111 0.288593 4.1638889 0.287050 4.1666667 0.297856 4.1694444 0.296312 4.1722222 0.299400 4.1750000 0.302487 4.1777778 0.304031 4.1805556 0.299400 4.1833333 0.300943 4.1861111 0.297856 4.1888889 0.297856 4.1916667 0.297856 4.1944444 0.296312 4.1972222 0.297856 4.2000000 0.294768 4.2027778 0.300943 4.2055556 0.302487 4.2083333 0.302487 4.2111111 0.307118 4.2138889 0.304031 4.2166667 0.302487 4.2194444 0.304031 4.2222222 0.304031 4.2250000 0.299400 4.2277778 0.297856 4.2305556 0.296312 4.2333333 0.299400 4.2361111 0.300943 4.2388889 0.304031 4.2416667 0.307118 4.2444444 0.308662 4.2472222 0.307118 4.2500000 0.304031 4.2527778 0.307118 4.2555556 0.300943 4.2583333 0.299400 4.2611111 0.297856 4.2638889 0.297856 4.2666667 0.304031 4.2694444 0.305575 4.2722222 0.307118 4.2750000 0.310206 4.2777778 0.310206 4.2805556 0.310206 4.2833333 0.310206 4.2861111 0.307118 4.2888889 0.308662 4.2916667 0.304031 4.2944444 0.305575 4.2972222 0.305575 4.3000000 0.307118 4.3027778 0.308662 4.3055556 0.313293 4.3083333 0.313293 4.3111111 0.314837 4.3138889 0.310206 4.3166667 0.314837 4.3194444 0.313293 4.3222222 0.307118 4.3250000 0.307118 4.3277778 0.304031 4.3305556 0.308662 4.3333333 0.308662 4.3361111 0.311750 4.3388889 0.314837 4.3416667 0.314837 4.3444444 0.317925 4.3472222 0.317925 4.3500000 0.317925 4.3527778 0.316381 4.3555556 0.314837 4.3583333 0.311750 4.3611111 0.310206 4.3638889 0.310206 4.3666667 0.317925 4.3694444 0.316381 4.3722222 0.319468 4.3750000 0.322556 4.3777778 0.321012 4.3805556 0.319468 4.3833333 0.316381 4.3861111 0.313293 4.3888889 0.316381 4.3916667 0.313293 4.7583333 0.293225 4.7611111 0.291681 4.7638889 0.290137 4.7666667 0.294768 4.7694444 0.288593 4.7722222 0.294768 4.7750000 0.291681 4.7777778 0.296312 4.7805556 0.291681 4.7833333 0.296312 4.7861111 0.294768 4.7888889 0.299400 4.7916667 0.297856 4.7944444 0.304031 4.7972222 0.307118 4.8000000 0.310206 4.8027778 0.310206 4.8055556 0.314837 4.8083333 0.317925 4.8111111 0.319468 4.8138889 0.317925 4.8166667 0.317925 4.8194444 0.310206 4.8222222 0.307118 4.8250000 0.305575 4.8277778 0.304031 4.8305556 0.299400 4.8333333 0.297856 4.8361111 0.299400 4.8388889 0.300943 4.8416667 0.300943 4.8444444 0.300943 4.8472222 0.297856 4.8500000 0.300943 4.8527778 0.294768 4.8555556 0.288593 4.8583333 0.283962 4.8611111 0.280875 4.8638889 0.282419 4.8666667 0.293225 4.8694444 0.294768 4.8722222 0.299400 4.8750000 0.297856 4.8777778 0.296312 4.8805556 0.293225 4.8833333 0.291681 4.8861111 0.285506 4.8888889 0.283962 4.8916667 0.285506 4.8944444 0.285506 4.8972222 0.283962 4.9000000 0.283962 4.9027778 0.290137 4.9055556 0.288593 4.9083333 0.288593 4.9111111 0.288593 4.9138889 0.291681 4.9166667 0.294768 4.9194444 0.291681 4.9222222 0.290137 4.9250000 0.287050 4.9277778 0.283962 4.9305556 0.283962 4.9333333 0.287050 4.9361111 0.290137 4.9388889 0.293225 4.9416667 0.291681 4.9444444 0.294768 4.9472222 0.297856 4.9500000 0.293225 4.9527778 0.290137 4.9555556 0.287050 4.9583333 0.288593 4.9611111 0.288593 4.9638889 0.291681 4.9666667 0.294768 4.9694444 0.307118 4.9722222 0.321012 4.9750000 0.328731 4.9777778 0.330274 4.9805556 0.328731 4.9833333 0.322556 4.9861111 0.311750 4.9888889 0.290137 4.9916667 0.271612 4.9944444 0.245369 4.9972222 0.234563 5.0000000 0.233019 5.0027778 0.237650 5.0055556 0.254631 5.0083333 0.270069 5.0111111 0.277787 5.0138889 0.280875 5.0166667 0.279331 5.0194444 0.291681 5.0222222 0.319468 5.0250000 0.365780 5.0277778 0.412093 5.0305556 0.456861 5.0333333 0.487736 5.0361111 0.517067 5.0388889 0.541767 5.0416667 0.557204 5.0444444 0.568010 5.0472222 0.575729 5.0500000 0.583448 5.0527778 0.581904 5.0555556 0.575729 5.0583333 0.561835 5.0611111 0.541767 5.0638889 0.521698 5.0666667 0.498542 5.0694444 0.472298 5.0722222 0.441424 5.0750000 0.409005 5.0777778 0.378130 5.0805556 0.348799 5.0833333 0.331818 5.0861111 0.317925 5.0888889 0.308662 5.0916667 0.305575 5.0944444 0.304031 5.0972222 0.300943 5.1000000 0.300943 5.1027778 0.297856 5.1055556 0.296312 5.1083333 0.293225 5.1111111 0.296312 5.1138889 0.293225 5.1166667 0.294768 5.1194444 0.287050 5.1222222 0.287050 5.1250000 0.285506 5.1277778 0.279331 5.1305556 0.282419 5.1333333 0.282419 5.1361111 0.283962 5.1388889 0.287050 5.1416667 0.287050 5.1444444 0.288593 5.1472222 0.282419 5.1500000 0.279331 5.1527778 0.276244 5.1555556 0.276244 5.1583333 0.274700 5.1611111 0.271612 5.1638889 0.274700 5.1666667 0.273156 5.1694444 0.274700 5.1722222 0.277787 5.1750000 0.280875 5.1777778 0.280875 5.1805556 0.280875 5.1833333 0.277787 5.1861111 0.274700 5.1888889 0.274700 5.1916667 0.271612 5.1944444 0.265437 5.1972222 0.268525 5.2000000 0.270069 5.2027778 0.270069 5.2055556 0.266981 5.2083333 0.270069 5.2111111 0.270069 5.2138889 0.270069 5.2166667 0.270069 5.2194444 0.268525 5.2222222 0.262350 5.2250000 0.260806 5.2277778 0.257719 5.2305556 0.262350 5.2333333 0.260806 5.2361111 0.260806 5.2388889 0.260806 5.2416667 0.260806 5.2444444 0.260806 5.2472222 0.259262 5.2500000 0.257719 5.2527778 0.254631 5.2555556 0.248456 5.2583333 0.245369 5.2611111 0.246913 5.2638889 0.239194 5.2666667 0.239194 5.2694444 0.236106 5.2722222 0.237650 5.2750000 0.237650 5.2777778 0.237650 5.2805556 0.239194 5.2833333 0.237650 5.2861111 0.237650 5.2888889 0.229931 5.2916667 0.225300 5.2944444 0.225300 5.2972222 0.225300 5.3000000 0.223756 5.3027778 0.229931 5.3055556 0.226844 5.5888889 0.307118 5.5916667 0.302487 5.5944444 0.300943 5.5972222 0.299400 5.6000000 0.296312 5.6027778 0.302487 5.6055556 0.300943 5.6083333 0.307118 5.6111111 0.307118 5.6138889 0.307118 5.6166667 0.304031 5.6194444 0.304031 5.6222222 0.299400 5.6250000 0.302487 5.6277778 0.299400 5.6305556 0.302487 5.6333333 0.305575 5.6361111 0.311750 5.6388889 0.313293 5.6416667 0.321012 5.6444444 0.324099 5.6472222 0.324099 5.6500000 0.327187 5.6527778 0.325643 5.6555556 0.322556 5.6583333 0.317925 5.6611111 0.310206 5.6638889 0.313293 5.6666667 0.313293 5.6694444 0.314837 5.6722222 0.311750 5.6750000 0.311750 5.6777778 0.313293 5.6805556 0.307118 5.6833333 0.307118 5.6861111 0.305575 5.6888889 0.302487 5.6916667 0.293225 5.6944444 0.290137 5.6972222 0.285506 5.7000000 0.290137 5.7027778 0.291681 5.7055556 0.296312 5.7083333 0.299400 5.7111111 0.300943 5.7138889 0.296312 5.7166667 0.296312 5.7194444 0.288593 5.7222222 0.290137 5.7250000 0.283962 5.7277778 0.285506 5.7305556 0.287050 5.7333333 0.285506 5.7361111 0.288593 5.7388889 0.291681 5.7416667 0.293225 5.7444444 0.293225 5.7472222 0.290137 5.7500000 0.290137 5.7527778 0.287050 5.7555556 0.287050 5.7583333 0.282419 5.7611111 0.283962 5.7638889 0.287050 5.7666667 0.287050 5.7694444 0.290137 5.7722222 0.285506 5.7750000 0.291681 5.7777778 0.293225 5.7805556 0.290137 5.7833333 0.290137 5.7861111 0.291681 5.7888889 0.293225 5.7916667 0.288593 5.7944444 0.294768 5.7972222 0.296312 5.8000000 0.304031 5.8027778 0.316381 5.8055556 0.324099 5.8083333 0.331818 5.8111111 0.330274 5.8138889 0.328731 5.8166667 0.314837 5.8194444 0.294768 5.8222222 0.268525 5.8250000 0.248456 5.8277778 0.234563 5.8305556 0.228388 5.8333333 0.234563 5.8361111 0.245369 5.8388889 0.253087 5.8416667 0.259262 5.8444444 0.268525 5.8472222 0.290137 5.8500000 0.328731 5.8527778 0.371955 5.8555556 0.424443 5.8583333 0.472298 5.8611111 0.507804 5.8638889 0.530961 5.8666667 0.549485 5.8694444 0.563379 5.8722222 0.578816 5.8750000 0.583448 5.8777778 0.583448 5.8805556 0.574185 5.8833333 0.552573 5.8861111 0.520154 5.8888889 0.492367 5.8916667 0.458405 5.8944444 0.427530 5.8972222 0.392024 5.9000000 0.364237 5.9027778 0.334906 5.9055556 0.324099 5.9083333 0.311750 5.9111111 0.310206 5.9138889 0.302487 5.9166667 0.299400 5.9194444 0.296312 5.9222222 0.290137 5.9250000 0.288593 5.9277778 0.288593 5.9305556 0.283962 5.9333333 0.282419 5.9361111 0.282419 5.9388889 0.282419 5.9416667 0.280875 5.9444444 0.279331 5.9472222 0.283962 5.9500000 0.280875 5.9527778 0.277787 5.9555556 0.277787 5.9583333 0.271612 5.9611111 0.270069 5.9638889 0.271612 5.9666667 0.266981 5.9694444 0.270069 5.9722222 0.270069 5.9750000 0.273156 5.9777778 0.274700 5.9805556 0.271612 5.9833333 0.270069 5.9861111 0.266981 5.9888889 0.266981 5.9916667 0.265437 5.9944444 0.262350 5.9972222 0.262350 6.0000000 0.260806 6.0027778 0.262350 6.0055556 0.265437 6.0083333 0.263894 6.0111111 0.266981 6.0138889 0.263894 6.0166667 0.263894 6.0194444 0.265437 6.0222222 0.259262 6.0250000 0.260806 6.0277778 0.257719 6.0305556 0.256175 6.0333333 0.254631 6.0361111 0.256175 6.0388889 0.257719 6.0416667 0.260806 6.0444444 0.262350 6.0472222 0.257719 6.0500000 0.257719 6.0527778 0.254631 6.0555556 0.253087 6.0583333 0.253087 6.0611111 0.248456 6.0638889 0.243825 6.0666667 0.242281 6.0694444 0.248456 6.0722222 0.246913 6.0750000 0.245369 6.0777778 0.246913 6.0805556 0.240738 6.0833333 0.242281 6.0861111 0.242281 6.0888889 0.239194 6.0916667 0.233019 6.0944444 0.229931 6.0972222 0.228388 6.1000000 0.228388 6.1027778 0.231475 6.1055556 0.229931 6.1083333 0.231475 6.1111111 0.231475 6.1138889 0.231475 6.1166667 0.226844 6.1194444 0.225300 6.1222222 0.226844 6.1250000 0.225300 6.1277778 0.223756 6.1305556 0.217581 6.1333333 0.220669 6.1361111 0.223756 6.5111111 0.291681 6.5138889 0.290137 6.5166667 0.290137 6.5194444 0.285506 6.5222222 0.287050 6.5250000 0.285506 6.5277778 0.285506 6.5305556 0.287050 6.5333333 0.285506 6.5361111 0.290137 6.5388889 0.293225 6.5416667 0.297856 6.5444444 0.297856 6.5472222 0.305575 6.5500000 0.308662 6.5527778 0.310206 6.5555556 0.308662 6.5583333 0.313293 6.5611111 0.314837 6.5638889 0.314837 6.5666667 0.313293 6.5694444 0.313293 6.5722222 0.313293 6.5750000 0.311750 6.5777778 0.313293 6.5805556 0.313293 6.5833333 0.310206 6.5861111 0.302487 6.5888889 0.297856 6.5916667 0.296312 6.5944444 0.293225 6.5972222 0.293225 6.6000000 0.294768 6.6027778 0.293225 6.6055556 0.293225 6.6083333 0.291681 6.6111111 0.293225 6.6138889 0.291681 6.6166667 0.288593 6.6194444 0.290137 6.6222222 0.288593 6.6250000 0.288593 6.6277778 0.288593 6.6305556 0.285506 6.6333333 0.285506 6.6361111 0.285506 6.6388889 0.285506 6.6416667 0.288593 6.6444444 0.291681 6.6472222 0.285506 6.6500000 0.285506 6.6527778 0.285506 6.6555556 0.283962 6.6583333 0.279331 6.6611111 0.282419 6.6638889 0.279331 6.6666667 0.279331 6.6694444 0.283962 6.6722222 0.283962 6.6750000 0.285506 6.6777778 0.290137 6.6805556 0.287050 6.6833333 0.287050 6.6861111 0.287050 6.6888889 0.287050 6.6916667 0.280875 6.6944444 0.280875 6.6972222 0.280875 6.7000000 0.283962 6.7027778 0.287050 6.7055556 0.290137 6.7083333 0.291681 6.7111111 0.297856 6.7138889 0.300943 6.7166667 0.305575 6.7194444 0.314837 6.7222222 0.322556 6.7250000 0.331818 6.7277778 0.333362 6.7305556 0.330274 6.7333333 0.325643 6.7361111 0.317925 6.7388889 0.307118 6.7416667 0.288593 6.7444444 0.274700 6.7472222 0.260806 6.7500000 0.250000 6.7527778 0.245369 6.7555556 0.239194 6.7583333 0.236106 6.7611111 0.236106 6.7638889 0.237650 6.7666667 0.246913 6.7694444 0.263894 6.7722222 0.299400 6.7750000 0.351887 6.7777778 0.410549 6.7805556 0.461492 6.7833333 0.506261 6.7861111 0.529417 6.7888889 0.547942 6.7916667 0.563379 6.7944444 0.572642 6.7972222 0.577273 6.8000000 0.580360 6.8027778 0.580360 6.8055556 0.569554 6.8083333 0.551029 6.8111111 0.527873 6.8138889 0.501630 6.8166667 0.467667 6.8194444 0.435249 6.8222222 0.398199 6.8250000 0.365780 6.8277778 0.342624 6.8305556 0.325643 6.8333333 0.317925 6.8361111 0.313293 6.8388889 0.313293 6.8416667 0.313293 6.8444444 0.310206 6.8472222 0.310206 6.8500000 0.308662 6.8527778 0.302487 6.8555556 0.296312 6.8583333 0.293225 6.8611111 0.290137 6.8638889 0.288593 6.8666667 0.290137 6.8694444 0.293225 6.8722222 0.291681 6.8750000 0.293225 6.8777778 0.291681 6.8805556 0.294768 6.8833333 0.288593 6.8861111 0.290137 6.8888889 0.287050 6.8916667 0.279331 6.8944444 0.279331 6.8972222 0.283962 6.9000000 0.277787 6.9027778 0.279331 6.9055556 0.282419 6.9083333 0.283962 6.9111111 0.283962 6.9138889 0.285506 6.9166667 0.287050 6.9194444 0.285506 6.9222222 0.283962 6.9250000 0.282419 6.9277778 0.277787 6.9305556 0.274700 6.9333333 0.279331 6.9361111 0.277787 6.9388889 0.280875 6.9416667 0.283962 6.9444444 0.283962 6.9472222 0.279331 6.9500000 0.282419 6.9527778 0.277787 6.9555556 0.274700 6.9583333 0.273156 6.9611111 0.273156 6.9638889 0.273156 6.9666667 0.270069 6.9694444 0.274700 6.9722222 0.276244 6.9750000 0.274700 6.9777778 0.276244 6.9805556 0.277787 6.9833333 0.276244 6.9861111 0.271612 6.9888889 0.271612 6.9916667 0.268525 6.9944444 0.263894 6.9972222 0.262350 7.0000000 0.262350 7.0027778 0.268525 7.0055556 0.266981 7.0083333 0.265437 7.0111111 0.268525 7.0138889 0.265437 7.0166667 0.265437 7.0194444 0.259262 7.0222222 0.262350 7.0250000 0.257719 7.0277778 0.250000 7.0305556 0.254631 7.0333333 0.248456 7.0361111 0.250000 7.0388889 0.251544 7.0416667 0.253087 7.0444444 0.250000 7.0472222 0.248456 7.0500000 0.250000 7.0527778 0.245369 7.0555556 0.243825 7.0583333 0.237650 7.4388889 0.300943 7.4416667 0.302487 7.4444444 0.302487 7.4472222 0.300943 7.4500000 0.302487 7.4527778 0.300943 7.4555556 0.302487 7.4583333 0.302487 7.4611111 0.302487 7.4638889 0.302487 7.4666667 0.299400 7.4694444 0.300943 7.4722222 0.304031 7.4750000 0.310206 7.4777778 0.314837 7.4805556 0.316381 7.4833333 0.322556 7.4861111 0.321012 7.4888889 0.325643 7.4916667 0.324099 7.4944444 0.322556 7.4972222 0.324099 7.5000000 0.319468 7.5027778 0.322556 7.5055556 0.322556 7.5083333 0.321012 7.5111111 0.321012 7.5138889 0.322556 7.5166667 0.317925 7.5194444 0.314837 7.5222222 0.307118 7.5250000 0.302487 7.5277778 0.304031 7.5305556 0.300943 7.5333333 0.300943 7.5361111 0.304031 7.5388889 0.304031 7.5416667 0.300943 7.5444444 0.305575 7.5472222 0.307118 7.5500000 0.313293 7.5527778 0.308662 7.5555556 0.311750 7.5583333 0.304031 7.5611111 0.300943 7.5638889 0.297856 7.5666667 0.296312 7.5694444 0.297856 7.5722222 0.299400 7.5750000 0.300943 7.5777778 0.300943 7.5805556 0.300943 7.5833333 0.299400 7.5861111 0.297856 7.5888889 0.293225 7.5916667 0.293225 7.5944444 0.290137 7.5972222 0.290137 7.6000000 0.291681 7.6027778 0.291681 7.6055556 0.297856 7.6083333 0.297856 7.6111111 0.299400 7.6138889 0.299400 7.6166667 0.297856 7.6194444 0.300943 7.6222222 0.299400 7.6250000 0.293225 7.6277778 0.293225 7.6305556 0.290137 7.6333333 0.293225 7.6361111 0.300943 7.6388889 0.300943 7.6416667 0.304031 7.6444444 0.313293 7.6472222 0.319468 7.6500000 0.330274 7.6527778 0.336449 7.6555556 0.342624 7.6583333 0.344168 7.6611111 0.339537 7.6638889 0.325643 7.6666667 0.316381 7.6694444 0.296312 7.6722222 0.279331 7.6750000 0.259262 7.6777778 0.250000 7.6805556 0.243825 7.6833333 0.246913 7.6861111 0.259262 7.6888889 0.263894 7.6916667 0.273156 7.6944444 0.273156 7.6972222 0.277787 7.7000000 0.297856 7.7027778 0.333362 7.7055556 0.384305 7.7083333 0.433705 7.7111111 0.481561 7.7138889 0.513979 7.7166667 0.541767 7.7194444 0.557204 7.7222222 0.563379 7.7250000 0.574185 7.7277778 0.577273 7.7305556 0.583448 7.7333333 0.581904 7.7361111 0.568010 7.7388889 0.557204 7.7416667 0.540223 7.7444444 0.524786 7.7472222 0.500086 7.7500000 0.470755 7.7527778 0.436792 7.7555556 0.401286 7.7583333 0.367324 7.7611111 0.342624 7.7638889 0.325643 7.7666667 0.314837 7.7694444 0.316381 7.7722222 0.314837 7.7750000 0.313293 7.7777778 0.316381 7.7805556 0.310206 7.7833333 0.308662 7.7861111 0.302487 7.7888889 0.299400 7.7916667 0.296312 7.7944444 0.293225 7.7972222 0.287050 7.8000000 0.290137 7.8027778 0.285506 7.8055556 0.288593 7.8083333 0.293225 7.8111111 0.297856 7.8138889 0.296312 7.8166667 0.291681 7.8194444 0.291681 7.8222222 0.287050 7.8250000 0.285506 7.8277778 0.279331 7.8305556 0.282419 7.8333333 0.282419 7.8361111 0.280875 7.8388889 0.285506 7.8416667 0.283962 7.8444444 0.285506 7.8472222 0.288593 7.8500000 0.285506 7.8527778 0.287050 7.8555556 0.283962 7.8583333 0.282419 7.8611111 0.277787 7.8638889 0.279331 7.8666667 0.276244 7.8694444 0.273156 7.8722222 0.279331 7.8750000 0.285506 7.8777778 0.280875 7.8805556 0.279331 7.8833333 0.277787 7.8861111 0.280875 7.8888889 0.273156 7.8916667 0.273156 7.8944444 0.271612 7.8972222 0.271612 7.9000000 0.271612 7.9027778 0.271612 7.9055556 0.271612 7.9083333 0.271612 7.9111111 0.277787 7.9138889 0.274700 7.9166667 0.270069 7.9194444 0.271612 7.9222222 0.266981 7.9250000 0.262350 7.9277778 0.263894 7.9305556 0.260806 7.9333333 0.259262 7.9361111 0.257719 7.9388889 0.259262 7.9416667 0.254631 7.9444444 0.257719 7.9472222 0.260806 7.9500000 0.256175 7.9527778 0.259262 7.9555556 0.250000 7.9583333 0.250000 7.9611111 0.248456 7.9638889 0.246913 7.9666667 0.243825 7.9694444 0.242281 7.9722222 0.243825 7.9750000 0.243825 7.9777778 0.243825 7.9805556 0.240738 7.9833333 0.242281 7.9861111 0.236106 8.2833333 0.305575 8.2861111 0.308662 8.2888889 0.307118 8.2916667 0.304031 8.2944444 0.304031 8.2972222 0.300943 8.3000000 0.304031 8.3027778 0.302487 8.3055556 0.300943 8.3083333 0.305575 8.3111111 0.307118 8.3138889 0.310206 8.3166667 0.308662 8.3194444 0.311750 8.3222222 0.313293 8.3250000 0.311750 8.3277778 0.317925 8.3305556 0.316381 8.3333333 0.321012 8.3361111 0.324099 8.3388889 0.325643 8.3416667 0.325643 8.3444444 0.324099 8.3472222 0.325643 8.3500000 0.325643 8.3527778 0.322556 8.3555556 0.322556 8.3583333 0.314837 8.3611111 0.314837 8.3638889 0.310206 8.3666667 0.308662 8.3694444 0.307118 8.3722222 0.307118 8.3750000 0.310206 8.3777778 0.308662 8.3805556 0.311750 8.3833333 0.307118 8.3861111 0.305575 8.3888889 0.299400 8.3916667 0.302487 8.3944444 0.302487 8.3972222 0.300943 8.4000000 0.297856 8.4027778 0.302487 8.4055556 0.300943 8.4083333 0.297856 8.4111111 0.300943 8.4138889 0.305575 8.4166667 0.302487 8.4194444 0.299400 8.4222222 0.299400 8.4250000 0.299400 8.4277778 0.293225 8.4305556 0.293225 8.4333333 0.293225 8.4361111 0.291681 8.4388889 0.299400 8.4416667 0.299400 8.4444444 0.299400 8.4472222 0.299400 8.4500000 0.300943 8.4527778 0.297856 8.4555556 0.299400 8.4583333 0.296312 8.4611111 0.296312 8.4638889 0.297856 8.4666667 0.296312 8.4694444 0.300943 8.4722222 0.300943 8.4750000 0.307118 8.4777778 0.305575 8.4805556 0.307118 8.4833333 0.307118 8.4861111 0.310206 8.4888889 0.313293 8.4916667 0.314837 8.4944444 0.321012 8.4972222 0.328731 8.5000000 0.339537 8.5027778 0.342624 8.5055556 0.341081 8.5083333 0.331818 8.5111111 0.317925 8.5138889 0.297856 8.5166667 0.276244 8.5194444 0.254631 8.5222222 0.243825 8.5250000 0.246913 8.5277778 0.250000 8.5305556 0.265437 8.5333333 0.268525 8.5361111 0.274700 8.5388889 0.285506 8.5416667 0.300943 8.5444444 0.339537 8.5472222 0.387393 8.5500000 0.439880 8.5527778 0.486192 8.5555556 0.515523 8.5583333 0.540223 8.5611111 0.551029 8.5638889 0.564923 8.5666667 0.574185 8.5694444 0.586535 8.5722222 0.589623 8.5750000 0.591166 8.5777778 0.574185 8.5805556 0.554117 8.5833333 0.526329 8.5861111 0.496998 8.5888889 0.464580 8.5916667 0.429074 8.5944444 0.395111 8.5972222 0.367324 8.6000000 0.345712 8.6027778 0.330274 8.6055556 0.321012 8.6083333 0.321012 8.6111111 0.313293 8.6138889 0.313293 8.6166667 0.313293 8.6194444 0.311750 8.6222222 0.307118 8.6250000 0.300943 8.6277778 0.297856 8.6305556 0.291681 8.6333333 0.293225 8.6361111 0.291681 8.6388889 0.290137 8.6416667 0.290137 8.6444444 0.293225 8.6472222 0.291681 8.6500000 0.293225 8.6527778 0.288593 8.6555556 0.290137 8.6583333 0.280875 8.6611111 0.279331 8.6638889 0.282419 8.6666667 0.285506 8.6694444 0.282419 8.6722222 0.285506 8.6750000 0.287050 8.6777778 0.288593 8.6805556 0.291681 8.6833333 0.288593 8.6861111 0.285506 8.6888889 0.282419 8.6916667 0.282419 8.6944444 0.277787 8.6972222 0.276244 8.7000000 0.277787 8.7027778 0.279331 8.7055556 0.277787 8.7083333 0.279331 8.7111111 0.280875 8.7138889 0.279331 8.7166667 0.279331 8.7194444 0.279331 8.7222222 0.273156 8.7250000 0.273156 8.7277778 0.270069 8.7305556 0.271612 8.7333333 0.270069 8.7361111 0.268525 8.7388889 0.270069 8.7416667 0.271612 8.7444444 0.273156 8.7472222 0.271612 8.7500000 0.270069 8.7527778 0.268525 8.7555556 0.262350 8.7583333 0.262350 8.7611111 0.260806 8.7638889 0.260806 8.7666667 0.257719 8.7694444 0.260806 8.7722222 0.257719 8.7750000 0.259262 8.7777778 0.262350 8.7805556 0.260806 8.7833333 0.259262 8.7861111 0.256175 8.7888889 0.254631 8.7916667 0.251544 8.7944444 0.245369 8.7972222 0.243825 8.8000000 0.242281 8.8027778 0.242281 8.8055556 0.243825 8.8083333 0.246913 8.8111111 0.245369 8.8138889 0.248456 8.8166667 0.243825 8.8194444 0.243825 8.8222222 0.239194 8.8250000 0.234563 8.8277778 0.229931 8.8305556 0.231475 9.1944444 0.305575 9.1972222 0.300943 9.2000000 0.300943 9.2027778 0.300943 9.2055556 0.304031 9.2083333 0.307118 9.2111111 0.308662 9.2138889 0.310206 9.2166667 0.311750 9.2194444 0.311750 9.2222222 0.311750 9.2250000 0.307118 9.2277778 0.307118 9.2305556 0.308662 9.2333333 0.307118 9.2361111 0.305575 9.2388889 0.308662 9.2416667 0.311750 9.2444444 0.316381 9.2472222 0.316381 9.2500000 0.319468 9.2527778 0.324099 9.2555556 0.327187 9.2583333 0.328731 9.2611111 0.331818 9.2638889 0.328731 9.2666667 0.333362 9.2694444 0.331818 9.2722222 0.331818 9.2750000 0.328731 9.2777778 0.327187 9.2805556 0.324099 9.2833333 0.316381 9.2861111 0.317925 9.2888889 0.311750 9.2916667 0.308662 9.2944444 0.304031 9.2972222 0.302487 9.3000000 0.299400 9.3027778 0.300943 9.3055556 0.299400 9.3083333 0.300943 9.3111111 0.305575 9.3138889 0.304031 9.3166667 0.307118 9.3194444 0.308662 9.3222222 0.302487 9.3250000 0.302487 9.3277778 0.296312 9.3305556 0.293225 9.3333333 0.293225 9.3361111 0.297856 9.3388889 0.297856 9.3416667 0.299400 9.3444444 0.300943 9.3472222 0.302487 9.3500000 0.300943 9.3527778 0.302487 9.3555556 0.296312 9.3583333 0.296312 9.3611111 0.293225 9.3638889 0.294768 9.3666667 0.294768 9.3694444 0.297856 9.3722222 0.300943 9.3750000 0.300943 9.3777778 0.304031 9.3805556 0.305575 9.3833333 0.310206 9.3861111 0.302487 9.3888889 0.305575 9.3916667 0.300943 9.3944444 0.302487 9.3972222 0.304031 9.4000000 0.307118 9.4027778 0.319468 9.4055556 0.328731 9.4083333 0.345712 9.4111111 0.353431 9.4138889 0.351887 9.4166667 0.347256 9.4194444 0.336449 9.4222222 0.314837 9.4250000 0.294768 9.4277778 0.276244 9.4305556 0.257719 9.4333333 0.251544 9.4361111 0.248456 9.4388889 0.250000 9.4416667 0.254631 9.4444444 0.257719 9.4472222 0.260806 9.4500000 0.270069 9.4527778 0.294768 9.4555556 0.337993 9.4583333 0.390480 9.4611111 0.441424 9.4638889 0.490823 9.4666667 0.523242 9.4694444 0.547942 9.4722222 0.566467 9.4750000 0.578816 9.4777778 0.586535 9.4805556 0.595798 9.4833333 0.594254 9.4861111 0.589623 9.4888889 0.568010 9.4916667 0.546398 9.4944444 0.518611 9.4972222 0.495455 9.5000000 0.463036 9.5027778 0.432161 9.5055556 0.402830 9.5083333 0.379674 9.5111111 0.361149 9.5138889 0.345712 9.5166667 0.334906 9.5194444 0.330274 9.5222222 0.322556 9.5250000 0.317925 9.5277778 0.313293 9.5305556 0.308662 9.5333333 0.313293 9.5361111 0.311750 9.5388889 0.311750 9.5416667 0.308662 9.5444444 0.310206 9.5472222 0.310206 9.5500000 0.308662 9.5527778 0.305575 9.5555556 0.297856 9.5583333 0.300943 9.5611111 0.297856 9.5638889 0.296312 9.5666667 0.293225 9.5694444 0.294768 9.5722222 0.297856 9.5750000 0.299400 9.5777778 0.300943 9.5805556 0.302487 9.5833333 0.300943 9.5861111 0.299400 9.5888889 0.297856 9.5916667 0.296312 9.5944444 0.294768 9.5972222 0.293225 9.6000000 0.293225 9.6027778 0.294768 9.6055556 0.297856 9.6083333 0.297856 9.6111111 0.297856 9.6138889 0.297856 9.6166667 0.297856 9.6194444 0.299400 9.6222222 0.296312 9.6250000 0.296312 9.6277778 0.293225 9.6305556 0.293225 9.6333333 0.288593 9.6361111 0.291681 9.6388889 0.291681 9.6416667 0.293225 9.6444444 0.290137 9.6472222 0.291681 9.6500000 0.291681 9.6527778 0.290137 9.6555556 0.288593 9.6583333 0.287050 9.6611111 0.282419 9.6638889 0.282419 9.6666667 0.280875 9.6694444 0.285506 9.6722222 0.283962 9.6750000 0.283962 9.6777778 0.283962 9.6805556 0.290137 9.6833333 0.288593 9.6861111 0.285506 9.6888889 0.282419 9.6916667 0.280875 9.6944444 0.276244 9.6972222 0.273156 9.7000000 0.274700 9.7027778 0.276244 9.7055556 0.276244 9.7083333 0.274700 9.7111111 0.270069 9.7138889 0.276244 9.7166667 0.270069 9.7194444 0.268525 9.7222222 0.263894 9.7250000 0.262350 9.7277778 0.260806 9.7305556 0.254631 9.7333333 0.256175 9.7361111 0.250000 9.7388889 0.253087 9.7416667 0.254631 10.1222222 0.314837 10.1250000 0.313293 10.1277778 0.311750 10.1305556 0.307118 10.1333333 0.313293 10.1361111 0.310206 10.1388889 0.308662 10.1416667 0.314837 10.1444444 0.322556 10.1472222 0.322556 10.1500000 0.321012 10.1527778 0.322556 10.1555556 0.321012 10.1583333 0.319468 10.1611111 0.317925 10.1638889 0.324099 10.1666667 0.330274 10.1694444 0.330274 10.1722222 0.336449 10.1750000 0.337993 10.1777778 0.337993 10.1805556 0.344168 10.1833333 0.336449 10.1861111 0.333362 10.1888889 0.331818 10.1916667 0.325643 10.1944444 0.327187 10.1972222 0.321012 10.2000000 0.319468 10.2027778 0.319468 10.2055556 0.316381 10.2083333 0.314837 10.2111111 0.314837 10.2138889 0.319468 10.2166667 0.316381 10.2194444 0.313293 10.2222222 0.311750 10.2250000 0.305575 10.2277778 0.307118 10.2305556 0.310206 10.2333333 0.307118 10.2361111 0.314837 10.2388889 0.310206 10.2416667 0.313293 10.2444444 0.308662 10.2472222 0.308662 10.2500000 0.305575 10.2527778 0.310206 10.2555556 0.305575 10.2583333 0.305575 10.2611111 0.304031 10.2638889 0.304031 10.2666667 0.302487 10.2694444 0.302487 10.2722222 0.304031 10.2750000 0.305575 10.2777778 0.308662 10.2805556 0.313293 10.2833333 0.311750 10.2861111 0.308662 10.2888889 0.307118 10.2916667 0.304031 10.2944444 0.302487 10.2972222 0.300943 10.3000000 0.304031 10.3027778 0.302487 10.3055556 0.305575 10.3083333 0.310206 10.3111111 0.311750 10.3138889 0.316381 10.3166667 0.317925 10.3194444 0.316381 10.3222222 0.319468 10.3250000 0.317925 10.3277778 0.319468 10.3305556 0.327187 10.3333333 0.333362 10.3361111 0.345712 10.3388889 0.348799 10.3416667 0.347256 10.3444444 0.341081 10.3472222 0.333362 10.3500000 0.319468 10.3527778 0.296312 10.3555556 0.277787 10.3583333 0.259262 10.3611111 0.253087 10.3638889 0.253087 10.3666667 0.259262 10.3694444 0.276244 10.3722222 0.291681 10.3750000 0.293225 10.3777778 0.302487 10.3805556 0.307118 10.3833333 0.328731 10.3861111 0.364237 10.3888889 0.407461 10.3916667 0.447599 10.3944444 0.486192 10.3972222 0.512436 10.4000000 0.534048 10.4027778 0.547942 10.4055556 0.563379 10.4083333 0.577273 10.4111111 0.584991 10.4138889 0.595798 10.4166667 0.597341 10.4194444 0.591166 10.4222222 0.578816 10.4250000 0.558748 10.4277778 0.540223 10.4305556 0.520154 10.4333333 0.496998 10.4361111 0.475386 10.4388889 0.452230 10.4416667 0.419811 10.4444444 0.388937 10.4472222 0.367324 10.4500000 0.344168 10.4527778 0.333362 10.4555556 0.325643 10.4583333 0.321012 10.4611111 0.319468 10.4638889 0.316381 10.4666667 0.316381 10.4694444 0.307118 10.4722222 0.308662 10.4750000 0.308662 10.4777778 0.310206 10.4805556 0.311750 10.4833333 0.310206 10.4861111 0.304031 10.4888889 0.300943 10.4916667 0.297856 10.4944444 0.294768 10.4972222 0.294768 10.5000000 0.293225 10.5027778 0.293225 10.5055556 0.294768 10.5083333 0.293225 10.5111111 0.293225 10.5138889 0.299400 10.5166667 0.299400 10.5194444 0.300943 10.5222222 0.294768 10.5250000 0.291681 10.5277778 0.287050 10.5305556 0.287050 10.5333333 0.285506 10.5361111 0.285506 10.5388889 0.283962 10.5416667 0.282419 10.5444444 0.287050 10.5472222 0.288593 10.5500000 0.283962 10.5527778 0.288593 10.5555556 0.283962 10.5583333 0.280875 10.5611111 0.280875 10.5638889 0.276244 10.5666667 0.276244 10.5694444 0.276244 10.5722222 0.277787 10.5750000 0.279331 10.5777778 0.279331 10.5805556 0.280875 10.5833333 0.279331 10.5861111 0.280875 10.5888889 0.276244 10.5916667 0.273156 10.5944444 0.270069 10.5972222 0.268525 10.6000000 0.270069 10.6027778 0.273156 10.6055556 0.273156 10.6083333 0.274700 10.6111111 0.276244 10.6138889 0.277787 10.6166667 0.273156 10.6194444 0.273156 10.6222222 0.265437 10.6250000 0.262350 10.6277778 0.257719 10.6305556 0.260806 10.6333333 0.259262 10.6361111 0.257719 10.6388889 0.257719 10.6416667 0.259262 10.6444444 0.260806 10.6472222 0.259262 10.6500000 0.253087 10.6527778 0.251544 10.6555556 0.251544 10.6583333 0.245369 10.6611111 0.248456 10.6638889 0.245369 10.6666667 0.243825 10.6694444 0.243825 10.9972222 0.302487 11.0000000 0.302487 11.0027778 0.305575 11.0055556 0.304031 11.0083333 0.305575 11.0111111 0.308662 11.0138889 0.311750 11.0166667 0.311750 11.0194444 0.310206 11.0222222 0.310206 11.0250000 0.313293 11.0277778 0.313293 11.0305556 0.313293 11.0333333 0.313293 11.0361111 0.317925 11.0388889 0.322556 11.0416667 0.330274 11.0444444 0.336449 11.0472222 0.336449 11.0500000 0.334906 11.0527778 0.331818 11.0555556 0.328731 11.0583333 0.325643 11.0611111 0.321012 11.0638889 0.317925 11.0666667 0.313293 11.0694444 0.313293 11.0722222 0.314837 11.0750000 0.314837 11.0777778 0.313293 11.0805556 0.314837 11.0833333 0.311750 11.0861111 0.311750 11.0888889 0.305575 11.0916667 0.302487 11.0944444 0.299400 11.0972222 0.296312 11.1000000 0.294768 11.1027778 0.294768 11.1055556 0.300943 11.1083333 0.300943 11.1111111 0.304031 11.1138889 0.304031 11.1166667 0.302487 11.1194444 0.297856 11.1222222 0.291681 11.1250000 0.288593 11.1277778 0.288593 11.1305556 0.287050 11.1333333 0.288593 11.1361111 0.290137 11.1388889 0.291681 11.1416667 0.291681 11.1444444 0.293225 11.1472222 0.296312 11.1500000 0.294768 11.1527778 0.294768 11.1555556 0.293225 11.1583333 0.290137 11.1611111 0.291681 11.1638889 0.288593 11.1666667 0.288593 11.1694444 0.288593 11.1722222 0.290137 11.1750000 0.293225 11.1777778 0.297856 11.1805556 0.299400 11.1833333 0.296312 11.1861111 0.293225 11.1888889 0.294768 11.1916667 0.293225 11.1944444 0.290137 11.1972222 0.290137 11.2000000 0.291681 11.2027778 0.302487 11.2055556 0.308662 11.2083333 0.317925 11.2111111 0.331818 11.2138889 0.348799 11.2166667 0.347256 11.2194444 0.345712 11.2222222 0.336449 11.2250000 0.317925 11.2277778 0.296312 11.2305556 0.273156 11.2333333 0.256175 11.2361111 0.243825 11.2388889 0.239194 11.2416667 0.240738 11.2444444 0.246913 11.2472222 0.248456 11.2500000 0.250000 11.2527778 0.254631 11.2555556 0.266981 11.2583333 0.293225 11.2611111 0.337993 11.2638889 0.393568 11.2666667 0.442967 11.2694444 0.487736 11.2722222 0.521698 11.2750000 0.544854 11.2777778 0.558748 11.2805556 0.574185 11.2833333 0.580360 11.2861111 0.586535 11.2888889 0.581904 11.2916667 0.566467 11.2944444 0.546398 11.2972222 0.517067 11.3000000 0.486192 11.3027778 0.456861 11.3055556 0.424443 11.3083333 0.393568 11.3111111 0.368868 11.3138889 0.344168 11.3166667 0.331818 11.3194444 0.314837 11.3222222 0.307118 11.3250000 0.305575 11.3277778 0.302487 11.3305556 0.296312 11.3333333 0.293225 11.3361111 0.296312 11.3388889 0.294768 11.3416667 0.290137 11.3444444 0.291681 11.3472222 0.293225 11.3500000 0.291681 11.3527778 0.288593 11.3555556 0.287050 11.3583333 0.285506 11.3611111 0.283962 11.3638889 0.282419 11.3666667 0.282419 11.3694444 0.280875 11.3722222 0.280875 11.3750000 0.282419 11.3777778 0.283962 11.3805556 0.285506 11.3833333 0.283962 11.3861111 0.283962 11.3888889 0.283962 11.3916667 0.282419 11.3944444 0.279331 11.3972222 0.279331 11.4000000 0.273156 11.4027778 0.277787 11.4055556 0.276244 11.4083333 0.280875 11.4111111 0.280875 11.4138889 0.277787 11.4166667 0.280875 11.4194444 0.280875 11.4222222 0.279331 11.4250000 0.273156 11.4277778 0.271612 11.4305556 0.273156 11.4333333 0.268525 11.4361111 0.270069 11.4388889 0.268525 11.4416667 0.268525 11.4444444 0.274700 11.4472222 0.274700 11.4500000 0.274700 11.4527778 0.270069 11.4555556 0.273156 11.4583333 0.266981 11.4611111 0.266981 11.4638889 0.263894 11.4666667 0.265437 11.4694444 0.262350 11.4722222 0.263894 11.4750000 0.263894 11.4777778 0.262350 11.4805556 0.265437 11.4833333 0.263894 11.4861111 0.260806 11.4888889 0.259262 11.4916667 0.257719 11.4944444 0.251544 11.4972222 0.250000 11.5000000 0.246913 11.5027778 0.250000 11.5055556 0.248456 11.5083333 0.248456 11.5111111 0.253087 11.5138889 0.251544 11.5166667 0.250000 11.5194444 0.250000 11.5222222 0.246913 11.5250000 0.239194 11.5277778 0.237650 11.5305556 0.234563 11.5333333 0.233019 11.5361111 0.233019 11.5388889 0.236106 11.5416667 0.240738 11.5444444 0.236106 11.9500000 0.311750 11.9527778 0.308662 11.9555556 0.310206 11.9583333 0.307118 11.9611111 0.302487 11.9638889 0.300943 11.9666667 0.302487 11.9694444 0.305575 11.9722222 0.308662 11.9750000 0.310206 11.9777778 0.314837 11.9805556 0.321012 11.9833333 0.322556 11.9861111 0.328731 11.9888889 0.328731 11.9916667 0.328731 11.9944444 0.331818 11.9972222 0.331818 12.0000000 0.334906 12.0027778 0.336449 12.0055556 0.331818 12.0083333 0.331818 12.0111111 0.333362 12.0138889 0.330274 12.0166667 0.324099 12.0194444 0.324099 12.0222222 0.321012 12.0250000 0.316381 12.0277778 0.313293 12.0305556 0.307118 12.0333333 0.304031 12.0361111 0.305575 12.0388889 0.305575 12.0416667 0.307118 12.0444444 0.305575 12.0472222 0.304031 12.0500000 0.304031 12.0527778 0.304031 12.0555556 0.302487 12.0583333 0.304031 12.0611111 0.300943 12.0638889 0.299400 12.0666667 0.291681 12.0694444 0.294768 12.0722222 0.299400 12.0750000 0.296312 12.0777778 0.297856 12.0805556 0.299400 12.0833333 0.300943 12.0861111 0.299400 12.0888889 0.300943 12.0916667 0.296312 12.0944444 0.293225 12.0972222 0.294768 12.1000000 0.293225 12.1027778 0.293225 12.1055556 0.296312 12.1083333 0.299400 12.1111111 0.299400 12.1138889 0.300943 12.1166667 0.304031 12.1194444 0.302487 12.1222222 0.302487 12.1250000 0.302487 12.1277778 0.302487 12.1305556 0.294768 12.1333333 0.293225 12.1361111 0.297856 12.1388889 0.299400 12.1416667 0.302487 12.1444444 0.307118 12.1472222 0.308662 12.1500000 0.311750 12.1527778 0.316381 12.1555556 0.324099 12.1583333 0.336449 12.1611111 0.341081 12.1638889 0.345712 12.1666667 0.342624 12.1694444 0.334906 12.1722222 0.330274 12.1750000 0.321012 12.1777778 0.308662 12.1805556 0.290137 12.1833333 0.276244 12.1861111 0.262350 12.1888889 0.256175 12.1916667 0.248456 12.1944444 0.248456 12.1972222 0.246913 12.2000000 0.246913 12.2027778 0.250000 12.2055556 0.260806 12.2083333 0.282419 12.2111111 0.325643 12.2138889 0.381218 12.2166667 0.435249 12.2194444 0.484648 12.2222222 0.521698 12.2250000 0.543310 12.2277778 0.557204 12.2305556 0.564923 12.2333333 0.575729 12.2361111 0.577273 12.2388889 0.586535 12.2416667 0.581904 12.2444444 0.571098 12.2472222 0.557204 12.2500000 0.534048 12.2527778 0.507804 12.2555556 0.476930 12.2583333 0.442967 12.2611111 0.410549 12.2638889 0.378130 12.2666667 0.359605 12.2694444 0.339537 12.2722222 0.328731 12.2750000 0.321012 12.2777778 0.327187 12.2805556 0.325643 12.2833333 0.319468 12.2861111 0.317925 12.2888889 0.311750 12.2916667 0.307118 12.2944444 0.304031 12.2972222 0.302487 12.3000000 0.296312 12.3027778 0.296312 12.3055556 0.297856 12.3083333 0.294768 12.3111111 0.294768 12.3138889 0.299400 12.3166667 0.297856 12.3194444 0.296312 12.3222222 0.293225 12.3250000 0.293225 12.3277778 0.288593 12.3305556 0.290137 12.3333333 0.290137 12.3361111 0.288593 12.3388889 0.288593 12.3416667 0.294768 12.3444444 0.294768 12.3472222 0.294768 12.3500000 0.293225 12.3527778 0.291681 12.3555556 0.290137 12.3583333 0.285506 12.3611111 0.287050 12.3638889 0.287050 12.3666667 0.283962 12.3694444 0.287050 12.3722222 0.288593 12.3750000 0.283962 12.3777778 0.285506 12.3805556 0.288593 12.3833333 0.287050 12.3861111 0.287050 12.3888889 0.285506 12.3916667 0.282419 12.3944444 0.277787 12.3972222 0.277787 12.4000000 0.274700 12.4027778 0.277787 12.4055556 0.280875 12.4083333 0.280875 12.4111111 0.279331 12.4138889 0.279331 12.4166667 0.283962 12.4194444 0.277787 12.4222222 0.274700 12.4250000 0.271612 12.4277778 0.270069 12.4305556 0.273156 12.4333333 0.274700 12.4361111 0.271612 12.4388889 0.273156 12.4416667 0.271612 12.4444444 0.270069 12.4472222 0.271612 12.4500000 0.273156 12.4527778 0.271612 12.4555556 0.266981 12.4583333 0.265437 12.4611111 0.263894 12.4638889 0.260806 12.4666667 0.262350 12.4694444 0.257719 12.4722222 0.259262 12.4750000 0.262350 12.4777778 0.260806 12.4805556 0.259262 12.4833333 0.257719 12.4861111 0.256175 12.4888889 0.251544 12.4916667 0.251544 12.4944444 0.250000 12.4972222 0.245369 12.9555556 0.302487 12.9583333 0.307118 12.9611111 0.305575 12.9638889 0.300943 12.9666667 0.297856 12.9694444 0.294768 12.9722222 0.299400 12.9750000 0.304031 12.9777778 0.305575 12.9805556 0.308662 12.9833333 0.311750 12.9861111 0.307118 12.9888889 0.310206 12.9916667 0.313293 12.9944444 0.311750 12.9972222 0.313293 13.0000000 0.314837 13.0027778 0.319468 13.0055556 0.321012 13.0083333 0.322556 13.0111111 0.322556 13.0138889 0.322556 13.0166667 0.321012 13.0194444 0.316381 13.0222222 0.311750 13.0250000 0.310206 13.0277778 0.308662 13.0305556 0.305575 13.0333333 0.300943 13.0361111 0.305575 13.0388889 0.304031 13.0416667 0.304031 13.0444444 0.307118 13.0472222 0.305575 13.0500000 0.302487 13.0527778 0.302487 13.0555556 0.299400 13.0583333 0.294768 13.0611111 0.294768 13.0638889 0.297856 13.0666667 0.297856 13.0694444 0.296312 13.0722222 0.296312 13.0750000 0.294768 13.0777778 0.297856 13.0805556 0.293225 13.0833333 0.294768 13.0861111 0.294768 13.0888889 0.296312 13.0916667 0.294768 13.0944444 0.288593 13.0972222 0.283962 13.1000000 0.291681 13.1027778 0.290137 13.1055556 0.293225 13.1083333 0.291681 13.1111111 0.293225 13.1138889 0.296312 13.1166667 0.299400 13.1194444 0.300943 13.1222222 0.300943 13.1250000 0.299400 13.1277778 0.296312 13.1305556 0.293225 13.1333333 0.294768 13.1361111 0.293225 13.1388889 0.293225 13.1416667 0.297856 13.1444444 0.297856 13.1472222 0.300943 13.1500000 0.299400 13.1527778 0.300943 13.1555556 0.304031 13.1583333 0.304031 13.1611111 0.304031 13.1638889 0.313293 13.1666667 0.324099 13.1694444 0.331818 13.1722222 0.336449 13.1750000 0.333362 13.1777778 0.331818 13.1805556 0.321012 13.1833333 0.307118 13.1861111 0.285506 13.1888889 0.263894 13.1916667 0.242281 13.1944444 0.236106 13.1972222 0.236106 13.2000000 0.245369 13.2027778 0.259262 13.2055556 0.271612 13.2083333 0.277787 13.2111111 0.283962 13.2138889 0.290137 13.2166667 0.316381 13.2194444 0.356518 13.2222222 0.398199 13.2250000 0.444511 13.2277778 0.481561 13.2305556 0.509348 13.2333333 0.529417 13.2361111 0.541767 13.2388889 0.555660 13.2416667 0.564923 13.2444444 0.574185 13.2472222 0.583448 13.2500000 0.580360 13.2527778 0.572642 13.2555556 0.557204 13.2583333 0.538679 13.2611111 0.517067 13.2638889 0.492367 13.2666667 0.470755 13.2694444 0.442967 13.2722222 0.404374 13.2750000 0.375043 13.2777778 0.348799 13.2805556 0.330274 13.2833333 0.317925 13.2861111 0.308662 13.2888889 0.310206 13.2916667 0.308662 13.2944444 0.305575 13.2972222 0.300943 13.3000000 0.294768 13.3027778 0.288593 13.3055556 0.290137 13.3083333 0.294768 13.3111111 0.291681 13.3138889 0.294768 13.3166667 0.293225 13.3194444 0.290137 13.3222222 0.288593 13.3250000 0.285506 13.3277778 0.287050 13.3305556 0.287050 13.3333333 0.287050 13.3361111 0.285506 13.3388889 0.287050 13.3416667 0.290137 13.3444444 0.288593 13.3472222 0.288593 13.3500000 0.288593 13.3527778 0.285506 13.3555556 0.283962 13.3583333 0.282419 13.3611111 0.279331 13.3638889 0.277787 13.3666667 0.277787 13.3694444 0.274700 13.3722222 0.276244 13.3750000 0.277787 13.3777778 0.279331 13.3805556 0.282419 13.3833333 0.283962 13.3861111 0.283962 13.3888889 0.279331 13.3916667 0.277787 13.3944444 0.274700 13.3972222 0.274700 13.4000000 0.266981 13.4027778 0.270069 13.4055556 0.266981 13.4083333 0.270069 13.4111111 0.276244 13.4138889 0.276244 13.4166667 0.274700 13.4194444 0.273156 13.4222222 0.271612 13.4250000 0.266981 13.4277778 0.268525 13.4305556 0.265437 13.4333333 0.263894 13.4361111 0.262350 13.4388889 0.263894 13.4416667 0.263894 13.4444444 0.260806 13.4472222 0.262350 13.4500000 0.260806 13.4527778 0.260806 13.4555556 0.262350 13.4583333 0.256175 13.4611111 0.254631 13.4638889 0.251544 13.4666667 0.248456 13.4694444 0.251544 13.4722222 0.250000 13.4750000 0.253087 13.4777778 0.253087 13.4805556 0.253087 13.4833333 0.250000 13.4861111 0.245369 13.4888889 0.242281 13.4916667 0.236106 13.4944444 0.233019 13.4972222 0.231475 13.5000000 0.231475 13.5027778 0.228388 13.8444444 0.290137 13.8472222 0.290137 13.8500000 0.296312 13.8527778 0.294768 13.8555556 0.291681 13.8583333 0.291681 13.8611111 0.288593 13.8638889 0.287050 13.8666667 0.287050 13.8694444 0.287050 13.8722222 0.288593 13.8750000 0.293225 13.8777778 0.296312 13.8805556 0.300943 13.8833333 0.307118 13.8861111 0.307118 13.8888889 0.308662 13.8916667 0.310206 13.8944444 0.307118 13.8972222 0.308662 13.9000000 0.307118 13.9027778 0.302487 13.9055556 0.300943 13.9083333 0.307118 13.9111111 0.308662 13.9138889 0.310206 13.9166667 0.307118 13.9194444 0.304031 13.9222222 0.299400 13.9250000 0.296312 13.9277778 0.293225 13.9305556 0.288593 13.9333333 0.283962 13.9361111 0.288593 13.9388889 0.283962 13.9416667 0.288593 13.9444444 0.285506 13.9472222 0.285506 13.9500000 0.285506 13.9527778 0.287050 13.9555556 0.288593 13.9583333 0.287050 13.9611111 0.282419 13.9638889 0.277787 13.9666667 0.279331 13.9694444 0.274700 13.9722222 0.274700 13.9750000 0.274700 13.9777778 0.279331 13.9805556 0.280875 13.9833333 0.282419 13.9861111 0.276244 13.9888889 0.276244 13.9916667 0.273156 13.9944444 0.270069 13.9972222 0.271612 14.0000000 0.270069 14.0027778 0.270069 14.0055556 0.271612 14.0083333 0.274700 14.0111111 0.274700 14.0138889 0.277787 14.0166667 0.279331 14.0194444 0.280875 14.0222222 0.277787 14.0250000 0.277787 14.0277778 0.276244 14.0305556 0.274700 14.0333333 0.274700 14.0361111 0.274700 14.0388889 0.279331 14.0416667 0.280875 14.0444444 0.280875 14.0472222 0.285506 14.0500000 0.290137 14.0527778 0.296312 14.0555556 0.304031 14.0583333 0.314837 14.0611111 0.319468 14.0638889 0.319468 14.0666667 0.311750 14.0694444 0.304031 14.0722222 0.288593 14.0750000 0.265437 14.0777778 0.246913 14.0805556 0.236106 14.0833333 0.225300 14.0861111 0.220669 14.0888889 0.226844 14.0916667 0.228388 14.0944444 0.228388 14.0972222 0.231475 14.1000000 0.240738 14.1027778 0.262350 14.1055556 0.304031 14.1083333 0.353431 14.1111111 0.410549 14.1138889 0.456861 14.1166667 0.495455 14.1194444 0.517067 14.1222222 0.534048 14.1250000 0.543310 14.1277778 0.555660 14.1305556 0.560292 14.1333333 0.558748 14.1361111 0.552573 14.1388889 0.534048 14.1416667 0.512436 14.1444444 0.484648 14.1472222 0.458405 14.1500000 0.429074 14.1527778 0.398199 14.1555556 0.365780 14.1583333 0.342624 14.1611111 0.316381 14.1638889 0.297856 14.1666667 0.288593 14.1694444 0.285506 14.1722222 0.280875 14.1750000 0.283962 14.1777778 0.280875 14.1805556 0.279331 14.1833333 0.279331 14.1861111 0.277787 14.1888889 0.273156 14.1916667 0.273156 14.1944444 0.265437 14.1972222 0.262350 14.2000000 0.260806 14.2027778 0.260806 14.2055556 0.262350 14.2083333 0.260806 14.2111111 0.265437 14.2138889 0.265437 14.2166667 0.268525 14.2194444 0.266981 14.2222222 0.265437 14.2250000 0.260806 14.2277778 0.257719 14.2305556 0.257719 14.2333333 0.254631 14.2361111 0.256175 14.2388889 0.259262 14.2416667 0.259262 14.2444444 0.262350 14.2472222 0.262350 14.2500000 0.259262 14.2527778 0.257719 14.2555556 0.257719 14.2583333 0.254631 14.2611111 0.253087 14.2638889 0.251544 14.2666667 0.250000 14.2694444 0.251544 14.2722222 0.253087 14.2750000 0.250000 14.2777778 0.253087 14.2805556 0.253087 14.2833333 0.256175 14.2861111 0.250000 14.2888889 0.253087 14.2916667 0.246913 14.2944444 0.248456 14.2972222 0.243825 14.3000000 0.245369 14.3027778 0.242281 14.3055556 0.243825 14.3083333 0.246913 14.3111111 0.246913 14.3138889 0.245369 14.3166667 0.248456 14.3194444 0.240738 14.3222222 0.245369 14.3250000 0.240738 14.3277778 0.237650 14.3305556 0.239194 14.3333333 0.234563 14.3361111 0.233019 14.3388889 0.229931 14.3416667 0.233019 14.3444444 0.234563 14.3472222 0.234563 14.3500000 0.233019 14.3527778 0.229931 14.3555556 0.228388 14.3583333 0.225300 14.3611111 0.222213 14.3638889 0.216038 14.3666667 0.219125 14.3694444 0.217581 14.3722222 0.214494 14.3750000 0.216038 14.3777778 0.214494 14.3805556 0.220669 14.3833333 0.219125 14.3861111 0.219125 14.3888889 0.214494 14.3916667 0.211407 14.8305556 0.273156 14.8333333 0.268525 14.8361111 0.270069 14.8388889 0.270069 14.8416667 0.273156 14.8444444 0.273156 14.8472222 0.274700 14.8500000 0.279331 14.8527778 0.277787 14.8555556 0.277787 14.8583333 0.276244 14.8611111 0.276244 14.8638889 0.268525 14.8666667 0.270069 14.8694444 0.268525 14.8722222 0.274700 14.8750000 0.277787 14.8777778 0.283962 14.8805556 0.287050 14.8833333 0.290137 14.8861111 0.294768 14.8888889 0.297856 14.8916667 0.299400 14.8944444 0.299400 14.8972222 0.294768 14.9000000 0.291681 14.9027778 0.290137 14.9055556 0.285506 14.9083333 0.287050 14.9111111 0.287050 14.9138889 0.283962 14.9166667 0.282419 14.9194444 0.280875 14.9222222 0.282419 14.9250000 0.273156 14.9277778 0.274700 14.9305556 0.268525 14.9333333 0.270069 14.9361111 0.268525 14.9388889 0.263894 14.9416667 0.268525 14.9444444 0.270069 14.9472222 0.276244 14.9500000 0.279331 14.9527778 0.276244 14.9555556 0.277787 14.9583333 0.271612 14.9611111 0.266981 14.9638889 0.262350 14.9666667 0.263894 14.9694444 0.259262 14.9722222 0.263894 14.9750000 0.268525 14.9777778 0.268525 14.9805556 0.266981 14.9833333 0.266981 14.9861111 0.266981 14.9888889 0.266981 14.9916667 0.266981 14.9944444 0.263894 14.9972222 0.257719 15.0000000 0.259262 15.0027778 0.259262 15.0055556 0.260806 15.0083333 0.265437 15.0111111 0.266981 15.0138889 0.266981 15.0166667 0.273156 15.0194444 0.274700 15.0222222 0.273156 15.0250000 0.276244 15.0277778 0.271612 15.0305556 0.274700 15.0333333 0.279331 15.0361111 0.279331 15.0388889 0.290137 15.0416667 0.307118 15.0444444 0.313293 15.0472222 0.321012 15.0500000 0.322556 15.0527778 0.310206 15.0555556 0.299400 15.0583333 0.280875 15.0611111 0.254631 15.0638889 0.236106 15.0666667 0.222213 15.0694444 0.216038 15.0722222 0.214494 15.0750000 0.214494 15.0777778 0.222213 15.0805556 0.225300 15.0833333 0.228388 15.0861111 0.236106 15.0888889 0.260806 15.0916667 0.297856 15.0944444 0.347256 15.0972222 0.396655 15.1000000 0.444511 15.1027778 0.476930 15.1055556 0.504717 15.1083333 0.521698 15.1111111 0.532504 15.1138889 0.540223 15.1166667 0.557204 15.1194444 0.555660 15.1222222 0.551029 15.1250000 0.538679 15.1277778 0.520154 15.1305556 0.498542 15.1333333 0.472298 15.1361111 0.442967 15.1388889 0.415180 15.1416667 0.384305 15.1444444 0.359605 15.1472222 0.331818 15.1500000 0.316381 15.1527778 0.300943 15.1555556 0.296312 15.1583333 0.290137 15.1611111 0.283962 15.1638889 0.280875 15.1666667 0.273156 15.1694444 0.271612 15.1722222 0.274700 15.1750000 0.274700 15.1777778 0.271612 15.1805556 0.274700 15.1833333 0.270069 15.1861111 0.270069 15.1888889 0.268525 15.1916667 0.266981 15.1944444 0.263894 15.1972222 0.262350 15.2000000 0.259262 15.2027778 0.259262 15.2055556 0.262350 15.2083333 0.266981 15.2111111 0.265437 15.2138889 0.266981 15.2166667 0.263894 15.2194444 0.262350 15.2222222 0.262350 15.2250000 0.260806 15.2277778 0.256175 15.2305556 0.256175 15.2333333 0.256175 15.2361111 0.254631 15.2388889 0.256175 15.2416667 0.259262 15.2444444 0.259262 15.2472222 0.260806 15.2500000 0.262350 15.2527778 0.257719 15.2555556 0.262350 15.2583333 0.257719 15.2611111 0.256175 15.2638889 0.251544 15.2666667 0.251544 15.2694444 0.254631 15.2722222 0.250000 15.2750000 0.251544 15.2777778 0.256175 15.2805556 0.260806 15.2833333 0.256175 15.2861111 0.254631 15.2888889 0.253087 15.2916667 0.251544 15.2944444 0.248456 15.2972222 0.245369 15.3000000 0.243825 15.3027778 0.243825 15.3055556 0.243825 15.3083333 0.248456 15.3111111 0.248456 15.3138889 0.246913 15.3166667 0.246913 15.3194444 0.246913 15.3222222 0.242281 15.3250000 0.239194 15.3277778 0.240738 15.3305556 0.239194 15.3333333 0.237650 15.3361111 0.233019 15.3388889 0.234563 15.3416667 0.236106 15.3444444 0.237650 15.3472222 0.236106 15.3500000 0.234563 15.3527778 0.234563 15.3555556 0.231475 15.3583333 0.231475 15.3611111 0.223756 15.3638889 0.223756 15.3666667 0.219125 15.3694444 0.219125 15.3722222 0.219125 15.3750000 0.216038 15.3777778 0.217581 15.8972222 0.257719 15.9000000 0.259262 15.9027778 0.259262 15.9055556 0.262350 15.9083333 0.262350 15.9111111 0.265437 15.9138889 0.266981 15.9166667 0.268525 15.9194444 0.270069 15.9222222 0.268525 15.9250000 0.270069 15.9277778 0.270069 15.9305556 0.271612 15.9333333 0.271612 15.9361111 0.277787 15.9388889 0.277787 15.9416667 0.282419 15.9444444 0.290137 15.9472222 0.287050 15.9500000 0.290137 15.9527778 0.287050 15.9555556 0.283962 15.9583333 0.280875 15.9611111 0.273156 15.9638889 0.271612 15.9666667 0.270069 15.9694444 0.265437 15.9722222 0.268525 15.9750000 0.271612 15.9777778 0.270069 15.9805556 0.268525 15.9833333 0.273156 15.9861111 0.271612 15.9888889 0.270069 15.9916667 0.266981 15.9944444 0.259262 15.9972222 0.256175 16.0000000 0.251544 16.0027778 0.253087 16.0055556 0.251544 16.0083333 0.260806 16.0111111 0.265437 16.0138889 0.266981 16.0166667 0.268525 16.0194444 0.265437 16.0222222 0.262350 16.0250000 0.257719 16.0277778 0.259262 16.0305556 0.257719 16.0333333 0.256175 16.0361111 0.251544 16.0388889 0.250000 16.0416667 0.254631 16.0444444 0.257719 16.0472222 0.260806 16.0500000 0.262350 16.0527778 0.262350 16.0555556 0.257719 16.0583333 0.259262 16.0611111 0.256175 16.0638889 0.253087 16.0666667 0.251544 16.0694444 0.253087 16.0722222 0.257719 16.0750000 0.259262 16.0777778 0.259262 16.0805556 0.259262 16.0833333 0.260806 16.0861111 0.260806 16.0888889 0.260806 16.0916667 0.259262 16.0944444 0.260806 16.0972222 0.260806 16.1000000 0.262350 16.1027778 0.263894 16.1055556 0.277787 16.1083333 0.288593 16.1111111 0.294768 16.1138889 0.305575 16.1166667 0.308662 16.1194444 0.300943 16.1222222 0.287050 16.1250000 0.270069 16.1277778 0.243825 16.1305556 0.223756 16.1333333 0.205232 16.1361111 0.197513 16.1388889 0.202144 16.1416667 0.220669 16.1444444 0.236106 16.1472222 0.245369 16.1500000 0.253087 16.1527778 0.256175 16.1555556 0.266981 16.1583333 0.291681 16.1611111 0.334906 16.1638889 0.384305 16.1666667 0.424443 16.1694444 0.461492 16.1722222 0.489280 16.1750000 0.509348 16.1777778 0.524786 16.1805556 0.538679 16.1833333 0.547942 16.1861111 0.551029 16.1888889 0.547942 16.1916667 0.538679 16.1944444 0.517067 16.1972222 0.495455 16.2000000 0.475386 16.2027778 0.447599 16.2055556 0.413636 16.2083333 0.382762 16.2111111 0.344168 16.2138889 0.317925 16.2166667 0.299400 16.2194444 0.283962 16.2222222 0.279331 16.2250000 0.276244 16.2277778 0.274700 16.2305556 0.271612 16.2333333 0.266981 16.2361111 0.265437 16.2388889 0.263894 16.2416667 0.262350 16.2444444 0.260806 16.2472222 0.262350 16.2500000 0.263894 16.2527778 0.259262 16.2555556 0.257719 16.2583333 0.257719 16.2611111 0.253087 16.2638889 0.251544 16.2666667 0.250000 16.2694444 0.250000 16.2722222 0.251544 16.2750000 0.253087 16.2777778 0.248456 16.2805556 0.250000 16.2833333 0.253087 16.2861111 0.253087 16.2888889 0.251544 16.2916667 0.250000 16.2944444 0.246913 16.2972222 0.245369 16.3000000 0.243825 16.3027778 0.242281 16.3055556 0.243825 16.3083333 0.248456 16.3111111 0.245369 16.3138889 0.246913 16.3166667 0.243825 16.3194444 0.245369 16.3222222 0.246913 16.3250000 0.242281 16.3277778 0.237650 16.3305556 0.237650 16.3333333 0.236106 16.3361111 0.234563 16.3388889 0.237650 16.3416667 0.236106 16.3444444 0.236106 16.3472222 0.240738 16.3500000 0.237650 16.3527778 0.239194 16.3555556 0.237650 16.3583333 0.233019 16.3611111 0.231475 16.3638889 0.229931 16.3666667 0.228388 16.3694444 0.223756 16.3722222 0.225300 16.3750000 0.225300 16.3777778 0.225300 16.3805556 0.226844 16.3833333 0.228388 16.3861111 0.226844 16.3888889 0.223756 16.3916667 0.220669 16.3944444 0.216038 16.3972222 0.212950 16.4000000 0.212950 16.4027778 0.208319 16.4055556 0.209863 16.4083333 0.208319 16.4111111 0.206775 16.4138889 0.206775 16.4166667 0.211407 16.4194444 0.206775 16.4222222 0.205232 16.4250000 0.200600 16.4277778 0.200600 16.4305556 0.197513 16.4333333 0.194425 16.4361111 0.199057 16.4388889 0.197513 16.4416667 0.197513 16.4444444 0.197513 16.7944444 0.259262 16.7972222 0.257719 16.8000000 0.253087 16.8027778 0.251544 16.8055556 0.253087 16.8083333 0.253087 16.8111111 0.256175 16.8138889 0.254631 16.8166667 0.257719 16.8194444 0.256175 16.8222222 0.262350 16.8250000 0.257719 16.8277778 0.257719 16.8305556 0.256175 16.8333333 0.259262 16.8361111 0.262350 16.8388889 0.257719 16.8416667 0.262350 16.8444444 0.266981 16.8472222 0.271612 16.8500000 0.276244 16.8527778 0.279331 16.8555556 0.280875 16.8583333 0.279331 16.8611111 0.273156 16.8638889 0.268525 16.8666667 0.263894 16.8694444 0.263894 16.8722222 0.262350 16.8750000 0.265437 16.8777778 0.262350 16.8805556 0.260806 16.8833333 0.262350 16.8861111 0.259262 16.8888889 0.259262 16.8916667 0.260806 16.8944444 0.251544 16.8972222 0.254631 16.9000000 0.246913 16.9027778 0.245369 16.9055556 0.243825 16.9083333 0.245369 16.9111111 0.250000 16.9138889 0.256175 16.9166667 0.256175 16.9194444 0.256175 16.9222222 0.250000 16.9250000 0.248456 16.9277778 0.246913 16.9305556 0.245369 16.9333333 0.240738 16.9361111 0.245369 16.9388889 0.243825 16.9416667 0.243825 16.9444444 0.248456 16.9472222 0.251544 16.9500000 0.251544 16.9527778 0.251544 16.9555556 0.246913 16.9583333 0.248456 16.9611111 0.243825 16.9638889 0.242281 16.9666667 0.239194 16.9694444 0.240738 16.9722222 0.243825 16.9750000 0.242281 16.9777778 0.245369 16.9805556 0.250000 16.9833333 0.251544 16.9861111 0.248456 16.9888889 0.250000 16.9916667 0.250000 16.9944444 0.246913 16.9972222 0.248456 17.0000000 0.248456 17.0027778 0.254631 17.0055556 0.263894 17.0083333 0.277787 17.0111111 0.294768 17.0138889 0.297856 17.0166667 0.293225 17.0194444 0.282419 17.0222222 0.262350 17.0250000 0.239194 17.0277778 0.216038 17.0305556 0.194425 17.0333333 0.188250 17.0361111 0.188250 17.0388889 0.194425 17.0416667 0.202144 17.0444444 0.208319 17.0472222 0.216038 17.0500000 0.236106 17.0527778 0.273156 17.0555556 0.321012 17.0583333 0.375043 17.0611111 0.424443 17.0638889 0.458405 17.0666667 0.484648 17.0694444 0.501630 17.0722222 0.512436 17.0750000 0.524786 17.0777778 0.527873 17.0805556 0.534048 17.0833333 0.527873 17.0861111 0.507804 17.0888889 0.484648 17.0916667 0.455317 17.0944444 0.422899 17.0972222 0.387393 17.1000000 0.356518 17.1027778 0.324099 17.1055556 0.304031 17.1083333 0.282419 17.1111111 0.271612 17.1138889 0.266981 17.1166667 0.265437 17.1194444 0.260806 17.1222222 0.259262 17.1250000 0.256175 17.1277778 0.248456 17.1305556 0.243825 17.1333333 0.240738 17.1361111 0.239194 17.1388889 0.236106 17.1416667 0.237650 17.1444444 0.237650 17.1472222 0.240738 17.1500000 0.239194 17.1527778 0.239194 17.1555556 0.237650 17.1583333 0.233019 17.1611111 0.231475 17.1638889 0.231475 17.1666667 0.226844 17.1694444 0.229931 17.1722222 0.228388 17.1750000 0.228388 17.1777778 0.233019 17.1805556 0.233019 17.1833333 0.234563 17.1861111 0.234563 17.1888889 0.233019 17.1916667 0.233019 17.1944444 0.229931 17.1972222 0.226844 17.2000000 0.225300 17.2027778 0.222213 17.2055556 0.226844 17.2083333 0.226844 17.2111111 0.223756 17.2138889 0.220669 17.2166667 0.228388 17.2194444 0.229931 17.2222222 0.226844 17.2250000 0.228388 17.2277778 0.223756 17.2305556 0.217581 17.2333333 0.217581 17.2361111 0.214494 17.2388889 0.217581 17.2416667 0.220669 17.2444444 0.219125 17.2472222 0.219125 17.2500000 0.220669 17.2527778 0.220669 17.2555556 0.219125 17.2583333 0.212950 17.2611111 0.216038 17.2638889 0.211407 17.2666667 0.209863 17.2694444 0.208319 17.2722222 0.208319 17.2750000 0.209863 17.2777778 0.209863 17.2805556 0.206775 17.2833333 0.212950 17.2861111 0.211407 17.2888889 0.208319 17.2916667 0.205232 17.2944444 0.202144 17.2972222 0.199057 17.3000000 0.192882 17.3027778 0.192882 17.3055556 0.192882 17.3083333 0.191338 17.3111111 0.194425 17.3138889 0.197513 17.3166667 0.194425 17.3194444 0.192882 17.3222222 0.194425 17.3250000 0.189794 17.3277778 0.186707 17.3305556 0.183619 17.3333333 0.180532 17.3361111 0.182075 17.3388889 0.177444 17.3416667 0.183619 17.7888889 0.256175 17.7916667 0.253087 17.7944444 0.246913 17.7972222 0.250000 17.8000000 0.246913 17.8027778 0.246913 17.8055556 0.248456 17.8083333 0.248456 17.8111111 0.251544 17.8138889 0.256175 17.8166667 0.259262 17.8194444 0.260806 17.8222222 0.265437 17.8250000 0.268525 17.8277778 0.268525 17.8305556 0.270069 17.8333333 0.273156 17.8361111 0.273156 17.8388889 0.273156 17.8416667 0.270069 17.8444444 0.270069 17.8472222 0.266981 17.8500000 0.263894 17.8527778 0.265437 17.8555556 0.262350 17.8583333 0.259262 17.8611111 0.253087 17.8638889 0.250000 17.8666667 0.248456 17.8694444 0.245369 17.8722222 0.245369 17.8750000 0.245369 17.8777778 0.246913 17.8805556 0.246913 17.8833333 0.248456 17.8861111 0.246913 17.8888889 0.246913 17.8916667 0.245369 17.8944444 0.243825 17.8972222 0.246913 17.9000000 0.246913 17.9027778 0.246913 17.9055556 0.245369 17.9083333 0.240738 17.9111111 0.245369 17.9138889 0.242281 17.9166667 0.242281 17.9194444 0.250000 17.9222222 0.242281 17.9250000 0.245369 17.9277778 0.245369 17.9305556 0.240738 17.9333333 0.236106 17.9361111 0.237650 17.9388889 0.233019 17.9416667 0.236106 17.9444444 0.239194 17.9472222 0.242281 17.9500000 0.245369 17.9527778 0.245369 17.9555556 0.243825 17.9583333 0.246913 17.9611111 0.240738 17.9638889 0.240738 17.9666667 0.237650 17.9694444 0.237650 17.9722222 0.239194 17.9750000 0.242281 17.9777778 0.240738 17.9805556 0.246913 17.9833333 0.248456 17.9861111 0.250000 17.9888889 0.253087 17.9916667 0.257719 17.9944444 0.262350 17.9972222 0.273156 18.0000000 0.282419 18.0027778 0.288593 18.0055556 0.285506 18.0083333 0.285506 18.0111111 0.282419 18.0138889 0.270069 18.0166667 0.253087 18.0194444 0.240738 18.0222222 0.217581 18.0250000 0.200600 18.0277778 0.199057 18.0305556 0.189794 18.0333333 0.192882 18.0361111 0.191338 18.0388889 0.191338 18.0416667 0.197513 18.0444444 0.208319 18.0472222 0.225300 18.0500000 0.262350 18.0527778 0.310206 18.0555556 0.359605 18.0583333 0.409005 18.0611111 0.446055 18.0638889 0.472298 18.0666667 0.490823 18.0694444 0.498542 18.0722222 0.510892 18.0750000 0.520154 18.0777778 0.527873 18.0805556 0.532504 18.0833333 0.526329 18.0861111 0.510892 18.0888889 0.490823 18.0916667 0.467667 18.0944444 0.441424 18.0972222 0.412093 18.1000000 0.382762 18.1027778 0.348799 18.1055556 0.322556 18.1083333 0.302487 18.1111111 0.285506 18.1138889 0.276244 18.1166667 0.270069 18.1194444 0.266981 18.1222222 0.259262 18.1250000 0.257719 18.1277778 0.256175 18.1305556 0.246913 18.1333333 0.248456 18.1361111 0.243825 18.1388889 0.243825 18.1416667 0.245369 18.1444444 0.242281 18.1472222 0.245369 18.1500000 0.248456 18.1527778 0.246913 18.1555556 0.242281 18.1583333 0.239194 18.1611111 0.236106 18.1638889 0.236106 18.1666667 0.236106 18.1694444 0.229931 18.1722222 0.233019 18.1750000 0.231475 18.1777778 0.234563 18.1805556 0.234563 18.1833333 0.233019 18.1861111 0.240738 18.1888889 0.234563 18.1916667 0.236106 18.1944444 0.234563 18.1972222 0.229931 18.2000000 0.228388 18.2027778 0.228388 18.2055556 0.231475 18.2083333 0.228388 18.2111111 0.233019 18.2138889 0.231475 18.2166667 0.228388 18.2194444 0.233019 18.2222222 0.234563 18.2250000 0.233019 18.2277778 0.229931 18.2305556 0.228388 18.2333333 0.225300 18.2361111 0.223756 18.2388889 0.226844 18.2416667 0.223756 18.2444444 0.229931 18.2472222 0.225300 18.2500000 0.223756 18.2527778 0.226844 18.2555556 0.223756 18.2583333 0.226844 18.2611111 0.220669 18.2638889 0.217581 18.2666667 0.214494 18.2694444 0.216038 18.2722222 0.214494 18.2750000 0.217581 18.2777778 0.219125 18.2805556 0.219125 18.2833333 0.220669 18.2861111 0.217581 18.2888889 0.216038 18.2916667 0.214494 18.2944444 0.214494 18.2972222 0.206775 18.3000000 0.202144 18.3027778 0.205232 18.3055556 0.203688 18.3083333 0.205232 18.3111111 0.205232 18.3138889 0.202144 18.3166667 0.203688 18.3194444 0.203688 18.3222222 0.200600 18.3250000 0.200600 18.3277778 0.194425 18.3305556 0.189794 18.3333333 0.185163 18.3361111 0.186707 18.7527778 0.248456 18.7555556 0.248456 18.7583333 0.246913 18.7611111 0.243825 18.7638889 0.240738 18.7666667 0.240738 18.7694444 0.242281 18.7722222 0.242281 18.7750000 0.243825 18.7777778 0.246913 18.7805556 0.248456 18.7833333 0.251544 18.7861111 0.256175 18.7888889 0.257719 18.7916667 0.262350 18.7944444 0.260806 18.7972222 0.260806 18.8000000 0.260806 18.8027778 0.262350 18.8055556 0.260806 18.8083333 0.262350 18.8111111 0.262350 18.8138889 0.260806 18.8166667 0.262350 18.8194444 0.263894 18.8222222 0.259262 18.8250000 0.259262 18.8277778 0.257719 18.8305556 0.251544 18.8333333 0.246913 18.8361111 0.243825 18.8388889 0.245369 18.8416667 0.245369 18.8444444 0.245369 18.8472222 0.250000 18.8500000 0.248456 18.8527778 0.248456 18.8555556 0.246913 18.8583333 0.246913 18.8611111 0.250000 18.8638889 0.248456 18.8666667 0.246913 18.8694444 0.245369 18.8722222 0.242281 18.8750000 0.243825 18.8777778 0.240738 18.8805556 0.243825 18.8833333 0.243825 18.8861111 0.245369 18.8888889 0.246913 18.8916667 0.243825 18.8944444 0.243825 18.8972222 0.242281 18.9000000 0.239194 18.9027778 0.236106 18.9055556 0.236106 18.9083333 0.242281 18.9111111 0.245369 18.9138889 0.245369 18.9166667 0.245369 18.9194444 0.248456 18.9222222 0.245369 18.9250000 0.246913 18.9277778 0.243825 18.9305556 0.245369 18.9333333 0.242281 18.9361111 0.242281 18.9388889 0.243825 18.9416667 0.245369 18.9444444 0.246913 18.9472222 0.253087 18.9500000 0.250000 18.9527778 0.253087 18.9555556 0.254631 18.9583333 0.260806 18.9611111 0.262350 18.9638889 0.271612 18.9666667 0.280875 18.9694444 0.282419 18.9722222 0.283962 18.9750000 0.277787 18.9777778 0.268525 18.9805556 0.250000 18.9833333 0.229931 18.9861111 0.209863 18.9888889 0.199057 18.9916667 0.194425 18.9944444 0.202144 18.9972222 0.212950 19.0000000 0.226844 19.0027778 0.233019 19.0055556 0.242281 19.0083333 0.248456 19.0111111 0.277787 19.0138889 0.316381 19.0166667 0.365780 19.0194444 0.413636 19.0222222 0.452230 19.0250000 0.487736 19.0277778 0.498542 19.0305556 0.513979 19.0333333 0.523242 19.0361111 0.527873 19.0388889 0.530961 19.0416667 0.534048 19.0444444 0.524786 19.0472222 0.510892 19.0500000 0.492367 19.0527778 0.473842 19.0555556 0.446055 19.0583333 0.409005 19.0611111 0.373499 19.0638889 0.337993 19.0666667 0.304031 19.0694444 0.282419 19.0722222 0.271612 19.0750000 0.266981 19.0777778 0.266981 19.0805556 0.270069 19.0833333 0.262350 19.0861111 0.265437 19.0888889 0.259262 19.0916667 0.262350 19.0944444 0.254631 19.0972222 0.246913 19.1000000 0.246913 19.1027778 0.243825 19.1055556 0.245369 19.1083333 0.243825 19.1111111 0.243825 19.1138889 0.246913 19.1166667 0.246913 19.1194444 0.245369 19.1222222 0.246913 19.1250000 0.243825 19.1277778 0.240738 19.1305556 0.239194 19.1333333 0.239194 19.1361111 0.239194 19.1388889 0.237650 19.1416667 0.240738 19.1444444 0.243825 19.1472222 0.240738 19.1500000 0.245369 19.1527778 0.245369 19.1555556 0.242281 19.1583333 0.242281 19.1611111 0.239194 19.1638889 0.240738 19.1666667 0.236106 19.1694444 0.233019 19.1722222 0.231475 19.1750000 0.231475 19.1777778 0.234563 19.1805556 0.233019 19.1833333 0.231475 19.1861111 0.234563 19.1888889 0.236106 19.1916667 0.234563 19.1944444 0.231475 19.1972222 0.229931 19.2000000 0.228388 19.2027778 0.222213 19.2055556 0.222213 19.2083333 0.222213 19.2111111 0.222213 19.2138889 0.220669 19.2166667 0.226844 19.2194444 0.228388 19.2222222 0.223756 19.2250000 0.223756 19.2277778 0.219125 19.2305556 0.222213 19.2333333 0.211407 19.2361111 0.209863 19.2388889 0.208319 19.2416667 0.206775 19.2444444 0.209863 19.2472222 0.209863 19.2500000 0.209863 19.2527778 0.208319 19.2555556 0.208319 19.2583333 0.206775 19.2611111 0.202144 19.2638889 0.197513 19.2666667 0.195969 19.2694444 0.191338 19.2722222 0.191338 19.2750000 0.191338 19.2777778 0.195969 19.2805556 0.192882 19.2833333 0.189794 19.2861111 0.191338 19.2888889 0.192882 19.2916667 0.189794 19.2944444 0.188250 19.2972222 0.189794 19.3000000 0.183619 19.6166667 0.259262 19.6194444 0.262350 19.6222222 0.260806 19.6250000 0.260806 19.6277778 0.257719 19.6305556 0.256175 19.6333333 0.254631 19.6361111 0.250000 19.6388889 0.253087 19.6416667 0.254631 19.6444444 0.257719 19.6472222 0.257719 19.6500000 0.260806 19.6527778 0.260806 19.6555556 0.265437 19.6583333 0.266981 19.6611111 0.263894 19.6638889 0.268525 19.6666667 0.268525 19.6694444 0.274700 19.6722222 0.277787 19.6750000 0.280875 19.6777778 0.282419 19.6805556 0.279331 19.6833333 0.280875 19.6861111 0.279331 19.6888889 0.277787 19.6916667 0.273156 19.6944444 0.265437 19.6972222 0.262350 19.7000000 0.256175 19.7027778 0.253087 19.7055556 0.253087 19.7083333 0.253087 19.7111111 0.253087 19.7138889 0.256175 19.7166667 0.254631 19.7194444 0.251544 19.7222222 0.251544 19.7250000 0.251544 19.7277778 0.250000 19.7305556 0.246913 19.7333333 0.248456 19.7361111 0.246913 19.7388889 0.246913 19.7416667 0.246913 19.7444444 0.242281 19.7472222 0.245369 19.7500000 0.246913 19.7527778 0.248456 19.7555556 0.248456 19.7583333 0.245369 19.7611111 0.242281 19.7638889 0.240738 19.7666667 0.237650 19.7694444 0.236106 19.7722222 0.234563 19.7750000 0.236106 19.7777778 0.239194 19.7805556 0.242281 19.7833333 0.243825 19.7861111 0.245369 19.7888889 0.246913 19.7916667 0.246913 19.7944444 0.240738 19.7972222 0.243825 19.8000000 0.243825 19.8027778 0.240738 19.8055556 0.243825 19.8083333 0.243825 19.8111111 0.245369 19.8138889 0.245369 19.8166667 0.248456 19.8194444 0.256175 19.8222222 0.260806 19.8250000 0.266981 19.8277778 0.274700 19.8305556 0.287050 19.8333333 0.290137 19.8361111 0.285506 19.8388889 0.279331 19.8416667 0.266981 19.8444444 0.248456 19.8472222 0.229931 19.8500000 0.214494 19.8527778 0.203688 19.8555556 0.194425 19.8583333 0.200600 19.8611111 0.199057 19.8638889 0.202144 19.8666667 0.205232 19.8694444 0.214494 19.8722222 0.228388 19.8750000 0.271612 19.8777778 0.322556 19.8805556 0.373499 19.8833333 0.421355 19.8861111 0.459949 19.8888889 0.486192 19.8916667 0.503173 19.8944444 0.510892 19.8972222 0.520154 19.9000000 0.527873 19.9027778 0.524786 19.9055556 0.518611 19.9083333 0.503173 19.9111111 0.481561 19.9138889 0.461492 19.9166667 0.439880 19.9194444 0.416724 19.9222222 0.382762 19.9250000 0.353431 19.9277778 0.322556 19.9305556 0.296312 19.9333333 0.279331 19.9361111 0.265437 19.9388889 0.260806 19.9416667 0.254631 19.9444444 0.257719 19.9472222 0.253087 19.9500000 0.254631 19.9527778 0.256175 19.9555556 0.251544 19.9583333 0.246913 19.9611111 0.243825 19.9638889 0.239194 19.9666667 0.237650 19.9694444 0.236106 19.9722222 0.233019 19.9750000 0.233019 19.9777778 0.234563 19.9805556 0.233019 19.9833333 0.234563 19.9861111 0.233019 19.9888889 0.234563 19.9916667 0.233019 19.9944444 0.233019 19.9972222 0.233019 20.0000000 0.231475 20.0027778 0.226844 20.0055556 0.229931 20.0083333 0.226844 20.0111111 0.231475 20.0138889 0.226844 20.0166667 0.228388 20.0194444 0.231475 20.0222222 0.229931 20.0250000 0.228388 20.0277778 0.226844 20.0305556 0.223756 20.0333333 0.222213 20.0361111 0.217581 20.0388889 0.219125 20.0416667 0.222213 20.0444444 0.220669 20.0472222 0.223756 20.0500000 0.225300 20.0527778 0.223756 20.0555556 0.223756 20.0583333 0.223756 20.0611111 0.220669 20.0638889 0.214494 20.0666667 0.214494 20.0694444 0.212950 20.0722222 0.212950 20.0750000 0.216038 20.0777778 0.216038 20.0805556 0.216038 20.0833333 0.220669 20.0861111 0.217581 20.0888889 0.222213 20.0916667 0.220669 20.0944444 0.217581 20.0972222 0.212950 20.1000000 0.208319 20.1027778 0.209863 20.1055556 0.202144 20.1083333 0.205232 20.1111111 0.205232 20.1138889 0.206775 20.1166667 0.208319 20.1194444 0.208319 20.1222222 0.206775 20.1250000 0.203688 20.1277778 0.202144 20.1305556 0.199057 20.1333333 0.197513 20.1361111 0.191338 20.1388889 0.191338 20.1416667 0.194425 20.1444444 0.194425 20.1472222 0.192882 20.1500000 0.194425 20.1527778 0.189794 20.1555556 0.189794 20.1583333 0.191338 20.1611111 0.188250 20.1638889 0.185163 20.5611111 0.245369 20.5638889 0.243825 20.5666667 0.243825 20.5694444 0.242281 20.5722222 0.245369 20.5750000 0.245369 20.5777778 0.248456 20.5805556 0.246913 20.5833333 0.251544 20.5861111 0.251544 20.5888889 0.253087 20.5916667 0.256175 20.5944444 0.262350 20.5972222 0.254631 20.6000000 0.260806 20.6027778 0.263894 20.6055556 0.263894 20.6083333 0.270069 20.6111111 0.268525 20.6138889 0.270069 20.6166667 0.270069 20.6194444 0.265437 20.6222222 0.260806 20.6250000 0.259262 20.6277778 0.253087 20.6305556 0.250000 20.6333333 0.246913 20.6361111 0.246913 20.6388889 0.245369 20.6416667 0.242281 20.6444444 0.245369 20.6472222 0.246913 20.6500000 0.245369 20.6527778 0.245369 20.6555556 0.243825 20.6583333 0.240738 20.6611111 0.239194 20.6638889 0.240738 20.6666667 0.242281 20.6694444 0.242281 20.6722222 0.240738 20.6750000 0.239194 20.6777778 0.237650 20.6805556 0.234563 20.6833333 0.237650 20.6861111 0.242281 20.6888889 0.237650 20.6916667 0.240738 20.6944444 0.234563 20.6972222 0.236106 20.7000000 0.234563 20.7027778 0.229931 20.7055556 0.229931 20.7083333 0.231475 20.7111111 0.231475 20.7138889 0.236106 20.7166667 0.237650 20.7194444 0.239194 20.7222222 0.236106 20.7250000 0.240738 20.7277778 0.236106 20.7305556 0.236106 20.7333333 0.231475 20.7361111 0.233019 20.7388889 0.231475 20.7416667 0.234563 20.7444444 0.236106 20.7472222 0.236106 20.7500000 0.243825 20.7527778 0.245369 20.7555556 0.245369 20.7583333 0.248456 20.7611111 0.251544 20.7638889 0.250000 20.7666667 0.257719 20.7694444 0.268525 20.7722222 0.279331 20.7750000 0.283962 20.7777778 0.285506 20.7805556 0.276244 20.7833333 0.271612 20.7861111 0.257719 20.7888889 0.240738 20.7916667 0.222213 20.7944444 0.206775 20.7972222 0.194425 20.8000000 0.182075 20.8027778 0.188250 20.8055556 0.186707 20.8083333 0.189794 20.8111111 0.191338 20.8138889 0.199057 20.8166667 0.209863 20.8194444 0.226844 20.8222222 0.251544 20.8250000 0.299400 20.8277778 0.350343 20.8305556 0.395111 20.8333333 0.436792 20.8361111 0.463036 20.8388889 0.483105 20.8416667 0.495455 20.8444444 0.509348 20.8472222 0.517067 20.8500000 0.526329 20.8527778 0.527873 20.8555556 0.520154 20.8583333 0.510892 20.8611111 0.487736 20.8638889 0.466123 20.8666667 0.438336 20.8694444 0.407461 20.8722222 0.379674 20.8750000 0.345712 20.8777778 0.324099 20.8805556 0.299400 20.8833333 0.285506 20.8861111 0.276244 20.8888889 0.270069 20.8916667 0.263894 20.8944444 0.262350 20.8972222 0.257719 20.9000000 0.251544 20.9027778 0.248456 20.9055556 0.243825 20.9083333 0.243825 20.9111111 0.245369 20.9138889 0.245369 20.9166667 0.248456 20.9194444 0.246913 20.9222222 0.246913 20.9250000 0.240738 20.9277778 0.243825 20.9305556 0.237650 20.9333333 0.236106 20.9361111 0.233019 20.9388889 0.234563 20.9416667 0.229931 20.9444444 0.231475 20.9472222 0.236106 20.9500000 0.236106 20.9527778 0.239194 20.9555556 0.234563 20.9583333 0.236106 20.9611111 0.233019 20.9638889 0.233019 20.9666667 0.229931 20.9694444 0.228388 20.9722222 0.229931 20.9750000 0.226844 20.9777778 0.231475 20.9805556 0.229931 20.9833333 0.234563 20.9861111 0.236106 20.9888889 0.237650 20.9916667 0.236106 20.9944444 0.234563 20.9972222 0.231475 21.0000000 0.223756 21.0027778 0.225300 21.0055556 0.223756 21.0083333 0.223756 21.0111111 0.222213 21.0138889 0.225300 21.0166667 0.226844 21.0194444 0.231475 21.0222222 0.226844 21.0250000 0.226844 21.0277778 0.223756 21.0305556 0.222213 21.0333333 0.216038 21.0361111 0.217581 21.0388889 0.212950 21.0416667 0.212950 21.0444444 0.216038 21.0472222 0.216038 21.0500000 0.214494 21.0527778 0.222213 21.0555556 0.216038 21.0583333 0.214494 21.0611111 0.211407 21.0638889 0.206775 21.0666667 0.206775 21.0694444 0.203688 21.0722222 0.199057 21.0750000 0.200600 21.0777778 0.200600 21.0805556 0.202144 21.0833333 0.205232 21.0861111 0.200600 21.0888889 0.200600 21.0916667 0.197513 21.0944444 0.199057 21.0972222 0.192882 21.1000000 0.194425 21.1027778 0.192882 21.1055556 0.189794 21.1083333 0.186707 21.5055556 0.248456 21.5083333 0.251544 21.5111111 0.251544 21.5138889 0.254631 21.5166667 0.256175 21.5194444 0.259262 21.5222222 0.259262 21.5250000 0.256175 21.5277778 0.257719 21.5305556 0.253087 21.5333333 0.251544 21.5361111 0.253087 21.5388889 0.250000 21.5416667 0.253087 21.5444444 0.256175 21.5472222 0.265437 21.5500000 0.266981 21.5527778 0.274700 21.5555556 0.273156 21.5583333 0.279331 21.5611111 0.277787 21.5638889 0.277787 21.5666667 0.276244 21.5694444 0.268525 21.5722222 0.266981 21.5750000 0.260806 21.5777778 0.262350 21.5805556 0.260806 21.5833333 0.260806 21.5861111 0.263894 21.5888889 0.262350 21.5916667 0.256175 21.5944444 0.259262 21.5972222 0.257719 21.6000000 0.251544 21.6027778 0.254631 21.6055556 0.251544 21.6083333 0.248456 21.6111111 0.248456 21.6138889 0.248456 21.6166667 0.251544 21.6194444 0.257719 21.6222222 0.260806 21.6250000 0.259262 21.6277778 0.257719 21.6305556 0.254631 21.6333333 0.250000 21.6361111 0.250000 21.6388889 0.245369 21.6416667 0.243825 21.6444444 0.248456 21.6472222 0.246913 21.6500000 0.248456 21.6527778 0.253087 21.6555556 0.248456 21.6583333 0.250000 21.6611111 0.248456 21.6638889 0.243825 21.6666667 0.240738 21.6694444 0.243825 21.6722222 0.240738 21.6750000 0.243825 21.6777778 0.242281 21.6805556 0.248456 21.6833333 0.253087 21.6861111 0.256175 21.6888889 0.256175 21.6916667 0.254631 21.6944444 0.256175 21.6972222 0.251544 21.7000000 0.253087 21.7027778 0.254631 21.7055556 0.254631 21.7083333 0.254631 21.7111111 0.260806 21.7138889 0.270069 21.7166667 0.277787 21.7194444 0.288593 21.7222222 0.293225 21.7250000 0.296312 21.7277778 0.290137 21.7305556 0.280875 21.7333333 0.263894 21.7361111 0.242281 21.7388889 0.220669 21.7416667 0.206775 21.7444444 0.199057 21.7472222 0.205232 21.7500000 0.220669 21.7527778 0.237650 21.7555556 0.245369 21.7583333 0.256175 21.7611111 0.259262 21.7638889 0.271612 21.7666667 0.304031 21.7694444 0.342624 21.7722222 0.393568 21.7750000 0.435249 21.7777778 0.472298 21.7805556 0.498542 21.7833333 0.518611 21.7861111 0.532504 21.7888889 0.538679 21.7916667 0.541767 21.7944444 0.543310 21.7972222 0.537136 21.8000000 0.520154 21.8027778 0.500086 21.8055556 0.478473 21.8083333 0.455317 21.8111111 0.424443 21.8138889 0.390480 21.8166667 0.353431 21.8194444 0.325643 21.8222222 0.299400 21.8250000 0.285506 21.8277778 0.279331 21.8305556 0.276244 21.8333333 0.273156 21.8361111 0.273156 21.8388889 0.271612 21.8416667 0.270069 21.8444444 0.266981 21.8472222 0.266981 21.8500000 0.265437 21.8527778 0.263894 21.8555556 0.262350 21.8583333 0.262350 21.8611111 0.259262 21.8638889 0.256175 21.8666667 0.256175 21.8694444 0.253087 21.8722222 0.251544 21.8750000 0.251544 21.8777778 0.251544 21.8805556 0.251544 21.8833333 0.253087 21.8861111 0.253087 21.8888889 0.253087 21.8916667 0.256175 21.8944444 0.254631 21.8972222 0.250000 21.9000000 0.246913 21.9027778 0.245369 21.9055556 0.242281 21.9083333 0.245369 21.9111111 0.243825 21.9138889 0.245369 21.9166667 0.245369 21.9194444 0.248456 21.9222222 0.248456 21.9250000 0.246913 21.9277778 0.243825 21.9305556 0.240738 21.9333333 0.239194 21.9361111 0.237650 21.9388889 0.233019 21.9416667 0.236106 21.9444444 0.233019 21.9472222 0.237650 21.9500000 0.237650 21.9527778 0.242281 21.9555556 0.240738 21.9583333 0.239194 21.9611111 0.236106 21.9638889 0.233019 21.9666667 0.231475 21.9694444 0.226844 21.9722222 0.228388 21.9750000 0.225300 21.9777778 0.228388 21.9805556 0.228388 21.9833333 0.226844 21.9861111 0.229931 21.9888889 0.226844 21.9916667 0.225300 21.9944444 0.223756 21.9972222 0.216038 22.0000000 0.216038 22.0027778 0.214494 22.0055556 0.209863 22.0083333 0.205232 22.0111111 0.208319 22.0138889 0.208319 22.0166667 0.212950 22.0194444 0.209863 22.0222222 0.209863 22.0250000 0.208319 22.0277778 0.203688 22.0305556 0.197513 22.0333333 0.194425 22.0361111 0.191338 22.0388889 0.194425 22.0416667 0.192882 22.0444444 0.192882 22.0472222 0.192882 22.0500000 0.194425 22.0527778 0.194425 22.3916667 0.256175 22.3944444 0.254631 22.3972222 0.250000 22.4000000 0.248456 22.4027778 0.246913 22.4055556 0.251544 22.4083333 0.250000 22.4111111 0.251544 22.4138889 0.250000 22.4166667 0.253087 22.4194444 0.253087 22.4222222 0.254631 22.4250000 0.259262 22.4277778 0.259262 22.4305556 0.259262 22.4333333 0.260806 22.4361111 0.263894 22.4388889 0.268525 22.4416667 0.271612 22.4444444 0.279331 22.4472222 0.277787 22.4500000 0.279331 22.4527778 0.279331 22.4555556 0.276244 22.4583333 0.274700 22.4611111 0.273156 22.4638889 0.266981 22.4666667 0.262350 22.4694444 0.257719 22.4722222 0.256175 22.4750000 0.254631 22.4777778 0.256175 22.4805556 0.256175 22.4833333 0.253087 22.4861111 0.254631 22.4888889 0.251544 22.4916667 0.251544 22.4944444 0.250000 22.4972222 0.246913 22.5000000 0.245369 22.5027778 0.245369 22.5055556 0.250000 22.5083333 0.246913 22.5111111 0.245369 22.5138889 0.250000 22.5166667 0.245369 22.5194444 0.246913 22.5222222 0.243825 22.5250000 0.248456 22.5277778 0.245369 22.5305556 0.243825 22.5333333 0.239194 22.5361111 0.237650 22.5388889 0.240738 22.5416667 0.239194 22.5444444 0.239194 22.5472222 0.240738 22.5500000 0.242281 22.5527778 0.245369 22.5555556 0.242281 22.5583333 0.239194 22.5611111 0.240738 22.5638889 0.239194 22.5666667 0.237650 22.5694444 0.236106 22.5722222 0.236106 22.5750000 0.234563 22.5777778 0.237650 22.5805556 0.240738 22.5833333 0.240738 22.5861111 0.245369 22.5888889 0.245369 22.5916667 0.246913 22.5944444 0.251544 22.5972222 0.253087 22.6000000 0.260806 22.6027778 0.270069 22.6055556 0.282419 22.6083333 0.287050 22.6111111 0.293225 22.6138889 0.288593 22.6166667 0.274700 22.6194444 0.259262 22.6222222 0.239194 22.6250000 0.220669 22.6277778 0.200600 22.6305556 0.191338 22.6333333 0.192882 22.6361111 0.192882 22.6388889 0.197513 22.6416667 0.202144 22.6444444 0.211407 22.6472222 0.231475 22.6500000 0.263894 22.6527778 0.316381 22.6555556 0.375043 22.6583333 0.422899 22.6611111 0.459949 22.6638889 0.486192 22.6666667 0.503173 22.6694444 0.512436 22.6722222 0.520154 22.6750000 0.526329 22.6777778 0.526329 22.6805556 0.515523 22.6833333 0.496998 22.6861111 0.473842 22.6888889 0.442967 22.6916667 0.407461 22.6944444 0.376587 22.6972222 0.339537 22.7000000 0.310206 22.7027778 0.282419 22.7055556 0.263894 22.7083333 0.260806 22.7111111 0.256175 22.7138889 0.256175 22.7166667 0.257719 22.7194444 0.257719 22.7222222 0.254631 22.7250000 0.248456 22.7277778 0.243825 22.7305556 0.242281 22.7333333 0.237650 22.7361111 0.236106 22.7388889 0.236106 22.7416667 0.233019 22.7444444 0.234563 22.7472222 0.233019 22.7500000 0.236106 22.7527778 0.236106 22.7555556 0.239194 22.7583333 0.234563 22.7611111 0.231475 22.7638889 0.233019 22.7666667 0.231475 22.7694444 0.226844 22.7722222 0.223756 22.7750000 0.226844 22.7777778 0.228388 22.7805556 0.228388 22.7833333 0.231475 22.7861111 0.231475 22.7888889 0.229931 22.7916667 0.228388 22.7944444 0.228388 22.7972222 0.225300 22.8000000 0.223756 22.8027778 0.223756 22.8055556 0.223756 22.8083333 0.220669 22.8111111 0.220669 22.8138889 0.223756 22.8166667 0.225300 22.8194444 0.226844 22.8222222 0.225300 22.8250000 0.225300 22.8277778 0.222213 22.8305556 0.219125 22.8333333 0.217581 22.8361111 0.216038 22.8388889 0.214494 22.8416667 0.212950 22.8444444 0.212950 22.8472222 0.217581 22.8500000 0.217581 22.8527778 0.216038 22.8555556 0.219125 22.8583333 0.217581 22.8611111 0.214494 22.8638889 0.216038 22.8666667 0.212950 22.8694444 0.206775 22.8722222 0.206775 22.8750000 0.203688 22.8777778 0.205232 22.8805556 0.205232 22.8833333 0.206775 22.8861111 0.206775 22.8888889 0.202144 22.8916667 0.203688 22.8944444 0.205232 22.8972222 0.197513 22.9000000 0.195969 22.9027778 0.192882 22.9055556 0.192882 22.9083333 0.188250 22.9111111 0.191338 22.9138889 0.192882 22.9166667 0.192882 22.9194444 0.192882 22.9222222 0.191338 22.9250000 0.185163 22.9277778 0.186707 22.9305556 0.185163 22.9333333 0.180532 22.9361111 0.180532 22.9388889 0.180532 23.3916667 0.243825 23.3944444 0.240738 23.3972222 0.240738 23.4000000 0.239194 23.4027778 0.242281 23.4055556 0.236106 23.4083333 0.237650 23.4111111 0.243825 23.4138889 0.246913 23.4166667 0.251544 23.4194444 0.259262 23.4222222 0.259262 23.4250000 0.262350 23.4277778 0.266981 23.4305556 0.266981 23.4333333 0.270069 23.4361111 0.266981 23.4388889 0.265437 23.4416667 0.260806 23.4444444 0.262350 23.4472222 0.256175 23.4500000 0.257719 23.4527778 0.257719 23.4555556 0.256175 23.4583333 0.254631 23.4611111 0.248456 23.4638889 0.246913 23.4666667 0.240738 23.4694444 0.236106 23.4722222 0.237650 23.4750000 0.239194 23.4777778 0.234563 23.4805556 0.234563 23.4833333 0.234563 23.4861111 0.234563 23.4888889 0.236106 23.4916667 0.242281 23.4944444 0.240738 23.4972222 0.242281 23.5000000 0.239194 23.5027778 0.240738 23.5055556 0.233019 23.5083333 0.233019 23.5111111 0.233019 23.5138889 0.233019 23.5166667 0.236106 23.5194444 0.237650 23.5222222 0.237650 23.5250000 0.236106 23.5277778 0.237650 23.5305556 0.236106 23.5333333 0.229931 23.5361111 0.231475 23.5388889 0.228388 23.5416667 0.228388 23.5444444 0.229931 23.5472222 0.236106 23.5500000 0.234563 23.5527778 0.234563 23.5555556 0.237650 23.5583333 0.237650 23.5611111 0.237650 23.5638889 0.234563 23.5666667 0.234563 23.5694444 0.233019 23.5722222 0.233019 23.5750000 0.234563 23.5777778 0.234563 23.5805556 0.234563 23.5833333 0.239194 23.5861111 0.243825 23.5888889 0.245369 23.5916667 0.250000 23.5944444 0.256175 23.5972222 0.268525 23.6000000 0.276244 23.6027778 0.283962 23.6055556 0.283962 23.6083333 0.279331 23.6111111 0.273156 23.6138889 0.268525 23.6166667 0.251544 23.6194444 0.234563 23.6222222 0.217581 23.6250000 0.203688 23.6277778 0.192882 23.6305556 0.186707 23.6333333 0.185163 23.6361111 0.186707 23.6388889 0.189794 23.6416667 0.194425 23.6444444 0.197513 23.6472222 0.208319 23.6500000 0.243825 23.6527778 0.288593 23.6555556 0.336449 23.6583333 0.388937 23.6611111 0.433705 23.6638889 0.463036 23.6666667 0.483105 23.6694444 0.495455 23.6722222 0.503173 23.6750000 0.512436 23.6777778 0.523242 23.6805556 0.524786 23.6833333 0.523242 23.6861111 0.512436 23.6888889 0.487736 23.6916667 0.467667 23.6944444 0.444511 23.6972222 0.413636 23.7000000 0.382762 23.7027778 0.350343 23.7055556 0.319468 23.7083333 0.297856 23.7111111 0.279331 23.7138889 0.271612 23.7166667 0.270069 23.7194444 0.263894 23.7222222 0.263894 23.7250000 0.259262 23.7277778 0.253087 23.7305556 0.251544 23.7333333 0.248456 23.7361111 0.242281 23.7388889 0.240738 23.7416667 0.237650 23.7444444 0.236106 23.7472222 0.239194 23.7500000 0.240738 23.7527778 0.240738 23.7555556 0.239194 23.7583333 0.233019 23.7611111 0.233019 23.7638889 0.233019 23.7666667 0.228388 23.7694444 0.228388 23.7722222 0.225300 23.7750000 0.228388 23.7777778 0.229931 23.7805556 0.231475 23.7833333 0.228388 23.7861111 0.233019 23.7888889 0.234563 23.7916667 0.229931 23.7944444 0.233019 23.7972222 0.229931 23.8000000 0.226844 23.8027778 0.225300 23.8055556 0.220669 23.8083333 0.223756 23.8111111 0.223756 23.8138889 0.228388 23.8166667 0.225300 23.8194444 0.229931 23.8222222 0.228388 23.8250000 0.229931 23.8277778 0.226844 23.8305556 0.220669 23.8333333 0.216038 23.8361111 0.220669 23.8388889 0.216038 23.8416667 0.212950 23.8444444 0.212950 23.8472222 0.219125 23.8500000 0.219125 23.8527778 0.222213 23.8555556 0.223756 23.8583333 0.220669 23.8611111 0.216038 23.8638889 0.214494 23.8666667 0.211407 23.8694444 0.209863 23.8722222 0.208319 23.8750000 0.205232 23.8777778 0.208319 23.8805556 0.211407 23.8833333 0.209863 23.8861111 0.209863 23.8888889 0.208319 23.8916667 0.209863 23.8944444 0.203688 23.8972222 0.203688 23.9000000 0.199057 23.9027778 0.195969 23.9055556 0.195969 23.9083333 0.195969 23.9111111 0.194425 23.9138889 0.192882 23.9166667 0.192882 23.9194444 0.194425 23.9222222 0.194425 23.9250000 0.191338 23.9277778 0.191338 23.9305556 0.185163 23.9333333 0.183619 23.9361111 0.180532 23.9388889 0.177444 24.3805556 0.234563 24.3833333 0.239194 24.3861111 0.240738 24.3888889 0.242281 24.3916667 0.242281 24.3944444 0.248456 24.3972222 0.240738 24.4000000 0.242281 24.4027778 0.237650 24.4055556 0.237650 24.4083333 0.236106 24.4111111 0.239194 24.4138889 0.242281 24.4166667 0.243825 24.4194444 0.251544 24.4222222 0.256175 24.4250000 0.256175 24.4277778 0.259262 24.4305556 0.265437 24.4333333 0.257719 24.4361111 0.257719 24.4388889 0.254631 24.4416667 0.253087 24.4444444 0.250000 24.4472222 0.254631 24.4500000 0.251544 24.4527778 0.250000 24.4555556 0.254631 24.4583333 0.251544 24.4611111 0.250000 24.4638889 0.246913 24.4666667 0.237650 24.4694444 0.231475 24.4722222 0.233019 24.4750000 0.231475 24.4777778 0.231475 24.4805556 0.229931 24.4833333 0.234563 24.4861111 0.237650 24.4888889 0.239194 24.4916667 0.243825 24.4944444 0.246913 24.4972222 0.243825 24.5000000 0.240738 24.5027778 0.234563 24.5055556 0.233019 24.5083333 0.233019 24.5111111 0.233019 24.5138889 0.234563 24.5166667 0.236106 24.5194444 0.236106 24.5222222 0.240738 24.5250000 0.237650 24.5277778 0.237650 24.5305556 0.231475 24.5333333 0.231475 24.5361111 0.228388 24.5388889 0.226844 24.5416667 0.231475 24.5444444 0.231475 24.5472222 0.236106 24.5500000 0.234563 24.5527778 0.237650 24.5555556 0.237650 24.5583333 0.240738 24.5611111 0.239194 24.5638889 0.236106 24.5666667 0.240738 24.5694444 0.233019 24.5722222 0.233019 24.5750000 0.236106 24.5777778 0.236106 24.5805556 0.237650 24.5833333 0.243825 24.5861111 0.251544 24.5888889 0.257719 24.5916667 0.270069 24.5944444 0.277787 24.5972222 0.282419 24.6000000 0.282419 24.6027778 0.271612 24.6055556 0.260806 24.6083333 0.243825 24.6111111 0.226844 24.6138889 0.206775 24.6166667 0.192882 24.6194444 0.185163 24.6222222 0.192882 24.6250000 0.205232 24.6277778 0.219125 24.6305556 0.231475 24.6333333 0.236106 24.6361111 0.239194 24.6388889 0.259262 24.6416667 0.291681 24.6444444 0.339537 24.6472222 0.390480 24.6500000 0.432161 24.6527778 0.467667 24.6555556 0.490823 24.6583333 0.504717 24.6611111 0.517067 24.6638889 0.524786 24.6666667 0.529417 24.6694444 0.530961 24.6722222 0.521698 24.6750000 0.504717 24.6777778 0.489280 24.6805556 0.467667 24.6833333 0.447599 24.6861111 0.418268 24.6888889 0.387393 24.6916667 0.354974 24.6944444 0.322556 24.6972222 0.293225 24.7000000 0.273156 24.7027778 0.262350 24.7055556 0.253087 24.7083333 0.253087 24.7111111 0.248456 24.7138889 0.248456 24.7166667 0.245369 24.7194444 0.246913 24.7222222 0.250000 24.7250000 0.246913 24.7277778 0.246913 24.7305556 0.240738 24.7333333 0.237650 24.7361111 0.236106 24.7388889 0.234563 24.7416667 0.233019 24.7444444 0.236106 24.7472222 0.229931 24.7500000 0.234563 24.7527778 0.234563 24.7555556 0.236106 24.7583333 0.234563 24.7611111 0.233019 24.7638889 0.226844 24.7666667 0.229931 24.7694444 0.228388 24.7722222 0.223756 24.7750000 0.223756 24.7777778 0.226844 24.7805556 0.228388 24.7833333 0.233019 24.7861111 0.229931 24.7888889 0.233019 24.7916667 0.229931 24.7944444 0.228388 24.7972222 0.225300 24.8000000 0.219125 24.8027778 0.216038 24.8055556 0.214494 24.8083333 0.217581 24.8111111 0.216038 24.8138889 0.219125 24.8166667 0.220669 24.8194444 0.222213 24.8222222 0.220669 24.8250000 0.219125 24.8277778 0.217581 24.8305556 0.216038 24.8333333 0.211407 24.8361111 0.211407 24.8388889 0.211407 24.8416667 0.206775 24.8444444 0.205232 24.8472222 0.206775 24.8500000 0.208319 24.8527778 0.209863 24.8555556 0.206775 24.8583333 0.205232 24.8611111 0.206775 24.8638889 0.205232 24.8666667 0.203688 24.8694444 0.199057 24.8722222 0.194425 24.8750000 0.195969 24.8777778 0.195969 24.8805556 0.197513 24.8833333 0.195969 24.8861111 0.192882 24.8888889 0.191338 24.8916667 0.188250 24.8944444 0.186707 24.8972222 0.183619 24.9000000 0.185163 24.9027778 0.180532 24.9055556 0.175901 24.9083333 0.175901 24.9111111 0.174357 24.9138889 0.178988 24.9166667 0.180532 24.9194444 0.178988 24.9222222 0.178988 24.9250000 0.178988 24.9277778 0.180532 25.2944444 0.251544 25.2972222 0.251544 25.3000000 0.248456 25.3027778 0.243825 25.3055556 0.245369 25.3083333 0.245369 25.3111111 0.245369 25.3138889 0.246913 25.3166667 0.250000 25.3194444 0.250000 25.3222222 0.253087 25.3250000 0.253087 25.3277778 0.257719 25.3305556 0.256175 25.3333333 0.256175 25.3361111 0.257719 25.3388889 0.259262 25.3416667 0.266981 25.3444444 0.263894 25.3472222 0.268525 25.3500000 0.262350 25.3527778 0.262350 25.3555556 0.265437 25.3583333 0.262350 25.3611111 0.260806 25.3638889 0.254631 25.3666667 0.253087 25.3694444 0.248456 25.3722222 0.248456 25.3750000 0.245369 25.3777778 0.246913 25.3805556 0.245369 25.3833333 0.246913 25.3861111 0.248456 25.3888889 0.243825 25.3916667 0.246913 25.3944444 0.243825 25.3972222 0.243825 25.4000000 0.242281 25.4027778 0.242281 25.4055556 0.243825 25.4083333 0.239194 25.4111111 0.237650 25.4138889 0.242281 25.4166667 0.242281 25.4194444 0.242281 25.4222222 0.245369 25.4250000 0.242281 25.4277778 0.240738 25.4305556 0.237650 25.4333333 0.233019 25.4361111 0.233019 25.4388889 0.234563 25.4416667 0.234563 25.4444444 0.233019 25.4472222 0.236106 25.4500000 0.234563 25.4527778 0.237650 25.4555556 0.239194 25.4583333 0.242281 25.4611111 0.240738 25.4638889 0.239194 25.4666667 0.236106 25.4694444 0.233019 25.4722222 0.237650 25.4750000 0.234563 25.4777778 0.234563 25.4805556 0.233019 25.4833333 0.237650 25.4861111 0.242281 25.4888889 0.245369 25.4916667 0.243825 25.4944444 0.246913 25.4972222 0.250000 25.5000000 0.253087 25.5027778 0.262350 25.5055556 0.270069 25.5083333 0.280875 25.5111111 0.283962 25.5138889 0.280875 25.5166667 0.273156 25.5194444 0.260806 25.5222222 0.240738 25.5250000 0.217581 25.5277778 0.200600 25.5305556 0.186707 25.5333333 0.180532 25.5361111 0.177444 25.5388889 0.183619 25.5416667 0.194425 25.5444444 0.197513 25.5472222 0.202144 25.5500000 0.220669 25.5527778 0.248456 25.5555556 0.294768 25.5583333 0.339537 25.5611111 0.392024 25.5638889 0.432161 25.5666667 0.459949 25.5694444 0.476930 25.5722222 0.493911 25.5750000 0.504717 25.5777778 0.517067 25.5805556 0.524786 25.5833333 0.530961 25.5861111 0.529417 25.5888889 0.517067 25.5916667 0.490823 25.5944444 0.467667 25.5972222 0.441424 25.6000000 0.407461 25.6027778 0.381218 25.6055556 0.350343 25.6083333 0.325643 25.6111111 0.300943 25.6138889 0.282419 25.6166667 0.270069 25.6194444 0.259262 25.6222222 0.251544 25.6250000 0.251544 25.6277778 0.248456 25.6305556 0.245369 25.6333333 0.240738 25.6361111 0.231475 25.6388889 0.234563 25.6416667 0.229931 25.6444444 0.225300 25.6472222 0.228388 25.6500000 0.231475 25.6527778 0.231475 25.6555556 0.236106 25.6583333 0.233019 25.6611111 0.228388 25.6638889 0.226844 25.6666667 0.222213 25.6694444 0.222213 25.6722222 0.219125 25.6750000 0.217581 25.6777778 0.219125 25.6805556 0.220669 25.6833333 0.222213 25.6861111 0.222213 25.6888889 0.223756 25.6916667 0.223756 25.6944444 0.223756 25.6972222 0.220669 25.7000000 0.220669 25.7027778 0.217581 25.7055556 0.216038 25.7083333 0.217581 25.7111111 0.214494 25.7138889 0.217581 25.7166667 0.217581 25.7194444 0.220669 25.7222222 0.222213 25.7250000 0.217581 25.7277778 0.216038 25.7305556 0.219125 25.7333333 0.212950 25.7361111 0.212950 25.7388889 0.211407 25.7416667 0.209863 25.7444444 0.206775 25.7472222 0.209863 25.7500000 0.211407 25.7527778 0.211407 25.7555556 0.212950 25.7583333 0.209863 25.7611111 0.212950 25.7638889 0.208319 25.7666667 0.203688 25.7694444 0.200600 25.7722222 0.200600 25.7750000 0.199057 25.7777778 0.199057 25.7805556 0.203688 25.7833333 0.205232 25.7861111 0.208319 25.7888889 0.205232 25.7916667 0.203688 25.7944444 0.202144 25.7972222 0.197513 25.8000000 0.200600 25.8027778 0.191338 25.8055556 0.191338 25.8083333 0.186707 25.8111111 0.189794 25.8138889 0.188250 25.8166667 0.192882 25.8194444 0.191338 25.8222222 0.192882 25.8250000 0.191338 25.8277778 0.188250 25.8305556 0.185163 25.8333333 0.182075 25.8361111 0.183619 25.8388889 0.183619 25.8416667 0.178988 26.2833333 0.243825 26.2861111 0.243825 26.2888889 0.246913 26.2916667 0.240738 26.2944444 0.243825 26.2972222 0.243825 26.3000000 0.240738 26.3027778 0.243825 26.3055556 0.246913 26.3083333 0.245369 26.3111111 0.250000 26.3138889 0.254631 26.3166667 0.259262 26.3194444 0.262350 26.3222222 0.266981 26.3250000 0.271612 26.3277778 0.270069 26.3305556 0.266981 26.3333333 0.263894 26.3361111 0.260806 26.3388889 0.257719 26.3416667 0.253087 26.3444444 0.253087 26.3472222 0.248456 26.3500000 0.250000 26.3527778 0.250000 26.3555556 0.248456 26.3583333 0.248456 26.3611111 0.243825 26.3638889 0.246913 26.3666667 0.240738 26.3694444 0.240738 26.3722222 0.236106 26.3750000 0.234563 26.3777778 0.234563 26.3805556 0.237650 26.3833333 0.239194 26.3861111 0.243825 26.3888889 0.243825 26.3916667 0.245369 26.3944444 0.242281 26.3972222 0.240738 26.4000000 0.239194 26.4027778 0.236106 26.4055556 0.233019 26.4083333 0.233019 26.4111111 0.234563 26.4138889 0.234563 26.4166667 0.233019 26.4194444 0.236106 26.4222222 0.239194 26.4250000 0.239194 26.4277778 0.234563 26.4305556 0.233019 26.4333333 0.234563 26.4361111 0.234563 26.4388889 0.231475 26.4416667 0.233019 26.4444444 0.228388 26.4472222 0.231475 26.4500000 0.236106 26.4527778 0.242281 26.4555556 0.243825 26.4583333 0.242281 26.4611111 0.243825 26.4638889 0.240738 26.4666667 0.239194 26.4694444 0.236106 26.4722222 0.236106 26.4750000 0.237650 26.4777778 0.237650 26.4805556 0.240738 26.4833333 0.248456 26.4861111 0.256175 26.4888889 0.268525 26.4916667 0.276244 26.4944444 0.285506 26.4972222 0.288593 26.5000000 0.283962 26.5027778 0.277787 26.5055556 0.268525 26.5083333 0.256175 26.5111111 0.236106 26.5138889 0.225300 26.5166667 0.206775 26.5194444 0.197513 26.5222222 0.197513 26.5250000 0.194425 26.5277778 0.199057 26.5305556 0.199057 26.5333333 0.200600 26.5361111 0.199057 26.5388889 0.214494 26.5416667 0.240738 26.5444444 0.282419 26.5472222 0.334906 26.5500000 0.388937 26.5527778 0.438336 26.5555556 0.472298 26.5583333 0.495455 26.5611111 0.507804 26.5638889 0.510892 26.5666667 0.520154 26.5694444 0.523242 26.5722222 0.521698 26.5750000 0.509348 26.5777778 0.492367 26.5805556 0.476930 26.5833333 0.453774 26.5861111 0.430617 26.5888889 0.401286 26.5916667 0.368868 26.5944444 0.336449 26.5972222 0.307118 26.6000000 0.288593 26.6027778 0.271612 26.6055556 0.265437 26.6083333 0.262350 26.6111111 0.262350 26.6138889 0.260806 26.6166667 0.260806 26.6194444 0.254631 26.6222222 0.253087 26.6250000 0.253087 26.6277778 0.253087 26.6305556 0.248456 26.6333333 0.246913 26.6361111 0.242281 26.6388889 0.239194 26.6416667 0.237650 26.6444444 0.237650 26.6472222 0.240738 26.6500000 0.240738 26.6527778 0.243825 26.6555556 0.246913 26.6583333 0.243825 26.6611111 0.245369 26.6638889 0.243825 26.6666667 0.239194 26.6694444 0.237650 26.6722222 0.233019 26.6750000 0.231475 26.6777778 0.236106 26.6805556 0.237650 26.6833333 0.237650 26.6861111 0.240738 26.6888889 0.242281 26.6916667 0.240738 26.6944444 0.240738 26.6972222 0.236106 26.7000000 0.234563 26.7027778 0.233019 26.7055556 0.231475 26.7083333 0.234563 26.7111111 0.228388 26.7138889 0.229931 26.7166667 0.233019 26.7194444 0.233019 26.7222222 0.231475 26.7250000 0.233019 26.7277778 0.231475 26.7305556 0.225300 26.7333333 0.222213 26.7361111 0.225300 26.7388889 0.223756 26.7416667 0.216038 26.7444444 0.219125 26.7472222 0.219125 26.7500000 0.222213 26.7527778 0.220669 26.7555556 0.225300 26.7583333 0.220669 26.7611111 0.219125 26.7638889 0.217581 26.7666667 0.216038 26.7694444 0.211407 26.7722222 0.211407 26.7750000 0.208319 26.7777778 0.208319 26.7805556 0.211407 26.7833333 0.211407 26.7861111 0.214494 26.7888889 0.216038 26.7916667 0.214494 26.7944444 0.212950 26.7972222 0.205232 26.8000000 0.199057 26.8027778 0.194425 26.8055556 0.195969 26.8083333 0.194425 26.8111111 0.192882 26.8138889 0.189794 26.8166667 0.194425 26.8194444 0.191338 26.8222222 0.192882 26.8250000 0.194425 26.8277778 0.189794 26.8305556 0.189794 27.2694444 0.242281 27.2722222 0.239194 27.2750000 0.239194 27.2777778 0.243825 27.2805556 0.245369 27.2833333 0.246913 27.2861111 0.246913 27.2888889 0.250000 27.2916667 0.250000 27.2944444 0.248456 27.2972222 0.250000 27.3000000 0.246913 27.3027778 0.248456 27.3055556 0.246913 27.3083333 0.248456 27.3111111 0.250000 27.3138889 0.254631 27.3166667 0.259262 27.3194444 0.262350 27.3222222 0.271612 27.3250000 0.273156 27.3277778 0.271612 27.3305556 0.266981 27.3333333 0.259262 27.3361111 0.256175 27.3388889 0.254631 27.3416667 0.254631 27.3444444 0.253087 27.3472222 0.253087 27.3500000 0.254631 27.3527778 0.256175 27.3555556 0.253087 27.3583333 0.251544 27.3611111 0.248456 27.3638889 0.246913 27.3666667 0.245369 27.3694444 0.240738 27.3722222 0.234563 27.3750000 0.231475 27.3777778 0.234563 27.3805556 0.240738 27.3833333 0.245369 27.3861111 0.248456 27.3888889 0.251544 27.3916667 0.250000 27.3944444 0.243825 27.3972222 0.242281 27.4000000 0.239194 27.4027778 0.236106 27.4055556 0.234563 27.4083333 0.237650 27.4111111 0.234563 27.4138889 0.239194 27.4166667 0.240738 27.4194444 0.236106 27.4222222 0.240738 27.4250000 0.243825 27.4277778 0.240738 27.4305556 0.243825 27.4333333 0.242281 27.4361111 0.240738 27.4388889 0.237650 27.4416667 0.237650 27.4444444 0.237650 27.4472222 0.239194 27.4500000 0.243825 27.4527778 0.245369 27.4555556 0.246913 27.4583333 0.248456 27.4611111 0.248456 27.4638889 0.243825 27.4666667 0.246913 27.4694444 0.246913 27.4722222 0.248456 27.4750000 0.256175 27.4777778 0.266981 27.4805556 0.277787 27.4833333 0.288593 27.4861111 0.294768 27.4888889 0.291681 27.4916667 0.283962 27.4944444 0.262350 27.4972222 0.242281 27.5000000 0.220669 27.5027778 0.203688 27.5055556 0.191338 27.5083333 0.194425 27.5111111 0.205232 27.5138889 0.223756 27.5166667 0.236106 27.5194444 0.245369 27.5222222 0.253087 27.5250000 0.263894 27.5277778 0.290137 27.5305556 0.325643 27.5333333 0.371955 27.5361111 0.410549 27.5388889 0.453774 27.5416667 0.475386 27.5444444 0.496998 27.5472222 0.510892 27.5500000 0.521698 27.5527778 0.532504 27.5555556 0.543310 27.5583333 0.541767 27.5611111 0.534048 27.5638889 0.520154 27.5666667 0.504717 27.5694444 0.483105 27.5722222 0.459949 27.5750000 0.432161 27.5777778 0.398199 27.5805556 0.367324 27.5833333 0.333362 27.5861111 0.307118 27.5888889 0.290137 27.5916667 0.277787 27.5944444 0.273156 27.5972222 0.268525 27.6000000 0.266981 27.6027778 0.263894 27.6055556 0.257719 27.6083333 0.257719 27.6111111 0.257719 27.6138889 0.254631 27.6166667 0.256175 27.6194444 0.256175 27.6222222 0.257719 27.6250000 0.250000 27.6277778 0.245369 27.6305556 0.245369 27.6333333 0.245369 27.6361111 0.242281 27.6388889 0.245369 27.6416667 0.240738 27.6444444 0.239194 27.6472222 0.239194 27.6500000 0.240738 27.6527778 0.242281 27.6555556 0.245369 27.6583333 0.248456 27.6611111 0.245369 27.6638889 0.242281 27.6666667 0.237650 27.6694444 0.237650 27.6722222 0.240738 27.6750000 0.233019 27.6777778 0.237650 27.6805556 0.237650 27.6833333 0.239194 27.6861111 0.239194 27.6888889 0.240738 27.6916667 0.240738 27.6944444 0.236106 27.6972222 0.236106 27.7000000 0.240738 27.7027778 0.236106 27.7055556 0.234563 27.7083333 0.229931 27.7111111 0.233019 27.7138889 0.233019 27.7166667 0.234563 27.7194444 0.231475 27.7222222 0.234563 27.7250000 0.233019 27.7277778 0.233019 27.7305556 0.229931 27.7333333 0.228388 27.7361111 0.226844 27.7388889 0.225300 27.7416667 0.226844 27.7444444 0.222213 27.7472222 0.223756 27.7500000 0.223756 27.7527778 0.226844 27.7555556 0.223756 27.7583333 0.225300 27.7611111 0.223756 27.7638889 0.222213 27.7666667 0.217581 27.7694444 0.217581 27.7722222 0.211407 27.7750000 0.211407 27.7777778 0.209863 27.7805556 0.209863 27.7833333 0.209863 27.7861111 0.211407 27.7888889 0.208319 27.7916667 0.211407 27.7944444 0.211407 27.7972222 0.206775 27.8000000 0.202144 27.8027778 0.200600 27.8055556 0.195969 27.8083333 0.192882 27.8111111 0.195969 27.8138889 0.194425 27.8166667 0.194425 28.1888889 0.266981 28.1916667 0.266981 28.1944444 0.265437 28.1972222 0.263894 28.2000000 0.260806 28.2027778 0.259262 28.2055556 0.256175 28.2083333 0.257719 28.2111111 0.256175 28.2138889 0.254631 28.2166667 0.260806 28.2194444 0.262350 28.2222222 0.266981 28.2250000 0.266981 28.2277778 0.266981 28.2305556 0.268525 28.2333333 0.265437 28.2361111 0.268525 28.2388889 0.266981 28.2416667 0.274700 28.2444444 0.276244 28.2472222 0.277787 28.2500000 0.287050 28.2527778 0.285506 28.2555556 0.287050 28.2583333 0.285506 28.2611111 0.282419 28.2638889 0.274700 28.2666667 0.270069 28.2694444 0.266981 28.2722222 0.265437 28.2750000 0.263894 28.2777778 0.260806 28.2805556 0.260806 28.2833333 0.265437 28.2861111 0.262350 28.2888889 0.262350 28.2916667 0.260806 28.2944444 0.259262 28.2972222 0.260806 28.3000000 0.257719 28.3027778 0.259262 28.3055556 0.256175 28.3083333 0.259262 28.3111111 0.256175 28.3138889 0.259262 28.3166667 0.254631 28.3194444 0.257719 28.3222222 0.260806 28.3250000 0.259262 28.3277778 0.256175 28.3305556 0.254631 28.3333333 0.253087 28.3361111 0.251544 28.3388889 0.246913 28.3416667 0.248456 28.3444444 0.250000 28.3472222 0.250000 28.3500000 0.253087 28.3527778 0.256175 28.3555556 0.257719 28.3583333 0.259262 28.3611111 0.257719 28.3638889 0.257719 28.3666667 0.257719 28.3694444 0.256175 28.3722222 0.254631 28.3750000 0.254631 28.3777778 0.256175 28.3805556 0.256175 28.3833333 0.259262 28.3861111 0.263894 28.3888889 0.265437 28.3916667 0.266981 28.3944444 0.273156 28.3972222 0.279331 28.4000000 0.287050 28.4027778 0.297856 28.4055556 0.297856 28.4083333 0.296312 28.4111111 0.291681 28.4138889 0.276244 28.4166667 0.262350 28.4194444 0.240738 28.4222222 0.222213 28.4250000 0.211407 28.4277778 0.206775 28.4305556 0.206775 28.4333333 0.209863 28.4361111 0.216038 28.4388889 0.217581 28.4416667 0.223756 28.4444444 0.236106 28.4472222 0.260806 28.4500000 0.302487 28.4527778 0.354974 28.4555556 0.409005 28.4583333 0.450686 28.4611111 0.478473 28.4638889 0.503173 28.4666667 0.520154 28.4694444 0.527873 28.4722222 0.535592 28.4750000 0.541767 28.4777778 0.541767 28.4805556 0.534048 28.4833333 0.515523 28.4861111 0.490823 28.4888889 0.464580 28.4916667 0.433705 28.4944444 0.405918 28.4972222 0.370412 28.5000000 0.341081 28.5027778 0.316381 28.5055556 0.296312 28.5083333 0.283962 28.5111111 0.276244 28.5138889 0.270069 28.5166667 0.268525 28.5194444 0.268525 28.5222222 0.266981 28.5250000 0.266981 28.5277778 0.263894 28.5305556 0.262350 28.5333333 0.254631 28.5361111 0.253087 28.5388889 0.245369 28.5416667 0.243825 28.5444444 0.245369 28.5472222 0.250000 28.5500000 0.250000 28.5527778 0.246913 28.5555556 0.248456 28.5583333 0.246913 28.5611111 0.250000 28.5638889 0.242281 28.5666667 0.243825 28.5694444 0.237650 28.5722222 0.237650 28.5750000 0.236106 28.5777778 0.234563 28.5805556 0.239194 28.5833333 0.242281 28.5861111 0.240738 28.5888889 0.242281 28.5916667 0.240738 28.5944444 0.242281 28.5972222 0.237650 28.6000000 0.236106 28.6027778 0.237650 28.6055556 0.236106 28.6083333 0.234563 28.6111111 0.229931 28.6138889 0.233019 28.6166667 0.237650 28.6194444 0.237650 28.6222222 0.236106 28.6250000 0.236106 28.6277778 0.236106 28.6305556 0.233019 28.6333333 0.228388 28.6361111 0.226844 28.6388889 0.225300 28.6416667 0.225300 28.6444444 0.228388 28.6472222 0.223756 28.6500000 0.226844 28.6527778 0.226844 28.6555556 0.228388 28.6583333 0.229931 28.6611111 0.228388 28.6638889 0.223756 28.6666667 0.223756 28.6694444 0.223756 28.6722222 0.212950 28.6750000 0.216038 28.6777778 0.212950 28.6805556 0.217581 28.6833333 0.219125 28.6861111 0.217581 28.6888889 0.217581 28.6916667 0.217581 28.6944444 0.214494 28.6972222 0.217581 28.7000000 0.212950 28.7027778 0.209863 28.7055556 0.205232 28.7083333 0.205232 28.7111111 0.200600 28.7138889 0.202144 28.7166667 0.200600 28.7194444 0.199057 28.7222222 0.202144 28.7250000 0.203688 28.7277778 0.200600 28.7305556 0.197513 28.7333333 0.199057 28.7361111 0.200600 29.1833333 0.256175 29.1861111 0.254631 29.1888889 0.254631 29.1916667 0.253087 29.1944444 0.253087 29.1972222 0.257719 29.2000000 0.256175 29.2027778 0.256175 29.2055556 0.253087 29.2083333 0.257719 29.2111111 0.254631 29.2138889 0.259262 29.2166667 0.266981 29.2194444 0.271612 29.2222222 0.274700 29.2250000 0.279331 29.2277778 0.288593 29.2305556 0.283962 29.2333333 0.276244 29.2361111 0.274700 29.2388889 0.271612 29.2416667 0.266981 29.2444444 0.263894 29.2472222 0.259262 29.2500000 0.260806 29.2527778 0.263894 29.2555556 0.263894 29.2583333 0.262350 29.2611111 0.260806 29.2638889 0.256175 29.2666667 0.254631 29.2694444 0.251544 29.2722222 0.248456 29.2750000 0.250000 29.2777778 0.248456 29.2805556 0.246913 29.2833333 0.246913 29.2861111 0.250000 29.2888889 0.253087 29.2916667 0.259262 29.2944444 0.257719 29.2972222 0.259262 29.3000000 0.254631 29.3027778 0.251544 29.3055556 0.246913 29.3083333 0.245369 29.3111111 0.246913 29.3138889 0.245369 29.3166667 0.246913 29.3194444 0.246913 29.3222222 0.248456 29.3250000 0.251544 29.3277778 0.251544 29.3305556 0.250000 29.3333333 0.246913 29.3361111 0.245369 29.3388889 0.245369 29.3416667 0.243825 29.3444444 0.245369 29.3472222 0.246913 29.3500000 0.250000 29.3527778 0.254631 29.3555556 0.254631 29.3583333 0.259262 29.3611111 0.254631 29.3638889 0.254631 29.3666667 0.253087 29.3694444 0.250000 29.3722222 0.251544 29.3750000 0.253087 29.3777778 0.254631 29.3805556 0.254631 29.3833333 0.259262 29.3861111 0.266981 29.3888889 0.279331 29.3916667 0.290137 29.3944444 0.299400 29.3972222 0.307118 29.4000000 0.304031 29.4027778 0.300943 29.4055556 0.282419 29.4083333 0.271612 29.4111111 0.251544 29.4138889 0.233019 29.4166667 0.217581 29.4194444 0.205232 29.4222222 0.205232 29.4250000 0.205232 29.4277778 0.208319 29.4305556 0.209863 29.4333333 0.208319 29.4361111 0.212950 29.4388889 0.228388 29.4416667 0.248456 29.4444444 0.297856 29.4472222 0.351887 29.4500000 0.404374 29.4527778 0.447599 29.4555556 0.483105 29.4583333 0.506261 29.4611111 0.520154 29.4638889 0.532504 29.4666667 0.538679 29.4694444 0.544854 29.4722222 0.541767 29.4750000 0.534048 29.4777778 0.517067 29.4805556 0.496998 29.4833333 0.473842 29.4861111 0.447599 29.4888889 0.416724 29.4916667 0.385849 29.4944444 0.351887 29.4972222 0.327187 29.5000000 0.300943 29.5027778 0.285506 29.5055556 0.276244 29.5083333 0.271612 29.5111111 0.266981 29.5138889 0.268525 29.5166667 0.268525 29.5194444 0.266981 29.5222222 0.265437 29.5250000 0.263894 29.5277778 0.259262 29.5305556 0.259262 29.5333333 0.257719 29.5361111 0.253087 29.5388889 0.246913 29.5416667 0.246913 29.5444444 0.245369 29.5472222 0.245369 29.5500000 0.250000 29.5527778 0.253087 29.5555556 0.248456 29.5583333 0.253087 29.5611111 0.250000 29.5638889 0.246913 29.5666667 0.246913 29.5694444 0.243825 29.5722222 0.242281 29.5750000 0.240738 29.5777778 0.240738 29.5805556 0.242281 29.5833333 0.245369 29.5861111 0.240738 29.5888889 0.246913 29.5916667 0.250000 29.5944444 0.245369 29.5972222 0.242281 29.6000000 0.243825 29.6027778 0.237650 29.6055556 0.239194 29.6083333 0.234563 29.6111111 0.233019 29.6138889 0.237650 29.6166667 0.239194 29.6194444 0.237650 29.6222222 0.239194 29.6250000 0.239194 29.6277778 0.240738 29.6305556 0.236106 29.6333333 0.231475 29.6361111 0.226844 29.6388889 0.228388 29.6416667 0.223756 29.6444444 0.228388 29.6472222 0.222213 29.6500000 0.228388 29.6527778 0.226844 29.6555556 0.226844 29.6583333 0.229931 29.6611111 0.223756 29.6638889 0.223756 29.6666667 0.223756 29.6694444 0.222213 29.6722222 0.214494 29.6750000 0.216038 29.6777778 0.212950 29.6805556 0.211407 29.6833333 0.214494 29.6861111 0.212950 29.6888889 0.216038 29.6916667 0.212950 29.6944444 0.212950 29.6972222 0.209863 29.7000000 0.209863 29.7027778 0.205232 29.7055556 0.202144 29.7083333 0.200600 29.7111111 0.199057 29.7138889 0.200600 29.7166667 0.195969 29.7194444 0.195969 29.7222222 0.197513 29.7250000 0.197513 29.7277778 0.199057 29.7305556 0.197513 30.1138889 0.248456 30.1166667 0.253087 30.1194444 0.253087 30.1222222 0.256175 30.1250000 0.257719 30.1277778 0.254631 30.1305556 0.254631 30.1333333 0.256175 30.1361111 0.250000 30.1388889 0.251544 30.1416667 0.250000 30.1444444 0.251544 30.1472222 0.251544 30.1500000 0.254631 30.1527778 0.256175 30.1555556 0.260806 30.1583333 0.263894 30.1611111 0.265437 30.1638889 0.273156 30.1666667 0.273156 30.1694444 0.273156 30.1722222 0.270069 30.1750000 0.270069 30.1777778 0.273156 30.1805556 0.270069 30.1833333 0.273156 30.1861111 0.268525 30.1888889 0.271612 30.1916667 0.266981 30.1944444 0.268525 30.1972222 0.266981 30.2000000 0.263894 30.2027778 0.262350 30.2055556 0.254631 30.2083333 0.254631 30.2111111 0.254631 30.2138889 0.254631 30.2166667 0.254631 30.2194444 0.254631 30.2222222 0.254631 30.2250000 0.253087 30.2277778 0.254631 30.2305556 0.259262 30.2333333 0.259262 30.2361111 0.259262 30.2388889 0.259262 30.2416667 0.257719 30.2444444 0.253087 30.2472222 0.253087 30.2500000 0.253087 30.2527778 0.254631 30.2555556 0.256175 30.2583333 0.257719 30.2611111 0.254631 30.2638889 0.254631 30.2666667 0.250000 30.2694444 0.253087 30.2722222 0.250000 30.2750000 0.251544 30.2777778 0.251544 30.2805556 0.256175 30.2833333 0.259262 30.2861111 0.257719 30.2888889 0.265437 30.2916667 0.263894 30.2944444 0.263894 30.2972222 0.260806 30.3000000 0.259262 30.3027778 0.257719 30.3055556 0.256175 30.3083333 0.254631 30.3111111 0.259262 30.3138889 0.259262 30.3166667 0.262350 30.3194444 0.268525 30.3222222 0.277787 30.3250000 0.285506 30.3277778 0.299400 30.3305556 0.307118 30.3333333 0.307118 30.3361111 0.297856 30.3388889 0.285506 30.3416667 0.263894 30.3444444 0.242281 30.3472222 0.220669 30.3500000 0.205232 30.3527778 0.205232 30.3555556 0.211407 30.3583333 0.229931 30.3611111 0.246913 30.3638889 0.251544 30.3666667 0.259262 30.3694444 0.265437 30.3722222 0.294768 30.3750000 0.334906 30.3777778 0.382762 30.3805556 0.433705 30.3833333 0.470755 30.3861111 0.504717 30.3888889 0.529417 30.3916667 0.537136 30.3944444 0.546398 30.3972222 0.551029 30.4000000 0.549485 30.4027778 0.538679 30.4055556 0.520154 30.4083333 0.503173 30.4111111 0.476930 30.4138889 0.453774 30.4166667 0.424443 30.4194444 0.390480 30.4222222 0.359605 30.4250000 0.325643 30.4277778 0.302487 30.4305556 0.288593 30.4333333 0.280875 30.4361111 0.276244 30.4388889 0.271612 30.4416667 0.270069 30.4444444 0.266981 30.4472222 0.260806 30.4500000 0.262350 30.4527778 0.254631 30.4555556 0.257719 30.4583333 0.254631 30.4611111 0.254631 30.4638889 0.257719 30.4666667 0.256175 30.4694444 0.251544 30.4722222 0.248456 30.4750000 0.246913 30.4777778 0.246913 30.4805556 0.246913 30.4833333 0.245369 30.4861111 0.246913 30.4888889 0.250000 30.4916667 0.253087 30.4944444 0.251544 30.4972222 0.248456 30.5000000 0.245369 30.5027778 0.246913 30.5055556 0.245369 30.5083333 0.240738 30.5111111 0.239194 30.5138889 0.240738 30.5166667 0.243825 30.5194444 0.245369 30.5222222 0.245369 30.5250000 0.243825 30.5277778 0.246913 30.5305556 0.243825 30.5333333 0.242281 30.5361111 0.240738 30.5388889 0.237650 30.5416667 0.236106 30.5444444 0.233019 30.5472222 0.234563 30.5500000 0.237650 30.5527778 0.242281 30.5555556 0.240738 30.5583333 0.245369 30.5611111 0.240738 30.5638889 0.237650 30.5666667 0.234563 30.5694444 0.231475 30.5722222 0.229931 30.5750000 0.229931 30.5777778 0.225300 30.5805556 0.225300 30.5833333 0.223756 30.5861111 0.226844 30.5888889 0.226844 30.5916667 0.226844 30.5944444 0.228388 30.5972222 0.228388 30.6000000 0.222213 30.6027778 0.220669 30.6055556 0.212950 30.6083333 0.212950 30.6111111 0.209863 30.6138889 0.212950 30.6166667 0.211407 30.6194444 0.211407 30.6222222 0.209863 30.6250000 0.212950 30.6277778 0.206775 30.6305556 0.205232 30.6333333 0.200600 30.6361111 0.199057 30.6388889 0.194425 30.6416667 0.189794 30.6444444 0.189794 30.6472222 0.191338 30.6500000 0.192882 30.6527778 0.192882 30.6555556 0.195969 30.6583333 0.191338 30.6611111 0.191338 31.0000000 0.260806 31.0027778 0.259262 31.0055556 0.254631 31.0083333 0.254631 31.0111111 0.254631 31.0138889 0.256175 31.0166667 0.259262 31.0194444 0.256175 31.0222222 0.260806 31.0250000 0.265437 31.0277778 0.268525 31.0305556 0.271612 31.0333333 0.273156 31.0361111 0.276244 31.0388889 0.276244 31.0416667 0.280875 31.0444444 0.277787 31.0472222 0.279331 31.0500000 0.277787 31.0527778 0.273156 31.0555556 0.276244 31.0583333 0.274700 31.0611111 0.270069 31.0638889 0.271612 31.0666667 0.265437 31.0694444 0.262350 31.0722222 0.257719 31.0750000 0.257719 31.0777778 0.254631 31.0805556 0.256175 31.0833333 0.254631 31.0861111 0.256175 31.0888889 0.259262 31.0916667 0.257719 31.0944444 0.256175 31.0972222 0.253087 31.1000000 0.254631 31.1027778 0.254631 31.1055556 0.254631 31.1083333 0.256175 31.1111111 0.250000 31.1138889 0.250000 31.1166667 0.248456 31.1194444 0.251544 31.1222222 0.248456 31.1250000 0.254631 31.1277778 0.257719 31.1305556 0.254631 31.1333333 0.250000 31.1361111 0.246913 31.1388889 0.245369 31.1416667 0.242281 31.1444444 0.242281 31.1472222 0.246913 31.1500000 0.245369 31.1527778 0.251544 31.1555556 0.256175 31.1583333 0.254631 31.1611111 0.250000 31.1638889 0.253087 31.1666667 0.250000 31.1694444 0.248456 31.1722222 0.248456 31.1750000 0.245369 31.1777778 0.242281 31.1805556 0.248456 31.1833333 0.250000 31.1861111 0.250000 31.1888889 0.251544 31.1916667 0.256175 31.1944444 0.251544 31.1972222 0.254631 31.2000000 0.257719 31.2027778 0.263894 31.2055556 0.268525 31.2083333 0.280875 31.2111111 0.290137 31.2138889 0.293225 31.2166667 0.294768 31.2194444 0.287050 31.2222222 0.276244 31.2250000 0.263894 31.2277778 0.240738 31.2305556 0.223756 31.2333333 0.206775 31.2361111 0.199057 31.2388889 0.194425 31.2416667 0.192882 31.2444444 0.197513 31.2472222 0.202144 31.2500000 0.205232 31.2527778 0.217581 31.2555556 0.240738 31.2583333 0.277787 31.2611111 0.324099 31.2638889 0.378130 31.2666667 0.424443 31.2694444 0.459949 31.2722222 0.481561 31.2750000 0.500086 31.2777778 0.515523 31.2805556 0.523242 31.2833333 0.534048 31.2861111 0.541767 31.2888889 0.537136 31.2916667 0.527873 31.2944444 0.504717 31.2972222 0.481561 31.3000000 0.449142 31.3027778 0.421355 31.3055556 0.388937 31.3083333 0.358062 31.3111111 0.325643 31.3138889 0.304031 31.3166667 0.288593 31.3194444 0.274700 31.3222222 0.271612 31.3250000 0.270069 31.3277778 0.268525 31.3305556 0.263894 31.3333333 0.260806 31.3361111 0.254631 31.3388889 0.251544 31.3416667 0.248456 31.3444444 0.246913 31.3472222 0.245369 31.3500000 0.245369 31.3527778 0.245369 31.3555556 0.250000 31.3583333 0.250000 31.3611111 0.248456 31.3638889 0.245369 31.3666667 0.245369 31.3694444 0.242281 31.3722222 0.239194 31.3750000 0.239194 31.3777778 0.237650 31.3805556 0.236106 31.3833333 0.236106 31.3861111 0.239194 31.3888889 0.239194 31.3916667 0.243825 31.3944444 0.240738 31.3972222 0.239194 31.4000000 0.236106 31.4027778 0.231475 31.4055556 0.231475 31.4083333 0.231475 31.4111111 0.229931 31.4138889 0.226844 31.4166667 0.229931 31.4194444 0.231475 31.4222222 0.236106 31.4250000 0.237650 31.4277778 0.237650 31.4305556 0.236106 31.4333333 0.233019 31.4361111 0.233019 31.4388889 0.226844 31.4416667 0.229931 31.4444444 0.225300 31.4472222 0.223756 31.4500000 0.229931 31.4527778 0.229931 31.4555556 0.228388 31.4583333 0.231475 31.4611111 0.228388 31.4638889 0.225300 31.4666667 0.226844 31.4694444 0.225300 31.4722222 0.223756 31.4750000 0.220669 31.4777778 0.222213 31.4805556 0.220669 31.4833333 0.217581 31.4861111 0.220669 31.4888889 0.220669 31.4916667 0.223756 31.4944444 0.220669 31.4972222 0.219125 31.5000000 0.216038 31.5027778 0.214494 31.5055556 0.208319 31.5083333 0.203688 31.5111111 0.205232 31.5138889 0.199057 31.5166667 0.202144 31.5194444 0.200600 31.5222222 0.203688 31.5250000 0.202144 31.5277778 0.202144 31.5305556 0.199057 31.5333333 0.199057 31.5361111 0.199057 31.5388889 0.192882 31.5416667 0.191338 31.5444444 0.191338 31.5472222 0.191338 31.9805556 0.259262 31.9833333 0.259262 31.9861111 0.260806 31.9888889 0.263894 31.9916667 0.263894 31.9944444 0.263894 31.9972222 0.262350 32.0000000 0.260806 32.0027778 0.260806 32.0055556 0.257719 32.0083333 0.259262 32.0111111 0.260806 32.0138889 0.260806 32.0166667 0.266981 32.0194444 0.266981 32.0222222 0.273156 32.0250000 0.276244 32.0277778 0.282419 32.0305556 0.282419 32.0333333 0.283962 32.0361111 0.282419 32.0388889 0.280875 32.0416667 0.276244 32.0444444 0.273156 32.0472222 0.270069 32.0500000 0.270069 32.0527778 0.270069 32.0555556 0.266981 32.0583333 0.265437 32.0611111 0.265437 32.0638889 0.265437 32.0666667 0.260806 32.0694444 0.254631 32.0722222 0.254631 32.0750000 0.253087 32.0777778 0.250000 32.0805556 0.246913 32.0833333 0.243825 32.0861111 0.248456 32.0888889 0.248456 32.0916667 0.251544 32.0944444 0.256175 32.0972222 0.254631 32.1000000 0.254631 32.1027778 0.250000 32.1055556 0.248456 32.1083333 0.245369 32.1111111 0.243825 32.1138889 0.245369 32.1166667 0.245369 32.1194444 0.248456 32.1222222 0.246913 32.1250000 0.248456 32.1277778 0.251544 32.1305556 0.250000 32.1333333 0.250000 32.1361111 0.243825 32.1388889 0.245369 32.1416667 0.245369 32.1444444 0.246913 32.1472222 0.246913 32.1500000 0.250000 32.1527778 0.248456 32.1555556 0.253087 32.1583333 0.251544 32.1611111 0.253087 32.1638889 0.259262 32.1666667 0.253087 32.1694444 0.250000 32.1722222 0.248456 32.1750000 0.246913 32.1777778 0.248456 32.1805556 0.254631 32.1833333 0.256175 32.1861111 0.268525 32.1888889 0.274700 32.1916667 0.288593 32.1944444 0.296312 32.1972222 0.304031 32.2000000 0.296312 32.2027778 0.287050 32.2055556 0.273156 32.2083333 0.254631 32.2111111 0.233019 32.2138889 0.217581 32.2166667 0.203688 32.2194444 0.195969 32.2222222 0.195969 32.2250000 0.200600 32.2277778 0.203688 32.2305556 0.206775 32.2333333 0.205232 32.2361111 0.217581 32.2388889 0.243825 32.2416667 0.282419 32.2444444 0.337993 32.2472222 0.396655 32.2500000 0.442967 32.2527778 0.480017 32.2555556 0.503173 32.2583333 0.518611 32.2611111 0.529417 32.2638889 0.538679 32.2666667 0.538679 32.2694444 0.538679 32.2722222 0.527873 32.2750000 0.510892 32.2777778 0.490823 32.2805556 0.469211 32.2833333 0.442967 32.2861111 0.413636 32.2888889 0.381218 32.2916667 0.354974 32.2944444 0.325643 32.2972222 0.305575 32.3000000 0.285506 32.3027778 0.276244 32.3055556 0.266981 32.3083333 0.263894 32.3111111 0.262350 32.3138889 0.262350 32.3166667 0.259262 32.3194444 0.259262 32.3222222 0.254631 32.3250000 0.256175 32.3277778 0.250000 32.3305556 0.251544 32.3333333 0.253087 32.3361111 0.245369 32.3388889 0.245369 32.3416667 0.239194 32.3444444 0.240738 32.3472222 0.240738 32.3500000 0.240738 32.3527778 0.242281 32.3555556 0.243825 32.3583333 0.245369 32.3611111 0.242281 32.3638889 0.243825 32.3666667 0.243825 32.3694444 0.237650 32.3722222 0.239194 32.3750000 0.234563 32.3777778 0.231475 32.3805556 0.233019 32.3833333 0.237650 32.3861111 0.237650 32.3888889 0.239194 32.3916667 0.239194 32.3944444 0.237650 32.3972222 0.237650 32.4000000 0.233019 32.4027778 0.234563 32.4055556 0.233019 32.4083333 0.226844 32.4111111 0.228388 32.4138889 0.229931 32.4166667 0.229931 32.4194444 0.233019 32.4222222 0.234563 32.4250000 0.234563 32.4277778 0.234563 32.4305556 0.231475 32.4333333 0.229931 32.4361111 0.228388 32.4388889 0.225300 32.4416667 0.225300 32.4444444 0.223756 32.4472222 0.219125 32.4500000 0.222213 32.4527778 0.223756 32.4555556 0.226844 32.4583333 0.225300 32.4611111 0.223756 32.4638889 0.220669 32.4666667 0.220669 32.4694444 0.212950 32.4722222 0.212950 32.4750000 0.209863 32.4777778 0.208319 32.4805556 0.209863 32.4833333 0.206775 32.4861111 0.212950 32.4888889 0.211407 32.4916667 0.216038 32.4944444 0.211407 32.4972222 0.208319 32.5000000 0.205232 32.5027778 0.202144 32.5055556 0.200600 32.5083333 0.197513 32.5111111 0.197513 32.5138889 0.195969 32.5166667 0.194425 32.5194444 0.192882 32.5222222 0.194425 32.5250000 0.195969 32.5277778 0.189794 32.9583333 0.250000 32.9611111 0.250000 32.9638889 0.246913 32.9666667 0.246913 32.9694444 0.245369 32.9722222 0.240738 32.9750000 0.240738 32.9777778 0.243825 32.9805556 0.243825 32.9833333 0.242281 32.9861111 0.243825 32.9888889 0.248456 32.9916667 0.253087 32.9944444 0.256175 32.9972222 0.260806 33.0000000 0.260806 33.0027778 0.259262 33.0055556 0.262350 33.0083333 0.263894 33.0111111 0.263894 33.0138889 0.266981 33.0166667 0.265437 33.0194444 0.266981 33.0222222 0.263894 33.0250000 0.262350 33.0277778 0.262350 33.0305556 0.260806 33.0333333 0.259262 33.0361111 0.254631 33.0388889 0.254631 33.0416667 0.248456 33.0444444 0.248456 33.0472222 0.250000 33.0500000 0.248456 33.0527778 0.250000 33.0555556 0.246913 33.0583333 0.248456 33.0611111 0.245369 33.0638889 0.245369 33.0666667 0.250000 33.0694444 0.246913 33.0722222 0.248456 33.0750000 0.250000 33.0777778 0.245369 33.0805556 0.243825 33.0833333 0.242281 33.0861111 0.243825 33.0888889 0.242281 33.0916667 0.248456 33.0944444 0.248456 33.0972222 0.245369 33.1000000 0.246913 33.1027778 0.245369 33.1055556 0.242281 33.1083333 0.239194 33.1111111 0.240738 33.1138889 0.239194 33.1166667 0.240738 33.1194444 0.243825 33.1222222 0.246913 33.1250000 0.246913 33.1277778 0.251544 33.1305556 0.253087 33.1333333 0.256175 33.1361111 0.256175 33.1388889 0.257719 33.1416667 0.254631 33.1444444 0.254631 33.1472222 0.256175 33.1500000 0.256175 33.1527778 0.260806 33.1555556 0.265437 33.1583333 0.270069 33.1611111 0.273156 33.1638889 0.279331 33.1666667 0.282419 33.1694444 0.288593 33.1722222 0.294768 33.1750000 0.297856 33.1777778 0.296312 33.1805556 0.291681 33.1833333 0.285506 33.1861111 0.265437 33.1888889 0.248456 33.1916667 0.228388 33.1944444 0.212950 33.1972222 0.205232 33.2000000 0.209863 33.2027778 0.223756 33.2055556 0.236106 33.2083333 0.248456 33.2111111 0.257719 33.2138889 0.262350 33.2166667 0.276244 33.2194444 0.305575 33.2222222 0.350343 33.2250000 0.396655 33.2277778 0.438336 33.2305556 0.472298 33.2333333 0.495455 33.2361111 0.510892 33.2388889 0.521698 33.2416667 0.527873 33.2444444 0.540223 33.2472222 0.547942 33.2500000 0.549485 33.2527778 0.541767 33.2555556 0.532504 33.2583333 0.517067 33.2611111 0.498542 33.2638889 0.478473 33.2666667 0.453774 33.2694444 0.419811 33.2722222 0.382762 33.2750000 0.344168 33.2777778 0.311750 33.2805556 0.290137 33.2833333 0.279331 33.2861111 0.273156 33.2888889 0.276244 33.2916667 0.274700 33.2944444 0.273156 33.2972222 0.270069 33.3000000 0.266981 33.3027778 0.262350 33.3055556 0.257719 33.3083333 0.251544 33.3111111 0.250000 33.3138889 0.248456 33.3166667 0.250000 33.3194444 0.251544 33.3222222 0.254631 33.3250000 0.254631 33.3277778 0.257719 33.3305556 0.254631 33.3333333 0.254631 33.3361111 0.251544 33.3388889 0.245369 33.3416667 0.245369 33.3444444 0.243825 33.3472222 0.243825 33.3500000 0.246913 33.3527778 0.250000 33.3555556 0.250000 33.3583333 0.250000 33.3611111 0.253087 33.3638889 0.251544 33.3666667 0.251544 33.3694444 0.245369 33.3722222 0.242281 33.3750000 0.243825 33.3777778 0.240738 33.3805556 0.239194 33.3833333 0.239194 33.3861111 0.240738 33.3888889 0.240738 33.3916667 0.239194 33.3944444 0.246913 33.3972222 0.242281 33.4000000 0.240738 33.4027778 0.237650 33.4055556 0.237650 33.4083333 0.231475 33.4111111 0.234563 33.4138889 0.236106 33.4166667 0.234563 33.4194444 0.233019 33.4222222 0.233019 33.4250000 0.233019 33.4277778 0.236106 33.4305556 0.236106 33.4333333 0.236106 33.4361111 0.233019 33.4388889 0.228388 33.4416667 0.223756 33.4444444 0.219125 33.4472222 0.225300 33.4500000 0.223756 33.4527778 0.223756 33.4555556 0.225300 33.4583333 0.228388 33.4611111 0.226844 33.4638889 0.225300 33.4666667 0.220669 33.4694444 0.216038 33.4722222 0.211407 33.4750000 0.205232 33.4777778 0.206775 33.4805556 0.200600 33.4833333 0.205232 33.4861111 0.203688 33.4888889 0.203688 33.4916667 0.202144 33.4944444 0.200600 33.4972222 0.200600 33.5000000 0.199057 33.5027778 0.194425 33.5055556 0.189794 33.8472222 0.254631 33.8500000 0.254631 33.8527778 0.257719 33.8555556 0.260806 33.8583333 0.262350 33.8611111 0.265437 33.8638889 0.257719 33.8666667 0.263894 33.8694444 0.259262 33.8722222 0.260806 33.8750000 0.257719 33.8777778 0.260806 33.8805556 0.259262 33.8833333 0.263894 33.8861111 0.271612 33.8888889 0.270069 33.8916667 0.277787 33.8944444 0.279331 33.8972222 0.280875 33.9000000 0.283962 33.9027778 0.283962 33.9055556 0.277787 33.9083333 0.276244 33.9111111 0.273156 33.9138889 0.263894 33.9166667 0.265437 33.9194444 0.265437 33.9222222 0.266981 33.9250000 0.266981 33.9277778 0.265437 33.9305556 0.262350 33.9333333 0.260806 33.9361111 0.256175 33.9388889 0.254631 33.9416667 0.248456 33.9444444 0.251544 33.9472222 0.246913 33.9500000 0.246913 33.9527778 0.248456 33.9555556 0.251544 33.9583333 0.254631 33.9611111 0.259262 33.9638889 0.259262 33.9666667 0.256175 33.9694444 0.253087 33.9722222 0.246913 33.9750000 0.246913 33.9777778 0.243825 33.9805556 0.242281 33.9833333 0.245369 33.9861111 0.246913 33.9888889 0.243825 33.9916667 0.248456 33.9944444 0.248456 33.9972222 0.251544 34.0000000 0.248456 34.0027778 0.243825 34.0055556 0.240738 34.0083333 0.243825 34.0111111 0.237650 34.0138889 0.242281 34.0166667 0.243825 34.0194444 0.243825 34.0222222 0.245369 34.0250000 0.246913 34.0277778 0.248456 34.0305556 0.250000 34.0333333 0.246913 34.0361111 0.246913 34.0388889 0.243825 34.0416667 0.242281 34.0444444 0.240738 34.0472222 0.246913 34.0500000 0.250000 34.0527778 0.260806 34.0555556 0.273156 34.0583333 0.287050 34.0611111 0.296312 34.0638889 0.297856 34.0666667 0.293225 34.0694444 0.276244 34.0722222 0.259262 34.0750000 0.240738 34.0777778 0.219125 34.0805556 0.200600 34.0833333 0.192882 34.0861111 0.188250 34.0888889 0.192882 34.0916667 0.199057 34.0944444 0.205232 34.0972222 0.209863 34.1000000 0.214494 34.1027778 0.231475 34.1055556 0.254631 34.1083333 0.296312 34.1111111 0.347256 34.1138889 0.395111 34.1166667 0.436792 34.1194444 0.470755 34.1222222 0.495455 34.1250000 0.510892 34.1277778 0.523242 34.1305556 0.534048 34.1333333 0.532504 34.1361111 0.538679 34.1388889 0.523242 34.1416667 0.503173 34.1444444 0.476930 34.1472222 0.456861 34.1500000 0.429074 34.1527778 0.401286 34.1555556 0.373499 34.1583333 0.345712 34.1611111 0.321012 34.1638889 0.297856 34.1666667 0.280875 34.1694444 0.265437 34.1722222 0.259262 34.1750000 0.250000 34.1777778 0.248456 34.1805556 0.245369 34.1833333 0.246913 34.1861111 0.243825 34.1888889 0.242281 34.1916667 0.242281 34.1944444 0.240738 34.1972222 0.237650 34.2000000 0.240738 34.2027778 0.236106 34.2055556 0.234563 34.2083333 0.233019 34.2111111 0.229931 34.2138889 0.229931 34.2166667 0.233019 34.2194444 0.233019 34.2222222 0.231475 34.2250000 0.233019 34.2277778 0.233019 34.2305556 0.231475 34.2333333 0.229931 34.2361111 0.228388 34.2388889 0.229931 34.2416667 0.228388 34.2444444 0.223756 34.2472222 0.225300 34.2500000 0.226844 34.2527778 0.231475 34.2555556 0.228388 34.2583333 0.229931 34.2611111 0.229931 34.2638889 0.231475 34.2666667 0.225300 34.2694444 0.223756 34.2722222 0.220669 34.2750000 0.220669 34.2777778 0.219125 34.2805556 0.219125 34.2833333 0.222213 34.2861111 0.222213 34.2888889 0.222213 34.2916667 0.225300 34.2944444 0.225300 34.2972222 0.225300 34.3000000 0.223756 34.3027778 0.222213 34.3055556 0.217581 34.3083333 0.216038 34.3111111 0.214494 34.3138889 0.212950 34.3166667 0.214494 34.3194444 0.217581 34.3222222 0.219125 34.3250000 0.219125 34.3277778 0.216038 34.3305556 0.216038 34.3333333 0.216038 34.3361111 0.212950 34.3388889 0.209863 34.3416667 0.203688 34.3444444 0.205232 34.3472222 0.202144 34.3500000 0.205232 34.3527778 0.205232 34.3555556 0.206775 34.3583333 0.208319 34.3611111 0.205232 34.3638889 0.206775 34.3666667 0.202144 34.3694444 0.200600 34.3722222 0.197513 34.3750000 0.191338 34.3777778 0.189794 34.3805556 0.186707 34.3833333 0.185163 34.3861111 0.188250 34.3888889 0.191338 34.3916667 0.189794 34.3944444 0.192882 34.8388889 0.259262 34.8416667 0.257719 34.8444444 0.257719 34.8472222 0.260806 34.8500000 0.259262 34.8527778 0.260806 34.8555556 0.260806 34.8583333 0.266981 34.8611111 0.266981 34.8638889 0.266981 34.8666667 0.265437 34.8694444 0.266981 34.8722222 0.268525 34.8750000 0.268525 34.8777778 0.270069 34.8805556 0.274700 34.8833333 0.276244 34.8861111 0.283962 34.8888889 0.288593 34.8916667 0.294768 34.8944444 0.294768 34.8972222 0.291681 34.9000000 0.290137 34.9027778 0.283962 34.9055556 0.277787 34.9083333 0.274700 34.9111111 0.274700 34.9138889 0.270069 34.9166667 0.273156 34.9194444 0.273156 34.9222222 0.270069 34.9250000 0.271612 34.9277778 0.265437 34.9305556 0.268525 34.9333333 0.266981 34.9361111 0.263894 34.9388889 0.257719 34.9416667 0.256175 34.9444444 0.251544 34.9472222 0.257719 34.9500000 0.260806 34.9527778 0.265437 34.9555556 0.263894 34.9583333 0.263894 34.9611111 0.262350 34.9638889 0.260806 34.9666667 0.259262 34.9694444 0.257719 34.9722222 0.254631 34.9750000 0.254631 34.9777778 0.250000 34.9805556 0.250000 34.9833333 0.251544 34.9861111 0.254631 34.9888889 0.259262 34.9916667 0.262350 34.9944444 0.257719 34.9972222 0.256175 35.0000000 0.256175 35.0027778 0.254631 35.0055556 0.254631 35.0083333 0.253087 35.0111111 0.253087 35.0138889 0.251544 35.0166667 0.253087 35.0194444 0.257719 35.0222222 0.260806 35.0250000 0.259262 35.0277778 0.260806 35.0305556 0.263894 35.0333333 0.262350 35.0361111 0.260806 35.0388889 0.260806 35.0416667 0.266981 35.0444444 0.271612 35.0472222 0.282419 35.0500000 0.294768 35.0527778 0.305575 35.0555556 0.308662 35.0583333 0.304031 35.0611111 0.297856 35.0638889 0.277787 35.0666667 0.257719 35.0694444 0.236106 35.0722222 0.220669 35.0750000 0.203688 35.0777778 0.195969 35.0805556 0.194425 35.0833333 0.197513 35.0861111 0.203688 35.0888889 0.212950 35.0916667 0.225300 35.0944444 0.253087 35.0972222 0.293225 35.1000000 0.348799 35.1027778 0.404374 35.1055556 0.450686 35.1083333 0.484648 35.1111111 0.507804 35.1138889 0.526329 35.1166667 0.534048 35.1194444 0.541767 35.1222222 0.551029 35.1250000 0.549485 35.1277778 0.543310 35.1305556 0.524786 35.1333333 0.504717 35.1361111 0.475386 35.1388889 0.446055 35.1416667 0.410549 35.1444444 0.375043 35.1472222 0.342624 35.1500000 0.319468 35.1527778 0.299400 35.1555556 0.287050 35.1583333 0.285506 35.1611111 0.279331 35.1638889 0.277787 35.1666667 0.274700 35.1694444 0.270069 35.1722222 0.263894 35.1750000 0.257719 35.1777778 0.257719 35.1805556 0.251544 35.1833333 0.254631 35.1861111 0.259262 35.1888889 0.256175 35.1916667 0.257719 35.1944444 0.256175 35.1972222 0.256175 35.2000000 0.254631 35.2027778 0.251544 35.2055556 0.248456 35.2083333 0.243825 35.2111111 0.242281 35.2138889 0.245369 35.2166667 0.245369 35.2194444 0.243825 35.2222222 0.248456 35.2250000 0.248456 35.2277778 0.250000 35.2305556 0.243825 35.2333333 0.245369 35.2361111 0.239194 35.2388889 0.242281 35.2416667 0.237650 35.2444444 0.237650 35.2472222 0.237650 35.2500000 0.239194 35.2527778 0.240738 35.2555556 0.245369 35.2583333 0.243825 35.2611111 0.243825 35.2638889 0.243825 35.2666667 0.242281 35.2694444 0.240738 35.2722222 0.237650 35.2750000 0.234563 35.2777778 0.231475 35.2805556 0.229931 35.2833333 0.229931 35.2861111 0.231475 35.2888889 0.233019 35.2916667 0.234563 35.2944444 0.234563 35.2972222 0.234563 35.3000000 0.231475 35.3027778 0.228388 35.3055556 0.225300 35.3083333 0.223756 35.3111111 0.223756 35.3138889 0.223756 35.3166667 0.222213 35.3194444 0.222213 35.3222222 0.222213 35.3250000 0.225300 35.3277778 0.223756 35.3305556 0.219125 35.3333333 0.219125 35.3361111 0.216038 35.3388889 0.212950 35.3416667 0.211407 35.3444444 0.209863 35.3472222 0.206775 35.3500000 0.208319 35.3527778 0.205232 35.3555556 0.203688 35.3583333 0.203688 35.3611111 0.203688 35.3638889 0.200600 35.3666667 0.200600 35.3694444 0.194425 35.3722222 0.194425 35.3750000 0.189794 35.3777778 0.188250 35.3805556 0.183619 35.3833333 0.188250 35.3861111 0.194425 35.7583333 0.260806 35.7611111 0.262350 35.7638889 0.259262 35.7666667 0.259262 35.7694444 0.256175 35.7722222 0.256175 35.7750000 0.254631 35.7777778 0.253087 35.7805556 0.248456 35.7833333 0.253087 35.7861111 0.256175 35.7888889 0.257719 35.7916667 0.259262 35.7944444 0.260806 35.7972222 0.260806 35.8000000 0.262350 35.8027778 0.260806 35.8055556 0.260806 35.8083333 0.260806 35.8111111 0.259262 35.8138889 0.263894 35.8166667 0.266981 35.8194444 0.273156 35.8222222 0.274700 35.8250000 0.276244 35.8277778 0.280875 35.8305556 0.274700 35.8333333 0.271612 35.8361111 0.271612 35.8388889 0.266981 35.8416667 0.265437 35.8444444 0.262350 35.8472222 0.262350 35.8500000 0.263894 35.8527778 0.262350 35.8555556 0.262350 35.8583333 0.262350 35.8611111 0.260806 35.8638889 0.260806 35.8666667 0.260806 35.8694444 0.254631 35.8722222 0.254631 35.8750000 0.256175 35.8777778 0.256175 35.8805556 0.256175 35.8833333 0.260806 35.8861111 0.260806 35.8888889 0.260806 35.8916667 0.257719 35.8944444 0.259262 35.8972222 0.257719 35.9000000 0.257719 35.9027778 0.254631 35.9055556 0.253087 35.9083333 0.251544 35.9111111 0.248456 35.9138889 0.246913 35.9166667 0.248456 35.9194444 0.251544 35.9222222 0.248456 35.9250000 0.251544 35.9277778 0.257719 35.9305556 0.257719 35.9333333 0.259262 35.9361111 0.256175 35.9388889 0.256175 35.9416667 0.250000 35.9444444 0.253087 35.9472222 0.251544 35.9500000 0.251544 35.9527778 0.256175 35.9555556 0.257719 35.9583333 0.260806 35.9611111 0.262350 35.9638889 0.270069 35.9666667 0.273156 35.9694444 0.277787 35.9722222 0.285506 35.9750000 0.293225 35.9777778 0.288593 35.9805556 0.285506 35.9833333 0.276244 35.9861111 0.254631 35.9888889 0.233019 35.9916667 0.214494 35.9944444 0.199057 35.9972222 0.203688 36.0000000 0.214494 36.0027778 0.228388 36.0055556 0.242281 36.0083333 0.248456 36.0111111 0.253087 36.0138889 0.260806 36.0166667 0.283962 36.0194444 0.324099 36.0222222 0.373499 36.0250000 0.418268 36.0277778 0.458405 36.0305556 0.486192 36.0333333 0.496998 36.0361111 0.512436 36.0388889 0.523242 36.0416667 0.532504 36.0444444 0.537136 36.0472222 0.540223 36.0500000 0.540223 36.0527778 0.529417 36.0555556 0.515523 36.0583333 0.500086 36.0611111 0.483105 36.0638889 0.459949 36.0666667 0.433705 36.0694444 0.395111 36.0722222 0.361149 36.0750000 0.327187 36.0777778 0.300943 36.0805556 0.280875 36.0833333 0.271612 36.0861111 0.266981 36.0888889 0.268525 36.0916667 0.268525 36.0944444 0.270069 36.0972222 0.265437 36.1000000 0.262350 36.1027778 0.256175 36.1055556 0.253087 36.1083333 0.253087 36.1111111 0.243825 36.1138889 0.248456 36.1166667 0.243825 36.1194444 0.243825 36.1222222 0.246913 36.1250000 0.248456 36.1277778 0.245369 36.1305556 0.248456 36.1333333 0.246913 36.1361111 0.242281 36.1388889 0.243825 36.1416667 0.240738 36.1444444 0.239194 36.1472222 0.242281 36.1500000 0.236106 36.1527778 0.237650 36.1555556 0.239194 36.1583333 0.245369 36.1611111 0.243825 36.1638889 0.246913 36.1666667 0.243825 36.1694444 0.243825 36.1722222 0.240738 36.1750000 0.239194 36.1777778 0.234563 36.1805556 0.234563 36.1833333 0.233019 36.1861111 0.236106 36.1888889 0.234563 36.1916667 0.236106 36.1944444 0.239194 36.1972222 0.240738 36.2000000 0.236106 36.2027778 0.234563 36.2055556 0.236106 36.2083333 0.231475 36.2111111 0.233019 36.2138889 0.228388 36.2166667 0.231475 36.2194444 0.233019 36.2222222 0.229931 36.2250000 0.234563 36.2277778 0.234563 36.2305556 0.229931 36.2333333 0.228388 36.2361111 0.225300 36.2388889 0.223756 36.2416667 0.223756 36.2444444 0.219125 36.2472222 0.220669 36.2500000 0.217581 36.2527778 0.217581 36.2555556 0.217581 36.2583333 0.220669 36.2611111 0.220669 36.2638889 0.220669 36.2666667 0.220669 36.2694444 0.216038 36.2722222 0.208319 36.2750000 0.206775 36.2777778 0.205232 36.2805556 0.195969 36.2833333 0.200600 36.2861111 0.202144 36.2888889 0.200600 36.2916667 0.202144 36.2944444 0.203688 36.2972222 0.199057 36.3000000 0.197513 36.3027778 0.194425 36.3055556 0.192882 36.6861111 0.243825 36.6888889 0.245369 36.6916667 0.250000 36.6944444 0.248456 36.6972222 0.250000 36.7000000 0.246913 36.7027778 0.248456 36.7055556 0.248456 36.7083333 0.246913 36.7111111 0.251544 36.7138889 0.253087 36.7166667 0.257719 36.7194444 0.262350 36.7222222 0.263894 36.7250000 0.271612 36.7277778 0.276244 36.7305556 0.274700 36.7333333 0.268525 36.7361111 0.262350 36.7388889 0.259262 36.7416667 0.257719 36.7444444 0.253087 36.7472222 0.250000 36.7500000 0.250000 36.7527778 0.251544 36.7555556 0.251544 36.7583333 0.253087 36.7611111 0.251544 36.7638889 0.248456 36.7666667 0.245369 36.7694444 0.245369 36.7722222 0.243825 36.7750000 0.237650 36.7777778 0.237650 36.7805556 0.234563 36.7833333 0.236106 36.7861111 0.237650 36.7888889 0.242281 36.7916667 0.243825 36.7944444 0.248456 36.7972222 0.246913 36.8000000 0.239194 36.8027778 0.237650 36.8055556 0.237650 36.8083333 0.229931 36.8111111 0.228388 36.8138889 0.229931 36.8166667 0.229931 36.8194444 0.233019 36.8222222 0.231475 36.8250000 0.236106 36.8277778 0.239194 36.8305556 0.234563 36.8333333 0.236106 36.8361111 0.236106 36.8388889 0.237650 36.8416667 0.229931 36.8444444 0.231475 36.8472222 0.228388 36.8500000 0.228388 36.8527778 0.233019 36.8555556 0.229931 36.8583333 0.236106 36.8611111 0.237650 36.8638889 0.236106 36.8666667 0.239194 36.8694444 0.240738 36.8722222 0.234563 36.8750000 0.234563 36.8777778 0.236106 36.8805556 0.237650 36.8833333 0.237650 36.8861111 0.240738 36.8888889 0.246913 36.8916667 0.256175 36.8944444 0.270069 36.8972222 0.279331 36.9000000 0.290137 36.9027778 0.291681 36.9055556 0.287050 36.9083333 0.274700 36.9111111 0.259262 36.9138889 0.240738 36.9166667 0.222213 36.9194444 0.205232 36.9222222 0.192882 36.9250000 0.188250 36.9277778 0.189794 36.9305556 0.191338 36.9333333 0.197513 36.9361111 0.199057 36.9388889 0.205232 36.9416667 0.223756 36.9444444 0.257719 36.9472222 0.300943 36.9500000 0.359605 36.9527778 0.412093 36.9555556 0.455317 36.9583333 0.484648 36.9611111 0.506261 36.9638889 0.518611 36.9666667 0.524786 36.9694444 0.529417 36.9722222 0.529417 36.9750000 0.518611 36.9777778 0.501630 36.9805556 0.480017 36.9833333 0.453774 36.9861111 0.424443 36.9888889 0.398199 36.9916667 0.365780 36.9944444 0.341081 36.9972222 0.310206 37.0000000 0.288593 37.0027778 0.270069 37.0055556 0.260806 37.0083333 0.254631 37.0111111 0.250000 37.0138889 0.250000 37.0166667 0.246913 37.0194444 0.245369 37.0222222 0.245369 37.0250000 0.245369 37.0277778 0.245369 37.0305556 0.242281 37.0333333 0.243825 37.0361111 0.239194 37.0388889 0.236106 37.0416667 0.233019 37.0444444 0.228388 37.0472222 0.231475 37.0500000 0.228388 37.0527778 0.233019 37.0555556 0.229931 37.0583333 0.231475 37.0611111 0.229931 37.0638889 0.231475 37.0666667 0.234563 37.0694444 0.228388 37.0722222 0.229931 37.0750000 0.229931 37.0777778 0.226844 37.0805556 0.222213 37.0833333 0.225300 37.0861111 0.222213 37.0888889 0.226844 37.0916667 0.228388 37.0944444 0.233019 37.0972222 0.228388 37.1000000 0.226844 37.1027778 0.226844 37.1055556 0.223756 37.1083333 0.219125 37.1111111 0.219125 37.1138889 0.220669 37.1166667 0.219125 37.1194444 0.220669 37.1222222 0.222213 37.1250000 0.222213 37.1277778 0.223756 37.1305556 0.225300 37.1333333 0.220669 37.1361111 0.216038 37.1388889 0.214494 37.1416667 0.212950 37.1444444 0.212950 37.1472222 0.209863 37.1500000 0.209863 37.1527778 0.209863 37.1555556 0.208319 37.1583333 0.212950 37.1611111 0.214494 37.1638889 0.211407 37.1666667 0.206775 37.1694444 0.206775 37.1722222 0.203688 37.1750000 0.203688 37.1777778 0.200600 37.1805556 0.197513 37.1833333 0.199057 37.1861111 0.195969 37.1888889 0.200600 37.1916667 0.199057 37.1944444 0.199057 37.1972222 0.197513 37.2000000 0.194425 37.2027778 0.191338 37.2055556 0.188250 37.2083333 0.185163 37.2111111 0.185163 37.2138889 0.186707 37.2166667 0.178988 37.2194444 0.183619 37.2222222 0.185163 37.2250000 0.186707 37.2277778 0.186707 37.2305556 0.185163 37.2333333 0.183619 37.6388889 0.245369 37.6416667 0.243825 37.6444444 0.240738 37.6472222 0.239194 37.6500000 0.239194 37.6527778 0.240738 37.6555556 0.243825 37.6583333 0.246913 37.6611111 0.248456 37.6638889 0.250000 37.6666667 0.250000 37.6694444 0.250000 37.6722222 0.251544 37.6750000 0.251544 37.6777778 0.257719 37.6805556 0.260806 37.6833333 0.259262 37.6861111 0.268525 37.6888889 0.273156 37.6916667 0.276244 37.6944444 0.276244 37.6972222 0.276244 37.7000000 0.273156 37.7027778 0.270069 37.7055556 0.263894 37.7083333 0.259262 37.7111111 0.254631 37.7138889 0.251544 37.7166667 0.250000 37.7194444 0.250000 37.7222222 0.251544 37.7250000 0.250000 37.7277778 0.254631 37.7305556 0.250000 37.7333333 0.246913 37.7361111 0.245369 37.7388889 0.242281 37.7416667 0.237650 37.7444444 0.237650 37.7472222 0.243825 37.7500000 0.242281 37.7527778 0.248456 37.7555556 0.246913 37.7583333 0.245369 37.7611111 0.248456 37.7638889 0.245369 37.7666667 0.243825 37.7694444 0.246913 37.7722222 0.242281 37.7750000 0.239194 37.7777778 0.239194 37.7805556 0.234563 37.7833333 0.240738 37.7861111 0.239194 37.7888889 0.243825 37.7916667 0.245369 37.7944444 0.250000 37.7972222 0.246913 37.8000000 0.246913 37.8027778 0.245369 37.8055556 0.243825 37.8083333 0.245369 37.8111111 0.240738 37.8138889 0.240738 37.8166667 0.243825 37.8194444 0.248456 37.8222222 0.248456 37.8250000 0.253087 37.8277778 0.254631 37.8305556 0.253087 37.8333333 0.254631 37.8361111 0.257719 37.8388889 0.257719 37.8416667 0.262350 37.8444444 0.265437 37.8472222 0.274700 37.8500000 0.290137 37.8527778 0.296312 37.8555556 0.296312 37.8583333 0.291681 37.8611111 0.285506 37.8638889 0.266981 37.8666667 0.250000 37.8694444 0.223756 37.8722222 0.209863 37.8750000 0.199057 37.8777778 0.192882 37.8805556 0.195969 37.8833333 0.191338 37.8861111 0.202144 37.8888889 0.206775 37.8916667 0.214494 37.8944444 0.229931 37.8972222 0.260806 37.9000000 0.304031 37.9027778 0.356518 37.9055556 0.405918 37.9083333 0.452230 37.9111111 0.483105 37.9138889 0.501630 37.9166667 0.517067 37.9194444 0.526329 37.9222222 0.535592 37.9250000 0.546398 37.9277778 0.541767 37.9305556 0.535592 37.9333333 0.520154 37.9361111 0.495455 37.9388889 0.472298 37.9416667 0.441424 37.9444444 0.409005 37.9472222 0.376587 37.9500000 0.345712 37.9527778 0.321012 37.9555556 0.300943 37.9583333 0.290137 37.9611111 0.283962 37.9638889 0.280875 37.9666667 0.274700 37.9694444 0.274700 37.9722222 0.265437 37.9750000 0.260806 37.9777778 0.260806 37.9805556 0.260806 37.9833333 0.256175 37.9861111 0.254631 37.9888889 0.251544 37.9916667 0.253087 37.9944444 0.256175 37.9972222 0.253087 38.0000000 0.254631 38.0027778 0.250000 38.0055556 0.251544 38.0083333 0.248456 38.0111111 0.245369 38.0138889 0.242281 38.0166667 0.246913 38.0194444 0.242281 38.0222222 0.245369 38.0250000 0.248456 38.0277778 0.245369 38.0305556 0.253087 38.0333333 0.248456 38.0361111 0.246913 38.0388889 0.245369 38.0416667 0.242281 38.0444444 0.239194 38.0472222 0.237650 38.0500000 0.239194 38.0527778 0.239194 38.0555556 0.245369 38.0583333 0.243825 38.0611111 0.248456 38.0638889 0.248456 38.0666667 0.245369 38.0694444 0.246913 38.0722222 0.240738 38.0750000 0.237650 38.0777778 0.237650 38.0805556 0.233019 38.0833333 0.229931 38.0861111 0.236106 38.0888889 0.234563 38.0916667 0.237650 38.0944444 0.237650 38.0972222 0.237650 38.1000000 0.234563 38.1027778 0.237650 38.1055556 0.229931 38.1083333 0.229931 38.1111111 0.225300 38.1138889 0.223756 38.1166667 0.223756 38.1194444 0.222213 38.1222222 0.226844 38.1250000 0.226844 38.1277778 0.228388 38.1305556 0.229931 38.1333333 0.225300 38.1361111 0.223756 38.1388889 0.220669 38.1416667 0.220669 38.1444444 0.216038 38.1472222 0.217581 38.1500000 0.214494 38.1527778 0.214494 38.1555556 0.212950 38.1583333 0.217581 38.1611111 0.217581 38.1638889 0.214494 38.1666667 0.208319 38.1694444 0.211407 38.1722222 0.208319 38.1750000 0.202144 38.1777778 0.197513 38.1805556 0.194425 38.1833333 0.197513 38.1861111 0.195969 38.3888889 0.250000)
Vrpeak rpeak_trigger 0 PWL(0.0000000 0.000000 0.4990000 0.000000 0.5000000 0.900000 0.5010000 0.900000 0.5020000 0.000000 1.4601111 0.000000 1.4611111 0.900000 1.4621111 0.900000 1.4631111 0.000000 2.3517778 0.000000 2.3527778 0.900000 2.3537778 0.900000 2.3547778 0.000000 4.0934444 0.000000 4.0944444 0.900000 4.0954444 0.900000 4.0964444 0.000000 5.0073333 0.000000 5.0083333 0.900000 5.0093333 0.900000 5.0103333 0.000000 5.8378889 0.000000 5.8388889 0.900000 5.8398889 0.900000 5.8408889 0.000000 6.7601111 0.000000 6.7611111 0.900000 6.7621111 0.900000 6.7631111 0.000000 7.6878889 0.000000 7.6888889 0.900000 7.6898889 0.900000 7.6908889 0.000000 8.5323333 0.000000 8.5333333 0.900000 8.5343333 0.900000 8.5353333 0.000000 9.4434444 0.000000 9.4444444 0.900000 9.4454444 0.900000 9.4464444 0.000000 10.3712222 0.000000 10.3722222 0.900000 10.3732222 0.900000 10.3742222 0.000000 11.2462222 0.000000 11.2472222 0.900000 11.2482222 0.900000 11.2492222 0.000000 12.1990000 0.000000 12.2000000 0.900000 12.2010000 0.900000 12.2020000 0.000000 13.2045556 0.000000 13.2055556 0.900000 13.2065556 0.900000 13.2075556 0.000000 14.0934444 0.000000 14.0944444 0.900000 14.0954444 0.900000 14.0964444 0.000000 15.0795556 0.000000 15.0805556 0.900000 15.0815556 0.900000 15.0825556 0.000000 16.1462222 0.000000 16.1472222 0.900000 16.1482222 0.900000 16.1492222 0.000000 17.0434444 0.000000 17.0444444 0.900000 17.0454444 0.900000 17.0464444 0.000000 18.0378889 0.000000 18.0388889 0.900000 18.0398889 0.900000 18.0408889 0.000000 19.0017778 0.000000 19.0027778 0.900000 19.0037778 0.900000 19.0047778 0.000000 19.8656667 0.000000 19.8666667 0.900000 19.8676667 0.900000 19.8686667 0.000000 20.8101111 0.000000 20.8111111 0.900000 20.8121111 0.900000 20.8131111 0.000000 21.7545556 0.000000 21.7555556 0.900000 21.7565556 0.900000 21.7575556 0.000000 22.6406667 0.000000 22.6416667 0.900000 22.6426667 0.900000 22.6436667 0.000000 23.6406667 0.000000 23.6416667 0.900000 23.6426667 0.900000 23.6436667 0.000000 24.6295556 0.000000 24.6305556 0.900000 24.6315556 0.900000 24.6325556 0.000000 25.5434444 0.000000 25.5444444 0.900000 25.5454444 0.900000 25.5464444 0.000000 26.5323333 0.000000 26.5333333 0.900000 26.5343333 0.900000 26.5353333 0.000000 27.5184444 0.000000 27.5194444 0.900000 27.5204444 0.900000 27.5214444 0.000000 28.4378889 0.000000 28.4388889 0.900000 28.4398889 0.900000 28.4408889 0.000000 29.4323333 0.000000 29.4333333 0.900000 29.4343333 0.900000 29.4353333 0.000000 30.3628889 0.000000 30.3638889 0.900000 30.3648889 0.900000 30.3658889 0.000000 31.2490000 0.000000 31.2500000 0.900000 31.2510000 0.900000 31.2520000 0.000000 32.2295556 0.000000 32.2305556 0.900000 32.2315556 0.900000 32.2325556 0.000000 33.2073333 0.000000 33.2083333 0.900000 33.2093333 0.900000 33.2103333 0.000000 34.0962222 0.000000 34.0972222 0.900000 34.0982222 0.900000 34.0992222 0.000000 35.0878889 0.000000 35.0888889 0.900000 35.0898889 0.900000 35.0908889 0.000000 36.0073333 0.000000 36.0083333 0.900000 36.0093333 0.900000 36.0103333 0.000000 36.9351111 0.000000 36.9361111 0.900000 36.9371111 0.900000 36.9381111 0.000000 37.8878889 0.000000 37.8888889 0.900000 37.8898889 0.900000 37.8908889 0.000000 38.3888889 0.000000)
Vqrs qrs_gate 0 PWL(0.0000000 0.000000 0.4690000 0.000000 0.4700000 0.900000 0.5716667 0.900000 0.5726667 0.000000 1.4273333 0.000000 1.4283333 0.900000 1.5355556 0.900000 1.5365556 0.000000 2.3245556 0.000000 2.3255556 0.900000 2.4216667 0.900000 2.4226667 0.000000 4.0773333 0.000000 4.0783333 0.900000 4.1105556 0.900000 4.1115556 0.000000 4.9940000 0.000000 4.9950000 0.900000 5.0772222 0.900000 5.0782222 0.000000 5.8245556 0.000000 5.8255556 0.900000 5.9050000 0.900000 5.9060000 0.000000 6.7440000 0.000000 6.7450000 0.900000 6.8272222 0.900000 6.8282222 0.000000 7.6745556 0.000000 7.6755556 0.900000 7.7605556 0.900000 7.7615556 0.000000 8.5162222 0.000000 8.5172222 0.900000 8.5994444 0.900000 8.6004444 0.000000 9.4273333 0.000000 9.4283333 0.900000 9.5105556 0.900000 9.5115556 0.000000 10.3412222 0.000000 10.3422222 0.900000 10.4494444 0.900000 10.4504444 0.000000 11.2162222 0.000000 11.2172222 0.900000 11.3188889 0.900000 11.3198889 0.000000 12.1634444 0.000000 12.1644444 0.900000 12.2744444 0.900000 12.2754444 0.000000 13.1717778 0.000000 13.1727778 0.900000 13.2855556 0.900000 13.2865556 0.000000 14.0578889 0.000000 14.0588889 0.900000 14.1716667 0.900000 14.1726667 0.000000 15.0440000 0.000000 15.0450000 0.900000 15.1550000 0.900000 15.1560000 0.000000 16.1134444 0.000000 16.1144444 0.900000 16.2216667 0.900000 16.2226667 0.000000 17.0051111 0.000000 17.0061111 0.900000 17.1244444 0.900000 17.1254444 0.000000 18.0023333 0.000000 18.0033333 0.900000 18.1188889 0.900000 18.1198889 0.000000 18.9690000 0.000000 18.9700000 0.900000 19.0744444 0.900000 19.0754444 0.000000 19.8051111 0.000000 19.8061111 0.900000 19.9577778 0.900000 19.9587778 0.000000 20.7690000 0.000000 20.7700000 0.900000 20.9022222 0.900000 20.9032222 0.000000 21.7217778 0.000000 21.7227778 0.900000 21.8300000 0.900000 21.8310000 0.000000 22.6051111 0.000000 22.6061111 0.900000 22.7133333 0.900000 22.7143333 0.000000 23.6051111 0.000000 23.6061111 0.900000 23.7161111 0.900000 23.7171111 0.000000 24.5995556 0.000000 24.6005556 0.900000 24.6994444 0.900000 24.7004444 0.000000 25.5106667 0.000000 25.5116667 0.900000 25.6216667 0.900000 25.6226667 0.000000 26.4967778 0.000000 26.4977778 0.900000 26.6077778 0.900000 26.6087778 0.000000 27.4856667 0.000000 27.4866667 0.900000 27.5938889 0.900000 27.5948889 0.000000 28.3995556 0.000000 28.4005556 0.900000 28.5272222 0.900000 28.5282222 0.000000 29.3717778 0.000000 29.3727778 0.900000 29.5438889 0.900000 29.5448889 0.000000 30.3273333 0.000000 30.3283333 0.900000 30.4383333 0.900000 30.4393333 0.000000 31.2051111 0.000000 31.2061111 0.900000 31.3383333 0.900000 31.3393333 0.000000 32.1940000 0.000000 32.1950000 0.900000 32.3133333 0.900000 32.3143333 0.000000 33.1717778 0.000000 33.1727778 0.900000 33.2911111 0.900000 33.2921111 0.000000 34.0578889 0.000000 34.0588889 0.900000 34.1966667 0.900000 34.1976667 0.000000 35.0467778 0.000000 35.0477778 0.900000 35.1772222 0.900000 35.1782222 0.000000 35.9717778 0.000000 35.9727778 0.900000 36.0911111 0.900000 36.0921111 0.000000 36.8745556 0.000000 36.8755556 0.900000 37.0300000 0.900000 37.0310000 0.000000 37.8495556 0.000000 37.8505556 0.900000 37.9688889 0.900000 37.9698889 0.000000 38.3888889 0.000000)
Vsym qrs_sym_gate 0 PWL(0.0000000 0.000000 0.4914444 0.000000 0.4924444 0.900000 0.5075556 0.900000 0.5085556 0.000000 1.4525556 0.000000 1.4535556 0.900000 1.4686667 0.900000 1.4696667 0.000000 2.3470000 0.000000 2.3480000 0.900000 2.3603333 0.900000 2.3613333 0.000000 4.0858889 0.000000 4.0868889 0.900000 4.1020000 0.900000 4.1030000 0.000000 5.0025556 0.000000 5.0035556 0.900000 5.0158889 0.900000 5.0168889 0.000000 5.8303333 0.000000 5.8313333 0.900000 5.8436667 0.900000 5.8446667 0.000000 6.7525556 0.000000 6.7535556 0.900000 6.7658889 0.900000 6.7668889 0.000000 7.6803333 0.000000 7.6813333 0.900000 7.6964444 0.900000 7.6974444 0.000000 8.5247778 0.000000 8.5257778 0.900000 8.5381111 0.900000 8.5391111 0.000000 9.4358889 0.000000 9.4368889 0.900000 9.4492222 0.900000 9.4502222 0.000000 10.3636667 0.000000 10.3646667 0.900000 10.3770000 0.900000 10.3780000 0.000000 11.2386667 0.000000 11.2396667 0.900000 11.2936667 0.900000 11.2946667 0.000000 12.1914444 0.000000 12.1924444 0.900000 12.2492222 0.900000 12.2502222 0.000000 13.1970000 0.000000 13.1980000 0.900000 13.2575556 0.900000 13.2585556 0.000000 14.0858889 0.000000 14.0868889 0.900000 14.1464444 0.900000 14.1474444 0.000000 15.0720000 0.000000 15.0730000 0.900000 15.1325556 0.900000 15.1335556 0.000000 16.1414444 0.000000 16.1424444 0.900000 16.1992222 0.900000 16.2002222 0.000000 17.0358889 0.000000 17.0368889 0.900000 17.0964444 0.900000 17.0974444 0.000000 18.0303333 0.000000 18.0313333 0.900000 18.0936667 0.900000 18.0946667 0.000000 18.9942222 0.000000 18.9952222 0.900000 19.0520000 0.900000 19.0530000 0.000000 19.8581111 0.000000 19.8591111 0.900000 19.9214444 0.900000 19.9224444 0.000000 20.8025556 0.000000 20.8035556 0.900000 20.8686667 0.900000 20.8696667 0.000000 21.7497778 0.000000 21.7507778 0.900000 21.8075556 0.900000 21.8085556 0.000000 22.6331111 0.000000 22.6341111 0.900000 22.6908889 0.900000 22.6918889 0.000000 23.6331111 0.000000 23.6341111 0.900000 23.6908889 0.900000 23.6918889 0.000000 24.6247778 0.000000 24.6257778 0.900000 24.6353333 0.900000 24.6363333 0.000000 25.5358889 0.000000 25.5368889 0.900000 25.5936667 0.900000 25.5946667 0.000000 26.5247778 0.000000 26.5257778 0.900000 26.5853333 0.900000 26.5863333 0.000000 27.5108889 0.000000 27.5118889 0.900000 27.5686667 0.900000 27.5696667 0.000000 28.4303333 0.000000 28.4313333 0.900000 28.4936667 0.900000 28.4946667 0.000000 29.4247778 0.000000 29.4257778 0.900000 29.4908889 0.900000 29.4918889 0.000000 30.3553333 0.000000 30.3563333 0.900000 30.4158889 0.900000 30.4168889 0.000000 31.2414444 0.000000 31.2424444 0.900000 31.3047778 0.900000 31.3057778 0.000000 32.2220000 0.000000 32.2230000 0.900000 32.2853333 0.900000 32.2863333 0.000000 33.2025556 0.000000 33.2035556 0.900000 33.2631111 0.900000 33.2641111 0.000000 34.0886667 0.000000 34.0896667 0.900000 34.1547778 0.900000 34.1557778 0.000000 35.0803333 0.000000 35.0813333 0.900000 35.1436667 0.900000 35.1446667 0.000000 35.9997778 0.000000 36.0007778 0.900000 36.0658889 0.900000 36.0668889 0.000000 36.9275556 0.000000 36.9285556 0.900000 36.9908889 0.900000 36.9918889 0.000000 37.8803333 0.000000 37.8813333 0.900000 37.9436667 0.900000 37.9446667 0.000000 38.3888889 0.000000)
Vpwave pwave_gate 0 PWL(0.0000000 0.000000 0.2934444 0.000000 0.2944444 0.900000 0.4444444 0.900000 0.4454444 0.000000 1.2545556 0.000000 1.2555556 0.900000 1.4055556 0.900000 1.4065556 0.000000 2.1462222 0.000000 2.1472222 0.900000 2.2972222 0.900000 2.2982222 0.000000 3.8878889 0.000000 3.8888889 0.900000 4.0388889 0.900000 4.0398889 0.000000 4.8017778 0.000000 4.8027778 0.900000 4.9527778 0.900000 4.9537778 0.000000 5.6323333 0.000000 5.6333333 0.900000 5.7833333 0.900000 5.7843333 0.000000 6.5545556 0.000000 6.5555556 0.900000 6.7055556 0.900000 6.7065556 0.000000 7.4823333 0.000000 7.4833333 0.900000 7.6333333 0.900000 7.6343333 0.000000 8.3267778 0.000000 8.3277778 0.900000 8.4777778 0.900000 8.4787778 0.000000 9.2378889 0.000000 9.2388889 0.900000 9.3888889 0.900000 9.3898889 0.000000 10.1656667 0.000000 10.1666667 0.900000 10.3166667 0.900000 10.3176667 0.000000 11.0406667 0.000000 11.0416667 0.900000 11.1916667 0.900000 11.1926667 0.000000 11.9934444 0.000000 11.9944444 0.900000 12.1444444 0.900000 12.1454444 0.000000 12.9990000 0.000000 13.0000000 0.900000 13.1500000 0.900000 13.1510000 0.000000 13.8878889 0.000000 13.8888889 0.900000 14.0388889 0.900000 14.0398889 0.000000 14.8740000 0.000000 14.8750000 0.900000 15.0250000 0.900000 15.0260000 0.000000 15.9406667 0.000000 15.9416667 0.900000 16.0916667 0.900000 16.0926667 0.000000 16.8378889 0.000000 16.8388889 0.900000 16.9888889 0.900000 16.9898889 0.000000 17.8323333 0.000000 17.8333333 0.900000 17.9833333 0.900000 17.9843333 0.000000 18.7962222 0.000000 18.7972222 0.900000 18.9472222 0.900000 18.9482222 0.000000 19.6601111 0.000000 19.6611111 0.900000 19.8111111 0.900000 19.8121111 0.000000 20.6045556 0.000000 20.6055556 0.900000 20.7555556 0.900000 20.7565556 0.000000 21.5490000 0.000000 21.5500000 0.900000 21.7000000 0.900000 21.7010000 0.000000 22.4351111 0.000000 22.4361111 0.900000 22.5861111 0.900000 22.5871111 0.000000 23.4351111 0.000000 23.4361111 0.900000 23.5861111 0.900000 23.5871111 0.000000 24.4240000 0.000000 24.4250000 0.900000 24.5750000 0.900000 24.5760000 0.000000 25.3378889 0.000000 25.3388889 0.900000 25.4888889 0.900000 25.4898889 0.000000 26.3267778 0.000000 26.3277778 0.900000 26.4777778 0.900000 26.4787778 0.000000 27.3128889 0.000000 27.3138889 0.900000 27.4638889 0.900000 27.4648889 0.000000 28.2323333 0.000000 28.2333333 0.900000 28.3833333 0.900000 28.3843333 0.000000 29.2267778 0.000000 29.2277778 0.900000 29.3777778 0.900000 29.3787778 0.000000 30.1573333 0.000000 30.1583333 0.900000 30.3083333 0.900000 30.3093333 0.000000 31.0434444 0.000000 31.0444444 0.900000 31.1944444 0.900000 31.1954444 0.000000 32.0240000 0.000000 32.0250000 0.900000 32.1750000 0.900000 32.1760000 0.000000 33.0017778 0.000000 33.0027778 0.900000 33.1527778 0.900000 33.1537778 0.000000 33.8906667 0.000000 33.8916667 0.900000 34.0416667 0.900000 34.0426667 0.000000 34.8823333 0.000000 34.8833333 0.900000 35.0333333 0.900000 35.0343333 0.000000 35.8017778 0.000000 35.8027778 0.900000 35.9527778 0.900000 35.9537778 0.000000 36.7295556 0.000000 36.7305556 0.900000 36.8805556 0.900000 36.8815556 0.000000 37.6823333 0.000000 37.6833333 0.900000 37.8333333 0.900000 37.8343333 0.000000 38.3888889 0.000000)

Xrr rpeak_trigger f_rr_ratio f_rr_asym vdd vss vbias rr_timing
Xinstab0 ecg_in qrs_gate rpeak_trigger f_instab_l0 peak_out_l0 vdd vss vbias vref beat_instability
Xinstab1 ecg_in_l1 qrs_gate rpeak_trigger f_instab_l1 peak_out_l1 vdd vss vbias vref beat_instability
Xpwave ecg_in_l1 pwave_gate rpeak_trigger f_pwave vdd vss vbias vref pwave_energy
Xwidth vref ecg_in qrs_gate rpeak_trigger f_width vdd vss vbias qrs_width
Xsym qrs_sym_gate rpeak_trigger f_sym rise_timer_out fall_timer_out vdd vss vbias qrs_symmetry
Xslope rise_timer_out fall_timer_out f_slope vdd vss vbias slope_ratio

* No IC needed - amplitude deviation uses fixed VREF

.tran 0.5m 38.3889

.meas tran f_rr_ratio_b0 FIND V(f_rr_ratio) AT=0.4950000
.meas tran f_rr_asym_b0 FIND V(f_rr_asym) AT=0.4950000
.meas tran f_instab_l0_b0 FIND V(f_instab_l0) AT=0.4950000
.meas tran f_instab_l1_b0 FIND V(f_instab_l1) AT=0.4950000
.meas tran f_pwave_b0 FIND V(f_pwave) AT=0.4950000
.meas tran f_width_b0 FIND V(f_width) AT=0.4950000
.meas tran f_sym_b0 FIND V(f_sym) AT=0.5065556
.meas tran f_slope_b0 FIND V(f_slope) AT=0.5065556
.meas tran f_rr_ratio_b1 FIND V(f_rr_ratio) AT=1.4561111
.meas tran f_rr_asym_b1 FIND V(f_rr_asym) AT=1.4561111
.meas tran f_instab_l0_b1 FIND V(f_instab_l0) AT=1.4561111
.meas tran f_instab_l1_b1 FIND V(f_instab_l1) AT=1.4561111
.meas tran f_pwave_b1 FIND V(f_pwave) AT=1.4561111
.meas tran f_width_b1 FIND V(f_width) AT=1.4561111
.meas tran f_sym_b1 FIND V(f_sym) AT=1.4676667
.meas tran f_slope_b1 FIND V(f_slope) AT=1.4676667
.meas tran f_rr_ratio_b2 FIND V(f_rr_ratio) AT=2.3477778
.meas tran f_rr_asym_b2 FIND V(f_rr_asym) AT=2.3477778
.meas tran f_instab_l0_b2 FIND V(f_instab_l0) AT=2.3477778
.meas tran f_instab_l1_b2 FIND V(f_instab_l1) AT=2.3477778
.meas tran f_pwave_b2 FIND V(f_pwave) AT=2.3477778
.meas tran f_width_b2 FIND V(f_width) AT=2.3477778
.meas tran f_sym_b2 FIND V(f_sym) AT=2.3593333
.meas tran f_slope_b2 FIND V(f_slope) AT=2.3593333
.meas tran f_rr_ratio_b3 FIND V(f_rr_ratio) AT=4.0894444
.meas tran f_rr_asym_b3 FIND V(f_rr_asym) AT=4.0894444
.meas tran f_instab_l0_b3 FIND V(f_instab_l0) AT=4.0894444
.meas tran f_instab_l1_b3 FIND V(f_instab_l1) AT=4.0894444
.meas tran f_pwave_b3 FIND V(f_pwave) AT=4.0894444
.meas tran f_width_b3 FIND V(f_width) AT=4.0894444
.meas tran f_sym_b3 FIND V(f_sym) AT=4.1010000
.meas tran f_slope_b3 FIND V(f_slope) AT=4.1010000
.meas tran f_rr_ratio_b4 FIND V(f_rr_ratio) AT=5.0033333
.meas tran f_rr_asym_b4 FIND V(f_rr_asym) AT=5.0033333
.meas tran f_instab_l0_b4 FIND V(f_instab_l0) AT=5.0033333
.meas tran f_instab_l1_b4 FIND V(f_instab_l1) AT=5.0033333
.meas tran f_pwave_b4 FIND V(f_pwave) AT=5.0033333
.meas tran f_width_b4 FIND V(f_width) AT=5.0033333
.meas tran f_sym_b4 FIND V(f_sym) AT=5.0148889
.meas tran f_slope_b4 FIND V(f_slope) AT=5.0148889
.meas tran f_rr_ratio_b5 FIND V(f_rr_ratio) AT=5.8338889
.meas tran f_rr_asym_b5 FIND V(f_rr_asym) AT=5.8338889
.meas tran f_instab_l0_b5 FIND V(f_instab_l0) AT=5.8338889
.meas tran f_instab_l1_b5 FIND V(f_instab_l1) AT=5.8338889
.meas tran f_pwave_b5 FIND V(f_pwave) AT=5.8338889
.meas tran f_width_b5 FIND V(f_width) AT=5.8338889
.meas tran f_sym_b5 FIND V(f_sym) AT=5.8426667
.meas tran f_slope_b5 FIND V(f_slope) AT=5.8426667
.meas tran f_rr_ratio_b6 FIND V(f_rr_ratio) AT=6.7561111
.meas tran f_rr_asym_b6 FIND V(f_rr_asym) AT=6.7561111
.meas tran f_instab_l0_b6 FIND V(f_instab_l0) AT=6.7561111
.meas tran f_instab_l1_b6 FIND V(f_instab_l1) AT=6.7561111
.meas tran f_pwave_b6 FIND V(f_pwave) AT=6.7561111
.meas tran f_width_b6 FIND V(f_width) AT=6.7561111
.meas tran f_sym_b6 FIND V(f_sym) AT=6.7648889
.meas tran f_slope_b6 FIND V(f_slope) AT=6.7648889
.meas tran f_rr_ratio_b7 FIND V(f_rr_ratio) AT=7.6838889
.meas tran f_rr_asym_b7 FIND V(f_rr_asym) AT=7.6838889
.meas tran f_instab_l0_b7 FIND V(f_instab_l0) AT=7.6838889
.meas tran f_instab_l1_b7 FIND V(f_instab_l1) AT=7.6838889
.meas tran f_pwave_b7 FIND V(f_pwave) AT=7.6838889
.meas tran f_width_b7 FIND V(f_width) AT=7.6838889
.meas tran f_sym_b7 FIND V(f_sym) AT=7.6954444
.meas tran f_slope_b7 FIND V(f_slope) AT=7.6954444
.meas tran f_rr_ratio_b8 FIND V(f_rr_ratio) AT=8.5283333
.meas tran f_rr_asym_b8 FIND V(f_rr_asym) AT=8.5283333
.meas tran f_instab_l0_b8 FIND V(f_instab_l0) AT=8.5283333
.meas tran f_instab_l1_b8 FIND V(f_instab_l1) AT=8.5283333
.meas tran f_pwave_b8 FIND V(f_pwave) AT=8.5283333
.meas tran f_width_b8 FIND V(f_width) AT=8.5283333
.meas tran f_sym_b8 FIND V(f_sym) AT=8.5371111
.meas tran f_slope_b8 FIND V(f_slope) AT=8.5371111
.meas tran f_rr_ratio_b9 FIND V(f_rr_ratio) AT=9.4394444
.meas tran f_rr_asym_b9 FIND V(f_rr_asym) AT=9.4394444
.meas tran f_instab_l0_b9 FIND V(f_instab_l0) AT=9.4394444
.meas tran f_instab_l1_b9 FIND V(f_instab_l1) AT=9.4394444
.meas tran f_pwave_b9 FIND V(f_pwave) AT=9.4394444
.meas tran f_width_b9 FIND V(f_width) AT=9.4394444
.meas tran f_sym_b9 FIND V(f_sym) AT=9.4482222
.meas tran f_slope_b9 FIND V(f_slope) AT=9.4482222
.meas tran f_rr_ratio_b10 FIND V(f_rr_ratio) AT=10.3672222
.meas tran f_rr_asym_b10 FIND V(f_rr_asym) AT=10.3672222
.meas tran f_instab_l0_b10 FIND V(f_instab_l0) AT=10.3672222
.meas tran f_instab_l1_b10 FIND V(f_instab_l1) AT=10.3672222
.meas tran f_pwave_b10 FIND V(f_pwave) AT=10.3672222
.meas tran f_width_b10 FIND V(f_width) AT=10.3672222
.meas tran f_sym_b10 FIND V(f_sym) AT=10.3760000
.meas tran f_slope_b10 FIND V(f_slope) AT=10.3760000
.meas tran f_rr_ratio_b11 FIND V(f_rr_ratio) AT=11.2422222
.meas tran f_rr_asym_b11 FIND V(f_rr_asym) AT=11.2422222
.meas tran f_instab_l0_b11 FIND V(f_instab_l0) AT=11.2422222
.meas tran f_instab_l1_b11 FIND V(f_instab_l1) AT=11.2422222
.meas tran f_pwave_b11 FIND V(f_pwave) AT=11.2422222
.meas tran f_width_b11 FIND V(f_width) AT=11.2422222
.meas tran f_sym_b11 FIND V(f_sym) AT=11.2926667
.meas tran f_slope_b11 FIND V(f_slope) AT=11.2926667
.meas tran f_rr_ratio_b12 FIND V(f_rr_ratio) AT=12.1950000
.meas tran f_rr_asym_b12 FIND V(f_rr_asym) AT=12.1950000
.meas tran f_instab_l0_b12 FIND V(f_instab_l0) AT=12.1950000
.meas tran f_instab_l1_b12 FIND V(f_instab_l1) AT=12.1950000
.meas tran f_pwave_b12 FIND V(f_pwave) AT=12.1950000
.meas tran f_width_b12 FIND V(f_width) AT=12.1950000
.meas tran f_sym_b12 FIND V(f_sym) AT=12.2482222
.meas tran f_slope_b12 FIND V(f_slope) AT=12.2482222
.meas tran f_rr_ratio_b13 FIND V(f_rr_ratio) AT=13.2005556
.meas tran f_rr_asym_b13 FIND V(f_rr_asym) AT=13.2005556
.meas tran f_instab_l0_b13 FIND V(f_instab_l0) AT=13.2005556
.meas tran f_instab_l1_b13 FIND V(f_instab_l1) AT=13.2005556
.meas tran f_pwave_b13 FIND V(f_pwave) AT=13.2005556
.meas tran f_width_b13 FIND V(f_width) AT=13.2005556
.meas tran f_sym_b13 FIND V(f_sym) AT=13.2565556
.meas tran f_slope_b13 FIND V(f_slope) AT=13.2565556
.meas tran f_rr_ratio_b14 FIND V(f_rr_ratio) AT=14.0894444
.meas tran f_rr_asym_b14 FIND V(f_rr_asym) AT=14.0894444
.meas tran f_instab_l0_b14 FIND V(f_instab_l0) AT=14.0894444
.meas tran f_instab_l1_b14 FIND V(f_instab_l1) AT=14.0894444
.meas tran f_pwave_b14 FIND V(f_pwave) AT=14.0894444
.meas tran f_width_b14 FIND V(f_width) AT=14.0894444
.meas tran f_sym_b14 FIND V(f_sym) AT=14.1454444
.meas tran f_slope_b14 FIND V(f_slope) AT=14.1454444
.meas tran f_rr_ratio_b15 FIND V(f_rr_ratio) AT=15.0755556
.meas tran f_rr_asym_b15 FIND V(f_rr_asym) AT=15.0755556
.meas tran f_instab_l0_b15 FIND V(f_instab_l0) AT=15.0755556
.meas tran f_instab_l1_b15 FIND V(f_instab_l1) AT=15.0755556
.meas tran f_pwave_b15 FIND V(f_pwave) AT=15.0755556
.meas tran f_width_b15 FIND V(f_width) AT=15.0755556
.meas tran f_sym_b15 FIND V(f_sym) AT=15.1315556
.meas tran f_slope_b15 FIND V(f_slope) AT=15.1315556
.meas tran f_rr_ratio_b16 FIND V(f_rr_ratio) AT=16.1422222
.meas tran f_rr_asym_b16 FIND V(f_rr_asym) AT=16.1422222
.meas tran f_instab_l0_b16 FIND V(f_instab_l0) AT=16.1422222
.meas tran f_instab_l1_b16 FIND V(f_instab_l1) AT=16.1422222
.meas tran f_pwave_b16 FIND V(f_pwave) AT=16.1422222
.meas tran f_width_b16 FIND V(f_width) AT=16.1422222
.meas tran f_sym_b16 FIND V(f_sym) AT=16.1982222
.meas tran f_slope_b16 FIND V(f_slope) AT=16.1982222
.meas tran f_rr_ratio_b17 FIND V(f_rr_ratio) AT=17.0394444
.meas tran f_rr_asym_b17 FIND V(f_rr_asym) AT=17.0394444
.meas tran f_instab_l0_b17 FIND V(f_instab_l0) AT=17.0394444
.meas tran f_instab_l1_b17 FIND V(f_instab_l1) AT=17.0394444
.meas tran f_pwave_b17 FIND V(f_pwave) AT=17.0394444
.meas tran f_width_b17 FIND V(f_width) AT=17.0394444
.meas tran f_sym_b17 FIND V(f_sym) AT=17.0954444
.meas tran f_slope_b17 FIND V(f_slope) AT=17.0954444
.meas tran f_rr_ratio_b18 FIND V(f_rr_ratio) AT=18.0338889
.meas tran f_rr_asym_b18 FIND V(f_rr_asym) AT=18.0338889
.meas tran f_instab_l0_b18 FIND V(f_instab_l0) AT=18.0338889
.meas tran f_instab_l1_b18 FIND V(f_instab_l1) AT=18.0338889
.meas tran f_pwave_b18 FIND V(f_pwave) AT=18.0338889
.meas tran f_width_b18 FIND V(f_width) AT=18.0338889
.meas tran f_sym_b18 FIND V(f_sym) AT=18.0926667
.meas tran f_slope_b18 FIND V(f_slope) AT=18.0926667
.meas tran f_rr_ratio_b19 FIND V(f_rr_ratio) AT=18.9977778
.meas tran f_rr_asym_b19 FIND V(f_rr_asym) AT=18.9977778
.meas tran f_instab_l0_b19 FIND V(f_instab_l0) AT=18.9977778
.meas tran f_instab_l1_b19 FIND V(f_instab_l1) AT=18.9977778
.meas tran f_pwave_b19 FIND V(f_pwave) AT=18.9977778
.meas tran f_width_b19 FIND V(f_width) AT=18.9977778
.meas tran f_sym_b19 FIND V(f_sym) AT=19.0510000
.meas tran f_slope_b19 FIND V(f_slope) AT=19.0510000
.meas tran f_rr_ratio_b20 FIND V(f_rr_ratio) AT=19.8616667
.meas tran f_rr_asym_b20 FIND V(f_rr_asym) AT=19.8616667
.meas tran f_instab_l0_b20 FIND V(f_instab_l0) AT=19.8616667
.meas tran f_instab_l1_b20 FIND V(f_instab_l1) AT=19.8616667
.meas tran f_pwave_b20 FIND V(f_pwave) AT=19.8616667
.meas tran f_width_b20 FIND V(f_width) AT=19.8616667
.meas tran f_sym_b20 FIND V(f_sym) AT=19.9204444
.meas tran f_slope_b20 FIND V(f_slope) AT=19.9204444
.meas tran f_rr_ratio_b21 FIND V(f_rr_ratio) AT=20.8061111
.meas tran f_rr_asym_b21 FIND V(f_rr_asym) AT=20.8061111
.meas tran f_instab_l0_b21 FIND V(f_instab_l0) AT=20.8061111
.meas tran f_instab_l1_b21 FIND V(f_instab_l1) AT=20.8061111
.meas tran f_pwave_b21 FIND V(f_pwave) AT=20.8061111
.meas tran f_width_b21 FIND V(f_width) AT=20.8061111
.meas tran f_sym_b21 FIND V(f_sym) AT=20.8676667
.meas tran f_slope_b21 FIND V(f_slope) AT=20.8676667
.meas tran f_rr_ratio_b22 FIND V(f_rr_ratio) AT=21.7505556
.meas tran f_rr_asym_b22 FIND V(f_rr_asym) AT=21.7505556
.meas tran f_instab_l0_b22 FIND V(f_instab_l0) AT=21.7505556
.meas tran f_instab_l1_b22 FIND V(f_instab_l1) AT=21.7505556
.meas tran f_pwave_b22 FIND V(f_pwave) AT=21.7505556
.meas tran f_width_b22 FIND V(f_width) AT=21.7505556
.meas tran f_sym_b22 FIND V(f_sym) AT=21.8065556
.meas tran f_slope_b22 FIND V(f_slope) AT=21.8065556
.meas tran f_rr_ratio_b23 FIND V(f_rr_ratio) AT=22.6366667
.meas tran f_rr_asym_b23 FIND V(f_rr_asym) AT=22.6366667
.meas tran f_instab_l0_b23 FIND V(f_instab_l0) AT=22.6366667
.meas tran f_instab_l1_b23 FIND V(f_instab_l1) AT=22.6366667
.meas tran f_pwave_b23 FIND V(f_pwave) AT=22.6366667
.meas tran f_width_b23 FIND V(f_width) AT=22.6366667
.meas tran f_sym_b23 FIND V(f_sym) AT=22.6898889
.meas tran f_slope_b23 FIND V(f_slope) AT=22.6898889
.meas tran f_rr_ratio_b24 FIND V(f_rr_ratio) AT=23.6366667
.meas tran f_rr_asym_b24 FIND V(f_rr_asym) AT=23.6366667
.meas tran f_instab_l0_b24 FIND V(f_instab_l0) AT=23.6366667
.meas tran f_instab_l1_b24 FIND V(f_instab_l1) AT=23.6366667
.meas tran f_pwave_b24 FIND V(f_pwave) AT=23.6366667
.meas tran f_width_b24 FIND V(f_width) AT=23.6366667
.meas tran f_sym_b24 FIND V(f_sym) AT=23.6898889
.meas tran f_slope_b24 FIND V(f_slope) AT=23.6898889
.meas tran f_rr_ratio_b25 FIND V(f_rr_ratio) AT=24.6255556
.meas tran f_rr_asym_b25 FIND V(f_rr_asym) AT=24.6255556
.meas tran f_instab_l0_b25 FIND V(f_instab_l0) AT=24.6255556
.meas tran f_instab_l1_b25 FIND V(f_instab_l1) AT=24.6255556
.meas tran f_pwave_b25 FIND V(f_pwave) AT=24.6255556
.meas tran f_width_b25 FIND V(f_width) AT=24.6255556
.meas tran f_sym_b25 FIND V(f_sym) AT=24.6343333
.meas tran f_slope_b25 FIND V(f_slope) AT=24.6343333
.meas tran f_rr_ratio_b26 FIND V(f_rr_ratio) AT=25.5394444
.meas tran f_rr_asym_b26 FIND V(f_rr_asym) AT=25.5394444
.meas tran f_instab_l0_b26 FIND V(f_instab_l0) AT=25.5394444
.meas tran f_instab_l1_b26 FIND V(f_instab_l1) AT=25.5394444
.meas tran f_pwave_b26 FIND V(f_pwave) AT=25.5394444
.meas tran f_width_b26 FIND V(f_width) AT=25.5394444
.meas tran f_sym_b26 FIND V(f_sym) AT=25.5926667
.meas tran f_slope_b26 FIND V(f_slope) AT=25.5926667
.meas tran f_rr_ratio_b27 FIND V(f_rr_ratio) AT=26.5283333
.meas tran f_rr_asym_b27 FIND V(f_rr_asym) AT=26.5283333
.meas tran f_instab_l0_b27 FIND V(f_instab_l0) AT=26.5283333
.meas tran f_instab_l1_b27 FIND V(f_instab_l1) AT=26.5283333
.meas tran f_pwave_b27 FIND V(f_pwave) AT=26.5283333
.meas tran f_width_b27 FIND V(f_width) AT=26.5283333
.meas tran f_sym_b27 FIND V(f_sym) AT=26.5843333
.meas tran f_slope_b27 FIND V(f_slope) AT=26.5843333
.meas tran f_rr_ratio_b28 FIND V(f_rr_ratio) AT=27.5144444
.meas tran f_rr_asym_b28 FIND V(f_rr_asym) AT=27.5144444
.meas tran f_instab_l0_b28 FIND V(f_instab_l0) AT=27.5144444
.meas tran f_instab_l1_b28 FIND V(f_instab_l1) AT=27.5144444
.meas tran f_pwave_b28 FIND V(f_pwave) AT=27.5144444
.meas tran f_width_b28 FIND V(f_width) AT=27.5144444
.meas tran f_sym_b28 FIND V(f_sym) AT=27.5676667
.meas tran f_slope_b28 FIND V(f_slope) AT=27.5676667
.meas tran f_rr_ratio_b29 FIND V(f_rr_ratio) AT=28.4338889
.meas tran f_rr_asym_b29 FIND V(f_rr_asym) AT=28.4338889
.meas tran f_instab_l0_b29 FIND V(f_instab_l0) AT=28.4338889
.meas tran f_instab_l1_b29 FIND V(f_instab_l1) AT=28.4338889
.meas tran f_pwave_b29 FIND V(f_pwave) AT=28.4338889
.meas tran f_width_b29 FIND V(f_width) AT=28.4338889
.meas tran f_sym_b29 FIND V(f_sym) AT=28.4926667
.meas tran f_slope_b29 FIND V(f_slope) AT=28.4926667
.meas tran f_rr_ratio_b30 FIND V(f_rr_ratio) AT=29.4283333
.meas tran f_rr_asym_b30 FIND V(f_rr_asym) AT=29.4283333
.meas tran f_instab_l0_b30 FIND V(f_instab_l0) AT=29.4283333
.meas tran f_instab_l1_b30 FIND V(f_instab_l1) AT=29.4283333
.meas tran f_pwave_b30 FIND V(f_pwave) AT=29.4283333
.meas tran f_width_b30 FIND V(f_width) AT=29.4283333
.meas tran f_sym_b30 FIND V(f_sym) AT=29.4898889
.meas tran f_slope_b30 FIND V(f_slope) AT=29.4898889
.meas tran f_rr_ratio_b31 FIND V(f_rr_ratio) AT=30.3588889
.meas tran f_rr_asym_b31 FIND V(f_rr_asym) AT=30.3588889
.meas tran f_instab_l0_b31 FIND V(f_instab_l0) AT=30.3588889
.meas tran f_instab_l1_b31 FIND V(f_instab_l1) AT=30.3588889
.meas tran f_pwave_b31 FIND V(f_pwave) AT=30.3588889
.meas tran f_width_b31 FIND V(f_width) AT=30.3588889
.meas tran f_sym_b31 FIND V(f_sym) AT=30.4148889
.meas tran f_slope_b31 FIND V(f_slope) AT=30.4148889
.meas tran f_rr_ratio_b32 FIND V(f_rr_ratio) AT=31.2450000
.meas tran f_rr_asym_b32 FIND V(f_rr_asym) AT=31.2450000
.meas tran f_instab_l0_b32 FIND V(f_instab_l0) AT=31.2450000
.meas tran f_instab_l1_b32 FIND V(f_instab_l1) AT=31.2450000
.meas tran f_pwave_b32 FIND V(f_pwave) AT=31.2450000
.meas tran f_width_b32 FIND V(f_width) AT=31.2450000
.meas tran f_sym_b32 FIND V(f_sym) AT=31.3037778
.meas tran f_slope_b32 FIND V(f_slope) AT=31.3037778
.meas tran f_rr_ratio_b33 FIND V(f_rr_ratio) AT=32.2255556
.meas tran f_rr_asym_b33 FIND V(f_rr_asym) AT=32.2255556
.meas tran f_instab_l0_b33 FIND V(f_instab_l0) AT=32.2255556
.meas tran f_instab_l1_b33 FIND V(f_instab_l1) AT=32.2255556
.meas tran f_pwave_b33 FIND V(f_pwave) AT=32.2255556
.meas tran f_width_b33 FIND V(f_width) AT=32.2255556
.meas tran f_sym_b33 FIND V(f_sym) AT=32.2843333
.meas tran f_slope_b33 FIND V(f_slope) AT=32.2843333
.meas tran f_rr_ratio_b34 FIND V(f_rr_ratio) AT=33.2033333
.meas tran f_rr_asym_b34 FIND V(f_rr_asym) AT=33.2033333
.meas tran f_instab_l0_b34 FIND V(f_instab_l0) AT=33.2033333
.meas tran f_instab_l1_b34 FIND V(f_instab_l1) AT=33.2033333
.meas tran f_pwave_b34 FIND V(f_pwave) AT=33.2033333
.meas tran f_width_b34 FIND V(f_width) AT=33.2033333
.meas tran f_sym_b34 FIND V(f_sym) AT=33.2621111
.meas tran f_slope_b34 FIND V(f_slope) AT=33.2621111
.meas tran f_rr_ratio_b35 FIND V(f_rr_ratio) AT=34.0922222
.meas tran f_rr_asym_b35 FIND V(f_rr_asym) AT=34.0922222
.meas tran f_instab_l0_b35 FIND V(f_instab_l0) AT=34.0922222
.meas tran f_instab_l1_b35 FIND V(f_instab_l1) AT=34.0922222
.meas tran f_pwave_b35 FIND V(f_pwave) AT=34.0922222
.meas tran f_width_b35 FIND V(f_width) AT=34.0922222
.meas tran f_sym_b35 FIND V(f_sym) AT=34.1537778
.meas tran f_slope_b35 FIND V(f_slope) AT=34.1537778
.meas tran f_rr_ratio_b36 FIND V(f_rr_ratio) AT=35.0838889
.meas tran f_rr_asym_b36 FIND V(f_rr_asym) AT=35.0838889
.meas tran f_instab_l0_b36 FIND V(f_instab_l0) AT=35.0838889
.meas tran f_instab_l1_b36 FIND V(f_instab_l1) AT=35.0838889
.meas tran f_pwave_b36 FIND V(f_pwave) AT=35.0838889
.meas tran f_width_b36 FIND V(f_width) AT=35.0838889
.meas tran f_sym_b36 FIND V(f_sym) AT=35.1426667
.meas tran f_slope_b36 FIND V(f_slope) AT=35.1426667
.meas tran f_rr_ratio_b37 FIND V(f_rr_ratio) AT=36.0033333
.meas tran f_rr_asym_b37 FIND V(f_rr_asym) AT=36.0033333
.meas tran f_instab_l0_b37 FIND V(f_instab_l0) AT=36.0033333
.meas tran f_instab_l1_b37 FIND V(f_instab_l1) AT=36.0033333
.meas tran f_pwave_b37 FIND V(f_pwave) AT=36.0033333
.meas tran f_width_b37 FIND V(f_width) AT=36.0033333
.meas tran f_sym_b37 FIND V(f_sym) AT=36.0648889
.meas tran f_slope_b37 FIND V(f_slope) AT=36.0648889
.meas tran f_rr_ratio_b38 FIND V(f_rr_ratio) AT=36.9311111
.meas tran f_rr_asym_b38 FIND V(f_rr_asym) AT=36.9311111
.meas tran f_instab_l0_b38 FIND V(f_instab_l0) AT=36.9311111
.meas tran f_instab_l1_b38 FIND V(f_instab_l1) AT=36.9311111
.meas tran f_pwave_b38 FIND V(f_pwave) AT=36.9311111
.meas tran f_width_b38 FIND V(f_width) AT=36.9311111
.meas tran f_sym_b38 FIND V(f_sym) AT=36.9898889
.meas tran f_slope_b38 FIND V(f_slope) AT=36.9898889
.meas tran f_rr_ratio_b39 FIND V(f_rr_ratio) AT=37.8838889
.meas tran f_rr_asym_b39 FIND V(f_rr_asym) AT=37.8838889
.meas tran f_instab_l0_b39 FIND V(f_instab_l0) AT=37.8838889
.meas tran f_instab_l1_b39 FIND V(f_instab_l1) AT=37.8838889
.meas tran f_pwave_b39 FIND V(f_pwave) AT=37.8838889
.meas tran f_width_b39 FIND V(f_width) AT=37.8838889
.meas tran f_sym_b39 FIND V(f_sym) AT=37.9426667
.meas tran f_slope_b39 FIND V(f_slope) AT=37.9426667

.end
