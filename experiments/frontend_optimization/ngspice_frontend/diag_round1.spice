* Diagnostic Round 1: Full Frontend Test
* 3 beats with varying amplitude and RR intervals

.title diag_round1

.lib "sky130_minimal.lib.spice" tt
.option scale=1.0u
.option method=gear
.option gmin=1e-15
.option abstol=1e-15
.option reltol=0.005
.temp 27

.include "ota_5t_subthreshold.spice"
.include "inverter.spice"
.include "resistor_div.spice"
.include "rr_timing.spice"
.include "beat_instability.spice"
.include "pwave_energy.spice"
.include "qrs_width.spice"
.include "slope_ratio.spice"
.include "qrs_symmetry.spice"

* --- Power supply ---
Vdd vdd 0 0.9
Vss vss 0 0
Vbias vbias 0 0.35
Vref vref 0 0.45

* --- Input signals ---
Vecg ecg_in 0 PWL(0.000000 0.150000 0.349000 0.150000 0.400000 0.200000 0.450000 0.150000 0.459000 0.150000 0.488000 0.250000 0.500000 0.650000 0.520000 0.100000 0.540000 0.150000 0.949000 0.150000 1.000000 0.180000 1.050000 0.150000 1.059000 0.150000 1.088000 0.210000 1.100000 0.450000 1.120000 0.120000 1.140000 0.150000 1.849000 0.150000 1.900000 0.210000 1.950000 0.150000 1.959000 0.150000 1.988000 0.270000 2.000000 0.750000 2.020000 0.090000 2.040000 0.150000 2.500000 0.150000)
Vecg2 ecg_in_l1 0 PWL(0.000000 0.150000 0.349000 0.150000 0.400000 0.200000 0.450000 0.150000 0.459000 0.150000 0.488000 0.250000 0.500000 0.650000 0.520000 0.100000 0.540000 0.150000 0.949000 0.150000 1.000000 0.180000 1.050000 0.150000 1.059000 0.150000 1.088000 0.210000 1.100000 0.450000 1.120000 0.120000 1.140000 0.150000 1.849000 0.150000 1.900000 0.210000 1.950000 0.150000 1.959000 0.150000 1.988000 0.270000 2.000000 0.750000 2.020000 0.090000 2.040000 0.150000 2.500000 0.150000)
Vrpeak rpeak_trigger 0 PWL(0.000000 0.000000 0.499000 0.000000 0.500000 0.900000 0.501000 0.900000 0.502000 0.000000 1.099000 0.000000 1.100000 0.900000 1.101000 0.900000 1.102000 0.000000 1.999000 0.000000 2.000000 0.900000 2.001000 0.900000 2.002000 0.000000 2.500000 0.000000)
Vqrs qrs_gate 0 PWL(0.000000 0.000000 0.459000 0.000000 0.460000 0.900000 0.540000 0.900000 0.541000 0.000000 1.059000 0.000000 1.060000 0.900000 1.140000 0.900000 1.141000 0.000000 1.959000 0.000000 1.960000 0.900000 2.040000 0.900000 2.041000 0.000000 2.500000 0.000000)
Vpwave pwave_gate 0 PWL(0.000000 0.000000 0.349000 0.000000 0.350000 0.900000 0.450000 0.900000 0.451000 0.000000 0.949000 0.000000 0.950000 0.900000 1.050000 0.900000 1.051000 0.000000 1.849000 0.000000 1.850000 0.900000 1.950000 0.900000 1.951000 0.000000 2.500000 0.000000)

* --- Stage 3: Feature extraction circuits ---
* rr_timing: rpeak_trigger rr_ratio_out rr_asym_out vdd vss vbias
Xrr rpeak_trigger f_rr_ratio f_rr_asym vdd vss vbias rr_timing

* beat_instability: ecg_in qrs_gate rpeak_trigger instab_out peak_out vdd vss vbias vref
Xinstab0 ecg_in qrs_gate rpeak_trigger f_instab_l0 peak_out_l0 vdd vss vbias vref beat_instability
Xinstab1 ecg_in_l1 qrs_gate rpeak_trigger f_instab_l1 peak_out_l1 vdd vss vbias vref beat_instability

* pwave_energy: ecg_in pwave_gate rpeak_trigger pw_energy_out vdd vss vbias vref
Xpwave ecg_in_l1 pwave_gate rpeak_trigger f_pwave vdd vss vbias vref pwave_energy

* qrs_width: peak_voltage ecg_in qrs_gate rpeak_trigger width_out vdd vss vbias
* Use vref as peak reference (NMOS SF Vgs drop makes peak_out too low)
Xwidth vref ecg_in qrs_gate rpeak_trigger f_width vdd vss vbias qrs_width

* qrs_symmetry: qrs_onset peak_detect width_voltage sym_out sym_timer_out rpeak_trigger vdd vss vbias
* qrs_onset = qrs_gate, peak_detect = rpeak_trigger (approximation)
Xsym qrs_gate rpeak_trigger f_width f_sym sym_timer_out rpeak_trigger vdd vss vbias qrs_symmetry

* slope_ratio: width_voltage sym_timer_voltage slope_out vdd vss
Xslope f_width sym_timer_out f_slope vdd vss slope_ratio

* --- Analysis ---
.tran 0.1m 2.3

* Measurements at 5ms before each rpeak (before integrators reset)
.meas tran f_rr_ratio_pre_b1 FIND V(f_rr_ratio) AT=0.495000
.meas tran f_rr_asym_pre_b1 FIND V(f_rr_asym) AT=0.495000
.meas tran f_instab_l0_pre_b1 FIND V(f_instab_l0) AT=0.495000
.meas tran f_instab_l1_pre_b1 FIND V(f_instab_l1) AT=0.495000
.meas tran f_pwave_pre_b1 FIND V(f_pwave) AT=0.495000
.meas tran f_width_pre_b1 FIND V(f_width) AT=0.495000
.meas tran f_slope_pre_b1 FIND V(f_slope) AT=0.495000
.meas tran f_sym_pre_b1 FIND V(f_sym) AT=0.495000
.meas tran peak_out_l0_pre_b1 FIND V(peak_out_l0) AT=0.495000
.meas tran ecg_in_pre_b1 FIND V(ecg_in) AT=0.495000
.meas tran sym_timer_out_pre_b1 FIND V(sym_timer_out) AT=0.495000
.meas tran f_rr_ratio_pre_b2 FIND V(f_rr_ratio) AT=1.095000
.meas tran f_rr_asym_pre_b2 FIND V(f_rr_asym) AT=1.095000
.meas tran f_instab_l0_pre_b2 FIND V(f_instab_l0) AT=1.095000
.meas tran f_instab_l1_pre_b2 FIND V(f_instab_l1) AT=1.095000
.meas tran f_pwave_pre_b2 FIND V(f_pwave) AT=1.095000
.meas tran f_width_pre_b2 FIND V(f_width) AT=1.095000
.meas tran f_slope_pre_b2 FIND V(f_slope) AT=1.095000
.meas tran f_sym_pre_b2 FIND V(f_sym) AT=1.095000
.meas tran peak_out_l0_pre_b2 FIND V(peak_out_l0) AT=1.095000
.meas tran ecg_in_pre_b2 FIND V(ecg_in) AT=1.095000
.meas tran sym_timer_out_pre_b2 FIND V(sym_timer_out) AT=1.095000
.meas tran f_rr_ratio_pre_b3 FIND V(f_rr_ratio) AT=1.995000
.meas tran f_rr_asym_pre_b3 FIND V(f_rr_asym) AT=1.995000
.meas tran f_instab_l0_pre_b3 FIND V(f_instab_l0) AT=1.995000
.meas tran f_instab_l1_pre_b3 FIND V(f_instab_l1) AT=1.995000
.meas tran f_pwave_pre_b3 FIND V(f_pwave) AT=1.995000
.meas tran f_width_pre_b3 FIND V(f_width) AT=1.995000
.meas tran f_slope_pre_b3 FIND V(f_slope) AT=1.995000
.meas tran f_sym_pre_b3 FIND V(f_sym) AT=1.995000
.meas tran peak_out_l0_pre_b3 FIND V(peak_out_l0) AT=1.995000
.meas tran ecg_in_pre_b3 FIND V(ecg_in) AT=1.995000
.meas tran sym_timer_out_pre_b3 FIND V(sym_timer_out) AT=1.995000
.meas tran f_rr_ratio_post_b1 FIND V(f_rr_ratio) AT=0.520000
.meas tran f_rr_asym_post_b1 FIND V(f_rr_asym) AT=0.520000
.meas tran f_instab_l0_post_b1 FIND V(f_instab_l0) AT=0.520000
.meas tran f_instab_l1_post_b1 FIND V(f_instab_l1) AT=0.520000
.meas tran f_pwave_post_b1 FIND V(f_pwave) AT=0.520000
.meas tran f_width_post_b1 FIND V(f_width) AT=0.520000
.meas tran f_slope_post_b1 FIND V(f_slope) AT=0.520000
.meas tran f_sym_post_b1 FIND V(f_sym) AT=0.520000
.meas tran f_rr_ratio_post_b2 FIND V(f_rr_ratio) AT=1.120000
.meas tran f_rr_asym_post_b2 FIND V(f_rr_asym) AT=1.120000
.meas tran f_instab_l0_post_b2 FIND V(f_instab_l0) AT=1.120000
.meas tran f_instab_l1_post_b2 FIND V(f_instab_l1) AT=1.120000
.meas tran f_pwave_post_b2 FIND V(f_pwave) AT=1.120000
.meas tran f_width_post_b2 FIND V(f_width) AT=1.120000
.meas tran f_slope_post_b2 FIND V(f_slope) AT=1.120000
.meas tran f_sym_post_b2 FIND V(f_sym) AT=1.120000
.meas tran f_rr_ratio_post_b3 FIND V(f_rr_ratio) AT=2.020000
.meas tran f_rr_asym_post_b3 FIND V(f_rr_asym) AT=2.020000
.meas tran f_instab_l0_post_b3 FIND V(f_instab_l0) AT=2.020000
.meas tran f_instab_l1_post_b3 FIND V(f_instab_l1) AT=2.020000
.meas tran f_pwave_post_b3 FIND V(f_pwave) AT=2.020000
.meas tran f_width_post_b3 FIND V(f_width) AT=2.020000
.meas tran f_slope_post_b3 FIND V(f_slope) AT=2.020000
.meas tran f_sym_post_b3 FIND V(f_sym) AT=2.020000

.end
