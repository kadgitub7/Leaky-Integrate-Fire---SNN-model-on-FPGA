* =================================================================
* PFET-Input Max Detector — Isolation Test
* =================================================================
* 6 scenarios: each cell wins, plus close-margin test
* Winner = HIGHEST output voltage (argmax compatible)
* =================================================================

* --- SKY130 models ---
.include "C:/src/skywater-pdk-libs-sky130_fd_pr/cells/nfet_01v8/sky130_fd_pr__nfet_01v8__tt.corner.spice"
.include "C:/src/skywater-pdk-libs-sky130_fd_pr/cells/nfet_01v8/sky130_fd_pr__nfet_01v8__mismatch.corner.spice"
.include "C:/src/skywater-pdk-libs-sky130_fd_pr/cells/pfet_01v8/sky130_fd_pr__pfet_01v8__tt.corner.spice"
.include "C:/src/skywater-pdk-libs-sky130_fd_pr/cells/pfet_01v8/sky130_fd_pr__pfet_01v8__mismatch.corner.spice"

* Zero PFET mismatch for clean isolation test
.param sky130_fd_pr__pfet_01v8__a0_diff = 0
.param sky130_fd_pr__pfet_01v8__agidl_diff = 0
.param sky130_fd_pr__pfet_01v8__ags_diff = 0
.param sky130_fd_pr__pfet_01v8__b0_diff = 0
.param sky130_fd_pr__pfet_01v8__b1_diff = 0
.param sky130_fd_pr__pfet_01v8__bgidl_diff = 0
.param sky130_fd_pr__pfet_01v8__cgidl_diff = 0
.param sky130_fd_pr__pfet_01v8__dlc_diff = 0
.param sky130_fd_pr__pfet_01v8__dwc_diff = 0
.param sky130_fd_pr__pfet_01v8__eta0_diff = 0
.param sky130_fd_pr__pfet_01v8__k2_diff = 0
.param sky130_fd_pr__pfet_01v8__keta_diff = 0
.param sky130_fd_pr__pfet_01v8__kt1_diff = 0
.param sky130_fd_pr__pfet_01v8__ku0_diff = 0
.param sky130_fd_pr__pfet_01v8__kvsat_diff = 0
.param sky130_fd_pr__pfet_01v8__kvth0_diff = 0
.param sky130_fd_pr__pfet_01v8__lint_diff = 0
.param sky130_fd_pr__pfet_01v8__lku0_diff = 0
.param sky130_fd_pr__pfet_01v8__lkvth0_diff = 0
.param sky130_fd_pr__pfet_01v8__nfactor_diff = 0
.param sky130_fd_pr__pfet_01v8__pclm_diff = 0
.param sky130_fd_pr__pfet_01v8__pdits_diff = 0
.param sky130_fd_pr__pfet_01v8__pditsd_diff = 0
.param sky130_fd_pr__pfet_01v8__rdsw_diff = 0
.param sky130_fd_pr__pfet_01v8__tvoff_diff = 0
.param sky130_fd_pr__pfet_01v8__u0_diff = 0
.param sky130_fd_pr__pfet_01v8__ua_diff = 0
.param sky130_fd_pr__pfet_01v8__ub_diff = 0
.param sky130_fd_pr__pfet_01v8__voff_diff = 0
.param sky130_fd_pr__pfet_01v8__vsat_diff = 0
.param sky130_fd_pr__pfet_01v8__vth0_diff = 0
.param sky130_fd_pr__pfet_01v8__wint_diff = 0
.param sky130_fd_pr__pfet_01v8__wku0_diff = 0
.param sky130_fd_pr__pfet_01v8__wkvth0_diff = 0
.param sky130_fd_pr__pfet_01v8__wlod_diff = 0

* --- Supply ---
VDD vdd 0 1.8

* --- NFET bias (10uA for source follower current sinks) ---
Ibias_n vdd nbias 10u
Xbd nbias nbias 0 0 sky130_fd_pr__nfet_01v8 W=2.0u L=0.5u

* --- PFET bias (10uA for tail current source) ---
Ibias_p pbias 0 10u
Xpbd pbias pbias vdd vdd sky130_fd_pr__pfet_01v8 W=4.0u L=0.5u

* --- Include WTA subcircuit ---
.include "wta_5class_fixed.spice"

* --- Instantiate ---
XWTA in0 in1 in2 in3 in4 out0 out1 out2 out3 out4 vdd 0 nbias pbias wta_5class

* =================================================================
* Test inputs: each scenario 20us, 1us ramp transitions
* Scenario 1 (0-20us):   Cell 0 wins (0.95V highest)
* Scenario 2 (20-40us):  Cell 1 wins
* Scenario 3 (40-60us):  Cell 2 wins
* Scenario 4 (60-80us):  Cell 3 wins
* Scenario 5 (80-100us): Cell 4 wins
* Scenario 6 (100-120us): Close margin (in0=0.82V vs 0.80V)
* =================================================================

Vin0 in0 0 PWL(
+ 0 0.0  1u 0.95
+ 19u 0.95  21u 0.70
+ 39u 0.70  41u 0.70
+ 59u 0.70  61u 0.70
+ 79u 0.70  81u 0.70
+ 99u 0.70  101u 0.82
+ 120u 0.82)

Vin1 in1 0 PWL(
+ 0 0.0  1u 0.70
+ 19u 0.70  21u 0.95
+ 39u 0.95  41u 0.75
+ 59u 0.75  61u 0.75
+ 79u 0.75  81u 0.75
+ 99u 0.75  101u 0.80
+ 120u 0.80)

Vin2 in2 0 PWL(
+ 0 0.0  1u 0.80
+ 19u 0.80  21u 0.80
+ 39u 0.80  41u 0.95
+ 59u 0.95  61u 0.60
+ 79u 0.60  81u 0.60
+ 99u 0.60  101u 0.80
+ 120u 0.80)

Vin3 in3 0 PWL(
+ 0 0.0  1u 0.75
+ 19u 0.75  21u 0.75
+ 39u 0.75  41u 0.80
+ 59u 0.80  61u 0.95
+ 79u 0.95  81u 0.80
+ 99u 0.80  101u 0.80
+ 120u 0.80)

Vin4 in4 0 PWL(
+ 0 0.0  1u 0.60
+ 19u 0.60  21u 0.60
+ 39u 0.60  41u 0.60
+ 59u 0.60  61u 0.80
+ 79u 0.80  81u 0.95
+ 99u 0.95  101u 0.80
+ 120u 0.80)

* --- Simulation ---
.tran 50n 120u

.control
run

echo ""
echo "============================================================"
echo "  PFET-INPUT MAX DETECTOR TEST (Winner = HIGHEST output)"
echo "============================================================"

* --- Scenario 1: Cell 0 wins ---
echo ""
echo "--- S1: Cell 0 should win (in0=0.95V) ---"
meas tran s1_o0 FIND v(out0) AT=15u
meas tran s1_o1 FIND v(out1) AT=15u
meas tran s1_o2 FIND v(out2) AT=15u
meas tran s1_o3 FIND v(out3) AT=15u
meas tran s1_o4 FIND v(out4) AT=15u
print s1_o0 s1_o1 s1_o2 s1_o3 s1_o4

* --- Scenario 2: Cell 1 wins ---
echo ""
echo "--- S2: Cell 1 should win (in1=0.95V) ---"
meas tran s2_o0 FIND v(out0) AT=35u
meas tran s2_o1 FIND v(out1) AT=35u
meas tran s2_o2 FIND v(out2) AT=35u
meas tran s2_o3 FIND v(out3) AT=35u
meas tran s2_o4 FIND v(out4) AT=35u
print s2_o0 s2_o1 s2_o2 s2_o3 s2_o4

* --- Scenario 3: Cell 2 wins ---
echo ""
echo "--- S3: Cell 2 should win (in2=0.95V) ---"
meas tran s3_o0 FIND v(out0) AT=55u
meas tran s3_o1 FIND v(out1) AT=55u
meas tran s3_o2 FIND v(out2) AT=55u
meas tran s3_o3 FIND v(out3) AT=55u
meas tran s3_o4 FIND v(out4) AT=55u
print s3_o0 s3_o1 s3_o2 s3_o3 s3_o4

* --- Scenario 4: Cell 3 wins ---
echo ""
echo "--- S4: Cell 3 should win (in3=0.95V) ---"
meas tran s4_o0 FIND v(out0) AT=75u
meas tran s4_o1 FIND v(out1) AT=75u
meas tran s4_o2 FIND v(out2) AT=75u
meas tran s4_o3 FIND v(out3) AT=75u
meas tran s4_o4 FIND v(out4) AT=75u
print s4_o0 s4_o1 s4_o2 s4_o3 s4_o4

* --- Scenario 5: Cell 4 wins ---
echo ""
echo "--- S5: Cell 4 should win (in4=0.95V) ---"
meas tran s5_o0 FIND v(out0) AT=95u
meas tran s5_o1 FIND v(out1) AT=95u
meas tran s5_o2 FIND v(out2) AT=95u
meas tran s5_o3 FIND v(out3) AT=95u
meas tran s5_o4 FIND v(out4) AT=95u
print s5_o0 s5_o1 s5_o2 s5_o3 s5_o4

* --- Scenario 6: Close margin ---
echo ""
echo "--- S6: Close margin (in0=0.82V vs 0.80V) ---"
meas tran s6_o0 FIND v(out0) AT=115u
meas tran s6_o1 FIND v(out1) AT=115u
meas tran s6_o2 FIND v(out2) AT=115u
meas tran s6_o3 FIND v(out3) AT=115u
meas tran s6_o4 FIND v(out4) AT=115u
print s6_o0 s6_o1 s6_o2 s6_o3 s6_o4

* --- Internal diagnostics at t=15us ---
echo ""
echo "--- Internal nodes (t=15us) ---"
meas tran v_nbias FIND v(nbias) AT=15u
meas tran v_pbias FIND v(pbias) AT=15u
meas tran v_src FIND v(xwta.src) AT=15u
meas tran v_d0 FIND v(xwta.d0) AT=15u
meas tran v_d1 FIND v(xwta.d1) AT=15u
meas tran v_d2 FIND v(xwta.d2) AT=15u
meas tran v_d3 FIND v(xwta.d3) AT=15u
meas tran v_d4 FIND v(xwta.d4) AT=15u
print v_nbias v_pbias v_src
print v_d0 v_d1 v_d2 v_d3 v_d4

echo ""
echo "============================================================"

quit
.endc

.end
