* =================================================================
* LAYER 2 (circuit features): 64x5 Differential 1T1R ReRAM Crossbar
* Technology: SKY130 sky130_fd_pr__nfet_01v8 + ReRAM PDK (behavioral sinh I-V)
* ReRAM model: sky130_fd_pr_reram__reram_cell (I_k1=6.14e-05, V_ref=0.43)
* =================================================================
*
* Conductance range: 0.296 - 99.273 uS (SKY130 ReRAM PDK)
* Tfilament range: 3.3 - 4.9 nm
* V_READ = 0.15V, V_GATE = 1.8V
* Scale factor: 2.239601e+05
* Total 1T1R cells: 640 (differential)
*
* Biases (add after current sensing):
*   b[0] = 0.039583
*   b[1] = 0.221185
*   b[2] = -0.391355
*   b[3] = -0.450722
*   b[4] = -0.840526
* =================================================================
* Column readout: NFET diode W=50.0u L=1.0u + col_readout subcircuit
* V_row offset: +0.52V (compensates NFET diode column voltage)

.include "C:/src/skywater-pdk-libs-sky130_fd_pr/cells/nfet_01v8/sky130_fd_pr__nfet_01v8__tt.corner.spice"
.include "C:/src/skywater-pdk-libs-sky130_fd_pr/cells/nfet_01v8/sky130_fd_pr__nfet_01v8__mismatch.corner.spice"
.include "C:/src/skywater-pdk-libs-sky130_fd_pr/cells/pfet_01v8/sky130_fd_pr__pfet_01v8__tt.corner.spice"
.include "C:/src/skywater-pdk-libs-sky130_fd_pr/cells/pfet_01v8/sky130_fd_pr__pfet_01v8__mismatch.corner.spice"

.param sky130_fd_pr__pfet_01v8__a0_diff = 0
.param sky130_fd_pr__pfet_01v8__agidl_diff = 0
.param sky130_fd_pr__pfet_01v8__ags_diff = 0
.param sky130_fd_pr__pfet_01v8__b0_diff = 0
.param sky130_fd_pr__pfet_01v8__b1_diff = 0
.param sky130_fd_pr__pfet_01v8__bgidl_diff = 0
.param sky130_fd_pr__pfet_01v8__cgidl_diff = 0
.param sky130_fd_pr__pfet_01v8__dlc_diff = 0
.param sky130_fd_pr__pfet_01v8__dwc_diff = 0
.param sky130_fd_pr__pfet_01v8__eta0_diff = 0
.param sky130_fd_pr__pfet_01v8__k2_diff = 0
.param sky130_fd_pr__pfet_01v8__keta_diff = 0
.param sky130_fd_pr__pfet_01v8__kt1_diff = 0
.param sky130_fd_pr__pfet_01v8__ku0_diff = 0
.param sky130_fd_pr__pfet_01v8__kvsat_diff = 0
.param sky130_fd_pr__pfet_01v8__kvth0_diff = 0
.param sky130_fd_pr__pfet_01v8__lint_diff = 0
.param sky130_fd_pr__pfet_01v8__lku0_diff = 0
.param sky130_fd_pr__pfet_01v8__lkvth0_diff = 0
.param sky130_fd_pr__pfet_01v8__nfactor_diff = 0
.param sky130_fd_pr__pfet_01v8__pclm_diff = 0
.param sky130_fd_pr__pfet_01v8__pdits_diff = 0
.param sky130_fd_pr__pfet_01v8__pditsd_diff = 0
.param sky130_fd_pr__pfet_01v8__rdsw_diff = 0
.param sky130_fd_pr__pfet_01v8__tvoff_diff = 0
.param sky130_fd_pr__pfet_01v8__u0_diff = 0
.param sky130_fd_pr__pfet_01v8__ua_diff = 0
.param sky130_fd_pr__pfet_01v8__ub_diff = 0
.param sky130_fd_pr__pfet_01v8__uc_diff = 0
.param sky130_fd_pr__pfet_01v8__ute_diff = 0
.param sky130_fd_pr__pfet_01v8__voff_diff = 0
.param sky130_fd_pr__pfet_01v8__vsat_diff = 0
.param sky130_fd_pr__pfet_01v8__vth0_diff = 0
.param sky130_fd_pr__pfet_01v8__wint_diff = 0
.param sky130_fd_pr__pfet_01v8__wku0_diff = 0
.param sky130_fd_pr__pfet_01v8__wkvth0_diff = 0
.param sky130_fd_pr__pfet_01v8__wlod_diff = 0

* === 1T1R ReRAM cell (SKY130 PDK behavioral I-V) ===
.subckt reram_1t1r row gate col gnd Tf0=3.3e-9
.param Ik1=6.14e-05
.param Tox=5e-09
.param Tfref=4.7249e-09
.param Vref=0.43
Xacc row gate mid gnd sky130_fd_pr__nfet_01v8 W=1.0u L=0.15u
Breram mid col I = Ik1*exp(-(Tox-Tf0)/(Tox-Tfref))*sinh(v(mid,col)/Vref)
.ends reram_1t1r

* === Differential column readout (replaces Vsource + CCCS) ===
.subckt col_readout col_p col_n nmac vdd gnd
Xpd col_p col_p gnd gnd sky130_fd_pr__nfet_01v8 W=50.0u L=1.0u
Xpm nmac col_p gnd gnd sky130_fd_pr__nfet_01v8 W=50.0u L=1.0u
Xnd col_n col_n gnd gnd sky130_fd_pr__nfet_01v8 W=50.0u L=1.0u
Xnm mid_n col_n gnd gnd sky130_fd_pr__nfet_01v8 W=50.0u L=1.0u
Xpcd mid_n mid_n vdd vdd sky130_fd_pr__pfet_01v8 W=50.0u L=1.0u
Xpcm nmac mid_n vdd vdd sky130_fd_pr__pfet_01v8 W=50.0u L=1.0u
.ends col_readout

Vgate gate 0 1.8
VDD vdd 0 1.8

* --- Row inputs ---
Vrow0 row0 0 0.0
Vrow1 row1 0 0.0
Vrow2 row2 0 0.0
Vrow3 row3 0 0.0
Vrow4 row4 0 0.0
Vrow5 row5 0 0.0
Vrow6 row6 0 0.0
Vrow7 row7 0 0.0
Vrow8 row8 0 0.0
Vrow9 row9 0 0.0
Vrow10 row10 0 0.0
Vrow11 row11 0 0.0
Vrow12 row12 0 0.0
Vrow13 row13 0 0.0
Vrow14 row14 0 0.0
Vrow15 row15 0 0.0
Vrow16 row16 0 0.0
Vrow17 row17 0 0.0
Vrow18 row18 0 0.0
Vrow19 row19 0 0.0
Vrow20 row20 0 0.0
Vrow21 row21 0 0.0
Vrow22 row22 0 0.0
Vrow23 row23 0 0.0
Vrow24 row24 0 0.0
Vrow25 row25 0 0.0
Vrow26 row26 0 0.0
Vrow27 row27 0 0.0
Vrow28 row28 0 0.0
Vrow29 row29 0 0.0
Vrow30 row30 0 0.0
Vrow31 row31 0 0.0
Vrow32 row32 0 0.0
Vrow33 row33 0 0.0
Vrow34 row34 0 0.0
Vrow35 row35 0 0.0
Vrow36 row36 0 0.0
Vrow37 row37 0 0.0
Vrow38 row38 0 0.0
Vrow39 row39 0 0.0
Vrow40 row40 0 0.0
Vrow41 row41 0 0.0
Vrow42 row42 0 0.0
Vrow43 row43 0 0.0
Vrow44 row44 0 0.0
Vrow45 row45 0 0.0
Vrow46 row46 0 0.0
Vrow47 row47 0 0.0
Vrow48 row48 0 0.0
Vrow49 row49 0 0.0
Vrow50 row50 0 0.0
Vrow51 row51 0 0.0
Vrow52 row52 0 0.0
Vrow53 row53 0 0.0
Vrow54 row54 0 0.0
Vrow55 row55 0 0.0
Vrow56 row56 0 0.0
Vrow57 row57 0 0.0
Vrow58 row58 0 0.0
Vrow59 row59 0 0.0
Vrow60 row60 0 0.0
Vrow61 row61 0 0.0
Vrow62 row62 0 0.0
Vrow63 row63 0 0.0

* --- Column readout (NFET diode + col_readout subcircuit) ---
Xcolrd0 cp0 cn0 nmac0 vdd 0 col_readout
Xcolrd1 cp1 cn1 nmac1 vdd 0 col_readout
Xcolrd2 cp2 cn2 nmac2 vdd 0 col_readout
Xcolrd3 cp3 cn3 nmac3 vdd 0 col_readout
Xcolrd4 cp4 cn4 nmac4 vdd 0 col_readout

* ===== POSITIVE CONDUCTANCE ARRAY (64x5) =====
* --- Row 0 ---
Xrp0_0 row0 gate cp0 0 reram_1t1r Tf0=3.300000e-09  $ G+=0.296uS w=-0.4047
Xrp0_1 row0 gate cp1 0 reram_1t1r Tf0=4.314027e-09  $ G+=12.038uS w=0.3944
Xrp0_2 row0 gate cp2 0 reram_1t1r Tf0=4.155991e-09  $ G+=6.777uS w=0.2177
Xrp0_3 row0 gate cp3 0 reram_1t1r Tf0=3.300000e-09  $ G+=0.296uS w=-0.1989
Xrp0_4 row0 gate cp4 0 reram_1t1r Tf0=3.300000e-09  $ G+=0.296uS w=-0.5297
* --- Row 1 ---
Xrp1_0 row1 gate cp0 0 reram_1t1r Tf0=4.485717e-09  $ G+=22.469uS w=0.7449
Xrp1_1 row1 gate cp1 0 reram_1t1r Tf0=3.300000e-09  $ G+=0.296uS w=-0.8341
Xrp1_2 row1 gate cp2 0 reram_1t1r Tf0=3.300000e-09  $ G+=0.296uS w=-0.7573
Xrp1_3 row1 gate cp3 0 reram_1t1r Tf0=4.316569e-09  $ G+=12.149uS w=0.3982
Xrp1_4 row1 gate cp4 0 reram_1t1r Tf0=3.300000e-09  $ G+=0.296uS w=-0.0297
* --- Row 2 ---
Xrp2_0 row2 gate cp0 0 reram_1t1r Tf0=3.300000e-09  $ G+=0.296uS w=-0.8871
Xrp2_1 row2 gate cp1 0 reram_1t1r Tf0=3.300000e-09  $ G+=0.296uS w=-0.2688
Xrp2_2 row2 gate cp2 0 reram_1t1r Tf0=4.206825e-09  $ G+=8.153uS w=0.2639
Xrp2_3 row2 gate cp3 0 reram_1t1r Tf0=4.124997e-09  $ G+=6.055uS w=0.1935
Xrp2_4 row2 gate cp4 0 reram_1t1r Tf0=3.300000e-09  $ G+=0.296uS w=-0.2297
* --- Row 3 ---
Xrp3_0 row3 gate cp0 0 reram_1t1r Tf0=4.077392e-09  $ G+=5.093uS w=0.1611
Xrp3_1 row3 gate cp1 0 reram_1t1r Tf0=3.300000e-09  $ G+=0.296uS w=-1.7690
Xrp3_2 row3 gate cp2 0 reram_1t1r Tf0=4.172548e-09  $ G+=7.198uS w=0.2319
Xrp3_3 row3 gate cp3 0 reram_1t1r Tf0=4.428510e-09  $ G+=18.250uS w=0.6032
Xrp3_4 row3 gate cp4 0 reram_1t1r Tf0=3.638481e-09  $ G+=1.033uS w=0.0248
* --- Row 4 ---
Xrp4_0 row4 gate cp0 0 reram_1t1r Tf0=4.099321e-09  $ G+=5.516uS w=0.1753
Xrp4_1 row4 gate cp1 0 reram_1t1r Tf0=3.300000e-09  $ G+=0.296uS w=-1.1527
Xrp4_2 row4 gate cp2 0 reram_1t1r Tf0=3.720731e-09  $ G+=1.393uS w=0.0368
Xrp4_3 row4 gate cp3 0 reram_1t1r Tf0=3.300000e-09  $ G+=0.296uS w=-0.1328
Xrp4_4 row4 gate cp4 0 reram_1t1r Tf0=3.300000e-09  $ G+=0.296uS w=-0.1991
* --- Row 5 ---
Xrp5_0 row5 gate cp0 0 reram_1t1r Tf0=4.212597e-09  $ G+=8.326uS w=0.2697
Xrp5_1 row5 gate cp1 0 reram_1t1r Tf0=3.300000e-09  $ G+=0.296uS w=-0.1467
Xrp5_2 row5 gate cp2 0 reram_1t1r Tf0=3.300000e-09  $ G+=0.296uS w=-0.7287
Xrp5_3 row5 gate cp3 0 reram_1t1r Tf0=3.300000e-09  $ G+=0.296uS w=-0.4380
Xrp5_4 row5 gate cp4 0 reram_1t1r Tf0=3.300000e-09  $ G+=0.296uS w=-0.2647
* --- Row 6 ---
Xrp6_0 row6 gate cp0 0 reram_1t1r Tf0=3.300000e-09  $ G+=0.296uS w=-0.5471
Xrp6_1 row6 gate cp1 0 reram_1t1r Tf0=3.300000e-09  $ G+=0.296uS w=-0.0033
Xrp6_2 row6 gate cp2 0 reram_1t1r Tf0=4.369677e-09  $ G+=14.737uS w=0.4851
Xrp6_3 row6 gate cp3 0 reram_1t1r Tf0=4.039008e-09  $ G+=4.430uS w=0.1389
Xrp6_4 row6 gate cp4 0 reram_1t1r Tf0=3.300000e-09  $ G+=0.296uS w=-0.6342
* --- Row 7 ---
Xrp7_0 row7 gate cp0 0 reram_1t1r Tf0=4.293086e-09  $ G+=11.155uS w=0.3648
Xrp7_1 row7 gate cp1 0 reram_1t1r Tf0=3.300000e-09  $ G+=0.296uS w=-2.0138
Xrp7_2 row7 gate cp2 0 reram_1t1r Tf0=3.300000e-09  $ G+=0.296uS w=-0.7022
Xrp7_3 row7 gate cp3 0 reram_1t1r Tf0=4.519673e-09  $ G+=25.421uS w=0.8440
Xrp7_4 row7 gate cp4 0 reram_1t1r Tf0=4.196232e-09  $ G+=7.845uS w=0.2536
* --- Row 8 ---
Xrp8_0 row8 gate cp0 0 reram_1t1r Tf0=3.300000e-09  $ G+=0.296uS w=-0.3996
Xrp8_1 row8 gate cp1 0 reram_1t1r Tf0=3.300000e-09  $ G+=0.296uS w=-0.5149
Xrp8_2 row8 gate cp2 0 reram_1t1r Tf0=4.253559e-09  $ G+=9.662uS w=0.3147
Xrp8_3 row8 gate cp3 0 reram_1t1r Tf0=4.326233e-09  $ G+=12.584uS w=0.4128
Xrp8_4 row8 gate cp4 0 reram_1t1r Tf0=3.638603e-09  $ G+=1.033uS w=0.0248
* --- Row 9 ---
Xrp9_0 row9 gate cp0 0 reram_1t1r Tf0=3.300000e-09  $ G+=0.296uS w=-0.2319
Xrp9_1 row9 gate cp1 0 reram_1t1r Tf0=3.300000e-09  $ G+=0.296uS w=-0.3994
Xrp9_2 row9 gate cp2 0 reram_1t1r Tf0=4.343667e-09  $ G+=13.407uS w=0.4405
Xrp9_3 row9 gate cp3 0 reram_1t1r Tf0=3.300000e-09  $ G+=0.296uS w=-0.1465
Xrp9_4 row9 gate cp4 0 reram_1t1r Tf0=3.300000e-09  $ G+=0.296uS w=-0.0253
* --- Row 10 ---
Xrp10_0 row10 gate cp0 0 reram_1t1r Tf0=4.270610e-09  $ G+=10.280uS w=0.3354
Xrp10_1 row10 gate cp1 0 reram_1t1r Tf0=3.945390e-09  $ G+=3.152uS w=0.0959
Xrp10_2 row10 gate cp2 0 reram_1t1r Tf0=3.300000e-09  $ G+=0.296uS w=-0.3562
Xrp10_3 row10 gate cp3 0 reram_1t1r Tf0=3.300000e-09  $ G+=0.296uS w=-0.6972
Xrp10_4 row10 gate cp4 0 reram_1t1r Tf0=3.300000e-09  $ G+=0.296uS w=-0.7016
* --- Row 11 ---
Xrp11_0 row11 gate cp0 0 reram_1t1r Tf0=4.118593e-09  $ G+=5.916uS w=0.1888
Xrp11_1 row11 gate cp1 0 reram_1t1r Tf0=3.300000e-09  $ G+=0.296uS w=-0.6018
Xrp11_2 row11 gate cp2 0 reram_1t1r Tf0=4.387350e-09  $ G+=15.714uS w=0.5180
Xrp11_3 row11 gate cp3 0 reram_1t1r Tf0=3.300000e-09  $ G+=0.296uS w=-0.7057
Xrp11_4 row11 gate cp4 0 reram_1t1r Tf0=3.898566e-09  $ G+=2.659uS w=0.0794
* --- Row 12 ---
Xrp12_0 row12 gate cp0 0 reram_1t1r Tf0=4.364033e-09  $ G+=14.437uS w=0.4751
Xrp12_1 row12 gate cp1 0 reram_1t1r Tf0=3.300000e-09  $ G+=0.296uS w=-0.9252
Xrp12_2 row12 gate cp2 0 reram_1t1r Tf0=3.300000e-09  $ G+=0.296uS w=-0.6294
Xrp12_3 row12 gate cp3 0 reram_1t1r Tf0=3.300000e-09  $ G+=0.296uS w=-0.1067
Xrp12_4 row12 gate cp4 0 reram_1t1r Tf0=3.300000e-09  $ G+=0.296uS w=-0.1419
* --- Row 13 ---
Xrp13_0 row13 gate cp0 0 reram_1t1r Tf0=3.300000e-09  $ G+=0.296uS w=-0.3926
Xrp13_1 row13 gate cp1 0 reram_1t1r Tf0=3.300000e-09  $ G+=0.296uS w=-0.8753
Xrp13_2 row13 gate cp2 0 reram_1t1r Tf0=4.290686e-09  $ G+=11.058uS w=0.3616
Xrp13_3 row13 gate cp3 0 reram_1t1r Tf0=3.300000e-09  $ G+=0.296uS w=-0.3002
Xrp13_4 row13 gate cp4 0 reram_1t1r Tf0=4.363726e-09  $ G+=14.421uS w=0.4745
* --- Row 14 ---
Xrp14_0 row14 gate cp0 0 reram_1t1r Tf0=3.320863e-09  $ G+=0.326uS w=0.0010
Xrp14_1 row14 gate cp1 0 reram_1t1r Tf0=3.300000e-09  $ G+=0.296uS w=-0.2643
Xrp14_2 row14 gate cp2 0 reram_1t1r Tf0=4.512780e-09  $ G+=24.792uS w=0.8229
Xrp14_3 row14 gate cp3 0 reram_1t1r Tf0=3.300000e-09  $ G+=0.296uS w=-0.5529
Xrp14_4 row14 gate cp4 0 reram_1t1r Tf0=3.300000e-09  $ G+=0.296uS w=-0.4674
* --- Row 15 ---
Xrp15_0 row15 gate cp0 0 reram_1t1r Tf0=3.300000e-09  $ G+=0.296uS w=-0.2237
Xrp15_1 row15 gate cp1 0 reram_1t1r Tf0=3.300000e-09  $ G+=0.296uS w=-0.2326
Xrp15_2 row15 gate cp2 0 reram_1t1r Tf0=4.389063e-09  $ G+=15.812uS w=0.5213
Xrp15_3 row15 gate cp3 0 reram_1t1r Tf0=3.889719e-09  $ G+=2.575uS w=0.0765
Xrp15_4 row15 gate cp4 0 reram_1t1r Tf0=3.300000e-09  $ G+=0.296uS w=-1.0433
* --- Row 16 ---
Xrp16_0 row16 gate cp0 0 reram_1t1r Tf0=3.300000e-09  $ G+=0.296uS w=-0.7432
Xrp16_1 row16 gate cp1 0 reram_1t1r Tf0=3.300000e-09  $ G+=0.296uS w=-0.0069
Xrp16_2 row16 gate cp2 0 reram_1t1r Tf0=4.463095e-09  $ G+=20.695uS w=0.6853
Xrp16_3 row16 gate cp3 0 reram_1t1r Tf0=4.328848e-09  $ G+=12.704uS w=0.4168
Xrp16_4 row16 gate cp4 0 reram_1t1r Tf0=3.300000e-09  $ G+=0.296uS w=-0.4344
* --- Row 17 ---
Xrp17_0 row17 gate cp0 0 reram_1t1r Tf0=4.432238e-09  $ G+=18.499uS w=0.6115
Xrp17_1 row17 gate cp1 0 reram_1t1r Tf0=3.300000e-09  $ G+=0.296uS w=-0.0019
Xrp17_2 row17 gate cp2 0 reram_1t1r Tf0=3.300000e-09  $ G+=0.296uS w=-0.3399
Xrp17_3 row17 gate cp3 0 reram_1t1r Tf0=3.300000e-09  $ G+=0.296uS w=-0.6562
Xrp17_4 row17 gate cp4 0 reram_1t1r Tf0=3.300000e-09  $ G+=0.296uS w=-0.6835
* --- Row 18 ---
Xrp18_0 row18 gate cp0 0 reram_1t1r Tf0=3.950970e-09  $ G+=3.217uS w=0.0981
Xrp18_1 row18 gate cp1 0 reram_1t1r Tf0=3.300000e-09  $ G+=0.296uS w=-0.8420
Xrp18_2 row18 gate cp2 0 reram_1t1r Tf0=3.300000e-09  $ G+=0.296uS w=-0.6035
Xrp18_3 row18 gate cp3 0 reram_1t1r Tf0=3.300000e-09  $ G+=0.296uS w=-0.2286
Xrp18_4 row18 gate cp4 0 reram_1t1r Tf0=3.300000e-09  $ G+=0.296uS w=-0.1376
* --- Row 19 ---
Xrp19_0 row19 gate cp0 0 reram_1t1r Tf0=4.402913e-09  $ G+=16.629uS w=0.5487
Xrp19_1 row19 gate cp1 0 reram_1t1r Tf0=3.300000e-09  $ G+=0.296uS w=-0.2207
Xrp19_2 row19 gate cp2 0 reram_1t1r Tf0=3.300000e-09  $ G+=0.296uS w=-0.4416
Xrp19_3 row19 gate cp3 0 reram_1t1r Tf0=3.300000e-09  $ G+=0.296uS w=-0.0712
Xrp19_4 row19 gate cp4 0 reram_1t1r Tf0=3.941115e-09  $ G+=3.103uS w=0.0943
* --- Row 20 ---
Xrp20_0 row20 gate cp0 0 reram_1t1r Tf0=3.300000e-09  $ G+=0.296uS w=-0.2772
Xrp20_1 row20 gate cp1 0 reram_1t1r Tf0=3.300000e-09  $ G+=0.296uS w=-0.2630
Xrp20_2 row20 gate cp2 0 reram_1t1r Tf0=4.305882e-09  $ G+=11.686uS w=0.3827
Xrp20_3 row20 gate cp3 0 reram_1t1r Tf0=4.242006e-09  $ G+=9.265uS w=0.3013
Xrp20_4 row20 gate cp4 0 reram_1t1r Tf0=4.037379e-09  $ G+=4.404uS w=0.1380
* --- Row 21 ---
Xrp21_0 row21 gate cp0 0 reram_1t1r Tf0=3.300000e-09  $ G+=0.296uS w=-0.3935
Xrp21_1 row21 gate cp1 0 reram_1t1r Tf0=3.300000e-09  $ G+=0.296uS w=-0.9018
Xrp21_2 row21 gate cp2 0 reram_1t1r Tf0=4.411586e-09  $ G+=17.162uS w=0.5666
Xrp21_3 row21 gate cp3 0 reram_1t1r Tf0=4.449404e-09  $ G+=19.691uS w=0.6515
Xrp21_4 row21 gate cp4 0 reram_1t1r Tf0=3.300000e-09  $ G+=0.296uS w=-0.3141
* --- Row 22 ---
Xrp22_0 row22 gate cp0 0 reram_1t1r Tf0=4.261584e-09  $ G+=9.948uS w=0.3243
Xrp22_1 row22 gate cp1 0 reram_1t1r Tf0=3.300000e-09  $ G+=0.296uS w=-0.4845
Xrp22_2 row22 gate cp2 0 reram_1t1r Tf0=4.207414e-09  $ G+=8.170uS w=0.2645
Xrp22_3 row22 gate cp3 0 reram_1t1r Tf0=3.300000e-09  $ G+=0.296uS w=-0.5976
Xrp22_4 row22 gate cp4 0 reram_1t1r Tf0=3.300000e-09  $ G+=0.296uS w=-0.2786
* --- Row 23 ---
Xrp23_0 row23 gate cp0 0 reram_1t1r Tf0=3.449893e-09  $ G+=0.520uS w=0.0075
Xrp23_1 row23 gate cp1 0 reram_1t1r Tf0=4.352194e-09  $ G+=13.829uS w=0.4546
Xrp23_2 row23 gate cp2 0 reram_1t1r Tf0=3.300000e-09  $ G+=0.296uS w=-0.8192
Xrp23_3 row23 gate cp3 0 reram_1t1r Tf0=3.300000e-09  $ G+=0.296uS w=-0.2265
Xrp23_4 row23 gate cp4 0 reram_1t1r Tf0=3.300000e-09  $ G+=0.296uS w=-0.2103
* --- Row 24 ---
Xrp24_0 row24 gate cp0 0 reram_1t1r Tf0=4.320710e-09  $ G+=12.334uS w=0.4044
Xrp24_1 row24 gate cp1 0 reram_1t1r Tf0=3.300000e-09  $ G+=0.296uS w=-0.2905
Xrp24_2 row24 gate cp2 0 reram_1t1r Tf0=3.300000e-09  $ G+=0.296uS w=-0.9145
Xrp24_3 row24 gate cp3 0 reram_1t1r Tf0=4.606958e-09  $ G+=34.913uS w=1.1629
Xrp24_4 row24 gate cp4 0 reram_1t1r Tf0=3.868407e-09  $ G+=2.383uS w=0.0701
* --- Row 25 ---
Xrp25_0 row25 gate cp0 0 reram_1t1r Tf0=3.300000e-09  $ G+=0.296uS w=-0.1356
Xrp25_1 row25 gate cp1 0 reram_1t1r Tf0=4.536229e-09  $ G+=26.998uS w=0.8970
Xrp25_2 row25 gate cp2 0 reram_1t1r Tf0=3.300000e-09  $ G+=0.296uS w=-1.4528
Xrp25_3 row25 gate cp3 0 reram_1t1r Tf0=4.427589e-09  $ G+=18.189uS w=0.6011
Xrp25_4 row25 gate cp4 0 reram_1t1r Tf0=4.457785e-09  $ G+=20.300uS w=0.6720
* --- Row 26 ---
Xrp26_0 row26 gate cp0 0 reram_1t1r Tf0=3.300000e-09  $ G+=0.296uS w=-0.4468
Xrp26_1 row26 gate cp1 0 reram_1t1r Tf0=4.592101e-09  $ G+=33.077uS w=1.1013
Xrp26_2 row26 gate cp2 0 reram_1t1r Tf0=3.300000e-09  $ G+=0.296uS w=-0.3237
Xrp26_3 row26 gate cp3 0 reram_1t1r Tf0=4.294349e-09  $ G+=11.207uS w=0.3665
Xrp26_4 row26 gate cp4 0 reram_1t1r Tf0=4.350366e-09  $ G+=13.738uS w=0.4516
* --- Row 27 ---
Xrp27_0 row27 gate cp0 0 reram_1t1r Tf0=4.538798e-09  $ G+=27.251uS w=0.9055
Xrp27_1 row27 gate cp1 0 reram_1t1r Tf0=3.300000e-09  $ G+=0.296uS w=-1.2904
Xrp27_2 row27 gate cp2 0 reram_1t1r Tf0=3.300000e-09  $ G+=0.296uS w=-1.4258
Xrp27_3 row27 gate cp3 0 reram_1t1r Tf0=3.300000e-09  $ G+=0.296uS w=-0.0880
Xrp27_4 row27 gate cp4 0 reram_1t1r Tf0=4.373265e-09  $ G+=14.930uS w=0.4916
* --- Row 28 ---
Xrp28_0 row28 gate cp0 0 reram_1t1r Tf0=4.390639e-09  $ G+=15.903uS w=0.5243
Xrp28_1 row28 gate cp1 0 reram_1t1r Tf0=4.128054e-09  $ G+=6.123uS w=0.1957
Xrp28_2 row28 gate cp2 0 reram_1t1r Tf0=3.300000e-09  $ G+=0.296uS w=-0.5763
Xrp28_3 row28 gate cp3 0 reram_1t1r Tf0=3.300000e-09  $ G+=0.296uS w=-0.0227
Xrp28_4 row28 gate cp4 0 reram_1t1r Tf0=3.588556e-09  $ G+=0.862uS w=0.0190
* --- Row 29 ---
Xrp29_0 row29 gate cp0 0 reram_1t1r Tf0=3.300000e-09  $ G+=0.296uS w=-0.5368
Xrp29_1 row29 gate cp1 0 reram_1t1r Tf0=3.300000e-09  $ G+=0.296uS w=-0.5162
Xrp29_2 row29 gate cp2 0 reram_1t1r Tf0=4.547957e-09  $ G+=28.174uS w=0.9365
Xrp29_3 row29 gate cp3 0 reram_1t1r Tf0=3.300000e-09  $ G+=0.296uS w=-0.4848
Xrp29_4 row29 gate cp4 0 reram_1t1r Tf0=3.300000e-09  $ G+=0.296uS w=-0.7267
* --- Row 30 ---
Xrp30_0 row30 gate cp0 0 reram_1t1r Tf0=3.300000e-09  $ G+=0.296uS w=-0.5237
Xrp30_1 row30 gate cp1 0 reram_1t1r Tf0=4.511926e-09  $ G+=24.715uS w=0.8203
Xrp30_2 row30 gate cp2 0 reram_1t1r Tf0=3.300000e-09  $ G+=0.296uS w=-0.2461
Xrp30_3 row30 gate cp3 0 reram_1t1r Tf0=4.063332e-09  $ G+=4.839uS w=0.1526
Xrp30_4 row30 gate cp4 0 reram_1t1r Tf0=3.300000e-09  $ G+=0.296uS w=-3.3250
* --- Row 31 ---
Xrp31_0 row31 gate cp0 0 reram_1t1r Tf0=4.159174e-09  $ G+=6.856uS w=0.2204
Xrp31_1 row31 gate cp1 0 reram_1t1r Tf0=4.391194e-09  $ G+=15.935uS w=0.5254
Xrp31_2 row31 gate cp2 0 reram_1t1r Tf0=3.300000e-09  $ G+=0.296uS w=-0.1754
Xrp31_3 row31 gate cp3 0 reram_1t1r Tf0=3.300000e-09  $ G+=0.296uS w=-0.7312
Xrp31_4 row31 gate cp4 0 reram_1t1r Tf0=3.836677e-09  $ G+=2.123uS w=0.0614
* --- Row 32 ---
Xrp32_0 row32 gate cp0 0 reram_1t1r Tf0=3.300000e-09  $ G+=0.296uS w=-0.3327
Xrp32_1 row32 gate cp1 0 reram_1t1r Tf0=4.497218e-09  $ G+=23.428uS w=0.7771
Xrp32_2 row32 gate cp2 0 reram_1t1r Tf0=4.176826e-09  $ G+=7.310uS w=0.2356
Xrp32_3 row32 gate cp3 0 reram_1t1r Tf0=3.300000e-09  $ G+=0.296uS w=-0.8394
Xrp32_4 row32 gate cp4 0 reram_1t1r Tf0=3.300000e-09  $ G+=0.296uS w=-1.7470
* --- Row 33 ---
Xrp33_0 row33 gate cp0 0 reram_1t1r Tf0=3.300000e-09  $ G+=0.296uS w=-0.8889
Xrp33_1 row33 gate cp1 0 reram_1t1r Tf0=4.494865e-09  $ G+=23.229uS w=0.7704
Xrp33_2 row33 gate cp2 0 reram_1t1r Tf0=4.451103e-09  $ G+=19.813uS w=0.6556
Xrp33_3 row33 gate cp3 0 reram_1t1r Tf0=3.300000e-09  $ G+=0.296uS w=-0.6837
Xrp33_4 row33 gate cp4 0 reram_1t1r Tf0=4.407749e-09  $ G+=16.924uS w=0.5586
* --- Row 34 ---
Xrp34_0 row34 gate cp0 0 reram_1t1r Tf0=3.300000e-09  $ G+=0.296uS w=-0.4163
Xrp34_1 row34 gate cp1 0 reram_1t1r Tf0=3.300000e-09  $ G+=0.296uS w=-0.1020
Xrp34_2 row34 gate cp2 0 reram_1t1r Tf0=4.316161e-09  $ G+=12.131uS w=0.3976
Xrp34_3 row34 gate cp3 0 reram_1t1r Tf0=4.350229e-09  $ G+=13.731uS w=0.4513
Xrp34_4 row34 gate cp4 0 reram_1t1r Tf0=3.892760e-09  $ G+=2.603uS w=0.0775
* --- Row 35 ---
Xrp35_0 row35 gate cp0 0 reram_1t1r Tf0=4.430637e-09  $ G+=18.392uS w=0.6079
Xrp35_1 row35 gate cp1 0 reram_1t1r Tf0=4.019996e-09  $ G+=4.134uS w=0.1289
Xrp35_2 row35 gate cp2 0 reram_1t1r Tf0=3.300000e-09  $ G+=0.296uS w=-0.8158
Xrp35_3 row35 gate cp3 0 reram_1t1r Tf0=3.300000e-09  $ G+=0.296uS w=-0.6893
Xrp35_4 row35 gate cp4 0 reram_1t1r Tf0=4.331263e-09  $ G+=12.816uS w=0.4206
* --- Row 36 ---
Xrp36_0 row36 gate cp0 0 reram_1t1r Tf0=3.929389e-09  $ G+=2.974uS w=0.0900
Xrp36_1 row36 gate cp1 0 reram_1t1r Tf0=3.300000e-09  $ G+=0.296uS w=-0.6620
Xrp36_2 row36 gate cp2 0 reram_1t1r Tf0=4.298100e-09  $ G+=11.361uS w=0.3717
Xrp36_3 row36 gate cp3 0 reram_1t1r Tf0=4.366591e-09  $ G+=14.572uS w=0.4796
Xrp36_4 row36 gate cp4 0 reram_1t1r Tf0=3.300000e-09  $ G+=0.296uS w=-0.0961
* --- Row 37 ---
Xrp37_0 row37 gate cp0 0 reram_1t1r Tf0=3.743770e-09  $ G+=1.515uS w=0.0409
Xrp37_1 row37 gate cp1 0 reram_1t1r Tf0=3.300000e-09  $ G+=0.296uS w=-0.2132
Xrp37_2 row37 gate cp2 0 reram_1t1r Tf0=4.313341e-09  $ G+=12.008uS w=0.3934
Xrp37_3 row37 gate cp3 0 reram_1t1r Tf0=3.300000e-09  $ G+=0.296uS w=-1.0121
Xrp37_4 row37 gate cp4 0 reram_1t1r Tf0=3.300000e-09  $ G+=0.296uS w=-0.0570
* --- Row 38 ---
Xrp38_0 row38 gate cp0 0 reram_1t1r Tf0=4.295095e-09  $ G+=11.237uS w=0.3676
Xrp38_1 row38 gate cp1 0 reram_1t1r Tf0=4.236250e-09  $ G+=9.073uS w=0.2949
Xrp38_2 row38 gate cp2 0 reram_1t1r Tf0=3.300000e-09  $ G+=0.296uS w=-0.2043
Xrp38_3 row38 gate cp3 0 reram_1t1r Tf0=3.300000e-09  $ G+=0.296uS w=-0.0571
Xrp38_4 row38 gate cp4 0 reram_1t1r Tf0=3.300000e-09  $ G+=0.296uS w=-1.0356
* --- Row 39 ---
Xrp39_0 row39 gate cp0 0 reram_1t1r Tf0=4.427846e-09  $ G+=18.206uS w=0.6017
Xrp39_1 row39 gate cp1 0 reram_1t1r Tf0=3.300000e-09  $ G+=0.296uS w=-0.7626
Xrp39_2 row39 gate cp2 0 reram_1t1r Tf0=3.300000e-09  $ G+=0.296uS w=-0.4796
Xrp39_3 row39 gate cp3 0 reram_1t1r Tf0=3.904088e-09  $ G+=2.713uS w=0.0812
Xrp39_4 row39 gate cp4 0 reram_1t1r Tf0=3.300000e-09  $ G+=0.296uS w=-0.1536
* --- Row 40 ---
Xrp40_0 row40 gate cp0 0 reram_1t1r Tf0=3.300000e-09  $ G+=0.296uS w=-0.4205
Xrp40_1 row40 gate cp1 0 reram_1t1r Tf0=4.238425e-09  $ G+=9.145uS w=0.2973
Xrp40_2 row40 gate cp2 0 reram_1t1r Tf0=4.212143e-09  $ G+=8.312uS w=0.2693
Xrp40_3 row40 gate cp3 0 reram_1t1r Tf0=4.499434e-09  $ G+=23.618uS w=0.7835
Xrp40_4 row40 gate cp4 0 reram_1t1r Tf0=3.300000e-09  $ G+=0.296uS w=-0.0483
* --- Row 41 ---
Xrp41_0 row41 gate cp0 0 reram_1t1r Tf0=4.395567e-09  $ G+=16.191uS w=0.5340
Xrp41_1 row41 gate cp1 0 reram_1t1r Tf0=3.300000e-09  $ G+=0.296uS w=-1.3789
Xrp41_2 row41 gate cp2 0 reram_1t1r Tf0=3.300000e-09  $ G+=0.296uS w=-0.5951
Xrp41_3 row41 gate cp3 0 reram_1t1r Tf0=3.300000e-09  $ G+=0.296uS w=-0.6372
Xrp41_4 row41 gate cp4 0 reram_1t1r Tf0=4.266665e-09  $ G+=10.134uS w=0.3305
* --- Row 42 ---
Xrp42_0 row42 gate cp0 0 reram_1t1r Tf0=4.415272e-09  $ G+=17.393uS w=0.5744
Xrp42_1 row42 gate cp1 0 reram_1t1r Tf0=4.162868e-09  $ G+=6.949uS w=0.2235
Xrp42_2 row42 gate cp2 0 reram_1t1r Tf0=3.300000e-09  $ G+=0.296uS w=-0.7688
Xrp42_3 row42 gate cp3 0 reram_1t1r Tf0=3.300000e-09  $ G+=0.296uS w=-0.0254
Xrp42_4 row42 gate cp4 0 reram_1t1r Tf0=3.300000e-09  $ G+=0.296uS w=-0.7572
* --- Row 43 ---
Xrp43_0 row43 gate cp0 0 reram_1t1r Tf0=4.334920e-09  $ G+=12.987uS w=0.4264
Xrp43_1 row43 gate cp1 0 reram_1t1r Tf0=3.300000e-09  $ G+=0.296uS w=-0.2032
Xrp43_2 row43 gate cp2 0 reram_1t1r Tf0=3.300000e-09  $ G+=0.296uS w=-0.3032
Xrp43_3 row43 gate cp3 0 reram_1t1r Tf0=3.300000e-09  $ G+=0.296uS w=-0.8216
Xrp43_4 row43 gate cp4 0 reram_1t1r Tf0=4.263301e-09  $ G+=10.011uS w=0.3264
* --- Row 44 ---
Xrp44_0 row44 gate cp0 0 reram_1t1r Tf0=4.407670e-09  $ G+=16.919uS w=0.5584
Xrp44_1 row44 gate cp1 0 reram_1t1r Tf0=3.300000e-09  $ G+=0.296uS w=-0.0006
Xrp44_2 row44 gate cp2 0 reram_1t1r Tf0=4.000146e-09  $ G+=3.846uS w=0.1193
Xrp44_3 row44 gate cp3 0 reram_1t1r Tf0=3.300000e-09  $ G+=0.296uS w=-0.4575
Xrp44_4 row44 gate cp4 0 reram_1t1r Tf0=4.090711e-09  $ G+=5.346uS w=0.1696
* --- Row 45 ---
Xrp45_0 row45 gate cp0 0 reram_1t1r Tf0=3.300000e-09  $ G+=0.296uS w=-0.3702
Xrp45_1 row45 gate cp1 0 reram_1t1r Tf0=4.303134e-09  $ G+=11.570uS w=0.3787
Xrp45_2 row45 gate cp2 0 reram_1t1r Tf0=4.314332e-09  $ G+=12.051uS w=0.3949
Xrp45_3 row45 gate cp3 0 reram_1t1r Tf0=3.300000e-09  $ G+=0.296uS w=-0.5259
Xrp45_4 row45 gate cp4 0 reram_1t1r Tf0=3.817473e-09  $ G+=1.980uS w=0.0566
* --- Row 46 ---
Xrp46_0 row46 gate cp0 0 reram_1t1r Tf0=4.277839e-09  $ G+=10.554uS w=0.3446
Xrp46_1 row46 gate cp1 0 reram_1t1r Tf0=4.396108e-09  $ G+=16.223uS w=0.5350
Xrp46_2 row46 gate cp2 0 reram_1t1r Tf0=3.300000e-09  $ G+=0.296uS w=-0.1099
Xrp46_3 row46 gate cp3 0 reram_1t1r Tf0=3.300000e-09  $ G+=0.296uS w=-0.6735
Xrp46_4 row46 gate cp4 0 reram_1t1r Tf0=3.300000e-09  $ G+=0.296uS w=-0.5433
* --- Row 47 ---
Xrp47_0 row47 gate cp0 0 reram_1t1r Tf0=4.440515e-09  $ G+=19.064uS w=0.6305
Xrp47_1 row47 gate cp1 0 reram_1t1r Tf0=3.300000e-09  $ G+=0.296uS w=-0.8427
Xrp47_2 row47 gate cp2 0 reram_1t1r Tf0=4.122899e-09  $ G+=6.009uS w=0.1919
Xrp47_3 row47 gate cp3 0 reram_1t1r Tf0=4.174738e-09  $ G+=7.255uS w=0.2338
Xrp47_4 row47 gate cp4 0 reram_1t1r Tf0=3.300000e-09  $ G+=0.296uS w=-0.1516
* --- Row 48 ---
Xrp48_0 row48 gate cp0 0 reram_1t1r Tf0=4.031445e-09  $ G+=4.310uS w=0.1348
Xrp48_1 row48 gate cp1 0 reram_1t1r Tf0=3.300000e-09  $ G+=0.296uS w=-0.1074
Xrp48_2 row48 gate cp2 0 reram_1t1r Tf0=3.300000e-09  $ G+=0.296uS w=-0.4750
Xrp48_3 row48 gate cp3 0 reram_1t1r Tf0=3.514131e-09  $ G+=0.657uS w=0.0121
Xrp48_4 row48 gate cp4 0 reram_1t1r Tf0=4.082126e-09  $ G+=5.181uS w=0.1641
* --- Row 49 ---
Xrp49_0 row49 gate cp0 0 reram_1t1r Tf0=3.300000e-09  $ G+=0.296uS w=-0.3939
Xrp49_1 row49 gate cp1 0 reram_1t1r Tf0=4.046607e-09  $ G+=4.554uS w=0.1430
Xrp49_2 row49 gate cp2 0 reram_1t1r Tf0=3.300000e-09  $ G+=0.296uS w=-0.1503
Xrp49_3 row49 gate cp3 0 reram_1t1r Tf0=4.345709e-09  $ G+=13.507uS w=0.4438
Xrp49_4 row49 gate cp4 0 reram_1t1r Tf0=4.357355e-09  $ G+=14.091uS w=0.4634
* --- Row 50 ---
Xrp50_0 row50 gate cp0 0 reram_1t1r Tf0=3.300000e-09  $ G+=0.296uS w=-0.1291
Xrp50_1 row50 gate cp1 0 reram_1t1r Tf0=3.300000e-09  $ G+=0.296uS w=-0.7012
Xrp50_2 row50 gate cp2 0 reram_1t1r Tf0=4.328986e-09  $ G+=12.710uS w=0.4170
Xrp50_3 row50 gate cp3 0 reram_1t1r Tf0=3.300000e-09  $ G+=0.296uS w=-0.3657
Xrp50_4 row50 gate cp4 0 reram_1t1r Tf0=3.482224e-09  $ G+=0.585uS w=0.0097
* --- Row 51 ---
Xrp51_0 row51 gate cp0 0 reram_1t1r Tf0=4.557286e-09  $ G+=29.145uS w=0.9692
Xrp51_1 row51 gate cp1 0 reram_1t1r Tf0=3.300000e-09  $ G+=0.296uS w=-1.4477
Xrp51_2 row51 gate cp2 0 reram_1t1r Tf0=3.300000e-09  $ G+=0.296uS w=-0.9401
Xrp51_3 row51 gate cp3 0 reram_1t1r Tf0=3.300000e-09  $ G+=0.296uS w=-0.0650
Xrp51_4 row51 gate cp4 0 reram_1t1r Tf0=3.795381e-09  $ G+=1.827uS w=0.0514
* --- Row 52 ---
Xrp52_0 row52 gate cp0 0 reram_1t1r Tf0=4.334836e-09  $ G+=12.984uS w=0.4262
Xrp52_1 row52 gate cp1 0 reram_1t1r Tf0=4.319176e-09  $ G+=12.265uS w=0.4021
Xrp52_2 row52 gate cp2 0 reram_1t1r Tf0=3.300000e-09  $ G+=0.296uS w=-0.7267
Xrp52_3 row52 gate cp3 0 reram_1t1r Tf0=3.437430e-09  $ G+=0.497uS w=0.0068
Xrp52_4 row52 gate cp4 0 reram_1t1r Tf0=3.300000e-09  $ G+=0.296uS w=-0.2039
* --- Row 53 ---
Xrp53_0 row53 gate cp0 0 reram_1t1r Tf0=3.300000e-09  $ G+=0.296uS w=-0.2561
Xrp53_1 row53 gate cp1 0 reram_1t1r Tf0=3.300000e-09  $ G+=0.296uS w=-0.9948
Xrp53_2 row53 gate cp2 0 reram_1t1r Tf0=4.485028e-09  $ G+=22.413uS w=0.7430
Xrp53_3 row53 gate cp3 0 reram_1t1r Tf0=4.166707e-09  $ G+=7.046uS w=0.2268
Xrp53_4 row53 gate cp4 0 reram_1t1r Tf0=3.813881e-09  $ G+=1.954uS w=0.0557
* --- Row 54 ---
Xrp54_0 row54 gate cp0 0 reram_1t1r Tf0=3.300000e-09  $ G+=0.296uS w=-0.5136
Xrp54_1 row54 gate cp1 0 reram_1t1r Tf0=3.976341e-09  $ G+=3.527uS w=0.1086
Xrp54_2 row54 gate cp2 0 reram_1t1r Tf0=4.180043e-09  $ G+=7.396uS w=0.2385
Xrp54_3 row54 gate cp3 0 reram_1t1r Tf0=4.533993e-09  $ G+=26.779uS w=0.8897
Xrp54_4 row54 gate cp4 0 reram_1t1r Tf0=3.300000e-09  $ G+=0.296uS w=-0.2619
* --- Row 55 ---
Xrp55_0 row55 gate cp0 0 reram_1t1r Tf0=4.481378e-09  $ G+=22.117uS w=0.7331
Xrp55_1 row55 gate cp1 0 reram_1t1r Tf0=3.300000e-09  $ G+=0.296uS w=-1.1161
Xrp55_2 row55 gate cp2 0 reram_1t1r Tf0=3.300000e-09  $ G+=0.296uS w=-0.5908
Xrp55_3 row55 gate cp3 0 reram_1t1r Tf0=3.300000e-09  $ G+=0.296uS w=-0.0197
Xrp55_4 row55 gate cp4 0 reram_1t1r Tf0=3.982119e-09  $ G+=3.602uS w=0.1111
* --- Row 56 ---
Xrp56_0 row56 gate cp0 0 reram_1t1r Tf0=3.300000e-09  $ G+=0.296uS w=-0.4853
Xrp56_1 row56 gate cp1 0 reram_1t1r Tf0=4.363038e-09  $ G+=14.385uS w=0.4733
Xrp56_2 row56 gate cp2 0 reram_1t1r Tf0=4.103878e-09  $ G+=5.608uS w=0.1784
Xrp56_3 row56 gate cp3 0 reram_1t1r Tf0=3.300000e-09  $ G+=0.296uS w=-0.7483
Xrp56_4 row56 gate cp4 0 reram_1t1r Tf0=4.197747e-09  $ G+=7.888uS w=0.2550
* --- Row 57 ---
Xrp57_0 row57 gate cp0 0 reram_1t1r Tf0=3.300000e-09  $ G+=0.296uS w=-0.2756
Xrp57_1 row57 gate cp1 0 reram_1t1r Tf0=3.300000e-09  $ G+=0.296uS w=-0.2147
Xrp57_2 row57 gate cp2 0 reram_1t1r Tf0=4.273359e-09  $ G+=10.383uS w=0.3389
Xrp57_3 row57 gate cp3 0 reram_1t1r Tf0=3.911877e-09  $ G+=2.790uS w=0.0838
Xrp57_4 row57 gate cp4 0 reram_1t1r Tf0=3.754789e-09  $ G+=1.576uS w=0.0430
* --- Row 58 ---
Xrp58_0 row58 gate cp0 0 reram_1t1r Tf0=3.300000e-09  $ G+=0.296uS w=-0.2450
Xrp58_1 row58 gate cp1 0 reram_1t1r Tf0=3.300000e-09  $ G+=0.296uS w=-0.5366
Xrp58_2 row58 gate cp2 0 reram_1t1r Tf0=4.356568e-09  $ G+=14.051uS w=0.4621
Xrp58_3 row58 gate cp3 0 reram_1t1r Tf0=4.274836e-09  $ G+=10.439uS w=0.3408
Xrp58_4 row58 gate cp4 0 reram_1t1r Tf0=3.300000e-09  $ G+=0.296uS w=-0.0858
* --- Row 59 ---
Xrp59_0 row59 gate cp0 0 reram_1t1r Tf0=4.065885e-09  $ G+=4.884uS w=0.1541
Xrp59_1 row59 gate cp1 0 reram_1t1r Tf0=4.242507e-09  $ G+=9.282uS w=0.3019
Xrp59_2 row59 gate cp2 0 reram_1t1r Tf0=3.300000e-09  $ G+=0.296uS w=-0.0886
Xrp59_3 row59 gate cp3 0 reram_1t1r Tf0=3.300000e-09  $ G+=0.296uS w=-1.1871
Xrp59_4 row59 gate cp4 0 reram_1t1r Tf0=3.300000e-09  $ G+=0.296uS w=-1.2026
* --- Row 60 ---
Xrp60_0 row60 gate cp0 0 reram_1t1r Tf0=4.387388e-09  $ G+=15.716uS w=0.5180
Xrp60_1 row60 gate cp1 0 reram_1t1r Tf0=3.300000e-09  $ G+=0.296uS w=-0.0520
Xrp60_2 row60 gate cp2 0 reram_1t1r Tf0=3.300000e-09  $ G+=0.296uS w=-0.9281
Xrp60_3 row60 gate cp3 0 reram_1t1r Tf0=3.808009e-09  $ G+=1.913uS w=0.0543
Xrp60_4 row60 gate cp4 0 reram_1t1r Tf0=3.300000e-09  $ G+=0.296uS w=-0.0199
* --- Row 61 ---
Xrp61_0 row61 gate cp0 0 reram_1t1r Tf0=3.960568e-09  $ G+=3.331uS w=0.1019
Xrp61_1 row61 gate cp1 0 reram_1t1r Tf0=3.300000e-09  $ G+=0.296uS w=-0.5287
Xrp61_2 row61 gate cp2 0 reram_1t1r Tf0=3.300000e-09  $ G+=0.296uS w=-0.3811
Xrp61_3 row61 gate cp3 0 reram_1t1r Tf0=4.556744e-09  $ G+=29.088uS w=0.9672
Xrp61_4 row61 gate cp4 0 reram_1t1r Tf0=3.300000e-09  $ G+=0.296uS w=-0.1245
* --- Row 62 ---
Xrp62_0 row62 gate cp0 0 reram_1t1r Tf0=4.337664e-09  $ G+=13.118uS w=0.4307
Xrp62_1 row62 gate cp1 0 reram_1t1r Tf0=3.300000e-09  $ G+=0.296uS w=-0.7204
Xrp62_2 row62 gate cp2 0 reram_1t1r Tf0=3.300000e-09  $ G+=0.296uS w=-0.2671
Xrp62_3 row62 gate cp3 0 reram_1t1r Tf0=3.300000e-09  $ G+=0.296uS w=-0.5036
Xrp62_4 row62 gate cp4 0 reram_1t1r Tf0=4.045084e-09  $ G+=4.529uS w=0.1422
* --- Row 63 ---
Xrp63_0 row63 gate cp0 0 reram_1t1r Tf0=4.427823e-09  $ G+=18.205uS w=0.6016
Xrp63_1 row63 gate cp1 0 reram_1t1r Tf0=4.262965e-09  $ G+=9.998uS w=0.3259
Xrp63_2 row63 gate cp2 0 reram_1t1r Tf0=3.300000e-09  $ G+=0.296uS w=-0.7217
Xrp63_3 row63 gate cp3 0 reram_1t1r Tf0=4.251334e-09  $ G+=9.585uS w=0.3120
Xrp63_4 row63 gate cp4 0 reram_1t1r Tf0=3.300000e-09  $ G+=0.296uS w=-0.6746

* ===== NEGATIVE CONDUCTANCE ARRAY (64x5) =====
* --- Row 0 ---
Xrn0_0 row0 gate cn0 0 reram_1t1r Tf0=4.320911e-09  $ G-=12.343uS w=-0.4047
Xrn0_1 row0 gate cn1 0 reram_1t1r Tf0=3.300000e-09  $ G-=0.296uS w=0.3944
Xrn0_2 row0 gate cn2 0 reram_1t1r Tf0=3.300000e-09  $ G-=0.296uS w=0.2177
Xrn0_3 row0 gate cn3 0 reram_1t1r Tf0=4.132225e-09  $ G-=6.216uS w=-0.1989
Xrn0_4 row0 gate cn4 0 reram_1t1r Tf0=4.393409e-09  $ G-=16.064uS w=-0.5297
* --- Row 1 ---
Xrn1_0 row1 gate cn0 0 reram_1t1r Tf0=3.300000e-09  $ G-=0.296uS w=0.7449
Xrn1_1 row1 gate cn1 0 reram_1t1r Tf0=4.516456e-09  $ G-=25.125uS w=-0.8341
Xrn1_2 row1 gate cn2 0 reram_1t1r Tf0=4.490212e-09  $ G-=22.839uS w=-0.7573
Xrn1_3 row1 gate cn3 0 reram_1t1r Tf0=3.300000e-09  $ G-=0.296uS w=0.3982
Xrn1_4 row1 gate cn4 0 reram_1t1r Tf0=3.675093e-09  $ G-=1.180uS w=-0.0297
* --- Row 2 ---
Xrn2_0 row2 gate cn0 0 reram_1t1r Tf0=4.533189e-09  $ G-=26.701uS w=-0.8871
Xrn2_1 row2 gate cn1 0 reram_1t1r Tf0=4.211641e-09  $ G-=8.297uS w=-0.2688
Xrn2_2 row2 gate cn2 0 reram_1t1r Tf0=3.300000e-09  $ G-=0.296uS w=0.2639
Xrn2_3 row2 gate cn3 0 reram_1t1r Tf0=3.300000e-09  $ G-=0.296uS w=0.1935
Xrn2_4 row2 gate cn4 0 reram_1t1r Tf0=4.170108e-09  $ G-=7.134uS w=-0.2297
* --- Row 3 ---
Xrn3_0 row3 gate cn0 0 reram_1t1r Tf0=3.300000e-09  $ G-=0.296uS w=0.1611
Xrn3_1 row3 gate cn1 0 reram_1t1r Tf0=4.721550e-09  $ G-=52.953uS w=-1.7690
Xrn3_2 row3 gate cn2 0 reram_1t1r Tf0=3.300000e-09  $ G-=0.296uS w=0.2319
Xrn3_3 row3 gate cn3 0 reram_1t1r Tf0=3.300000e-09  $ G-=0.296uS w=0.6032
Xrn3_4 row3 gate cn4 0 reram_1t1r Tf0=3.300000e-09  $ G-=0.296uS w=0.0248
* --- Row 4 ---
Xrn4_0 row4 gate cn0 0 reram_1t1r Tf0=3.300000e-09  $ G-=0.296uS w=0.1753
Xrn4_1 row4 gate cn1 0 reram_1t1r Tf0=4.604559e-09  $ G-=34.610uS w=-1.1527
Xrn4_2 row4 gate cn2 0 reram_1t1r Tf0=3.300000e-09  $ G-=0.296uS w=0.0368
Xrn4_3 row4 gate cn3 0 reram_1t1r Tf0=4.027652e-09  $ G-=4.251uS w=-0.1328
Xrn4_4 row4 gate cn4 0 reram_1t1r Tf0=4.132474e-09  $ G-=6.222uS w=-0.1991
* --- Row 5 ---
Xrn5_0 row5 gate cn0 0 reram_1t1r Tf0=3.300000e-09  $ G-=0.296uS w=0.2697
Xrn5_1 row5 gate cn1 0 reram_1t1r Tf0=4.053084e-09  $ G-=4.662uS w=-0.1467
Xrn5_2 row5 gate cn2 0 reram_1t1r Tf0=4.479747e-09  $ G-=21.987uS w=-0.7287
Xrn5_3 row5 gate cn3 0 reram_1t1r Tf0=4.342178e-09  $ G-=13.335uS w=-0.4380
Xrn5_4 row5 gate cn4 0 reram_1t1r Tf0=4.207637e-09  $ G-=8.177uS w=-0.2647
* --- Row 6 ---
Xrn6_0 row6 gate cn0 0 reram_1t1r Tf0=4.402110e-09  $ G-=16.580uS w=-0.5471
Xrn6_1 row6 gate cn1 0 reram_1t1r Tf0=3.373642e-09  $ G-=0.394uS w=-0.0033
Xrn6_2 row6 gate cn2 0 reram_1t1r Tf0=3.300000e-09  $ G-=0.296uS w=0.4851
Xrn6_3 row6 gate cn3 0 reram_1t1r Tf0=3.300000e-09  $ G-=0.296uS w=0.1389
Xrn6_4 row6 gate cn4 0 reram_1t1r Tf0=4.442088e-09  $ G-=19.174uS w=-0.6342
* --- Row 7 ---
Xrn7_0 row7 gate cn0 0 reram_1t1r Tf0=3.300000e-09  $ G-=0.296uS w=0.3648
Xrn7_1 row7 gate cn1 0 reram_1t1r Tf0=4.757021e-09  $ G-=60.240uS w=-2.0138
Xrn7_2 row7 gate cn2 0 reram_1t1r Tf0=4.469707e-09  $ G-=21.199uS w=-0.7022
Xrn7_3 row7 gate cn3 0 reram_1t1r Tf0=3.300000e-09  $ G-=0.296uS w=0.8440
Xrn7_4 row7 gate cn4 0 reram_1t1r Tf0=3.300000e-09  $ G-=0.296uS w=0.2536
* --- Row 8 ---
Xrn8_0 row8 gate cn0 0 reram_1t1r Tf0=4.317522e-09  $ G-=12.192uS w=-0.3996
Xrn8_1 row8 gate cn1 0 reram_1t1r Tf0=4.385735e-09  $ G-=15.622uS w=-0.5149
Xrn8_2 row8 gate cn2 0 reram_1t1r Tf0=3.300000e-09  $ G-=0.296uS w=0.3147
Xrn8_3 row8 gate cn3 0 reram_1t1r Tf0=3.300000e-09  $ G-=0.296uS w=0.4128
Xrn8_4 row8 gate cn4 0 reram_1t1r Tf0=3.300000e-09  $ G-=0.296uS w=0.0248
* --- Row 9 ---
Xrn9_0 row9 gate cn0 0 reram_1t1r Tf0=4.172544e-09  $ G-=7.198uS w=-0.2319
Xrn9_1 row9 gate cn1 0 reram_1t1r Tf0=4.317392e-09  $ G-=12.186uS w=-0.3994
Xrn9_2 row9 gate cn2 0 reram_1t1r Tf0=3.300000e-09  $ G-=0.296uS w=0.4405
Xrn9_3 row9 gate cn3 0 reram_1t1r Tf0=4.052821e-09  $ G-=4.658uS w=-0.1465
Xrn9_4 row9 gate cn4 0 reram_1t1r Tf0=3.642486e-09  $ G-=1.048uS w=-0.0253
* --- Row 10 ---
Xrn10_0 row10 gate cn0 0 reram_1t1r Tf0=3.300000e-09  $ G-=0.296uS w=0.3354
Xrn10_1 row10 gate cn1 0 reram_1t1r Tf0=3.300000e-09  $ G-=0.296uS w=0.0959
Xrn10_2 row10 gate cn2 0 reram_1t1r Tf0=4.286659e-09  $ G-=10.898uS w=-0.3562
Xrn10_3 row10 gate cn3 0 reram_1t1r Tf0=4.467767e-09  $ G-=21.050uS w=-0.6972
Xrn10_4 row10 gate cn4 0 reram_1t1r Tf0=4.469476e-09  $ G-=21.181uS w=-0.7016
* --- Row 11 ---
Xrn11_0 row11 gate cn0 0 reram_1t1r Tf0=3.300000e-09  $ G-=0.296uS w=0.1888
Xrn11_1 row11 gate cn1 0 reram_1t1r Tf0=4.427906e-09  $ G-=18.210uS w=-0.6018
Xrn11_2 row11 gate cn2 0 reram_1t1r Tf0=3.300000e-09  $ G-=0.296uS w=0.5180
Xrn11_3 row11 gate cn3 0 reram_1t1r Tf0=4.471037e-09  $ G-=21.302uS w=-0.7057
Xrn11_4 row11 gate cn4 0 reram_1t1r Tf0=3.300000e-09  $ G-=0.296uS w=0.0794
* --- Row 12 ---
Xrn12_0 row12 gate cn0 0 reram_1t1r Tf0=3.300000e-09  $ G-=0.296uS w=0.4751
Xrn12_1 row12 gate cn1 0 reram_1t1r Tf0=4.544658e-09  $ G-=27.838uS w=-0.9252
Xrn12_2 row12 gate cn2 0 reram_1t1r Tf0=4.440045e-09  $ G-=19.032uS w=-0.6294
Xrn12_3 row12 gate cn3 0 reram_1t1r Tf0=3.972060e-09  $ G-=3.473uS w=-0.1067
Xrn12_4 row12 gate cn4 0 reram_1t1r Tf0=4.044543e-09  $ G-=4.520uS w=-0.1419
* --- Row 13 ---
Xrn13_0 row13 gate cn0 0 reram_1t1r Tf0=4.312785e-09  $ G-=11.983uS w=-0.3926
Xrn13_1 row13 gate cn1 0 reram_1t1r Tf0=4.529551e-09  $ G-=26.350uS w=-0.8753
Xrn13_2 row13 gate cn2 0 reram_1t1r Tf0=3.300000e-09  $ G-=0.296uS w=0.3616
Xrn13_3 row13 gate cn3 0 reram_1t1r Tf0=4.241063e-09  $ G-=9.233uS w=-0.3002
Xrn13_4 row13 gate cn4 0 reram_1t1r Tf0=3.300000e-09  $ G-=0.296uS w=0.4745
* --- Row 14 ---
Xrn14_0 row14 gate cn0 0 reram_1t1r Tf0=3.300000e-09  $ G-=0.296uS w=0.0010
Xrn14_1 row14 gate cn1 0 reram_1t1r Tf0=4.207205e-09  $ G-=8.164uS w=-0.2643
Xrn14_2 row14 gate cn2 0 reram_1t1r Tf0=3.300000e-09  $ G-=0.296uS w=0.8229
Xrn14_3 row14 gate cn3 0 reram_1t1r Tf0=4.404979e-09  $ G-=16.754uS w=-0.5529
Xrn14_4 row14 gate cn4 0 reram_1t1r Tf0=4.359635e-09  $ G-=14.208uS w=-0.4674
* --- Row 15 ---
Xrn15_0 row15 gate cn0 0 reram_1t1r Tf0=4.163068e-09  $ G-=6.954uS w=-0.2237
Xrn15_1 row15 gate cn1 0 reram_1t1r Tf0=4.173381e-09  $ G-=7.219uS w=-0.2326
Xrn15_2 row15 gate cn2 0 reram_1t1r Tf0=3.300000e-09  $ G-=0.296uS w=0.5213
Xrn15_3 row15 gate cn3 0 reram_1t1r Tf0=3.300000e-09  $ G-=0.296uS w=0.0765
Xrn15_4 row15 gate cn4 0 reram_1t1r Tf0=4.577363e-09  $ G-=31.352uS w=-1.0433
* --- Row 16 ---
Xrn16_0 row16 gate cn0 0 reram_1t1r Tf0=4.485092e-09  $ G-=22.418uS w=-0.7432
Xrn16_1 row16 gate cn1 0 reram_1t1r Tf0=3.439082e-09  $ G-=0.500uS w=-0.0069
Xrn16_2 row16 gate cn2 0 reram_1t1r Tf0=3.300000e-09  $ G-=0.296uS w=0.6853
Xrn16_3 row16 gate cn3 0 reram_1t1r Tf0=3.300000e-09  $ G-=0.296uS w=0.4168
Xrn16_4 row16 gate cn4 0 reram_1t1r Tf0=4.339921e-09  $ G-=13.226uS w=-0.4344
* --- Row 17 ---
Xrn17_0 row17 gate cn0 0 reram_1t1r Tf0=3.300000e-09  $ G-=0.296uS w=0.6115
Xrn17_1 row17 gate cn1 0 reram_1t1r Tf0=3.341961e-09  $ G-=0.352uS w=-0.0019
Xrn17_2 row17 gate cn2 0 reram_1t1r Tf0=4.274152e-09  $ G-=10.413uS w=-0.3399
Xrn17_3 row17 gate cn3 0 reram_1t1r Tf0=4.451347e-09  $ G-=19.830uS w=-0.6562
Xrn17_4 row17 gate cn4 0 reram_1t1r Tf0=4.462365e-09  $ G-=20.641uS w=-0.6835
* --- Row 18 ---
Xrn18_0 row18 gate cn0 0 reram_1t1r Tf0=3.300000e-09  $ G-=0.296uS w=0.0981
Xrn18_1 row18 gate cn1 0 reram_1t1r Tf0=4.519020e-09  $ G-=25.361uS w=-0.8420
Xrn18_2 row18 gate cn2 0 reram_1t1r Tf0=4.428660e-09  $ G-=18.260uS w=-0.6035
Xrn18_3 row18 gate cn3 0 reram_1t1r Tf0=4.168788e-09  $ G-=7.100uS w=-0.2286
Xrn18_4 row18 gate cn4 0 reram_1t1r Tf0=4.036693e-09  $ G-=4.393uS w=-0.1376
* --- Row 19 ---
Xrn19_0 row19 gate cn0 0 reram_1t1r Tf0=3.300000e-09  $ G-=0.296uS w=0.5487
Xrn19_1 row19 gate cn1 0 reram_1t1r Tf0=4.159521e-09  $ G-=6.865uS w=-0.2207
Xrn19_2 row19 gate cn2 0 reram_1t1r Tf0=4.344355e-09  $ G-=13.441uS w=-0.4416
Xrn19_3 row19 gate cn3 0 reram_1t1r Tf0=3.872062e-09  $ G-=2.414uS w=-0.0712
Xrn19_4 row19 gate cn4 0 reram_1t1r Tf0=3.300000e-09  $ G-=0.296uS w=0.0943
* --- Row 20 ---
Xrn20_0 row20 gate cn0 0 reram_1t1r Tf0=4.219794e-09  $ G-=8.546uS w=-0.2772
Xrn20_1 row20 gate cn1 0 reram_1t1r Tf0=4.205895e-09  $ G-=8.125uS w=-0.2630
Xrn20_2 row20 gate cn2 0 reram_1t1r Tf0=3.300000e-09  $ G-=0.296uS w=0.3827
Xrn20_3 row20 gate cn3 0 reram_1t1r Tf0=3.300000e-09  $ G-=0.296uS w=0.3013
Xrn20_4 row20 gate cn4 0 reram_1t1r Tf0=3.300000e-09  $ G-=0.296uS w=0.1380
* --- Row 21 ---
Xrn21_0 row21 gate cn0 0 reram_1t1r Tf0=4.313357e-09  $ G-=12.008uS w=-0.3935
Xrn21_1 row21 gate cn1 0 reram_1t1r Tf0=4.537672e-09  $ G-=27.140uS w=-0.9018
Xrn21_2 row21 gate cn2 0 reram_1t1r Tf0=3.300000e-09  $ G-=0.296uS w=0.5666
Xrn21_3 row21 gate cn3 0 reram_1t1r Tf0=3.300000e-09  $ G-=0.296uS w=0.6515
Xrn21_4 row21 gate cn4 0 reram_1t1r Tf0=4.253067e-09  $ G-=9.645uS w=-0.3141
* --- Row 22 ---
Xrn22_0 row22 gate cn0 0 reram_1t1r Tf0=3.300000e-09  $ G-=0.296uS w=0.3243
Xrn22_1 row22 gate cn1 0 reram_1t1r Tf0=4.369326e-09  $ G-=14.718uS w=-0.4845
Xrn22_2 row22 gate cn2 0 reram_1t1r Tf0=3.300000e-09  $ G-=0.296uS w=0.2645
Xrn22_3 row22 gate cn3 0 reram_1t1r Tf0=4.425991e-09  $ G-=18.084uS w=-0.5976
Xrn22_4 row22 gate cn4 0 reram_1t1r Tf0=4.221135e-09  $ G-=8.588uS w=-0.2786
* --- Row 23 ---
Xrn23_0 row23 gate cn0 0 reram_1t1r Tf0=3.300000e-09  $ G-=0.296uS w=0.0075
Xrn23_1 row23 gate cn1 0 reram_1t1r Tf0=3.300000e-09  $ G-=0.296uS w=0.4546
Xrn23_2 row23 gate cn2 0 reram_1t1r Tf0=4.511548e-09  $ G-=24.681uS w=-0.8192
Xrn23_3 row23 gate cn3 0 reram_1t1r Tf0=4.166366e-09  $ G-=7.038uS w=-0.2265
Xrn23_4 row23 gate cn4 0 reram_1t1r Tf0=4.146804e-09  $ G-=6.555uS w=-0.2103
* --- Row 24 ---
Xrn24_0 row24 gate cn0 0 reram_1t1r Tf0=3.300000e-09  $ G-=0.296uS w=0.4044
Xrn24_1 row24 gate cn1 0 reram_1t1r Tf0=4.232323e-09  $ G-=8.945uS w=-0.2905
Xrn24_2 row24 gate cn2 0 reram_1t1r Tf0=4.541490e-09  $ G-=27.519uS w=-0.9145
Xrn24_3 row24 gate cn3 0 reram_1t1r Tf0=3.300000e-09  $ G-=0.296uS w=1.1629
Xrn24_4 row24 gate cn4 0 reram_1t1r Tf0=3.300000e-09  $ G-=0.296uS w=0.0701
* --- Row 25 ---
Xrn25_0 row25 gate cn0 0 reram_1t1r Tf0=4.032968e-09  $ G-=4.334uS w=-0.1356
Xrn25_1 row25 gate cn1 0 reram_1t1r Tf0=3.300000e-09  $ G-=0.296uS w=0.8970
Xrn25_2 row25 gate cn2 0 reram_1t1r Tf0=4.667713e-09  $ G-=43.541uS w=-1.4528
Xrn25_3 row25 gate cn3 0 reram_1t1r Tf0=3.300000e-09  $ G-=0.296uS w=0.6011
Xrn25_4 row25 gate cn4 0 reram_1t1r Tf0=3.300000e-09  $ G-=0.296uS w=0.6720
* --- Row 26 ---
Xrn26_0 row26 gate cn0 0 reram_1t1r Tf0=4.347533e-09  $ G-=13.597uS w=-0.4468
Xrn26_1 row26 gate cn1 0 reram_1t1r Tf0=3.300000e-09  $ G-=0.296uS w=1.1013
Xrn26_2 row26 gate cn2 0 reram_1t1r Tf0=4.261139e-09  $ G-=9.932uS w=-0.3237
Xrn26_3 row26 gate cn3 0 reram_1t1r Tf0=3.300000e-09  $ G-=0.296uS w=0.3665
Xrn26_4 row26 gate cn4 0 reram_1t1r Tf0=3.300000e-09  $ G-=0.296uS w=0.4516
* --- Row 27 ---
Xrn27_0 row27 gate cn0 0 reram_1t1r Tf0=3.300000e-09  $ G-=0.296uS w=0.9055
Xrn27_1 row27 gate cn1 0 reram_1t1r Tf0=4.635344e-09  $ G-=38.708uS w=-1.2904
Xrn27_2 row27 gate cn2 0 reram_1t1r Tf0=4.662589e-09  $ G-=42.738uS w=-1.4258
Xrn27_3 row27 gate cn3 0 reram_1t1r Tf0=3.924008e-09  $ G-=2.916uS w=-0.0880
Xrn27_4 row27 gate cn4 0 reram_1t1r Tf0=3.300000e-09  $ G-=0.296uS w=0.4916
* --- Row 28 ---
Xrn28_0 row28 gate cn0 0 reram_1t1r Tf0=3.300000e-09  $ G-=0.296uS w=0.5243
Xrn28_1 row28 gate cn1 0 reram_1t1r Tf0=3.300000e-09  $ G-=0.296uS w=0.1957
Xrn28_2 row28 gate cn2 0 reram_1t1r Tf0=4.416172e-09  $ G-=17.450uS w=-0.5763
Xrn28_3 row28 gate cn3 0 reram_1t1r Tf0=3.621610e-09  $ G-=0.971uS w=-0.0227
Xrn28_4 row28 gate cn4 0 reram_1t1r Tf0=3.300000e-09  $ G-=0.296uS w=0.0190
* --- Row 29 ---
Xrn29_0 row29 gate cn0 0 reram_1t1r Tf0=4.397011e-09  $ G-=16.276uS w=-0.5368
Xrn29_1 row29 gate cn1 0 reram_1t1r Tf0=4.386430e-09  $ G-=15.662uS w=-0.5162
Xrn29_2 row29 gate cn2 0 reram_1t1r Tf0=3.300000e-09  $ G-=0.296uS w=0.9365
Xrn29_3 row29 gate cn3 0 reram_1t1r Tf0=4.369475e-09  $ G-=14.726uS w=-0.4848
Xrn29_4 row29 gate cn4 0 reram_1t1r Tf0=4.479012e-09  $ G-=21.928uS w=-0.7267
* --- Row 30 ---
Xrn30_0 row30 gate cn0 0 reram_1t1r Tf0=4.390312e-09  $ G-=15.884uS w=-0.5237
Xrn30_1 row30 gate cn1 0 reram_1t1r Tf0=3.300000e-09  $ G-=0.296uS w=0.8203
Xrn30_2 row30 gate cn2 0 reram_1t1r Tf0=4.188316e-09  $ G-=7.622uS w=-0.2461
Xrn30_3 row30 gate cn3 0 reram_1t1r Tf0=3.300000e-09  $ G-=0.296uS w=0.1526
Xrn30_4 row30 gate cn4 0 reram_1t1r Tf0=4.894443e-09  $ G-=99.273uS w=-3.3250
* --- Row 31 ---
Xrn31_0 row31 gate cn0 0 reram_1t1r Tf0=3.300000e-09  $ G-=0.296uS w=0.2204
Xrn31_1 row31 gate cn1 0 reram_1t1r Tf0=3.300000e-09  $ G-=0.296uS w=0.5254
Xrn31_2 row31 gate cn2 0 reram_1t1r Tf0=4.099336e-09  $ G-=5.516uS w=-0.1754
Xrn31_3 row31 gate cn3 0 reram_1t1r Tf0=4.480693e-09  $ G-=22.062uS w=-0.7312
Xrn31_4 row31 gate cn4 0 reram_1t1r Tf0=3.300000e-09  $ G-=0.296uS w=0.0614
* --- Row 32 ---
Xrn32_0 row32 gate cn0 0 reram_1t1r Tf0=4.268459e-09  $ G-=10.200uS w=-0.3327
Xrn32_1 row32 gate cn1 0 reram_1t1r Tf0=3.300000e-09  $ G-=0.296uS w=0.7771
Xrn32_2 row32 gate cn2 0 reram_1t1r Tf0=3.300000e-09  $ G-=0.296uS w=0.2356
Xrn32_3 row32 gate cn3 0 reram_1t1r Tf0=4.518165e-09  $ G-=25.282uS w=-0.8394
Xrn32_4 row32 gate cn4 0 reram_1t1r Tf0=4.718135e-09  $ G-=52.300uS w=-1.7470
* --- Row 33 ---
Xrn33_0 row33 gate cn0 0 reram_1t1r Tf0=4.533750e-09  $ G-=26.756uS w=-0.8889
Xrn33_1 row33 gate cn1 0 reram_1t1r Tf0=3.300000e-09  $ G-=0.296uS w=0.7704
Xrn33_2 row33 gate cn2 0 reram_1t1r Tf0=3.300000e-09  $ G-=0.296uS w=0.6556
Xrn33_3 row33 gate cn3 0 reram_1t1r Tf0=4.462461e-09  $ G-=20.648uS w=-0.6837
Xrn33_4 row33 gate cn4 0 reram_1t1r Tf0=3.300000e-09  $ G-=0.296uS w=0.5586
* --- Row 34 ---
Xrn34_0 row34 gate cn0 0 reram_1t1r Tf0=4.328522e-09  $ G-=12.689uS w=-0.4163
Xrn34_1 row34 gate cn1 0 reram_1t1r Tf0=3.960691e-09  $ G-=3.332uS w=-0.1020
Xrn34_2 row34 gate cn2 0 reram_1t1r Tf0=3.300000e-09  $ G-=0.296uS w=0.3976
Xrn34_3 row34 gate cn3 0 reram_1t1r Tf0=3.300000e-09  $ G-=0.296uS w=0.4513
Xrn34_4 row34 gate cn4 0 reram_1t1r Tf0=3.300000e-09  $ G-=0.296uS w=0.0775
* --- Row 35 ---
Xrn35_0 row35 gate cn0 0 reram_1t1r Tf0=3.300000e-09  $ G-=0.296uS w=0.6079
Xrn35_1 row35 gate cn1 0 reram_1t1r Tf0=3.300000e-09  $ G-=0.296uS w=0.1289
Xrn35_2 row35 gate cn2 0 reram_1t1r Tf0=4.510437e-09  $ G-=24.582uS w=-0.8158
Xrn35_3 row35 gate cn3 0 reram_1t1r Tf0=4.464673e-09  $ G-=20.814uS w=-0.6893
Xrn35_4 row35 gate cn4 0 reram_1t1r Tf0=3.300000e-09  $ G-=0.296uS w=0.4206
* --- Row 36 ---
Xrn36_0 row36 gate cn0 0 reram_1t1r Tf0=3.300000e-09  $ G-=0.296uS w=0.0900
Xrn36_1 row36 gate cn1 0 reram_1t1r Tf0=4.453717e-09  $ G-=20.002uS w=-0.6620
Xrn36_2 row36 gate cn2 0 reram_1t1r Tf0=3.300000e-09  $ G-=0.296uS w=0.3717
Xrn36_3 row36 gate cn3 0 reram_1t1r Tf0=3.300000e-09  $ G-=0.296uS w=0.4796
Xrn36_4 row36 gate cn4 0 reram_1t1r Tf0=3.945782e-09  $ G-=3.156uS w=-0.0961
* --- Row 37 ---
Xrn37_0 row37 gate cn0 0 reram_1t1r Tf0=3.300000e-09  $ G-=0.296uS w=0.0409
Xrn37_1 row37 gate cn1 0 reram_1t1r Tf0=4.150465e-09  $ G-=6.642uS w=-0.2132
Xrn37_2 row37 gate cn2 0 reram_1t1r Tf0=3.300000e-09  $ G-=0.296uS w=0.3934
Xrn37_3 row37 gate cn3 0 reram_1t1r Tf0=4.569090e-09  $ G-=30.423uS w=-1.0121
Xrn37_4 row37 gate cn4 0 reram_1t1r Tf0=3.819448e-09  $ G-=1.994uS w=-0.0570
* --- Row 38 ---
Xrn38_0 row38 gate cn0 0 reram_1t1r Tf0=3.300000e-09  $ G-=0.296uS w=0.3676
Xrn38_1 row38 gate cn1 0 reram_1t1r Tf0=3.300000e-09  $ G-=0.296uS w=0.2949
Xrn38_2 row38 gate cn2 0 reram_1t1r Tf0=4.139285e-09  $ G-=6.378uS w=-0.2043
Xrn38_3 row38 gate cn3 0 reram_1t1r Tf0=3.819503e-09  $ G-=1.995uS w=-0.0571
Xrn38_4 row38 gate cn4 0 reram_1t1r Tf0=4.575339e-09  $ G-=31.122uS w=-1.0356
* --- Row 39 ---
Xrn39_0 row39 gate cn0 0 reram_1t1r Tf0=3.300000e-09  $ G-=0.296uS w=0.6017
Xrn39_1 row39 gate cn1 0 reram_1t1r Tf0=4.492100e-09  $ G-=22.996uS w=-0.7626
Xrn39_2 row39 gate cn2 0 reram_1t1r Tf0=4.366600e-09  $ G-=14.573uS w=-0.4796
Xrn39_3 row39 gate cn3 0 reram_1t1r Tf0=3.300000e-09  $ G-=0.296uS w=0.0812
Xrn39_4 row39 gate cn4 0 reram_1t1r Tf0=4.064995e-09  $ G-=4.869uS w=-0.1536
* --- Row 40 ---
Xrn40_0 row40 gate cn0 0 reram_1t1r Tf0=4.331208e-09  $ G-=12.813uS w=-0.4205
Xrn40_1 row40 gate cn1 0 reram_1t1r Tf0=3.300000e-09  $ G-=0.296uS w=0.2973
Xrn40_2 row40 gate cn2 0 reram_1t1r Tf0=3.300000e-09  $ G-=0.296uS w=0.2693
Xrn40_3 row40 gate cn3 0 reram_1t1r Tf0=3.300000e-09  $ G-=0.296uS w=0.7835
Xrn40_4 row40 gate cn4 0 reram_1t1r Tf0=3.780858e-09  $ G-=1.733uS w=-0.0483
* --- Row 41 ---
Xrn41_0 row41 gate cn0 0 reram_1t1r Tf0=3.300000e-09  $ G-=0.296uS w=0.5340
Xrn41_1 row41 gate cn1 0 reram_1t1r Tf0=4.653455e-09  $ G-=41.342uS w=-1.3789
Xrn41_2 row41 gate cn2 0 reram_1t1r Tf0=4.424865e-09  $ G-=18.010uS w=-0.5951
Xrn41_3 row41 gate cn3 0 reram_1t1r Tf0=4.443378e-09  $ G-=19.264uS w=-0.6372
Xrn41_4 row41 gate cn4 0 reram_1t1r Tf0=3.300000e-09  $ G-=0.296uS w=0.3305
* --- Row 42 ---
Xrn42_0 row42 gate cn0 0 reram_1t1r Tf0=3.300000e-09  $ G-=0.296uS w=0.5744
Xrn42_1 row42 gate cn1 0 reram_1t1r Tf0=3.300000e-09  $ G-=0.296uS w=0.2235
Xrn42_2 row42 gate cn2 0 reram_1t1r Tf0=4.494287e-09  $ G-=23.180uS w=-0.7688
Xrn42_3 row42 gate cn3 0 reram_1t1r Tf0=3.643612e-09  $ G-=1.052uS w=-0.0254
Xrn42_4 row42 gate cn4 0 reram_1t1r Tf0=4.490182e-09  $ G-=22.837uS w=-0.7572
* --- Row 43 ---
Xrn43_0 row43 gate cn0 0 reram_1t1r Tf0=3.300000e-09  $ G-=0.296uS w=0.4264
Xrn43_1 row43 gate cn1 0 reram_1t1r Tf0=4.137907e-09  $ G-=6.346uS w=-0.2032
Xrn43_2 row43 gate cn2 0 reram_1t1r Tf0=4.243699e-09  $ G-=9.322uS w=-0.3032
Xrn43_3 row43 gate cn3 0 reram_1t1r Tf0=4.512350e-09  $ G-=24.753uS w=-0.8216
Xrn43_4 row43 gate cn4 0 reram_1t1r Tf0=3.300000e-09  $ G-=0.296uS w=0.3264
* --- Row 44 ---
Xrn44_0 row44 gate cn0 0 reram_1t1r Tf0=3.300000e-09  $ G-=0.296uS w=0.5584
Xrn44_1 row44 gate cn1 0 reram_1t1r Tf0=3.309781e-09  $ G-=0.313uS w=-0.0006
Xrn44_2 row44 gate cn2 0 reram_1t1r Tf0=3.300000e-09  $ G-=0.296uS w=0.1193
Xrn44_3 row44 gate cn3 0 reram_1t1r Tf0=4.353882e-09  $ G-=13.914uS w=-0.4575
Xrn44_4 row44 gate cn4 0 reram_1t1r Tf0=3.300000e-09  $ G-=0.296uS w=0.1696
* --- Row 45 ---
Xrn45_0 row45 gate cn0 0 reram_1t1r Tf0=4.296992e-09  $ G-=11.315uS w=-0.3702
Xrn45_1 row45 gate cn1 0 reram_1t1r Tf0=3.300000e-09  $ G-=0.296uS w=0.3787
Xrn45_2 row45 gate cn2 0 reram_1t1r Tf0=3.300000e-09  $ G-=0.296uS w=0.3949
Xrn45_3 row45 gate cn3 0 reram_1t1r Tf0=4.391479e-09  $ G-=15.952uS w=-0.5259
Xrn45_4 row45 gate cn4 0 reram_1t1r Tf0=3.300000e-09  $ G-=0.296uS w=0.0566
* --- Row 46 ---
Xrn46_0 row46 gate cn0 0 reram_1t1r Tf0=3.300000e-09  $ G-=0.296uS w=0.3446
Xrn46_1 row46 gate cn1 0 reram_1t1r Tf0=3.300000e-09  $ G-=0.296uS w=0.5350
Xrn46_2 row46 gate cn2 0 reram_1t1r Tf0=3.979385e-09  $ G-=3.567uS w=-0.1099
Xrn46_3 row46 gate cn3 0 reram_1t1r Tf0=4.458391e-09  $ G-=20.344uS w=-0.6735
Xrn46_4 row46 gate cn4 0 reram_1t1r Tf0=4.400261e-09  $ G-=16.469uS w=-0.5433
* --- Row 47 ---
Xrn47_0 row47 gate cn0 0 reram_1t1r Tf0=3.300000e-09  $ G-=0.296uS w=0.6305
Xrn47_1 row47 gate cn1 0 reram_1t1r Tf0=4.519234e-09  $ G-=25.380uS w=-0.8427
Xrn47_2 row47 gate cn2 0 reram_1t1r Tf0=3.300000e-09  $ G-=0.296uS w=0.1919
Xrn47_3 row47 gate cn3 0 reram_1t1r Tf0=3.300000e-09  $ G-=0.296uS w=0.2338
Xrn47_4 row47 gate cn4 0 reram_1t1r Tf0=4.061611e-09  $ G-=4.809uS w=-0.1516
* --- Row 48 ---
Xrn48_0 row48 gate cn0 0 reram_1t1r Tf0=3.300000e-09  $ G-=0.296uS w=0.1348
Xrn48_1 row48 gate cn1 0 reram_1t1r Tf0=3.973745e-09  $ G-=3.494uS w=-0.1074
Xrn48_2 row48 gate cn2 0 reram_1t1r Tf0=4.364014e-09  $ G-=14.436uS w=-0.4750
Xrn48_3 row48 gate cn3 0 reram_1t1r Tf0=3.300000e-09  $ G-=0.296uS w=0.0121
Xrn48_4 row48 gate cn4 0 reram_1t1r Tf0=3.300000e-09  $ G-=0.296uS w=0.1641
* --- Row 49 ---
Xrn49_0 row49 gate cn0 0 reram_1t1r Tf0=4.313651e-09  $ G-=12.021uS w=-0.3939
Xrn49_1 row49 gate cn1 0 reram_1t1r Tf0=3.300000e-09  $ G-=0.296uS w=0.1430
Xrn49_2 row49 gate cn2 0 reram_1t1r Tf0=4.059337e-09  $ G-=4.769uS w=-0.1503
Xrn49_3 row49 gate cn3 0 reram_1t1r Tf0=3.300000e-09  $ G-=0.296uS w=0.4438
Xrn49_4 row49 gate cn4 0 reram_1t1r Tf0=3.300000e-09  $ G-=0.296uS w=0.4634
* --- Row 50 ---
Xrn50_0 row50 gate cn0 0 reram_1t1r Tf0=4.020314e-09  $ G-=4.139uS w=-0.1291
Xrn50_1 row50 gate cn1 0 reram_1t1r Tf0=4.469327e-09  $ G-=21.169uS w=-0.7012
Xrn50_2 row50 gate cn2 0 reram_1t1r Tf0=3.300000e-09  $ G-=0.296uS w=0.4170
Xrn50_3 row50 gate cn3 0 reram_1t1r Tf0=4.293757e-09  $ G-=11.183uS w=-0.3657
Xrn50_4 row50 gate cn4 0 reram_1t1r Tf0=3.300000e-09  $ G-=0.296uS w=0.0097
* --- Row 51 ---
Xrn51_0 row51 gate cn0 0 reram_1t1r Tf0=3.300000e-09  $ G-=0.296uS w=0.9692
Xrn51_1 row51 gate cn1 0 reram_1t1r Tf0=4.666754e-09  $ G-=43.389uS w=-1.4477
Xrn51_2 row51 gate cn2 0 reram_1t1r Tf0=4.548991e-09  $ G-=28.280uS w=-0.9401
Xrn51_3 row51 gate cn3 0 reram_1t1r Tf0=3.850375e-09  $ G-=2.231uS w=-0.0650
Xrn51_4 row51 gate cn4 0 reram_1t1r Tf0=3.300000e-09  $ G-=0.296uS w=0.0514
* --- Row 52 ---
Xrn52_0 row52 gate cn0 0 reram_1t1r Tf0=3.300000e-09  $ G-=0.296uS w=0.4262
Xrn52_1 row52 gate cn1 0 reram_1t1r Tf0=3.300000e-09  $ G-=0.296uS w=0.4021
Xrn52_2 row52 gate cn2 0 reram_1t1r Tf0=4.479021e-09  $ G-=21.929uS w=-0.7267
Xrn52_3 row52 gate cn3 0 reram_1t1r Tf0=3.300000e-09  $ G-=0.296uS w=0.0068
Xrn52_4 row52 gate cn4 0 reram_1t1r Tf0=4.138717e-09  $ G-=6.365uS w=-0.2039
* --- Row 53 ---
Xrn53_0 row53 gate cn0 0 reram_1t1r Tf0=4.198831e-09  $ G-=7.919uS w=-0.2561
Xrn53_1 row53 gate cn1 0 reram_1t1r Tf0=4.564390e-09  $ G-=29.908uS w=-0.9948
Xrn53_2 row53 gate cn2 0 reram_1t1r Tf0=3.300000e-09  $ G-=0.296uS w=0.7430
Xrn53_3 row53 gate cn3 0 reram_1t1r Tf0=3.300000e-09  $ G-=0.296uS w=0.2268
Xrn53_4 row53 gate cn4 0 reram_1t1r Tf0=3.300000e-09  $ G-=0.296uS w=0.0557
* --- Row 54 ---
Xrn54_0 row54 gate cn0 0 reram_1t1r Tf0=4.385072e-09  $ G-=15.585uS w=-0.5136
Xrn54_1 row54 gate cn1 0 reram_1t1r Tf0=3.300000e-09  $ G-=0.296uS w=0.1086
Xrn54_2 row54 gate cn2 0 reram_1t1r Tf0=3.300000e-09  $ G-=0.296uS w=0.2385
Xrn54_3 row54 gate cn3 0 reram_1t1r Tf0=3.300000e-09  $ G-=0.296uS w=0.8897
Xrn54_4 row54 gate cn4 0 reram_1t1r Tf0=4.204785e-09  $ G-=8.093uS w=-0.2619
* --- Row 55 ---
Xrn55_0 row55 gate cn0 0 reram_1t1r Tf0=3.300000e-09  $ G-=0.296uS w=0.7331
Xrn55_1 row55 gate cn1 0 reram_1t1r Tf0=4.595740e-09  $ G-=33.518uS w=-1.1161
Xrn55_2 row55 gate cn2 0 reram_1t1r Tf0=4.422894e-09  $ G-=17.882uS w=-0.5908
Xrn55_3 row55 gate cn3 0 reram_1t1r Tf0=3.595095e-09  $ G-=0.882uS w=-0.0197
Xrn55_4 row55 gate cn4 0 reram_1t1r Tf0=3.300000e-09  $ G-=0.296uS w=0.1111
* --- Row 56 ---
Xrn56_0 row56 gate cn0 0 reram_1t1r Tf0=4.369777e-09  $ G-=14.742uS w=-0.4853
Xrn56_1 row56 gate cn1 0 reram_1t1r Tf0=3.300000e-09  $ G-=0.296uS w=0.4733
Xrn56_2 row56 gate cn2 0 reram_1t1r Tf0=3.300000e-09  $ G-=0.296uS w=0.1784
Xrn56_3 row56 gate cn3 0 reram_1t1r Tf0=4.486971e-09  $ G-=22.572uS w=-0.7483
Xrn56_4 row56 gate cn4 0 reram_1t1r Tf0=3.300000e-09  $ G-=0.296uS w=0.2550
* --- Row 57 ---
Xrn57_0 row57 gate cn0 0 reram_1t1r Tf0=4.218274e-09  $ G-=8.499uS w=-0.2756
Xrn57_1 row57 gate cn1 0 reram_1t1r Tf0=4.152311e-09  $ G-=6.687uS w=-0.2147
Xrn57_2 row57 gate cn2 0 reram_1t1r Tf0=3.300000e-09  $ G-=0.296uS w=0.3389
Xrn57_3 row57 gate cn3 0 reram_1t1r Tf0=3.300000e-09  $ G-=0.296uS w=0.0838
Xrn57_4 row57 gate cn4 0 reram_1t1r Tf0=3.300000e-09  $ G-=0.296uS w=0.0430
* --- Row 58 ---
Xrn58_0 row58 gate cn0 0 reram_1t1r Tf0=4.187068e-09  $ G-=7.588uS w=-0.2450
Xrn58_1 row58 gate cn1 0 reram_1t1r Tf0=4.396881e-09  $ G-=16.268uS w=-0.5366
Xrn58_2 row58 gate cn2 0 reram_1t1r Tf0=3.300000e-09  $ G-=0.296uS w=0.4621
Xrn58_3 row58 gate cn3 0 reram_1t1r Tf0=3.300000e-09  $ G-=0.296uS w=0.3408
Xrn58_4 row58 gate cn4 0 reram_1t1r Tf0=3.917714e-09  $ G-=2.850uS w=-0.0858
* --- Row 59 ---
Xrn59_0 row59 gate cn0 0 reram_1t1r Tf0=3.300000e-09  $ G-=0.296uS w=0.1541
Xrn59_1 row59 gate cn1 0 reram_1t1r Tf0=3.300000e-09  $ G-=0.296uS w=0.3019
Xrn59_2 row59 gate cn2 0 reram_1t1r Tf0=3.925533e-09  $ G-=2.932uS w=-0.0886
Xrn59_3 row59 gate cn3 0 reram_1t1r Tf0=4.612574e-09  $ G-=35.633uS w=-1.1871
Xrn59_4 row59 gate cn4 0 reram_1t1r Tf0=4.616100e-09  $ G-=36.093uS w=-1.2026
* --- Row 60 ---
Xrn60_0 row60 gate cn0 0 reram_1t1r Tf0=3.300000e-09  $ G-=0.296uS w=0.5180
Xrn60_1 row60 gate cn1 0 reram_1t1r Tf0=3.797835e-09  $ G-=1.843uS w=-0.0520
Xrn60_2 row60 gate cn2 0 reram_1t1r Tf0=4.545508e-09  $ G-=27.924uS w=-0.9281
Xrn60_3 row60 gate cn3 0 reram_1t1r Tf0=3.300000e-09  $ G-=0.296uS w=0.0543
Xrn60_4 row60 gate cn4 0 reram_1t1r Tf0=3.597128e-09  $ G-=0.889uS w=-0.0199
* --- Row 61 ---
Xrn61_0 row61 gate cn0 0 reram_1t1r Tf0=3.300000e-09  $ G-=0.296uS w=0.1019
Xrn61_1 row61 gate cn1 0 reram_1t1r Tf0=4.392891e-09  $ G-=16.034uS w=-0.5287
Xrn61_2 row61 gate cn2 0 reram_1t1r Tf0=4.304819e-09  $ G-=11.641uS w=-0.3811
Xrn61_3 row61 gate cn3 0 reram_1t1r Tf0=3.300000e-09  $ G-=0.296uS w=0.9672
Xrn61_4 row61 gate cn4 0 reram_1t1r Tf0=4.011101e-09  $ G-=4.002uS w=-0.1245
* --- Row 62 ---
Xrn62_0 row62 gate cn0 0 reram_1t1r Tf0=3.300000e-09  $ G-=0.296uS w=0.4307
Xrn62_1 row62 gate cn1 0 reram_1t1r Tf0=4.476628e-09  $ G-=21.739uS w=-0.7204
Xrn62_2 row62 gate cn2 0 reram_1t1r Tf0=4.209985e-09  $ G-=8.247uS w=-0.2671
Xrn62_3 row62 gate cn3 0 reram_1t1r Tf0=4.379740e-09  $ G-=15.286uS w=-0.5036
Xrn62_4 row62 gate cn4 0 reram_1t1r Tf0=3.300000e-09  $ G-=0.296uS w=0.1422
* --- Row 63 ---
Xrn63_0 row63 gate cn0 0 reram_1t1r Tf0=3.300000e-09  $ G-=0.296uS w=0.6016
Xrn63_1 row63 gate cn1 0 reram_1t1r Tf0=3.300000e-09  $ G-=0.296uS w=0.3259
Xrn63_2 row63 gate cn2 0 reram_1t1r Tf0=4.477118e-09  $ G-=21.778uS w=-0.7217
Xrn63_3 row63 gate cn3 0 reram_1t1r Tf0=3.300000e-09  $ G-=0.296uS w=0.3120
Xrn63_4 row63 gate cn4 0 reram_1t1r Tf0=4.458825e-09  $ G-=20.377uS w=-0.6746

.op

.control
run
print i(Vsp0) i(Vsn0)
print i(Vsp1) i(Vsn1)
print i(Vsp2) i(Vsn2)
print i(Vsp3) i(Vsn3)
print i(Vsp4) i(Vsn4)
quit
.endc

.end
