* =================================================================
* ReLU Cell: NMOS Current-Mirror Diode Clamp
* Technology: SKY130 sky130_fd_pr__nfet_01v8
* =================================================================
* Current-domain ReLU: I_out = max(0, I_in)
* M1 (diode-connected) conducts for positive current; M2 mirrors it.
* Negative current turns M1 off -> I_out = 0.
* M1, M2: W=4.0u L=0.5u
* =================================================================

.include "C:/src/skywater-pdk-libs-sky130_fd_pr/cells/nfet_01v8/sky130_fd_pr__nfet_01v8__tt.corner.spice"
.include "C:/src/skywater-pdk-libs-sky130_fd_pr/cells/nfet_01v8/sky130_fd_pr__nfet_01v8__mismatch.corner.spice"

X1 nref nref 0 0 sky130_fd_pr__nfet_01v8 W=4.0u L=0.5u
X2 nout nref 0 0 sky130_fd_pr__nfet_01v8 W=4.0u L=0.5u
Vfix nout 0 1.0
Iin 0 nref 5u

.op
.control
run
print i(Vfix)
quit
.endc
.end
