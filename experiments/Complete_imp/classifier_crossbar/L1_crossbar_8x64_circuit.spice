* =================================================================
* LAYER 1 (circuit features): 8x64 Differential 1T1R ReRAM Crossbar
* Technology: SKY130 sky130_fd_pr__nfet_01v8 + ReRAM PDK (behavioral sinh I-V)
* ReRAM model: sky130_fd_pr_reram__reram_cell (I_k1=6.14e-05, V_ref=0.43)
* =================================================================
*
* Conductance range: 0.296 - 99.273 uS (SKY130 ReRAM PDK)
* Tfilament range: 3.3 - 4.9 nm
* V_READ = 0.15V, V_GATE = 1.8V
* Scale factor: 1.470605e+05
* Total 1T1R cells: 1024 (differential)
*
* Biases (add after current sensing):
*   b[0] = 0.401224
*   b[1] = 0.458277
*   b[2] = -0.272206
*   b[3] = 0.053293
*   b[4] = 0.231053
*   b[5] = 0.798822
*   b[6] = 0.839803
*   b[7] = 0.422630
*   b[8] = 0.060437
*   b[9] = -0.158792
*   b[10] = 0.816327
*   b[11] = 0.503960
*   b[12] = 0.430154
*   b[13] = -0.051189
*   b[14] = 0.378879
*   b[15] = 0.436782
*   b[16] = -0.709409
*   b[17] = 0.405458
*   b[18] = 0.367692
*   b[19] = 0.581199
*   b[20] = 0.423393
*   b[21] = 0.218903
*   b[22] = 0.619005
*   b[23] = 0.020435
*   b[24] = -0.155160
*   b[25] = -0.576510
*   b[26] = -0.156714
*   b[27] = -0.220227
*   b[28] = 0.638174
*   b[29] = -0.224821
*   b[30] = 0.131708
*   b[31] = 0.377639
*   b[32] = 0.458786
*   b[33] = 0.367612
*   b[34] = -0.048095
*   b[35] = 0.027035
*   b[36] = 0.057567
*   b[37] = 0.122350
*   b[38] = 0.529416
*   b[39] = 0.276474
*   b[40] = 0.113632
*   b[41] = 0.522518
*   b[42] = 0.826732
*   b[43] = 0.359881
*   b[44] = 0.032252
*   b[45] = -0.061804
*   b[46] = -0.005327
*   b[47] = -0.032005
*   b[48] = 0.439325
*   b[49] = -0.351290
*   b[50] = 0.518463
*   b[51] = -0.275361
*   b[52] = 0.011696
*   b[53] = 0.599962
*   b[54] = 0.023888
*   b[55] = -0.002831
*   b[56] = -0.000310
*   b[57] = 0.156087
*   b[58] = -0.082177
*   b[59] = 0.970853
*   b[60] = -0.011662
*   b[61] = 0.314709
*   b[62] = 0.442909
*   b[63] = 0.816306
* =================================================================
* Column readout: NFET diode W=50.0u L=1.0u + col_readout subcircuit
* V_row offset: +0.52V (compensates NFET diode column voltage)

.include "C:/src/skywater-pdk-libs-sky130_fd_pr/cells/nfet_01v8/sky130_fd_pr__nfet_01v8__tt.corner.spice"
.include "C:/src/skywater-pdk-libs-sky130_fd_pr/cells/nfet_01v8/sky130_fd_pr__nfet_01v8__mismatch.corner.spice"
.include "C:/src/skywater-pdk-libs-sky130_fd_pr/cells/pfet_01v8/sky130_fd_pr__pfet_01v8__tt.corner.spice"
.include "C:/src/skywater-pdk-libs-sky130_fd_pr/cells/pfet_01v8/sky130_fd_pr__pfet_01v8__mismatch.corner.spice"

.param sky130_fd_pr__pfet_01v8__a0_diff = 0
.param sky130_fd_pr__pfet_01v8__agidl_diff = 0
.param sky130_fd_pr__pfet_01v8__ags_diff = 0
.param sky130_fd_pr__pfet_01v8__b0_diff = 0
.param sky130_fd_pr__pfet_01v8__b1_diff = 0
.param sky130_fd_pr__pfet_01v8__bgidl_diff = 0
.param sky130_fd_pr__pfet_01v8__cgidl_diff = 0
.param sky130_fd_pr__pfet_01v8__dlc_diff = 0
.param sky130_fd_pr__pfet_01v8__dwc_diff = 0
.param sky130_fd_pr__pfet_01v8__eta0_diff = 0
.param sky130_fd_pr__pfet_01v8__k2_diff = 0
.param sky130_fd_pr__pfet_01v8__keta_diff = 0
.param sky130_fd_pr__pfet_01v8__kt1_diff = 0
.param sky130_fd_pr__pfet_01v8__ku0_diff = 0
.param sky130_fd_pr__pfet_01v8__kvsat_diff = 0
.param sky130_fd_pr__pfet_01v8__kvth0_diff = 0
.param sky130_fd_pr__pfet_01v8__lint_diff = 0
.param sky130_fd_pr__pfet_01v8__lku0_diff = 0
.param sky130_fd_pr__pfet_01v8__lkvth0_diff = 0
.param sky130_fd_pr__pfet_01v8__nfactor_diff = 0
.param sky130_fd_pr__pfet_01v8__pclm_diff = 0
.param sky130_fd_pr__pfet_01v8__pdits_diff = 0
.param sky130_fd_pr__pfet_01v8__pditsd_diff = 0
.param sky130_fd_pr__pfet_01v8__rdsw_diff = 0
.param sky130_fd_pr__pfet_01v8__tvoff_diff = 0
.param sky130_fd_pr__pfet_01v8__u0_diff = 0
.param sky130_fd_pr__pfet_01v8__ua_diff = 0
.param sky130_fd_pr__pfet_01v8__ub_diff = 0
.param sky130_fd_pr__pfet_01v8__uc_diff = 0
.param sky130_fd_pr__pfet_01v8__ute_diff = 0
.param sky130_fd_pr__pfet_01v8__voff_diff = 0
.param sky130_fd_pr__pfet_01v8__vsat_diff = 0
.param sky130_fd_pr__pfet_01v8__vth0_diff = 0
.param sky130_fd_pr__pfet_01v8__wint_diff = 0
.param sky130_fd_pr__pfet_01v8__wku0_diff = 0
.param sky130_fd_pr__pfet_01v8__wkvth0_diff = 0
.param sky130_fd_pr__pfet_01v8__wlod_diff = 0

* === 1T1R ReRAM cell (SKY130 PDK behavioral I-V) ===
.subckt reram_1t1r row gate col gnd Tf0=3.3e-9
.param Ik1=6.14e-05
.param Tox=5e-09
.param Tfref=4.7249e-09
.param Vref=0.43
Xacc row gate mid gnd sky130_fd_pr__nfet_01v8 W=1.0u L=0.15u
Breram mid col I = Ik1*exp(-(Tox-Tf0)/(Tox-Tfref))*sinh(v(mid,col)/Vref)
.ends reram_1t1r

* === Differential column readout (replaces Vsource + CCCS) ===
.subckt col_readout col_p col_n nmac vdd gnd
Xpd col_p col_p gnd gnd sky130_fd_pr__nfet_01v8 W=50.0u L=1.0u
Xpm nmac col_p gnd gnd sky130_fd_pr__nfet_01v8 W=50.0u L=1.0u
Xnd col_n col_n gnd gnd sky130_fd_pr__nfet_01v8 W=50.0u L=1.0u
Xnm mid_n col_n gnd gnd sky130_fd_pr__nfet_01v8 W=50.0u L=1.0u
Xpcd mid_n mid_n vdd vdd sky130_fd_pr__pfet_01v8 W=50.0u L=1.0u
Xpcm nmac mid_n vdd vdd sky130_fd_pr__pfet_01v8 W=50.0u L=1.0u
.ends col_readout

Vgate gate 0 1.8
VDD vdd 0 1.8

* --- Row inputs ---
Vrow0 row0 0 0.0
Vrow1 row1 0 0.0
Vrow2 row2 0 0.0
Vrow3 row3 0 0.0
Vrow4 row4 0 0.0
Vrow5 row5 0 0.0
Vrow6 row6 0 0.0
Vrow7 row7 0 0.0

* --- Column readout (NFET diode + col_readout subcircuit) ---
Xcolrd0 cp0 cn0 nmac0 vdd 0 col_readout
Xcolrd1 cp1 cn1 nmac1 vdd 0 col_readout
Xcolrd2 cp2 cn2 nmac2 vdd 0 col_readout
Xcolrd3 cp3 cn3 nmac3 vdd 0 col_readout
Xcolrd4 cp4 cn4 nmac4 vdd 0 col_readout
Xcolrd5 cp5 cn5 nmac5 vdd 0 col_readout
Xcolrd6 cp6 cn6 nmac6 vdd 0 col_readout
Xcolrd7 cp7 cn7 nmac7 vdd 0 col_readout
Xcolrd8 cp8 cn8 nmac8 vdd 0 col_readout
Xcolrd9 cp9 cn9 nmac9 vdd 0 col_readout
Xcolrd10 cp10 cn10 nmac10 vdd 0 col_readout
Xcolrd11 cp11 cn11 nmac11 vdd 0 col_readout
Xcolrd12 cp12 cn12 nmac12 vdd 0 col_readout
Xcolrd13 cp13 cn13 nmac13 vdd 0 col_readout
Xcolrd14 cp14 cn14 nmac14 vdd 0 col_readout
Xcolrd15 cp15 cn15 nmac15 vdd 0 col_readout
Xcolrd16 cp16 cn16 nmac16 vdd 0 col_readout
Xcolrd17 cp17 cn17 nmac17 vdd 0 col_readout
Xcolrd18 cp18 cn18 nmac18 vdd 0 col_readout
Xcolrd19 cp19 cn19 nmac19 vdd 0 col_readout
Xcolrd20 cp20 cn20 nmac20 vdd 0 col_readout
Xcolrd21 cp21 cn21 nmac21 vdd 0 col_readout
Xcolrd22 cp22 cn22 nmac22 vdd 0 col_readout
Xcolrd23 cp23 cn23 nmac23 vdd 0 col_readout
Xcolrd24 cp24 cn24 nmac24 vdd 0 col_readout
Xcolrd25 cp25 cn25 nmac25 vdd 0 col_readout
Xcolrd26 cp26 cn26 nmac26 vdd 0 col_readout
Xcolrd27 cp27 cn27 nmac27 vdd 0 col_readout
Xcolrd28 cp28 cn28 nmac28 vdd 0 col_readout
Xcolrd29 cp29 cn29 nmac29 vdd 0 col_readout
Xcolrd30 cp30 cn30 nmac30 vdd 0 col_readout
Xcolrd31 cp31 cn31 nmac31 vdd 0 col_readout
Xcolrd32 cp32 cn32 nmac32 vdd 0 col_readout
Xcolrd33 cp33 cn33 nmac33 vdd 0 col_readout
Xcolrd34 cp34 cn34 nmac34 vdd 0 col_readout
Xcolrd35 cp35 cn35 nmac35 vdd 0 col_readout
Xcolrd36 cp36 cn36 nmac36 vdd 0 col_readout
Xcolrd37 cp37 cn37 nmac37 vdd 0 col_readout
Xcolrd38 cp38 cn38 nmac38 vdd 0 col_readout
Xcolrd39 cp39 cn39 nmac39 vdd 0 col_readout
Xcolrd40 cp40 cn40 nmac40 vdd 0 col_readout
Xcolrd41 cp41 cn41 nmac41 vdd 0 col_readout
Xcolrd42 cp42 cn42 nmac42 vdd 0 col_readout
Xcolrd43 cp43 cn43 nmac43 vdd 0 col_readout
Xcolrd44 cp44 cn44 nmac44 vdd 0 col_readout
Xcolrd45 cp45 cn45 nmac45 vdd 0 col_readout
Xcolrd46 cp46 cn46 nmac46 vdd 0 col_readout
Xcolrd47 cp47 cn47 nmac47 vdd 0 col_readout
Xcolrd48 cp48 cn48 nmac48 vdd 0 col_readout
Xcolrd49 cp49 cn49 nmac49 vdd 0 col_readout
Xcolrd50 cp50 cn50 nmac50 vdd 0 col_readout
Xcolrd51 cp51 cn51 nmac51 vdd 0 col_readout
Xcolrd52 cp52 cn52 nmac52 vdd 0 col_readout
Xcolrd53 cp53 cn53 nmac53 vdd 0 col_readout
Xcolrd54 cp54 cn54 nmac54 vdd 0 col_readout
Xcolrd55 cp55 cn55 nmac55 vdd 0 col_readout
Xcolrd56 cp56 cn56 nmac56 vdd 0 col_readout
Xcolrd57 cp57 cn57 nmac57 vdd 0 col_readout
Xcolrd58 cp58 cn58 nmac58 vdd 0 col_readout
Xcolrd59 cp59 cn59 nmac59 vdd 0 col_readout
Xcolrd60 cp60 cn60 nmac60 vdd 0 col_readout
Xcolrd61 cp61 cn61 nmac61 vdd 0 col_readout
Xcolrd62 cp62 cn62 nmac62 vdd 0 col_readout
Xcolrd63 cp63 cn63 nmac63 vdd 0 col_readout

* ===== POSITIVE CONDUCTANCE ARRAY (8x64) =====
* --- Row 0 ---
Xrp0_0 row0 gate cp0 0 reram_1t1r Tf0=3.300000e-09  $ G+=0.296uS w=-0.6454
Xrp0_1 row0 gate cp1 0 reram_1t1r Tf0=4.803596e-09  $ G+=71.353uS w=1.5675
Xrp0_2 row0 gate cp2 0 reram_1t1r Tf0=4.484956e-09  $ G+=22.407uS w=0.4877
Xrp0_3 row0 gate cp3 0 reram_1t1r Tf0=4.613434e-09  $ G+=35.744uS w=0.7820
Xrp0_4 row0 gate cp4 0 reram_1t1r Tf0=3.300000e-09  $ G+=0.296uS w=-0.1707
Xrp0_5 row0 gate cp5 0 reram_1t1r Tf0=3.300000e-09  $ G+=0.296uS w=-0.2264
Xrp0_6 row0 gate cp6 0 reram_1t1r Tf0=3.300000e-09  $ G+=0.296uS w=-0.1944
Xrp0_7 row0 gate cp7 0 reram_1t1r Tf0=4.894443e-09  $ G+=99.273uS w=2.1833
Xrp0_8 row0 gate cp8 0 reram_1t1r Tf0=4.481435e-09  $ G+=22.122uS w=0.4815
Xrp0_9 row0 gate cp9 0 reram_1t1r Tf0=3.300000e-09  $ G+=0.296uS w=-0.4574
Xrp0_10 row0 gate cp10 0 reram_1t1r Tf0=3.300000e-09  $ G+=0.296uS w=-0.6893
Xrp0_11 row0 gate cp11 0 reram_1t1r Tf0=4.621973e-09  $ G+=36.871uS w=0.8068
Xrp0_12 row0 gate cp12 0 reram_1t1r Tf0=4.829367e-09  $ G+=78.361uS w=1.7220
Xrp0_13 row0 gate cp13 0 reram_1t1r Tf0=4.564477e-09  $ G+=29.917uS w=0.6534
Xrp0_14 row0 gate cp14 0 reram_1t1r Tf0=3.300000e-09  $ G+=0.296uS w=-0.7435
Xrp0_15 row0 gate cp15 0 reram_1t1r Tf0=3.300000e-09  $ G+=0.296uS w=-0.4759
Xrp0_16 row0 gate cp16 0 reram_1t1r Tf0=3.300000e-09  $ G+=0.296uS w=-0.3056
Xrp0_17 row0 gate cp17 0 reram_1t1r Tf0=4.307516e-09  $ G+=11.756uS w=0.2528
Xrp0_18 row0 gate cp18 0 reram_1t1r Tf0=4.669676e-09  $ G+=43.853uS w=0.9608
Xrp0_19 row0 gate cp19 0 reram_1t1r Tf0=4.089955e-09  $ G+=5.331uS w=0.1111
Xrp0_20 row0 gate cp20 0 reram_1t1r Tf0=4.347709e-09  $ G+=13.606uS w=0.2936
Xrp0_21 row0 gate cp21 0 reram_1t1r Tf0=3.300000e-09  $ G+=0.296uS w=-0.3701
Xrp0_22 row0 gate cp22 0 reram_1t1r Tf0=3.300000e-09  $ G+=0.296uS w=-0.3774
Xrp0_23 row0 gate cp23 0 reram_1t1r Tf0=4.515089e-09  $ G+=25.001uS w=0.5450
Xrp0_24 row0 gate cp24 0 reram_1t1r Tf0=3.300000e-09  $ G+=0.296uS w=-0.2639
Xrp0_25 row0 gate cp25 0 reram_1t1r Tf0=4.053176e-09  $ G+=4.664uS w=0.0963
Xrp0_26 row0 gate cp26 0 reram_1t1r Tf0=3.300000e-09  $ G+=0.296uS w=-0.1215
Xrp0_27 row0 gate cp27 0 reram_1t1r Tf0=4.644574e-09  $ G+=40.029uS w=0.8765
Xrp0_28 row0 gate cp28 0 reram_1t1r Tf0=3.300000e-09  $ G+=0.296uS w=-0.0560
Xrp0_29 row0 gate cp29 0 reram_1t1r Tf0=3.300000e-09  $ G+=0.296uS w=-0.8271
Xrp0_30 row0 gate cp30 0 reram_1t1r Tf0=3.300000e-09  $ G+=0.296uS w=-0.3890
Xrp0_31 row0 gate cp31 0 reram_1t1r Tf0=4.130987e-09  $ G+=6.188uS w=0.1300
Xrp0_32 row0 gate cp32 0 reram_1t1r Tf0=3.300000e-09  $ G+=0.296uS w=-1.0774
Xrp0_33 row0 gate cp33 0 reram_1t1r Tf0=4.555036e-09  $ G+=28.908uS w=0.6312
Xrp0_34 row0 gate cp34 0 reram_1t1r Tf0=4.587940e-09  $ G+=32.581uS w=0.7122
Xrp0_35 row0 gate cp35 0 reram_1t1r Tf0=4.552567e-09  $ G+=28.650uS w=0.6255
Xrp0_36 row0 gate cp36 0 reram_1t1r Tf0=3.319512e-09  $ G+=0.324uS w=0.0006
Xrp0_37 row0 gate cp37 0 reram_1t1r Tf0=3.300000e-09  $ G+=0.296uS w=-0.5892
Xrp0_38 row0 gate cp38 0 reram_1t1r Tf0=3.300000e-09  $ G+=0.296uS w=-0.3300
Xrp0_39 row0 gate cp39 0 reram_1t1r Tf0=4.614648e-09  $ G+=35.903uS w=0.7854
Xrp0_40 row0 gate cp40 0 reram_1t1r Tf0=3.300000e-09  $ G+=0.296uS w=-0.6451
Xrp0_41 row0 gate cp41 0 reram_1t1r Tf0=4.792540e-09  $ G+=68.542uS w=1.5055
Xrp0_42 row0 gate cp42 0 reram_1t1r Tf0=3.300000e-09  $ G+=0.296uS w=-0.3221
Xrp0_43 row0 gate cp43 0 reram_1t1r Tf0=4.778869e-09  $ G+=65.219uS w=1.4322
Xrp0_44 row0 gate cp44 0 reram_1t1r Tf0=3.300000e-09  $ G+=0.296uS w=-0.3717
Xrp0_45 row0 gate cp45 0 reram_1t1r Tf0=3.300000e-09  $ G+=0.296uS w=-0.0008
Xrp0_46 row0 gate cp46 0 reram_1t1r Tf0=3.300000e-09  $ G+=0.296uS w=-0.2209
Xrp0_47 row0 gate cp47 0 reram_1t1r Tf0=4.540237e-09  $ G+=27.394uS w=0.5978
Xrp0_48 row0 gate cp48 0 reram_1t1r Tf0=3.949319e-09  $ G+=3.197uS w=0.0640
Xrp0_49 row0 gate cp49 0 reram_1t1r Tf0=4.401370e-09  $ G+=16.536uS w=0.3582
Xrp0_50 row0 gate cp50 0 reram_1t1r Tf0=4.642248e-09  $ G+=39.691uS w=0.8690
Xrp0_51 row0 gate cp51 0 reram_1t1r Tf0=4.597641e-09  $ G+=33.750uS w=0.7380
Xrp0_52 row0 gate cp52 0 reram_1t1r Tf0=4.697796e-09  $ G+=48.572uS w=1.0649
Xrp0_53 row0 gate cp53 0 reram_1t1r Tf0=4.722515e-09  $ G+=53.139uS w=1.1657
Xrp0_54 row0 gate cp54 0 reram_1t1r Tf0=4.241426e-09  $ G+=9.245uS w=0.1974
Xrp0_55 row0 gate cp55 0 reram_1t1r Tf0=4.470013e-09  $ G+=21.222uS w=0.4616
Xrp0_56 row0 gate cp56 0 reram_1t1r Tf0=3.938558e-09  $ G+=3.075uS w=0.0613
Xrp0_57 row0 gate cp57 0 reram_1t1r Tf0=3.300000e-09  $ G+=0.296uS w=-0.3077
Xrp0_58 row0 gate cp58 0 reram_1t1r Tf0=3.300000e-09  $ G+=0.296uS w=-0.3443
Xrp0_59 row0 gate cp59 0 reram_1t1r Tf0=3.300000e-09  $ G+=0.296uS w=-1.4770
Xrp0_60 row0 gate cp60 0 reram_1t1r Tf0=3.300000e-09  $ G+=0.296uS w=-0.2795
Xrp0_61 row0 gate cp61 0 reram_1t1r Tf0=4.634832e-09  $ G+=38.636uS w=0.8457
Xrp0_62 row0 gate cp62 0 reram_1t1r Tf0=4.744029e-09  $ G+=57.461uS w=1.2610
Xrp0_63 row0 gate cp63 0 reram_1t1r Tf0=3.300000e-09  $ G+=0.296uS w=-0.0311
* --- Row 1 ---
Xrp1_0 row1 gate cp0 0 reram_1t1r Tf0=3.300000e-09  $ G+=0.296uS w=-0.0197
Xrp1_1 row1 gate cp1 0 reram_1t1r Tf0=4.047423e-09  $ G+=4.567uS w=0.0942
Xrp1_2 row1 gate cp2 0 reram_1t1r Tf0=3.300000e-09  $ G+=0.296uS w=-0.8995
Xrp1_3 row1 gate cp3 0 reram_1t1r Tf0=4.133824e-09  $ G+=6.253uS w=0.1314
Xrp1_4 row1 gate cp4 0 reram_1t1r Tf0=3.300000e-09  $ G+=0.296uS w=-0.1273
Xrp1_5 row1 gate cp5 0 reram_1t1r Tf0=4.562471e-09  $ G+=29.700uS w=0.6486
Xrp1_6 row1 gate cp6 0 reram_1t1r Tf0=3.959662e-09  $ G+=3.320uS w=0.0667
Xrp1_7 row1 gate cp7 0 reram_1t1r Tf0=3.300000e-09  $ G+=0.296uS w=-0.1023
Xrp1_8 row1 gate cp8 0 reram_1t1r Tf0=3.300000e-09  $ G+=0.296uS w=-0.6800
Xrp1_9 row1 gate cp9 0 reram_1t1r Tf0=4.329131e-09  $ G+=12.717uS w=0.2740
Xrp1_10 row1 gate cp10 0 reram_1t1r Tf0=4.365381e-09  $ G+=14.508uS w=0.3135
Xrp1_11 row1 gate cp11 0 reram_1t1r Tf0=4.492650e-09  $ G+=23.043uS w=0.5018
Xrp1_12 row1 gate cp12 0 reram_1t1r Tf0=4.102983e-09  $ G+=5.589uS w=0.1168
Xrp1_13 row1 gate cp13 0 reram_1t1r Tf0=3.300000e-09  $ G+=0.296uS w=-0.4652
Xrp1_14 row1 gate cp14 0 reram_1t1r Tf0=4.024094e-09  $ G+=4.196uS w=0.0860
Xrp1_15 row1 gate cp15 0 reram_1t1r Tf0=3.300000e-09  $ G+=0.296uS w=-0.0033
Xrp1_16 row1 gate cp16 0 reram_1t1r Tf0=4.580043e-09  $ G+=31.659uS w=0.6918
Xrp1_17 row1 gate cp17 0 reram_1t1r Tf0=4.112454e-09  $ G+=5.785uS w=0.1211
Xrp1_18 row1 gate cp18 0 reram_1t1r Tf0=3.300000e-09  $ G+=0.296uS w=-0.3546
Xrp1_19 row1 gate cp19 0 reram_1t1r Tf0=3.300000e-09  $ G+=0.296uS w=-0.2170
Xrp1_20 row1 gate cp20 0 reram_1t1r Tf0=3.300000e-09  $ G+=0.296uS w=-0.3639
Xrp1_21 row1 gate cp21 0 reram_1t1r Tf0=3.662736e-09  $ G+=1.128uS w=0.0184
Xrp1_22 row1 gate cp22 0 reram_1t1r Tf0=4.230758e-09  $ G+=8.894uS w=0.1897
Xrp1_23 row1 gate cp23 0 reram_1t1r Tf0=4.298940e-09  $ G+=11.395uS w=0.2448
Xrp1_24 row1 gate cp24 0 reram_1t1r Tf0=3.749762e-09  $ G+=1.548uS w=0.0276
Xrp1_25 row1 gate cp25 0 reram_1t1r Tf0=3.300000e-09  $ G+=0.296uS w=-0.2746
Xrp1_26 row1 gate cp26 0 reram_1t1r Tf0=3.300000e-09  $ G+=0.296uS w=-0.1034
Xrp1_27 row1 gate cp27 0 reram_1t1r Tf0=3.639701e-09  $ G+=1.038uS w=0.0164
Xrp1_28 row1 gate cp28 0 reram_1t1r Tf0=3.300000e-09  $ G+=0.296uS w=-0.2058
Xrp1_29 row1 gate cp29 0 reram_1t1r Tf0=3.300000e-09  $ G+=0.296uS w=-0.0334
Xrp1_30 row1 gate cp30 0 reram_1t1r Tf0=4.494607e-09  $ G+=23.207uS w=0.5054
Xrp1_31 row1 gate cp31 0 reram_1t1r Tf0=3.300000e-09  $ G+=0.296uS w=-0.0487
Xrp1_32 row1 gate cp32 0 reram_1t1r Tf0=3.300000e-09  $ G+=0.296uS w=-0.2145
Xrp1_33 row1 gate cp33 0 reram_1t1r Tf0=3.649245e-09  $ G+=1.074uS w=0.0172
Xrp1_34 row1 gate cp34 0 reram_1t1r Tf0=3.300000e-09  $ G+=0.296uS w=-0.5159
Xrp1_35 row1 gate cp35 0 reram_1t1r Tf0=3.300000e-09  $ G+=0.296uS w=-0.1771
Xrp1_36 row1 gate cp36 0 reram_1t1r Tf0=3.300000e-09  $ G+=0.296uS w=-0.5895
Xrp1_37 row1 gate cp37 0 reram_1t1r Tf0=4.541166e-09  $ G+=27.487uS w=0.5998
Xrp1_38 row1 gate cp38 0 reram_1t1r Tf0=3.300000e-09  $ G+=0.296uS w=-0.4457
Xrp1_39 row1 gate cp39 0 reram_1t1r Tf0=3.300000e-09  $ G+=0.296uS w=-0.3616
Xrp1_40 row1 gate cp40 0 reram_1t1r Tf0=4.579355e-09  $ G+=31.580uS w=0.6901
Xrp1_41 row1 gate cp41 0 reram_1t1r Tf0=3.300000e-09  $ G+=0.296uS w=-0.1145
Xrp1_42 row1 gate cp42 0 reram_1t1r Tf0=3.300000e-09  $ G+=0.296uS w=-0.6453
Xrp1_43 row1 gate cp43 0 reram_1t1r Tf0=4.315221e-09  $ G+=12.090uS w=0.2602
Xrp1_44 row1 gate cp44 0 reram_1t1r Tf0=3.300000e-09  $ G+=0.296uS w=-0.3444
Xrp1_45 row1 gate cp45 0 reram_1t1r Tf0=3.300000e-09  $ G+=0.296uS w=-0.6342
Xrp1_46 row1 gate cp46 0 reram_1t1r Tf0=3.300000e-09  $ G+=0.296uS w=-0.3621
Xrp1_47 row1 gate cp47 0 reram_1t1r Tf0=3.300000e-09  $ G+=0.296uS w=-0.0530
Xrp1_48 row1 gate cp48 0 reram_1t1r Tf0=4.313248e-09  $ G+=12.004uS w=0.2583
Xrp1_49 row1 gate cp49 0 reram_1t1r Tf0=4.381036e-09  $ G+=15.358uS w=0.3322
Xrp1_50 row1 gate cp50 0 reram_1t1r Tf0=3.300000e-09  $ G+=0.296uS w=-0.0332
Xrp1_51 row1 gate cp51 0 reram_1t1r Tf0=4.222401e-09  $ G+=8.628uS w=0.1838
Xrp1_52 row1 gate cp52 0 reram_1t1r Tf0=4.240502e-09  $ G+=9.214uS w=0.1967
Xrp1_53 row1 gate cp53 0 reram_1t1r Tf0=3.300000e-09  $ G+=0.296uS w=-0.0145
Xrp1_54 row1 gate cp54 0 reram_1t1r Tf0=4.561388e-09  $ G+=29.583uS w=0.6460
Xrp1_55 row1 gate cp55 0 reram_1t1r Tf0=4.217769e-09  $ G+=8.484uS w=0.1806
Xrp1_56 row1 gate cp56 0 reram_1t1r Tf0=4.150916e-09  $ G+=6.653uS w=0.1402
Xrp1_57 row1 gate cp57 0 reram_1t1r Tf0=4.631721e-09  $ G+=38.201uS w=0.8362
Xrp1_58 row1 gate cp58 0 reram_1t1r Tf0=3.300000e-09  $ G+=0.296uS w=-0.2959
Xrp1_59 row1 gate cp59 0 reram_1t1r Tf0=3.300000e-09  $ G+=0.296uS w=-0.0904
Xrp1_60 row1 gate cp60 0 reram_1t1r Tf0=4.175890e-09  $ G+=7.286uS w=0.1542
Xrp1_61 row1 gate cp61 0 reram_1t1r Tf0=4.093241e-09  $ G+=5.395uS w=0.1125
Xrp1_62 row1 gate cp62 0 reram_1t1r Tf0=4.296161e-09  $ G+=11.281uS w=0.2423
Xrp1_63 row1 gate cp63 0 reram_1t1r Tf0=4.354735e-09  $ G+=13.957uS w=0.3014
* --- Row 2 ---
Xrp2_0 row2 gate cp0 0 reram_1t1r Tf0=3.300000e-09  $ G+=0.296uS w=-1.0699
Xrp2_1 row2 gate cp1 0 reram_1t1r Tf0=3.300000e-09  $ G+=0.296uS w=-0.2071
Xrp2_2 row2 gate cp2 0 reram_1t1r Tf0=3.300000e-09  $ G+=0.296uS w=-0.4072
Xrp2_3 row2 gate cp3 0 reram_1t1r Tf0=3.300000e-09  $ G+=0.296uS w=-0.1990
Xrp2_4 row2 gate cp4 0 reram_1t1r Tf0=3.911546e-09  $ G+=2.787uS w=0.0550
Xrp2_5 row2 gate cp5 0 reram_1t1r Tf0=3.300000e-09  $ G+=0.296uS w=-0.4808
Xrp2_6 row2 gate cp6 0 reram_1t1r Tf0=3.300000e-09  $ G+=0.296uS w=-0.2750
Xrp2_7 row2 gate cp7 0 reram_1t1r Tf0=3.300000e-09  $ G+=0.296uS w=-0.4527
Xrp2_8 row2 gate cp8 0 reram_1t1r Tf0=3.300000e-09  $ G+=0.296uS w=-0.0831
Xrp2_9 row2 gate cp9 0 reram_1t1r Tf0=4.484737e-09  $ G+=22.389uS w=0.4874
Xrp2_10 row2 gate cp10 0 reram_1t1r Tf0=3.300000e-09  $ G+=0.296uS w=-0.0062
Xrp2_11 row2 gate cp11 0 reram_1t1r Tf0=4.031919e-09  $ G+=4.317uS w=0.0887
Xrp2_12 row2 gate cp12 0 reram_1t1r Tf0=4.237267e-09  $ G+=9.107uS w=0.1944
Xrp2_13 row2 gate cp13 0 reram_1t1r Tf0=3.300000e-09  $ G+=0.296uS w=-0.3448
Xrp2_14 row2 gate cp14 0 reram_1t1r Tf0=3.300000e-09  $ G+=0.296uS w=-0.1936
Xrp2_15 row2 gate cp15 0 reram_1t1r Tf0=3.300000e-09  $ G+=0.296uS w=-0.5159
Xrp2_16 row2 gate cp16 0 reram_1t1r Tf0=3.300000e-09  $ G+=0.296uS w=-0.4634
Xrp2_17 row2 gate cp17 0 reram_1t1r Tf0=3.300000e-09  $ G+=0.296uS w=-0.3455
Xrp2_18 row2 gate cp18 0 reram_1t1r Tf0=4.288713e-09  $ G+=10.979uS w=0.2357
Xrp2_19 row2 gate cp19 0 reram_1t1r Tf0=4.066986e-09  $ G+=4.904uS w=0.1016
Xrp2_20 row2 gate cp20 0 reram_1t1r Tf0=4.347882e-09  $ G+=13.614uS w=0.2938
Xrp2_21 row2 gate cp21 0 reram_1t1r Tf0=3.844422e-09  $ G+=2.184uS w=0.0416
Xrp2_22 row2 gate cp22 0 reram_1t1r Tf0=4.471974e-09  $ G+=21.374uS w=0.4650
Xrp2_23 row2 gate cp23 0 reram_1t1r Tf0=3.300000e-09  $ G+=0.296uS w=-0.2814
Xrp2_24 row2 gate cp24 0 reram_1t1r Tf0=3.300000e-09  $ G+=0.296uS w=-0.3425
Xrp2_25 row2 gate cp25 0 reram_1t1r Tf0=4.696494e-09  $ G+=48.343uS w=1.0599
Xrp2_26 row2 gate cp26 0 reram_1t1r Tf0=3.300000e-09  $ G+=0.296uS w=-0.0012
Xrp2_27 row2 gate cp27 0 reram_1t1r Tf0=4.642716e-09  $ G+=39.759uS w=0.8705
Xrp2_28 row2 gate cp28 0 reram_1t1r Tf0=4.291913e-09  $ G+=11.108uS w=0.2385
Xrp2_29 row2 gate cp29 0 reram_1t1r Tf0=3.415963e-09  $ G+=0.460uS w=0.0036
Xrp2_30 row2 gate cp30 0 reram_1t1r Tf0=3.300000e-09  $ G+=0.296uS w=-0.3181
Xrp2_31 row2 gate cp31 0 reram_1t1r Tf0=4.605834e-09  $ G+=34.770uS w=0.7605
Xrp2_32 row2 gate cp32 0 reram_1t1r Tf0=3.300000e-09  $ G+=0.296uS w=-0.9690
Xrp2_33 row2 gate cp33 0 reram_1t1r Tf0=4.390817e-09  $ G+=15.914uS w=0.3445
Xrp2_34 row2 gate cp34 0 reram_1t1r Tf0=3.300000e-09  $ G+=0.296uS w=-0.5105
Xrp2_35 row2 gate cp35 0 reram_1t1r Tf0=4.646007e-09  $ G+=40.237uS w=0.8811
Xrp2_36 row2 gate cp36 0 reram_1t1r Tf0=4.398655e-09  $ G+=16.374uS w=0.3547
Xrp2_37 row2 gate cp37 0 reram_1t1r Tf0=4.356422e-09  $ G+=14.043uS w=0.3033
Xrp2_38 row2 gate cp38 0 reram_1t1r Tf0=3.300000e-09  $ G+=0.296uS w=-0.0193
Xrp2_39 row2 gate cp39 0 reram_1t1r Tf0=3.300000e-09  $ G+=0.296uS w=-0.5305
Xrp2_40 row2 gate cp40 0 reram_1t1r Tf0=3.300000e-09  $ G+=0.296uS w=-0.3001
Xrp2_41 row2 gate cp41 0 reram_1t1r Tf0=4.692111e-09  $ G+=47.579uS w=1.0430
Xrp2_42 row2 gate cp42 0 reram_1t1r Tf0=4.434703e-09  $ G+=18.666uS w=0.4052
Xrp2_43 row2 gate cp43 0 reram_1t1r Tf0=3.300000e-09  $ G+=0.296uS w=-0.3557
Xrp2_44 row2 gate cp44 0 reram_1t1r Tf0=4.569784e-09  $ G+=30.500uS w=0.6663
Xrp2_45 row2 gate cp45 0 reram_1t1r Tf0=3.300000e-09  $ G+=0.296uS w=-0.3610
Xrp2_46 row2 gate cp46 0 reram_1t1r Tf0=4.516483e-09  $ G+=25.128uS w=0.5478
Xrp2_47 row2 gate cp47 0 reram_1t1r Tf0=3.300000e-09  $ G+=0.296uS w=-0.3286
Xrp2_48 row2 gate cp48 0 reram_1t1r Tf0=3.300000e-09  $ G+=0.296uS w=-0.0859
Xrp2_49 row2 gate cp49 0 reram_1t1r Tf0=3.300000e-09  $ G+=0.296uS w=-0.2324
Xrp2_50 row2 gate cp50 0 reram_1t1r Tf0=3.300000e-09  $ G+=0.296uS w=-0.0492
Xrp2_51 row2 gate cp51 0 reram_1t1r Tf0=3.300000e-09  $ G+=0.296uS w=-0.0937
Xrp2_52 row2 gate cp52 0 reram_1t1r Tf0=3.300000e-09  $ G+=0.296uS w=-0.6751
Xrp2_53 row2 gate cp53 0 reram_1t1r Tf0=3.300000e-09  $ G+=0.296uS w=-0.3619
Xrp2_54 row2 gate cp54 0 reram_1t1r Tf0=3.300000e-09  $ G+=0.296uS w=-0.0880
Xrp2_55 row2 gate cp55 0 reram_1t1r Tf0=4.075687e-09  $ G+=5.062uS w=0.1051
Xrp2_56 row2 gate cp56 0 reram_1t1r Tf0=3.385469e-09  $ G+=0.412uS w=0.0026
Xrp2_57 row2 gate cp57 0 reram_1t1r Tf0=4.319064e-09  $ G+=12.260uS w=0.2639
Xrp2_58 row2 gate cp58 0 reram_1t1r Tf0=4.101748e-09  $ G+=5.564uS w=0.1162
Xrp2_59 row2 gate cp59 0 reram_1t1r Tf0=3.997574e-09  $ G+=3.810uS w=0.0775
Xrp2_60 row2 gate cp60 0 reram_1t1r Tf0=4.268172e-09  $ G+=10.189uS w=0.2182
Xrp2_61 row2 gate cp61 0 reram_1t1r Tf0=3.300000e-09  $ G+=0.296uS w=-0.0243
Xrp2_62 row2 gate cp62 0 reram_1t1r Tf0=3.300000e-09  $ G+=0.296uS w=-0.4746
Xrp2_63 row2 gate cp63 0 reram_1t1r Tf0=3.300000e-09  $ G+=0.296uS w=-0.0570
* --- Row 3 ---
Xrp3_0 row3 gate cp0 0 reram_1t1r Tf0=3.300000e-09  $ G+=0.296uS w=-0.0492
Xrp3_1 row3 gate cp1 0 reram_1t1r Tf0=3.549371e-09  $ G+=0.747uS w=0.0100
Xrp3_2 row3 gate cp2 0 reram_1t1r Tf0=3.300000e-09  $ G+=0.296uS w=-0.0026
Xrp3_3 row3 gate cp3 0 reram_1t1r Tf0=3.300000e-09  $ G+=0.296uS w=-0.1679
Xrp3_4 row3 gate cp4 0 reram_1t1r Tf0=4.331419e-09  $ G+=12.823uS w=0.2763
Xrp3_5 row3 gate cp5 0 reram_1t1r Tf0=3.893259e-09  $ G+=2.608uS w=0.0510
Xrp3_6 row3 gate cp6 0 reram_1t1r Tf0=3.618352e-09  $ G+=0.960uS w=0.0146
Xrp3_7 row3 gate cp7 0 reram_1t1r Tf0=3.968089e-09  $ G+=3.423uS w=0.0690
Xrp3_8 row3 gate cp8 0 reram_1t1r Tf0=3.300000e-09  $ G+=0.296uS w=-0.0546
Xrp3_9 row3 gate cp9 0 reram_1t1r Tf0=3.300000e-09  $ G+=0.296uS w=-0.1996
Xrp3_10 row3 gate cp10 0 reram_1t1r Tf0=3.300000e-09  $ G+=0.296uS w=-0.0449
Xrp3_11 row3 gate cp11 0 reram_1t1r Tf0=4.332480e-09  $ G+=12.873uS w=0.2774
Xrp3_12 row3 gate cp12 0 reram_1t1r Tf0=3.881909e-09  $ G+=2.502uS w=0.0487
Xrp3_13 row3 gate cp13 0 reram_1t1r Tf0=3.300000e-09  $ G+=0.296uS w=-0.3082
Xrp3_14 row3 gate cp14 0 reram_1t1r Tf0=3.300000e-09  $ G+=0.296uS w=-0.7752
Xrp3_15 row3 gate cp15 0 reram_1t1r Tf0=3.300000e-09  $ G+=0.296uS w=-0.0840
Xrp3_16 row3 gate cp16 0 reram_1t1r Tf0=3.300000e-09  $ G+=0.296uS w=-0.2887
Xrp3_17 row3 gate cp17 0 reram_1t1r Tf0=3.300000e-09  $ G+=0.296uS w=-0.6153
Xrp3_18 row3 gate cp18 0 reram_1t1r Tf0=3.710128e-09  $ G+=1.340uS w=0.0230
Xrp3_19 row3 gate cp19 0 reram_1t1r Tf0=3.779104e-09  $ G+=1.722uS w=0.0315
Xrp3_20 row3 gate cp20 0 reram_1t1r Tf0=3.300000e-09  $ G+=0.296uS w=-0.0606
Xrp3_21 row3 gate cp21 0 reram_1t1r Tf0=3.644376e-09  $ G+=1.055uS w=0.0167
Xrp3_22 row3 gate cp22 0 reram_1t1r Tf0=4.465250e-09  $ G+=20.858uS w=0.4536
Xrp3_23 row3 gate cp23 0 reram_1t1r Tf0=3.300000e-09  $ G+=0.296uS w=-0.2523
Xrp3_24 row3 gate cp24 0 reram_1t1r Tf0=3.300000e-09  $ G+=0.296uS w=-0.2348
Xrp3_25 row3 gate cp25 0 reram_1t1r Tf0=3.300000e-09  $ G+=0.296uS w=-0.3711
Xrp3_26 row3 gate cp26 0 reram_1t1r Tf0=4.619411e-09  $ G+=36.530uS w=0.7993
Xrp3_27 row3 gate cp27 0 reram_1t1r Tf0=3.300000e-09  $ G+=0.296uS w=-0.0604
Xrp3_28 row3 gate cp28 0 reram_1t1r Tf0=3.620273e-09  $ G+=0.967uS w=0.0148
Xrp3_29 row3 gate cp29 0 reram_1t1r Tf0=3.300000e-09  $ G+=0.296uS w=-0.2323
Xrp3_30 row3 gate cp30 0 reram_1t1r Tf0=3.300000e-09  $ G+=0.296uS w=-0.0176
Xrp3_31 row3 gate cp31 0 reram_1t1r Tf0=3.300000e-09  $ G+=0.296uS w=-0.3262
Xrp3_32 row3 gate cp32 0 reram_1t1r Tf0=3.300000e-09  $ G+=0.296uS w=-0.4298
Xrp3_33 row3 gate cp33 0 reram_1t1r Tf0=3.825622e-09  $ G+=2.039uS w=0.0385
Xrp3_34 row3 gate cp34 0 reram_1t1r Tf0=4.050458e-09  $ G+=4.618uS w=0.0953
Xrp3_35 row3 gate cp35 0 reram_1t1r Tf0=3.300000e-09  $ G+=0.296uS w=-0.2803
Xrp3_36 row3 gate cp36 0 reram_1t1r Tf0=4.180081e-09  $ G+=7.397uS w=0.1567
Xrp3_37 row3 gate cp37 0 reram_1t1r Tf0=3.965512e-09  $ G+=3.391uS w=0.0683
Xrp3_38 row3 gate cp38 0 reram_1t1r Tf0=4.283769e-09  $ G+=10.784uS w=0.2314
Xrp3_39 row3 gate cp39 0 reram_1t1r Tf0=3.915840e-09  $ G+=2.831uS w=0.0559
Xrp3_40 row3 gate cp40 0 reram_1t1r Tf0=3.300000e-09  $ G+=0.296uS w=-0.2793
Xrp3_41 row3 gate cp41 0 reram_1t1r Tf0=3.300000e-09  $ G+=0.296uS w=-0.0512
Xrp3_42 row3 gate cp42 0 reram_1t1r Tf0=3.300000e-09  $ G+=0.296uS w=-0.1137
Xrp3_43 row3 gate cp43 0 reram_1t1r Tf0=3.300000e-09  $ G+=0.296uS w=-0.0351
Xrp3_44 row3 gate cp44 0 reram_1t1r Tf0=3.300000e-09  $ G+=0.296uS w=-0.1571
Xrp3_45 row3 gate cp45 0 reram_1t1r Tf0=3.300000e-09  $ G+=0.296uS w=-0.3058
Xrp3_46 row3 gate cp46 0 reram_1t1r Tf0=3.447297e-09  $ G+=0.516uS w=0.0048
Xrp3_47 row3 gate cp47 0 reram_1t1r Tf0=3.300000e-09  $ G+=0.296uS w=-0.4888
Xrp3_48 row3 gate cp48 0 reram_1t1r Tf0=4.273285e-09  $ G+=10.381uS w=0.2225
Xrp3_49 row3 gate cp49 0 reram_1t1r Tf0=4.331943e-09  $ G+=12.848uS w=0.2769
Xrp3_50 row3 gate cp50 0 reram_1t1r Tf0=4.430579e-09  $ G+=18.388uS w=0.3991
Xrp3_51 row3 gate cp51 0 reram_1t1r Tf0=3.353331e-09  $ G+=0.366uS w=0.0016
Xrp3_52 row3 gate cp52 0 reram_1t1r Tf0=3.300000e-09  $ G+=0.296uS w=-0.0404
Xrp3_53 row3 gate cp53 0 reram_1t1r Tf0=4.473357e-09  $ G+=21.482uS w=0.4673
Xrp3_54 row3 gate cp54 0 reram_1t1r Tf0=3.762272e-09  $ G+=1.620uS w=0.0292
Xrp3_55 row3 gate cp55 0 reram_1t1r Tf0=4.279338e-09  $ G+=10.612uS w=0.2276
Xrp3_56 row3 gate cp56 0 reram_1t1r Tf0=4.527370e-09  $ G+=26.142uS w=0.5701
Xrp3_57 row3 gate cp57 0 reram_1t1r Tf0=4.319491e-09  $ G+=12.279uS w=0.2643
Xrp3_58 row3 gate cp58 0 reram_1t1r Tf0=3.300000e-09  $ G+=0.296uS w=-0.0663
Xrp3_59 row3 gate cp59 0 reram_1t1r Tf0=3.300000e-09  $ G+=0.296uS w=-0.0695
Xrp3_60 row3 gate cp60 0 reram_1t1r Tf0=4.451642e-09  $ G+=19.851uS w=0.4314
Xrp3_61 row3 gate cp61 0 reram_1t1r Tf0=3.304296e-09  $ G+=0.307uS w=0.0002
Xrp3_62 row3 gate cp62 0 reram_1t1r Tf0=3.443884e-09  $ G+=0.509uS w=0.0047
Xrp3_63 row3 gate cp63 0 reram_1t1r Tf0=3.441971e-09  $ G+=0.506uS w=0.0046
* --- Row 4 ---
Xrp4_0 row4 gate cp0 0 reram_1t1r Tf0=3.300000e-09  $ G+=0.296uS w=-0.0684
Xrp4_1 row4 gate cp1 0 reram_1t1r Tf0=3.839800e-09  $ G+=2.147uS w=0.0408
Xrp4_2 row4 gate cp2 0 reram_1t1r Tf0=3.300000e-09  $ G+=0.296uS w=-0.2863
Xrp4_3 row4 gate cp3 0 reram_1t1r Tf0=3.300000e-09  $ G+=0.296uS w=-0.7471
Xrp4_4 row4 gate cp4 0 reram_1t1r Tf0=4.554425e-09  $ G+=28.844uS w=0.6297
Xrp4_5 row4 gate cp5 0 reram_1t1r Tf0=4.297920e-09  $ G+=11.353uS w=0.2439
Xrp4_6 row4 gate cp6 0 reram_1t1r Tf0=3.300000e-09  $ G+=0.296uS w=-0.3460
Xrp4_7 row4 gate cp7 0 reram_1t1r Tf0=3.300000e-09  $ G+=0.296uS w=-0.1465
Xrp4_8 row4 gate cp8 0 reram_1t1r Tf0=3.300000e-09  $ G+=0.296uS w=-0.0092
Xrp4_9 row4 gate cp9 0 reram_1t1r Tf0=4.430238e-09  $ G+=18.365uS w=0.3986
Xrp4_10 row4 gate cp10 0 reram_1t1r Tf0=3.300000e-09  $ G+=0.296uS w=-0.0555
Xrp4_11 row4 gate cp11 0 reram_1t1r Tf0=4.155244e-09  $ G+=6.759uS w=0.1426
Xrp4_12 row4 gate cp12 0 reram_1t1r Tf0=3.300000e-09  $ G+=0.296uS w=-0.0371
Xrp4_13 row4 gate cp13 0 reram_1t1r Tf0=3.300000e-09  $ G+=0.296uS w=-0.4560
Xrp4_14 row4 gate cp14 0 reram_1t1r Tf0=4.453802e-09  $ G+=20.008uS w=0.4348
Xrp4_15 row4 gate cp15 0 reram_1t1r Tf0=3.967547e-09  $ G+=3.416uS w=0.0688
Xrp4_16 row4 gate cp16 0 reram_1t1r Tf0=3.300000e-09  $ G+=0.296uS w=-0.6357
Xrp4_17 row4 gate cp17 0 reram_1t1r Tf0=4.212719e-09  $ G+=8.329uS w=0.1772
Xrp4_18 row4 gate cp18 0 reram_1t1r Tf0=3.300000e-09  $ G+=0.296uS w=-0.0128
Xrp4_19 row4 gate cp19 0 reram_1t1r Tf0=3.898178e-09  $ G+=2.655uS w=0.0520
Xrp4_20 row4 gate cp20 0 reram_1t1r Tf0=4.362043e-09  $ G+=14.333uS w=0.3096
Xrp4_21 row4 gate cp21 0 reram_1t1r Tf0=4.613684e-09  $ G+=35.777uS w=0.7827
Xrp4_22 row4 gate cp22 0 reram_1t1r Tf0=4.465984e-09  $ G+=20.914uS w=0.4548
Xrp4_23 row4 gate cp23 0 reram_1t1r Tf0=4.629153e-09  $ G+=37.846uS w=0.8283
Xrp4_24 row4 gate cp24 0 reram_1t1r Tf0=4.379352e-09  $ G+=15.264uS w=0.3302
Xrp4_25 row4 gate cp25 0 reram_1t1r Tf0=4.299232e-09  $ G+=11.407uS w=0.2451
Xrp4_26 row4 gate cp26 0 reram_1t1r Tf0=4.356652e-09  $ G+=14.055uS w=0.3035
Xrp4_27 row4 gate cp27 0 reram_1t1r Tf0=3.300000e-09  $ G+=0.296uS w=-0.1195
Xrp4_28 row4 gate cp28 0 reram_1t1r Tf0=3.885348e-09  $ G+=2.534uS w=0.0494
Xrp4_29 row4 gate cp29 0 reram_1t1r Tf0=3.300000e-09  $ G+=0.296uS w=-0.2004
Xrp4_30 row4 gate cp30 0 reram_1t1r Tf0=3.300000e-09  $ G+=0.296uS w=-0.2822
Xrp4_31 row4 gate cp31 0 reram_1t1r Tf0=3.300000e-09  $ G+=0.296uS w=-0.0233
Xrp4_32 row4 gate cp32 0 reram_1t1r Tf0=3.300000e-09  $ G+=0.296uS w=-0.3096
Xrp4_33 row4 gate cp33 0 reram_1t1r Tf0=4.144438e-09  $ G+=6.499uS w=0.1368
Xrp4_34 row4 gate cp34 0 reram_1t1r Tf0=3.300000e-09  $ G+=0.296uS w=-0.4478
Xrp4_35 row4 gate cp35 0 reram_1t1r Tf0=3.300000e-09  $ G+=0.296uS w=-0.8095
Xrp4_36 row4 gate cp36 0 reram_1t1r Tf0=4.476384e-09  $ G+=21.720uS w=0.4726
Xrp4_37 row4 gate cp37 0 reram_1t1r Tf0=3.989108e-09  $ G+=3.695uS w=0.0750
Xrp4_38 row4 gate cp38 0 reram_1t1r Tf0=3.300000e-09  $ G+=0.296uS w=-0.2700
Xrp4_39 row4 gate cp39 0 reram_1t1r Tf0=4.153226e-09  $ G+=6.709uS w=0.1415
Xrp4_40 row4 gate cp40 0 reram_1t1r Tf0=3.300000e-09  $ G+=0.296uS w=-0.1167
Xrp4_41 row4 gate cp41 0 reram_1t1r Tf0=3.300000e-09  $ G+=0.296uS w=-0.1352
Xrp4_42 row4 gate cp42 0 reram_1t1r Tf0=3.300000e-09  $ G+=0.296uS w=-0.1272
Xrp4_43 row4 gate cp43 0 reram_1t1r Tf0=3.300000e-09  $ G+=0.296uS w=-0.3615
Xrp4_44 row4 gate cp44 0 reram_1t1r Tf0=3.300000e-09  $ G+=0.296uS w=-0.7448
Xrp4_45 row4 gate cp45 0 reram_1t1r Tf0=3.459993e-09  $ G+=0.540uS w=0.0054
Xrp4_46 row4 gate cp46 0 reram_1t1r Tf0=4.478199e-09  $ G+=21.863uS w=0.4758
Xrp4_47 row4 gate cp47 0 reram_1t1r Tf0=4.511062e-09  $ G+=24.638uS w=0.5370
Xrp4_48 row4 gate cp48 0 reram_1t1r Tf0=3.300000e-09  $ G+=0.296uS w=-0.0739
Xrp4_49 row4 gate cp49 0 reram_1t1r Tf0=4.206353e-09  $ G+=8.139uS w=0.1730
Xrp4_50 row4 gate cp50 0 reram_1t1r Tf0=3.300000e-09  $ G+=0.296uS w=-0.0795
Xrp4_51 row4 gate cp51 0 reram_1t1r Tf0=3.389451e-09  $ G+=0.418uS w=0.0027
Xrp4_52 row4 gate cp52 0 reram_1t1r Tf0=4.449334e-09  $ G+=19.686uS w=0.4277
Xrp4_53 row4 gate cp53 0 reram_1t1r Tf0=3.300000e-09  $ G+=0.296uS w=-0.0181
Xrp4_54 row4 gate cp54 0 reram_1t1r Tf0=3.300000e-09  $ G+=0.296uS w=-0.0209
Xrp4_55 row4 gate cp55 0 reram_1t1r Tf0=3.300000e-09  $ G+=0.296uS w=-0.6626
Xrp4_56 row4 gate cp56 0 reram_1t1r Tf0=3.300000e-09  $ G+=0.296uS w=-0.7855
Xrp4_57 row4 gate cp57 0 reram_1t1r Tf0=4.473157e-09  $ G+=21.466uS w=0.4670
Xrp4_58 row4 gate cp58 0 reram_1t1r Tf0=3.890545e-09  $ G+=2.582uS w=0.0504
Xrp4_59 row4 gate cp59 0 reram_1t1r Tf0=3.300000e-09  $ G+=0.296uS w=-0.5536
Xrp4_60 row4 gate cp60 0 reram_1t1r Tf0=3.300000e-09  $ G+=0.296uS w=-0.2890
Xrp4_61 row4 gate cp61 0 reram_1t1r Tf0=3.300000e-09  $ G+=0.296uS w=-0.2835
Xrp4_62 row4 gate cp62 0 reram_1t1r Tf0=3.784168e-09  $ G+=1.754uS w=0.0322
Xrp4_63 row4 gate cp63 0 reram_1t1r Tf0=3.300000e-09  $ G+=0.296uS w=-0.2324
* --- Row 5 ---
Xrp5_0 row5 gate cp0 0 reram_1t1r Tf0=3.300000e-09  $ G+=0.296uS w=-0.0330
Xrp5_1 row5 gate cp1 0 reram_1t1r Tf0=4.367591e-09  $ G+=14.625uS w=0.3161
Xrp5_2 row5 gate cp2 0 reram_1t1r Tf0=4.189670e-09  $ G+=7.660uS w=0.1624
Xrp5_3 row5 gate cp3 0 reram_1t1r Tf0=3.300000e-09  $ G+=0.296uS w=-0.6497
Xrp5_4 row5 gate cp4 0 reram_1t1r Tf0=4.373745e-09  $ G+=14.956uS w=0.3234
Xrp5_5 row5 gate cp5 0 reram_1t1r Tf0=3.300000e-09  $ G+=0.296uS w=-0.0799
Xrp5_6 row5 gate cp6 0 reram_1t1r Tf0=3.300000e-09  $ G+=0.296uS w=-0.4482
Xrp5_7 row5 gate cp7 0 reram_1t1r Tf0=3.300000e-09  $ G+=0.296uS w=-0.0817
Xrp5_8 row5 gate cp8 0 reram_1t1r Tf0=3.300000e-09  $ G+=0.296uS w=-0.2741
Xrp5_9 row5 gate cp9 0 reram_1t1r Tf0=3.300000e-09  $ G+=0.296uS w=-0.1355
Xrp5_10 row5 gate cp10 0 reram_1t1r Tf0=3.300000e-09  $ G+=0.296uS w=-0.2811
Xrp5_11 row5 gate cp11 0 reram_1t1r Tf0=4.187337e-09  $ G+=7.595uS w=0.1610
Xrp5_12 row5 gate cp12 0 reram_1t1r Tf0=3.300000e-09  $ G+=0.296uS w=-0.1114
Xrp5_13 row5 gate cp13 0 reram_1t1r Tf0=3.300000e-09  $ G+=0.296uS w=-0.7253
Xrp5_14 row5 gate cp14 0 reram_1t1r Tf0=3.300000e-09  $ G+=0.296uS w=-0.6611
Xrp5_15 row5 gate cp15 0 reram_1t1r Tf0=3.300000e-09  $ G+=0.296uS w=-0.4005
Xrp5_16 row5 gate cp16 0 reram_1t1r Tf0=4.562517e-09  $ G+=29.705uS w=0.6487
Xrp5_17 row5 gate cp17 0 reram_1t1r Tf0=4.402053e-09  $ G+=16.577uS w=0.3591
Xrp5_18 row5 gate cp18 0 reram_1t1r Tf0=4.003281e-09  $ G+=3.890uS w=0.0793
Xrp5_19 row5 gate cp19 0 reram_1t1r Tf0=3.300000e-09  $ G+=0.296uS w=-0.3358
Xrp5_20 row5 gate cp20 0 reram_1t1r Tf0=3.300000e-09  $ G+=0.296uS w=-0.1522
Xrp5_21 row5 gate cp21 0 reram_1t1r Tf0=4.157232e-09  $ G+=6.808uS w=0.1436
Xrp5_22 row5 gate cp22 0 reram_1t1r Tf0=3.300000e-09  $ G+=0.296uS w=-0.0776
Xrp5_23 row5 gate cp23 0 reram_1t1r Tf0=4.243341e-09  $ G+=9.310uS w=0.1988
Xrp5_24 row5 gate cp24 0 reram_1t1r Tf0=3.300000e-09  $ G+=0.296uS w=-0.0050
Xrp5_25 row5 gate cp25 0 reram_1t1r Tf0=3.300000e-09  $ G+=0.296uS w=-0.7068
Xrp5_26 row5 gate cp26 0 reram_1t1r Tf0=3.300000e-09  $ G+=0.296uS w=-0.0371
Xrp5_27 row5 gate cp27 0 reram_1t1r Tf0=3.300000e-09  $ G+=0.296uS w=-0.3538
Xrp5_28 row5 gate cp28 0 reram_1t1r Tf0=3.300000e-09  $ G+=0.296uS w=-0.2749
Xrp5_29 row5 gate cp29 0 reram_1t1r Tf0=4.609868e-09  $ G+=35.284uS w=0.7718
Xrp5_30 row5 gate cp30 0 reram_1t1r Tf0=4.120578e-09  $ G+=5.959uS w=0.1249
Xrp5_31 row5 gate cp31 0 reram_1t1r Tf0=4.194575e-09  $ G+=7.798uS w=0.1655
Xrp5_32 row5 gate cp32 0 reram_1t1r Tf0=3.726321e-09  $ G+=1.421uS w=0.0248
Xrp5_33 row5 gate cp33 0 reram_1t1r Tf0=3.300000e-09  $ G+=0.296uS w=-0.6009
Xrp5_34 row5 gate cp34 0 reram_1t1r Tf0=3.300000e-09  $ G+=0.296uS w=-0.5633
Xrp5_35 row5 gate cp35 0 reram_1t1r Tf0=3.300000e-09  $ G+=0.296uS w=-0.1285
Xrp5_36 row5 gate cp36 0 reram_1t1r Tf0=3.300000e-09  $ G+=0.296uS w=-0.7383
Xrp5_37 row5 gate cp37 0 reram_1t1r Tf0=4.076827e-09  $ G+=5.083uS w=0.1056
Xrp5_38 row5 gate cp38 0 reram_1t1r Tf0=4.411659e-09  $ G+=17.166uS w=0.3721
Xrp5_39 row5 gate cp39 0 reram_1t1r Tf0=4.240407e-09  $ G+=9.211uS w=0.1967
Xrp5_40 row5 gate cp40 0 reram_1t1r Tf0=3.300000e-09  $ G+=0.296uS w=-0.3234
Xrp5_41 row5 gate cp41 0 reram_1t1r Tf0=3.300000e-09  $ G+=0.296uS w=-0.1470
Xrp5_42 row5 gate cp42 0 reram_1t1r Tf0=3.886365e-09  $ G+=2.543uS w=0.0496
Xrp5_43 row5 gate cp43 0 reram_1t1r Tf0=3.300000e-09  $ G+=0.296uS w=-0.2464
Xrp5_44 row5 gate cp44 0 reram_1t1r Tf0=4.018835e-09  $ G+=4.116uS w=0.0843
Xrp5_45 row5 gate cp45 0 reram_1t1r Tf0=3.300000e-09  $ G+=0.296uS w=-0.1823
Xrp5_46 row5 gate cp46 0 reram_1t1r Tf0=4.307302e-09  $ G+=11.747uS w=0.2526
Xrp5_47 row5 gate cp47 0 reram_1t1r Tf0=3.300000e-09  $ G+=0.296uS w=-0.0241
Xrp5_48 row5 gate cp48 0 reram_1t1r Tf0=3.300000e-09  $ G+=0.296uS w=-0.0811
Xrp5_49 row5 gate cp49 0 reram_1t1r Tf0=3.300000e-09  $ G+=0.296uS w=-0.5130
Xrp5_50 row5 gate cp50 0 reram_1t1r Tf0=3.300000e-09  $ G+=0.296uS w=-0.5306
Xrp5_51 row5 gate cp51 0 reram_1t1r Tf0=3.300000e-09  $ G+=0.296uS w=-0.5438
Xrp5_52 row5 gate cp52 0 reram_1t1r Tf0=3.717338e-09  $ G+=1.376uS w=0.0238
Xrp5_53 row5 gate cp53 0 reram_1t1r Tf0=3.806026e-09  $ G+=1.899uS w=0.0354
Xrp5_54 row5 gate cp54 0 reram_1t1r Tf0=3.300000e-09  $ G+=0.296uS w=-0.3980
Xrp5_55 row5 gate cp55 0 reram_1t1r Tf0=3.300000e-09  $ G+=0.296uS w=-0.0390
Xrp5_56 row5 gate cp56 0 reram_1t1r Tf0=4.545440e-09  $ G+=27.917uS w=0.6093
Xrp5_57 row5 gate cp57 0 reram_1t1r Tf0=3.300000e-09  $ G+=0.296uS w=-0.2143
Xrp5_58 row5 gate cp58 0 reram_1t1r Tf0=4.536288e-09  $ G+=27.003uS w=0.5891
Xrp5_59 row5 gate cp59 0 reram_1t1r Tf0=3.300000e-09  $ G+=0.296uS w=-0.7629
Xrp5_60 row5 gate cp60 0 reram_1t1r Tf0=3.300000e-09  $ G+=0.296uS w=-0.4254
Xrp5_61 row5 gate cp61 0 reram_1t1r Tf0=4.439701e-09  $ G+=19.008uS w=0.4128
Xrp5_62 row5 gate cp62 0 reram_1t1r Tf0=3.300000e-09  $ G+=0.296uS w=-0.1957
Xrp5_63 row5 gate cp63 0 reram_1t1r Tf0=4.515010e-09  $ G+=24.994uS w=0.5448
* --- Row 6 ---
Xrp6_0 row6 gate cp0 0 reram_1t1r Tf0=4.177780e-09  $ G+=7.336uS w=0.1553
Xrp6_1 row6 gate cp1 0 reram_1t1r Tf0=4.100057e-09  $ G+=5.530uS w=0.1155
Xrp6_2 row6 gate cp2 0 reram_1t1r Tf0=3.823350e-09  $ G+=2.023uS w=0.0381
Xrp6_3 row6 gate cp3 0 reram_1t1r Tf0=3.300000e-09  $ G+=0.296uS w=-0.6025
Xrp6_4 row6 gate cp4 0 reram_1t1r Tf0=4.497898e-09  $ G+=23.486uS w=0.5116
Xrp6_5 row6 gate cp5 0 reram_1t1r Tf0=4.375284e-09  $ G+=15.040uS w=0.3252
Xrp6_6 row6 gate cp6 0 reram_1t1r Tf0=4.703093e-09  $ G+=49.517uS w=1.0858
Xrp6_7 row6 gate cp7 0 reram_1t1r Tf0=3.300000e-09  $ G+=0.296uS w=-0.1645
Xrp6_8 row6 gate cp8 0 reram_1t1r Tf0=3.300000e-09  $ G+=0.296uS w=-0.0316
Xrp6_9 row6 gate cp9 0 reram_1t1r Tf0=4.389824e-09  $ G+=15.856uS w=0.3432
Xrp6_10 row6 gate cp10 0 reram_1t1r Tf0=3.300000e-09  $ G+=0.296uS w=-0.0853
Xrp6_11 row6 gate cp11 0 reram_1t1r Tf0=4.272043e-09  $ G+=10.334uS w=0.2214
Xrp6_12 row6 gate cp12 0 reram_1t1r Tf0=3.300000e-09  $ G+=0.296uS w=-0.0205
Xrp6_13 row6 gate cp13 0 reram_1t1r Tf0=3.300000e-09  $ G+=0.296uS w=-0.3951
Xrp6_14 row6 gate cp14 0 reram_1t1r Tf0=3.300000e-09  $ G+=0.296uS w=-0.1157
Xrp6_15 row6 gate cp15 0 reram_1t1r Tf0=4.556828e-09  $ G+=29.097uS w=0.6353
Xrp6_16 row6 gate cp16 0 reram_1t1r Tf0=4.248713e-09  $ G+=9.494uS w=0.2029
Xrp6_17 row6 gate cp17 0 reram_1t1r Tf0=4.139287e-09  $ G+=6.378uS w=0.1342
Xrp6_18 row6 gate cp18 0 reram_1t1r Tf0=3.808437e-09  $ G+=1.916uS w=0.0357
Xrp6_19 row6 gate cp19 0 reram_1t1r Tf0=4.373223e-09  $ G+=14.928uS w=0.3228
Xrp6_20 row6 gate cp20 0 reram_1t1r Tf0=3.300000e-09  $ G+=0.296uS w=-0.0623
Xrp6_21 row6 gate cp21 0 reram_1t1r Tf0=4.693220e-09  $ G+=47.771uS w=1.0473
Xrp6_22 row6 gate cp22 0 reram_1t1r Tf0=4.035865e-09  $ G+=4.379uS w=0.0901
Xrp6_23 row6 gate cp23 0 reram_1t1r Tf0=3.300000e-09  $ G+=0.296uS w=-0.7168
Xrp6_24 row6 gate cp24 0 reram_1t1r Tf0=4.598405e-09  $ G+=33.844uS w=0.7400
Xrp6_25 row6 gate cp25 0 reram_1t1r Tf0=3.300000e-09  $ G+=0.296uS w=-0.7364
Xrp6_26 row6 gate cp26 0 reram_1t1r Tf0=3.300000e-09  $ G+=0.296uS w=-0.3666
Xrp6_27 row6 gate cp27 0 reram_1t1r Tf0=3.300000e-09  $ G+=0.296uS w=-0.4474
Xrp6_28 row6 gate cp28 0 reram_1t1r Tf0=4.390460e-09  $ G+=15.893uS w=0.3441
Xrp6_29 row6 gate cp29 0 reram_1t1r Tf0=4.049472e-09  $ G+=4.601uS w=0.0950
Xrp6_30 row6 gate cp30 0 reram_1t1r Tf0=3.300000e-09  $ G+=0.296uS w=-0.6494
Xrp6_31 row6 gate cp31 0 reram_1t1r Tf0=4.202303e-09  $ G+=8.020uS w=0.1704
Xrp6_32 row6 gate cp32 0 reram_1t1r Tf0=3.300000e-09  $ G+=0.296uS w=-0.1915
Xrp6_33 row6 gate cp33 0 reram_1t1r Tf0=3.300000e-09  $ G+=0.296uS w=-0.3593
Xrp6_34 row6 gate cp34 0 reram_1t1r Tf0=3.300000e-09  $ G+=0.296uS w=-0.0300
Xrp6_35 row6 gate cp35 0 reram_1t1r Tf0=3.300000e-09  $ G+=0.296uS w=-0.1366
Xrp6_36 row6 gate cp36 0 reram_1t1r Tf0=4.368325e-09  $ G+=14.664uS w=0.3170
Xrp6_37 row6 gate cp37 0 reram_1t1r Tf0=4.496783e-09  $ G+=23.391uS w=0.5095
Xrp6_38 row6 gate cp38 0 reram_1t1r Tf0=3.300000e-09  $ G+=0.296uS w=-0.4283
Xrp6_39 row6 gate cp39 0 reram_1t1r Tf0=4.074276e-09  $ G+=5.036uS w=0.1046
Xrp6_40 row6 gate cp40 0 reram_1t1r Tf0=3.300000e-09  $ G+=0.296uS w=-0.1752
Xrp6_41 row6 gate cp41 0 reram_1t1r Tf0=3.300000e-09  $ G+=0.296uS w=-0.1117
Xrp6_42 row6 gate cp42 0 reram_1t1r Tf0=4.143367e-09  $ G+=6.473uS w=0.1363
Xrp6_43 row6 gate cp43 0 reram_1t1r Tf0=3.300000e-09  $ G+=0.296uS w=-0.1753
Xrp6_44 row6 gate cp44 0 reram_1t1r Tf0=3.300000e-09  $ G+=0.296uS w=-0.1886
Xrp6_45 row6 gate cp45 0 reram_1t1r Tf0=3.300000e-09  $ G+=0.296uS w=-0.5710
Xrp6_46 row6 gate cp46 0 reram_1t1r Tf0=3.300000e-09  $ G+=0.296uS w=-0.3596
Xrp6_47 row6 gate cp47 0 reram_1t1r Tf0=4.520437e-09  $ G+=25.492uS w=0.5558
Xrp6_48 row6 gate cp48 0 reram_1t1r Tf0=4.009232e-09  $ G+=3.975uS w=0.0812
Xrp6_49 row6 gate cp49 0 reram_1t1r Tf0=3.300000e-09  $ G+=0.296uS w=-0.0935
Xrp6_50 row6 gate cp50 0 reram_1t1r Tf0=3.300000e-09  $ G+=0.296uS w=-0.3075
Xrp6_51 row6 gate cp51 0 reram_1t1r Tf0=3.300000e-09  $ G+=0.296uS w=-0.0720
Xrp6_52 row6 gate cp52 0 reram_1t1r Tf0=3.300000e-09  $ G+=0.296uS w=-0.2617
Xrp6_53 row6 gate cp53 0 reram_1t1r Tf0=3.300000e-09  $ G+=0.296uS w=-0.0654
Xrp6_54 row6 gate cp54 0 reram_1t1r Tf0=4.105044e-09  $ G+=5.632uS w=0.1177
Xrp6_55 row6 gate cp55 0 reram_1t1r Tf0=3.300000e-09  $ G+=0.296uS w=-0.8200
Xrp6_56 row6 gate cp56 0 reram_1t1r Tf0=4.255491e-09  $ G+=9.730uS w=0.2081
Xrp6_57 row6 gate cp57 0 reram_1t1r Tf0=4.152617e-09  $ G+=6.695uS w=0.1411
Xrp6_58 row6 gate cp58 0 reram_1t1r Tf0=4.115949e-09  $ G+=5.859uS w=0.1227
Xrp6_59 row6 gate cp59 0 reram_1t1r Tf0=3.300000e-09  $ G+=0.296uS w=-0.4501
Xrp6_60 row6 gate cp60 0 reram_1t1r Tf0=3.300000e-09  $ G+=0.296uS w=-0.0585
Xrp6_61 row6 gate cp61 0 reram_1t1r Tf0=3.300000e-09  $ G+=0.296uS w=-0.3312
Xrp6_62 row6 gate cp62 0 reram_1t1r Tf0=3.487029e-09  $ G+=0.596uS w=0.0066
Xrp6_63 row6 gate cp63 0 reram_1t1r Tf0=3.300000e-09  $ G+=0.296uS w=-0.0160
* --- Row 7 ---
Xrp7_0 row7 gate cp0 0 reram_1t1r Tf0=4.327652e-09  $ G+=12.649uS w=0.2725
Xrp7_1 row7 gate cp1 0 reram_1t1r Tf0=3.300000e-09  $ G+=0.296uS w=-0.1386
Xrp7_2 row7 gate cp2 0 reram_1t1r Tf0=4.466758e-09  $ G+=20.973uS w=0.4561
Xrp7_3 row7 gate cp3 0 reram_1t1r Tf0=3.300000e-09  $ G+=0.296uS w=-0.0175
Xrp7_4 row7 gate cp4 0 reram_1t1r Tf0=3.300000e-09  $ G+=0.296uS w=-0.0975
Xrp7_5 row7 gate cp5 0 reram_1t1r Tf0=4.308368e-09  $ G+=11.793uS w=0.2536
Xrp7_6 row7 gate cp6 0 reram_1t1r Tf0=4.367943e-09  $ G+=14.644uS w=0.3165
Xrp7_7 row7 gate cp7 0 reram_1t1r Tf0=4.379431e-09  $ G+=15.268uS w=0.3303
Xrp7_8 row7 gate cp8 0 reram_1t1r Tf0=3.300000e-09  $ G+=0.296uS w=-0.1494
Xrp7_9 row7 gate cp9 0 reram_1t1r Tf0=4.376785e-09  $ G+=15.122uS w=0.3271
Xrp7_10 row7 gate cp10 0 reram_1t1r Tf0=3.300000e-09  $ G+=0.296uS w=-0.1423
Xrp7_11 row7 gate cp11 0 reram_1t1r Tf0=3.300000e-09  $ G+=0.296uS w=-0.2467
Xrp7_12 row7 gate cp12 0 reram_1t1r Tf0=3.300000e-09  $ G+=0.296uS w=-0.1233
Xrp7_13 row7 gate cp13 0 reram_1t1r Tf0=3.937007e-09  $ G+=3.057uS w=0.0609
Xrp7_14 row7 gate cp14 0 reram_1t1r Tf0=4.543444e-09  $ G+=27.715uS w=0.6048
Xrp7_15 row7 gate cp15 0 reram_1t1r Tf0=4.469689e-09  $ G+=21.197uS w=0.4611
Xrp7_16 row7 gate cp16 0 reram_1t1r Tf0=4.225191e-09  $ G+=8.716uS w=0.1857
Xrp7_17 row7 gate cp17 0 reram_1t1r Tf0=3.300000e-09  $ G+=0.296uS w=-0.2438
Xrp7_18 row7 gate cp18 0 reram_1t1r Tf0=3.300000e-09  $ G+=0.296uS w=-0.0184
Xrp7_19 row7 gate cp19 0 reram_1t1r Tf0=3.300000e-09  $ G+=0.296uS w=-0.1824
Xrp7_20 row7 gate cp20 0 reram_1t1r Tf0=3.300000e-09  $ G+=0.296uS w=-0.2072
Xrp7_21 row7 gate cp21 0 reram_1t1r Tf0=4.600782e-09  $ G+=34.138uS w=0.7465
Xrp7_22 row7 gate cp22 0 reram_1t1r Tf0=3.300000e-09  $ G+=0.296uS w=-0.4770
Xrp7_23 row7 gate cp23 0 reram_1t1r Tf0=4.500086e-09  $ G+=23.674uS w=0.5157
Xrp7_24 row7 gate cp24 0 reram_1t1r Tf0=3.300000e-09  $ G+=0.296uS w=-0.6621
Xrp7_25 row7 gate cp25 0 reram_1t1r Tf0=4.264534e-09  $ G+=10.056uS w=0.2153
Xrp7_26 row7 gate cp26 0 reram_1t1r Tf0=4.600703e-09  $ G+=34.128uS w=0.7463
Xrp7_27 row7 gate cp27 0 reram_1t1r Tf0=4.720578e-09  $ G+=52.766uS w=1.1574
Xrp7_28 row7 gate cp28 0 reram_1t1r Tf0=3.300000e-09  $ G+=0.296uS w=-0.1958
Xrp7_29 row7 gate cp29 0 reram_1t1r Tf0=3.300000e-09  $ G+=0.296uS w=-0.3417
Xrp7_30 row7 gate cp30 0 reram_1t1r Tf0=4.632507e-09  $ G+=38.311uS w=0.8386
Xrp7_31 row7 gate cp31 0 reram_1t1r Tf0=3.300000e-09  $ G+=0.296uS w=-0.1115
Xrp7_32 row7 gate cp32 0 reram_1t1r Tf0=4.444929e-09  $ G+=19.373uS w=0.4208
Xrp7_33 row7 gate cp33 0 reram_1t1r Tf0=4.605767e-09  $ G+=34.762uS w=0.7603
Xrp7_34 row7 gate cp34 0 reram_1t1r Tf0=3.300000e-09  $ G+=0.296uS w=-0.1324
Xrp7_35 row7 gate cp35 0 reram_1t1r Tf0=4.378324e-09  $ G+=15.207uS w=0.3289
Xrp7_36 row7 gate cp36 0 reram_1t1r Tf0=3.300000e-09  $ G+=0.296uS w=-0.0805
Xrp7_37 row7 gate cp37 0 reram_1t1r Tf0=4.418096e-09  $ G+=17.572uS w=0.3811
Xrp7_38 row7 gate cp38 0 reram_1t1r Tf0=3.300000e-09  $ G+=0.296uS w=-0.1563
Xrp7_39 row7 gate cp39 0 reram_1t1r Tf0=3.300000e-09  $ G+=0.296uS w=-0.0514
Xrp7_40 row7 gate cp40 0 reram_1t1r Tf0=3.435049e-09  $ G+=0.493uS w=0.0043
Xrp7_41 row7 gate cp41 0 reram_1t1r Tf0=3.776707e-09  $ G+=1.707uS w=0.0311
Xrp7_42 row7 gate cp42 0 reram_1t1r Tf0=4.225309e-09  $ G+=8.719uS w=0.1858
Xrp7_43 row7 gate cp43 0 reram_1t1r Tf0=4.337914e-09  $ G+=13.130uS w=0.2831
Xrp7_44 row7 gate cp44 0 reram_1t1r Tf0=3.300000e-09  $ G+=0.296uS w=-0.0017
Xrp7_45 row7 gate cp45 0 reram_1t1r Tf0=3.300000e-09  $ G+=0.296uS w=-0.1052
Xrp7_46 row7 gate cp46 0 reram_1t1r Tf0=4.082267e-09  $ G+=5.184uS w=0.1078
Xrp7_47 row7 gate cp47 0 reram_1t1r Tf0=3.300000e-09  $ G+=0.296uS w=-0.1179
Xrp7_48 row7 gate cp48 0 reram_1t1r Tf0=4.340808e-09  $ G+=13.268uS w=0.2862
Xrp7_49 row7 gate cp49 0 reram_1t1r Tf0=3.300000e-09  $ G+=0.296uS w=-0.3787
Xrp7_50 row7 gate cp50 0 reram_1t1r Tf0=3.975262e-09  $ G+=3.514uS w=0.0710
Xrp7_51 row7 gate cp51 0 reram_1t1r Tf0=4.754940e-09  $ G+=59.786uS w=1.3123
Xrp7_52 row7 gate cp52 0 reram_1t1r Tf0=4.284590e-09  $ G+=10.816uS w=0.2321
Xrp7_53 row7 gate cp53 0 reram_1t1r Tf0=3.300000e-09  $ G+=0.296uS w=-0.1100
Xrp7_54 row7 gate cp54 0 reram_1t1r Tf0=3.300000e-09  $ G+=0.296uS w=-0.0624
Xrp7_55 row7 gate cp55 0 reram_1t1r Tf0=4.604617e-09  $ G+=34.617uS w=0.7571
Xrp7_56 row7 gate cp56 0 reram_1t1r Tf0=3.300000e-09  $ G+=0.296uS w=-0.3137
Xrp7_57 row7 gate cp57 0 reram_1t1r Tf0=3.300000e-09  $ G+=0.296uS w=-0.3843
Xrp7_58 row7 gate cp58 0 reram_1t1r Tf0=3.795417e-09  $ G+=1.827uS w=0.0338
Xrp7_59 row7 gate cp59 0 reram_1t1r Tf0=3.990062e-09  $ G+=3.708uS w=0.0753
Xrp7_60 row7 gate cp60 0 reram_1t1r Tf0=4.603435e-09  $ G+=34.469uS w=0.7538
Xrp7_61 row7 gate cp61 0 reram_1t1r Tf0=4.411944e-09  $ G+=17.184uS w=0.3725
Xrp7_62 row7 gate cp62 0 reram_1t1r Tf0=3.300000e-09  $ G+=0.296uS w=-0.0086
Xrp7_63 row7 gate cp63 0 reram_1t1r Tf0=4.377861e-09  $ G+=15.181uS w=0.3284

* ===== NEGATIVE CONDUCTANCE ARRAY (8x64) =====
* --- Row 0 ---
Xrn0_0 row0 gate cn0 0 reram_1t1r Tf0=4.561113e-09  $ G-=29.554uS w=-0.6454
Xrn0_1 row0 gate cn1 0 reram_1t1r Tf0=3.300000e-09  $ G-=0.296uS w=1.5675
Xrn0_2 row0 gate cn2 0 reram_1t1r Tf0=3.300000e-09  $ G-=0.296uS w=0.4877
Xrn0_3 row0 gate cn3 0 reram_1t1r Tf0=3.300000e-09  $ G-=0.296uS w=0.7820
Xrn0_4 row0 gate cn4 0 reram_1t1r Tf0=4.202811e-09  $ G-=8.035uS w=-0.1707
Xrn0_5 row0 gate cn5 0 reram_1t1r Tf0=4.277936e-09  $ G-=10.558uS w=-0.2264
Xrn0_6 row0 gate cn6 0 reram_1t1r Tf0=4.237389e-09  $ G-=9.111uS w=-0.1944
Xrn0_7 row0 gate cn7 0 reram_1t1r Tf0=3.300000e-09  $ G-=0.296uS w=2.1833
Xrn0_8 row0 gate cn8 0 reram_1t1r Tf0=3.300000e-09  $ G-=0.296uS w=0.4815
Xrn0_9 row0 gate cn9 0 reram_1t1r Tf0=4.467528e-09  $ G-=21.032uS w=-0.4574
Xrn0_10 row0 gate cn10 0 reram_1t1r Tf0=4.579036e-09  $ G-=31.543uS w=-0.6893
Xrn0_11 row0 gate cn11 0 reram_1t1r Tf0=3.300000e-09  $ G-=0.296uS w=0.8068
Xrn0_12 row0 gate cn12 0 reram_1t1r Tf0=3.300000e-09  $ G-=0.296uS w=1.7220
Xrn0_13 row0 gate cn13 0 reram_1t1r Tf0=3.300000e-09  $ G-=0.296uS w=0.6534
Xrn0_14 row0 gate cn14 0 reram_1t1r Tf0=4.599660e-09  $ G-=33.999uS w=-0.7435
Xrn0_15 row0 gate cn15 0 reram_1t1r Tf0=4.478286e-09  $ G-=21.870uS w=-0.4759
Xrn0_16 row0 gate cn16 0 reram_1t1r Tf0=4.358477e-09  $ G-=14.149uS w=-0.3056
Xrn0_17 row0 gate cn17 0 reram_1t1r Tf0=3.300000e-09  $ G-=0.296uS w=0.2528
Xrn0_18 row0 gate cn18 0 reram_1t1r Tf0=3.300000e-09  $ G-=0.296uS w=0.9608
Xrn0_19 row0 gate cn19 0 reram_1t1r Tf0=3.300000e-09  $ G-=0.296uS w=0.1111
Xrn0_20 row0 gate cn20 0 reram_1t1r Tf0=3.300000e-09  $ G-=0.296uS w=0.2936
Xrn0_21 row0 gate cn21 0 reram_1t1r Tf0=4.410181e-09  $ G-=17.074uS w=-0.3701
Xrn0_22 row0 gate cn22 0 reram_1t1r Tf0=4.415439e-09  $ G-=17.404uS w=-0.3774
Xrn0_23 row0 gate cn23 0 reram_1t1r Tf0=3.300000e-09  $ G-=0.296uS w=0.5450
Xrn0_24 row0 gate cn24 0 reram_1t1r Tf0=4.319045e-09  $ G-=12.259uS w=-0.2639
Xrn0_25 row0 gate cn25 0 reram_1t1r Tf0=3.300000e-09  $ G-=0.296uS w=0.0963
Xrn0_26 row0 gate cn26 0 reram_1t1r Tf0=4.113370e-09  $ G-=5.805uS w=-0.1215
Xrn0_27 row0 gate cn27 0 reram_1t1r Tf0=3.300000e-09  $ G-=0.296uS w=0.8765
Xrn0_28 row0 gate cn28 0 reram_1t1r Tf0=3.916056e-09  $ G-=2.833uS w=-0.0560
Xrn0_29 row0 gate cn29 0 reram_1t1r Tf0=4.628757e-09  $ G-=37.792uS w=-0.8271
Xrn0_30 row0 gate cn30 0 reram_1t1r Tf0=4.423629e-09  $ G-=17.929uS w=-0.3890
Xrn0_31 row0 gate cn31 0 reram_1t1r Tf0=3.300000e-09  $ G-=0.296uS w=0.1300
Xrn0_32 row0 gate cn32 0 reram_1t1r Tf0=4.700970e-09  $ G-=49.136uS w=-1.0774
Xrn0_33 row0 gate cn33 0 reram_1t1r Tf0=3.300000e-09  $ G-=0.296uS w=0.6312
Xrn0_34 row0 gate cn34 0 reram_1t1r Tf0=3.300000e-09  $ G-=0.296uS w=0.7122
Xrn0_35 row0 gate cn35 0 reram_1t1r Tf0=3.300000e-09  $ G-=0.296uS w=0.6255
Xrn0_36 row0 gate cn36 0 reram_1t1r Tf0=3.300000e-09  $ G-=0.296uS w=0.0006
Xrn0_37 row0 gate cn37 0 reram_1t1r Tf0=4.536328e-09  $ G-=27.007uS w=-0.5892
Xrn0_38 row0 gate cn38 0 reram_1t1r Tf0=4.379166e-09  $ G-=15.254uS w=-0.3300
Xrn0_39 row0 gate cn39 0 reram_1t1r Tf0=3.300000e-09  $ G-=0.296uS w=0.7854
Xrn0_40 row0 gate cn40 0 reram_1t1r Tf0=4.560988e-09  $ G-=29.540uS w=-0.6451
Xrn0_41 row0 gate cn41 0 reram_1t1r Tf0=3.300000e-09  $ G-=0.296uS w=1.5055
Xrn0_42 row0 gate cn42 0 reram_1t1r Tf0=4.372707e-09  $ G-=14.900uS w=-0.3221
Xrn0_43 row0 gate cn43 0 reram_1t1r Tf0=3.300000e-09  $ G-=0.296uS w=1.4322
Xrn0_44 row0 gate cn44 0 reram_1t1r Tf0=4.411345e-09  $ G-=17.146uS w=-0.3717
Xrn0_45 row0 gate cn45 0 reram_1t1r Tf0=3.326761e-09  $ G-=0.333uS w=-0.0008
Xrn0_46 row0 gate cn46 0 reram_1t1r Tf0=4.271418e-09  $ G-=10.310uS w=-0.2209
Xrn0_47 row0 gate cn47 0 reram_1t1r Tf0=3.300000e-09  $ G-=0.296uS w=0.5978
Xrn0_48 row0 gate cn48 0 reram_1t1r Tf0=3.300000e-09  $ G-=0.296uS w=0.0640
Xrn0_49 row0 gate cn49 0 reram_1t1r Tf0=3.300000e-09  $ G-=0.296uS w=0.3582
Xrn0_50 row0 gate cn50 0 reram_1t1r Tf0=3.300000e-09  $ G-=0.296uS w=0.8690
Xrn0_51 row0 gate cn51 0 reram_1t1r Tf0=3.300000e-09  $ G-=0.296uS w=0.7380
Xrn0_52 row0 gate cn52 0 reram_1t1r Tf0=3.300000e-09  $ G-=0.296uS w=1.0649
Xrn0_53 row0 gate cn53 0 reram_1t1r Tf0=3.300000e-09  $ G-=0.296uS w=1.1657
Xrn0_54 row0 gate cn54 0 reram_1t1r Tf0=3.300000e-09  $ G-=0.296uS w=0.1974
Xrn0_55 row0 gate cn55 0 reram_1t1r Tf0=3.300000e-09  $ G-=0.296uS w=0.4616
Xrn0_56 row0 gate cn56 0 reram_1t1r Tf0=3.300000e-09  $ G-=0.296uS w=0.0613
Xrn0_57 row0 gate cn57 0 reram_1t1r Tf0=4.360324e-09  $ G-=14.244uS w=-0.3077
Xrn0_58 row0 gate cn58 0 reram_1t1r Tf0=4.390650e-09  $ G-=15.904uS w=-0.3443
Xrn0_59 row0 gate cn59 0 reram_1t1r Tf0=4.787322e-09  $ G-=67.255uS w=-1.4770
Xrn0_60 row0 gate cn60 0 reram_1t1r Tf0=4.334484e-09  $ G-=12.967uS w=-0.2795
Xrn0_61 row0 gate cn61 0 reram_1t1r Tf0=3.300000e-09  $ G-=0.296uS w=0.8457
Xrn0_62 row0 gate cn62 0 reram_1t1r Tf0=3.300000e-09  $ G-=0.296uS w=1.2610
Xrn0_63 row0 gate cn63 0 reram_1t1r Tf0=3.776701e-09  $ G-=1.707uS w=-0.0311
* --- Row 1 ---
Xrn1_0 row1 gate cn0 0 reram_1t1r Tf0=3.676986e-09  $ G-=1.188uS w=-0.0197
Xrn1_1 row1 gate cn1 0 reram_1t1r Tf0=3.300000e-09  $ G-=0.296uS w=0.0942
Xrn1_2 row1 gate cn2 0 reram_1t1r Tf0=4.651670e-09  $ G-=41.074uS w=-0.8995
Xrn1_3 row1 gate cn3 0 reram_1t1r Tf0=3.300000e-09  $ G-=0.296uS w=0.1314
Xrn1_4 row1 gate cn4 0 reram_1t1r Tf0=4.125443e-09  $ G-=6.065uS w=-0.1273
Xrn1_5 row1 gate cn5 0 reram_1t1r Tf0=3.300000e-09  $ G-=0.296uS w=0.6486
Xrn1_6 row1 gate cn6 0 reram_1t1r Tf0=3.300000e-09  $ G-=0.296uS w=0.0667
Xrn1_7 row1 gate cn7 0 reram_1t1r Tf0=4.068712e-09  $ G-=4.935uS w=-0.1023
Xrn1_8 row1 gate cn8 0 reram_1t1r Tf0=4.575354e-09  $ G-=31.124uS w=-0.6800
Xrn1_9 row1 gate cn9 0 reram_1t1r Tf0=3.300000e-09  $ G-=0.296uS w=0.2740
Xrn1_10 row1 gate cn10 0 reram_1t1r Tf0=3.300000e-09  $ G-=0.296uS w=0.3135
Xrn1_11 row1 gate cn11 0 reram_1t1r Tf0=3.300000e-09  $ G-=0.296uS w=0.5018
Xrn1_12 row1 gate cn12 0 reram_1t1r Tf0=3.300000e-09  $ G-=0.296uS w=0.1168
Xrn1_13 row1 gate cn13 0 reram_1t1r Tf0=4.472087e-09  $ G-=21.383uS w=-0.4652
Xrn1_14 row1 gate cn14 0 reram_1t1r Tf0=3.300000e-09  $ G-=0.296uS w=0.0860
Xrn1_15 row1 gate cn15 0 reram_1t1r Tf0=3.406109e-09  $ G-=0.444uS w=-0.0033
Xrn1_16 row1 gate cn16 0 reram_1t1r Tf0=3.300000e-09  $ G-=0.296uS w=0.6918
Xrn1_17 row1 gate cn17 0 reram_1t1r Tf0=3.300000e-09  $ G-=0.296uS w=0.1211
Xrn1_18 row1 gate cn18 0 reram_1t1r Tf0=4.398628e-09  $ G-=16.372uS w=-0.3546
Xrn1_19 row1 gate cn19 0 reram_1t1r Tf0=4.266604e-09  $ G-=10.132uS w=-0.2170
Xrn1_20 row1 gate cn20 0 reram_1t1r Tf0=4.405608e-09  $ G-=16.793uS w=-0.3639
Xrn1_21 row1 gate cn21 0 reram_1t1r Tf0=3.300000e-09  $ G-=0.296uS w=0.0184
Xrn1_22 row1 gate cn22 0 reram_1t1r Tf0=3.300000e-09  $ G-=0.296uS w=0.1897
Xrn1_23 row1 gate cn23 0 reram_1t1r Tf0=3.300000e-09  $ G-=0.296uS w=0.2448
Xrn1_24 row1 gate cn24 0 reram_1t1r Tf0=3.300000e-09  $ G-=0.296uS w=0.0276
Xrn1_25 row1 gate cn25 0 reram_1t1r Tf0=4.329703e-09  $ G-=12.744uS w=-0.2746
Xrn1_26 row1 gate cn26 0 reram_1t1r Tf0=4.071531e-09  $ G-=4.986uS w=-0.1034
Xrn1_27 row1 gate cn27 0 reram_1t1r Tf0=3.300000e-09  $ G-=0.296uS w=0.0164
Xrn1_28 row1 gate cn28 0 reram_1t1r Tf0=4.252541e-09  $ G-=9.627uS w=-0.2058
Xrn1_29 row1 gate cn29 0 reram_1t1r Tf0=3.792949e-09  $ G-=1.811uS w=-0.0334
Xrn1_30 row1 gate cn30 0 reram_1t1r Tf0=3.300000e-09  $ G-=0.296uS w=0.5054
Xrn1_31 row1 gate cn31 0 reram_1t1r Tf0=3.881922e-09  $ G-=2.503uS w=-0.0487
Xrn1_32 row1 gate cn32 0 reram_1t1r Tf0=4.263549e-09  $ G-=10.020uS w=-0.2145
Xrn1_33 row1 gate cn33 0 reram_1t1r Tf0=3.300000e-09  $ G-=0.296uS w=0.0172
Xrn1_34 row1 gate cn34 0 reram_1t1r Tf0=4.500206e-09  $ G-=23.684uS w=-0.5159
Xrn1_35 row1 gate cn35 0 reram_1t1r Tf0=4.212486e-09  $ G-=8.322uS w=-0.1771
Xrn1_36 row1 gate cn36 0 reram_1t1r Tf0=4.536434e-09  $ G-=27.018uS w=-0.5895
Xrn1_37 row1 gate cn37 0 reram_1t1r Tf0=3.300000e-09  $ G-=0.296uS w=0.5998
Xrn1_38 row1 gate cn38 0 reram_1t1r Tf0=4.460502e-09  $ G-=20.501uS w=-0.4457
Xrn1_39 row1 gate cn39 0 reram_1t1r Tf0=4.403884e-09  $ G-=16.688uS w=-0.3616
Xrn1_40 row1 gate cn40 0 reram_1t1r Tf0=3.300000e-09  $ G-=0.296uS w=0.6901
Xrn1_41 row1 gate cn41 0 reram_1t1r Tf0=4.097854e-09  $ G-=5.486uS w=-0.1145
Xrn1_42 row1 gate cn42 0 reram_1t1r Tf0=4.561076e-09  $ G-=29.550uS w=-0.6453
Xrn1_43 row1 gate cn43 0 reram_1t1r Tf0=3.300000e-09  $ G-=0.296uS w=0.2602
Xrn1_44 row1 gate cn44 0 reram_1t1r Tf0=4.390721e-09  $ G-=15.908uS w=-0.3444
Xrn1_45 row1 gate cn45 0 reram_1t1r Tf0=4.556345e-09  $ G-=29.046uS w=-0.6342
Xrn1_46 row1 gate cn46 0 reram_1t1r Tf0=4.404292e-09  $ G-=16.712uS w=-0.3621
Xrn1_47 row1 gate cn47 0 reram_1t1r Tf0=3.902635e-09  $ G-=2.698uS w=-0.0530
Xrn1_48 row1 gate cn48 0 reram_1t1r Tf0=3.300000e-09  $ G-=0.296uS w=0.2583
Xrn1_49 row1 gate cn49 0 reram_1t1r Tf0=3.300000e-09  $ G-=0.296uS w=0.3322
Xrn1_50 row1 gate cn50 0 reram_1t1r Tf0=3.791701e-09  $ G-=1.803uS w=-0.0332
Xrn1_51 row1 gate cn51 0 reram_1t1r Tf0=3.300000e-09  $ G-=0.296uS w=0.1838
Xrn1_52 row1 gate cn52 0 reram_1t1r Tf0=3.300000e-09  $ G-=0.296uS w=0.1967
Xrn1_53 row1 gate cn53 0 reram_1t1r Tf0=3.616692e-09  $ G-=0.954uS w=-0.0145
Xrn1_54 row1 gate cn54 0 reram_1t1r Tf0=3.300000e-09  $ G-=0.296uS w=0.6460
Xrn1_55 row1 gate cn55 0 reram_1t1r Tf0=3.300000e-09  $ G-=0.296uS w=0.1806
Xrn1_56 row1 gate cn56 0 reram_1t1r Tf0=3.300000e-09  $ G-=0.296uS w=0.1402
Xrn1_57 row1 gate cn57 0 reram_1t1r Tf0=3.300000e-09  $ G-=0.296uS w=0.8362
Xrn1_58 row1 gate cn58 0 reram_1t1r Tf0=4.349852e-09  $ G-=13.712uS w=-0.2959
Xrn1_59 row1 gate cn59 0 reram_1t1r Tf0=4.036896e-09  $ G-=4.396uS w=-0.0904
Xrn1_60 row1 gate cn60 0 reram_1t1r Tf0=3.300000e-09  $ G-=0.296uS w=0.1542
Xrn1_61 row1 gate cn61 0 reram_1t1r Tf0=3.300000e-09  $ G-=0.296uS w=0.1125
Xrn1_62 row1 gate cn62 0 reram_1t1r Tf0=3.300000e-09  $ G-=0.296uS w=0.2423
Xrn1_63 row1 gate cn63 0 reram_1t1r Tf0=3.300000e-09  $ G-=0.296uS w=0.3014
* --- Row 2 ---
Xrn2_0 row2 gate cn0 0 reram_1t1r Tf0=4.699068e-09  $ G-=48.797uS w=-1.0699
Xrn2_1 row2 gate cn1 0 reram_1t1r Tf0=4.254136e-09  $ G-=9.683uS w=-0.2071
Xrn2_2 row2 gate cn2 0 reram_1t1r Tf0=4.435990e-09  $ G-=18.754uS w=-0.4072
Xrn2_3 row2 gate cn3 0 reram_1t1r Tf0=4.243581e-09  $ G-=9.318uS w=-0.1990
Xrn2_4 row2 gate cn4 0 reram_1t1r Tf0=3.300000e-09  $ G-=0.296uS w=0.0550
Xrn2_5 row2 gate cn5 0 reram_1t1r Tf0=4.481052e-09  $ G-=22.091uS w=-0.4808
Xrn2_6 row2 gate cn6 0 reram_1t1r Tf0=4.330075e-09  $ G-=12.761uS w=-0.2750
Xrn2_7 row2 gate cn7 0 reram_1t1r Tf0=4.464748e-09  $ G-=20.820uS w=-0.4527
Xrn2_8 row2 gate cn8 0 reram_1t1r Tf0=4.015377e-09  $ G-=4.065uS w=-0.0831
Xrn2_9 row2 gate cn9 0 reram_1t1r Tf0=3.300000e-09  $ G-=0.296uS w=0.4874
Xrn2_10 row2 gate cn10 0 reram_1t1r Tf0=3.478612e-09  $ G-=0.578uS w=-0.0062
Xrn2_11 row2 gate cn11 0 reram_1t1r Tf0=3.300000e-09  $ G-=0.296uS w=0.0887
Xrn2_12 row2 gate cn12 0 reram_1t1r Tf0=3.300000e-09  $ G-=0.296uS w=0.1944
Xrn2_13 row2 gate cn13 0 reram_1t1r Tf0=4.391072e-09  $ G-=15.928uS w=-0.3448
Xrn2_14 row2 gate cn14 0 reram_1t1r Tf0=4.236243e-09  $ G-=9.073uS w=-0.1936
Xrn2_15 row2 gate cn15 0 reram_1t1r Tf0=4.500205e-09  $ G-=23.684uS w=-0.5159
Xrn2_16 row2 gate cn16 0 reram_1t1r Tf0=4.471066e-09  $ G-=21.304uS w=-0.4634
Xrn2_17 row2 gate cn17 0 reram_1t1r Tf0=4.391623e-09  $ G-=15.960uS w=-0.3455
Xrn2_18 row2 gate cn18 0 reram_1t1r Tf0=3.300000e-09  $ G-=0.296uS w=0.2357
Xrn2_19 row2 gate cn19 0 reram_1t1r Tf0=3.300000e-09  $ G-=0.296uS w=0.1016
Xrn2_20 row2 gate cn20 0 reram_1t1r Tf0=3.300000e-09  $ G-=0.296uS w=0.2938
Xrn2_21 row2 gate cn21 0 reram_1t1r Tf0=3.300000e-09  $ G-=0.296uS w=0.0416
Xrn2_22 row2 gate cn22 0 reram_1t1r Tf0=3.300000e-09  $ G-=0.296uS w=0.4650
Xrn2_23 row2 gate cn23 0 reram_1t1r Tf0=4.336278e-09  $ G-=13.052uS w=-0.2814
Xrn2_24 row2 gate cn24 0 reram_1t1r Tf0=4.389215e-09  $ G-=15.821uS w=-0.3425
Xrn2_25 row2 gate cn25 0 reram_1t1r Tf0=3.300000e-09  $ G-=0.296uS w=1.0599
Xrn2_26 row2 gate cn26 0 reram_1t1r Tf0=3.340947e-09  $ G-=0.350uS w=-0.0012
Xrn2_27 row2 gate cn27 0 reram_1t1r Tf0=3.300000e-09  $ G-=0.296uS w=0.8705
Xrn2_28 row2 gate cn28 0 reram_1t1r Tf0=3.300000e-09  $ G-=0.296uS w=0.2385
Xrn2_29 row2 gate cn29 0 reram_1t1r Tf0=3.300000e-09  $ G-=0.296uS w=0.0036
Xrn2_30 row2 gate cn30 0 reram_1t1r Tf0=4.369311e-09  $ G-=14.717uS w=-0.3181
Xrn2_31 row2 gate cn31 0 reram_1t1r Tf0=3.300000e-09  $ G-=0.296uS w=0.7605
Xrn2_32 row2 gate cn32 0 reram_1t1r Tf0=4.672000e-09  $ G-=44.225uS w=-0.9690
Xrn2_33 row2 gate cn33 0 reram_1t1r Tf0=3.300000e-09  $ G-=0.296uS w=0.3445
Xrn2_34 row2 gate cn34 0 reram_1t1r Tf0=4.497347e-09  $ G-=23.439uS w=-0.5105
Xrn2_35 row2 gate cn35 0 reram_1t1r Tf0=3.300000e-09  $ G-=0.296uS w=0.8811
Xrn2_36 row2 gate cn36 0 reram_1t1r Tf0=3.300000e-09  $ G-=0.296uS w=0.3547
Xrn2_37 row2 gate cn37 0 reram_1t1r Tf0=3.300000e-09  $ G-=0.296uS w=0.3033
Xrn2_38 row2 gate cn38 0 reram_1t1r Tf0=3.672796e-09  $ G-=1.170uS w=-0.0193
Xrn2_39 row2 gate cn39 0 reram_1t1r Tf0=4.507778e-09  $ G-=24.345uS w=-0.5305
Xrn2_40 row2 gate cn40 0 reram_1t1r Tf0=4.353584e-09  $ G-=13.899uS w=-0.3001
Xrn2_41 row2 gate cn41 0 reram_1t1r Tf0=3.300000e-09  $ G-=0.296uS w=1.0430
Xrn2_42 row2 gate cn42 0 reram_1t1r Tf0=3.300000e-09  $ G-=0.296uS w=0.4052
Xrn2_43 row2 gate cn43 0 reram_1t1r Tf0=4.399459e-09  $ G-=16.421uS w=-0.3557
Xrn2_44 row2 gate cn44 0 reram_1t1r Tf0=3.300000e-09  $ G-=0.296uS w=0.6663
Xrn2_45 row2 gate cn45 0 reram_1t1r Tf0=4.403447e-09  $ G-=16.661uS w=-0.3610
Xrn2_46 row2 gate cn46 0 reram_1t1r Tf0=3.300000e-09  $ G-=0.296uS w=0.5478
Xrn2_47 row2 gate cn47 0 reram_1t1r Tf0=4.378044e-09  $ G-=15.192uS w=-0.3286
Xrn2_48 row2 gate cn48 0 reram_1t1r Tf0=4.023782e-09  $ G-=4.191uS w=-0.0859
Xrn2_49 row2 gate cn49 0 reram_1t1r Tf0=4.284986e-09  $ G-=10.832uS w=-0.2324
Xrn2_50 row2 gate cn50 0 reram_1t1r Tf0=3.884756e-09  $ G-=2.528uS w=-0.0492
Xrn2_51 row2 gate cn51 0 reram_1t1r Tf0=4.045911e-09  $ G-=4.542uS w=-0.0937
Xrn2_52 row2 gate cn52 0 reram_1t1r Tf0=4.573361e-09  $ G-=30.899uS w=-0.6751
Xrn2_53 row2 gate cn53 0 reram_1t1r Tf0=4.404087e-09  $ G-=16.700uS w=-0.3619
Xrn2_54 row2 gate cn54 0 reram_1t1r Tf0=4.029931e-09  $ G-=4.286uS w=-0.0880
Xrn2_55 row2 gate cn55 0 reram_1t1r Tf0=3.300000e-09  $ G-=0.296uS w=0.1051
Xrn2_56 row2 gate cn56 0 reram_1t1r Tf0=3.300000e-09  $ G-=0.296uS w=0.0026
Xrn2_57 row2 gate cn57 0 reram_1t1r Tf0=3.300000e-09  $ G-=0.296uS w=0.2639
Xrn2_58 row2 gate cn58 0 reram_1t1r Tf0=3.300000e-09  $ G-=0.296uS w=0.1162
Xrn2_59 row2 gate cn59 0 reram_1t1r Tf0=3.300000e-09  $ G-=0.296uS w=0.0775
Xrn2_60 row2 gate cn60 0 reram_1t1r Tf0=3.300000e-09  $ G-=0.296uS w=0.2182
Xrn2_61 row2 gate cn61 0 reram_1t1r Tf0=3.721995e-09  $ G-=1.399uS w=-0.0243
Xrn2_62 row2 gate cn62 0 reram_1t1r Tf0=4.477556e-09  $ G-=21.812uS w=-0.4746
Xrn2_63 row2 gate cn63 0 reram_1t1r Tf0=3.920425e-09  $ G-=2.879uS w=-0.0570
* --- Row 3 ---
Xrn3_0 row3 gate cn0 0 reram_1t1r Tf0=3.884587e-09  $ G-=2.527uS w=-0.0492
Xrn3_1 row3 gate cn1 0 reram_1t1r Tf0=3.300000e-09  $ G-=0.296uS w=0.0100
Xrn3_2 row3 gate cn2 0 reram_1t1r Tf0=3.386968e-09  $ G-=0.414uS w=-0.0026
Xrn3_3 row3 gate cn3 0 reram_1t1r Tf0=4.198357e-09  $ G-=7.906uS w=-0.1679
Xrn3_4 row3 gate cn4 0 reram_1t1r Tf0=3.300000e-09  $ G-=0.296uS w=0.2763
Xrn3_5 row3 gate cn5 0 reram_1t1r Tf0=3.300000e-09  $ G-=0.296uS w=0.0510
Xrn3_6 row3 gate cn6 0 reram_1t1r Tf0=3.300000e-09  $ G-=0.296uS w=0.0146
Xrn3_7 row3 gate cn7 0 reram_1t1r Tf0=3.300000e-09  $ G-=0.296uS w=0.0690
Xrn3_8 row3 gate cn8 0 reram_1t1r Tf0=3.910007e-09  $ G-=2.772uS w=-0.0546
Xrn3_9 row3 gate cn9 0 reram_1t1r Tf0=4.244405e-09  $ G-=9.346uS w=-0.1996
Xrn3_10 row3 gate cn10 0 reram_1t1r Tf0=3.862172e-09  $ G-=2.329uS w=-0.0449
Xrn3_11 row3 gate cn11 0 reram_1t1r Tf0=3.300000e-09  $ G-=0.296uS w=0.2774
Xrn3_12 row3 gate cn12 0 reram_1t1r Tf0=3.300000e-09  $ G-=0.296uS w=0.0487
Xrn3_13 row3 gate cn13 0 reram_1t1r Tf0=4.360804e-09  $ G-=14.269uS w=-0.3082
Xrn3_14 row3 gate cn14 0 reram_1t1r Tf0=4.611054e-09  $ G-=35.437uS w=-0.7752
Xrn3_15 row3 gate cn15 0 reram_1t1r Tf0=4.018132e-09  $ G-=4.106uS w=-0.0840
Xrn3_16 row3 gate cn16 0 reram_1t1r Tf0=4.343169e-09  $ G-=13.383uS w=-0.2887
Xrn3_17 row3 gate cn17 0 reram_1t1r Tf0=4.548112e-09  $ G-=28.189uS w=-0.6153
Xrn3_18 row3 gate cn18 0 reram_1t1r Tf0=3.300000e-09  $ G-=0.296uS w=0.0230
Xrn3_19 row3 gate cn19 0 reram_1t1r Tf0=3.300000e-09  $ G-=0.296uS w=0.0315
Xrn3_20 row3 gate cn20 0 reram_1t1r Tf0=3.935899e-09  $ G-=3.045uS w=-0.0606
Xrn3_21 row3 gate cn21 0 reram_1t1r Tf0=3.300000e-09  $ G-=0.296uS w=0.0167
Xrn3_22 row3 gate cn22 0 reram_1t1r Tf0=3.300000e-09  $ G-=0.296uS w=0.4536
Xrn3_23 row3 gate cn23 0 reram_1t1r Tf0=4.306952e-09  $ G-=11.732uS w=-0.2523
Xrn3_24 row3 gate cn24 0 reram_1t1r Tf0=4.287768e-09  $ G-=10.942uS w=-0.2348
Xrn3_25 row3 gate cn25 0 reram_1t1r Tf0=4.410920e-09  $ G-=17.120uS w=-0.3711
Xrn3_26 row3 gate cn26 0 reram_1t1r Tf0=3.300000e-09  $ G-=0.296uS w=0.7993
Xrn3_27 row3 gate cn27 0 reram_1t1r Tf0=3.934881e-09  $ G-=3.034uS w=-0.0604
Xrn3_28 row3 gate cn28 0 reram_1t1r Tf0=3.300000e-09  $ G-=0.296uS w=0.0148
Xrn3_29 row3 gate cn29 0 reram_1t1r Tf0=4.284905e-09  $ G-=10.828uS w=-0.2323
Xrn3_30 row3 gate cn30 0 reram_1t1r Tf0=3.653864e-09  $ G-=1.092uS w=-0.0176
Xrn3_31 row3 gate cn31 0 reram_1t1r Tf0=4.376115e-09  $ G-=15.085uS w=-0.3262
Xrn3_32 row3 gate cn32 0 reram_1t1r Tf0=4.450645e-09  $ G-=19.780uS w=-0.4298
Xrn3_33 row3 gate cn33 0 reram_1t1r Tf0=3.300000e-09  $ G-=0.296uS w=0.0385
Xrn3_34 row3 gate cn34 0 reram_1t1r Tf0=3.300000e-09  $ G-=0.296uS w=0.0953
Xrn3_35 row3 gate cn35 0 reram_1t1r Tf0=4.335243e-09  $ G-=13.003uS w=-0.2803
Xrn3_36 row3 gate cn36 0 reram_1t1r Tf0=3.300000e-09  $ G-=0.296uS w=0.1567
Xrn3_37 row3 gate cn37 0 reram_1t1r Tf0=3.300000e-09  $ G-=0.296uS w=0.0683
Xrn3_38 row3 gate cn38 0 reram_1t1r Tf0=3.300000e-09  $ G-=0.296uS w=0.2314
Xrn3_39 row3 gate cn39 0 reram_1t1r Tf0=3.300000e-09  $ G-=0.296uS w=0.0559
Xrn3_40 row3 gate cn40 0 reram_1t1r Tf0=4.334278e-09  $ G-=12.957uS w=-0.2793
Xrn3_41 row3 gate cn41 0 reram_1t1r Tf0=3.894336e-09  $ G-=2.618uS w=-0.0512
Xrn3_42 row3 gate cn42 0 reram_1t1r Tf0=4.096019e-09  $ G-=5.450uS w=-0.1137
Xrn3_43 row3 gate cn43 0 reram_1t1r Tf0=3.804513e-09  $ G-=1.889uS w=-0.0351
Xrn3_44 row3 gate cn44 0 reram_1t1r Tf0=4.180893e-09  $ G-=7.419uS w=-0.1571
Xrn3_45 row3 gate cn45 0 reram_1t1r Tf0=4.358707e-09  $ G-=14.160uS w=-0.3058
Xrn3_46 row3 gate cn46 0 reram_1t1r Tf0=3.300000e-09  $ G-=0.296uS w=0.0048
Xrn3_47 row3 gate cn47 0 reram_1t1r Tf0=4.485524e-09  $ G-=22.453uS w=-0.4888
Xrn3_48 row3 gate cn48 0 reram_1t1r Tf0=3.300000e-09  $ G-=0.296uS w=0.2225
Xrn3_49 row3 gate cn49 0 reram_1t1r Tf0=3.300000e-09  $ G-=0.296uS w=0.2769
Xrn3_50 row3 gate cn50 0 reram_1t1r Tf0=3.300000e-09  $ G-=0.296uS w=0.3991
Xrn3_51 row3 gate cn51 0 reram_1t1r Tf0=3.300000e-09  $ G-=0.296uS w=0.0016
Xrn3_52 row3 gate cn52 0 reram_1t1r Tf0=3.837493e-09  $ G-=2.129uS w=-0.0404
Xrn3_53 row3 gate cn53 0 reram_1t1r Tf0=3.300000e-09  $ G-=0.296uS w=0.4673
Xrn3_54 row3 gate cn54 0 reram_1t1r Tf0=3.300000e-09  $ G-=0.296uS w=0.0292
Xrn3_55 row3 gate cn55 0 reram_1t1r Tf0=3.300000e-09  $ G-=0.296uS w=0.2276
Xrn3_56 row3 gate cn56 0 reram_1t1r Tf0=3.300000e-09  $ G-=0.296uS w=0.5701
Xrn3_57 row3 gate cn57 0 reram_1t1r Tf0=3.300000e-09  $ G-=0.296uS w=0.2643
Xrn3_58 row3 gate cn58 0 reram_1t1r Tf0=3.958232e-09  $ G-=3.303uS w=-0.0663
Xrn3_59 row3 gate cn59 0 reram_1t1r Tf0=3.970109e-09  $ G-=3.448uS w=-0.0695
Xrn3_60 row3 gate cn60 0 reram_1t1r Tf0=3.300000e-09  $ G-=0.296uS w=0.4314
Xrn3_61 row3 gate cn61 0 reram_1t1r Tf0=3.300000e-09  $ G-=0.296uS w=0.0002
Xrn3_62 row3 gate cn62 0 reram_1t1r Tf0=3.300000e-09  $ G-=0.296uS w=0.0047
Xrn3_63 row3 gate cn63 0 reram_1t1r Tf0=3.300000e-09  $ G-=0.296uS w=0.0046
* --- Row 4 ---
Xrn4_0 row4 gate cn0 0 reram_1t1r Tf0=3.965835e-09  $ G-=3.395uS w=-0.0684
Xrn4_1 row4 gate cn1 0 reram_1t1r Tf0=3.300000e-09  $ G-=0.296uS w=0.0408
Xrn4_2 row4 gate cn2 0 reram_1t1r Tf0=4.340962e-09  $ G-=13.276uS w=-0.2863
Xrn4_3 row4 gate cn3 0 reram_1t1r Tf0=4.600995e-09  $ G-=34.164uS w=-0.7471
Xrn4_4 row4 gate cn4 0 reram_1t1r Tf0=3.300000e-09  $ G-=0.296uS w=0.6297
Xrn4_5 row4 gate cn5 0 reram_1t1r Tf0=3.300000e-09  $ G-=0.296uS w=0.2439
Xrn4_6 row4 gate cn6 0 reram_1t1r Tf0=4.391947e-09  $ G-=15.979uS w=-0.3460
Xrn4_7 row4 gate cn7 0 reram_1t1r Tf0=4.162366e-09  $ G-=6.936uS w=-0.1465
Xrn4_8 row4 gate cn8 0 reram_1t1r Tf0=3.536318e-09  $ G-=0.713uS w=-0.0092
Xrn4_9 row4 gate cn9 0 reram_1t1r Tf0=3.300000e-09  $ G-=0.296uS w=0.3986
Xrn4_10 row4 gate cn10 0 reram_1t1r Tf0=3.913935e-09  $ G-=2.811uS w=-0.0555
Xrn4_11 row4 gate cn11 0 reram_1t1r Tf0=3.300000e-09  $ G-=0.296uS w=0.1426
Xrn4_12 row4 gate cn12 0 reram_1t1r Tf0=3.816923e-09  $ G-=1.976uS w=-0.0371
Xrn4_13 row4 gate cn13 0 reram_1t1r Tf0=4.466699e-09  $ G-=20.968uS w=-0.4560
Xrn4_14 row4 gate cn14 0 reram_1t1r Tf0=3.300000e-09  $ G-=0.296uS w=0.4348
Xrn4_15 row4 gate cn15 0 reram_1t1r Tf0=3.300000e-09  $ G-=0.296uS w=0.0688
Xrn4_16 row4 gate cn16 0 reram_1t1r Tf0=4.556976e-09  $ G-=29.113uS w=-0.6357
Xrn4_17 row4 gate cn17 0 reram_1t1r Tf0=3.300000e-09  $ G-=0.296uS w=0.1772
Xrn4_18 row4 gate cn18 0 reram_1t1r Tf0=3.592960e-09  $ G-=0.875uS w=-0.0128
Xrn4_19 row4 gate cn19 0 reram_1t1r Tf0=3.300000e-09  $ G-=0.296uS w=0.0520
Xrn4_20 row4 gate cn20 0 reram_1t1r Tf0=3.300000e-09  $ G-=0.296uS w=0.3096
Xrn4_21 row4 gate cn21 0 reram_1t1r Tf0=3.300000e-09  $ G-=0.296uS w=0.7827
Xrn4_22 row4 gate cn22 0 reram_1t1r Tf0=3.300000e-09  $ G-=0.296uS w=0.4548
Xrn4_23 row4 gate cn23 0 reram_1t1r Tf0=3.300000e-09  $ G-=0.296uS w=0.8283
Xrn4_24 row4 gate cn24 0 reram_1t1r Tf0=3.300000e-09  $ G-=0.296uS w=0.3302
Xrn4_25 row4 gate cn25 0 reram_1t1r Tf0=3.300000e-09  $ G-=0.296uS w=0.2451
Xrn4_26 row4 gate cn26 0 reram_1t1r Tf0=3.300000e-09  $ G-=0.296uS w=0.3035
Xrn4_27 row4 gate cn27 0 reram_1t1r Tf0=4.108925e-09  $ G-=5.712uS w=-0.1195
Xrn4_28 row4 gate cn28 0 reram_1t1r Tf0=3.300000e-09  $ G-=0.296uS w=0.0494
Xrn4_29 row4 gate cn29 0 reram_1t1r Tf0=4.245483e-09  $ G-=9.383uS w=-0.2004
Xrn4_30 row4 gate cn30 0 reram_1t1r Tf0=4.337091e-09  $ G-=13.090uS w=-0.2822
Xrn4_31 row4 gate cn31 0 reram_1t1r Tf0=3.712493e-09  $ G-=1.352uS w=-0.0233
Xrn4_32 row4 gate cn32 0 reram_1t1r Tf0=4.361975e-09  $ G-=14.330uS w=-0.3096
Xrn4_33 row4 gate cn33 0 reram_1t1r Tf0=3.300000e-09  $ G-=0.296uS w=0.1368
Xrn4_34 row4 gate cn34 0 reram_1t1r Tf0=4.461799e-09  $ G-=20.598uS w=-0.4478
Xrn4_35 row4 gate cn35 0 reram_1t1r Tf0=4.622888e-09  $ G-=36.994uS w=-0.8095
Xrn4_36 row4 gate cn36 0 reram_1t1r Tf0=3.300000e-09  $ G-=0.296uS w=0.4726
Xrn4_37 row4 gate cn37 0 reram_1t1r Tf0=3.300000e-09  $ G-=0.296uS w=0.0750
Xrn4_38 row4 gate cn38 0 reram_1t1r Tf0=4.325166e-09  $ G-=12.535uS w=-0.2700
Xrn4_39 row4 gate cn39 0 reram_1t1r Tf0=3.300000e-09  $ G-=0.296uS w=0.1415
Xrn4_40 row4 gate cn40 0 reram_1t1r Tf0=4.102799e-09  $ G-=5.586uS w=-0.1167
Xrn4_41 row4 gate cn41 0 reram_1t1r Tf0=4.141226e-09  $ G-=6.423uS w=-0.1352
Xrn4_42 row4 gate cn42 0 reram_1t1r Tf0=4.125231e-09  $ G-=6.060uS w=-0.1272
Xrn4_43 row4 gate cn43 0 reram_1t1r Tf0=4.403848e-09  $ G-=16.686uS w=-0.3615
Xrn4_44 row4 gate cn44 0 reram_1t1r Tf0=4.600157e-09  $ G-=34.060uS w=-0.7448
Xrn4_45 row4 gate cn45 0 reram_1t1r Tf0=3.300000e-09  $ G-=0.296uS w=0.0054
Xrn4_46 row4 gate cn46 0 reram_1t1r Tf0=3.300000e-09  $ G-=0.296uS w=0.4758
Xrn4_47 row4 gate cn47 0 reram_1t1r Tf0=3.300000e-09  $ G-=0.296uS w=0.5370
Xrn4_48 row4 gate cn48 0 reram_1t1r Tf0=3.985529e-09  $ G-=3.647uS w=-0.0739
Xrn4_49 row4 gate cn49 0 reram_1t1r Tf0=3.300000e-09  $ G-=0.296uS w=0.1730
Xrn4_50 row4 gate cn50 0 reram_1t1r Tf0=4.004026e-09  $ G-=3.901uS w=-0.0795
Xrn4_51 row4 gate cn51 0 reram_1t1r Tf0=3.300000e-09  $ G-=0.296uS w=0.0027
Xrn4_52 row4 gate cn52 0 reram_1t1r Tf0=3.300000e-09  $ G-=0.296uS w=0.4277
Xrn4_53 row4 gate cn53 0 reram_1t1r Tf0=3.659591e-09  $ G-=1.115uS w=-0.0181
Xrn4_54 row4 gate cn54 0 reram_1t1r Tf0=3.689998e-09  $ G-=1.246uS w=-0.0209
Xrn4_55 row4 gate cn55 0 reram_1t1r Tf0=4.568286e-09  $ G-=30.334uS w=-0.6626
Xrn4_56 row4 gate cn56 0 reram_1t1r Tf0=4.614682e-09  $ G-=35.907uS w=-0.7855
Xrn4_57 row4 gate cn57 0 reram_1t1r Tf0=3.300000e-09  $ G-=0.296uS w=0.4670
Xrn4_58 row4 gate cn58 0 reram_1t1r Tf0=3.300000e-09  $ G-=0.296uS w=0.0504
Xrn4_59 row4 gate cn59 0 reram_1t1r Tf0=4.519358e-09  $ G-=25.392uS w=-0.5536
Xrn4_60 row4 gate cn60 0 reram_1t1r Tf0=4.343431e-09  $ G-=13.396uS w=-0.2890
Xrn4_61 row4 gate cn61 0 reram_1t1r Tf0=4.338265e-09  $ G-=13.146uS w=-0.2835
Xrn4_62 row4 gate cn62 0 reram_1t1r Tf0=3.300000e-09  $ G-=0.296uS w=0.0322
Xrn4_63 row4 gate cn63 0 reram_1t1r Tf0=4.285030e-09  $ G-=10.833uS w=-0.2324
* --- Row 5 ---
Xrn5_0 row5 gate cn0 0 reram_1t1r Tf0=3.789942e-09  $ G-=1.791uS w=-0.0330
Xrn5_1 row5 gate cn1 0 reram_1t1r Tf0=3.300000e-09  $ G-=0.296uS w=0.3161
Xrn5_2 row5 gate cn2 0 reram_1t1r Tf0=3.300000e-09  $ G-=0.296uS w=0.1624
Xrn5_3 row5 gate cn3 0 reram_1t1r Tf0=4.562915e-09  $ G-=29.748uS w=-0.6497
Xrn5_4 row5 gate cn4 0 reram_1t1r Tf0=3.300000e-09  $ G-=0.296uS w=0.3234
Xrn5_5 row5 gate cn5 0 reram_1t1r Tf0=4.005281e-09  $ G-=3.919uS w=-0.0799
Xrn5_6 row5 gate cn6 0 reram_1t1r Tf0=4.462032e-09  $ G-=20.615uS w=-0.4482
Xrn5_7 row5 gate cn7 0 reram_1t1r Tf0=4.010866e-09  $ G-=3.999uS w=-0.0817
Xrn5_8 row5 gate cn8 0 reram_1t1r Tf0=4.329262e-09  $ G-=12.723uS w=-0.2741
Xrn5_9 row5 gate cn9 0 reram_1t1r Tf0=4.141934e-09  $ G-=6.440uS w=-0.1355
Xrn5_10 row5 gate cn10 0 reram_1t1r Tf0=4.335964e-09  $ G-=13.037uS w=-0.2811
Xrn5_11 row5 gate cn11 0 reram_1t1r Tf0=3.300000e-09  $ G-=0.296uS w=0.1610
Xrn5_12 row5 gate cn12 0 reram_1t1r Tf0=4.090780e-09  $ G-=5.347uS w=-0.1114
Xrn5_13 row5 gate cn13 0 reram_1t1r Tf0=4.592926e-09  $ G-=33.177uS w=-0.7253
Xrn5_14 row5 gate cn14 0 reram_1t1r Tf0=4.567662e-09  $ G-=30.266uS w=-0.6611
Xrn5_15 row5 gate cn15 0 reram_1t1r Tf0=4.431519e-09  $ G-=18.451uS w=-0.4005
Xrn5_16 row5 gate cn16 0 reram_1t1r Tf0=3.300000e-09  $ G-=0.296uS w=0.6487
Xrn5_17 row5 gate cn17 0 reram_1t1r Tf0=3.300000e-09  $ G-=0.296uS w=0.3591
Xrn5_18 row5 gate cn18 0 reram_1t1r Tf0=3.300000e-09  $ G-=0.296uS w=0.0793
Xrn5_19 row5 gate cn19 0 reram_1t1r Tf0=4.383897e-09  $ G-=15.518uS w=-0.3358
Xrn5_20 row5 gate cn20 0 reram_1t1r Tf0=4.172535e-09  $ G-=7.197uS w=-0.1522
Xrn5_21 row5 gate cn21 0 reram_1t1r Tf0=3.300000e-09  $ G-=0.296uS w=0.1436
Xrn5_22 row5 gate cn22 0 reram_1t1r Tf0=3.997725e-09  $ G-=3.812uS w=-0.0776
Xrn5_23 row5 gate cn23 0 reram_1t1r Tf0=3.300000e-09  $ G-=0.296uS w=0.1988
Xrn5_24 row5 gate cn24 0 reram_1t1r Tf0=3.450500e-09  $ G-=0.522uS w=-0.0050
Xrn5_25 row5 gate cn25 0 reram_1t1r Tf0=4.585869e-09  $ G-=32.336uS w=-0.7068
Xrn5_26 row5 gate cn26 0 reram_1t1r Tf0=3.816954e-09  $ G-=1.976uS w=-0.0371
Xrn5_27 row5 gate cn27 0 reram_1t1r Tf0=4.398039e-09  $ G-=16.337uS w=-0.3538
Xrn5_28 row5 gate cn28 0 reram_1t1r Tf0=4.329969e-09  $ G-=12.756uS w=-0.2749
Xrn5_29 row5 gate cn29 0 reram_1t1r Tf0=3.300000e-09  $ G-=0.296uS w=0.7718
Xrn5_30 row5 gate cn30 0 reram_1t1r Tf0=3.300000e-09  $ G-=0.296uS w=0.1249
Xrn5_31 row5 gate cn31 0 reram_1t1r Tf0=3.300000e-09  $ G-=0.296uS w=0.1655
Xrn5_32 row5 gate cn32 0 reram_1t1r Tf0=3.300000e-09  $ G-=0.296uS w=0.0248
Xrn5_33 row5 gate cn33 0 reram_1t1r Tf0=4.541654e-09  $ G-=27.535uS w=-0.6009
Xrn5_34 row5 gate cn34 0 reram_1t1r Tf0=4.524079e-09  $ G-=25.831uS w=-0.5633
Xrn5_35 row5 gate cn35 0 reram_1t1r Tf0=4.127954e-09  $ G-=6.121uS w=-0.1285
Xrn5_36 row5 gate cn36 0 reram_1t1r Tf0=4.597773e-09  $ G-=33.766uS w=-0.7383
Xrn5_37 row5 gate cn37 0 reram_1t1r Tf0=3.300000e-09  $ G-=0.296uS w=0.1056
Xrn5_38 row5 gate cn38 0 reram_1t1r Tf0=3.300000e-09  $ G-=0.296uS w=0.3721
Xrn5_39 row5 gate cn39 0 reram_1t1r Tf0=3.300000e-09  $ G-=0.296uS w=0.1967
Xrn5_40 row5 gate cn40 0 reram_1t1r Tf0=4.373731e-09  $ G-=14.955uS w=-0.3234
Xrn5_41 row5 gate cn41 0 reram_1t1r Tf0=4.163382e-09  $ G-=6.962uS w=-0.1470
Xrn5_42 row5 gate cn42 0 reram_1t1r Tf0=3.300000e-09  $ G-=0.296uS w=0.0496
Xrn5_43 row5 gate cn43 0 reram_1t1r Tf0=4.300683e-09  $ G-=11.468uS w=-0.2464
Xrn5_44 row5 gate cn44 0 reram_1t1r Tf0=3.300000e-09  $ G-=0.296uS w=0.0843
Xrn5_45 row5 gate cn45 0 reram_1t1r Tf0=4.220235e-09  $ G-=8.560uS w=-0.1823
Xrn5_46 row5 gate cn46 0 reram_1t1r Tf0=3.300000e-09  $ G-=0.296uS w=0.2526
Xrn5_47 row5 gate cn47 0 reram_1t1r Tf0=3.719994e-09  $ G-=1.389uS w=-0.0241
Xrn5_48 row5 gate cn48 0 reram_1t1r Tf0=4.008916e-09  $ G-=3.971uS w=-0.0811
Xrn5_49 row5 gate cn49 0 reram_1t1r Tf0=4.498644e-09  $ G-=23.550uS w=-0.5130
Xrn5_50 row5 gate cn50 0 reram_1t1r Tf0=4.507841e-09  $ G-=24.351uS w=-0.5306
Xrn5_51 row5 gate cn51 0 reram_1t1r Tf0=4.514490e-09  $ G-=24.946uS w=-0.5438
Xrn5_52 row5 gate cn52 0 reram_1t1r Tf0=3.300000e-09  $ G-=0.296uS w=0.0238
Xrn5_53 row5 gate cn53 0 reram_1t1r Tf0=3.300000e-09  $ G-=0.296uS w=0.0354
Xrn5_54 row5 gate cn54 0 reram_1t1r Tf0=4.429804e-09  $ G-=18.336uS w=-0.3980
Xrn5_55 row5 gate cn55 0 reram_1t1r Tf0=3.828844e-09  $ G-=2.063uS w=-0.0390
Xrn5_56 row5 gate cn56 0 reram_1t1r Tf0=3.300000e-09  $ G-=0.296uS w=0.6093
Xrn5_57 row5 gate cn57 0 reram_1t1r Tf0=4.263341e-09  $ G-=10.012uS w=-0.2143
Xrn5_58 row5 gate cn58 0 reram_1t1r Tf0=3.300000e-09  $ G-=0.296uS w=0.5891
Xrn5_59 row5 gate cn59 0 reram_1t1r Tf0=4.606704e-09  $ G-=34.881uS w=-0.7629
Xrn5_60 row5 gate cn60 0 reram_1t1r Tf0=4.447873e-09  $ G-=19.581uS w=-0.4254
Xrn5_61 row5 gate cn61 0 reram_1t1r Tf0=3.300000e-09  $ G-=0.296uS w=0.4128
Xrn5_62 row5 gate cn62 0 reram_1t1r Tf0=4.239167e-09  $ G-=9.170uS w=-0.1957
Xrn5_63 row5 gate cn63 0 reram_1t1r Tf0=3.300000e-09  $ G-=0.296uS w=0.5448
* --- Row 6 ---
Xrn6_0 row6 gate cn0 0 reram_1t1r Tf0=3.300000e-09  $ G-=0.296uS w=0.1553
Xrn6_1 row6 gate cn1 0 reram_1t1r Tf0=3.300000e-09  $ G-=0.296uS w=0.1155
Xrn6_2 row6 gate cn2 0 reram_1t1r Tf0=3.300000e-09  $ G-=0.296uS w=0.0381
Xrn6_3 row6 gate cn3 0 reram_1t1r Tf0=4.542408e-09  $ G-=27.611uS w=-0.6025
Xrn6_4 row6 gate cn4 0 reram_1t1r Tf0=3.300000e-09  $ G-=0.296uS w=0.5116
Xrn6_5 row6 gate cn5 0 reram_1t1r Tf0=3.300000e-09  $ G-=0.296uS w=0.3252
Xrn6_6 row6 gate cn6 0 reram_1t1r Tf0=3.300000e-09  $ G-=0.296uS w=1.0858
Xrn6_7 row6 gate cn7 0 reram_1t1r Tf0=4.192956e-09  $ G-=7.752uS w=-0.1645
Xrn6_8 row6 gate cn8 0 reram_1t1r Tf0=3.780314e-09  $ G-=1.730uS w=-0.0316
Xrn6_9 row6 gate cn9 0 reram_1t1r Tf0=3.300000e-09  $ G-=0.296uS w=0.3432
Xrn6_10 row6 gate cn10 0 reram_1t1r Tf0=4.021778e-09  $ G-=4.161uS w=-0.0853
Xrn6_11 row6 gate cn11 0 reram_1t1r Tf0=3.300000e-09  $ G-=0.296uS w=0.2214
Xrn6_12 row6 gate cn12 0 reram_1t1r Tf0=3.685159e-09  $ G-=1.224uS w=-0.0205
Xrn6_13 row6 gate cn13 0 reram_1t1r Tf0=4.427883e-09  $ G-=18.209uS w=-0.3951
Xrn6_14 row6 gate cn14 0 reram_1t1r Tf0=4.100573e-09  $ G-=5.541uS w=-0.1157
Xrn6_15 row6 gate cn15 0 reram_1t1r Tf0=3.300000e-09  $ G-=0.296uS w=0.6353
Xrn6_16 row6 gate cn16 0 reram_1t1r Tf0=3.300000e-09  $ G-=0.296uS w=0.2029
Xrn6_17 row6 gate cn17 0 reram_1t1r Tf0=3.300000e-09  $ G-=0.296uS w=0.1342
Xrn6_18 row6 gate cn18 0 reram_1t1r Tf0=3.300000e-09  $ G-=0.296uS w=0.0357
Xrn6_19 row6 gate cn19 0 reram_1t1r Tf0=3.300000e-09  $ G-=0.296uS w=0.3228
Xrn6_20 row6 gate cn20 0 reram_1t1r Tf0=3.942579e-09  $ G-=3.120uS w=-0.0623
Xrn6_21 row6 gate cn21 0 reram_1t1r Tf0=3.300000e-09  $ G-=0.296uS w=1.0473
Xrn6_22 row6 gate cn22 0 reram_1t1r Tf0=3.300000e-09  $ G-=0.296uS w=0.0901
Xrn6_23 row6 gate cn23 0 reram_1t1r Tf0=4.589691e-09  $ G-=32.789uS w=-0.7168
Xrn6_24 row6 gate cn24 0 reram_1t1r Tf0=3.300000e-09  $ G-=0.296uS w=0.7400
Xrn6_25 row6 gate cn25 0 reram_1t1r Tf0=4.597074e-09  $ G-=33.681uS w=-0.7364
Xrn6_26 row6 gate cn26 0 reram_1t1r Tf0=4.407629e-09  $ G-=16.916uS w=-0.3666
Xrn6_27 row6 gate cn27 0 reram_1t1r Tf0=4.461539e-09  $ G-=20.579uS w=-0.4474
Xrn6_28 row6 gate cn28 0 reram_1t1r Tf0=3.300000e-09  $ G-=0.296uS w=0.3441
Xrn6_29 row6 gate cn29 0 reram_1t1r Tf0=3.300000e-09  $ G-=0.296uS w=0.0950
Xrn6_30 row6 gate cn30 0 reram_1t1r Tf0=4.562798e-09  $ G-=29.735uS w=-0.6494
Xrn6_31 row6 gate cn31 0 reram_1t1r Tf0=3.300000e-09  $ G-=0.296uS w=0.1704
Xrn6_32 row6 gate cn32 0 reram_1t1r Tf0=4.233270e-09  $ G-=8.975uS w=-0.1915
Xrn6_33 row6 gate cn33 0 reram_1t1r Tf0=4.402160e-09  $ G-=16.583uS w=-0.3593
Xrn6_34 row6 gate cn34 0 reram_1t1r Tf0=3.768461e-09  $ G-=1.657uS w=-0.0300
Xrn6_35 row6 gate cn35 0 reram_1t1r Tf0=4.144086e-09  $ G-=6.490uS w=-0.1366
Xrn6_36 row6 gate cn36 0 reram_1t1r Tf0=3.300000e-09  $ G-=0.296uS w=0.3170
Xrn6_37 row6 gate cn37 0 reram_1t1r Tf0=3.300000e-09  $ G-=0.296uS w=0.5095
Xrn6_38 row6 gate cn38 0 reram_1t1r Tf0=4.449718e-09  $ G-=19.713uS w=-0.4283
Xrn6_39 row6 gate cn39 0 reram_1t1r Tf0=3.300000e-09  $ G-=0.296uS w=0.1046
Xrn6_40 row6 gate cn40 0 reram_1t1r Tf0=4.209671e-09  $ G-=8.238uS w=-0.1752
Xrn6_41 row6 gate cn41 0 reram_1t1r Tf0=4.091318e-09  $ G-=5.357uS w=-0.1117
Xrn6_42 row6 gate cn42 0 reram_1t1r Tf0=3.300000e-09  $ G-=0.296uS w=0.1363
Xrn6_43 row6 gate cn43 0 reram_1t1r Tf0=4.209910e-09  $ G-=8.245uS w=-0.1753
Xrn6_44 row6 gate cn44 0 reram_1t1r Tf0=4.229252e-09  $ G-=8.845uS w=-0.1886
Xrn6_45 row6 gate cn45 0 reram_1t1r Tf0=4.527759e-09  $ G-=26.179uS w=-0.5710
Xrn6_46 row6 gate cn46 0 reram_1t1r Tf0=4.402429e-09  $ G-=16.600uS w=-0.3596
Xrn6_47 row6 gate cn47 0 reram_1t1r Tf0=3.300000e-09  $ G-=0.296uS w=0.5558
Xrn6_48 row6 gate cn48 0 reram_1t1r Tf0=3.300000e-09  $ G-=0.296uS w=0.0812
Xrn6_49 row6 gate cn49 0 reram_1t1r Tf0=4.045437e-09  $ G-=4.534uS w=-0.0935
Xrn6_50 row6 gate cn50 0 reram_1t1r Tf0=4.360181e-09  $ G-=14.237uS w=-0.3075
Xrn6_51 row6 gate cn51 0 reram_1t1r Tf0=3.978976e-09  $ G-=3.561uS w=-0.0720
Xrn6_52 row6 gate cn52 0 reram_1t1r Tf0=4.316794e-09  $ G-=12.159uS w=-0.2617
Xrn6_53 row6 gate cn53 0 reram_1t1r Tf0=3.954751e-09  $ G-=3.261uS w=-0.0654
Xrn6_54 row6 gate cn54 0 reram_1t1r Tf0=3.300000e-09  $ G-=0.296uS w=0.1177
Xrn6_55 row6 gate cn55 0 reram_1t1r Tf0=4.626409e-09  $ G-=37.471uS w=-0.8200
Xrn6_56 row6 gate cn56 0 reram_1t1r Tf0=3.300000e-09  $ G-=0.296uS w=0.2081
Xrn6_57 row6 gate cn57 0 reram_1t1r Tf0=3.300000e-09  $ G-=0.296uS w=0.1411
Xrn6_58 row6 gate cn58 0 reram_1t1r Tf0=3.300000e-09  $ G-=0.296uS w=0.1227
Xrn6_59 row6 gate cn59 0 reram_1t1r Tf0=4.463190e-09  $ G-=20.702uS w=-0.4501
Xrn6_60 row6 gate cn60 0 reram_1t1r Tf0=3.926892e-09  $ G-=2.947uS w=-0.0585
Xrn6_61 row6 gate cn61 0 reram_1t1r Tf0=4.380145e-09  $ G-=15.308uS w=-0.3312
Xrn6_62 row6 gate cn62 0 reram_1t1r Tf0=3.300000e-09  $ G-=0.296uS w=0.0066
Xrn6_63 row6 gate cn63 0 reram_1t1r Tf0=3.635531e-09  $ G-=1.022uS w=-0.0160
* --- Row 7 ---
Xrn7_0 row7 gate cn0 0 reram_1t1r Tf0=3.300000e-09  $ G-=0.296uS w=0.2725
Xrn7_1 row7 gate cn1 0 reram_1t1r Tf0=4.147781e-09  $ G-=6.578uS w=-0.1386
Xrn7_2 row7 gate cn2 0 reram_1t1r Tf0=3.300000e-09  $ G-=0.296uS w=0.4561
Xrn7_3 row7 gate cn3 0 reram_1t1r Tf0=3.652587e-09  $ G-=1.087uS w=-0.0175
Xrn7_4 row7 gate cn4 0 reram_1t1r Tf0=4.056220e-09  $ G-=4.716uS w=-0.0975
Xrn7_5 row7 gate cn5 0 reram_1t1r Tf0=3.300000e-09  $ G-=0.296uS w=0.2536
Xrn7_6 row7 gate cn6 0 reram_1t1r Tf0=3.300000e-09  $ G-=0.296uS w=0.3165
Xrn7_7 row7 gate cn7 0 reram_1t1r Tf0=3.300000e-09  $ G-=0.296uS w=0.3303
Xrn7_8 row7 gate cn8 0 reram_1t1r Tf0=4.167578e-09  $ G-=7.069uS w=-0.1494
Xrn7_9 row7 gate cn9 0 reram_1t1r Tf0=3.300000e-09  $ G-=0.296uS w=0.3271
Xrn7_10 row7 gate cn10 0 reram_1t1r Tf0=4.154749e-09  $ G-=6.747uS w=-0.1423
Xrn7_11 row7 gate cn11 0 reram_1t1r Tf0=4.300988e-09  $ G-=11.480uS w=-0.2467
Xrn7_12 row7 gate cn12 0 reram_1t1r Tf0=4.117198e-09  $ G-=5.886uS w=-0.1233
Xrn7_13 row7 gate cn13 0 reram_1t1r Tf0=3.300000e-09  $ G-=0.296uS w=0.0609
Xrn7_14 row7 gate cn14 0 reram_1t1r Tf0=3.300000e-09  $ G-=0.296uS w=0.6048
Xrn7_15 row7 gate cn15 0 reram_1t1r Tf0=3.300000e-09  $ G-=0.296uS w=0.4611
Xrn7_16 row7 gate cn16 0 reram_1t1r Tf0=3.300000e-09  $ G-=0.296uS w=0.1857
Xrn7_17 row7 gate cn17 0 reram_1t1r Tf0=4.297850e-09  $ G-=11.350uS w=-0.2438
Xrn7_18 row7 gate cn18 0 reram_1t1r Tf0=3.663072e-09  $ G-=1.130uS w=-0.0184
Xrn7_19 row7 gate cn19 0 reram_1t1r Tf0=4.220369e-09  $ G-=8.564uS w=-0.1824
Xrn7_20 row7 gate cn20 0 reram_1t1r Tf0=4.254332e-09  $ G-=9.690uS w=-0.2072
Xrn7_21 row7 gate cn21 0 reram_1t1r Tf0=3.300000e-09  $ G-=0.296uS w=0.7465
Xrn7_22 row7 gate cn22 0 reram_1t1r Tf0=4.478912e-09  $ G-=21.920uS w=-0.4770
Xrn7_23 row7 gate cn23 0 reram_1t1r Tf0=3.300000e-09  $ G-=0.296uS w=0.5157
Xrn7_24 row7 gate cn24 0 reram_1t1r Tf0=4.568081e-09  $ G-=30.312uS w=-0.6621
Xrn7_25 row7 gate cn25 0 reram_1t1r Tf0=3.300000e-09  $ G-=0.296uS w=0.2153
Xrn7_26 row7 gate cn26 0 reram_1t1r Tf0=3.300000e-09  $ G-=0.296uS w=0.7463
Xrn7_27 row7 gate cn27 0 reram_1t1r Tf0=3.300000e-09  $ G-=0.296uS w=1.1574
Xrn7_28 row7 gate cn28 0 reram_1t1r Tf0=4.239290e-09  $ G-=9.174uS w=-0.1958
Xrn7_29 row7 gate cn29 0 reram_1t1r Tf0=4.388604e-09  $ G-=15.786uS w=-0.3417
Xrn7_30 row7 gate cn30 0 reram_1t1r Tf0=3.300000e-09  $ G-=0.296uS w=0.8386
Xrn7_31 row7 gate cn31 0 reram_1t1r Tf0=4.091019e-09  $ G-=5.352uS w=-0.1115
Xrn7_32 row7 gate cn32 0 reram_1t1r Tf0=3.300000e-09  $ G-=0.296uS w=0.4208
Xrn7_33 row7 gate cn33 0 reram_1t1r Tf0=3.300000e-09  $ G-=0.296uS w=0.7603
Xrn7_34 row7 gate cn34 0 reram_1t1r Tf0=4.135869e-09  $ G-=6.299uS w=-0.1324
Xrn7_35 row7 gate cn35 0 reram_1t1r Tf0=3.300000e-09  $ G-=0.296uS w=0.3289
Xrn7_36 row7 gate cn36 0 reram_1t1r Tf0=4.007079e-09  $ G-=3.944uS w=-0.0805
Xrn7_37 row7 gate cn37 0 reram_1t1r Tf0=3.300000e-09  $ G-=0.296uS w=0.3811
Xrn7_38 row7 gate cn38 0 reram_1t1r Tf0=4.179422e-09  $ G-=7.380uS w=-0.1563
Xrn7_39 row7 gate cn39 0 reram_1t1r Tf0=3.894981e-09  $ G-=2.624uS w=-0.0514
Xrn7_40 row7 gate cn40 0 reram_1t1r Tf0=3.300000e-09  $ G-=0.296uS w=0.0043
Xrn7_41 row7 gate cn41 0 reram_1t1r Tf0=3.300000e-09  $ G-=0.296uS w=0.0311
Xrn7_42 row7 gate cn42 0 reram_1t1r Tf0=3.300000e-09  $ G-=0.296uS w=0.1858
Xrn7_43 row7 gate cn43 0 reram_1t1r Tf0=3.300000e-09  $ G-=0.296uS w=0.2831
Xrn7_44 row7 gate cn44 0 reram_1t1r Tf0=3.358239e-09  $ G-=0.373uS w=-0.0017
Xrn7_45 row7 gate cn45 0 reram_1t1r Tf0=4.075847e-09  $ G-=5.064uS w=-0.1052
Xrn7_46 row7 gate cn46 0 reram_1t1r Tf0=3.300000e-09  $ G-=0.296uS w=0.1078
Xrn7_47 row7 gate cn47 0 reram_1t1r Tf0=4.105403e-09  $ G-=5.639uS w=-0.1179
Xrn7_48 row7 gate cn48 0 reram_1t1r Tf0=3.300000e-09  $ G-=0.296uS w=0.2862
Xrn7_49 row7 gate cn49 0 reram_1t1r Tf0=4.416382e-09  $ G-=17.463uS w=-0.3787
Xrn7_50 row7 gate cn50 0 reram_1t1r Tf0=3.300000e-09  $ G-=0.296uS w=0.0710
Xrn7_51 row7 gate cn51 0 reram_1t1r Tf0=3.300000e-09  $ G-=0.296uS w=1.3123
Xrn7_52 row7 gate cn52 0 reram_1t1r Tf0=3.300000e-09  $ G-=0.296uS w=0.2321
Xrn7_53 row7 gate cn53 0 reram_1t1r Tf0=4.087456e-09  $ G-=5.283uS w=-0.1100
Xrn7_54 row7 gate cn54 0 reram_1t1r Tf0=3.942908e-09  $ G-=3.124uS w=-0.0624
Xrn7_55 row7 gate cn55 0 reram_1t1r Tf0=3.300000e-09  $ G-=0.296uS w=0.7571
Xrn7_56 row7 gate cn56 0 reram_1t1r Tf0=4.365551e-09  $ G-=14.517uS w=-0.3137
Xrn7_57 row7 gate cn57 0 reram_1t1r Tf0=4.420327e-09  $ G-=17.716uS w=-0.3843
Xrn7_58 row7 gate cn58 0 reram_1t1r Tf0=3.300000e-09  $ G-=0.296uS w=0.0338
Xrn7_59 row7 gate cn59 0 reram_1t1r Tf0=3.300000e-09  $ G-=0.296uS w=0.0753
Xrn7_60 row7 gate cn60 0 reram_1t1r Tf0=3.300000e-09  $ G-=0.296uS w=0.7538
Xrn7_61 row7 gate cn61 0 reram_1t1r Tf0=3.300000e-09  $ G-=0.296uS w=0.3725
Xrn7_62 row7 gate cn62 0 reram_1t1r Tf0=3.524980e-09  $ G-=0.684uS w=-0.0086
Xrn7_63 row7 gate cn63 0 reram_1t1r Tf0=3.300000e-09  $ G-=0.296uS w=0.3284

.op

.control
run
print i(Vsp0) i(Vsn0)
print i(Vsp1) i(Vsn1)
print i(Vsp2) i(Vsn2)
print i(Vsp3) i(Vsn3)
print i(Vsp4) i(Vsn4)
print i(Vsp5) i(Vsn5)
print i(Vsp6) i(Vsn6)
print i(Vsp7) i(Vsn7)
print i(Vsp8) i(Vsn8)
print i(Vsp9) i(Vsn9)
print i(Vsp10) i(Vsn10)
print i(Vsp11) i(Vsn11)
print i(Vsp12) i(Vsn12)
print i(Vsp13) i(Vsn13)
print i(Vsp14) i(Vsn14)
print i(Vsp15) i(Vsn15)
print i(Vsp16) i(Vsn16)
print i(Vsp17) i(Vsn17)
print i(Vsp18) i(Vsn18)
print i(Vsp19) i(Vsn19)
print i(Vsp20) i(Vsn20)
print i(Vsp21) i(Vsn21)
print i(Vsp22) i(Vsn22)
print i(Vsp23) i(Vsn23)
print i(Vsp24) i(Vsn24)
print i(Vsp25) i(Vsn25)
print i(Vsp26) i(Vsn26)
print i(Vsp27) i(Vsn27)
print i(Vsp28) i(Vsn28)
print i(Vsp29) i(Vsn29)
print i(Vsp30) i(Vsn30)
print i(Vsp31) i(Vsn31)
print i(Vsp32) i(Vsn32)
print i(Vsp33) i(Vsn33)
print i(Vsp34) i(Vsn34)
print i(Vsp35) i(Vsn35)
print i(Vsp36) i(Vsn36)
print i(Vsp37) i(Vsn37)
print i(Vsp38) i(Vsn38)
print i(Vsp39) i(Vsn39)
print i(Vsp40) i(Vsn40)
print i(Vsp41) i(Vsn41)
print i(Vsp42) i(Vsn42)
print i(Vsp43) i(Vsn43)
print i(Vsp44) i(Vsn44)
print i(Vsp45) i(Vsn45)
print i(Vsp46) i(Vsn46)
print i(Vsp47) i(Vsn47)
print i(Vsp48) i(Vsn48)
print i(Vsp49) i(Vsn49)
print i(Vsp50) i(Vsn50)
print i(Vsp51) i(Vsn51)
print i(Vsp52) i(Vsn52)
print i(Vsp53) i(Vsn53)
print i(Vsp54) i(Vsn54)
print i(Vsp55) i(Vsn55)
print i(Vsp56) i(Vsn56)
print i(Vsp57) i(Vsn57)
print i(Vsp58) i(Vsn58)
print i(Vsp59) i(Vsn59)
print i(Vsp60) i(Vsn60)
print i(Vsp61) i(Vsn61)
print i(Vsp62) i(Vsn62)
print i(Vsp63) i(Vsn63)
quit
.endc

.end
