* =================================================================
* TOP-LEVEL: Complete Analog ECG Classifier
* Architecture: 8 -> 64 -> 5 MLP on ReRAM Crossbar
* Technology: SKY130 (NFET/PFET 01v8 + ReRAM)
* =================================================================
*
* Signal path (fully analog):
*   feat0..feat7 (8 raw feature voltages)
*     -> Input Conditioning (analog normalization: gain + offset)
*     -> row0..row7 (normalized voltages, scaled to V_READ domain)
*     -> L1 Crossbar (8x64 differential 1T1R ReRAM)
*     -> 64 differential column currents
*     -> L1 Interstage (64 channels):
*         - Current-mirror bias injection (PMOS/NMOS per channel)
*         - NMOS current-mirror ReLU (diode clamp)
*         - Output PMOS mirror -> voltage for L2 rows
*     -> L2 Crossbar (64x5 differential 1T1R ReRAM)
*     -> 5 differential column currents
*     -> L2 Bias injection (5 current mirrors)
*     -> Lazzaro WTA (5-input analog argmax)
*     -> out0..out4 (one-hot voltage output)
*
* L1 scale: 1.3705e+05,  L2 scale: 1.9785e+05
* V_READ: 0.15V,  VDD: 1.8V
* L1 cells: 1024 1T1R,  L2 cells: 640 1T1R
* =================================================================

.include "C:/src/skywater-pdk-libs-sky130_fd_pr/cells/nfet_01v8/sky130_fd_pr__nfet_01v8__tt.corner.spice"
.include "C:/src/skywater-pdk-libs-sky130_fd_pr/cells/nfet_01v8/sky130_fd_pr__nfet_01v8__mismatch.corner.spice"
.include "C:/src/skywater-pdk-libs-sky130_fd_pr/cells/pfet_01v8/sky130_fd_pr__pfet_01v8__tt.corner.spice"
.include "C:/src/skywater-pdk-libs-sky130_fd_pr/cells/pfet_01v8/sky130_fd_pr__pfet_01v8__mismatch.corner.spice"
.param sky130_fd_pr__pfet_01v8__a0_diff = 0
.param sky130_fd_pr__pfet_01v8__agidl_diff = 0
.param sky130_fd_pr__pfet_01v8__ags_diff = 0
.param sky130_fd_pr__pfet_01v8__b0_diff = 0
.param sky130_fd_pr__pfet_01v8__b1_diff = 0
.param sky130_fd_pr__pfet_01v8__bgidl_diff = 0
.param sky130_fd_pr__pfet_01v8__cgidl_diff = 0
.param sky130_fd_pr__pfet_01v8__dlc_diff = 0
.param sky130_fd_pr__pfet_01v8__dwc_diff = 0
.param sky130_fd_pr__pfet_01v8__eta0_diff = 0
.param sky130_fd_pr__pfet_01v8__k2_diff = 0
.param sky130_fd_pr__pfet_01v8__keta_diff = 0
.param sky130_fd_pr__pfet_01v8__kt1_diff = 0
.param sky130_fd_pr__pfet_01v8__ku0_diff = 0
.param sky130_fd_pr__pfet_01v8__kvsat_diff = 0
.param sky130_fd_pr__pfet_01v8__kvth0_diff = 0
.param sky130_fd_pr__pfet_01v8__lint_diff = 0
.param sky130_fd_pr__pfet_01v8__lku0_diff = 0
.param sky130_fd_pr__pfet_01v8__lkvth0_diff = 0
.param sky130_fd_pr__pfet_01v8__nfactor_diff = 0
.param sky130_fd_pr__pfet_01v8__pclm_diff = 0
.param sky130_fd_pr__pfet_01v8__pdits_diff = 0
.param sky130_fd_pr__pfet_01v8__pditsd_diff = 0
.param sky130_fd_pr__pfet_01v8__rdsw_diff = 0
.param sky130_fd_pr__pfet_01v8__tvoff_diff = 0
.param sky130_fd_pr__pfet_01v8__u0_diff = 0
.param sky130_fd_pr__pfet_01v8__ua_diff = 0
.param sky130_fd_pr__pfet_01v8__ub_diff = 0
.param sky130_fd_pr__pfet_01v8__voff_diff = 0
.param sky130_fd_pr__pfet_01v8__vsat_diff = 0
.param sky130_fd_pr__pfet_01v8__vth0_diff = 0
.param sky130_fd_pr__pfet_01v8__wint_diff = 0
.param sky130_fd_pr__pfet_01v8__wku0_diff = 0
.param sky130_fd_pr__pfet_01v8__wkvth0_diff = 0
.param sky130_fd_pr__pfet_01v8__wlod_diff = 0

* --- Supply ---
VDD vdd 0 1.8

* --- Feature inputs (8 raw ECG feature voltages) ---
Vfeat0 feat0 0 0.0
Vfeat1 feat1 0 0.0
Vfeat2 feat2 0 0.0
Vfeat3 feat3 0 0.0
Vfeat4 feat4 0 0.0
Vfeat5 feat5 0 0.0
Vfeat6 feat6 0 0.0
Vfeat7 feat7 0 0.0

* ===== INPUT CONDITIONING (8 channels) =====
* Offset-binary normalization: maps normalized features to [0, V_READ]
* x_norm = (V_feat - mean) / scale; V_row = (x_norm + 4.0) * V_READ / 8.0
* Constant offset current absorbed into bias mirrors
* ASIC: differential amplifier with resistive feedback per channel

* --- Feature 0: mean=0.000000, scale=1.000000 ---
* gain=1.87500014e-02 V/V, V_row = gain*V_feat + 7.49999949e-02
Econd0 row0 0 vol='v(feat0)*1.87500014e-02 + 7.49999949e-02'

* --- Feature 1: mean=0.000000, scale=1.000000 ---
* gain=1.87500009e-02 V/V, V_row = gain*V_feat + 7.50000000e-02
Econd1 row1 0 vol='v(feat1)*1.87500009e-02 + 7.50000000e-02'

* --- Feature 2: mean=0.000000, scale=1.000000 ---
* gain=1.87500001e-02 V/V, V_row = gain*V_feat + 7.49999973e-02
Econd2 row2 0 vol='v(feat2)*1.87500001e-02 + 7.49999973e-02'

* --- Feature 3: mean=-0.000000, scale=0.999997 ---
* gain=1.87500522e-02 V/V, V_row = gain*V_feat + 7.50000005e-02
Econd3 row3 0 vol='v(feat3)*1.87500522e-02 + 7.50000005e-02'

* --- Feature 4: mean=-0.000000, scale=1.000000 ---
* gain=1.87499992e-02 V/V, V_row = gain*V_feat + 7.50000042e-02
Econd4 row4 0 vol='v(feat4)*1.87499992e-02 + 7.50000042e-02'

* --- Feature 5: mean=-0.000000, scale=1.000000 ---
* gain=1.87500024e-02 V/V, V_row = gain*V_feat + 7.50000009e-02
Econd5 row5 0 vol='v(feat5)*1.87500024e-02 + 7.50000009e-02'

* --- Feature 6: mean=-0.000000, scale=1.000000 ---
* gain=1.87500013e-02 V/V, V_row = gain*V_feat + 7.50000008e-02
Econd6 row6 0 vol='v(feat6)*1.87500013e-02 + 7.50000008e-02'

* --- Feature 7: mean=0.000000, scale=1.000000 ---
* gain=1.87500009e-02 V/V, V_row = gain*V_feat + 7.49999995e-02
Econd7 row7 0 vol='v(feat7)*1.87500009e-02 + 7.49999995e-02'

* ===== LAYER 1: 8x64 DIFFERENTIAL 1T1R ReRAM CROSSBAR =====
Vgate_l1 gate_l1 0 1.8

* --- Positive conductance array ---
XTpl1_0_0 row0 gate_l1 mpl1_0_0 0 sky130_fd_pr__nfet_01v8 W=1.0u L=0.15u
Rrpl1_0_0 mpl1_0_0 cpl1_0 54753.9180
XTpl1_0_1 row0 gate_l1 mpl1_0_1 0 sky130_fd_pr__nfet_01v8 W=1.0u L=0.15u
Rrpl1_0_1 mpl1_0_1 cpl1_1 3378378.2500
XTpl1_0_2 row0 gate_l1 mpl1_0_2 0 sky130_fd_pr__nfet_01v8 W=1.0u L=0.15u
Rrpl1_0_2 mpl1_0_2 cpl1_2 3378378.2500
XTpl1_0_3 row0 gate_l1 mpl1_0_3 0 sky130_fd_pr__nfet_01v8 W=1.0u L=0.15u
Rrpl1_0_3 mpl1_0_3 cpl1_3 3378378.2500
XTpl1_0_4 row0 gate_l1 mpl1_0_4 0 sky130_fd_pr__nfet_01v8 W=1.0u L=0.15u
Rrpl1_0_4 mpl1_0_4 cpl1_4 69037.8125
XTpl1_0_5 row0 gate_l1 mpl1_0_5 0 sky130_fd_pr__nfet_01v8 W=1.0u L=0.15u
Rrpl1_0_5 mpl1_0_5 cpl1_5 254810.7344
XTpl1_0_6 row0 gate_l1 mpl1_0_6 0 sky130_fd_pr__nfet_01v8 W=1.0u L=0.15u
Rrpl1_0_6 mpl1_0_6 cpl1_6 3378378.2500
XTpl1_0_7 row0 gate_l1 mpl1_0_7 0 sky130_fd_pr__nfet_01v8 W=1.0u L=0.15u
Rrpl1_0_7 mpl1_0_7 cpl1_7 3378378.2500
XTpl1_0_8 row0 gate_l1 mpl1_0_8 0 sky130_fd_pr__nfet_01v8 W=1.0u L=0.15u
Rrpl1_0_8 mpl1_0_8 cpl1_8 46049.4102
XTpl1_0_9 row0 gate_l1 mpl1_0_9 0 sky130_fd_pr__nfet_01v8 W=1.0u L=0.15u
Rrpl1_0_9 mpl1_0_9 cpl1_9 193673.0000
XTpl1_0_10 row0 gate_l1 mpl1_0_10 0 sky130_fd_pr__nfet_01v8 W=1.0u L=0.15u
Rrpl1_0_10 mpl1_0_10 cpl1_10 85784.4688
XTpl1_0_11 row0 gate_l1 mpl1_0_11 0 sky130_fd_pr__nfet_01v8 W=1.0u L=0.15u
Rrpl1_0_11 mpl1_0_11 cpl1_11 83855.5469
XTpl1_0_12 row0 gate_l1 mpl1_0_12 0 sky130_fd_pr__nfet_01v8 W=1.0u L=0.15u
Rrpl1_0_12 mpl1_0_12 cpl1_12 3378378.2500
XTpl1_0_13 row0 gate_l1 mpl1_0_13 0 sky130_fd_pr__nfet_01v8 W=1.0u L=0.15u
Rrpl1_0_13 mpl1_0_13 cpl1_13 3378378.2500
XTpl1_0_14 row0 gate_l1 mpl1_0_14 0 sky130_fd_pr__nfet_01v8 W=1.0u L=0.15u
Rrpl1_0_14 mpl1_0_14 cpl1_14 51308.5352
XTpl1_0_15 row0 gate_l1 mpl1_0_15 0 sky130_fd_pr__nfet_01v8 W=1.0u L=0.15u
Rrpl1_0_15 mpl1_0_15 cpl1_15 36603.6719
XTpl1_0_16 row0 gate_l1 mpl1_0_16 0 sky130_fd_pr__nfet_01v8 W=1.0u L=0.15u
Rrpl1_0_16 mpl1_0_16 cpl1_16 134982.8125
XTpl1_0_17 row0 gate_l1 mpl1_0_17 0 sky130_fd_pr__nfet_01v8 W=1.0u L=0.15u
Rrpl1_0_17 mpl1_0_17 cpl1_17 527915.0000
XTpl1_0_18 row0 gate_l1 mpl1_0_18 0 sky130_fd_pr__nfet_01v8 W=1.0u L=0.15u
Rrpl1_0_18 mpl1_0_18 cpl1_18 48783.1836
XTpl1_0_19 row0 gate_l1 mpl1_0_19 0 sky130_fd_pr__nfet_01v8 W=1.0u L=0.15u
Rrpl1_0_19 mpl1_0_19 cpl1_19 3378378.2500
XTpl1_0_20 row0 gate_l1 mpl1_0_20 0 sky130_fd_pr__nfet_01v8 W=1.0u L=0.15u
Rrpl1_0_20 mpl1_0_20 cpl1_20 3378378.2500
XTpl1_0_21 row0 gate_l1 mpl1_0_21 0 sky130_fd_pr__nfet_01v8 W=1.0u L=0.15u
Rrpl1_0_21 mpl1_0_21 cpl1_21 3378378.2500
XTpl1_0_22 row0 gate_l1 mpl1_0_22 0 sky130_fd_pr__nfet_01v8 W=1.0u L=0.15u
Rrpl1_0_22 mpl1_0_22 cpl1_22 78530.8750
XTpl1_0_23 row0 gate_l1 mpl1_0_23 0 sky130_fd_pr__nfet_01v8 W=1.0u L=0.15u
Rrpl1_0_23 mpl1_0_23 cpl1_23 43984.6172
XTpl1_0_24 row0 gate_l1 mpl1_0_24 0 sky130_fd_pr__nfet_01v8 W=1.0u L=0.15u
Rrpl1_0_24 mpl1_0_24 cpl1_24 58847.1719
XTpl1_0_25 row0 gate_l1 mpl1_0_25 0 sky130_fd_pr__nfet_01v8 W=1.0u L=0.15u
Rrpl1_0_25 mpl1_0_25 cpl1_25 111631.7266
XTpl1_0_26 row0 gate_l1 mpl1_0_26 0 sky130_fd_pr__nfet_01v8 W=1.0u L=0.15u
Rrpl1_0_26 mpl1_0_26 cpl1_26 149268.2188
XTpl1_0_27 row0 gate_l1 mpl1_0_27 0 sky130_fd_pr__nfet_01v8 W=1.0u L=0.15u
Rrpl1_0_27 mpl1_0_27 cpl1_27 3378378.2500
XTpl1_0_28 row0 gate_l1 mpl1_0_28 0 sky130_fd_pr__nfet_01v8 W=1.0u L=0.15u
Rrpl1_0_28 mpl1_0_28 cpl1_28 1532077.3750
XTpl1_0_29 row0 gate_l1 mpl1_0_29 0 sky130_fd_pr__nfet_01v8 W=1.0u L=0.15u
Rrpl1_0_29 mpl1_0_29 cpl1_29 3378378.2500
XTpl1_0_30 row0 gate_l1 mpl1_0_30 0 sky130_fd_pr__nfet_01v8 W=1.0u L=0.15u
Rrpl1_0_30 mpl1_0_30 cpl1_30 3378378.2500
XTpl1_0_31 row0 gate_l1 mpl1_0_31 0 sky130_fd_pr__nfet_01v8 W=1.0u L=0.15u
Rrpl1_0_31 mpl1_0_31 cpl1_31 3378378.2500
XTpl1_0_32 row0 gate_l1 mpl1_0_32 0 sky130_fd_pr__nfet_01v8 W=1.0u L=0.15u
Rrpl1_0_32 mpl1_0_32 cpl1_32 3378378.2500
XTpl1_0_33 row0 gate_l1 mpl1_0_33 0 sky130_fd_pr__nfet_01v8 W=1.0u L=0.15u
Rrpl1_0_33 mpl1_0_33 cpl1_33 3378378.2500
XTpl1_0_34 row0 gate_l1 mpl1_0_34 0 sky130_fd_pr__nfet_01v8 W=1.0u L=0.15u
Rrpl1_0_34 mpl1_0_34 cpl1_34 69374.5703
XTpl1_0_35 row0 gate_l1 mpl1_0_35 0 sky130_fd_pr__nfet_01v8 W=1.0u L=0.15u
Rrpl1_0_35 mpl1_0_35 cpl1_35 30321.7051
XTpl1_0_36 row0 gate_l1 mpl1_0_36 0 sky130_fd_pr__nfet_01v8 W=1.0u L=0.15u
Rrpl1_0_36 mpl1_0_36 cpl1_36 49573.6094
XTpl1_0_37 row0 gate_l1 mpl1_0_37 0 sky130_fd_pr__nfet_01v8 W=1.0u L=0.15u
Rrpl1_0_37 mpl1_0_37 cpl1_37 224732.8125
XTpl1_0_38 row0 gate_l1 mpl1_0_38 0 sky130_fd_pr__nfet_01v8 W=1.0u L=0.15u
Rrpl1_0_38 mpl1_0_38 cpl1_38 3378378.2500
XTpl1_0_39 row0 gate_l1 mpl1_0_39 0 sky130_fd_pr__nfet_01v8 W=1.0u L=0.15u
Rrpl1_0_39 mpl1_0_39 cpl1_39 80419.4453
XTpl1_0_40 row0 gate_l1 mpl1_0_40 0 sky130_fd_pr__nfet_01v8 W=1.0u L=0.15u
Rrpl1_0_40 mpl1_0_40 cpl1_40 66722.1484
XTpl1_0_41 row0 gate_l1 mpl1_0_41 0 sky130_fd_pr__nfet_01v8 W=1.0u L=0.15u
Rrpl1_0_41 mpl1_0_41 cpl1_41 3378378.2500
XTpl1_0_42 row0 gate_l1 mpl1_0_42 0 sky130_fd_pr__nfet_01v8 W=1.0u L=0.15u
Rrpl1_0_42 mpl1_0_42 cpl1_42 2045309.0000
XTpl1_0_43 row0 gate_l1 mpl1_0_43 0 sky130_fd_pr__nfet_01v8 W=1.0u L=0.15u
Rrpl1_0_43 mpl1_0_43 cpl1_43 286655.7500
XTpl1_0_44 row0 gate_l1 mpl1_0_44 0 sky130_fd_pr__nfet_01v8 W=1.0u L=0.15u
Rrpl1_0_44 mpl1_0_44 cpl1_44 1973522.0000
XTpl1_0_45 row0 gate_l1 mpl1_0_45 0 sky130_fd_pr__nfet_01v8 W=1.0u L=0.15u
Rrpl1_0_45 mpl1_0_45 cpl1_45 28820.4922
XTpl1_0_46 row0 gate_l1 mpl1_0_46 0 sky130_fd_pr__nfet_01v8 W=1.0u L=0.15u
Rrpl1_0_46 mpl1_0_46 cpl1_46 80577.0547
XTpl1_0_47 row0 gate_l1 mpl1_0_47 0 sky130_fd_pr__nfet_01v8 W=1.0u L=0.15u
Rrpl1_0_47 mpl1_0_47 cpl1_47 44476.2383
XTpl1_0_48 row0 gate_l1 mpl1_0_48 0 sky130_fd_pr__nfet_01v8 W=1.0u L=0.15u
Rrpl1_0_48 mpl1_0_48 cpl1_48 197241.0312
XTpl1_0_49 row0 gate_l1 mpl1_0_49 0 sky130_fd_pr__nfet_01v8 W=1.0u L=0.15u
Rrpl1_0_49 mpl1_0_49 cpl1_49 3378378.2500
XTpl1_0_50 row0 gate_l1 mpl1_0_50 0 sky130_fd_pr__nfet_01v8 W=1.0u L=0.15u
Rrpl1_0_50 mpl1_0_50 cpl1_50 60429.3555
XTpl1_0_51 row0 gate_l1 mpl1_0_51 0 sky130_fd_pr__nfet_01v8 W=1.0u L=0.15u
Rrpl1_0_51 mpl1_0_51 cpl1_51 107819.7109
XTpl1_0_52 row0 gate_l1 mpl1_0_52 0 sky130_fd_pr__nfet_01v8 W=1.0u L=0.15u
Rrpl1_0_52 mpl1_0_52 cpl1_52 3378378.2500
XTpl1_0_53 row0 gate_l1 mpl1_0_53 0 sky130_fd_pr__nfet_01v8 W=1.0u L=0.15u
Rrpl1_0_53 mpl1_0_53 cpl1_53 3378378.2500
XTpl1_0_54 row0 gate_l1 mpl1_0_54 0 sky130_fd_pr__nfet_01v8 W=1.0u L=0.15u
Rrpl1_0_54 mpl1_0_54 cpl1_54 2831735.0000
XTpl1_0_55 row0 gate_l1 mpl1_0_55 0 sky130_fd_pr__nfet_01v8 W=1.0u L=0.15u
Rrpl1_0_55 mpl1_0_55 cpl1_55 3378378.2500
XTpl1_0_56 row0 gate_l1 mpl1_0_56 0 sky130_fd_pr__nfet_01v8 W=1.0u L=0.15u
Rrpl1_0_56 mpl1_0_56 cpl1_56 50518.9141
XTpl1_0_57 row0 gate_l1 mpl1_0_57 0 sky130_fd_pr__nfet_01v8 W=1.0u L=0.15u
Rrpl1_0_57 mpl1_0_57 cpl1_57 3378378.2500
XTpl1_0_58 row0 gate_l1 mpl1_0_58 0 sky130_fd_pr__nfet_01v8 W=1.0u L=0.15u
Rrpl1_0_58 mpl1_0_58 cpl1_58 3378378.2500
XTpl1_0_59 row0 gate_l1 mpl1_0_59 0 sky130_fd_pr__nfet_01v8 W=1.0u L=0.15u
Rrpl1_0_59 mpl1_0_59 cpl1_59 3378378.2500
XTpl1_0_60 row0 gate_l1 mpl1_0_60 0 sky130_fd_pr__nfet_01v8 W=1.0u L=0.15u
Rrpl1_0_60 mpl1_0_60 cpl1_60 3378378.2500
XTpl1_0_61 row0 gate_l1 mpl1_0_61 0 sky130_fd_pr__nfet_01v8 W=1.0u L=0.15u
Rrpl1_0_61 mpl1_0_61 cpl1_61 3378378.2500
XTpl1_0_62 row0 gate_l1 mpl1_0_62 0 sky130_fd_pr__nfet_01v8 W=1.0u L=0.15u
Rrpl1_0_62 mpl1_0_62 cpl1_62 207503.0781
XTpl1_0_63 row0 gate_l1 mpl1_0_63 0 sky130_fd_pr__nfet_01v8 W=1.0u L=0.15u
Rrpl1_0_63 mpl1_0_63 cpl1_63 37827.7812
XTpl1_1_0 row1 gate_l1 mpl1_1_0 0 sky130_fd_pr__nfet_01v8 W=1.0u L=0.15u
Rrpl1_1_0 mpl1_1_0 cpl1_0 3378378.2500
XTpl1_1_1 row1 gate_l1 mpl1_1_1 0 sky130_fd_pr__nfet_01v8 W=1.0u L=0.15u
Rrpl1_1_1 mpl1_1_1 cpl1_1 3378378.2500
XTpl1_1_2 row1 gate_l1 mpl1_1_2 0 sky130_fd_pr__nfet_01v8 W=1.0u L=0.15u
Rrpl1_1_2 mpl1_1_2 cpl1_2 3378378.2500
XTpl1_1_3 row1 gate_l1 mpl1_1_3 0 sky130_fd_pr__nfet_01v8 W=1.0u L=0.15u
Rrpl1_1_3 mpl1_1_3 cpl1_3 125260.2734
XTpl1_1_4 row1 gate_l1 mpl1_1_4 0 sky130_fd_pr__nfet_01v8 W=1.0u L=0.15u
Rrpl1_1_4 mpl1_1_4 cpl1_4 283151.4688
XTpl1_1_5 row1 gate_l1 mpl1_1_5 0 sky130_fd_pr__nfet_01v8 W=1.0u L=0.15u
Rrpl1_1_5 mpl1_1_5 cpl1_5 3378378.2500
XTpl1_1_6 row1 gate_l1 mpl1_1_6 0 sky130_fd_pr__nfet_01v8 W=1.0u L=0.15u
Rrpl1_1_6 mpl1_1_6 cpl1_6 68964.1641
XTpl1_1_7 row1 gate_l1 mpl1_1_7 0 sky130_fd_pr__nfet_01v8 W=1.0u L=0.15u
Rrpl1_1_7 mpl1_1_7 cpl1_7 2663462.0000
XTpl1_1_8 row1 gate_l1 mpl1_1_8 0 sky130_fd_pr__nfet_01v8 W=1.0u L=0.15u
Rrpl1_1_8 mpl1_1_8 cpl1_8 3378378.2500
XTpl1_1_9 row1 gate_l1 mpl1_1_9 0 sky130_fd_pr__nfet_01v8 W=1.0u L=0.15u
Rrpl1_1_9 mpl1_1_9 cpl1_9 3378378.2500
XTpl1_1_10 row1 gate_l1 mpl1_1_10 0 sky130_fd_pr__nfet_01v8 W=1.0u L=0.15u
Rrpl1_1_10 mpl1_1_10 cpl1_10 149243.4688
XTpl1_1_11 row1 gate_l1 mpl1_1_11 0 sky130_fd_pr__nfet_01v8 W=1.0u L=0.15u
Rrpl1_1_11 mpl1_1_11 cpl1_11 3378378.2500
XTpl1_1_12 row1 gate_l1 mpl1_1_12 0 sky130_fd_pr__nfet_01v8 W=1.0u L=0.15u
Rrpl1_1_12 mpl1_1_12 cpl1_12 2850828.7500
XTpl1_1_13 row1 gate_l1 mpl1_1_13 0 sky130_fd_pr__nfet_01v8 W=1.0u L=0.15u
Rrpl1_1_13 mpl1_1_13 cpl1_13 283005.0000
XTpl1_1_14 row1 gate_l1 mpl1_1_14 0 sky130_fd_pr__nfet_01v8 W=1.0u L=0.15u
Rrpl1_1_14 mpl1_1_14 cpl1_14 128863.5547
XTpl1_1_15 row1 gate_l1 mpl1_1_15 0 sky130_fd_pr__nfet_01v8 W=1.0u L=0.15u
Rrpl1_1_15 mpl1_1_15 cpl1_15 76774.6328
XTpl1_1_16 row1 gate_l1 mpl1_1_16 0 sky130_fd_pr__nfet_01v8 W=1.0u L=0.15u
Rrpl1_1_16 mpl1_1_16 cpl1_16 51802.0586
XTpl1_1_17 row1 gate_l1 mpl1_1_17 0 sky130_fd_pr__nfet_01v8 W=1.0u L=0.15u
Rrpl1_1_17 mpl1_1_17 cpl1_17 3378378.2500
XTpl1_1_18 row1 gate_l1 mpl1_1_18 0 sky130_fd_pr__nfet_01v8 W=1.0u L=0.15u
Rrpl1_1_18 mpl1_1_18 cpl1_18 3378378.2500
XTpl1_1_19 row1 gate_l1 mpl1_1_19 0 sky130_fd_pr__nfet_01v8 W=1.0u L=0.15u
Rrpl1_1_19 mpl1_1_19 cpl1_19 183315.1094
XTpl1_1_20 row1 gate_l1 mpl1_1_20 0 sky130_fd_pr__nfet_01v8 W=1.0u L=0.15u
Rrpl1_1_20 mpl1_1_20 cpl1_20 3378378.2500
XTpl1_1_21 row1 gate_l1 mpl1_1_21 0 sky130_fd_pr__nfet_01v8 W=1.0u L=0.15u
Rrpl1_1_21 mpl1_1_21 cpl1_21 3378378.2500
XTpl1_1_22 row1 gate_l1 mpl1_1_22 0 sky130_fd_pr__nfet_01v8 W=1.0u L=0.15u
Rrpl1_1_22 mpl1_1_22 cpl1_22 3378378.2500
XTpl1_1_23 row1 gate_l1 mpl1_1_23 0 sky130_fd_pr__nfet_01v8 W=1.0u L=0.15u
Rrpl1_1_23 mpl1_1_23 cpl1_23 235406.1562
XTpl1_1_24 row1 gate_l1 mpl1_1_24 0 sky130_fd_pr__nfet_01v8 W=1.0u L=0.15u
Rrpl1_1_24 mpl1_1_24 cpl1_24 3378378.2500
XTpl1_1_25 row1 gate_l1 mpl1_1_25 0 sky130_fd_pr__nfet_01v8 W=1.0u L=0.15u
Rrpl1_1_25 mpl1_1_25 cpl1_25 87053.6641
XTpl1_1_26 row1 gate_l1 mpl1_1_26 0 sky130_fd_pr__nfet_01v8 W=1.0u L=0.15u
Rrpl1_1_26 mpl1_1_26 cpl1_26 65232.7969
XTpl1_1_27 row1 gate_l1 mpl1_1_27 0 sky130_fd_pr__nfet_01v8 W=1.0u L=0.15u
Rrpl1_1_27 mpl1_1_27 cpl1_27 73832.1250
XTpl1_1_28 row1 gate_l1 mpl1_1_28 0 sky130_fd_pr__nfet_01v8 W=1.0u L=0.15u
Rrpl1_1_28 mpl1_1_28 cpl1_28 3378378.2500
XTpl1_1_29 row1 gate_l1 mpl1_1_29 0 sky130_fd_pr__nfet_01v8 W=1.0u L=0.15u
Rrpl1_1_29 mpl1_1_29 cpl1_29 79585.7109
XTpl1_1_30 row1 gate_l1 mpl1_1_30 0 sky130_fd_pr__nfet_01v8 W=1.0u L=0.15u
Rrpl1_1_30 mpl1_1_30 cpl1_30 3378378.2500
XTpl1_1_31 row1 gate_l1 mpl1_1_31 0 sky130_fd_pr__nfet_01v8 W=1.0u L=0.15u
Rrpl1_1_31 mpl1_1_31 cpl1_31 3378378.2500
XTpl1_1_32 row1 gate_l1 mpl1_1_32 0 sky130_fd_pr__nfet_01v8 W=1.0u L=0.15u
Rrpl1_1_32 mpl1_1_32 cpl1_32 3378378.2500
XTpl1_1_33 row1 gate_l1 mpl1_1_33 0 sky130_fd_pr__nfet_01v8 W=1.0u L=0.15u
Rrpl1_1_33 mpl1_1_33 cpl1_33 3378378.2500
XTpl1_1_34 row1 gate_l1 mpl1_1_34 0 sky130_fd_pr__nfet_01v8 W=1.0u L=0.15u
Rrpl1_1_34 mpl1_1_34 cpl1_34 62812.5195
XTpl1_1_35 row1 gate_l1 mpl1_1_35 0 sky130_fd_pr__nfet_01v8 W=1.0u L=0.15u
Rrpl1_1_35 mpl1_1_35 cpl1_35 3378378.2500
XTpl1_1_36 row1 gate_l1 mpl1_1_36 0 sky130_fd_pr__nfet_01v8 W=1.0u L=0.15u
Rrpl1_1_36 mpl1_1_36 cpl1_36 3378378.2500
XTpl1_1_37 row1 gate_l1 mpl1_1_37 0 sky130_fd_pr__nfet_01v8 W=1.0u L=0.15u
Rrpl1_1_37 mpl1_1_37 cpl1_37 3378378.2500
XTpl1_1_38 row1 gate_l1 mpl1_1_38 0 sky130_fd_pr__nfet_01v8 W=1.0u L=0.15u
Rrpl1_1_38 mpl1_1_38 cpl1_38 3378378.2500
XTpl1_1_39 row1 gate_l1 mpl1_1_39 0 sky130_fd_pr__nfet_01v8 W=1.0u L=0.15u
Rrpl1_1_39 mpl1_1_39 cpl1_39 3378378.2500
XTpl1_1_40 row1 gate_l1 mpl1_1_40 0 sky130_fd_pr__nfet_01v8 W=1.0u L=0.15u
Rrpl1_1_40 mpl1_1_40 cpl1_40 3378378.2500
XTpl1_1_41 row1 gate_l1 mpl1_1_41 0 sky130_fd_pr__nfet_01v8 W=1.0u L=0.15u
Rrpl1_1_41 mpl1_1_41 cpl1_41 241104.3594
XTpl1_1_42 row1 gate_l1 mpl1_1_42 0 sky130_fd_pr__nfet_01v8 W=1.0u L=0.15u
Rrpl1_1_42 mpl1_1_42 cpl1_42 3378378.2500
XTpl1_1_43 row1 gate_l1 mpl1_1_43 0 sky130_fd_pr__nfet_01v8 W=1.0u L=0.15u
Rrpl1_1_43 mpl1_1_43 cpl1_43 3378378.2500
XTpl1_1_44 row1 gate_l1 mpl1_1_44 0 sky130_fd_pr__nfet_01v8 W=1.0u L=0.15u
Rrpl1_1_44 mpl1_1_44 cpl1_44 3378378.2500
XTpl1_1_45 row1 gate_l1 mpl1_1_45 0 sky130_fd_pr__nfet_01v8 W=1.0u L=0.15u
Rrpl1_1_45 mpl1_1_45 cpl1_45 3378378.2500
XTpl1_1_46 row1 gate_l1 mpl1_1_46 0 sky130_fd_pr__nfet_01v8 W=1.0u L=0.15u
Rrpl1_1_46 mpl1_1_46 cpl1_46 3378378.2500
XTpl1_1_47 row1 gate_l1 mpl1_1_47 0 sky130_fd_pr__nfet_01v8 W=1.0u L=0.15u
Rrpl1_1_47 mpl1_1_47 cpl1_47 98511.1719
XTpl1_1_48 row1 gate_l1 mpl1_1_48 0 sky130_fd_pr__nfet_01v8 W=1.0u L=0.15u
Rrpl1_1_48 mpl1_1_48 cpl1_48 3378378.2500
XTpl1_1_49 row1 gate_l1 mpl1_1_49 0 sky130_fd_pr__nfet_01v8 W=1.0u L=0.15u
Rrpl1_1_49 mpl1_1_49 cpl1_49 78643.4922
XTpl1_1_50 row1 gate_l1 mpl1_1_50 0 sky130_fd_pr__nfet_01v8 W=1.0u L=0.15u
Rrpl1_1_50 mpl1_1_50 cpl1_50 3378378.2500
XTpl1_1_51 row1 gate_l1 mpl1_1_51 0 sky130_fd_pr__nfet_01v8 W=1.0u L=0.15u
Rrpl1_1_51 mpl1_1_51 cpl1_51 64382.7188
XTpl1_1_52 row1 gate_l1 mpl1_1_52 0 sky130_fd_pr__nfet_01v8 W=1.0u L=0.15u
Rrpl1_1_52 mpl1_1_52 cpl1_52 3378378.2500
XTpl1_1_53 row1 gate_l1 mpl1_1_53 0 sky130_fd_pr__nfet_01v8 W=1.0u L=0.15u
Rrpl1_1_53 mpl1_1_53 cpl1_53 611910.5000
XTpl1_1_54 row1 gate_l1 mpl1_1_54 0 sky130_fd_pr__nfet_01v8 W=1.0u L=0.15u
Rrpl1_1_54 mpl1_1_54 cpl1_54 269021.9688
XTpl1_1_55 row1 gate_l1 mpl1_1_55 0 sky130_fd_pr__nfet_01v8 W=1.0u L=0.15u
Rrpl1_1_55 mpl1_1_55 cpl1_55 3378378.2500
XTpl1_1_56 row1 gate_l1 mpl1_1_56 0 sky130_fd_pr__nfet_01v8 W=1.0u L=0.15u
Rrpl1_1_56 mpl1_1_56 cpl1_56 3378378.2500
XTpl1_1_57 row1 gate_l1 mpl1_1_57 0 sky130_fd_pr__nfet_01v8 W=1.0u L=0.15u
Rrpl1_1_57 mpl1_1_57 cpl1_57 135745.5156
XTpl1_1_58 row1 gate_l1 mpl1_1_58 0 sky130_fd_pr__nfet_01v8 W=1.0u L=0.15u
Rrpl1_1_58 mpl1_1_58 cpl1_58 83447.4922
XTpl1_1_59 row1 gate_l1 mpl1_1_59 0 sky130_fd_pr__nfet_01v8 W=1.0u L=0.15u
Rrpl1_1_59 mpl1_1_59 cpl1_59 3378378.2500
XTpl1_1_60 row1 gate_l1 mpl1_1_60 0 sky130_fd_pr__nfet_01v8 W=1.0u L=0.15u
Rrpl1_1_60 mpl1_1_60 cpl1_60 3378378.2500
XTpl1_1_61 row1 gate_l1 mpl1_1_61 0 sky130_fd_pr__nfet_01v8 W=1.0u L=0.15u
Rrpl1_1_61 mpl1_1_61 cpl1_61 3378378.2500
XTpl1_1_62 row1 gate_l1 mpl1_1_62 0 sky130_fd_pr__nfet_01v8 W=1.0u L=0.15u
Rrpl1_1_62 mpl1_1_62 cpl1_62 3378378.2500
XTpl1_1_63 row1 gate_l1 mpl1_1_63 0 sky130_fd_pr__nfet_01v8 W=1.0u L=0.15u
Rrpl1_1_63 mpl1_1_63 cpl1_63 3378378.2500
XTpl1_2_0 row2 gate_l1 mpl1_2_0 0 sky130_fd_pr__nfet_01v8 W=1.0u L=0.15u
Rrpl1_2_0 mpl1_2_0 cpl1_0 321228.6562
XTpl1_2_1 row2 gate_l1 mpl1_2_1 0 sky130_fd_pr__nfet_01v8 W=1.0u L=0.15u
Rrpl1_2_1 mpl1_2_1 cpl1_1 3378378.2500
XTpl1_2_2 row2 gate_l1 mpl1_2_2 0 sky130_fd_pr__nfet_01v8 W=1.0u L=0.15u
Rrpl1_2_2 mpl1_2_2 cpl1_2 287939.0625
XTpl1_2_3 row2 gate_l1 mpl1_2_3 0 sky130_fd_pr__nfet_01v8 W=1.0u L=0.15u
Rrpl1_2_3 mpl1_2_3 cpl1_3 3378378.2500
XTpl1_2_4 row2 gate_l1 mpl1_2_4 0 sky130_fd_pr__nfet_01v8 W=1.0u L=0.15u
Rrpl1_2_4 mpl1_2_4 cpl1_4 127525.0703
XTpl1_2_5 row2 gate_l1 mpl1_2_5 0 sky130_fd_pr__nfet_01v8 W=1.0u L=0.15u
Rrpl1_2_5 mpl1_2_5 cpl1_5 3378378.2500
XTpl1_2_6 row2 gate_l1 mpl1_2_6 0 sky130_fd_pr__nfet_01v8 W=1.0u L=0.15u
Rrpl1_2_6 mpl1_2_6 cpl1_6 3378378.2500
XTpl1_2_7 row2 gate_l1 mpl1_2_7 0 sky130_fd_pr__nfet_01v8 W=1.0u L=0.15u
Rrpl1_2_7 mpl1_2_7 cpl1_7 190389.6250
XTpl1_2_8 row2 gate_l1 mpl1_2_8 0 sky130_fd_pr__nfet_01v8 W=1.0u L=0.15u
Rrpl1_2_8 mpl1_2_8 cpl1_8 3378378.2500
XTpl1_2_9 row2 gate_l1 mpl1_2_9 0 sky130_fd_pr__nfet_01v8 W=1.0u L=0.15u
Rrpl1_2_9 mpl1_2_9 cpl1_9 3168464.2500
XTpl1_2_10 row2 gate_l1 mpl1_2_10 0 sky130_fd_pr__nfet_01v8 W=1.0u L=0.15u
Rrpl1_2_10 mpl1_2_10 cpl1_10 3378378.2500
XTpl1_2_11 row2 gate_l1 mpl1_2_11 0 sky130_fd_pr__nfet_01v8 W=1.0u L=0.15u
Rrpl1_2_11 mpl1_2_11 cpl1_11 77196.2266
XTpl1_2_12 row2 gate_l1 mpl1_2_12 0 sky130_fd_pr__nfet_01v8 W=1.0u L=0.15u
Rrpl1_2_12 mpl1_2_12 cpl1_12 67487.9219
XTpl1_2_13 row2 gate_l1 mpl1_2_13 0 sky130_fd_pr__nfet_01v8 W=1.0u L=0.15u
Rrpl1_2_13 mpl1_2_13 cpl1_13 512202.3750
XTpl1_2_14 row2 gate_l1 mpl1_2_14 0 sky130_fd_pr__nfet_01v8 W=1.0u L=0.15u
Rrpl1_2_14 mpl1_2_14 cpl1_14 49721.2695
XTpl1_2_15 row2 gate_l1 mpl1_2_15 0 sky130_fd_pr__nfet_01v8 W=1.0u L=0.15u
Rrpl1_2_15 mpl1_2_15 cpl1_15 3378378.2500
XTpl1_2_16 row2 gate_l1 mpl1_2_16 0 sky130_fd_pr__nfet_01v8 W=1.0u L=0.15u
Rrpl1_2_16 mpl1_2_16 cpl1_16 901559.5625
XTpl1_2_17 row2 gate_l1 mpl1_2_17 0 sky130_fd_pr__nfet_01v8 W=1.0u L=0.15u
Rrpl1_2_17 mpl1_2_17 cpl1_17 3378378.2500
XTpl1_2_18 row2 gate_l1 mpl1_2_18 0 sky130_fd_pr__nfet_01v8 W=1.0u L=0.15u
Rrpl1_2_18 mpl1_2_18 cpl1_18 53318.4609
XTpl1_2_19 row2 gate_l1 mpl1_2_19 0 sky130_fd_pr__nfet_01v8 W=1.0u L=0.15u
Rrpl1_2_19 mpl1_2_19 cpl1_19 143109.0000
XTpl1_2_20 row2 gate_l1 mpl1_2_20 0 sky130_fd_pr__nfet_01v8 W=1.0u L=0.15u
Rrpl1_2_20 mpl1_2_20 cpl1_20 3378378.2500
XTpl1_2_21 row2 gate_l1 mpl1_2_21 0 sky130_fd_pr__nfet_01v8 W=1.0u L=0.15u
Rrpl1_2_21 mpl1_2_21 cpl1_21 183075.2812
XTpl1_2_22 row2 gate_l1 mpl1_2_22 0 sky130_fd_pr__nfet_01v8 W=1.0u L=0.15u
Rrpl1_2_22 mpl1_2_22 cpl1_22 3378378.2500
XTpl1_2_23 row2 gate_l1 mpl1_2_23 0 sky130_fd_pr__nfet_01v8 W=1.0u L=0.15u
Rrpl1_2_23 mpl1_2_23 cpl1_23 271256.5625
XTpl1_2_24 row2 gate_l1 mpl1_2_24 0 sky130_fd_pr__nfet_01v8 W=1.0u L=0.15u
Rrpl1_2_24 mpl1_2_24 cpl1_24 63796.2383
XTpl1_2_25 row2 gate_l1 mpl1_2_25 0 sky130_fd_pr__nfet_01v8 W=1.0u L=0.15u
Rrpl1_2_25 mpl1_2_25 cpl1_25 93026.3906
XTpl1_2_26 row2 gate_l1 mpl1_2_26 0 sky130_fd_pr__nfet_01v8 W=1.0u L=0.15u
Rrpl1_2_26 mpl1_2_26 cpl1_26 49509.0664
XTpl1_2_27 row2 gate_l1 mpl1_2_27 0 sky130_fd_pr__nfet_01v8 W=1.0u L=0.15u
Rrpl1_2_27 mpl1_2_27 cpl1_27 106819.2734
XTpl1_2_28 row2 gate_l1 mpl1_2_28 0 sky130_fd_pr__nfet_01v8 W=1.0u L=0.15u
Rrpl1_2_28 mpl1_2_28 cpl1_28 3378378.2500
XTpl1_2_29 row2 gate_l1 mpl1_2_29 0 sky130_fd_pr__nfet_01v8 W=1.0u L=0.15u
Rrpl1_2_29 mpl1_2_29 cpl1_29 98189.1406
XTpl1_2_30 row2 gate_l1 mpl1_2_30 0 sky130_fd_pr__nfet_01v8 W=1.0u L=0.15u
Rrpl1_2_30 mpl1_2_30 cpl1_30 57259.7344
XTpl1_2_31 row2 gate_l1 mpl1_2_31 0 sky130_fd_pr__nfet_01v8 W=1.0u L=0.15u
Rrpl1_2_31 mpl1_2_31 cpl1_31 225565.4375
XTpl1_2_32 row2 gate_l1 mpl1_2_32 0 sky130_fd_pr__nfet_01v8 W=1.0u L=0.15u
Rrpl1_2_32 mpl1_2_32 cpl1_32 3378378.2500
XTpl1_2_33 row2 gate_l1 mpl1_2_33 0 sky130_fd_pr__nfet_01v8 W=1.0u L=0.15u
Rrpl1_2_33 mpl1_2_33 cpl1_33 308008.0625
XTpl1_2_34 row2 gate_l1 mpl1_2_34 0 sky130_fd_pr__nfet_01v8 W=1.0u L=0.15u
Rrpl1_2_34 mpl1_2_34 cpl1_34 3378378.2500
XTpl1_2_35 row2 gate_l1 mpl1_2_35 0 sky130_fd_pr__nfet_01v8 W=1.0u L=0.15u
Rrpl1_2_35 mpl1_2_35 cpl1_35 75649.8672
XTpl1_2_36 row2 gate_l1 mpl1_2_36 0 sky130_fd_pr__nfet_01v8 W=1.0u L=0.15u
Rrpl1_2_36 mpl1_2_36 cpl1_36 102290.1953
XTpl1_2_37 row2 gate_l1 mpl1_2_37 0 sky130_fd_pr__nfet_01v8 W=1.0u L=0.15u
Rrpl1_2_37 mpl1_2_37 cpl1_37 3378378.2500
XTpl1_2_38 row2 gate_l1 mpl1_2_38 0 sky130_fd_pr__nfet_01v8 W=1.0u L=0.15u
Rrpl1_2_38 mpl1_2_38 cpl1_38 1748333.8750
XTpl1_2_39 row2 gate_l1 mpl1_2_39 0 sky130_fd_pr__nfet_01v8 W=1.0u L=0.15u
Rrpl1_2_39 mpl1_2_39 cpl1_39 101577.4766
XTpl1_2_40 row2 gate_l1 mpl1_2_40 0 sky130_fd_pr__nfet_01v8 W=1.0u L=0.15u
Rrpl1_2_40 mpl1_2_40 cpl1_40 3378378.2500
XTpl1_2_41 row2 gate_l1 mpl1_2_41 0 sky130_fd_pr__nfet_01v8 W=1.0u L=0.15u
Rrpl1_2_41 mpl1_2_41 cpl1_41 139643.7812
XTpl1_2_42 row2 gate_l1 mpl1_2_42 0 sky130_fd_pr__nfet_01v8 W=1.0u L=0.15u
Rrpl1_2_42 mpl1_2_42 cpl1_42 3378378.2500
XTpl1_2_43 row2 gate_l1 mpl1_2_43 0 sky130_fd_pr__nfet_01v8 W=1.0u L=0.15u
Rrpl1_2_43 mpl1_2_43 cpl1_43 3378378.2500
XTpl1_2_44 row2 gate_l1 mpl1_2_44 0 sky130_fd_pr__nfet_01v8 W=1.0u L=0.15u
Rrpl1_2_44 mpl1_2_44 cpl1_44 3378378.2500
XTpl1_2_45 row2 gate_l1 mpl1_2_45 0 sky130_fd_pr__nfet_01v8 W=1.0u L=0.15u
Rrpl1_2_45 mpl1_2_45 cpl1_45 43814.0039
XTpl1_2_46 row2 gate_l1 mpl1_2_46 0 sky130_fd_pr__nfet_01v8 W=1.0u L=0.15u
Rrpl1_2_46 mpl1_2_46 cpl1_46 77233.6875
XTpl1_2_47 row2 gate_l1 mpl1_2_47 0 sky130_fd_pr__nfet_01v8 W=1.0u L=0.15u
Rrpl1_2_47 mpl1_2_47 cpl1_47 3378378.2500
XTpl1_2_48 row2 gate_l1 mpl1_2_48 0 sky130_fd_pr__nfet_01v8 W=1.0u L=0.15u
Rrpl1_2_48 mpl1_2_48 cpl1_48 44826.0820
XTpl1_2_49 row2 gate_l1 mpl1_2_49 0 sky130_fd_pr__nfet_01v8 W=1.0u L=0.15u
Rrpl1_2_49 mpl1_2_49 cpl1_49 59861.0039
XTpl1_2_50 row2 gate_l1 mpl1_2_50 0 sky130_fd_pr__nfet_01v8 W=1.0u L=0.15u
Rrpl1_2_50 mpl1_2_50 cpl1_50 3378378.2500
XTpl1_2_51 row2 gate_l1 mpl1_2_51 0 sky130_fd_pr__nfet_01v8 W=1.0u L=0.15u
Rrpl1_2_51 mpl1_2_51 cpl1_51 3378378.2500
XTpl1_2_52 row2 gate_l1 mpl1_2_52 0 sky130_fd_pr__nfet_01v8 W=1.0u L=0.15u
Rrpl1_2_52 mpl1_2_52 cpl1_52 501173.0000
XTpl1_2_53 row2 gate_l1 mpl1_2_53 0 sky130_fd_pr__nfet_01v8 W=1.0u L=0.15u
Rrpl1_2_53 mpl1_2_53 cpl1_53 3378378.2500
XTpl1_2_54 row2 gate_l1 mpl1_2_54 0 sky130_fd_pr__nfet_01v8 W=1.0u L=0.15u
Rrpl1_2_54 mpl1_2_54 cpl1_54 3378378.2500
XTpl1_2_55 row2 gate_l1 mpl1_2_55 0 sky130_fd_pr__nfet_01v8 W=1.0u L=0.15u
Rrpl1_2_55 mpl1_2_55 cpl1_55 3378378.2500
XTpl1_2_56 row2 gate_l1 mpl1_2_56 0 sky130_fd_pr__nfet_01v8 W=1.0u L=0.15u
Rrpl1_2_56 mpl1_2_56 cpl1_56 3378378.2500
XTpl1_2_57 row2 gate_l1 mpl1_2_57 0 sky130_fd_pr__nfet_01v8 W=1.0u L=0.15u
Rrpl1_2_57 mpl1_2_57 cpl1_57 3378378.2500
XTpl1_2_58 row2 gate_l1 mpl1_2_58 0 sky130_fd_pr__nfet_01v8 W=1.0u L=0.15u
Rrpl1_2_58 mpl1_2_58 cpl1_58 47927.2969
XTpl1_2_59 row2 gate_l1 mpl1_2_59 0 sky130_fd_pr__nfet_01v8 W=1.0u L=0.15u
Rrpl1_2_59 mpl1_2_59 cpl1_59 80086.8984
XTpl1_2_60 row2 gate_l1 mpl1_2_60 0 sky130_fd_pr__nfet_01v8 W=1.0u L=0.15u
Rrpl1_2_60 mpl1_2_60 cpl1_60 3378378.2500
XTpl1_2_61 row2 gate_l1 mpl1_2_61 0 sky130_fd_pr__nfet_01v8 W=1.0u L=0.15u
Rrpl1_2_61 mpl1_2_61 cpl1_61 3378378.2500
XTpl1_2_62 row2 gate_l1 mpl1_2_62 0 sky130_fd_pr__nfet_01v8 W=1.0u L=0.15u
Rrpl1_2_62 mpl1_2_62 cpl1_62 3378378.2500
XTpl1_2_63 row2 gate_l1 mpl1_2_63 0 sky130_fd_pr__nfet_01v8 W=1.0u L=0.15u
Rrpl1_2_63 mpl1_2_63 cpl1_63 3378378.2500
XTpl1_3_0 row3 gate_l1 mpl1_3_0 0 sky130_fd_pr__nfet_01v8 W=1.0u L=0.15u
Rrpl1_3_0 mpl1_3_0 cpl1_0 64143.5156
XTpl1_3_1 row3 gate_l1 mpl1_3_1 0 sky130_fd_pr__nfet_01v8 W=1.0u L=0.15u
Rrpl1_3_1 mpl1_3_1 cpl1_1 118454.3906
XTpl1_3_2 row3 gate_l1 mpl1_3_2 0 sky130_fd_pr__nfet_01v8 W=1.0u L=0.15u
Rrpl1_3_2 mpl1_3_2 cpl1_2 376188.8125
XTpl1_3_3 row3 gate_l1 mpl1_3_3 0 sky130_fd_pr__nfet_01v8 W=1.0u L=0.15u
Rrpl1_3_3 mpl1_3_3 cpl1_3 73708.7734
XTpl1_3_4 row3 gate_l1 mpl1_3_4 0 sky130_fd_pr__nfet_01v8 W=1.0u L=0.15u
Rrpl1_3_4 mpl1_3_4 cpl1_4 81668.0781
XTpl1_3_5 row3 gate_l1 mpl1_3_5 0 sky130_fd_pr__nfet_01v8 W=1.0u L=0.15u
Rrpl1_3_5 mpl1_3_5 cpl1_5 385416.0000
XTpl1_3_6 row3 gate_l1 mpl1_3_6 0 sky130_fd_pr__nfet_01v8 W=1.0u L=0.15u
Rrpl1_3_6 mpl1_3_6 cpl1_6 3378378.2500
XTpl1_3_7 row3 gate_l1 mpl1_3_7 0 sky130_fd_pr__nfet_01v8 W=1.0u L=0.15u
Rrpl1_3_7 mpl1_3_7 cpl1_7 3378378.2500
XTpl1_3_8 row3 gate_l1 mpl1_3_8 0 sky130_fd_pr__nfet_01v8 W=1.0u L=0.15u
Rrpl1_3_8 mpl1_3_8 cpl1_8 3378378.2500
XTpl1_3_9 row3 gate_l1 mpl1_3_9 0 sky130_fd_pr__nfet_01v8 W=1.0u L=0.15u
Rrpl1_3_9 mpl1_3_9 cpl1_9 3378378.2500
XTpl1_3_10 row3 gate_l1 mpl1_3_10 0 sky130_fd_pr__nfet_01v8 W=1.0u L=0.15u
Rrpl1_3_10 mpl1_3_10 cpl1_10 3378378.2500
XTpl1_3_11 row3 gate_l1 mpl1_3_11 0 sky130_fd_pr__nfet_01v8 W=1.0u L=0.15u
Rrpl1_3_11 mpl1_3_11 cpl1_11 352718.3438
XTpl1_3_12 row3 gate_l1 mpl1_3_12 0 sky130_fd_pr__nfet_01v8 W=1.0u L=0.15u
Rrpl1_3_12 mpl1_3_12 cpl1_12 3378378.2500
XTpl1_3_13 row3 gate_l1 mpl1_3_13 0 sky130_fd_pr__nfet_01v8 W=1.0u L=0.15u
Rrpl1_3_13 mpl1_3_13 cpl1_13 29762.6152
XTpl1_3_14 row3 gate_l1 mpl1_3_14 0 sky130_fd_pr__nfet_01v8 W=1.0u L=0.15u
Rrpl1_3_14 mpl1_3_14 cpl1_14 106108.8594
XTpl1_3_15 row3 gate_l1 mpl1_3_15 0 sky130_fd_pr__nfet_01v8 W=1.0u L=0.15u
Rrpl1_3_15 mpl1_3_15 cpl1_15 145530.8906
XTpl1_3_16 row3 gate_l1 mpl1_3_16 0 sky130_fd_pr__nfet_01v8 W=1.0u L=0.15u
Rrpl1_3_16 mpl1_3_16 cpl1_16 3378378.2500
XTpl1_3_17 row3 gate_l1 mpl1_3_17 0 sky130_fd_pr__nfet_01v8 W=1.0u L=0.15u
Rrpl1_3_17 mpl1_3_17 cpl1_17 3378378.2500
XTpl1_3_18 row3 gate_l1 mpl1_3_18 0 sky130_fd_pr__nfet_01v8 W=1.0u L=0.15u
Rrpl1_3_18 mpl1_3_18 cpl1_18 3378378.2500
XTpl1_3_19 row3 gate_l1 mpl1_3_19 0 sky130_fd_pr__nfet_01v8 W=1.0u L=0.15u
Rrpl1_3_19 mpl1_3_19 cpl1_19 3378378.2500
XTpl1_3_20 row3 gate_l1 mpl1_3_20 0 sky130_fd_pr__nfet_01v8 W=1.0u L=0.15u
Rrpl1_3_20 mpl1_3_20 cpl1_20 37917.7344
XTpl1_3_21 row3 gate_l1 mpl1_3_21 0 sky130_fd_pr__nfet_01v8 W=1.0u L=0.15u
Rrpl1_3_21 mpl1_3_21 cpl1_21 3378378.2500
XTpl1_3_22 row3 gate_l1 mpl1_3_22 0 sky130_fd_pr__nfet_01v8 W=1.0u L=0.15u
Rrpl1_3_22 mpl1_3_22 cpl1_22 3378378.2500
XTpl1_3_23 row3 gate_l1 mpl1_3_23 0 sky130_fd_pr__nfet_01v8 W=1.0u L=0.15u
Rrpl1_3_23 mpl1_3_23 cpl1_23 49453.5820
XTpl1_3_24 row3 gate_l1 mpl1_3_24 0 sky130_fd_pr__nfet_01v8 W=1.0u L=0.15u
Rrpl1_3_24 mpl1_3_24 cpl1_24 3378378.2500
XTpl1_3_25 row3 gate_l1 mpl1_3_25 0 sky130_fd_pr__nfet_01v8 W=1.0u L=0.15u
Rrpl1_3_25 mpl1_3_25 cpl1_25 3378378.2500
XTpl1_3_26 row3 gate_l1 mpl1_3_26 0 sky130_fd_pr__nfet_01v8 W=1.0u L=0.15u
Rrpl1_3_26 mpl1_3_26 cpl1_26 64146.7500
XTpl1_3_27 row3 gate_l1 mpl1_3_27 0 sky130_fd_pr__nfet_01v8 W=1.0u L=0.15u
Rrpl1_3_27 mpl1_3_27 cpl1_27 55918.2031
XTpl1_3_28 row3 gate_l1 mpl1_3_28 0 sky130_fd_pr__nfet_01v8 W=1.0u L=0.15u
Rrpl1_3_28 mpl1_3_28 cpl1_28 42947.6172
XTpl1_3_29 row3 gate_l1 mpl1_3_29 0 sky130_fd_pr__nfet_01v8 W=1.0u L=0.15u
Rrpl1_3_29 mpl1_3_29 cpl1_29 3378378.2500
XTpl1_3_30 row3 gate_l1 mpl1_3_30 0 sky130_fd_pr__nfet_01v8 W=1.0u L=0.15u
Rrpl1_3_30 mpl1_3_30 cpl1_30 197410.9531
XTpl1_3_31 row3 gate_l1 mpl1_3_31 0 sky130_fd_pr__nfet_01v8 W=1.0u L=0.15u
Rrpl1_3_31 mpl1_3_31 cpl1_31 3378378.2500
XTpl1_3_32 row3 gate_l1 mpl1_3_32 0 sky130_fd_pr__nfet_01v8 W=1.0u L=0.15u
Rrpl1_3_32 mpl1_3_32 cpl1_32 3378378.2500
XTpl1_3_33 row3 gate_l1 mpl1_3_33 0 sky130_fd_pr__nfet_01v8 W=1.0u L=0.15u
Rrpl1_3_33 mpl1_3_33 cpl1_33 3378378.2500
XTpl1_3_34 row3 gate_l1 mpl1_3_34 0 sky130_fd_pr__nfet_01v8 W=1.0u L=0.15u
Rrpl1_3_34 mpl1_3_34 cpl1_34 3378378.2500
XTpl1_3_35 row3 gate_l1 mpl1_3_35 0 sky130_fd_pr__nfet_01v8 W=1.0u L=0.15u
Rrpl1_3_35 mpl1_3_35 cpl1_35 96860.6328
XTpl1_3_36 row3 gate_l1 mpl1_3_36 0 sky130_fd_pr__nfet_01v8 W=1.0u L=0.15u
Rrpl1_3_36 mpl1_3_36 cpl1_36 3378378.2500
XTpl1_3_37 row3 gate_l1 mpl1_3_37 0 sky130_fd_pr__nfet_01v8 W=1.0u L=0.15u
Rrpl1_3_37 mpl1_3_37 cpl1_37 3378378.2500
XTpl1_3_38 row3 gate_l1 mpl1_3_38 0 sky130_fd_pr__nfet_01v8 W=1.0u L=0.15u
Rrpl1_3_38 mpl1_3_38 cpl1_38 3378378.2500
XTpl1_3_39 row3 gate_l1 mpl1_3_39 0 sky130_fd_pr__nfet_01v8 W=1.0u L=0.15u
Rrpl1_3_39 mpl1_3_39 cpl1_39 47677.4766
XTpl1_3_40 row3 gate_l1 mpl1_3_40 0 sky130_fd_pr__nfet_01v8 W=1.0u L=0.15u
Rrpl1_3_40 mpl1_3_40 cpl1_40 3378378.2500
XTpl1_3_41 row3 gate_l1 mpl1_3_41 0 sky130_fd_pr__nfet_01v8 W=1.0u L=0.15u
Rrpl1_3_41 mpl1_3_41 cpl1_41 227041.7344
XTpl1_3_42 row3 gate_l1 mpl1_3_42 0 sky130_fd_pr__nfet_01v8 W=1.0u L=0.15u
Rrpl1_3_42 mpl1_3_42 cpl1_42 3378378.2500
XTpl1_3_43 row3 gate_l1 mpl1_3_43 0 sky130_fd_pr__nfet_01v8 W=1.0u L=0.15u
Rrpl1_3_43 mpl1_3_43 cpl1_43 37480.9727
XTpl1_3_44 row3 gate_l1 mpl1_3_44 0 sky130_fd_pr__nfet_01v8 W=1.0u L=0.15u
Rrpl1_3_44 mpl1_3_44 cpl1_44 324653.1875
XTpl1_3_45 row3 gate_l1 mpl1_3_45 0 sky130_fd_pr__nfet_01v8 W=1.0u L=0.15u
Rrpl1_3_45 mpl1_3_45 cpl1_45 45359.7852
XTpl1_3_46 row3 gate_l1 mpl1_3_46 0 sky130_fd_pr__nfet_01v8 W=1.0u L=0.15u
Rrpl1_3_46 mpl1_3_46 cpl1_46 3378378.2500
XTpl1_3_47 row3 gate_l1 mpl1_3_47 0 sky130_fd_pr__nfet_01v8 W=1.0u L=0.15u
Rrpl1_3_47 mpl1_3_47 cpl1_47 110914.3203
XTpl1_3_48 row3 gate_l1 mpl1_3_48 0 sky130_fd_pr__nfet_01v8 W=1.0u L=0.15u
Rrpl1_3_48 mpl1_3_48 cpl1_48 22512.7031
XTpl1_3_49 row3 gate_l1 mpl1_3_49 0 sky130_fd_pr__nfet_01v8 W=1.0u L=0.15u
Rrpl1_3_49 mpl1_3_49 cpl1_49 413742.6250
XTpl1_3_50 row3 gate_l1 mpl1_3_50 0 sky130_fd_pr__nfet_01v8 W=1.0u L=0.15u
Rrpl1_3_50 mpl1_3_50 cpl1_50 3378378.2500
XTpl1_3_51 row3 gate_l1 mpl1_3_51 0 sky130_fd_pr__nfet_01v8 W=1.0u L=0.15u
Rrpl1_3_51 mpl1_3_51 cpl1_51 3378378.2500
XTpl1_3_52 row3 gate_l1 mpl1_3_52 0 sky130_fd_pr__nfet_01v8 W=1.0u L=0.15u
Rrpl1_3_52 mpl1_3_52 cpl1_52 3378378.2500
XTpl1_3_53 row3 gate_l1 mpl1_3_53 0 sky130_fd_pr__nfet_01v8 W=1.0u L=0.15u
Rrpl1_3_53 mpl1_3_53 cpl1_53 228904.4375
XTpl1_3_54 row3 gate_l1 mpl1_3_54 0 sky130_fd_pr__nfet_01v8 W=1.0u L=0.15u
Rrpl1_3_54 mpl1_3_54 cpl1_54 73069.7266
XTpl1_3_55 row3 gate_l1 mpl1_3_55 0 sky130_fd_pr__nfet_01v8 W=1.0u L=0.15u
Rrpl1_3_55 mpl1_3_55 cpl1_55 69891.2344
XTpl1_3_56 row3 gate_l1 mpl1_3_56 0 sky130_fd_pr__nfet_01v8 W=1.0u L=0.15u
Rrpl1_3_56 mpl1_3_56 cpl1_56 182583.3281
XTpl1_3_57 row3 gate_l1 mpl1_3_57 0 sky130_fd_pr__nfet_01v8 W=1.0u L=0.15u
Rrpl1_3_57 mpl1_3_57 cpl1_57 53146.6289
XTpl1_3_58 row3 gate_l1 mpl1_3_58 0 sky130_fd_pr__nfet_01v8 W=1.0u L=0.15u
Rrpl1_3_58 mpl1_3_58 cpl1_58 3378378.2500
XTpl1_3_59 row3 gate_l1 mpl1_3_59 0 sky130_fd_pr__nfet_01v8 W=1.0u L=0.15u
Rrpl1_3_59 mpl1_3_59 cpl1_59 3378378.2500
XTpl1_3_60 row3 gate_l1 mpl1_3_60 0 sky130_fd_pr__nfet_01v8 W=1.0u L=0.15u
Rrpl1_3_60 mpl1_3_60 cpl1_60 782903.7500
XTpl1_3_61 row3 gate_l1 mpl1_3_61 0 sky130_fd_pr__nfet_01v8 W=1.0u L=0.15u
Rrpl1_3_61 mpl1_3_61 cpl1_61 24971.2891
XTpl1_3_62 row3 gate_l1 mpl1_3_62 0 sky130_fd_pr__nfet_01v8 W=1.0u L=0.15u
Rrpl1_3_62 mpl1_3_62 cpl1_62 3378378.2500
XTpl1_3_63 row3 gate_l1 mpl1_3_63 0 sky130_fd_pr__nfet_01v8 W=1.0u L=0.15u
Rrpl1_3_63 mpl1_3_63 cpl1_63 107796.0312
XTpl1_4_0 row4 gate_l1 mpl1_4_0 0 sky130_fd_pr__nfet_01v8 W=1.0u L=0.15u
Rrpl1_4_0 mpl1_4_0 cpl1_0 276474.2812
XTpl1_4_1 row4 gate_l1 mpl1_4_1 0 sky130_fd_pr__nfet_01v8 W=1.0u L=0.15u
Rrpl1_4_1 mpl1_4_1 cpl1_1 79890.7969
XTpl1_4_2 row4 gate_l1 mpl1_4_2 0 sky130_fd_pr__nfet_01v8 W=1.0u L=0.15u
Rrpl1_4_2 mpl1_4_2 cpl1_2 27257.3145
XTpl1_4_3 row4 gate_l1 mpl1_4_3 0 sky130_fd_pr__nfet_01v8 W=1.0u L=0.15u
Rrpl1_4_3 mpl1_4_3 cpl1_3 38640.6055
XTpl1_4_4 row4 gate_l1 mpl1_4_4 0 sky130_fd_pr__nfet_01v8 W=1.0u L=0.15u
Rrpl1_4_4 mpl1_4_4 cpl1_4 30443.6113
XTpl1_4_5 row4 gate_l1 mpl1_4_5 0 sky130_fd_pr__nfet_01v8 W=1.0u L=0.15u
Rrpl1_4_5 mpl1_4_5 cpl1_5 650535.2500
XTpl1_4_6 row4 gate_l1 mpl1_4_6 0 sky130_fd_pr__nfet_01v8 W=1.0u L=0.15u
Rrpl1_4_6 mpl1_4_6 cpl1_6 3378378.2500
XTpl1_4_7 row4 gate_l1 mpl1_4_7 0 sky130_fd_pr__nfet_01v8 W=1.0u L=0.15u
Rrpl1_4_7 mpl1_4_7 cpl1_7 25674.4238
XTpl1_4_8 row4 gate_l1 mpl1_4_8 0 sky130_fd_pr__nfet_01v8 W=1.0u L=0.15u
Rrpl1_4_8 mpl1_4_8 cpl1_8 43055.0273
XTpl1_4_9 row4 gate_l1 mpl1_4_9 0 sky130_fd_pr__nfet_01v8 W=1.0u L=0.15u
Rrpl1_4_9 mpl1_4_9 cpl1_9 22930.0195
XTpl1_4_10 row4 gate_l1 mpl1_4_10 0 sky130_fd_pr__nfet_01v8 W=1.0u L=0.15u
Rrpl1_4_10 mpl1_4_10 cpl1_10 82010.0156
XTpl1_4_11 row4 gate_l1 mpl1_4_11 0 sky130_fd_pr__nfet_01v8 W=1.0u L=0.15u
Rrpl1_4_11 mpl1_4_11 cpl1_11 36926.7812
XTpl1_4_12 row4 gate_l1 mpl1_4_12 0 sky130_fd_pr__nfet_01v8 W=1.0u L=0.15u
Rrpl1_4_12 mpl1_4_12 cpl1_12 3378378.2500
XTpl1_4_13 row4 gate_l1 mpl1_4_13 0 sky130_fd_pr__nfet_01v8 W=1.0u L=0.15u
Rrpl1_4_13 mpl1_4_13 cpl1_13 3378378.2500
XTpl1_4_14 row4 gate_l1 mpl1_4_14 0 sky130_fd_pr__nfet_01v8 W=1.0u L=0.15u
Rrpl1_4_14 mpl1_4_14 cpl1_14 62437.6992
XTpl1_4_15 row4 gate_l1 mpl1_4_15 0 sky130_fd_pr__nfet_01v8 W=1.0u L=0.15u
Rrpl1_4_15 mpl1_4_15 cpl1_15 3378378.2500
XTpl1_4_16 row4 gate_l1 mpl1_4_16 0 sky130_fd_pr__nfet_01v8 W=1.0u L=0.15u
Rrpl1_4_16 mpl1_4_16 cpl1_16 3378378.2500
XTpl1_4_17 row4 gate_l1 mpl1_4_17 0 sky130_fd_pr__nfet_01v8 W=1.0u L=0.15u
Rrpl1_4_17 mpl1_4_17 cpl1_17 24318.9473
XTpl1_4_18 row4 gate_l1 mpl1_4_18 0 sky130_fd_pr__nfet_01v8 W=1.0u L=0.15u
Rrpl1_4_18 mpl1_4_18 cpl1_18 39714.5625
XTpl1_4_19 row4 gate_l1 mpl1_4_19 0 sky130_fd_pr__nfet_01v8 W=1.0u L=0.15u
Rrpl1_4_19 mpl1_4_19 cpl1_19 31942.1973
XTpl1_4_20 row4 gate_l1 mpl1_4_20 0 sky130_fd_pr__nfet_01v8 W=1.0u L=0.15u
Rrpl1_4_20 mpl1_4_20 cpl1_20 292181.5312
XTpl1_4_21 row4 gate_l1 mpl1_4_21 0 sky130_fd_pr__nfet_01v8 W=1.0u L=0.15u
Rrpl1_4_21 mpl1_4_21 cpl1_21 47061.9336
XTpl1_4_22 row4 gate_l1 mpl1_4_22 0 sky130_fd_pr__nfet_01v8 W=1.0u L=0.15u
Rrpl1_4_22 mpl1_4_22 cpl1_22 81257.4453
XTpl1_4_23 row4 gate_l1 mpl1_4_23 0 sky130_fd_pr__nfet_01v8 W=1.0u L=0.15u
Rrpl1_4_23 mpl1_4_23 cpl1_23 35326.6094
XTpl1_4_24 row4 gate_l1 mpl1_4_24 0 sky130_fd_pr__nfet_01v8 W=1.0u L=0.15u
Rrpl1_4_24 mpl1_4_24 cpl1_24 115541.9453
XTpl1_4_25 row4 gate_l1 mpl1_4_25 0 sky130_fd_pr__nfet_01v8 W=1.0u L=0.15u
Rrpl1_4_25 mpl1_4_25 cpl1_25 3378378.2500
XTpl1_4_26 row4 gate_l1 mpl1_4_26 0 sky130_fd_pr__nfet_01v8 W=1.0u L=0.15u
Rrpl1_4_26 mpl1_4_26 cpl1_26 3378378.2500
XTpl1_4_27 row4 gate_l1 mpl1_4_27 0 sky130_fd_pr__nfet_01v8 W=1.0u L=0.15u
Rrpl1_4_27 mpl1_4_27 cpl1_27 3378378.2500
XTpl1_4_28 row4 gate_l1 mpl1_4_28 0 sky130_fd_pr__nfet_01v8 W=1.0u L=0.15u
Rrpl1_4_28 mpl1_4_28 cpl1_28 42145.0820
XTpl1_4_29 row4 gate_l1 mpl1_4_29 0 sky130_fd_pr__nfet_01v8 W=1.0u L=0.15u
Rrpl1_4_29 mpl1_4_29 cpl1_29 3378378.2500
XTpl1_4_30 row4 gate_l1 mpl1_4_30 0 sky130_fd_pr__nfet_01v8 W=1.0u L=0.15u
Rrpl1_4_30 mpl1_4_30 cpl1_30 165433.6406
XTpl1_4_31 row4 gate_l1 mpl1_4_31 0 sky130_fd_pr__nfet_01v8 W=1.0u L=0.15u
Rrpl1_4_31 mpl1_4_31 cpl1_31 3378378.2500
XTpl1_4_32 row4 gate_l1 mpl1_4_32 0 sky130_fd_pr__nfet_01v8 W=1.0u L=0.15u
Rrpl1_4_32 mpl1_4_32 cpl1_32 20590.9434
XTpl1_4_33 row4 gate_l1 mpl1_4_33 0 sky130_fd_pr__nfet_01v8 W=1.0u L=0.15u
Rrpl1_4_33 mpl1_4_33 cpl1_33 50884.3242
XTpl1_4_34 row4 gate_l1 mpl1_4_34 0 sky130_fd_pr__nfet_01v8 W=1.0u L=0.15u
Rrpl1_4_34 mpl1_4_34 cpl1_34 3378378.2500
XTpl1_4_35 row4 gate_l1 mpl1_4_35 0 sky130_fd_pr__nfet_01v8 W=1.0u L=0.15u
Rrpl1_4_35 mpl1_4_35 cpl1_35 3378378.2500
XTpl1_4_36 row4 gate_l1 mpl1_4_36 0 sky130_fd_pr__nfet_01v8 W=1.0u L=0.15u
Rrpl1_4_36 mpl1_4_36 cpl1_36 24076.0918
XTpl1_4_37 row4 gate_l1 mpl1_4_37 0 sky130_fd_pr__nfet_01v8 W=1.0u L=0.15u
Rrpl1_4_37 mpl1_4_37 cpl1_37 50351.9727
XTpl1_4_38 row4 gate_l1 mpl1_4_38 0 sky130_fd_pr__nfet_01v8 W=1.0u L=0.15u
Rrpl1_4_38 mpl1_4_38 cpl1_38 22521.9258
XTpl1_4_39 row4 gate_l1 mpl1_4_39 0 sky130_fd_pr__nfet_01v8 W=1.0u L=0.15u
Rrpl1_4_39 mpl1_4_39 cpl1_39 36290.1992
XTpl1_4_40 row4 gate_l1 mpl1_4_40 0 sky130_fd_pr__nfet_01v8 W=1.0u L=0.15u
Rrpl1_4_40 mpl1_4_40 cpl1_40 445723.1562
XTpl1_4_41 row4 gate_l1 mpl1_4_41 0 sky130_fd_pr__nfet_01v8 W=1.0u L=0.15u
Rrpl1_4_41 mpl1_4_41 cpl1_41 66729.6016
XTpl1_4_42 row4 gate_l1 mpl1_4_42 0 sky130_fd_pr__nfet_01v8 W=1.0u L=0.15u
Rrpl1_4_42 mpl1_4_42 cpl1_42 28231.7598
XTpl1_4_43 row4 gate_l1 mpl1_4_43 0 sky130_fd_pr__nfet_01v8 W=1.0u L=0.15u
Rrpl1_4_43 mpl1_4_43 cpl1_43 855301.3750
XTpl1_4_44 row4 gate_l1 mpl1_4_44 0 sky130_fd_pr__nfet_01v8 W=1.0u L=0.15u
Rrpl1_4_44 mpl1_4_44 cpl1_44 3378378.2500
XTpl1_4_45 row4 gate_l1 mpl1_4_45 0 sky130_fd_pr__nfet_01v8 W=1.0u L=0.15u
Rrpl1_4_45 mpl1_4_45 cpl1_45 51022.8750
XTpl1_4_46 row4 gate_l1 mpl1_4_46 0 sky130_fd_pr__nfet_01v8 W=1.0u L=0.15u
Rrpl1_4_46 mpl1_4_46 cpl1_46 75590.5547
XTpl1_4_47 row4 gate_l1 mpl1_4_47 0 sky130_fd_pr__nfet_01v8 W=1.0u L=0.15u
Rrpl1_4_47 mpl1_4_47 cpl1_47 3378378.2500
XTpl1_4_48 row4 gate_l1 mpl1_4_48 0 sky130_fd_pr__nfet_01v8 W=1.0u L=0.15u
Rrpl1_4_48 mpl1_4_48 cpl1_48 31877.1758
XTpl1_4_49 row4 gate_l1 mpl1_4_49 0 sky130_fd_pr__nfet_01v8 W=1.0u L=0.15u
Rrpl1_4_49 mpl1_4_49 cpl1_49 31551.3301
XTpl1_4_50 row4 gate_l1 mpl1_4_50 0 sky130_fd_pr__nfet_01v8 W=1.0u L=0.15u
Rrpl1_4_50 mpl1_4_50 cpl1_50 28235.7773
XTpl1_4_51 row4 gate_l1 mpl1_4_51 0 sky130_fd_pr__nfet_01v8 W=1.0u L=0.15u
Rrpl1_4_51 mpl1_4_51 cpl1_51 84567.5469
XTpl1_4_52 row4 gate_l1 mpl1_4_52 0 sky130_fd_pr__nfet_01v8 W=1.0u L=0.15u
Rrpl1_4_52 mpl1_4_52 cpl1_52 3378378.2500
XTpl1_4_53 row4 gate_l1 mpl1_4_53 0 sky130_fd_pr__nfet_01v8 W=1.0u L=0.15u
Rrpl1_4_53 mpl1_4_53 cpl1_53 105568.8203
XTpl1_4_54 row4 gate_l1 mpl1_4_54 0 sky130_fd_pr__nfet_01v8 W=1.0u L=0.15u
Rrpl1_4_54 mpl1_4_54 cpl1_54 30133.4785
XTpl1_4_55 row4 gate_l1 mpl1_4_55 0 sky130_fd_pr__nfet_01v8 W=1.0u L=0.15u
Rrpl1_4_55 mpl1_4_55 cpl1_55 195325.5781
XTpl1_4_56 row4 gate_l1 mpl1_4_56 0 sky130_fd_pr__nfet_01v8 W=1.0u L=0.15u
Rrpl1_4_56 mpl1_4_56 cpl1_56 304983.0938
XTpl1_4_57 row4 gate_l1 mpl1_4_57 0 sky130_fd_pr__nfet_01v8 W=1.0u L=0.15u
Rrpl1_4_57 mpl1_4_57 cpl1_57 44101.1836
XTpl1_4_58 row4 gate_l1 mpl1_4_58 0 sky130_fd_pr__nfet_01v8 W=1.0u L=0.15u
Rrpl1_4_58 mpl1_4_58 cpl1_58 3378378.2500
XTpl1_4_59 row4 gate_l1 mpl1_4_59 0 sky130_fd_pr__nfet_01v8 W=1.0u L=0.15u
Rrpl1_4_59 mpl1_4_59 cpl1_59 3378378.2500
XTpl1_4_60 row4 gate_l1 mpl1_4_60 0 sky130_fd_pr__nfet_01v8 W=1.0u L=0.15u
Rrpl1_4_60 mpl1_4_60 cpl1_60 3378378.2500
XTpl1_4_61 row4 gate_l1 mpl1_4_61 0 sky130_fd_pr__nfet_01v8 W=1.0u L=0.15u
Rrpl1_4_61 mpl1_4_61 cpl1_61 3378378.2500
XTpl1_4_62 row4 gate_l1 mpl1_4_62 0 sky130_fd_pr__nfet_01v8 W=1.0u L=0.15u
Rrpl1_4_62 mpl1_4_62 cpl1_62 75655.2578
XTpl1_4_63 row4 gate_l1 mpl1_4_63 0 sky130_fd_pr__nfet_01v8 W=1.0u L=0.15u
Rrpl1_4_63 mpl1_4_63 cpl1_63 3378378.2500
XTpl1_5_0 row5 gate_l1 mpl1_5_0 0 sky130_fd_pr__nfet_01v8 W=1.0u L=0.15u
Rrpl1_5_0 mpl1_5_0 cpl1_0 3378378.2500
XTpl1_5_1 row5 gate_l1 mpl1_5_1 0 sky130_fd_pr__nfet_01v8 W=1.0u L=0.15u
Rrpl1_5_1 mpl1_5_1 cpl1_1 200183.2188
XTpl1_5_2 row5 gate_l1 mpl1_5_2 0 sky130_fd_pr__nfet_01v8 W=1.0u L=0.15u
Rrpl1_5_2 mpl1_5_2 cpl1_2 3378378.2500
XTpl1_5_3 row5 gate_l1 mpl1_5_3 0 sky130_fd_pr__nfet_01v8 W=1.0u L=0.15u
Rrpl1_5_3 mpl1_5_3 cpl1_3 64167.7578
XTpl1_5_4 row5 gate_l1 mpl1_5_4 0 sky130_fd_pr__nfet_01v8 W=1.0u L=0.15u
Rrpl1_5_4 mpl1_5_4 cpl1_4 3378378.2500
XTpl1_5_5 row5 gate_l1 mpl1_5_5 0 sky130_fd_pr__nfet_01v8 W=1.0u L=0.15u
Rrpl1_5_5 mpl1_5_5 cpl1_5 3378378.2500
XTpl1_5_6 row5 gate_l1 mpl1_5_6 0 sky130_fd_pr__nfet_01v8 W=1.0u L=0.15u
Rrpl1_5_6 mpl1_5_6 cpl1_6 3378378.2500
XTpl1_5_7 row5 gate_l1 mpl1_5_7 0 sky130_fd_pr__nfet_01v8 W=1.0u L=0.15u
Rrpl1_5_7 mpl1_5_7 cpl1_7 47878.1250
XTpl1_5_8 row5 gate_l1 mpl1_5_8 0 sky130_fd_pr__nfet_01v8 W=1.0u L=0.15u
Rrpl1_5_8 mpl1_5_8 cpl1_8 31964.9453
XTpl1_5_9 row5 gate_l1 mpl1_5_9 0 sky130_fd_pr__nfet_01v8 W=1.0u L=0.15u
Rrpl1_5_9 mpl1_5_9 cpl1_9 3378378.2500
XTpl1_5_10 row5 gate_l1 mpl1_5_10 0 sky130_fd_pr__nfet_01v8 W=1.0u L=0.15u
Rrpl1_5_10 mpl1_5_10 cpl1_10 3378378.2500
XTpl1_5_11 row5 gate_l1 mpl1_5_11 0 sky130_fd_pr__nfet_01v8 W=1.0u L=0.15u
Rrpl1_5_11 mpl1_5_11 cpl1_11 150622.1562
XTpl1_5_12 row5 gate_l1 mpl1_5_12 0 sky130_fd_pr__nfet_01v8 W=1.0u L=0.15u
Rrpl1_5_12 mpl1_5_12 cpl1_12 3378378.2500
XTpl1_5_13 row5 gate_l1 mpl1_5_13 0 sky130_fd_pr__nfet_01v8 W=1.0u L=0.15u
Rrpl1_5_13 mpl1_5_13 cpl1_13 81475.3984
XTpl1_5_14 row5 gate_l1 mpl1_5_14 0 sky130_fd_pr__nfet_01v8 W=1.0u L=0.15u
Rrpl1_5_14 mpl1_5_14 cpl1_14 3378378.2500
XTpl1_5_15 row5 gate_l1 mpl1_5_15 0 sky130_fd_pr__nfet_01v8 W=1.0u L=0.15u
Rrpl1_5_15 mpl1_5_15 cpl1_15 3378378.2500
XTpl1_5_16 row5 gate_l1 mpl1_5_16 0 sky130_fd_pr__nfet_01v8 W=1.0u L=0.15u
Rrpl1_5_16 mpl1_5_16 cpl1_16 3378378.2500
XTpl1_5_17 row5 gate_l1 mpl1_5_17 0 sky130_fd_pr__nfet_01v8 W=1.0u L=0.15u
Rrpl1_5_17 mpl1_5_17 cpl1_17 101386.1562
XTpl1_5_18 row5 gate_l1 mpl1_5_18 0 sky130_fd_pr__nfet_01v8 W=1.0u L=0.15u
Rrpl1_5_18 mpl1_5_18 cpl1_18 3378378.2500
XTpl1_5_19 row5 gate_l1 mpl1_5_19 0 sky130_fd_pr__nfet_01v8 W=1.0u L=0.15u
Rrpl1_5_19 mpl1_5_19 cpl1_19 3378378.2500
XTpl1_5_20 row5 gate_l1 mpl1_5_20 0 sky130_fd_pr__nfet_01v8 W=1.0u L=0.15u
Rrpl1_5_20 mpl1_5_20 cpl1_20 3378378.2500
XTpl1_5_21 row5 gate_l1 mpl1_5_21 0 sky130_fd_pr__nfet_01v8 W=1.0u L=0.15u
Rrpl1_5_21 mpl1_5_21 cpl1_21 388314.6562
XTpl1_5_22 row5 gate_l1 mpl1_5_22 0 sky130_fd_pr__nfet_01v8 W=1.0u L=0.15u
Rrpl1_5_22 mpl1_5_22 cpl1_22 3378378.2500
XTpl1_5_23 row5 gate_l1 mpl1_5_23 0 sky130_fd_pr__nfet_01v8 W=1.0u L=0.15u
Rrpl1_5_23 mpl1_5_23 cpl1_23 3378378.2500
XTpl1_5_24 row5 gate_l1 mpl1_5_24 0 sky130_fd_pr__nfet_01v8 W=1.0u L=0.15u
Rrpl1_5_24 mpl1_5_24 cpl1_24 3378378.2500
XTpl1_5_25 row5 gate_l1 mpl1_5_25 0 sky130_fd_pr__nfet_01v8 W=1.0u L=0.15u
Rrpl1_5_25 mpl1_5_25 cpl1_25 90557.1719
XTpl1_5_26 row5 gate_l1 mpl1_5_26 0 sky130_fd_pr__nfet_01v8 W=1.0u L=0.15u
Rrpl1_5_26 mpl1_5_26 cpl1_26 91772.3672
XTpl1_5_27 row5 gate_l1 mpl1_5_27 0 sky130_fd_pr__nfet_01v8 W=1.0u L=0.15u
Rrpl1_5_27 mpl1_5_27 cpl1_27 320291.2188
XTpl1_5_28 row5 gate_l1 mpl1_5_28 0 sky130_fd_pr__nfet_01v8 W=1.0u L=0.15u
Rrpl1_5_28 mpl1_5_28 cpl1_28 3378378.2500
XTpl1_5_29 row5 gate_l1 mpl1_5_29 0 sky130_fd_pr__nfet_01v8 W=1.0u L=0.15u
Rrpl1_5_29 mpl1_5_29 cpl1_29 3378378.2500
XTpl1_5_30 row5 gate_l1 mpl1_5_30 0 sky130_fd_pr__nfet_01v8 W=1.0u L=0.15u
Rrpl1_5_30 mpl1_5_30 cpl1_30 121196.9375
XTpl1_5_31 row5 gate_l1 mpl1_5_31 0 sky130_fd_pr__nfet_01v8 W=1.0u L=0.15u
Rrpl1_5_31 mpl1_5_31 cpl1_31 3378378.2500
XTpl1_5_32 row5 gate_l1 mpl1_5_32 0 sky130_fd_pr__nfet_01v8 W=1.0u L=0.15u
Rrpl1_5_32 mpl1_5_32 cpl1_32 3378378.2500
XTpl1_5_33 row5 gate_l1 mpl1_5_33 0 sky130_fd_pr__nfet_01v8 W=1.0u L=0.15u
Rrpl1_5_33 mpl1_5_33 cpl1_33 3378378.2500
XTpl1_5_34 row5 gate_l1 mpl1_5_34 0 sky130_fd_pr__nfet_01v8 W=1.0u L=0.15u
Rrpl1_5_34 mpl1_5_34 cpl1_34 3378378.2500
XTpl1_5_35 row5 gate_l1 mpl1_5_35 0 sky130_fd_pr__nfet_01v8 W=1.0u L=0.15u
Rrpl1_5_35 mpl1_5_35 cpl1_35 3378378.2500
XTpl1_5_36 row5 gate_l1 mpl1_5_36 0 sky130_fd_pr__nfet_01v8 W=1.0u L=0.15u
Rrpl1_5_36 mpl1_5_36 cpl1_36 3378378.2500
XTpl1_5_37 row5 gate_l1 mpl1_5_37 0 sky130_fd_pr__nfet_01v8 W=1.0u L=0.15u
Rrpl1_5_37 mpl1_5_37 cpl1_37 3378378.2500
XTpl1_5_38 row5 gate_l1 mpl1_5_38 0 sky130_fd_pr__nfet_01v8 W=1.0u L=0.15u
Rrpl1_5_38 mpl1_5_38 cpl1_38 133012.6875
XTpl1_5_39 row5 gate_l1 mpl1_5_39 0 sky130_fd_pr__nfet_01v8 W=1.0u L=0.15u
Rrpl1_5_39 mpl1_5_39 cpl1_39 162542.1250
XTpl1_5_40 row5 gate_l1 mpl1_5_40 0 sky130_fd_pr__nfet_01v8 W=1.0u L=0.15u
Rrpl1_5_40 mpl1_5_40 cpl1_40 3378378.2500
XTpl1_5_41 row5 gate_l1 mpl1_5_41 0 sky130_fd_pr__nfet_01v8 W=1.0u L=0.15u
Rrpl1_5_41 mpl1_5_41 cpl1_41 95168.0156
XTpl1_5_42 row5 gate_l1 mpl1_5_42 0 sky130_fd_pr__nfet_01v8 W=1.0u L=0.15u
Rrpl1_5_42 mpl1_5_42 cpl1_42 3378378.2500
XTpl1_5_43 row5 gate_l1 mpl1_5_43 0 sky130_fd_pr__nfet_01v8 W=1.0u L=0.15u
Rrpl1_5_43 mpl1_5_43 cpl1_43 55589.2031
XTpl1_5_44 row5 gate_l1 mpl1_5_44 0 sky130_fd_pr__nfet_01v8 W=1.0u L=0.15u
Rrpl1_5_44 mpl1_5_44 cpl1_44 119578.0938
XTpl1_5_45 row5 gate_l1 mpl1_5_45 0 sky130_fd_pr__nfet_01v8 W=1.0u L=0.15u
Rrpl1_5_45 mpl1_5_45 cpl1_45 3378378.2500
XTpl1_5_46 row5 gate_l1 mpl1_5_46 0 sky130_fd_pr__nfet_01v8 W=1.0u L=0.15u
Rrpl1_5_46 mpl1_5_46 cpl1_46 217335.8906
XTpl1_5_47 row5 gate_l1 mpl1_5_47 0 sky130_fd_pr__nfet_01v8 W=1.0u L=0.15u
Rrpl1_5_47 mpl1_5_47 cpl1_47 3378378.2500
XTpl1_5_48 row5 gate_l1 mpl1_5_48 0 sky130_fd_pr__nfet_01v8 W=1.0u L=0.15u
Rrpl1_5_48 mpl1_5_48 cpl1_48 280348.2812
XTpl1_5_49 row5 gate_l1 mpl1_5_49 0 sky130_fd_pr__nfet_01v8 W=1.0u L=0.15u
Rrpl1_5_49 mpl1_5_49 cpl1_49 3378378.2500
XTpl1_5_50 row5 gate_l1 mpl1_5_50 0 sky130_fd_pr__nfet_01v8 W=1.0u L=0.15u
Rrpl1_5_50 mpl1_5_50 cpl1_50 3378378.2500
XTpl1_5_51 row5 gate_l1 mpl1_5_51 0 sky130_fd_pr__nfet_01v8 W=1.0u L=0.15u
Rrpl1_5_51 mpl1_5_51 cpl1_51 3378378.2500
XTpl1_5_52 row5 gate_l1 mpl1_5_52 0 sky130_fd_pr__nfet_01v8 W=1.0u L=0.15u
Rrpl1_5_52 mpl1_5_52 cpl1_52 3378378.2500
XTpl1_5_53 row5 gate_l1 mpl1_5_53 0 sky130_fd_pr__nfet_01v8 W=1.0u L=0.15u
Rrpl1_5_53 mpl1_5_53 cpl1_53 507615.4375
XTpl1_5_54 row5 gate_l1 mpl1_5_54 0 sky130_fd_pr__nfet_01v8 W=1.0u L=0.15u
Rrpl1_5_54 mpl1_5_54 cpl1_54 486554.2500
XTpl1_5_55 row5 gate_l1 mpl1_5_55 0 sky130_fd_pr__nfet_01v8 W=1.0u L=0.15u
Rrpl1_5_55 mpl1_5_55 cpl1_55 3378378.2500
XTpl1_5_56 row5 gate_l1 mpl1_5_56 0 sky130_fd_pr__nfet_01v8 W=1.0u L=0.15u
Rrpl1_5_56 mpl1_5_56 cpl1_56 3378378.2500
XTpl1_5_57 row5 gate_l1 mpl1_5_57 0 sky130_fd_pr__nfet_01v8 W=1.0u L=0.15u
Rrpl1_5_57 mpl1_5_57 cpl1_57 3378378.2500
XTpl1_5_58 row5 gate_l1 mpl1_5_58 0 sky130_fd_pr__nfet_01v8 W=1.0u L=0.15u
Rrpl1_5_58 mpl1_5_58 cpl1_58 618332.8125
XTpl1_5_59 row5 gate_l1 mpl1_5_59 0 sky130_fd_pr__nfet_01v8 W=1.0u L=0.15u
Rrpl1_5_59 mpl1_5_59 cpl1_59 3378378.2500
XTpl1_5_60 row5 gate_l1 mpl1_5_60 0 sky130_fd_pr__nfet_01v8 W=1.0u L=0.15u
Rrpl1_5_60 mpl1_5_60 cpl1_60 3378378.2500
XTpl1_5_61 row5 gate_l1 mpl1_5_61 0 sky130_fd_pr__nfet_01v8 W=1.0u L=0.15u
Rrpl1_5_61 mpl1_5_61 cpl1_61 45271.5156
XTpl1_5_62 row5 gate_l1 mpl1_5_62 0 sky130_fd_pr__nfet_01v8 W=1.0u L=0.15u
Rrpl1_5_62 mpl1_5_62 cpl1_62 3378378.2500
XTpl1_5_63 row5 gate_l1 mpl1_5_63 0 sky130_fd_pr__nfet_01v8 W=1.0u L=0.15u
Rrpl1_5_63 mpl1_5_63 cpl1_63 249236.1250
XTpl1_6_0 row6 gate_l1 mpl1_6_0 0 sky130_fd_pr__nfet_01v8 W=1.0u L=0.15u
Rrpl1_6_0 mpl1_6_0 cpl1_0 188650.1406
XTpl1_6_1 row6 gate_l1 mpl1_6_1 0 sky130_fd_pr__nfet_01v8 W=1.0u L=0.15u
Rrpl1_6_1 mpl1_6_1 cpl1_1 84190.1875
XTpl1_6_2 row6 gate_l1 mpl1_6_2 0 sky130_fd_pr__nfet_01v8 W=1.0u L=0.15u
Rrpl1_6_2 mpl1_6_2 cpl1_2 3378378.2500
XTpl1_6_3 row6 gate_l1 mpl1_6_3 0 sky130_fd_pr__nfet_01v8 W=1.0u L=0.15u
Rrpl1_6_3 mpl1_6_3 cpl1_3 3378378.2500
XTpl1_6_4 row6 gate_l1 mpl1_6_4 0 sky130_fd_pr__nfet_01v8 W=1.0u L=0.15u
Rrpl1_6_4 mpl1_6_4 cpl1_4 3378378.2500
XTpl1_6_5 row6 gate_l1 mpl1_6_5 0 sky130_fd_pr__nfet_01v8 W=1.0u L=0.15u
Rrpl1_6_5 mpl1_6_5 cpl1_5 3378378.2500
XTpl1_6_6 row6 gate_l1 mpl1_6_6 0 sky130_fd_pr__nfet_01v8 W=1.0u L=0.15u
Rrpl1_6_6 mpl1_6_6 cpl1_6 86310.4062
XTpl1_6_7 row6 gate_l1 mpl1_6_7 0 sky130_fd_pr__nfet_01v8 W=1.0u L=0.15u
Rrpl1_6_7 mpl1_6_7 cpl1_7 159317.0469
XTpl1_6_8 row6 gate_l1 mpl1_6_8 0 sky130_fd_pr__nfet_01v8 W=1.0u L=0.15u
Rrpl1_6_8 mpl1_6_8 cpl1_8 3378378.2500
XTpl1_6_9 row6 gate_l1 mpl1_6_9 0 sky130_fd_pr__nfet_01v8 W=1.0u L=0.15u
Rrpl1_6_9 mpl1_6_9 cpl1_9 102220.4531
XTpl1_6_10 row6 gate_l1 mpl1_6_10 0 sky130_fd_pr__nfet_01v8 W=1.0u L=0.15u
Rrpl1_6_10 mpl1_6_10 cpl1_10 44275.0547
XTpl1_6_11 row6 gate_l1 mpl1_6_11 0 sky130_fd_pr__nfet_01v8 W=1.0u L=0.15u
Rrpl1_6_11 mpl1_6_11 cpl1_11 52578.3555
XTpl1_6_12 row6 gate_l1 mpl1_6_12 0 sky130_fd_pr__nfet_01v8 W=1.0u L=0.15u
Rrpl1_6_12 mpl1_6_12 cpl1_12 3378378.2500
XTpl1_6_13 row6 gate_l1 mpl1_6_13 0 sky130_fd_pr__nfet_01v8 W=1.0u L=0.15u
Rrpl1_6_13 mpl1_6_13 cpl1_13 3378378.2500
XTpl1_6_14 row6 gate_l1 mpl1_6_14 0 sky130_fd_pr__nfet_01v8 W=1.0u L=0.15u
Rrpl1_6_14 mpl1_6_14 cpl1_14 3378378.2500
XTpl1_6_15 row6 gate_l1 mpl1_6_15 0 sky130_fd_pr__nfet_01v8 W=1.0u L=0.15u
Rrpl1_6_15 mpl1_6_15 cpl1_15 101385.1016
XTpl1_6_16 row6 gate_l1 mpl1_6_16 0 sky130_fd_pr__nfet_01v8 W=1.0u L=0.15u
Rrpl1_6_16 mpl1_6_16 cpl1_16 540957.5000
XTpl1_6_17 row6 gate_l1 mpl1_6_17 0 sky130_fd_pr__nfet_01v8 W=1.0u L=0.15u
Rrpl1_6_17 mpl1_6_17 cpl1_17 208544.5625
XTpl1_6_18 row6 gate_l1 mpl1_6_18 0 sky130_fd_pr__nfet_01v8 W=1.0u L=0.15u
Rrpl1_6_18 mpl1_6_18 cpl1_18 3378378.2500
XTpl1_6_19 row6 gate_l1 mpl1_6_19 0 sky130_fd_pr__nfet_01v8 W=1.0u L=0.15u
Rrpl1_6_19 mpl1_6_19 cpl1_19 3378378.2500
XTpl1_6_20 row6 gate_l1 mpl1_6_20 0 sky130_fd_pr__nfet_01v8 W=1.0u L=0.15u
Rrpl1_6_20 mpl1_6_20 cpl1_20 79773.0469
XTpl1_6_21 row6 gate_l1 mpl1_6_21 0 sky130_fd_pr__nfet_01v8 W=1.0u L=0.15u
Rrpl1_6_21 mpl1_6_21 cpl1_21 130639.1406
XTpl1_6_22 row6 gate_l1 mpl1_6_22 0 sky130_fd_pr__nfet_01v8 W=1.0u L=0.15u
Rrpl1_6_22 mpl1_6_22 cpl1_22 3378378.2500
XTpl1_6_23 row6 gate_l1 mpl1_6_23 0 sky130_fd_pr__nfet_01v8 W=1.0u L=0.15u
Rrpl1_6_23 mpl1_6_23 cpl1_23 3378378.2500
XTpl1_6_24 row6 gate_l1 mpl1_6_24 0 sky130_fd_pr__nfet_01v8 W=1.0u L=0.15u
Rrpl1_6_24 mpl1_6_24 cpl1_24 3378378.2500
XTpl1_6_25 row6 gate_l1 mpl1_6_25 0 sky130_fd_pr__nfet_01v8 W=1.0u L=0.15u
Rrpl1_6_25 mpl1_6_25 cpl1_25 3378378.2500
XTpl1_6_26 row6 gate_l1 mpl1_6_26 0 sky130_fd_pr__nfet_01v8 W=1.0u L=0.15u
Rrpl1_6_26 mpl1_6_26 cpl1_26 3378378.2500
XTpl1_6_27 row6 gate_l1 mpl1_6_27 0 sky130_fd_pr__nfet_01v8 W=1.0u L=0.15u
Rrpl1_6_27 mpl1_6_27 cpl1_27 3378378.2500
XTpl1_6_28 row6 gate_l1 mpl1_6_28 0 sky130_fd_pr__nfet_01v8 W=1.0u L=0.15u
Rrpl1_6_28 mpl1_6_28 cpl1_28 143672.8906
XTpl1_6_29 row6 gate_l1 mpl1_6_29 0 sky130_fd_pr__nfet_01v8 W=1.0u L=0.15u
Rrpl1_6_29 mpl1_6_29 cpl1_29 3378378.2500
XTpl1_6_30 row6 gate_l1 mpl1_6_30 0 sky130_fd_pr__nfet_01v8 W=1.0u L=0.15u
Rrpl1_6_30 mpl1_6_30 cpl1_30 3378378.2500
XTpl1_6_31 row6 gate_l1 mpl1_6_31 0 sky130_fd_pr__nfet_01v8 W=1.0u L=0.15u
Rrpl1_6_31 mpl1_6_31 cpl1_31 3378378.2500
XTpl1_6_32 row6 gate_l1 mpl1_6_32 0 sky130_fd_pr__nfet_01v8 W=1.0u L=0.15u
Rrpl1_6_32 mpl1_6_32 cpl1_32 188006.2656
XTpl1_6_33 row6 gate_l1 mpl1_6_33 0 sky130_fd_pr__nfet_01v8 W=1.0u L=0.15u
Rrpl1_6_33 mpl1_6_33 cpl1_33 22216.3125
XTpl1_6_34 row6 gate_l1 mpl1_6_34 0 sky130_fd_pr__nfet_01v8 W=1.0u L=0.15u
Rrpl1_6_34 mpl1_6_34 cpl1_34 3378378.2500
XTpl1_6_35 row6 gate_l1 mpl1_6_35 0 sky130_fd_pr__nfet_01v8 W=1.0u L=0.15u
Rrpl1_6_35 mpl1_6_35 cpl1_35 3378378.2500
XTpl1_6_36 row6 gate_l1 mpl1_6_36 0 sky130_fd_pr__nfet_01v8 W=1.0u L=0.15u
Rrpl1_6_36 mpl1_6_36 cpl1_36 39916.6914
XTpl1_6_37 row6 gate_l1 mpl1_6_37 0 sky130_fd_pr__nfet_01v8 W=1.0u L=0.15u
Rrpl1_6_37 mpl1_6_37 cpl1_37 3378378.2500
XTpl1_6_38 row6 gate_l1 mpl1_6_38 0 sky130_fd_pr__nfet_01v8 W=1.0u L=0.15u
Rrpl1_6_38 mpl1_6_38 cpl1_38 210712.3906
XTpl1_6_39 row6 gate_l1 mpl1_6_39 0 sky130_fd_pr__nfet_01v8 W=1.0u L=0.15u
Rrpl1_6_39 mpl1_6_39 cpl1_39 3378378.2500
XTpl1_6_40 row6 gate_l1 mpl1_6_40 0 sky130_fd_pr__nfet_01v8 W=1.0u L=0.15u
Rrpl1_6_40 mpl1_6_40 cpl1_40 3378378.2500
XTpl1_6_41 row6 gate_l1 mpl1_6_41 0 sky130_fd_pr__nfet_01v8 W=1.0u L=0.15u
Rrpl1_6_41 mpl1_6_41 cpl1_41 3378378.2500
XTpl1_6_42 row6 gate_l1 mpl1_6_42 0 sky130_fd_pr__nfet_01v8 W=1.0u L=0.15u
Rrpl1_6_42 mpl1_6_42 cpl1_42 67958.1328
XTpl1_6_43 row6 gate_l1 mpl1_6_43 0 sky130_fd_pr__nfet_01v8 W=1.0u L=0.15u
Rrpl1_6_43 mpl1_6_43 cpl1_43 102395.5391
XTpl1_6_44 row6 gate_l1 mpl1_6_44 0 sky130_fd_pr__nfet_01v8 W=1.0u L=0.15u
Rrpl1_6_44 mpl1_6_44 cpl1_44 3378378.2500
XTpl1_6_45 row6 gate_l1 mpl1_6_45 0 sky130_fd_pr__nfet_01v8 W=1.0u L=0.15u
Rrpl1_6_45 mpl1_6_45 cpl1_45 3378378.2500
XTpl1_6_46 row6 gate_l1 mpl1_6_46 0 sky130_fd_pr__nfet_01v8 W=1.0u L=0.15u
Rrpl1_6_46 mpl1_6_46 cpl1_46 31506.6152
XTpl1_6_47 row6 gate_l1 mpl1_6_47 0 sky130_fd_pr__nfet_01v8 W=1.0u L=0.15u
Rrpl1_6_47 mpl1_6_47 cpl1_47 341520.0312
XTpl1_6_48 row6 gate_l1 mpl1_6_48 0 sky130_fd_pr__nfet_01v8 W=1.0u L=0.15u
Rrpl1_6_48 mpl1_6_48 cpl1_48 3378378.2500
XTpl1_6_49 row6 gate_l1 mpl1_6_49 0 sky130_fd_pr__nfet_01v8 W=1.0u L=0.15u
Rrpl1_6_49 mpl1_6_49 cpl1_49 51078.5078
XTpl1_6_50 row6 gate_l1 mpl1_6_50 0 sky130_fd_pr__nfet_01v8 W=1.0u L=0.15u
Rrpl1_6_50 mpl1_6_50 cpl1_50 43386.6406
XTpl1_6_51 row6 gate_l1 mpl1_6_51 0 sky130_fd_pr__nfet_01v8 W=1.0u L=0.15u
Rrpl1_6_51 mpl1_6_51 cpl1_51 93255.0000
XTpl1_6_52 row6 gate_l1 mpl1_6_52 0 sky130_fd_pr__nfet_01v8 W=1.0u L=0.15u
Rrpl1_6_52 mpl1_6_52 cpl1_52 202684.5469
XTpl1_6_53 row6 gate_l1 mpl1_6_53 0 sky130_fd_pr__nfet_01v8 W=1.0u L=0.15u
Rrpl1_6_53 mpl1_6_53 cpl1_53 3378378.2500
XTpl1_6_54 row6 gate_l1 mpl1_6_54 0 sky130_fd_pr__nfet_01v8 W=1.0u L=0.15u
Rrpl1_6_54 mpl1_6_54 cpl1_54 60472.0352
XTpl1_6_55 row6 gate_l1 mpl1_6_55 0 sky130_fd_pr__nfet_01v8 W=1.0u L=0.15u
Rrpl1_6_55 mpl1_6_55 cpl1_55 268017.8125
XTpl1_6_56 row6 gate_l1 mpl1_6_56 0 sky130_fd_pr__nfet_01v8 W=1.0u L=0.15u
Rrpl1_6_56 mpl1_6_56 cpl1_56 3378378.2500
XTpl1_6_57 row6 gate_l1 mpl1_6_57 0 sky130_fd_pr__nfet_01v8 W=1.0u L=0.15u
Rrpl1_6_57 mpl1_6_57 cpl1_57 74457.1172
XTpl1_6_58 row6 gate_l1 mpl1_6_58 0 sky130_fd_pr__nfet_01v8 W=1.0u L=0.15u
Rrpl1_6_58 mpl1_6_58 cpl1_58 3378378.2500
XTpl1_6_59 row6 gate_l1 mpl1_6_59 0 sky130_fd_pr__nfet_01v8 W=1.0u L=0.15u
Rrpl1_6_59 mpl1_6_59 cpl1_59 89633.4609
XTpl1_6_60 row6 gate_l1 mpl1_6_60 0 sky130_fd_pr__nfet_01v8 W=1.0u L=0.15u
Rrpl1_6_60 mpl1_6_60 cpl1_60 232682.4531
XTpl1_6_61 row6 gate_l1 mpl1_6_61 0 sky130_fd_pr__nfet_01v8 W=1.0u L=0.15u
Rrpl1_6_61 mpl1_6_61 cpl1_61 472709.9062
XTpl1_6_62 row6 gate_l1 mpl1_6_62 0 sky130_fd_pr__nfet_01v8 W=1.0u L=0.15u
Rrpl1_6_62 mpl1_6_62 cpl1_62 122582.6328
XTpl1_6_63 row6 gate_l1 mpl1_6_63 0 sky130_fd_pr__nfet_01v8 W=1.0u L=0.15u
Rrpl1_6_63 mpl1_6_63 cpl1_63 3378378.2500
XTpl1_7_0 row7 gate_l1 mpl1_7_0 0 sky130_fd_pr__nfet_01v8 W=1.0u L=0.15u
Rrpl1_7_0 mpl1_7_0 cpl1_0 43407.4062
XTpl1_7_1 row7 gate_l1 mpl1_7_1 0 sky130_fd_pr__nfet_01v8 W=1.0u L=0.15u
Rrpl1_7_1 mpl1_7_1 cpl1_1 3378378.2500
XTpl1_7_2 row7 gate_l1 mpl1_7_2 0 sky130_fd_pr__nfet_01v8 W=1.0u L=0.15u
Rrpl1_7_2 mpl1_7_2 cpl1_2 17468.5020
XTpl1_7_3 row7 gate_l1 mpl1_7_3 0 sky130_fd_pr__nfet_01v8 W=1.0u L=0.15u
Rrpl1_7_3 mpl1_7_3 cpl1_3 64192.0977
XTpl1_7_4 row7 gate_l1 mpl1_7_4 0 sky130_fd_pr__nfet_01v8 W=1.0u L=0.15u
Rrpl1_7_4 mpl1_7_4 cpl1_4 3378378.2500
XTpl1_7_5 row7 gate_l1 mpl1_7_5 0 sky130_fd_pr__nfet_01v8 W=1.0u L=0.15u
Rrpl1_7_5 mpl1_7_5 cpl1_5 3378378.2500
XTpl1_7_6 row7 gate_l1 mpl1_7_6 0 sky130_fd_pr__nfet_01v8 W=1.0u L=0.15u
Rrpl1_7_6 mpl1_7_6 cpl1_6 3378378.2500
XTpl1_7_7 row7 gate_l1 mpl1_7_7 0 sky130_fd_pr__nfet_01v8 W=1.0u L=0.15u
Rrpl1_7_7 mpl1_7_7 cpl1_7 3378378.2500
XTpl1_7_8 row7 gate_l1 mpl1_7_8 0 sky130_fd_pr__nfet_01v8 W=1.0u L=0.15u
Rrpl1_7_8 mpl1_7_8 cpl1_8 55040.4766
XTpl1_7_9 row7 gate_l1 mpl1_7_9 0 sky130_fd_pr__nfet_01v8 W=1.0u L=0.15u
Rrpl1_7_9 mpl1_7_9 cpl1_9 3378378.2500
XTpl1_7_10 row7 gate_l1 mpl1_7_10 0 sky130_fd_pr__nfet_01v8 W=1.0u L=0.15u
Rrpl1_7_10 mpl1_7_10 cpl1_10 32192.2422
XTpl1_7_11 row7 gate_l1 mpl1_7_11 0 sky130_fd_pr__nfet_01v8 W=1.0u L=0.15u
Rrpl1_7_11 mpl1_7_11 cpl1_11 35761.1172
XTpl1_7_12 row7 gate_l1 mpl1_7_12 0 sky130_fd_pr__nfet_01v8 W=1.0u L=0.15u
Rrpl1_7_12 mpl1_7_12 cpl1_12 3378378.2500
XTpl1_7_13 row7 gate_l1 mpl1_7_13 0 sky130_fd_pr__nfet_01v8 W=1.0u L=0.15u
Rrpl1_7_13 mpl1_7_13 cpl1_13 34527.3984
XTpl1_7_14 row7 gate_l1 mpl1_7_14 0 sky130_fd_pr__nfet_01v8 W=1.0u L=0.15u
Rrpl1_7_14 mpl1_7_14 cpl1_14 584197.7500
XTpl1_7_15 row7 gate_l1 mpl1_7_15 0 sky130_fd_pr__nfet_01v8 W=1.0u L=0.15u
Rrpl1_7_15 mpl1_7_15 cpl1_15 35866.6367
XTpl1_7_16 row7 gate_l1 mpl1_7_16 0 sky130_fd_pr__nfet_01v8 W=1.0u L=0.15u
Rrpl1_7_16 mpl1_7_16 cpl1_16 3378378.2500
XTpl1_7_17 row7 gate_l1 mpl1_7_17 0 sky130_fd_pr__nfet_01v8 W=1.0u L=0.15u
Rrpl1_7_17 mpl1_7_17 cpl1_17 53365.7305
XTpl1_7_18 row7 gate_l1 mpl1_7_18 0 sky130_fd_pr__nfet_01v8 W=1.0u L=0.15u
Rrpl1_7_18 mpl1_7_18 cpl1_18 3378378.2500
XTpl1_7_19 row7 gate_l1 mpl1_7_19 0 sky130_fd_pr__nfet_01v8 W=1.0u L=0.15u
Rrpl1_7_19 mpl1_7_19 cpl1_19 3378378.2500
XTpl1_7_20 row7 gate_l1 mpl1_7_20 0 sky130_fd_pr__nfet_01v8 W=1.0u L=0.15u
Rrpl1_7_20 mpl1_7_20 cpl1_20 3378378.2500
XTpl1_7_21 row7 gate_l1 mpl1_7_21 0 sky130_fd_pr__nfet_01v8 W=1.0u L=0.15u
Rrpl1_7_21 mpl1_7_21 cpl1_21 3378378.2500
XTpl1_7_22 row7 gate_l1 mpl1_7_22 0 sky130_fd_pr__nfet_01v8 W=1.0u L=0.15u
Rrpl1_7_22 mpl1_7_22 cpl1_22 46814.5586
XTpl1_7_23 row7 gate_l1 mpl1_7_23 0 sky130_fd_pr__nfet_01v8 W=1.0u L=0.15u
Rrpl1_7_23 mpl1_7_23 cpl1_23 2332946.5000
XTpl1_7_24 row7 gate_l1 mpl1_7_24 0 sky130_fd_pr__nfet_01v8 W=1.0u L=0.15u
Rrpl1_7_24 mpl1_7_24 cpl1_24 17860.6523
XTpl1_7_25 row7 gate_l1 mpl1_7_25 0 sky130_fd_pr__nfet_01v8 W=1.0u L=0.15u
Rrpl1_7_25 mpl1_7_25 cpl1_25 90480.2812
XTpl1_7_26 row7 gate_l1 mpl1_7_26 0 sky130_fd_pr__nfet_01v8 W=1.0u L=0.15u
Rrpl1_7_26 mpl1_7_26 cpl1_26 25344.9980
XTpl1_7_27 row7 gate_l1 mpl1_7_27 0 sky130_fd_pr__nfet_01v8 W=1.0u L=0.15u
Rrpl1_7_27 mpl1_7_27 cpl1_27 53511.0898
XTpl1_7_28 row7 gate_l1 mpl1_7_28 0 sky130_fd_pr__nfet_01v8 W=1.0u L=0.15u
Rrpl1_7_28 mpl1_7_28 cpl1_28 3378378.2500
XTpl1_7_29 row7 gate_l1 mpl1_7_29 0 sky130_fd_pr__nfet_01v8 W=1.0u L=0.15u
Rrpl1_7_29 mpl1_7_29 cpl1_29 189972.8438
XTpl1_7_30 row7 gate_l1 mpl1_7_30 0 sky130_fd_pr__nfet_01v8 W=1.0u L=0.15u
Rrpl1_7_30 mpl1_7_30 cpl1_30 3378378.2500
XTpl1_7_31 row7 gate_l1 mpl1_7_31 0 sky130_fd_pr__nfet_01v8 W=1.0u L=0.15u
Rrpl1_7_31 mpl1_7_31 cpl1_31 3378378.2500
XTpl1_7_32 row7 gate_l1 mpl1_7_32 0 sky130_fd_pr__nfet_01v8 W=1.0u L=0.15u
Rrpl1_7_32 mpl1_7_32 cpl1_32 3378378.2500
XTpl1_7_33 row7 gate_l1 mpl1_7_33 0 sky130_fd_pr__nfet_01v8 W=1.0u L=0.15u
Rrpl1_7_33 mpl1_7_33 cpl1_33 88873.5625
XTpl1_7_34 row7 gate_l1 mpl1_7_34 0 sky130_fd_pr__nfet_01v8 W=1.0u L=0.15u
Rrpl1_7_34 mpl1_7_34 cpl1_34 201533.0156
XTpl1_7_35 row7 gate_l1 mpl1_7_35 0 sky130_fd_pr__nfet_01v8 W=1.0u L=0.15u
Rrpl1_7_35 mpl1_7_35 cpl1_35 214283.8125
XTpl1_7_36 row7 gate_l1 mpl1_7_36 0 sky130_fd_pr__nfet_01v8 W=1.0u L=0.15u
Rrpl1_7_36 mpl1_7_36 cpl1_36 3378378.2500
XTpl1_7_37 row7 gate_l1 mpl1_7_37 0 sky130_fd_pr__nfet_01v8 W=1.0u L=0.15u
Rrpl1_7_37 mpl1_7_37 cpl1_37 3378378.2500
XTpl1_7_38 row7 gate_l1 mpl1_7_38 0 sky130_fd_pr__nfet_01v8 W=1.0u L=0.15u
Rrpl1_7_38 mpl1_7_38 cpl1_38 26026.8613
XTpl1_7_39 row7 gate_l1 mpl1_7_39 0 sky130_fd_pr__nfet_01v8 W=1.0u L=0.15u
Rrpl1_7_39 mpl1_7_39 cpl1_39 3378378.2500
XTpl1_7_40 row7 gate_l1 mpl1_7_40 0 sky130_fd_pr__nfet_01v8 W=1.0u L=0.15u
Rrpl1_7_40 mpl1_7_40 cpl1_40 399908.4062
XTpl1_7_41 row7 gate_l1 mpl1_7_41 0 sky130_fd_pr__nfet_01v8 W=1.0u L=0.15u
Rrpl1_7_41 mpl1_7_41 cpl1_41 3378378.2500
XTpl1_7_42 row7 gate_l1 mpl1_7_42 0 sky130_fd_pr__nfet_01v8 W=1.0u L=0.15u
Rrpl1_7_42 mpl1_7_42 cpl1_42 3378378.2500
XTpl1_7_43 row7 gate_l1 mpl1_7_43 0 sky130_fd_pr__nfet_01v8 W=1.0u L=0.15u
Rrpl1_7_43 mpl1_7_43 cpl1_43 3378378.2500
XTpl1_7_44 row7 gate_l1 mpl1_7_44 0 sky130_fd_pr__nfet_01v8 W=1.0u L=0.15u
Rrpl1_7_44 mpl1_7_44 cpl1_44 3378378.2500
XTpl1_7_45 row7 gate_l1 mpl1_7_45 0 sky130_fd_pr__nfet_01v8 W=1.0u L=0.15u
Rrpl1_7_45 mpl1_7_45 cpl1_45 510394.5312
XTpl1_7_46 row7 gate_l1 mpl1_7_46 0 sky130_fd_pr__nfet_01v8 W=1.0u L=0.15u
Rrpl1_7_46 mpl1_7_46 cpl1_46 181142.9688
XTpl1_7_47 row7 gate_l1 mpl1_7_47 0 sky130_fd_pr__nfet_01v8 W=1.0u L=0.15u
Rrpl1_7_47 mpl1_7_47 cpl1_47 46380.0898
XTpl1_7_48 row7 gate_l1 mpl1_7_48 0 sky130_fd_pr__nfet_01v8 W=1.0u L=0.15u
Rrpl1_7_48 mpl1_7_48 cpl1_48 77930.8984
XTpl1_7_49 row7 gate_l1 mpl1_7_49 0 sky130_fd_pr__nfet_01v8 W=1.0u L=0.15u
Rrpl1_7_49 mpl1_7_49 cpl1_49 3378378.2500
XTpl1_7_50 row7 gate_l1 mpl1_7_50 0 sky130_fd_pr__nfet_01v8 W=1.0u L=0.15u
Rrpl1_7_50 mpl1_7_50 cpl1_50 3378378.2500
XTpl1_7_51 row7 gate_l1 mpl1_7_51 0 sky130_fd_pr__nfet_01v8 W=1.0u L=0.15u
Rrpl1_7_51 mpl1_7_51 cpl1_51 108235.5859
XTpl1_7_52 row7 gate_l1 mpl1_7_52 0 sky130_fd_pr__nfet_01v8 W=1.0u L=0.15u
Rrpl1_7_52 mpl1_7_52 cpl1_52 3378378.2500
XTpl1_7_53 row7 gate_l1 mpl1_7_53 0 sky130_fd_pr__nfet_01v8 W=1.0u L=0.15u
Rrpl1_7_53 mpl1_7_53 cpl1_53 3378378.2500
XTpl1_7_54 row7 gate_l1 mpl1_7_54 0 sky130_fd_pr__nfet_01v8 W=1.0u L=0.15u
Rrpl1_7_54 mpl1_7_54 cpl1_54 3378378.2500
XTpl1_7_55 row7 gate_l1 mpl1_7_55 0 sky130_fd_pr__nfet_01v8 W=1.0u L=0.15u
Rrpl1_7_55 mpl1_7_55 cpl1_55 3378378.2500
XTpl1_7_56 row7 gate_l1 mpl1_7_56 0 sky130_fd_pr__nfet_01v8 W=1.0u L=0.15u
Rrpl1_7_56 mpl1_7_56 cpl1_56 474649.3438
XTpl1_7_57 row7 gate_l1 mpl1_7_57 0 sky130_fd_pr__nfet_01v8 W=1.0u L=0.15u
Rrpl1_7_57 mpl1_7_57 cpl1_57 33213.4102
XTpl1_7_58 row7 gate_l1 mpl1_7_58 0 sky130_fd_pr__nfet_01v8 W=1.0u L=0.15u
Rrpl1_7_58 mpl1_7_58 cpl1_58 3378378.2500
XTpl1_7_59 row7 gate_l1 mpl1_7_59 0 sky130_fd_pr__nfet_01v8 W=1.0u L=0.15u
Rrpl1_7_59 mpl1_7_59 cpl1_59 567082.9375
XTpl1_7_60 row7 gate_l1 mpl1_7_60 0 sky130_fd_pr__nfet_01v8 W=1.0u L=0.15u
Rrpl1_7_60 mpl1_7_60 cpl1_60 44232.2656
XTpl1_7_61 row7 gate_l1 mpl1_7_61 0 sky130_fd_pr__nfet_01v8 W=1.0u L=0.15u
Rrpl1_7_61 mpl1_7_61 cpl1_61 3378378.2500
XTpl1_7_62 row7 gate_l1 mpl1_7_62 0 sky130_fd_pr__nfet_01v8 W=1.0u L=0.15u
Rrpl1_7_62 mpl1_7_62 cpl1_62 27943.3164
XTpl1_7_63 row7 gate_l1 mpl1_7_63 0 sky130_fd_pr__nfet_01v8 W=1.0u L=0.15u
Rrpl1_7_63 mpl1_7_63 cpl1_63 3378378.2500

* --- Negative conductance array ---
XTnl1_0_0 row0 gate_l1 mnl1_0_0 0 sky130_fd_pr__nfet_01v8 W=1.0u L=0.15u
Rrnl1_0_0 mnl1_0_0 cnl1_0 3378378.2500
XTnl1_0_1 row0 gate_l1 mnl1_0_1 0 sky130_fd_pr__nfet_01v8 W=1.0u L=0.15u
Rrnl1_0_1 mnl1_0_1 cnl1_1 104303.0625
XTnl1_0_2 row0 gate_l1 mnl1_0_2 0 sky130_fd_pr__nfet_01v8 W=1.0u L=0.15u
Rrnl1_0_2 mnl1_0_2 cnl1_2 90627.8672
XTnl1_0_3 row0 gate_l1 mnl1_0_3 0 sky130_fd_pr__nfet_01v8 W=1.0u L=0.15u
Rrnl1_0_3 mnl1_0_3 cnl1_3 124070.4375
XTnl1_0_4 row0 gate_l1 mnl1_0_4 0 sky130_fd_pr__nfet_01v8 W=1.0u L=0.15u
Rrnl1_0_4 mnl1_0_4 cnl1_4 3378378.2500
XTnl1_0_5 row0 gate_l1 mnl1_0_5 0 sky130_fd_pr__nfet_01v8 W=1.0u L=0.15u
Rrnl1_0_5 mnl1_0_5 cnl1_5 3378378.2500
XTnl1_0_6 row0 gate_l1 mnl1_0_6 0 sky130_fd_pr__nfet_01v8 W=1.0u L=0.15u
Rrnl1_0_6 mnl1_0_6 cnl1_6 358799.0312
XTnl1_0_7 row0 gate_l1 mnl1_0_7 0 sky130_fd_pr__nfet_01v8 W=1.0u L=0.15u
Rrnl1_0_7 mnl1_0_7 cnl1_7 135941.5938
XTnl1_0_8 row0 gate_l1 mnl1_0_8 0 sky130_fd_pr__nfet_01v8 W=1.0u L=0.15u
Rrnl1_0_8 mnl1_0_8 cnl1_8 3378378.2500
XTnl1_0_9 row0 gate_l1 mnl1_0_9 0 sky130_fd_pr__nfet_01v8 W=1.0u L=0.15u
Rrnl1_0_9 mnl1_0_9 cnl1_9 3378378.2500
XTnl1_0_10 row0 gate_l1 mnl1_0_10 0 sky130_fd_pr__nfet_01v8 W=1.0u L=0.15u
Rrnl1_0_10 mnl1_0_10 cnl1_10 3378378.2500
XTnl1_0_11 row0 gate_l1 mnl1_0_11 0 sky130_fd_pr__nfet_01v8 W=1.0u L=0.15u
Rrnl1_0_11 mnl1_0_11 cnl1_11 3378378.2500
XTnl1_0_12 row0 gate_l1 mnl1_0_12 0 sky130_fd_pr__nfet_01v8 W=1.0u L=0.15u
Rrnl1_0_12 mnl1_0_12 cnl1_12 138792.1406
XTnl1_0_13 row0 gate_l1 mnl1_0_13 0 sky130_fd_pr__nfet_01v8 W=1.0u L=0.15u
Rrnl1_0_13 mnl1_0_13 cnl1_13 155873.7500
XTnl1_0_14 row0 gate_l1 mnl1_0_14 0 sky130_fd_pr__nfet_01v8 W=1.0u L=0.15u
Rrnl1_0_14 mnl1_0_14 cnl1_14 3378378.2500
XTnl1_0_15 row0 gate_l1 mnl1_0_15 0 sky130_fd_pr__nfet_01v8 W=1.0u L=0.15u
Rrnl1_0_15 mnl1_0_15 cnl1_15 3378378.2500
XTnl1_0_16 row0 gate_l1 mnl1_0_16 0 sky130_fd_pr__nfet_01v8 W=1.0u L=0.15u
Rrnl1_0_16 mnl1_0_16 cnl1_16 3378378.2500
XTnl1_0_17 row0 gate_l1 mnl1_0_17 0 sky130_fd_pr__nfet_01v8 W=1.0u L=0.15u
Rrnl1_0_17 mnl1_0_17 cnl1_17 3378378.2500
XTnl1_0_18 row0 gate_l1 mnl1_0_18 0 sky130_fd_pr__nfet_01v8 W=1.0u L=0.15u
Rrnl1_0_18 mnl1_0_18 cnl1_18 3378378.2500
XTnl1_0_19 row0 gate_l1 mnl1_0_19 0 sky130_fd_pr__nfet_01v8 W=1.0u L=0.15u
Rrnl1_0_19 mnl1_0_19 cnl1_19 121341.6406
XTnl1_0_20 row0 gate_l1 mnl1_0_20 0 sky130_fd_pr__nfet_01v8 W=1.0u L=0.15u
Rrnl1_0_20 mnl1_0_20 cnl1_20 193890.7188
XTnl1_0_21 row0 gate_l1 mnl1_0_21 0 sky130_fd_pr__nfet_01v8 W=1.0u L=0.15u
Rrnl1_0_21 mnl1_0_21 cnl1_21 192226.8438
XTnl1_0_22 row0 gate_l1 mnl1_0_22 0 sky130_fd_pr__nfet_01v8 W=1.0u L=0.15u
Rrnl1_0_22 mnl1_0_22 cnl1_22 3378378.2500
XTnl1_0_23 row0 gate_l1 mnl1_0_23 0 sky130_fd_pr__nfet_01v8 W=1.0u L=0.15u
Rrnl1_0_23 mnl1_0_23 cnl1_23 3378378.2500
XTnl1_0_24 row0 gate_l1 mnl1_0_24 0 sky130_fd_pr__nfet_01v8 W=1.0u L=0.15u
Rrnl1_0_24 mnl1_0_24 cnl1_24 3378378.2500
XTnl1_0_25 row0 gate_l1 mnl1_0_25 0 sky130_fd_pr__nfet_01v8 W=1.0u L=0.15u
Rrnl1_0_25 mnl1_0_25 cnl1_25 3378378.2500
XTnl1_0_26 row0 gate_l1 mnl1_0_26 0 sky130_fd_pr__nfet_01v8 W=1.0u L=0.15u
Rrnl1_0_26 mnl1_0_26 cnl1_26 3378378.2500
XTnl1_0_27 row0 gate_l1 mnl1_0_27 0 sky130_fd_pr__nfet_01v8 W=1.0u L=0.15u
Rrnl1_0_27 mnl1_0_27 cnl1_27 50280.1250
XTnl1_0_28 row0 gate_l1 mnl1_0_28 0 sky130_fd_pr__nfet_01v8 W=1.0u L=0.15u
Rrnl1_0_28 mnl1_0_28 cnl1_28 3378378.2500
XTnl1_0_29 row0 gate_l1 mnl1_0_29 0 sky130_fd_pr__nfet_01v8 W=1.0u L=0.15u
Rrnl1_0_29 mnl1_0_29 cnl1_29 129598.2031
XTnl1_0_30 row0 gate_l1 mnl1_0_30 0 sky130_fd_pr__nfet_01v8 W=1.0u L=0.15u
Rrnl1_0_30 mnl1_0_30 cnl1_30 21774.7207
XTnl1_0_31 row0 gate_l1 mnl1_0_31 0 sky130_fd_pr__nfet_01v8 W=1.0u L=0.15u
Rrnl1_0_31 mnl1_0_31 cnl1_31 1071796.6250
XTnl1_0_32 row0 gate_l1 mnl1_0_32 0 sky130_fd_pr__nfet_01v8 W=1.0u L=0.15u
Rrnl1_0_32 mnl1_0_32 cnl1_32 32095.7969
XTnl1_0_33 row0 gate_l1 mnl1_0_33 0 sky130_fd_pr__nfet_01v8 W=1.0u L=0.15u
Rrnl1_0_33 mnl1_0_33 cnl1_33 727091.0000
XTnl1_0_34 row0 gate_l1 mnl1_0_34 0 sky130_fd_pr__nfet_01v8 W=1.0u L=0.15u
Rrnl1_0_34 mnl1_0_34 cnl1_34 3378378.2500
XTnl1_0_35 row0 gate_l1 mnl1_0_35 0 sky130_fd_pr__nfet_01v8 W=1.0u L=0.15u
Rrnl1_0_35 mnl1_0_35 cnl1_35 3378378.2500
XTnl1_0_36 row0 gate_l1 mnl1_0_36 0 sky130_fd_pr__nfet_01v8 W=1.0u L=0.15u
Rrnl1_0_36 mnl1_0_36 cnl1_36 3378378.2500
XTnl1_0_37 row0 gate_l1 mnl1_0_37 0 sky130_fd_pr__nfet_01v8 W=1.0u L=0.15u
Rrnl1_0_37 mnl1_0_37 cnl1_37 3378378.2500
XTnl1_0_38 row0 gate_l1 mnl1_0_38 0 sky130_fd_pr__nfet_01v8 W=1.0u L=0.15u
Rrnl1_0_38 mnl1_0_38 cnl1_38 708953.7500
XTnl1_0_39 row0 gate_l1 mnl1_0_39 0 sky130_fd_pr__nfet_01v8 W=1.0u L=0.15u
Rrnl1_0_39 mnl1_0_39 cnl1_39 3378378.2500
XTnl1_0_40 row0 gate_l1 mnl1_0_40 0 sky130_fd_pr__nfet_01v8 W=1.0u L=0.15u
Rrnl1_0_40 mnl1_0_40 cnl1_40 3378378.2500
XTnl1_0_41 row0 gate_l1 mnl1_0_41 0 sky130_fd_pr__nfet_01v8 W=1.0u L=0.15u
Rrnl1_0_41 mnl1_0_41 cnl1_41 23466.4785
XTnl1_0_42 row0 gate_l1 mnl1_0_42 0 sky130_fd_pr__nfet_01v8 W=1.0u L=0.15u
Rrnl1_0_42 mnl1_0_42 cnl1_42 3378378.2500
XTnl1_0_43 row0 gate_l1 mnl1_0_43 0 sky130_fd_pr__nfet_01v8 W=1.0u L=0.15u
Rrnl1_0_43 mnl1_0_43 cnl1_43 3378378.2500
XTnl1_0_44 row0 gate_l1 mnl1_0_44 0 sky130_fd_pr__nfet_01v8 W=1.0u L=0.15u
Rrnl1_0_44 mnl1_0_44 cnl1_44 3378378.2500
XTnl1_0_45 row0 gate_l1 mnl1_0_45 0 sky130_fd_pr__nfet_01v8 W=1.0u L=0.15u
Rrnl1_0_45 mnl1_0_45 cnl1_45 3378378.2500
XTnl1_0_46 row0 gate_l1 mnl1_0_46 0 sky130_fd_pr__nfet_01v8 W=1.0u L=0.15u
Rrnl1_0_46 mnl1_0_46 cnl1_46 3378378.2500
XTnl1_0_47 row0 gate_l1 mnl1_0_47 0 sky130_fd_pr__nfet_01v8 W=1.0u L=0.15u
Rrnl1_0_47 mnl1_0_47 cnl1_47 3378378.2500
XTnl1_0_48 row0 gate_l1 mnl1_0_48 0 sky130_fd_pr__nfet_01v8 W=1.0u L=0.15u
Rrnl1_0_48 mnl1_0_48 cnl1_48 3378378.2500
XTnl1_0_49 row0 gate_l1 mnl1_0_49 0 sky130_fd_pr__nfet_01v8 W=1.0u L=0.15u
Rrnl1_0_49 mnl1_0_49 cnl1_49 140632.0781
XTnl1_0_50 row0 gate_l1 mnl1_0_50 0 sky130_fd_pr__nfet_01v8 W=1.0u L=0.15u
Rrnl1_0_50 mnl1_0_50 cnl1_50 3378378.2500
XTnl1_0_51 row0 gate_l1 mnl1_0_51 0 sky130_fd_pr__nfet_01v8 W=1.0u L=0.15u
Rrnl1_0_51 mnl1_0_51 cnl1_51 3378378.2500
XTnl1_0_52 row0 gate_l1 mnl1_0_52 0 sky130_fd_pr__nfet_01v8 W=1.0u L=0.15u
Rrnl1_0_52 mnl1_0_52 cnl1_52 87869.6406
XTnl1_0_53 row0 gate_l1 mnl1_0_53 0 sky130_fd_pr__nfet_01v8 W=1.0u L=0.15u
Rrnl1_0_53 mnl1_0_53 cnl1_53 22571.6953
XTnl1_0_54 row0 gate_l1 mnl1_0_54 0 sky130_fd_pr__nfet_01v8 W=1.0u L=0.15u
Rrnl1_0_54 mnl1_0_54 cnl1_54 3378378.2500
XTnl1_0_55 row0 gate_l1 mnl1_0_55 0 sky130_fd_pr__nfet_01v8 W=1.0u L=0.15u
Rrnl1_0_55 mnl1_0_55 cnl1_55 35712.9961
XTnl1_0_56 row0 gate_l1 mnl1_0_56 0 sky130_fd_pr__nfet_01v8 W=1.0u L=0.15u
Rrnl1_0_56 mnl1_0_56 cnl1_56 3378378.2500
XTnl1_0_57 row0 gate_l1 mnl1_0_57 0 sky130_fd_pr__nfet_01v8 W=1.0u L=0.15u
Rrnl1_0_57 mnl1_0_57 cnl1_57 32244.7754
XTnl1_0_58 row0 gate_l1 mnl1_0_58 0 sky130_fd_pr__nfet_01v8 W=1.0u L=0.15u
Rrnl1_0_58 mnl1_0_58 cnl1_58 65425.3320
XTnl1_0_59 row0 gate_l1 mnl1_0_59 0 sky130_fd_pr__nfet_01v8 W=1.0u L=0.15u
Rrnl1_0_59 mnl1_0_59 cnl1_59 90955.4609
XTnl1_0_60 row0 gate_l1 mnl1_0_60 0 sky130_fd_pr__nfet_01v8 W=1.0u L=0.15u
Rrnl1_0_60 mnl1_0_60 cnl1_60 383586.6562
XTnl1_0_61 row0 gate_l1 mnl1_0_61 0 sky130_fd_pr__nfet_01v8 W=1.0u L=0.15u
Rrnl1_0_61 mnl1_0_61 cnl1_61 203512.9531
XTnl1_0_62 row0 gate_l1 mnl1_0_62 0 sky130_fd_pr__nfet_01v8 W=1.0u L=0.15u
Rrnl1_0_62 mnl1_0_62 cnl1_62 3378378.2500
XTnl1_0_63 row0 gate_l1 mnl1_0_63 0 sky130_fd_pr__nfet_01v8 W=1.0u L=0.15u
Rrnl1_0_63 mnl1_0_63 cnl1_63 3378378.2500
XTnl1_1_0 row1 gate_l1 mnl1_1_0 0 sky130_fd_pr__nfet_01v8 W=1.0u L=0.15u
Rrnl1_1_0 mnl1_1_0 cnl1_0 316519.9062
XTnl1_1_1 row1 gate_l1 mnl1_1_1 0 sky130_fd_pr__nfet_01v8 W=1.0u L=0.15u
Rrnl1_1_1 mnl1_1_1 cnl1_1 174894.7031
XTnl1_1_2 row1 gate_l1 mnl1_1_2 0 sky130_fd_pr__nfet_01v8 W=1.0u L=0.15u
Rrnl1_1_2 mnl1_1_2 cnl1_2 188711.0781
XTnl1_1_3 row1 gate_l1 mnl1_1_3 0 sky130_fd_pr__nfet_01v8 W=1.0u L=0.15u
Rrnl1_1_3 mnl1_1_3 cnl1_3 3378378.2500
XTnl1_1_4 row1 gate_l1 mnl1_1_4 0 sky130_fd_pr__nfet_01v8 W=1.0u L=0.15u
Rrnl1_1_4 mnl1_1_4 cnl1_4 3378378.2500
XTnl1_1_5 row1 gate_l1 mnl1_1_5 0 sky130_fd_pr__nfet_01v8 W=1.0u L=0.15u
Rrnl1_1_5 mnl1_1_5 cnl1_5 15146.9834
XTnl1_1_6 row1 gate_l1 mnl1_1_6 0 sky130_fd_pr__nfet_01v8 W=1.0u L=0.15u
Rrnl1_1_6 mnl1_1_6 cnl1_6 3378378.2500
XTnl1_1_7 row1 gate_l1 mnl1_1_7 0 sky130_fd_pr__nfet_01v8 W=1.0u L=0.15u
Rrnl1_1_7 mnl1_1_7 cnl1_7 3378378.2500
XTnl1_1_8 row1 gate_l1 mnl1_1_8 0 sky130_fd_pr__nfet_01v8 W=1.0u L=0.15u
Rrnl1_1_8 mnl1_1_8 cnl1_8 47611.3008
XTnl1_1_9 row1 gate_l1 mnl1_1_9 0 sky130_fd_pr__nfet_01v8 W=1.0u L=0.15u
Rrnl1_1_9 mnl1_1_9 cnl1_9 20410.1152
XTnl1_1_10 row1 gate_l1 mnl1_1_10 0 sky130_fd_pr__nfet_01v8 W=1.0u L=0.15u
Rrnl1_1_10 mnl1_1_10 cnl1_10 3378378.2500
XTnl1_1_11 row1 gate_l1 mnl1_1_11 0 sky130_fd_pr__nfet_01v8 W=1.0u L=0.15u
Rrnl1_1_11 mnl1_1_11 cnl1_11 1675549.6250
XTnl1_1_12 row1 gate_l1 mnl1_1_12 0 sky130_fd_pr__nfet_01v8 W=1.0u L=0.15u
Rrnl1_1_12 mnl1_1_12 cnl1_12 3378378.2500
XTnl1_1_13 row1 gate_l1 mnl1_1_13 0 sky130_fd_pr__nfet_01v8 W=1.0u L=0.15u
Rrnl1_1_13 mnl1_1_13 cnl1_13 3378378.2500
XTnl1_1_14 row1 gate_l1 mnl1_1_14 0 sky130_fd_pr__nfet_01v8 W=1.0u L=0.15u
Rrnl1_1_14 mnl1_1_14 cnl1_14 3378378.2500
XTnl1_1_15 row1 gate_l1 mnl1_1_15 0 sky130_fd_pr__nfet_01v8 W=1.0u L=0.15u
Rrnl1_1_15 mnl1_1_15 cnl1_15 3378378.2500
XTnl1_1_16 row1 gate_l1 mnl1_1_16 0 sky130_fd_pr__nfet_01v8 W=1.0u L=0.15u
Rrnl1_1_16 mnl1_1_16 cnl1_16 3378378.2500
XTnl1_1_17 row1 gate_l1 mnl1_1_17 0 sky130_fd_pr__nfet_01v8 W=1.0u L=0.15u
Rrnl1_1_17 mnl1_1_17 cnl1_17 37639.4648
XTnl1_1_18 row1 gate_l1 mnl1_1_18 0 sky130_fd_pr__nfet_01v8 W=1.0u L=0.15u
Rrnl1_1_18 mnl1_1_18 cnl1_18 116318.3281
XTnl1_1_19 row1 gate_l1 mnl1_1_19 0 sky130_fd_pr__nfet_01v8 W=1.0u L=0.15u
Rrnl1_1_19 mnl1_1_19 cnl1_19 3378378.2500
XTnl1_1_20 row1 gate_l1 mnl1_1_20 0 sky130_fd_pr__nfet_01v8 W=1.0u L=0.15u
Rrnl1_1_20 mnl1_1_20 cnl1_20 13791.6738
XTnl1_1_21 row1 gate_l1 mnl1_1_21 0 sky130_fd_pr__nfet_01v8 W=1.0u L=0.15u
Rrnl1_1_21 mnl1_1_21 cnl1_21 196744.4531
XTnl1_1_22 row1 gate_l1 mnl1_1_22 0 sky130_fd_pr__nfet_01v8 W=1.0u L=0.15u
Rrnl1_1_22 mnl1_1_22 cnl1_22 22129.4609
XTnl1_1_23 row1 gate_l1 mnl1_1_23 0 sky130_fd_pr__nfet_01v8 W=1.0u L=0.15u
Rrnl1_1_23 mnl1_1_23 cnl1_23 3378378.2500
XTnl1_1_24 row1 gate_l1 mnl1_1_24 0 sky130_fd_pr__nfet_01v8 W=1.0u L=0.15u
Rrnl1_1_24 mnl1_1_24 cnl1_24 180657.5469
XTnl1_1_25 row1 gate_l1 mnl1_1_25 0 sky130_fd_pr__nfet_01v8 W=1.0u L=0.15u
Rrnl1_1_25 mnl1_1_25 cnl1_25 3378378.2500
XTnl1_1_26 row1 gate_l1 mnl1_1_26 0 sky130_fd_pr__nfet_01v8 W=1.0u L=0.15u
Rrnl1_1_26 mnl1_1_26 cnl1_26 3378378.2500
XTnl1_1_27 row1 gate_l1 mnl1_1_27 0 sky130_fd_pr__nfet_01v8 W=1.0u L=0.15u
Rrnl1_1_27 mnl1_1_27 cnl1_27 3378378.2500
XTnl1_1_28 row1 gate_l1 mnl1_1_28 0 sky130_fd_pr__nfet_01v8 W=1.0u L=0.15u
Rrnl1_1_28 mnl1_1_28 cnl1_28 60678.8906
XTnl1_1_29 row1 gate_l1 mnl1_1_29 0 sky130_fd_pr__nfet_01v8 W=1.0u L=0.15u
Rrnl1_1_29 mnl1_1_29 cnl1_29 3378378.2500
XTnl1_1_30 row1 gate_l1 mnl1_1_30 0 sky130_fd_pr__nfet_01v8 W=1.0u L=0.15u
Rrnl1_1_30 mnl1_1_30 cnl1_30 78143.7969
XTnl1_1_31 row1 gate_l1 mnl1_1_31 0 sky130_fd_pr__nfet_01v8 W=1.0u L=0.15u
Rrnl1_1_31 mnl1_1_31 cnl1_31 402205.9062
XTnl1_1_32 row1 gate_l1 mnl1_1_32 0 sky130_fd_pr__nfet_01v8 W=1.0u L=0.15u
Rrnl1_1_32 mnl1_1_32 cnl1_32 39565.0039
XTnl1_1_33 row1 gate_l1 mnl1_1_33 0 sky130_fd_pr__nfet_01v8 W=1.0u L=0.15u
Rrnl1_1_33 mnl1_1_33 cnl1_33 107841.8438
XTnl1_1_34 row1 gate_l1 mnl1_1_34 0 sky130_fd_pr__nfet_01v8 W=1.0u L=0.15u
Rrnl1_1_34 mnl1_1_34 cnl1_34 3378378.2500
XTnl1_1_35 row1 gate_l1 mnl1_1_35 0 sky130_fd_pr__nfet_01v8 W=1.0u L=0.15u
Rrnl1_1_35 mnl1_1_35 cnl1_35 500821.1875
XTnl1_1_36 row1 gate_l1 mnl1_1_36 0 sky130_fd_pr__nfet_01v8 W=1.0u L=0.15u
Rrnl1_1_36 mnl1_1_36 cnl1_36 97463.0234
XTnl1_1_37 row1 gate_l1 mnl1_1_37 0 sky130_fd_pr__nfet_01v8 W=1.0u L=0.15u
Rrnl1_1_37 mnl1_1_37 cnl1_37 81207.3203
XTnl1_1_38 row1 gate_l1 mnl1_1_38 0 sky130_fd_pr__nfet_01v8 W=1.0u L=0.15u
Rrnl1_1_38 mnl1_1_38 cnl1_38 180408.5312
XTnl1_1_39 row1 gate_l1 mnl1_1_39 0 sky130_fd_pr__nfet_01v8 W=1.0u L=0.15u
Rrnl1_1_39 mnl1_1_39 cnl1_39 186219.8906
XTnl1_1_40 row1 gate_l1 mnl1_1_40 0 sky130_fd_pr__nfet_01v8 W=1.0u L=0.15u
Rrnl1_1_40 mnl1_1_40 cnl1_40 17262.0273
XTnl1_1_41 row1 gate_l1 mnl1_1_41 0 sky130_fd_pr__nfet_01v8 W=1.0u L=0.15u
Rrnl1_1_41 mnl1_1_41 cnl1_41 3378378.2500
XTnl1_1_42 row1 gate_l1 mnl1_1_42 0 sky130_fd_pr__nfet_01v8 W=1.0u L=0.15u
Rrnl1_1_42 mnl1_1_42 cnl1_42 292869.1562
XTnl1_1_43 row1 gate_l1 mnl1_1_43 0 sky130_fd_pr__nfet_01v8 W=1.0u L=0.15u
Rrnl1_1_43 mnl1_1_43 cnl1_43 124212.1641
XTnl1_1_44 row1 gate_l1 mnl1_1_44 0 sky130_fd_pr__nfet_01v8 W=1.0u L=0.15u
Rrnl1_1_44 mnl1_1_44 cnl1_44 101631.6484
XTnl1_1_45 row1 gate_l1 mnl1_1_45 0 sky130_fd_pr__nfet_01v8 W=1.0u L=0.15u
Rrnl1_1_45 mnl1_1_45 cnl1_45 84836.6719
XTnl1_1_46 row1 gate_l1 mnl1_1_46 0 sky130_fd_pr__nfet_01v8 W=1.0u L=0.15u
Rrnl1_1_46 mnl1_1_46 cnl1_46 21870.2480
XTnl1_1_47 row1 gate_l1 mnl1_1_47 0 sky130_fd_pr__nfet_01v8 W=1.0u L=0.15u
Rrnl1_1_47 mnl1_1_47 cnl1_47 3378378.2500
XTnl1_1_48 row1 gate_l1 mnl1_1_48 0 sky130_fd_pr__nfet_01v8 W=1.0u L=0.15u
Rrnl1_1_48 mnl1_1_48 cnl1_48 334308.6250
XTnl1_1_49 row1 gate_l1 mnl1_1_49 0 sky130_fd_pr__nfet_01v8 W=1.0u L=0.15u
Rrnl1_1_49 mnl1_1_49 cnl1_49 3378378.2500
XTnl1_1_50 row1 gate_l1 mnl1_1_50 0 sky130_fd_pr__nfet_01v8 W=1.0u L=0.15u
Rrnl1_1_50 mnl1_1_50 cnl1_50 48579.4609
XTnl1_1_51 row1 gate_l1 mnl1_1_51 0 sky130_fd_pr__nfet_01v8 W=1.0u L=0.15u
Rrnl1_1_51 mnl1_1_51 cnl1_51 3378378.2500
XTnl1_1_52 row1 gate_l1 mnl1_1_52 0 sky130_fd_pr__nfet_01v8 W=1.0u L=0.15u
Rrnl1_1_52 mnl1_1_52 cnl1_52 28985.6074
XTnl1_1_53 row1 gate_l1 mnl1_1_53 0 sky130_fd_pr__nfet_01v8 W=1.0u L=0.15u
Rrnl1_1_53 mnl1_1_53 cnl1_53 3378378.2500
XTnl1_1_54 row1 gate_l1 mnl1_1_54 0 sky130_fd_pr__nfet_01v8 W=1.0u L=0.15u
Rrnl1_1_54 mnl1_1_54 cnl1_54 3378378.2500
XTnl1_1_55 row1 gate_l1 mnl1_1_55 0 sky130_fd_pr__nfet_01v8 W=1.0u L=0.15u
Rrnl1_1_55 mnl1_1_55 cnl1_55 52232.7148
XTnl1_1_56 row1 gate_l1 mnl1_1_56 0 sky130_fd_pr__nfet_01v8 W=1.0u L=0.15u
Rrnl1_1_56 mnl1_1_56 cnl1_56 330883.5312
XTnl1_1_57 row1 gate_l1 mnl1_1_57 0 sky130_fd_pr__nfet_01v8 W=1.0u L=0.15u
Rrnl1_1_57 mnl1_1_57 cnl1_57 3378378.2500
XTnl1_1_58 row1 gate_l1 mnl1_1_58 0 sky130_fd_pr__nfet_01v8 W=1.0u L=0.15u
Rrnl1_1_58 mnl1_1_58 cnl1_58 3378378.2500
XTnl1_1_59 row1 gate_l1 mnl1_1_59 0 sky130_fd_pr__nfet_01v8 W=1.0u L=0.15u
Rrnl1_1_59 mnl1_1_59 cnl1_59 44575.0195
XTnl1_1_60 row1 gate_l1 mnl1_1_60 0 sky130_fd_pr__nfet_01v8 W=1.0u L=0.15u
Rrnl1_1_60 mnl1_1_60 cnl1_60 908324.5625
XTnl1_1_61 row1 gate_l1 mnl1_1_61 0 sky130_fd_pr__nfet_01v8 W=1.0u L=0.15u
Rrnl1_1_61 mnl1_1_61 cnl1_61 68057.2578
XTnl1_1_62 row1 gate_l1 mnl1_1_62 0 sky130_fd_pr__nfet_01v8 W=1.0u L=0.15u
Rrnl1_1_62 mnl1_1_62 cnl1_62 464044.7188
XTnl1_1_63 row1 gate_l1 mnl1_1_63 0 sky130_fd_pr__nfet_01v8 W=1.0u L=0.15u
Rrnl1_1_63 mnl1_1_63 cnl1_63 177298.6250
XTnl1_2_0 row2 gate_l1 mnl1_2_0 0 sky130_fd_pr__nfet_01v8 W=1.0u L=0.15u
Rrnl1_2_0 mnl1_2_0 cnl1_0 3378378.2500
XTnl1_2_1 row2 gate_l1 mnl1_2_1 0 sky130_fd_pr__nfet_01v8 W=1.0u L=0.15u
Rrnl1_2_1 mnl1_2_1 cnl1_1 78404.2656
XTnl1_2_2 row2 gate_l1 mnl1_2_2 0 sky130_fd_pr__nfet_01v8 W=1.0u L=0.15u
Rrnl1_2_2 mnl1_2_2 cnl1_2 3378378.2500
XTnl1_2_3 row2 gate_l1 mnl1_2_3 0 sky130_fd_pr__nfet_01v8 W=1.0u L=0.15u
Rrnl1_2_3 mnl1_2_3 cnl1_3 53801.0508
XTnl1_2_4 row2 gate_l1 mnl1_2_4 0 sky130_fd_pr__nfet_01v8 W=1.0u L=0.15u
Rrnl1_2_4 mnl1_2_4 cnl1_4 3378378.2500
XTnl1_2_5 row2 gate_l1 mnl1_2_5 0 sky130_fd_pr__nfet_01v8 W=1.0u L=0.15u
Rrnl1_2_5 mnl1_2_5 cnl1_5 430330.6875
XTnl1_2_6 row2 gate_l1 mnl1_2_6 0 sky130_fd_pr__nfet_01v8 W=1.0u L=0.15u
Rrnl1_2_6 mnl1_2_6 cnl1_6 94403.9688
XTnl1_2_7 row2 gate_l1 mnl1_2_7 0 sky130_fd_pr__nfet_01v8 W=1.0u L=0.15u
Rrnl1_2_7 mnl1_2_7 cnl1_7 3378378.2500
XTnl1_2_8 row2 gate_l1 mnl1_2_8 0 sky130_fd_pr__nfet_01v8 W=1.0u L=0.15u
Rrnl1_2_8 mnl1_2_8 cnl1_8 231787.3594
XTnl1_2_9 row2 gate_l1 mnl1_2_9 0 sky130_fd_pr__nfet_01v8 W=1.0u L=0.15u
Rrnl1_2_9 mnl1_2_9 cnl1_9 3378378.2500
XTnl1_2_10 row2 gate_l1 mnl1_2_10 0 sky130_fd_pr__nfet_01v8 W=1.0u L=0.15u
Rrnl1_2_10 mnl1_2_10 cnl1_10 412453.3438
XTnl1_2_11 row2 gate_l1 mnl1_2_11 0 sky130_fd_pr__nfet_01v8 W=1.0u L=0.15u
Rrnl1_2_11 mnl1_2_11 cnl1_11 3378378.2500
XTnl1_2_12 row2 gate_l1 mnl1_2_12 0 sky130_fd_pr__nfet_01v8 W=1.0u L=0.15u
Rrnl1_2_12 mnl1_2_12 cnl1_12 3378378.2500
XTnl1_2_13 row2 gate_l1 mnl1_2_13 0 sky130_fd_pr__nfet_01v8 W=1.0u L=0.15u
Rrnl1_2_13 mnl1_2_13 cnl1_13 3378378.2500
XTnl1_2_14 row2 gate_l1 mnl1_2_14 0 sky130_fd_pr__nfet_01v8 W=1.0u L=0.15u
Rrnl1_2_14 mnl1_2_14 cnl1_14 3378378.2500
XTnl1_2_15 row2 gate_l1 mnl1_2_15 0 sky130_fd_pr__nfet_01v8 W=1.0u L=0.15u
Rrnl1_2_15 mnl1_2_15 cnl1_15 512198.5625
XTnl1_2_16 row2 gate_l1 mnl1_2_16 0 sky130_fd_pr__nfet_01v8 W=1.0u L=0.15u
Rrnl1_2_16 mnl1_2_16 cnl1_16 3378378.2500
XTnl1_2_17 row2 gate_l1 mnl1_2_17 0 sky130_fd_pr__nfet_01v8 W=1.0u L=0.15u
Rrnl1_2_17 mnl1_2_17 cnl1_17 91887.9141
XTnl1_2_18 row2 gate_l1 mnl1_2_18 0 sky130_fd_pr__nfet_01v8 W=1.0u L=0.15u
Rrnl1_2_18 mnl1_2_18 cnl1_18 3378378.2500
XTnl1_2_19 row2 gate_l1 mnl1_2_19 0 sky130_fd_pr__nfet_01v8 W=1.0u L=0.15u
Rrnl1_2_19 mnl1_2_19 cnl1_19 3378378.2500
XTnl1_2_20 row2 gate_l1 mnl1_2_20 0 sky130_fd_pr__nfet_01v8 W=1.0u L=0.15u
Rrnl1_2_20 mnl1_2_20 cnl1_20 800843.9375
XTnl1_2_21 row2 gate_l1 mnl1_2_21 0 sky130_fd_pr__nfet_01v8 W=1.0u L=0.15u
Rrnl1_2_21 mnl1_2_21 cnl1_21 3378378.2500
XTnl1_2_22 row2 gate_l1 mnl1_2_22 0 sky130_fd_pr__nfet_01v8 W=1.0u L=0.15u
Rrnl1_2_22 mnl1_2_22 cnl1_22 119606.1953
XTnl1_2_23 row2 gate_l1 mnl1_2_23 0 sky130_fd_pr__nfet_01v8 W=1.0u L=0.15u
Rrnl1_2_23 mnl1_2_23 cnl1_23 3378378.2500
XTnl1_2_24 row2 gate_l1 mnl1_2_24 0 sky130_fd_pr__nfet_01v8 W=1.0u L=0.15u
Rrnl1_2_24 mnl1_2_24 cnl1_24 3378378.2500
XTnl1_2_25 row2 gate_l1 mnl1_2_25 0 sky130_fd_pr__nfet_01v8 W=1.0u L=0.15u
Rrnl1_2_25 mnl1_2_25 cnl1_25 3378378.2500
XTnl1_2_26 row2 gate_l1 mnl1_2_26 0 sky130_fd_pr__nfet_01v8 W=1.0u L=0.15u
Rrnl1_2_26 mnl1_2_26 cnl1_26 3378378.2500
XTnl1_2_27 row2 gate_l1 mnl1_2_27 0 sky130_fd_pr__nfet_01v8 W=1.0u L=0.15u
Rrnl1_2_27 mnl1_2_27 cnl1_27 3378378.2500
XTnl1_2_28 row2 gate_l1 mnl1_2_28 0 sky130_fd_pr__nfet_01v8 W=1.0u L=0.15u
Rrnl1_2_28 mnl1_2_28 cnl1_28 984829.4375
XTnl1_2_29 row2 gate_l1 mnl1_2_29 0 sky130_fd_pr__nfet_01v8 W=1.0u L=0.15u
Rrnl1_2_29 mnl1_2_29 cnl1_29 3378378.2500
XTnl1_2_30 row2 gate_l1 mnl1_2_30 0 sky130_fd_pr__nfet_01v8 W=1.0u L=0.15u
Rrnl1_2_30 mnl1_2_30 cnl1_30 3378378.2500
XTnl1_2_31 row2 gate_l1 mnl1_2_31 0 sky130_fd_pr__nfet_01v8 W=1.0u L=0.15u
Rrnl1_2_31 mnl1_2_31 cnl1_31 3378378.2500
XTnl1_2_32 row2 gate_l1 mnl1_2_32 0 sky130_fd_pr__nfet_01v8 W=1.0u L=0.15u
Rrnl1_2_32 mnl1_2_32 cnl1_32 3070934.2500
XTnl1_2_33 row2 gate_l1 mnl1_2_33 0 sky130_fd_pr__nfet_01v8 W=1.0u L=0.15u
Rrnl1_2_33 mnl1_2_33 cnl1_33 3378378.2500
XTnl1_2_34 row2 gate_l1 mnl1_2_34 0 sky130_fd_pr__nfet_01v8 W=1.0u L=0.15u
Rrnl1_2_34 mnl1_2_34 cnl1_34 87800.8594
XTnl1_2_35 row2 gate_l1 mnl1_2_35 0 sky130_fd_pr__nfet_01v8 W=1.0u L=0.15u
Rrnl1_2_35 mnl1_2_35 cnl1_35 3378378.2500
XTnl1_2_36 row2 gate_l1 mnl1_2_36 0 sky130_fd_pr__nfet_01v8 W=1.0u L=0.15u
Rrnl1_2_36 mnl1_2_36 cnl1_36 3378378.2500
XTnl1_2_37 row2 gate_l1 mnl1_2_37 0 sky130_fd_pr__nfet_01v8 W=1.0u L=0.15u
Rrnl1_2_37 mnl1_2_37 cnl1_37 310666.1250
XTnl1_2_38 row2 gate_l1 mnl1_2_38 0 sky130_fd_pr__nfet_01v8 W=1.0u L=0.15u
Rrnl1_2_38 mnl1_2_38 cnl1_38 3378378.2500
XTnl1_2_39 row2 gate_l1 mnl1_2_39 0 sky130_fd_pr__nfet_01v8 W=1.0u L=0.15u
Rrnl1_2_39 mnl1_2_39 cnl1_39 3378378.2500
XTnl1_2_40 row2 gate_l1 mnl1_2_40 0 sky130_fd_pr__nfet_01v8 W=1.0u L=0.15u
Rrnl1_2_40 mnl1_2_40 cnl1_40 66148.7656
XTnl1_2_41 row2 gate_l1 mnl1_2_41 0 sky130_fd_pr__nfet_01v8 W=1.0u L=0.15u
Rrnl1_2_41 mnl1_2_41 cnl1_41 3378378.2500
XTnl1_2_42 row2 gate_l1 mnl1_2_42 0 sky130_fd_pr__nfet_01v8 W=1.0u L=0.15u
Rrnl1_2_42 mnl1_2_42 cnl1_42 584523.1875
XTnl1_2_43 row2 gate_l1 mnl1_2_43 0 sky130_fd_pr__nfet_01v8 W=1.0u L=0.15u
Rrnl1_2_43 mnl1_2_43 cnl1_43 557185.9375
XTnl1_2_44 row2 gate_l1 mnl1_2_44 0 sky130_fd_pr__nfet_01v8 W=1.0u L=0.15u
Rrnl1_2_44 mnl1_2_44 cnl1_44 199513.9375
XTnl1_2_45 row2 gate_l1 mnl1_2_45 0 sky130_fd_pr__nfet_01v8 W=1.0u L=0.15u
Rrnl1_2_45 mnl1_2_45 cnl1_45 3378378.2500
XTnl1_2_46 row2 gate_l1 mnl1_2_46 0 sky130_fd_pr__nfet_01v8 W=1.0u L=0.15u
Rrnl1_2_46 mnl1_2_46 cnl1_46 3378378.2500
XTnl1_2_47 row2 gate_l1 mnl1_2_47 0 sky130_fd_pr__nfet_01v8 W=1.0u L=0.15u
Rrnl1_2_47 mnl1_2_47 cnl1_47 16791.4414
XTnl1_2_48 row2 gate_l1 mnl1_2_48 0 sky130_fd_pr__nfet_01v8 W=1.0u L=0.15u
Rrnl1_2_48 mnl1_2_48 cnl1_48 3378378.2500
XTnl1_2_49 row2 gate_l1 mnl1_2_49 0 sky130_fd_pr__nfet_01v8 W=1.0u L=0.15u
Rrnl1_2_49 mnl1_2_49 cnl1_49 3378378.2500
XTnl1_2_50 row2 gate_l1 mnl1_2_50 0 sky130_fd_pr__nfet_01v8 W=1.0u L=0.15u
Rrnl1_2_50 mnl1_2_50 cnl1_50 69023.1250
XTnl1_2_51 row2 gate_l1 mnl1_2_51 0 sky130_fd_pr__nfet_01v8 W=1.0u L=0.15u
Rrnl1_2_51 mnl1_2_51 cnl1_51 273717.4375
XTnl1_2_52 row2 gate_l1 mnl1_2_52 0 sky130_fd_pr__nfet_01v8 W=1.0u L=0.15u
Rrnl1_2_52 mnl1_2_52 cnl1_52 3378378.2500
XTnl1_2_53 row2 gate_l1 mnl1_2_53 0 sky130_fd_pr__nfet_01v8 W=1.0u L=0.15u
Rrnl1_2_53 mnl1_2_53 cnl1_53 59236.7891
XTnl1_2_54 row2 gate_l1 mnl1_2_54 0 sky130_fd_pr__nfet_01v8 W=1.0u L=0.15u
Rrnl1_2_54 mnl1_2_54 cnl1_54 957521.0000
XTnl1_2_55 row2 gate_l1 mnl1_2_55 0 sky130_fd_pr__nfet_01v8 W=1.0u L=0.15u
Rrnl1_2_55 mnl1_2_55 cnl1_55 40507.2695
XTnl1_2_56 row2 gate_l1 mnl1_2_56 0 sky130_fd_pr__nfet_01v8 W=1.0u L=0.15u
Rrnl1_2_56 mnl1_2_56 cnl1_56 16223.7041
XTnl1_2_57 row2 gate_l1 mnl1_2_57 0 sky130_fd_pr__nfet_01v8 W=1.0u L=0.15u
Rrnl1_2_57 mnl1_2_57 cnl1_57 40969.7031
XTnl1_2_58 row2 gate_l1 mnl1_2_58 0 sky130_fd_pr__nfet_01v8 W=1.0u L=0.15u
Rrnl1_2_58 mnl1_2_58 cnl1_58 3378378.2500
XTnl1_2_59 row2 gate_l1 mnl1_2_59 0 sky130_fd_pr__nfet_01v8 W=1.0u L=0.15u
Rrnl1_2_59 mnl1_2_59 cnl1_59 3378378.2500
XTnl1_2_60 row2 gate_l1 mnl1_2_60 0 sky130_fd_pr__nfet_01v8 W=1.0u L=0.15u
Rrnl1_2_60 mnl1_2_60 cnl1_60 241145.6406
XTnl1_2_61 row2 gate_l1 mnl1_2_61 0 sky130_fd_pr__nfet_01v8 W=1.0u L=0.15u
Rrnl1_2_61 mnl1_2_61 cnl1_61 205283.9062
XTnl1_2_62 row2 gate_l1 mnl1_2_62 0 sky130_fd_pr__nfet_01v8 W=1.0u L=0.15u
Rrnl1_2_62 mnl1_2_62 cnl1_62 295673.2812
XTnl1_2_63 row2 gate_l1 mnl1_2_63 0 sky130_fd_pr__nfet_01v8 W=1.0u L=0.15u
Rrnl1_2_63 mnl1_2_63 cnl1_63 122607.0859
XTnl1_3_0 row3 gate_l1 mnl1_3_0 0 sky130_fd_pr__nfet_01v8 W=1.0u L=0.15u
Rrnl1_3_0 mnl1_3_0 cnl1_0 3378378.2500
XTnl1_3_1 row3 gate_l1 mnl1_3_1 0 sky130_fd_pr__nfet_01v8 W=1.0u L=0.15u
Rrnl1_3_1 mnl1_3_1 cnl1_1 3378378.2500
XTnl1_3_2 row3 gate_l1 mnl1_3_2 0 sky130_fd_pr__nfet_01v8 W=1.0u L=0.15u
Rrnl1_3_2 mnl1_3_2 cnl1_2 3378378.2500
XTnl1_3_3 row3 gate_l1 mnl1_3_3 0 sky130_fd_pr__nfet_01v8 W=1.0u L=0.15u
Rrnl1_3_3 mnl1_3_3 cnl1_3 3378378.2500
XTnl1_3_4 row3 gate_l1 mnl1_3_4 0 sky130_fd_pr__nfet_01v8 W=1.0u L=0.15u
Rrnl1_3_4 mnl1_3_4 cnl1_4 3378378.2500
XTnl1_3_5 row3 gate_l1 mnl1_3_5 0 sky130_fd_pr__nfet_01v8 W=1.0u L=0.15u
Rrnl1_3_5 mnl1_3_5 cnl1_5 3378378.2500
XTnl1_3_6 row3 gate_l1 mnl1_3_6 0 sky130_fd_pr__nfet_01v8 W=1.0u L=0.15u
Rrnl1_3_6 mnl1_3_6 cnl1_6 502242.3125
XTnl1_3_7 row3 gate_l1 mnl1_3_7 0 sky130_fd_pr__nfet_01v8 W=1.0u L=0.15u
Rrnl1_3_7 mnl1_3_7 cnl1_7 29663.9121
XTnl1_3_8 row3 gate_l1 mnl1_3_8 0 sky130_fd_pr__nfet_01v8 W=1.0u L=0.15u
Rrnl1_3_8 mnl1_3_8 cnl1_8 20469.8242
XTnl1_3_9 row3 gate_l1 mnl1_3_9 0 sky130_fd_pr__nfet_01v8 W=1.0u L=0.15u
Rrnl1_3_9 mnl1_3_9 cnl1_9 2388026.0000
XTnl1_3_10 row3 gate_l1 mnl1_3_10 0 sky130_fd_pr__nfet_01v8 W=1.0u L=0.15u
Rrnl1_3_10 mnl1_3_10 cnl1_10 48476.3594
XTnl1_3_11 row3 gate_l1 mnl1_3_11 0 sky130_fd_pr__nfet_01v8 W=1.0u L=0.15u
Rrnl1_3_11 mnl1_3_11 cnl1_11 3378378.2500
XTnl1_3_12 row3 gate_l1 mnl1_3_12 0 sky130_fd_pr__nfet_01v8 W=1.0u L=0.15u
Rrnl1_3_12 mnl1_3_12 cnl1_12 53496.4727
XTnl1_3_13 row3 gate_l1 mnl1_3_13 0 sky130_fd_pr__nfet_01v8 W=1.0u L=0.15u
Rrnl1_3_13 mnl1_3_13 cnl1_13 3378378.2500
XTnl1_3_14 row3 gate_l1 mnl1_3_14 0 sky130_fd_pr__nfet_01v8 W=1.0u L=0.15u
Rrnl1_3_14 mnl1_3_14 cnl1_14 3378378.2500
XTnl1_3_15 row3 gate_l1 mnl1_3_15 0 sky130_fd_pr__nfet_01v8 W=1.0u L=0.15u
Rrnl1_3_15 mnl1_3_15 cnl1_15 3378378.2500
XTnl1_3_16 row3 gate_l1 mnl1_3_16 0 sky130_fd_pr__nfet_01v8 W=1.0u L=0.15u
Rrnl1_3_16 mnl1_3_16 cnl1_16 16770.5957
XTnl1_3_17 row3 gate_l1 mnl1_3_17 0 sky130_fd_pr__nfet_01v8 W=1.0u L=0.15u
Rrnl1_3_17 mnl1_3_17 cnl1_17 224443.1562
XTnl1_3_18 row3 gate_l1 mnl1_3_18 0 sky130_fd_pr__nfet_01v8 W=1.0u L=0.15u
Rrnl1_3_18 mnl1_3_18 cnl1_18 38299.0156
XTnl1_3_19 row3 gate_l1 mnl1_3_19 0 sky130_fd_pr__nfet_01v8 W=1.0u L=0.15u
Rrnl1_3_19 mnl1_3_19 cnl1_19 25334.7773
XTnl1_3_20 row3 gate_l1 mnl1_3_20 0 sky130_fd_pr__nfet_01v8 W=1.0u L=0.15u
Rrnl1_3_20 mnl1_3_20 cnl1_20 3378378.2500
XTnl1_3_21 row3 gate_l1 mnl1_3_21 0 sky130_fd_pr__nfet_01v8 W=1.0u L=0.15u
Rrnl1_3_21 mnl1_3_21 cnl1_21 27285.3496
XTnl1_3_22 row3 gate_l1 mnl1_3_22 0 sky130_fd_pr__nfet_01v8 W=1.0u L=0.15u
Rrnl1_3_22 mnl1_3_22 cnl1_22 636080.1250
XTnl1_3_23 row3 gate_l1 mnl1_3_23 0 sky130_fd_pr__nfet_01v8 W=1.0u L=0.15u
Rrnl1_3_23 mnl1_3_23 cnl1_23 3378378.2500
XTnl1_3_24 row3 gate_l1 mnl1_3_24 0 sky130_fd_pr__nfet_01v8 W=1.0u L=0.15u
Rrnl1_3_24 mnl1_3_24 cnl1_24 62770.2773
XTnl1_3_25 row3 gate_l1 mnl1_3_25 0 sky130_fd_pr__nfet_01v8 W=1.0u L=0.15u
Rrnl1_3_25 mnl1_3_25 cnl1_25 100884.7969
XTnl1_3_26 row3 gate_l1 mnl1_3_26 0 sky130_fd_pr__nfet_01v8 W=1.0u L=0.15u
Rrnl1_3_26 mnl1_3_26 cnl1_26 3378378.2500
XTnl1_3_27 row3 gate_l1 mnl1_3_27 0 sky130_fd_pr__nfet_01v8 W=1.0u L=0.15u
Rrnl1_3_27 mnl1_3_27 cnl1_27 3378378.2500
XTnl1_3_28 row3 gate_l1 mnl1_3_28 0 sky130_fd_pr__nfet_01v8 W=1.0u L=0.15u
Rrnl1_3_28 mnl1_3_28 cnl1_28 3378378.2500
XTnl1_3_29 row3 gate_l1 mnl1_3_29 0 sky130_fd_pr__nfet_01v8 W=1.0u L=0.15u
Rrnl1_3_29 mnl1_3_29 cnl1_29 1928535.3750
XTnl1_3_30 row3 gate_l1 mnl1_3_30 0 sky130_fd_pr__nfet_01v8 W=1.0u L=0.15u
Rrnl1_3_30 mnl1_3_30 cnl1_30 3378378.2500
XTnl1_3_31 row3 gate_l1 mnl1_3_31 0 sky130_fd_pr__nfet_01v8 W=1.0u L=0.15u
Rrnl1_3_31 mnl1_3_31 cnl1_31 15209.0068
XTnl1_3_32 row3 gate_l1 mnl1_3_32 0 sky130_fd_pr__nfet_01v8 W=1.0u L=0.15u
Rrnl1_3_32 mnl1_3_32 cnl1_32 66001.4531
XTnl1_3_33 row3 gate_l1 mnl1_3_33 0 sky130_fd_pr__nfet_01v8 W=1.0u L=0.15u
Rrnl1_3_33 mnl1_3_33 cnl1_33 101273.4922
XTnl1_3_34 row3 gate_l1 mnl1_3_34 0 sky130_fd_pr__nfet_01v8 W=1.0u L=0.15u
Rrnl1_3_34 mnl1_3_34 cnl1_34 13084.1523
XTnl1_3_35 row3 gate_l1 mnl1_3_35 0 sky130_fd_pr__nfet_01v8 W=1.0u L=0.15u
Rrnl1_3_35 mnl1_3_35 cnl1_35 3378378.2500
XTnl1_3_36 row3 gate_l1 mnl1_3_36 0 sky130_fd_pr__nfet_01v8 W=1.0u L=0.15u
Rrnl1_3_36 mnl1_3_36 cnl1_36 11498.5479
XTnl1_3_37 row3 gate_l1 mnl1_3_37 0 sky130_fd_pr__nfet_01v8 W=1.0u L=0.15u
Rrnl1_3_37 mnl1_3_37 cnl1_37 688843.7500
XTnl1_3_38 row3 gate_l1 mnl1_3_38 0 sky130_fd_pr__nfet_01v8 W=1.0u L=0.15u
Rrnl1_3_38 mnl1_3_38 cnl1_38 1124840.7500
XTnl1_3_39 row3 gate_l1 mnl1_3_39 0 sky130_fd_pr__nfet_01v8 W=1.0u L=0.15u
Rrnl1_3_39 mnl1_3_39 cnl1_39 3378378.2500
XTnl1_3_40 row3 gate_l1 mnl1_3_40 0 sky130_fd_pr__nfet_01v8 W=1.0u L=0.15u
Rrnl1_3_40 mnl1_3_40 cnl1_40 15901.5879
XTnl1_3_41 row3 gate_l1 mnl1_3_41 0 sky130_fd_pr__nfet_01v8 W=1.0u L=0.15u
Rrnl1_3_41 mnl1_3_41 cnl1_41 3378378.2500
XTnl1_3_42 row3 gate_l1 mnl1_3_42 0 sky130_fd_pr__nfet_01v8 W=1.0u L=0.15u
Rrnl1_3_42 mnl1_3_42 cnl1_42 32212.3008
XTnl1_3_43 row3 gate_l1 mnl1_3_43 0 sky130_fd_pr__nfet_01v8 W=1.0u L=0.15u
Rrnl1_3_43 mnl1_3_43 cnl1_43 3378378.2500
XTnl1_3_44 row3 gate_l1 mnl1_3_44 0 sky130_fd_pr__nfet_01v8 W=1.0u L=0.15u
Rrnl1_3_44 mnl1_3_44 cnl1_44 3378378.2500
XTnl1_3_45 row3 gate_l1 mnl1_3_45 0 sky130_fd_pr__nfet_01v8 W=1.0u L=0.15u
Rrnl1_3_45 mnl1_3_45 cnl1_45 3378378.2500
XTnl1_3_46 row3 gate_l1 mnl1_3_46 0 sky130_fd_pr__nfet_01v8 W=1.0u L=0.15u
Rrnl1_3_46 mnl1_3_46 cnl1_46 39222.9727
XTnl1_3_47 row3 gate_l1 mnl1_3_47 0 sky130_fd_pr__nfet_01v8 W=1.0u L=0.15u
Rrnl1_3_47 mnl1_3_47 cnl1_47 3378378.2500
XTnl1_3_48 row3 gate_l1 mnl1_3_48 0 sky130_fd_pr__nfet_01v8 W=1.0u L=0.15u
Rrnl1_3_48 mnl1_3_48 cnl1_48 3378378.2500
XTnl1_3_49 row3 gate_l1 mnl1_3_49 0 sky130_fd_pr__nfet_01v8 W=1.0u L=0.15u
Rrnl1_3_49 mnl1_3_49 cnl1_49 3378378.2500
XTnl1_3_50 row3 gate_l1 mnl1_3_50 0 sky130_fd_pr__nfet_01v8 W=1.0u L=0.15u
Rrnl1_3_50 mnl1_3_50 cnl1_50 556967.1875
XTnl1_3_51 row3 gate_l1 mnl1_3_51 0 sky130_fd_pr__nfet_01v8 W=1.0u L=0.15u
Rrnl1_3_51 mnl1_3_51 cnl1_51 15750.4961
XTnl1_3_52 row3 gate_l1 mnl1_3_52 0 sky130_fd_pr__nfet_01v8 W=1.0u L=0.15u
Rrnl1_3_52 mnl1_3_52 cnl1_52 438147.0938
XTnl1_3_53 row3 gate_l1 mnl1_3_53 0 sky130_fd_pr__nfet_01v8 W=1.0u L=0.15u
Rrnl1_3_53 mnl1_3_53 cnl1_53 3378378.2500
XTnl1_3_54 row3 gate_l1 mnl1_3_54 0 sky130_fd_pr__nfet_01v8 W=1.0u L=0.15u
Rrnl1_3_54 mnl1_3_54 cnl1_54 3378378.2500
XTnl1_3_55 row3 gate_l1 mnl1_3_55 0 sky130_fd_pr__nfet_01v8 W=1.0u L=0.15u
Rrnl1_3_55 mnl1_3_55 cnl1_55 3378378.2500
XTnl1_3_56 row3 gate_l1 mnl1_3_56 0 sky130_fd_pr__nfet_01v8 W=1.0u L=0.15u
Rrnl1_3_56 mnl1_3_56 cnl1_56 3378378.2500
XTnl1_3_57 row3 gate_l1 mnl1_3_57 0 sky130_fd_pr__nfet_01v8 W=1.0u L=0.15u
Rrnl1_3_57 mnl1_3_57 cnl1_57 3378378.2500
XTnl1_3_58 row3 gate_l1 mnl1_3_58 0 sky130_fd_pr__nfet_01v8 W=1.0u L=0.15u
Rrnl1_3_58 mnl1_3_58 cnl1_58 88516.1719
XTnl1_3_59 row3 gate_l1 mnl1_3_59 0 sky130_fd_pr__nfet_01v8 W=1.0u L=0.15u
Rrnl1_3_59 mnl1_3_59 cnl1_59 114020.6406
XTnl1_3_60 row3 gate_l1 mnl1_3_60 0 sky130_fd_pr__nfet_01v8 W=1.0u L=0.15u
Rrnl1_3_60 mnl1_3_60 cnl1_60 3378378.2500
XTnl1_3_61 row3 gate_l1 mnl1_3_61 0 sky130_fd_pr__nfet_01v8 W=1.0u L=0.15u
Rrnl1_3_61 mnl1_3_61 cnl1_61 3378378.2500
XTnl1_3_62 row3 gate_l1 mnl1_3_62 0 sky130_fd_pr__nfet_01v8 W=1.0u L=0.15u
Rrnl1_3_62 mnl1_3_62 cnl1_62 10073.2324
XTnl1_3_63 row3 gate_l1 mnl1_3_63 0 sky130_fd_pr__nfet_01v8 W=1.0u L=0.15u
Rrnl1_3_63 mnl1_3_63 cnl1_63 3378378.2500
XTnl1_4_0 row4 gate_l1 mnl1_4_0 0 sky130_fd_pr__nfet_01v8 W=1.0u L=0.15u
Rrnl1_4_0 mnl1_4_0 cnl1_0 3378378.2500
XTnl1_4_1 row4 gate_l1 mnl1_4_1 0 sky130_fd_pr__nfet_01v8 W=1.0u L=0.15u
Rrnl1_4_1 mnl1_4_1 cnl1_1 3378378.2500
XTnl1_4_2 row4 gate_l1 mnl1_4_2 0 sky130_fd_pr__nfet_01v8 W=1.0u L=0.15u
Rrnl1_4_2 mnl1_4_2 cnl1_2 3378378.2500
XTnl1_4_3 row4 gate_l1 mnl1_4_3 0 sky130_fd_pr__nfet_01v8 W=1.0u L=0.15u
Rrnl1_4_3 mnl1_4_3 cnl1_3 3378378.2500
XTnl1_4_4 row4 gate_l1 mnl1_4_4 0 sky130_fd_pr__nfet_01v8 W=1.0u L=0.15u
Rrnl1_4_4 mnl1_4_4 cnl1_4 3378378.2500
XTnl1_4_5 row4 gate_l1 mnl1_4_5 0 sky130_fd_pr__nfet_01v8 W=1.0u L=0.15u
Rrnl1_4_5 mnl1_4_5 cnl1_5 3378378.2500
XTnl1_4_6 row4 gate_l1 mnl1_4_6 0 sky130_fd_pr__nfet_01v8 W=1.0u L=0.15u
Rrnl1_4_6 mnl1_4_6 cnl1_6 578904.3125
XTnl1_4_7 row4 gate_l1 mnl1_4_7 0 sky130_fd_pr__nfet_01v8 W=1.0u L=0.15u
Rrnl1_4_7 mnl1_4_7 cnl1_7 3378378.2500
XTnl1_4_8 row4 gate_l1 mnl1_4_8 0 sky130_fd_pr__nfet_01v8 W=1.0u L=0.15u
Rrnl1_4_8 mnl1_4_8 cnl1_8 3378378.2500
XTnl1_4_9 row4 gate_l1 mnl1_4_9 0 sky130_fd_pr__nfet_01v8 W=1.0u L=0.15u
Rrnl1_4_9 mnl1_4_9 cnl1_9 3378378.2500
XTnl1_4_10 row4 gate_l1 mnl1_4_10 0 sky130_fd_pr__nfet_01v8 W=1.0u L=0.15u
Rrnl1_4_10 mnl1_4_10 cnl1_10 3378378.2500
XTnl1_4_11 row4 gate_l1 mnl1_4_11 0 sky130_fd_pr__nfet_01v8 W=1.0u L=0.15u
Rrnl1_4_11 mnl1_4_11 cnl1_11 3378378.2500
XTnl1_4_12 row4 gate_l1 mnl1_4_12 0 sky130_fd_pr__nfet_01v8 W=1.0u L=0.15u
Rrnl1_4_12 mnl1_4_12 cnl1_12 46983.6562
XTnl1_4_13 row4 gate_l1 mnl1_4_13 0 sky130_fd_pr__nfet_01v8 W=1.0u L=0.15u
Rrnl1_4_13 mnl1_4_13 cnl1_13 58120.4102
XTnl1_4_14 row4 gate_l1 mnl1_4_14 0 sky130_fd_pr__nfet_01v8 W=1.0u L=0.15u
Rrnl1_4_14 mnl1_4_14 cnl1_14 3378378.2500
XTnl1_4_15 row4 gate_l1 mnl1_4_15 0 sky130_fd_pr__nfet_01v8 W=1.0u L=0.15u
Rrnl1_4_15 mnl1_4_15 cnl1_15 55946.7422
XTnl1_4_16 row4 gate_l1 mnl1_4_16 0 sky130_fd_pr__nfet_01v8 W=1.0u L=0.15u
Rrnl1_4_16 mnl1_4_16 cnl1_16 47813.4922
XTnl1_4_17 row4 gate_l1 mnl1_4_17 0 sky130_fd_pr__nfet_01v8 W=1.0u L=0.15u
Rrnl1_4_17 mnl1_4_17 cnl1_17 3378378.2500
XTnl1_4_18 row4 gate_l1 mnl1_4_18 0 sky130_fd_pr__nfet_01v8 W=1.0u L=0.15u
Rrnl1_4_18 mnl1_4_18 cnl1_18 3378378.2500
XTnl1_4_19 row4 gate_l1 mnl1_4_19 0 sky130_fd_pr__nfet_01v8 W=1.0u L=0.15u
Rrnl1_4_19 mnl1_4_19 cnl1_19 3378378.2500
XTnl1_4_20 row4 gate_l1 mnl1_4_20 0 sky130_fd_pr__nfet_01v8 W=1.0u L=0.15u
Rrnl1_4_20 mnl1_4_20 cnl1_20 3378378.2500
XTnl1_4_21 row4 gate_l1 mnl1_4_21 0 sky130_fd_pr__nfet_01v8 W=1.0u L=0.15u
Rrnl1_4_21 mnl1_4_21 cnl1_21 3378378.2500
XTnl1_4_22 row4 gate_l1 mnl1_4_22 0 sky130_fd_pr__nfet_01v8 W=1.0u L=0.15u
Rrnl1_4_22 mnl1_4_22 cnl1_22 3378378.2500
XTnl1_4_23 row4 gate_l1 mnl1_4_23 0 sky130_fd_pr__nfet_01v8 W=1.0u L=0.15u
Rrnl1_4_23 mnl1_4_23 cnl1_23 3378378.2500
XTnl1_4_24 row4 gate_l1 mnl1_4_24 0 sky130_fd_pr__nfet_01v8 W=1.0u L=0.15u
Rrnl1_4_24 mnl1_4_24 cnl1_24 3378378.2500
XTnl1_4_25 row4 gate_l1 mnl1_4_25 0 sky130_fd_pr__nfet_01v8 W=1.0u L=0.15u
Rrnl1_4_25 mnl1_4_25 cnl1_25 25942.7168
XTnl1_4_26 row4 gate_l1 mnl1_4_26 0 sky130_fd_pr__nfet_01v8 W=1.0u L=0.15u
Rrnl1_4_26 mnl1_4_26 cnl1_26 25698.3379
XTnl1_4_27 row4 gate_l1 mnl1_4_27 0 sky130_fd_pr__nfet_01v8 W=1.0u L=0.15u
Rrnl1_4_27 mnl1_4_27 cnl1_27 34847.6992
XTnl1_4_28 row4 gate_l1 mnl1_4_28 0 sky130_fd_pr__nfet_01v8 W=1.0u L=0.15u
Rrnl1_4_28 mnl1_4_28 cnl1_28 3378378.2500
XTnl1_4_29 row4 gate_l1 mnl1_4_29 0 sky130_fd_pr__nfet_01v8 W=1.0u L=0.15u
Rrnl1_4_29 mnl1_4_29 cnl1_29 80590.5703
XTnl1_4_30 row4 gate_l1 mnl1_4_30 0 sky130_fd_pr__nfet_01v8 W=1.0u L=0.15u
Rrnl1_4_30 mnl1_4_30 cnl1_30 3378378.2500
XTnl1_4_31 row4 gate_l1 mnl1_4_31 0 sky130_fd_pr__nfet_01v8 W=1.0u L=0.15u
Rrnl1_4_31 mnl1_4_31 cnl1_31 27751.6758
XTnl1_4_32 row4 gate_l1 mnl1_4_32 0 sky130_fd_pr__nfet_01v8 W=1.0u L=0.15u
Rrnl1_4_32 mnl1_4_32 cnl1_32 3378378.2500
XTnl1_4_33 row4 gate_l1 mnl1_4_33 0 sky130_fd_pr__nfet_01v8 W=1.0u L=0.15u
Rrnl1_4_33 mnl1_4_33 cnl1_33 3378378.2500
XTnl1_4_34 row4 gate_l1 mnl1_4_34 0 sky130_fd_pr__nfet_01v8 W=1.0u L=0.15u
Rrnl1_4_34 mnl1_4_34 cnl1_34 29682.1074
XTnl1_4_35 row4 gate_l1 mnl1_4_35 0 sky130_fd_pr__nfet_01v8 W=1.0u L=0.15u
Rrnl1_4_35 mnl1_4_35 cnl1_35 72362.5156
XTnl1_4_36 row4 gate_l1 mnl1_4_36 0 sky130_fd_pr__nfet_01v8 W=1.0u L=0.15u
Rrnl1_4_36 mnl1_4_36 cnl1_36 3378378.2500
XTnl1_4_37 row4 gate_l1 mnl1_4_37 0 sky130_fd_pr__nfet_01v8 W=1.0u L=0.15u
Rrnl1_4_37 mnl1_4_37 cnl1_37 3378378.2500
XTnl1_4_38 row4 gate_l1 mnl1_4_38 0 sky130_fd_pr__nfet_01v8 W=1.0u L=0.15u
Rrnl1_4_38 mnl1_4_38 cnl1_38 3378378.2500
XTnl1_4_39 row4 gate_l1 mnl1_4_39 0 sky130_fd_pr__nfet_01v8 W=1.0u L=0.15u
Rrnl1_4_39 mnl1_4_39 cnl1_39 3378378.2500
XTnl1_4_40 row4 gate_l1 mnl1_4_40 0 sky130_fd_pr__nfet_01v8 W=1.0u L=0.15u
Rrnl1_4_40 mnl1_4_40 cnl1_40 3378378.2500
XTnl1_4_41 row4 gate_l1 mnl1_4_41 0 sky130_fd_pr__nfet_01v8 W=1.0u L=0.15u
Rrnl1_4_41 mnl1_4_41 cnl1_41 3378378.2500
XTnl1_4_42 row4 gate_l1 mnl1_4_42 0 sky130_fd_pr__nfet_01v8 W=1.0u L=0.15u
Rrnl1_4_42 mnl1_4_42 cnl1_42 3378378.2500
XTnl1_4_43 row4 gate_l1 mnl1_4_43 0 sky130_fd_pr__nfet_01v8 W=1.0u L=0.15u
Rrnl1_4_43 mnl1_4_43 cnl1_43 3378378.2500
XTnl1_4_44 row4 gate_l1 mnl1_4_44 0 sky130_fd_pr__nfet_01v8 W=1.0u L=0.15u
Rrnl1_4_44 mnl1_4_44 cnl1_44 54772.7109
XTnl1_4_45 row4 gate_l1 mnl1_4_45 0 sky130_fd_pr__nfet_01v8 W=1.0u L=0.15u
Rrnl1_4_45 mnl1_4_45 cnl1_45 3378378.2500
XTnl1_4_46 row4 gate_l1 mnl1_4_46 0 sky130_fd_pr__nfet_01v8 W=1.0u L=0.15u
Rrnl1_4_46 mnl1_4_46 cnl1_46 3378378.2500
XTnl1_4_47 row4 gate_l1 mnl1_4_47 0 sky130_fd_pr__nfet_01v8 W=1.0u L=0.15u
Rrnl1_4_47 mnl1_4_47 cnl1_47 106990.8047
XTnl1_4_48 row4 gate_l1 mnl1_4_48 0 sky130_fd_pr__nfet_01v8 W=1.0u L=0.15u
Rrnl1_4_48 mnl1_4_48 cnl1_48 3378378.2500
XTnl1_4_49 row4 gate_l1 mnl1_4_49 0 sky130_fd_pr__nfet_01v8 W=1.0u L=0.15u
Rrnl1_4_49 mnl1_4_49 cnl1_49 3378378.2500
XTnl1_4_50 row4 gate_l1 mnl1_4_50 0 sky130_fd_pr__nfet_01v8 W=1.0u L=0.15u
Rrnl1_4_50 mnl1_4_50 cnl1_50 3378378.2500
XTnl1_4_51 row4 gate_l1 mnl1_4_51 0 sky130_fd_pr__nfet_01v8 W=1.0u L=0.15u
Rrnl1_4_51 mnl1_4_51 cnl1_51 3378378.2500
XTnl1_4_52 row4 gate_l1 mnl1_4_52 0 sky130_fd_pr__nfet_01v8 W=1.0u L=0.15u
Rrnl1_4_52 mnl1_4_52 cnl1_52 19411.5566
XTnl1_4_53 row4 gate_l1 mnl1_4_53 0 sky130_fd_pr__nfet_01v8 W=1.0u L=0.15u
Rrnl1_4_53 mnl1_4_53 cnl1_53 3378378.2500
XTnl1_4_54 row4 gate_l1 mnl1_4_54 0 sky130_fd_pr__nfet_01v8 W=1.0u L=0.15u
Rrnl1_4_54 mnl1_4_54 cnl1_54 3378378.2500
XTnl1_4_55 row4 gate_l1 mnl1_4_55 0 sky130_fd_pr__nfet_01v8 W=1.0u L=0.15u
Rrnl1_4_55 mnl1_4_55 cnl1_55 3378378.2500
XTnl1_4_56 row4 gate_l1 mnl1_4_56 0 sky130_fd_pr__nfet_01v8 W=1.0u L=0.15u
Rrnl1_4_56 mnl1_4_56 cnl1_56 3378378.2500
XTnl1_4_57 row4 gate_l1 mnl1_4_57 0 sky130_fd_pr__nfet_01v8 W=1.0u L=0.15u
Rrnl1_4_57 mnl1_4_57 cnl1_57 3378378.2500
XTnl1_4_58 row4 gate_l1 mnl1_4_58 0 sky130_fd_pr__nfet_01v8 W=1.0u L=0.15u
Rrnl1_4_58 mnl1_4_58 cnl1_58 58015.1680
XTnl1_4_59 row4 gate_l1 mnl1_4_59 0 sky130_fd_pr__nfet_01v8 W=1.0u L=0.15u
Rrnl1_4_59 mnl1_4_59 cnl1_59 33074.4258
XTnl1_4_60 row4 gate_l1 mnl1_4_60 0 sky130_fd_pr__nfet_01v8 W=1.0u L=0.15u
Rrnl1_4_60 mnl1_4_60 cnl1_60 26289.8555
XTnl1_4_61 row4 gate_l1 mnl1_4_61 0 sky130_fd_pr__nfet_01v8 W=1.0u L=0.15u
Rrnl1_4_61 mnl1_4_61 cnl1_61 173768.9062
XTnl1_4_62 row4 gate_l1 mnl1_4_62 0 sky130_fd_pr__nfet_01v8 W=1.0u L=0.15u
Rrnl1_4_62 mnl1_4_62 cnl1_62 3378378.2500
XTnl1_4_63 row4 gate_l1 mnl1_4_63 0 sky130_fd_pr__nfet_01v8 W=1.0u L=0.15u
Rrnl1_4_63 mnl1_4_63 cnl1_63 86154.7734
XTnl1_5_0 row5 gate_l1 mnl1_5_0 0 sky130_fd_pr__nfet_01v8 W=1.0u L=0.15u
Rrnl1_5_0 mnl1_5_0 cnl1_0 137789.5625
XTnl1_5_1 row5 gate_l1 mnl1_5_1 0 sky130_fd_pr__nfet_01v8 W=1.0u L=0.15u
Rrnl1_5_1 mnl1_5_1 cnl1_1 3378378.2500
XTnl1_5_2 row5 gate_l1 mnl1_5_2 0 sky130_fd_pr__nfet_01v8 W=1.0u L=0.15u
Rrnl1_5_2 mnl1_5_2 cnl1_2 101459.6953
XTnl1_5_3 row5 gate_l1 mnl1_5_3 0 sky130_fd_pr__nfet_01v8 W=1.0u L=0.15u
Rrnl1_5_3 mnl1_5_3 cnl1_3 3378378.2500
XTnl1_5_4 row5 gate_l1 mnl1_5_4 0 sky130_fd_pr__nfet_01v8 W=1.0u L=0.15u
Rrnl1_5_4 mnl1_5_4 cnl1_4 172309.7969
XTnl1_5_5 row5 gate_l1 mnl1_5_5 0 sky130_fd_pr__nfet_01v8 W=1.0u L=0.15u
Rrnl1_5_5 mnl1_5_5 cnl1_5 34550.0469
XTnl1_5_6 row5 gate_l1 mnl1_5_6 0 sky130_fd_pr__nfet_01v8 W=1.0u L=0.15u
Rrnl1_5_6 mnl1_5_6 cnl1_6 27747.2520
XTnl1_5_7 row5 gate_l1 mnl1_5_7 0 sky130_fd_pr__nfet_01v8 W=1.0u L=0.15u
Rrnl1_5_7 mnl1_5_7 cnl1_7 3378378.2500
XTnl1_5_8 row5 gate_l1 mnl1_5_8 0 sky130_fd_pr__nfet_01v8 W=1.0u L=0.15u
Rrnl1_5_8 mnl1_5_8 cnl1_8 3378378.2500
XTnl1_5_9 row5 gate_l1 mnl1_5_9 0 sky130_fd_pr__nfet_01v8 W=1.0u L=0.15u
Rrnl1_5_9 mnl1_5_9 cnl1_9 23427.8164
XTnl1_5_10 row5 gate_l1 mnl1_5_10 0 sky130_fd_pr__nfet_01v8 W=1.0u L=0.15u
Rrnl1_5_10 mnl1_5_10 cnl1_10 38286.9141
XTnl1_5_11 row5 gate_l1 mnl1_5_11 0 sky130_fd_pr__nfet_01v8 W=1.0u L=0.15u
Rrnl1_5_11 mnl1_5_11 cnl1_11 3378378.2500
XTnl1_5_12 row5 gate_l1 mnl1_5_12 0 sky130_fd_pr__nfet_01v8 W=1.0u L=0.15u
Rrnl1_5_12 mnl1_5_12 cnl1_12 14897.1680
XTnl1_5_13 row5 gate_l1 mnl1_5_13 0 sky130_fd_pr__nfet_01v8 W=1.0u L=0.15u
Rrnl1_5_13 mnl1_5_13 cnl1_13 3378378.2500
XTnl1_5_14 row5 gate_l1 mnl1_5_14 0 sky130_fd_pr__nfet_01v8 W=1.0u L=0.15u
Rrnl1_5_14 mnl1_5_14 cnl1_14 71712.9141
XTnl1_5_15 row5 gate_l1 mnl1_5_15 0 sky130_fd_pr__nfet_01v8 W=1.0u L=0.15u
Rrnl1_5_15 mnl1_5_15 cnl1_15 125688.4375
XTnl1_5_16 row5 gate_l1 mnl1_5_16 0 sky130_fd_pr__nfet_01v8 W=1.0u L=0.15u
Rrnl1_5_16 mnl1_5_16 cnl1_16 63976.4766
XTnl1_5_17 row5 gate_l1 mnl1_5_17 0 sky130_fd_pr__nfet_01v8 W=1.0u L=0.15u
Rrnl1_5_17 mnl1_5_17 cnl1_17 3378378.2500
XTnl1_5_18 row5 gate_l1 mnl1_5_18 0 sky130_fd_pr__nfet_01v8 W=1.0u L=0.15u
Rrnl1_5_18 mnl1_5_18 cnl1_18 267849.5000
XTnl1_5_19 row5 gate_l1 mnl1_5_19 0 sky130_fd_pr__nfet_01v8 W=1.0u L=0.15u
Rrnl1_5_19 mnl1_5_19 cnl1_19 87829.5859
XTnl1_5_20 row5 gate_l1 mnl1_5_20 0 sky130_fd_pr__nfet_01v8 W=1.0u L=0.15u
Rrnl1_5_20 mnl1_5_20 cnl1_20 78088.9453
XTnl1_5_21 row5 gate_l1 mnl1_5_21 0 sky130_fd_pr__nfet_01v8 W=1.0u L=0.15u
Rrnl1_5_21 mnl1_5_21 cnl1_21 3378378.2500
XTnl1_5_22 row5 gate_l1 mnl1_5_22 0 sky130_fd_pr__nfet_01v8 W=1.0u L=0.15u
Rrnl1_5_22 mnl1_5_22 cnl1_22 19935.7227
XTnl1_5_23 row5 gate_l1 mnl1_5_23 0 sky130_fd_pr__nfet_01v8 W=1.0u L=0.15u
Rrnl1_5_23 mnl1_5_23 cnl1_23 69378.1406
XTnl1_5_24 row5 gate_l1 mnl1_5_24 0 sky130_fd_pr__nfet_01v8 W=1.0u L=0.15u
Rrnl1_5_24 mnl1_5_24 cnl1_24 32813.2539
XTnl1_5_25 row5 gate_l1 mnl1_5_25 0 sky130_fd_pr__nfet_01v8 W=1.0u L=0.15u
Rrnl1_5_25 mnl1_5_25 cnl1_25 3378378.2500
XTnl1_5_26 row5 gate_l1 mnl1_5_26 0 sky130_fd_pr__nfet_01v8 W=1.0u L=0.15u
Rrnl1_5_26 mnl1_5_26 cnl1_26 3378378.2500
XTnl1_5_27 row5 gate_l1 mnl1_5_27 0 sky130_fd_pr__nfet_01v8 W=1.0u L=0.15u
Rrnl1_5_27 mnl1_5_27 cnl1_27 3378378.2500
XTnl1_5_28 row5 gate_l1 mnl1_5_28 0 sky130_fd_pr__nfet_01v8 W=1.0u L=0.15u
Rrnl1_5_28 mnl1_5_28 cnl1_28 2033100.5000
XTnl1_5_29 row5 gate_l1 mnl1_5_29 0 sky130_fd_pr__nfet_01v8 W=1.0u L=0.15u
Rrnl1_5_29 mnl1_5_29 cnl1_29 152603.2031
XTnl1_5_30 row5 gate_l1 mnl1_5_30 0 sky130_fd_pr__nfet_01v8 W=1.0u L=0.15u
Rrnl1_5_30 mnl1_5_30 cnl1_30 3378378.2500
XTnl1_5_31 row5 gate_l1 mnl1_5_31 0 sky130_fd_pr__nfet_01v8 W=1.0u L=0.15u
Rrnl1_5_31 mnl1_5_31 cnl1_31 28469.3711
XTnl1_5_32 row5 gate_l1 mnl1_5_32 0 sky130_fd_pr__nfet_01v8 W=1.0u L=0.15u
Rrnl1_5_32 mnl1_5_32 cnl1_32 1134839.7500
XTnl1_5_33 row5 gate_l1 mnl1_5_33 0 sky130_fd_pr__nfet_01v8 W=1.0u L=0.15u
Rrnl1_5_33 mnl1_5_33 cnl1_33 310715.4688
XTnl1_5_34 row5 gate_l1 mnl1_5_34 0 sky130_fd_pr__nfet_01v8 W=1.0u L=0.15u
Rrnl1_5_34 mnl1_5_34 cnl1_34 247241.6406
XTnl1_5_35 row5 gate_l1 mnl1_5_35 0 sky130_fd_pr__nfet_01v8 W=1.0u L=0.15u
Rrnl1_5_35 mnl1_5_35 cnl1_35 67533.9844
XTnl1_5_36 row5 gate_l1 mnl1_5_36 0 sky130_fd_pr__nfet_01v8 W=1.0u L=0.15u
Rrnl1_5_36 mnl1_5_36 cnl1_36 1510359.8750
XTnl1_5_37 row5 gate_l1 mnl1_5_37 0 sky130_fd_pr__nfet_01v8 W=1.0u L=0.15u
Rrnl1_5_37 mnl1_5_37 cnl1_37 298194.4688
XTnl1_5_38 row5 gate_l1 mnl1_5_38 0 sky130_fd_pr__nfet_01v8 W=1.0u L=0.15u
Rrnl1_5_38 mnl1_5_38 cnl1_38 3378378.2500
XTnl1_5_39 row5 gate_l1 mnl1_5_39 0 sky130_fd_pr__nfet_01v8 W=1.0u L=0.15u
Rrnl1_5_39 mnl1_5_39 cnl1_39 3378378.2500
XTnl1_5_40 row5 gate_l1 mnl1_5_40 0 sky130_fd_pr__nfet_01v8 W=1.0u L=0.15u
Rrnl1_5_40 mnl1_5_40 cnl1_40 48919.5391
XTnl1_5_41 row5 gate_l1 mnl1_5_41 0 sky130_fd_pr__nfet_01v8 W=1.0u L=0.15u
Rrnl1_5_41 mnl1_5_41 cnl1_41 3378378.2500
XTnl1_5_42 row5 gate_l1 mnl1_5_42 0 sky130_fd_pr__nfet_01v8 W=1.0u L=0.15u
Rrnl1_5_42 mnl1_5_42 cnl1_42 540021.6875
XTnl1_5_43 row5 gate_l1 mnl1_5_43 0 sky130_fd_pr__nfet_01v8 W=1.0u L=0.15u
Rrnl1_5_43 mnl1_5_43 cnl1_43 3378378.2500
XTnl1_5_44 row5 gate_l1 mnl1_5_44 0 sky130_fd_pr__nfet_01v8 W=1.0u L=0.15u
Rrnl1_5_44 mnl1_5_44 cnl1_44 3378378.2500
XTnl1_5_45 row5 gate_l1 mnl1_5_45 0 sky130_fd_pr__nfet_01v8 W=1.0u L=0.15u
Rrnl1_5_45 mnl1_5_45 cnl1_45 121084.8750
XTnl1_5_46 row5 gate_l1 mnl1_5_46 0 sky130_fd_pr__nfet_01v8 W=1.0u L=0.15u
Rrnl1_5_46 mnl1_5_46 cnl1_46 3378378.2500
XTnl1_5_47 row5 gate_l1 mnl1_5_47 0 sky130_fd_pr__nfet_01v8 W=1.0u L=0.15u
Rrnl1_5_47 mnl1_5_47 cnl1_47 64094.3750
XTnl1_5_48 row5 gate_l1 mnl1_5_48 0 sky130_fd_pr__nfet_01v8 W=1.0u L=0.15u
Rrnl1_5_48 mnl1_5_48 cnl1_48 3378378.2500
XTnl1_5_49 row5 gate_l1 mnl1_5_49 0 sky130_fd_pr__nfet_01v8 W=1.0u L=0.15u
Rrnl1_5_49 mnl1_5_49 cnl1_49 33751.4531
XTnl1_5_50 row5 gate_l1 mnl1_5_50 0 sky130_fd_pr__nfet_01v8 W=1.0u L=0.15u
Rrnl1_5_50 mnl1_5_50 cnl1_50 45282.1758
XTnl1_5_51 row5 gate_l1 mnl1_5_51 0 sky130_fd_pr__nfet_01v8 W=1.0u L=0.15u
Rrnl1_5_51 mnl1_5_51 cnl1_51 25362.2070
XTnl1_5_52 row5 gate_l1 mnl1_5_52 0 sky130_fd_pr__nfet_01v8 W=1.0u L=0.15u
Rrnl1_5_52 mnl1_5_52 cnl1_52 99309.4609
XTnl1_5_53 row5 gate_l1 mnl1_5_53 0 sky130_fd_pr__nfet_01v8 W=1.0u L=0.15u
Rrnl1_5_53 mnl1_5_53 cnl1_53 3378378.2500
XTnl1_5_54 row5 gate_l1 mnl1_5_54 0 sky130_fd_pr__nfet_01v8 W=1.0u L=0.15u
Rrnl1_5_54 mnl1_5_54 cnl1_54 3378378.2500
XTnl1_5_55 row5 gate_l1 mnl1_5_55 0 sky130_fd_pr__nfet_01v8 W=1.0u L=0.15u
Rrnl1_5_55 mnl1_5_55 cnl1_55 20164.4941
XTnl1_5_56 row5 gate_l1 mnl1_5_56 0 sky130_fd_pr__nfet_01v8 W=1.0u L=0.15u
Rrnl1_5_56 mnl1_5_56 cnl1_56 1201862.5000
XTnl1_5_57 row5 gate_l1 mnl1_5_57 0 sky130_fd_pr__nfet_01v8 W=1.0u L=0.15u
Rrnl1_5_57 mnl1_5_57 cnl1_57 82164.4297
XTnl1_5_58 row5 gate_l1 mnl1_5_58 0 sky130_fd_pr__nfet_01v8 W=1.0u L=0.15u
Rrnl1_5_58 mnl1_5_58 cnl1_58 3378378.2500
XTnl1_5_59 row5 gate_l1 mnl1_5_59 0 sky130_fd_pr__nfet_01v8 W=1.0u L=0.15u
Rrnl1_5_59 mnl1_5_59 cnl1_59 140602.3125
XTnl1_5_60 row5 gate_l1 mnl1_5_60 0 sky130_fd_pr__nfet_01v8 W=1.0u L=0.15u
Rrnl1_5_60 mnl1_5_60 cnl1_60 592026.1250
XTnl1_5_61 row5 gate_l1 mnl1_5_61 0 sky130_fd_pr__nfet_01v8 W=1.0u L=0.15u
Rrnl1_5_61 mnl1_5_61 cnl1_61 3378378.2500
XTnl1_5_62 row5 gate_l1 mnl1_5_62 0 sky130_fd_pr__nfet_01v8 W=1.0u L=0.15u
Rrnl1_5_62 mnl1_5_62 cnl1_62 71392.0469
XTnl1_5_63 row5 gate_l1 mnl1_5_63 0 sky130_fd_pr__nfet_01v8 W=1.0u L=0.15u
Rrnl1_5_63 mnl1_5_63 cnl1_63 3378378.2500
XTnl1_6_0 row6 gate_l1 mnl1_6_0 0 sky130_fd_pr__nfet_01v8 W=1.0u L=0.15u
Rrnl1_6_0 mnl1_6_0 cnl1_0 3378378.2500
XTnl1_6_1 row6 gate_l1 mnl1_6_1 0 sky130_fd_pr__nfet_01v8 W=1.0u L=0.15u
Rrnl1_6_1 mnl1_6_1 cnl1_1 3378378.2500
XTnl1_6_2 row6 gate_l1 mnl1_6_2 0 sky130_fd_pr__nfet_01v8 W=1.0u L=0.15u
Rrnl1_6_2 mnl1_6_2 cnl1_2 707520.7500
XTnl1_6_3 row6 gate_l1 mnl1_6_3 0 sky130_fd_pr__nfet_01v8 W=1.0u L=0.15u
Rrnl1_6_3 mnl1_6_3 cnl1_3 85230.3203
XTnl1_6_4 row6 gate_l1 mnl1_6_4 0 sky130_fd_pr__nfet_01v8 W=1.0u L=0.15u
Rrnl1_6_4 mnl1_6_4 cnl1_4 18634.4297
XTnl1_6_5 row6 gate_l1 mnl1_6_5 0 sky130_fd_pr__nfet_01v8 W=1.0u L=0.15u
Rrnl1_6_5 mnl1_6_5 cnl1_5 24057.7344
XTnl1_6_6 row6 gate_l1 mnl1_6_6 0 sky130_fd_pr__nfet_01v8 W=1.0u L=0.15u
Rrnl1_6_6 mnl1_6_6 cnl1_6 3378378.2500
XTnl1_6_7 row6 gate_l1 mnl1_6_7 0 sky130_fd_pr__nfet_01v8 W=1.0u L=0.15u
Rrnl1_6_7 mnl1_6_7 cnl1_7 3378378.2500
XTnl1_6_8 row6 gate_l1 mnl1_6_8 0 sky130_fd_pr__nfet_01v8 W=1.0u L=0.15u
Rrnl1_6_8 mnl1_6_8 cnl1_8 35028.7930
XTnl1_6_9 row6 gate_l1 mnl1_6_9 0 sky130_fd_pr__nfet_01v8 W=1.0u L=0.15u
Rrnl1_6_9 mnl1_6_9 cnl1_9 3378378.2500
XTnl1_6_10 row6 gate_l1 mnl1_6_10 0 sky130_fd_pr__nfet_01v8 W=1.0u L=0.15u
Rrnl1_6_10 mnl1_6_10 cnl1_10 3378378.2500
XTnl1_6_11 row6 gate_l1 mnl1_6_11 0 sky130_fd_pr__nfet_01v8 W=1.0u L=0.15u
Rrnl1_6_11 mnl1_6_11 cnl1_11 3378378.2500
XTnl1_6_12 row6 gate_l1 mnl1_6_12 0 sky130_fd_pr__nfet_01v8 W=1.0u L=0.15u
Rrnl1_6_12 mnl1_6_12 cnl1_12 59949.1367
XTnl1_6_13 row6 gate_l1 mnl1_6_13 0 sky130_fd_pr__nfet_01v8 W=1.0u L=0.15u
Rrnl1_6_13 mnl1_6_13 cnl1_13 315533.0938
XTnl1_6_14 row6 gate_l1 mnl1_6_14 0 sky130_fd_pr__nfet_01v8 W=1.0u L=0.15u
Rrnl1_6_14 mnl1_6_14 cnl1_14 68141.7031
XTnl1_6_15 row6 gate_l1 mnl1_6_15 0 sky130_fd_pr__nfet_01v8 W=1.0u L=0.15u
Rrnl1_6_15 mnl1_6_15 cnl1_15 3378378.2500
XTnl1_6_16 row6 gate_l1 mnl1_6_16 0 sky130_fd_pr__nfet_01v8 W=1.0u L=0.15u
Rrnl1_6_16 mnl1_6_16 cnl1_16 3378378.2500
XTnl1_6_17 row6 gate_l1 mnl1_6_17 0 sky130_fd_pr__nfet_01v8 W=1.0u L=0.15u
Rrnl1_6_17 mnl1_6_17 cnl1_17 3378378.2500
XTnl1_6_18 row6 gate_l1 mnl1_6_18 0 sky130_fd_pr__nfet_01v8 W=1.0u L=0.15u
Rrnl1_6_18 mnl1_6_18 cnl1_18 34979.5039
XTnl1_6_19 row6 gate_l1 mnl1_6_19 0 sky130_fd_pr__nfet_01v8 W=1.0u L=0.15u
Rrnl1_6_19 mnl1_6_19 cnl1_19 342573.5000
XTnl1_6_20 row6 gate_l1 mnl1_6_20 0 sky130_fd_pr__nfet_01v8 W=1.0u L=0.15u
Rrnl1_6_20 mnl1_6_20 cnl1_20 3378378.2500
XTnl1_6_21 row6 gate_l1 mnl1_6_21 0 sky130_fd_pr__nfet_01v8 W=1.0u L=0.15u
Rrnl1_6_21 mnl1_6_21 cnl1_21 3378378.2500
XTnl1_6_22 row6 gate_l1 mnl1_6_22 0 sky130_fd_pr__nfet_01v8 W=1.0u L=0.15u
Rrnl1_6_22 mnl1_6_22 cnl1_22 37714.9648
XTnl1_6_23 row6 gate_l1 mnl1_6_23 0 sky130_fd_pr__nfet_01v8 W=1.0u L=0.15u
Rrnl1_6_23 mnl1_6_23 cnl1_23 36342.4375
XTnl1_6_24 row6 gate_l1 mnl1_6_24 0 sky130_fd_pr__nfet_01v8 W=1.0u L=0.15u
Rrnl1_6_24 mnl1_6_24 cnl1_24 30698.4746
XTnl1_6_25 row6 gate_l1 mnl1_6_25 0 sky130_fd_pr__nfet_01v8 W=1.0u L=0.15u
Rrnl1_6_25 mnl1_6_25 cnl1_25 178766.7969
XTnl1_6_26 row6 gate_l1 mnl1_6_26 0 sky130_fd_pr__nfet_01v8 W=1.0u L=0.15u
Rrnl1_6_26 mnl1_6_26 cnl1_26 242251.5781
XTnl1_6_27 row6 gate_l1 mnl1_6_27 0 sky130_fd_pr__nfet_01v8 W=1.0u L=0.15u
Rrnl1_6_27 mnl1_6_27 cnl1_27 35781.6992
XTnl1_6_28 row6 gate_l1 mnl1_6_28 0 sky130_fd_pr__nfet_01v8 W=1.0u L=0.15u
Rrnl1_6_28 mnl1_6_28 cnl1_28 3378378.2500
XTnl1_6_29 row6 gate_l1 mnl1_6_29 0 sky130_fd_pr__nfet_01v8 W=1.0u L=0.15u
Rrnl1_6_29 mnl1_6_29 cnl1_29 334734.2500
XTnl1_6_30 row6 gate_l1 mnl1_6_30 0 sky130_fd_pr__nfet_01v8 W=1.0u L=0.15u
Rrnl1_6_30 mnl1_6_30 cnl1_30 307622.2500
XTnl1_6_31 row6 gate_l1 mnl1_6_31 0 sky130_fd_pr__nfet_01v8 W=1.0u L=0.15u
Rrnl1_6_31 mnl1_6_31 cnl1_31 87735.5078
XTnl1_6_32 row6 gate_l1 mnl1_6_32 0 sky130_fd_pr__nfet_01v8 W=1.0u L=0.15u
Rrnl1_6_32 mnl1_6_32 cnl1_32 3378378.2500
XTnl1_6_33 row6 gate_l1 mnl1_6_33 0 sky130_fd_pr__nfet_01v8 W=1.0u L=0.15u
Rrnl1_6_33 mnl1_6_33 cnl1_33 3378378.2500
XTnl1_6_34 row6 gate_l1 mnl1_6_34 0 sky130_fd_pr__nfet_01v8 W=1.0u L=0.15u
Rrnl1_6_34 mnl1_6_34 cnl1_34 115032.5000
XTnl1_6_35 row6 gate_l1 mnl1_6_35 0 sky130_fd_pr__nfet_01v8 W=1.0u L=0.15u
Rrnl1_6_35 mnl1_6_35 cnl1_35 70037.9453
XTnl1_6_36 row6 gate_l1 mnl1_6_36 0 sky130_fd_pr__nfet_01v8 W=1.0u L=0.15u
Rrnl1_6_36 mnl1_6_36 cnl1_36 3378378.2500
XTnl1_6_37 row6 gate_l1 mnl1_6_37 0 sky130_fd_pr__nfet_01v8 W=1.0u L=0.15u
Rrnl1_6_37 mnl1_6_37 cnl1_37 140295.2031
XTnl1_6_38 row6 gate_l1 mnl1_6_38 0 sky130_fd_pr__nfet_01v8 W=1.0u L=0.15u
Rrnl1_6_38 mnl1_6_38 cnl1_38 3378378.2500
XTnl1_6_39 row6 gate_l1 mnl1_6_39 0 sky130_fd_pr__nfet_01v8 W=1.0u L=0.15u
Rrnl1_6_39 mnl1_6_39 cnl1_39 61776.8477
XTnl1_6_40 row6 gate_l1 mnl1_6_40 0 sky130_fd_pr__nfet_01v8 W=1.0u L=0.15u
Rrnl1_6_40 mnl1_6_40 cnl1_40 154341.4531
XTnl1_6_41 row6 gate_l1 mnl1_6_41 0 sky130_fd_pr__nfet_01v8 W=1.0u L=0.15u
Rrnl1_6_41 mnl1_6_41 cnl1_41 235928.6719
XTnl1_6_42 row6 gate_l1 mnl1_6_42 0 sky130_fd_pr__nfet_01v8 W=1.0u L=0.15u
Rrnl1_6_42 mnl1_6_42 cnl1_42 3378378.2500
XTnl1_6_43 row6 gate_l1 mnl1_6_43 0 sky130_fd_pr__nfet_01v8 W=1.0u L=0.15u
Rrnl1_6_43 mnl1_6_43 cnl1_43 3378378.2500
XTnl1_6_44 row6 gate_l1 mnl1_6_44 0 sky130_fd_pr__nfet_01v8 W=1.0u L=0.15u
Rrnl1_6_44 mnl1_6_44 cnl1_44 621313.8750
XTnl1_6_45 row6 gate_l1 mnl1_6_45 0 sky130_fd_pr__nfet_01v8 W=1.0u L=0.15u
Rrnl1_6_45 mnl1_6_45 cnl1_45 87134.3906
XTnl1_6_46 row6 gate_l1 mnl1_6_46 0 sky130_fd_pr__nfet_01v8 W=1.0u L=0.15u
Rrnl1_6_46 mnl1_6_46 cnl1_46 3378378.2500
XTnl1_6_47 row6 gate_l1 mnl1_6_47 0 sky130_fd_pr__nfet_01v8 W=1.0u L=0.15u
Rrnl1_6_47 mnl1_6_47 cnl1_47 3378378.2500
XTnl1_6_48 row6 gate_l1 mnl1_6_48 0 sky130_fd_pr__nfet_01v8 W=1.0u L=0.15u
Rrnl1_6_48 mnl1_6_48 cnl1_48 35286.3008
XTnl1_6_49 row6 gate_l1 mnl1_6_49 0 sky130_fd_pr__nfet_01v8 W=1.0u L=0.15u
Rrnl1_6_49 mnl1_6_49 cnl1_49 3378378.2500
XTnl1_6_50 row6 gate_l1 mnl1_6_50 0 sky130_fd_pr__nfet_01v8 W=1.0u L=0.15u
Rrnl1_6_50 mnl1_6_50 cnl1_50 3378378.2500
XTnl1_6_51 row6 gate_l1 mnl1_6_51 0 sky130_fd_pr__nfet_01v8 W=1.0u L=0.15u
Rrnl1_6_51 mnl1_6_51 cnl1_51 3378378.2500
XTnl1_6_52 row6 gate_l1 mnl1_6_52 0 sky130_fd_pr__nfet_01v8 W=1.0u L=0.15u
Rrnl1_6_52 mnl1_6_52 cnl1_52 3378378.2500
XTnl1_6_53 row6 gate_l1 mnl1_6_53 0 sky130_fd_pr__nfet_01v8 W=1.0u L=0.15u
Rrnl1_6_53 mnl1_6_53 cnl1_53 347565.7188
XTnl1_6_54 row6 gate_l1 mnl1_6_54 0 sky130_fd_pr__nfet_01v8 W=1.0u L=0.15u
Rrnl1_6_54 mnl1_6_54 cnl1_54 3378378.2500
XTnl1_6_55 row6 gate_l1 mnl1_6_55 0 sky130_fd_pr__nfet_01v8 W=1.0u L=0.15u
Rrnl1_6_55 mnl1_6_55 cnl1_55 3378378.2500
XTnl1_6_56 row6 gate_l1 mnl1_6_56 0 sky130_fd_pr__nfet_01v8 W=1.0u L=0.15u
Rrnl1_6_56 mnl1_6_56 cnl1_56 42445.0547
XTnl1_6_57 row6 gate_l1 mnl1_6_57 0 sky130_fd_pr__nfet_01v8 W=1.0u L=0.15u
Rrnl1_6_57 mnl1_6_57 cnl1_57 3378378.2500
XTnl1_6_58 row6 gate_l1 mnl1_6_58 0 sky130_fd_pr__nfet_01v8 W=1.0u L=0.15u
Rrnl1_6_58 mnl1_6_58 cnl1_58 55154.0859
XTnl1_6_59 row6 gate_l1 mnl1_6_59 0 sky130_fd_pr__nfet_01v8 W=1.0u L=0.15u
Rrnl1_6_59 mnl1_6_59 cnl1_59 3378378.2500
XTnl1_6_60 row6 gate_l1 mnl1_6_60 0 sky130_fd_pr__nfet_01v8 W=1.0u L=0.15u
Rrnl1_6_60 mnl1_6_60 cnl1_60 3378378.2500
XTnl1_6_61 row6 gate_l1 mnl1_6_61 0 sky130_fd_pr__nfet_01v8 W=1.0u L=0.15u
Rrnl1_6_61 mnl1_6_61 cnl1_61 3378378.2500
XTnl1_6_62 row6 gate_l1 mnl1_6_62 0 sky130_fd_pr__nfet_01v8 W=1.0u L=0.15u
Rrnl1_6_62 mnl1_6_62 cnl1_62 3378378.2500
XTnl1_6_63 row6 gate_l1 mnl1_6_63 0 sky130_fd_pr__nfet_01v8 W=1.0u L=0.15u
Rrnl1_6_63 mnl1_6_63 cnl1_63 72044.3828
XTnl1_7_0 row7 gate_l1 mnl1_7_0 0 sky130_fd_pr__nfet_01v8 W=1.0u L=0.15u
Rrnl1_7_0 mnl1_7_0 cnl1_0 3378378.2500
XTnl1_7_1 row7 gate_l1 mnl1_7_1 0 sky130_fd_pr__nfet_01v8 W=1.0u L=0.15u
Rrnl1_7_1 mnl1_7_1 cnl1_1 23933.4258
XTnl1_7_2 row7 gate_l1 mnl1_7_2 0 sky130_fd_pr__nfet_01v8 W=1.0u L=0.15u
Rrnl1_7_2 mnl1_7_2 cnl1_2 3378378.2500
XTnl1_7_3 row7 gate_l1 mnl1_7_3 0 sky130_fd_pr__nfet_01v8 W=1.0u L=0.15u
Rrnl1_7_3 mnl1_7_3 cnl1_3 3378378.2500
XTnl1_7_4 row7 gate_l1 mnl1_7_4 0 sky130_fd_pr__nfet_01v8 W=1.0u L=0.15u
Rrnl1_7_4 mnl1_7_4 cnl1_4 22944.4453
XTnl1_7_5 row7 gate_l1 mnl1_7_5 0 sky130_fd_pr__nfet_01v8 W=1.0u L=0.15u
Rrnl1_7_5 mnl1_7_5 cnl1_5 93848.2109
XTnl1_7_6 row7 gate_l1 mnl1_7_6 0 sky130_fd_pr__nfet_01v8 W=1.0u L=0.15u
Rrnl1_7_6 mnl1_7_6 cnl1_6 27278.1953
XTnl1_7_7 row7 gate_l1 mnl1_7_7 0 sky130_fd_pr__nfet_01v8 W=1.0u L=0.15u
Rrnl1_7_7 mnl1_7_7 cnl1_7 38880.8945
XTnl1_7_8 row7 gate_l1 mnl1_7_8 0 sky130_fd_pr__nfet_01v8 W=1.0u L=0.15u
Rrnl1_7_8 mnl1_7_8 cnl1_8 3378378.2500
XTnl1_7_9 row7 gate_l1 mnl1_7_9 0 sky130_fd_pr__nfet_01v8 W=1.0u L=0.15u
Rrnl1_7_9 mnl1_7_9 cnl1_9 183095.4375
XTnl1_7_10 row7 gate_l1 mnl1_7_10 0 sky130_fd_pr__nfet_01v8 W=1.0u L=0.15u
Rrnl1_7_10 mnl1_7_10 cnl1_10 3378378.2500
XTnl1_7_11 row7 gate_l1 mnl1_7_11 0 sky130_fd_pr__nfet_01v8 W=1.0u L=0.15u
Rrnl1_7_11 mnl1_7_11 cnl1_11 3378378.2500
XTnl1_7_12 row7 gate_l1 mnl1_7_12 0 sky130_fd_pr__nfet_01v8 W=1.0u L=0.15u
Rrnl1_7_12 mnl1_7_12 cnl1_12 22528.1777
XTnl1_7_13 row7 gate_l1 mnl1_7_13 0 sky130_fd_pr__nfet_01v8 W=1.0u L=0.15u
Rrnl1_7_13 mnl1_7_13 cnl1_13 3378378.2500
XTnl1_7_14 row7 gate_l1 mnl1_7_14 0 sky130_fd_pr__nfet_01v8 W=1.0u L=0.15u
Rrnl1_7_14 mnl1_7_14 cnl1_14 3378378.2500
XTnl1_7_15 row7 gate_l1 mnl1_7_15 0 sky130_fd_pr__nfet_01v8 W=1.0u L=0.15u
Rrnl1_7_15 mnl1_7_15 cnl1_15 3378378.2500
XTnl1_7_16 row7 gate_l1 mnl1_7_16 0 sky130_fd_pr__nfet_01v8 W=1.0u L=0.15u
Rrnl1_7_16 mnl1_7_16 cnl1_16 26283.3535
XTnl1_7_17 row7 gate_l1 mnl1_7_17 0 sky130_fd_pr__nfet_01v8 W=1.0u L=0.15u
Rrnl1_7_17 mnl1_7_17 cnl1_17 3378378.2500
XTnl1_7_18 row7 gate_l1 mnl1_7_18 0 sky130_fd_pr__nfet_01v8 W=1.0u L=0.15u
Rrnl1_7_18 mnl1_7_18 cnl1_18 23070.8945
XTnl1_7_19 row7 gate_l1 mnl1_7_19 0 sky130_fd_pr__nfet_01v8 W=1.0u L=0.15u
Rrnl1_7_19 mnl1_7_19 cnl1_19 43869.3086
XTnl1_7_20 row7 gate_l1 mnl1_7_20 0 sky130_fd_pr__nfet_01v8 W=1.0u L=0.15u
Rrnl1_7_20 mnl1_7_20 cnl1_20 67476.1172
XTnl1_7_21 row7 gate_l1 mnl1_7_21 0 sky130_fd_pr__nfet_01v8 W=1.0u L=0.15u
Rrnl1_7_21 mnl1_7_21 cnl1_21 23567.2168
XTnl1_7_22 row7 gate_l1 mnl1_7_22 0 sky130_fd_pr__nfet_01v8 W=1.0u L=0.15u
Rrnl1_7_22 mnl1_7_22 cnl1_22 3378378.2500
XTnl1_7_23 row7 gate_l1 mnl1_7_23 0 sky130_fd_pr__nfet_01v8 W=1.0u L=0.15u
Rrnl1_7_23 mnl1_7_23 cnl1_23 3378378.2500
XTnl1_7_24 row7 gate_l1 mnl1_7_24 0 sky130_fd_pr__nfet_01v8 W=1.0u L=0.15u
Rrnl1_7_24 mnl1_7_24 cnl1_24 3378378.2500
XTnl1_7_25 row7 gate_l1 mnl1_7_25 0 sky130_fd_pr__nfet_01v8 W=1.0u L=0.15u
Rrnl1_7_25 mnl1_7_25 cnl1_25 3378378.2500
XTnl1_7_26 row7 gate_l1 mnl1_7_26 0 sky130_fd_pr__nfet_01v8 W=1.0u L=0.15u
Rrnl1_7_26 mnl1_7_26 cnl1_26 3378378.2500
XTnl1_7_27 row7 gate_l1 mnl1_7_27 0 sky130_fd_pr__nfet_01v8 W=1.0u L=0.15u
Rrnl1_7_27 mnl1_7_27 cnl1_27 3378378.2500
XTnl1_7_28 row7 gate_l1 mnl1_7_28 0 sky130_fd_pr__nfet_01v8 W=1.0u L=0.15u
Rrnl1_7_28 mnl1_7_28 cnl1_28 58833.4180
XTnl1_7_29 row7 gate_l1 mnl1_7_29 0 sky130_fd_pr__nfet_01v8 W=1.0u L=0.15u
Rrnl1_7_29 mnl1_7_29 cnl1_29 3378378.2500
XTnl1_7_30 row7 gate_l1 mnl1_7_30 0 sky130_fd_pr__nfet_01v8 W=1.0u L=0.15u
Rrnl1_7_30 mnl1_7_30 cnl1_30 529322.5000
XTnl1_7_31 row7 gate_l1 mnl1_7_31 0 sky130_fd_pr__nfet_01v8 W=1.0u L=0.15u
Rrnl1_7_31 mnl1_7_31 cnl1_31 32049.5273
XTnl1_7_32 row7 gate_l1 mnl1_7_32 0 sky130_fd_pr__nfet_01v8 W=1.0u L=0.15u
Rrnl1_7_32 mnl1_7_32 cnl1_32 113543.4453
XTnl1_7_33 row7 gate_l1 mnl1_7_33 0 sky130_fd_pr__nfet_01v8 W=1.0u L=0.15u
Rrnl1_7_33 mnl1_7_33 cnl1_33 3378378.2500
XTnl1_7_34 row7 gate_l1 mnl1_7_34 0 sky130_fd_pr__nfet_01v8 W=1.0u L=0.15u
Rrnl1_7_34 mnl1_7_34 cnl1_34 3378378.2500
XTnl1_7_35 row7 gate_l1 mnl1_7_35 0 sky130_fd_pr__nfet_01v8 W=1.0u L=0.15u
Rrnl1_7_35 mnl1_7_35 cnl1_35 3378378.2500
XTnl1_7_36 row7 gate_l1 mnl1_7_36 0 sky130_fd_pr__nfet_01v8 W=1.0u L=0.15u
Rrnl1_7_36 mnl1_7_36 cnl1_36 45589.6719
XTnl1_7_37 row7 gate_l1 mnl1_7_37 0 sky130_fd_pr__nfet_01v8 W=1.0u L=0.15u
Rrnl1_7_37 mnl1_7_37 cnl1_37 34809.0234
XTnl1_7_38 row7 gate_l1 mnl1_7_38 0 sky130_fd_pr__nfet_01v8 W=1.0u L=0.15u
Rrnl1_7_38 mnl1_7_38 cnl1_38 3378378.2500
XTnl1_7_39 row7 gate_l1 mnl1_7_39 0 sky130_fd_pr__nfet_01v8 W=1.0u L=0.15u
Rrnl1_7_39 mnl1_7_39 cnl1_39 27072.8730
XTnl1_7_40 row7 gate_l1 mnl1_7_40 0 sky130_fd_pr__nfet_01v8 W=1.0u L=0.15u
Rrnl1_7_40 mnl1_7_40 cnl1_40 3378378.2500
XTnl1_7_41 row7 gate_l1 mnl1_7_41 0 sky130_fd_pr__nfet_01v8 W=1.0u L=0.15u
Rrnl1_7_41 mnl1_7_41 cnl1_41 55055.7539
XTnl1_7_42 row7 gate_l1 mnl1_7_42 0 sky130_fd_pr__nfet_01v8 W=1.0u L=0.15u
Rrnl1_7_42 mnl1_7_42 cnl1_42 21840.7324
XTnl1_7_43 row7 gate_l1 mnl1_7_43 0 sky130_fd_pr__nfet_01v8 W=1.0u L=0.15u
Rrnl1_7_43 mnl1_7_43 cnl1_43 43986.1484
XTnl1_7_44 row7 gate_l1 mnl1_7_44 0 sky130_fd_pr__nfet_01v8 W=1.0u L=0.15u
Rrnl1_7_44 mnl1_7_44 cnl1_44 49870.8828
XTnl1_7_45 row7 gate_l1 mnl1_7_45 0 sky130_fd_pr__nfet_01v8 W=1.0u L=0.15u
Rrnl1_7_45 mnl1_7_45 cnl1_45 3378378.2500
XTnl1_7_46 row7 gate_l1 mnl1_7_46 0 sky130_fd_pr__nfet_01v8 W=1.0u L=0.15u
Rrnl1_7_46 mnl1_7_46 cnl1_46 3378378.2500
XTnl1_7_47 row7 gate_l1 mnl1_7_47 0 sky130_fd_pr__nfet_01v8 W=1.0u L=0.15u
Rrnl1_7_47 mnl1_7_47 cnl1_47 3378378.2500
XTnl1_7_48 row7 gate_l1 mnl1_7_48 0 sky130_fd_pr__nfet_01v8 W=1.0u L=0.15u
Rrnl1_7_48 mnl1_7_48 cnl1_48 3378378.2500
XTnl1_7_49 row7 gate_l1 mnl1_7_49 0 sky130_fd_pr__nfet_01v8 W=1.0u L=0.15u
Rrnl1_7_49 mnl1_7_49 cnl1_49 722871.6250
XTnl1_7_50 row7 gate_l1 mnl1_7_50 0 sky130_fd_pr__nfet_01v8 W=1.0u L=0.15u
Rrnl1_7_50 mnl1_7_50 cnl1_50 121767.7812
XTnl1_7_51 row7 gate_l1 mnl1_7_51 0 sky130_fd_pr__nfet_01v8 W=1.0u L=0.15u
Rrnl1_7_51 mnl1_7_51 cnl1_51 3378378.2500
XTnl1_7_52 row7 gate_l1 mnl1_7_52 0 sky130_fd_pr__nfet_01v8 W=1.0u L=0.15u
Rrnl1_7_52 mnl1_7_52 cnl1_52 119675.0156
XTnl1_7_53 row7 gate_l1 mnl1_7_53 0 sky130_fd_pr__nfet_01v8 W=1.0u L=0.15u
Rrnl1_7_53 mnl1_7_53 cnl1_53 112672.7109
XTnl1_7_54 row7 gate_l1 mnl1_7_54 0 sky130_fd_pr__nfet_01v8 W=1.0u L=0.15u
Rrnl1_7_54 mnl1_7_54 cnl1_54 52960.1562
XTnl1_7_55 row7 gate_l1 mnl1_7_55 0 sky130_fd_pr__nfet_01v8 W=1.0u L=0.15u
Rrnl1_7_55 mnl1_7_55 cnl1_55 853421.0000
XTnl1_7_56 row7 gate_l1 mnl1_7_56 0 sky130_fd_pr__nfet_01v8 W=1.0u L=0.15u
Rrnl1_7_56 mnl1_7_56 cnl1_56 3378378.2500
XTnl1_7_57 row7 gate_l1 mnl1_7_57 0 sky130_fd_pr__nfet_01v8 W=1.0u L=0.15u
Rrnl1_7_57 mnl1_7_57 cnl1_57 3378378.2500
XTnl1_7_58 row7 gate_l1 mnl1_7_58 0 sky130_fd_pr__nfet_01v8 W=1.0u L=0.15u
Rrnl1_7_58 mnl1_7_58 cnl1_58 41718.5859
XTnl1_7_59 row7 gate_l1 mnl1_7_59 0 sky130_fd_pr__nfet_01v8 W=1.0u L=0.15u
Rrnl1_7_59 mnl1_7_59 cnl1_59 3378378.2500
XTnl1_7_60 row7 gate_l1 mnl1_7_60 0 sky130_fd_pr__nfet_01v8 W=1.0u L=0.15u
Rrnl1_7_60 mnl1_7_60 cnl1_60 3378378.2500
XTnl1_7_61 row7 gate_l1 mnl1_7_61 0 sky130_fd_pr__nfet_01v8 W=1.0u L=0.15u
Rrnl1_7_61 mnl1_7_61 cnl1_61 107258.1641
XTnl1_7_62 row7 gate_l1 mnl1_7_62 0 sky130_fd_pr__nfet_01v8 W=1.0u L=0.15u
Rrnl1_7_62 mnl1_7_62 cnl1_62 3378378.2500
XTnl1_7_63 row7 gate_l1 mnl1_7_63 0 sky130_fd_pr__nfet_01v8 W=1.0u L=0.15u
Rrnl1_7_63 mnl1_7_63 cnl1_63 1463917.1250

* --- Column current sensing (virtual ground) ---
Vspl1_0 cpl1_0 0 0
Vsnl1_0 cnl1_0 0 0
Vspl1_1 cpl1_1 0 0
Vsnl1_1 cnl1_1 0 0
Vspl1_2 cpl1_2 0 0
Vsnl1_2 cnl1_2 0 0
Vspl1_3 cpl1_3 0 0
Vsnl1_3 cnl1_3 0 0
Vspl1_4 cpl1_4 0 0
Vsnl1_4 cnl1_4 0 0
Vspl1_5 cpl1_5 0 0
Vsnl1_5 cnl1_5 0 0
Vspl1_6 cpl1_6 0 0
Vsnl1_6 cnl1_6 0 0
Vspl1_7 cpl1_7 0 0
Vsnl1_7 cnl1_7 0 0
Vspl1_8 cpl1_8 0 0
Vsnl1_8 cnl1_8 0 0
Vspl1_9 cpl1_9 0 0
Vsnl1_9 cnl1_9 0 0
Vspl1_10 cpl1_10 0 0
Vsnl1_10 cnl1_10 0 0
Vspl1_11 cpl1_11 0 0
Vsnl1_11 cnl1_11 0 0
Vspl1_12 cpl1_12 0 0
Vsnl1_12 cnl1_12 0 0
Vspl1_13 cpl1_13 0 0
Vsnl1_13 cnl1_13 0 0
Vspl1_14 cpl1_14 0 0
Vsnl1_14 cnl1_14 0 0
Vspl1_15 cpl1_15 0 0
Vsnl1_15 cnl1_15 0 0
Vspl1_16 cpl1_16 0 0
Vsnl1_16 cnl1_16 0 0
Vspl1_17 cpl1_17 0 0
Vsnl1_17 cnl1_17 0 0
Vspl1_18 cpl1_18 0 0
Vsnl1_18 cnl1_18 0 0
Vspl1_19 cpl1_19 0 0
Vsnl1_19 cnl1_19 0 0
Vspl1_20 cpl1_20 0 0
Vsnl1_20 cnl1_20 0 0
Vspl1_21 cpl1_21 0 0
Vsnl1_21 cnl1_21 0 0
Vspl1_22 cpl1_22 0 0
Vsnl1_22 cnl1_22 0 0
Vspl1_23 cpl1_23 0 0
Vsnl1_23 cnl1_23 0 0
Vspl1_24 cpl1_24 0 0
Vsnl1_24 cnl1_24 0 0
Vspl1_25 cpl1_25 0 0
Vsnl1_25 cnl1_25 0 0
Vspl1_26 cpl1_26 0 0
Vsnl1_26 cnl1_26 0 0
Vspl1_27 cpl1_27 0 0
Vsnl1_27 cnl1_27 0 0
Vspl1_28 cpl1_28 0 0
Vsnl1_28 cnl1_28 0 0
Vspl1_29 cpl1_29 0 0
Vsnl1_29 cnl1_29 0 0
Vspl1_30 cpl1_30 0 0
Vsnl1_30 cnl1_30 0 0
Vspl1_31 cpl1_31 0 0
Vsnl1_31 cnl1_31 0 0
Vspl1_32 cpl1_32 0 0
Vsnl1_32 cnl1_32 0 0
Vspl1_33 cpl1_33 0 0
Vsnl1_33 cnl1_33 0 0
Vspl1_34 cpl1_34 0 0
Vsnl1_34 cnl1_34 0 0
Vspl1_35 cpl1_35 0 0
Vsnl1_35 cnl1_35 0 0
Vspl1_36 cpl1_36 0 0
Vsnl1_36 cnl1_36 0 0
Vspl1_37 cpl1_37 0 0
Vsnl1_37 cnl1_37 0 0
Vspl1_38 cpl1_38 0 0
Vsnl1_38 cnl1_38 0 0
Vspl1_39 cpl1_39 0 0
Vsnl1_39 cnl1_39 0 0
Vspl1_40 cpl1_40 0 0
Vsnl1_40 cnl1_40 0 0
Vspl1_41 cpl1_41 0 0
Vsnl1_41 cnl1_41 0 0
Vspl1_42 cpl1_42 0 0
Vsnl1_42 cnl1_42 0 0
Vspl1_43 cpl1_43 0 0
Vsnl1_43 cnl1_43 0 0
Vspl1_44 cpl1_44 0 0
Vsnl1_44 cnl1_44 0 0
Vspl1_45 cpl1_45 0 0
Vsnl1_45 cnl1_45 0 0
Vspl1_46 cpl1_46 0 0
Vsnl1_46 cnl1_46 0 0
Vspl1_47 cpl1_47 0 0
Vsnl1_47 cnl1_47 0 0
Vspl1_48 cpl1_48 0 0
Vsnl1_48 cnl1_48 0 0
Vspl1_49 cpl1_49 0 0
Vsnl1_49 cnl1_49 0 0
Vspl1_50 cpl1_50 0 0
Vsnl1_50 cnl1_50 0 0
Vspl1_51 cpl1_51 0 0
Vsnl1_51 cnl1_51 0 0
Vspl1_52 cpl1_52 0 0
Vsnl1_52 cnl1_52 0 0
Vspl1_53 cpl1_53 0 0
Vsnl1_53 cnl1_53 0 0
Vspl1_54 cpl1_54 0 0
Vsnl1_54 cnl1_54 0 0
Vspl1_55 cpl1_55 0 0
Vsnl1_55 cnl1_55 0 0
Vspl1_56 cpl1_56 0 0
Vsnl1_56 cnl1_56 0 0
Vspl1_57 cpl1_57 0 0
Vsnl1_57 cnl1_57 0 0
Vspl1_58 cpl1_58 0 0
Vsnl1_58 cnl1_58 0 0
Vspl1_59 cpl1_59 0 0
Vsnl1_59 cnl1_59 0 0
Vspl1_60 cpl1_60 0 0
Vsnl1_60 cnl1_60 0 0
Vspl1_61 cpl1_61 0 0
Vsnl1_61 cnl1_61 0 0
Vspl1_62 cpl1_62 0 0
Vsnl1_62 cnl1_62 0 0
Vspl1_63 cpl1_63 0 0
Vsnl1_63 cnl1_63 0 0

* ===== L1 CROSSBAR -> INTERSTAGE CONNECTIONS =====
* CCCS transfers differential MAC current to interstage nodes
* Scale factor: 1.3705e+05

Fmac1p_0 nmac1_0 0 Vspl1_0 1.0
Fmac1n_0 0 nmac1_0 Vsnl1_0 1.0
Fmac1p_1 nmac1_1 0 Vspl1_1 1.0
Fmac1n_1 0 nmac1_1 Vsnl1_1 1.0
Fmac1p_2 nmac1_2 0 Vspl1_2 1.0
Fmac1n_2 0 nmac1_2 Vsnl1_2 1.0
Fmac1p_3 nmac1_3 0 Vspl1_3 1.0
Fmac1n_3 0 nmac1_3 Vsnl1_3 1.0
Fmac1p_4 nmac1_4 0 Vspl1_4 1.0
Fmac1n_4 0 nmac1_4 Vsnl1_4 1.0
Fmac1p_5 nmac1_5 0 Vspl1_5 1.0
Fmac1n_5 0 nmac1_5 Vsnl1_5 1.0
Fmac1p_6 nmac1_6 0 Vspl1_6 1.0
Fmac1n_6 0 nmac1_6 Vsnl1_6 1.0
Fmac1p_7 nmac1_7 0 Vspl1_7 1.0
Fmac1n_7 0 nmac1_7 Vsnl1_7 1.0
Fmac1p_8 nmac1_8 0 Vspl1_8 1.0
Fmac1n_8 0 nmac1_8 Vsnl1_8 1.0
Fmac1p_9 nmac1_9 0 Vspl1_9 1.0
Fmac1n_9 0 nmac1_9 Vsnl1_9 1.0
Fmac1p_10 nmac1_10 0 Vspl1_10 1.0
Fmac1n_10 0 nmac1_10 Vsnl1_10 1.0
Fmac1p_11 nmac1_11 0 Vspl1_11 1.0
Fmac1n_11 0 nmac1_11 Vsnl1_11 1.0
Fmac1p_12 nmac1_12 0 Vspl1_12 1.0
Fmac1n_12 0 nmac1_12 Vsnl1_12 1.0
Fmac1p_13 nmac1_13 0 Vspl1_13 1.0
Fmac1n_13 0 nmac1_13 Vsnl1_13 1.0
Fmac1p_14 nmac1_14 0 Vspl1_14 1.0
Fmac1n_14 0 nmac1_14 Vsnl1_14 1.0
Fmac1p_15 nmac1_15 0 Vspl1_15 1.0
Fmac1n_15 0 nmac1_15 Vsnl1_15 1.0
Fmac1p_16 nmac1_16 0 Vspl1_16 1.0
Fmac1n_16 0 nmac1_16 Vsnl1_16 1.0
Fmac1p_17 nmac1_17 0 Vspl1_17 1.0
Fmac1n_17 0 nmac1_17 Vsnl1_17 1.0
Fmac1p_18 nmac1_18 0 Vspl1_18 1.0
Fmac1n_18 0 nmac1_18 Vsnl1_18 1.0
Fmac1p_19 nmac1_19 0 Vspl1_19 1.0
Fmac1n_19 0 nmac1_19 Vsnl1_19 1.0
Fmac1p_20 nmac1_20 0 Vspl1_20 1.0
Fmac1n_20 0 nmac1_20 Vsnl1_20 1.0
Fmac1p_21 nmac1_21 0 Vspl1_21 1.0
Fmac1n_21 0 nmac1_21 Vsnl1_21 1.0
Fmac1p_22 nmac1_22 0 Vspl1_22 1.0
Fmac1n_22 0 nmac1_22 Vsnl1_22 1.0
Fmac1p_23 nmac1_23 0 Vspl1_23 1.0
Fmac1n_23 0 nmac1_23 Vsnl1_23 1.0
Fmac1p_24 nmac1_24 0 Vspl1_24 1.0
Fmac1n_24 0 nmac1_24 Vsnl1_24 1.0
Fmac1p_25 nmac1_25 0 Vspl1_25 1.0
Fmac1n_25 0 nmac1_25 Vsnl1_25 1.0
Fmac1p_26 nmac1_26 0 Vspl1_26 1.0
Fmac1n_26 0 nmac1_26 Vsnl1_26 1.0
Fmac1p_27 nmac1_27 0 Vspl1_27 1.0
Fmac1n_27 0 nmac1_27 Vsnl1_27 1.0
Fmac1p_28 nmac1_28 0 Vspl1_28 1.0
Fmac1n_28 0 nmac1_28 Vsnl1_28 1.0
Fmac1p_29 nmac1_29 0 Vspl1_29 1.0
Fmac1n_29 0 nmac1_29 Vsnl1_29 1.0
Fmac1p_30 nmac1_30 0 Vspl1_30 1.0
Fmac1n_30 0 nmac1_30 Vsnl1_30 1.0
Fmac1p_31 nmac1_31 0 Vspl1_31 1.0
Fmac1n_31 0 nmac1_31 Vsnl1_31 1.0
Fmac1p_32 nmac1_32 0 Vspl1_32 1.0
Fmac1n_32 0 nmac1_32 Vsnl1_32 1.0
Fmac1p_33 nmac1_33 0 Vspl1_33 1.0
Fmac1n_33 0 nmac1_33 Vsnl1_33 1.0
Fmac1p_34 nmac1_34 0 Vspl1_34 1.0
Fmac1n_34 0 nmac1_34 Vsnl1_34 1.0
Fmac1p_35 nmac1_35 0 Vspl1_35 1.0
Fmac1n_35 0 nmac1_35 Vsnl1_35 1.0
Fmac1p_36 nmac1_36 0 Vspl1_36 1.0
Fmac1n_36 0 nmac1_36 Vsnl1_36 1.0
Fmac1p_37 nmac1_37 0 Vspl1_37 1.0
Fmac1n_37 0 nmac1_37 Vsnl1_37 1.0
Fmac1p_38 nmac1_38 0 Vspl1_38 1.0
Fmac1n_38 0 nmac1_38 Vsnl1_38 1.0
Fmac1p_39 nmac1_39 0 Vspl1_39 1.0
Fmac1n_39 0 nmac1_39 Vsnl1_39 1.0
Fmac1p_40 nmac1_40 0 Vspl1_40 1.0
Fmac1n_40 0 nmac1_40 Vsnl1_40 1.0
Fmac1p_41 nmac1_41 0 Vspl1_41 1.0
Fmac1n_41 0 nmac1_41 Vsnl1_41 1.0
Fmac1p_42 nmac1_42 0 Vspl1_42 1.0
Fmac1n_42 0 nmac1_42 Vsnl1_42 1.0
Fmac1p_43 nmac1_43 0 Vspl1_43 1.0
Fmac1n_43 0 nmac1_43 Vsnl1_43 1.0
Fmac1p_44 nmac1_44 0 Vspl1_44 1.0
Fmac1n_44 0 nmac1_44 Vsnl1_44 1.0
Fmac1p_45 nmac1_45 0 Vspl1_45 1.0
Fmac1n_45 0 nmac1_45 Vsnl1_45 1.0
Fmac1p_46 nmac1_46 0 Vspl1_46 1.0
Fmac1n_46 0 nmac1_46 Vsnl1_46 1.0
Fmac1p_47 nmac1_47 0 Vspl1_47 1.0
Fmac1n_47 0 nmac1_47 Vsnl1_47 1.0
Fmac1p_48 nmac1_48 0 Vspl1_48 1.0
Fmac1n_48 0 nmac1_48 Vsnl1_48 1.0
Fmac1p_49 nmac1_49 0 Vspl1_49 1.0
Fmac1n_49 0 nmac1_49 Vsnl1_49 1.0
Fmac1p_50 nmac1_50 0 Vspl1_50 1.0
Fmac1n_50 0 nmac1_50 Vsnl1_50 1.0
Fmac1p_51 nmac1_51 0 Vspl1_51 1.0
Fmac1n_51 0 nmac1_51 Vsnl1_51 1.0
Fmac1p_52 nmac1_52 0 Vspl1_52 1.0
Fmac1n_52 0 nmac1_52 Vsnl1_52 1.0
Fmac1p_53 nmac1_53 0 Vspl1_53 1.0
Fmac1n_53 0 nmac1_53 Vsnl1_53 1.0
Fmac1p_54 nmac1_54 0 Vspl1_54 1.0
Fmac1n_54 0 nmac1_54 Vsnl1_54 1.0
Fmac1p_55 nmac1_55 0 Vspl1_55 1.0
Fmac1n_55 0 nmac1_55 Vsnl1_55 1.0
Fmac1p_56 nmac1_56 0 Vspl1_56 1.0
Fmac1n_56 0 nmac1_56 Vsnl1_56 1.0
Fmac1p_57 nmac1_57 0 Vspl1_57 1.0
Fmac1n_57 0 nmac1_57 Vsnl1_57 1.0
Fmac1p_58 nmac1_58 0 Vspl1_58 1.0
Fmac1n_58 0 nmac1_58 Vsnl1_58 1.0
Fmac1p_59 nmac1_59 0 Vspl1_59 1.0
Fmac1n_59 0 nmac1_59 Vsnl1_59 1.0
Fmac1p_60 nmac1_60 0 Vspl1_60 1.0
Fmac1n_60 0 nmac1_60 Vsnl1_60 1.0
Fmac1p_61 nmac1_61 0 Vspl1_61 1.0
Fmac1n_61 0 nmac1_61 Vsnl1_61 1.0
Fmac1p_62 nmac1_62 0 Vspl1_62 1.0
Fmac1n_62 0 nmac1_62 Vsnl1_62 1.0
Fmac1p_63 nmac1_63 0 Vspl1_63 1.0
Fmac1n_63 0 nmac1_63 Vsnl1_63 1.0

* ===== L1->L2 INTERSTAGE: BIAS + ReLU + OUTPUT (64 channels) =====

* --- Ch 0: b1=+0.4650, I_bias=+3.393uA ---
Ibr1_0 pbr1_0 0 3.393170e-06
Xbr1_0 pbr1_0 pbr1_0 vdd vdd sky130_fd_pr__pfet_01v8 W=2.0u L=0.5u
Xbm1_0 nmac1_0 pbr1_0 vdd vdd sky130_fd_pr__pfet_01v8 W=2.0u L=0.5u
Xr1a_0 nmac1_0 nmac1_0 0 0 sky130_fd_pr__nfet_01v8 W=4.0u L=0.5u
Xr1b_0 nrelu1_0 nmac1_0 0 0 sky130_fd_pr__nfet_01v8 W=4.0u L=0.5u
Xopr_0 nrelu1_0 nrelu1_0 vdd vdd sky130_fd_pr__pfet_01v8 W=2.0u L=0.5u
Xopm_0 vout1_0 nrelu1_0 vdd vdd sky130_fd_pr__pfet_01v8 W=2.0u L=0.5u

* --- Ch 1: b1=+0.6426, I_bias=+4.689uA ---
Ibr1_1 pbr1_1 0 4.688775e-06
Xbr1_1 pbr1_1 pbr1_1 vdd vdd sky130_fd_pr__pfet_01v8 W=2.0u L=0.5u
Xbm1_1 nmac1_1 pbr1_1 vdd vdd sky130_fd_pr__pfet_01v8 W=2.0u L=0.5u
Xr1a_1 nmac1_1 nmac1_1 0 0 sky130_fd_pr__nfet_01v8 W=4.0u L=0.5u
Xr1b_1 nrelu1_1 nmac1_1 0 0 sky130_fd_pr__nfet_01v8 W=4.0u L=0.5u
Xopr_1 nrelu1_1 nrelu1_1 vdd vdd sky130_fd_pr__pfet_01v8 W=2.0u L=0.5u
Xopm_1 vout1_1 nrelu1_1 vdd vdd sky130_fd_pr__pfet_01v8 W=2.0u L=0.5u

* --- Ch 2: b1=+0.3112, I_bias=+2.271uA ---
Ibr1_2 pbr1_2 0 2.271013e-06
Xbr1_2 pbr1_2 pbr1_2 vdd vdd sky130_fd_pr__pfet_01v8 W=2.0u L=0.5u
Xbm1_2 nmac1_2 pbr1_2 vdd vdd sky130_fd_pr__pfet_01v8 W=2.0u L=0.5u
Xr1a_2 nmac1_2 nmac1_2 0 0 sky130_fd_pr__nfet_01v8 W=4.0u L=0.5u
Xr1b_2 nrelu1_2 nmac1_2 0 0 sky130_fd_pr__nfet_01v8 W=4.0u L=0.5u
Xopr_2 nrelu1_2 nrelu1_2 vdd vdd sky130_fd_pr__pfet_01v8 W=2.0u L=0.5u
Xopm_2 vout1_2 nrelu1_2 vdd vdd sky130_fd_pr__pfet_01v8 W=2.0u L=0.5u

* --- Ch 3: b1=-0.5029, I_bias=-3.669uA ---
Ibr1_3 vdd nbr1_3 3.669412e-06
Xbr1_3 nbr1_3 nbr1_3 0 0 sky130_fd_pr__nfet_01v8 W=2.0u L=0.5u
Xbm1_3 nmac1_3 nbr1_3 0 0 sky130_fd_pr__nfet_01v8 W=2.0u L=0.5u
Xr1a_3 nmac1_3 nmac1_3 0 0 sky130_fd_pr__nfet_01v8 W=4.0u L=0.5u
Xr1b_3 nrelu1_3 nmac1_3 0 0 sky130_fd_pr__nfet_01v8 W=4.0u L=0.5u
Xopr_3 nrelu1_3 nrelu1_3 vdd vdd sky130_fd_pr__pfet_01v8 W=2.0u L=0.5u
Xopm_3 vout1_3 nrelu1_3 vdd vdd sky130_fd_pr__pfet_01v8 W=2.0u L=0.5u

* --- Ch 4: b1=-0.5301, I_bias=-3.868uA ---
Ibr1_4 vdd nbr1_4 3.867704e-06
Xbr1_4 nbr1_4 nbr1_4 0 0 sky130_fd_pr__nfet_01v8 W=2.0u L=0.5u
Xbm1_4 nmac1_4 nbr1_4 0 0 sky130_fd_pr__nfet_01v8 W=2.0u L=0.5u
Xr1a_4 nmac1_4 nmac1_4 0 0 sky130_fd_pr__nfet_01v8 W=4.0u L=0.5u
Xr1b_4 nrelu1_4 nmac1_4 0 0 sky130_fd_pr__nfet_01v8 W=4.0u L=0.5u
Xopr_4 nrelu1_4 nrelu1_4 vdd vdd sky130_fd_pr__pfet_01v8 W=2.0u L=0.5u
Xopm_4 vout1_4 nrelu1_4 vdd vdd sky130_fd_pr__pfet_01v8 W=2.0u L=0.5u

* --- Ch 5: b1=+0.3955, I_bias=+2.886uA ---
Ibr1_5 pbr1_5 0 2.886097e-06
Xbr1_5 pbr1_5 pbr1_5 vdd vdd sky130_fd_pr__pfet_01v8 W=2.0u L=0.5u
Xbm1_5 nmac1_5 pbr1_5 vdd vdd sky130_fd_pr__pfet_01v8 W=2.0u L=0.5u
Xr1a_5 nmac1_5 nmac1_5 0 0 sky130_fd_pr__nfet_01v8 W=4.0u L=0.5u
Xr1b_5 nrelu1_5 nmac1_5 0 0 sky130_fd_pr__nfet_01v8 W=4.0u L=0.5u
Xopr_5 nrelu1_5 nrelu1_5 vdd vdd sky130_fd_pr__pfet_01v8 W=2.0u L=0.5u
Xopm_5 vout1_5 nrelu1_5 vdd vdd sky130_fd_pr__pfet_01v8 W=2.0u L=0.5u

* --- Ch 6: b1=-0.2996, I_bias=-2.186uA ---
Ibr1_6 vdd nbr1_6 2.186062e-06
Xbr1_6 nbr1_6 nbr1_6 0 0 sky130_fd_pr__nfet_01v8 W=2.0u L=0.5u
Xbm1_6 nmac1_6 nbr1_6 0 0 sky130_fd_pr__nfet_01v8 W=2.0u L=0.5u
Xr1a_6 nmac1_6 nmac1_6 0 0 sky130_fd_pr__nfet_01v8 W=4.0u L=0.5u
Xr1b_6 nrelu1_6 nmac1_6 0 0 sky130_fd_pr__nfet_01v8 W=4.0u L=0.5u
Xopr_6 nrelu1_6 nrelu1_6 vdd vdd sky130_fd_pr__pfet_01v8 W=2.0u L=0.5u
Xopm_6 vout1_6 nrelu1_6 vdd vdd sky130_fd_pr__pfet_01v8 W=2.0u L=0.5u

* --- Ch 7: b1=+0.1716, I_bias=+1.252uA ---
Ibr1_7 pbr1_7 0 1.252094e-06
Xbr1_7 pbr1_7 pbr1_7 vdd vdd sky130_fd_pr__pfet_01v8 W=2.0u L=0.5u
Xbm1_7 nmac1_7 pbr1_7 vdd vdd sky130_fd_pr__pfet_01v8 W=2.0u L=0.5u
Xr1a_7 nmac1_7 nmac1_7 0 0 sky130_fd_pr__nfet_01v8 W=4.0u L=0.5u
Xr1b_7 nrelu1_7 nmac1_7 0 0 sky130_fd_pr__nfet_01v8 W=4.0u L=0.5u
Xopr_7 nrelu1_7 nrelu1_7 vdd vdd sky130_fd_pr__pfet_01v8 W=2.0u L=0.5u
Xopm_7 vout1_7 nrelu1_7 vdd vdd sky130_fd_pr__pfet_01v8 W=2.0u L=0.5u

* --- Ch 8: b1=+0.2146, I_bias=+1.566uA ---
Ibr1_8 pbr1_8 0 1.565698e-06
Xbr1_8 pbr1_8 pbr1_8 vdd vdd sky130_fd_pr__pfet_01v8 W=2.0u L=0.5u
Xbm1_8 nmac1_8 pbr1_8 vdd vdd sky130_fd_pr__pfet_01v8 W=2.0u L=0.5u
Xr1a_8 nmac1_8 nmac1_8 0 0 sky130_fd_pr__nfet_01v8 W=4.0u L=0.5u
Xr1b_8 nrelu1_8 nmac1_8 0 0 sky130_fd_pr__nfet_01v8 W=4.0u L=0.5u
Xopr_8 nrelu1_8 nrelu1_8 vdd vdd sky130_fd_pr__pfet_01v8 W=2.0u L=0.5u
Xopm_8 vout1_8 nrelu1_8 vdd vdd sky130_fd_pr__pfet_01v8 W=2.0u L=0.5u

* --- Ch 9: b1=+0.3301, I_bias=+2.409uA ---
Ibr1_9 pbr1_9 0 2.408927e-06
Xbr1_9 pbr1_9 pbr1_9 vdd vdd sky130_fd_pr__pfet_01v8 W=2.0u L=0.5u
Xbm1_9 nmac1_9 pbr1_9 vdd vdd sky130_fd_pr__pfet_01v8 W=2.0u L=0.5u
Xr1a_9 nmac1_9 nmac1_9 0 0 sky130_fd_pr__nfet_01v8 W=4.0u L=0.5u
Xr1b_9 nrelu1_9 nmac1_9 0 0 sky130_fd_pr__nfet_01v8 W=4.0u L=0.5u
Xopr_9 nrelu1_9 nrelu1_9 vdd vdd sky130_fd_pr__pfet_01v8 W=2.0u L=0.5u
Xopm_9 vout1_9 nrelu1_9 vdd vdd sky130_fd_pr__pfet_01v8 W=2.0u L=0.5u

* --- Ch 10: b1=+0.4096, I_bias=+2.989uA ---
Ibr1_10 pbr1_10 0 2.988797e-06
Xbr1_10 pbr1_10 pbr1_10 vdd vdd sky130_fd_pr__pfet_01v8 W=2.0u L=0.5u
Xbm1_10 nmac1_10 pbr1_10 vdd vdd sky130_fd_pr__pfet_01v8 W=2.0u L=0.5u
Xr1a_10 nmac1_10 nmac1_10 0 0 sky130_fd_pr__nfet_01v8 W=4.0u L=0.5u
Xr1b_10 nrelu1_10 nmac1_10 0 0 sky130_fd_pr__nfet_01v8 W=4.0u L=0.5u
Xopr_10 nrelu1_10 nrelu1_10 vdd vdd sky130_fd_pr__pfet_01v8 W=2.0u L=0.5u
Xopm_10 vout1_10 nrelu1_10 vdd vdd sky130_fd_pr__pfet_01v8 W=2.0u L=0.5u

* --- Ch 11: b1=+0.1977, I_bias=+1.442uA ---
Ibr1_11 pbr1_11 0 1.442247e-06
Xbr1_11 pbr1_11 pbr1_11 vdd vdd sky130_fd_pr__pfet_01v8 W=2.0u L=0.5u
Xbm1_11 nmac1_11 pbr1_11 vdd vdd sky130_fd_pr__pfet_01v8 W=2.0u L=0.5u
Xr1a_11 nmac1_11 nmac1_11 0 0 sky130_fd_pr__nfet_01v8 W=4.0u L=0.5u
Xr1b_11 nrelu1_11 nmac1_11 0 0 sky130_fd_pr__nfet_01v8 W=4.0u L=0.5u
Xopr_11 nrelu1_11 nrelu1_11 vdd vdd sky130_fd_pr__pfet_01v8 W=2.0u L=0.5u
Xopm_11 vout1_11 nrelu1_11 vdd vdd sky130_fd_pr__pfet_01v8 W=2.0u L=0.5u

* --- Ch 12: b1=+0.6179, I_bias=+4.508uA ---
Ibr1_12 pbr1_12 0 4.508251e-06
Xbr1_12 pbr1_12 pbr1_12 vdd vdd sky130_fd_pr__pfet_01v8 W=2.0u L=0.5u
Xbm1_12 nmac1_12 pbr1_12 vdd vdd sky130_fd_pr__pfet_01v8 W=2.0u L=0.5u
Xr1a_12 nmac1_12 nmac1_12 0 0 sky130_fd_pr__nfet_01v8 W=4.0u L=0.5u
Xr1b_12 nrelu1_12 nmac1_12 0 0 sky130_fd_pr__nfet_01v8 W=4.0u L=0.5u
Xopr_12 nrelu1_12 nrelu1_12 vdd vdd sky130_fd_pr__pfet_01v8 W=2.0u L=0.5u
Xopm_12 vout1_12 nrelu1_12 vdd vdd sky130_fd_pr__pfet_01v8 W=2.0u L=0.5u

* --- Ch 13: b1=-0.1762, I_bias=-1.286uA ---
Ibr1_13 vdd nbr1_13 1.285916e-06
Xbr1_13 nbr1_13 nbr1_13 0 0 sky130_fd_pr__nfet_01v8 W=2.0u L=0.5u
Xbm1_13 nmac1_13 nbr1_13 0 0 sky130_fd_pr__nfet_01v8 W=2.0u L=0.5u
Xr1a_13 nmac1_13 nmac1_13 0 0 sky130_fd_pr__nfet_01v8 W=4.0u L=0.5u
Xr1b_13 nrelu1_13 nmac1_13 0 0 sky130_fd_pr__nfet_01v8 W=4.0u L=0.5u
Xopr_13 nrelu1_13 nrelu1_13 vdd vdd sky130_fd_pr__pfet_01v8 W=2.0u L=0.5u
Xopm_13 vout1_13 nrelu1_13 vdd vdd sky130_fd_pr__pfet_01v8 W=2.0u L=0.5u

* --- Ch 14: b1=+0.2749, I_bias=+2.006uA ---
Ibr1_14 pbr1_14 0 2.005765e-06
Xbr1_14 pbr1_14 pbr1_14 vdd vdd sky130_fd_pr__pfet_01v8 W=2.0u L=0.5u
Xbm1_14 nmac1_14 pbr1_14 vdd vdd sky130_fd_pr__pfet_01v8 W=2.0u L=0.5u
Xr1a_14 nmac1_14 nmac1_14 0 0 sky130_fd_pr__nfet_01v8 W=4.0u L=0.5u
Xr1b_14 nrelu1_14 nmac1_14 0 0 sky130_fd_pr__nfet_01v8 W=4.0u L=0.5u
Xopr_14 nrelu1_14 nrelu1_14 vdd vdd sky130_fd_pr__pfet_01v8 W=2.0u L=0.5u
Xopm_14 vout1_14 nrelu1_14 vdd vdd sky130_fd_pr__pfet_01v8 W=2.0u L=0.5u

* --- Ch 15: b1=+0.8467, I_bias=+6.178uA ---
Ibr1_15 pbr1_15 0 6.177771e-06
Xbr1_15 pbr1_15 pbr1_15 vdd vdd sky130_fd_pr__pfet_01v8 W=2.0u L=0.5u
Xbm1_15 nmac1_15 pbr1_15 vdd vdd sky130_fd_pr__pfet_01v8 W=2.0u L=0.5u
Xr1a_15 nmac1_15 nmac1_15 0 0 sky130_fd_pr__nfet_01v8 W=4.0u L=0.5u
Xr1b_15 nrelu1_15 nmac1_15 0 0 sky130_fd_pr__nfet_01v8 W=4.0u L=0.5u
Xopr_15 nrelu1_15 nrelu1_15 vdd vdd sky130_fd_pr__pfet_01v8 W=2.0u L=0.5u
Xopm_15 vout1_15 nrelu1_15 vdd vdd sky130_fd_pr__pfet_01v8 W=2.0u L=0.5u

* --- Ch 16: b1=+0.2326, I_bias=+1.698uA ---
Ibr1_16 pbr1_16 0 1.697520e-06
Xbr1_16 pbr1_16 pbr1_16 vdd vdd sky130_fd_pr__pfet_01v8 W=2.0u L=0.5u
Xbm1_16 nmac1_16 pbr1_16 vdd vdd sky130_fd_pr__pfet_01v8 W=2.0u L=0.5u
Xr1a_16 nmac1_16 nmac1_16 0 0 sky130_fd_pr__nfet_01v8 W=4.0u L=0.5u
Xr1b_16 nrelu1_16 nmac1_16 0 0 sky130_fd_pr__nfet_01v8 W=4.0u L=0.5u
Xopr_16 nrelu1_16 nrelu1_16 vdd vdd sky130_fd_pr__pfet_01v8 W=2.0u L=0.5u
Xopm_16 vout1_16 nrelu1_16 vdd vdd sky130_fd_pr__pfet_01v8 W=2.0u L=0.5u

* --- Ch 17: b1=-0.0738, I_bias=-0.539uA ---
Ibr1_17 vdd nbr1_17 5.388297e-07
Xbr1_17 nbr1_17 nbr1_17 0 0 sky130_fd_pr__nfet_01v8 W=2.0u L=0.5u
Xbm1_17 nmac1_17 nbr1_17 0 0 sky130_fd_pr__nfet_01v8 W=2.0u L=0.5u
Xr1a_17 nmac1_17 nmac1_17 0 0 sky130_fd_pr__nfet_01v8 W=4.0u L=0.5u
Xr1b_17 nrelu1_17 nmac1_17 0 0 sky130_fd_pr__nfet_01v8 W=4.0u L=0.5u
Xopr_17 nrelu1_17 nrelu1_17 vdd vdd sky130_fd_pr__pfet_01v8 W=2.0u L=0.5u
Xopm_17 vout1_17 nrelu1_17 vdd vdd sky130_fd_pr__pfet_01v8 W=2.0u L=0.5u

* --- Ch 18: b1=+0.4478, I_bias=+3.267uA ---
Ibr1_18 pbr1_18 0 3.267203e-06
Xbr1_18 pbr1_18 pbr1_18 vdd vdd sky130_fd_pr__pfet_01v8 W=2.0u L=0.5u
Xbm1_18 nmac1_18 pbr1_18 vdd vdd sky130_fd_pr__pfet_01v8 W=2.0u L=0.5u
Xr1a_18 nmac1_18 nmac1_18 0 0 sky130_fd_pr__nfet_01v8 W=4.0u L=0.5u
Xr1b_18 nrelu1_18 nmac1_18 0 0 sky130_fd_pr__nfet_01v8 W=4.0u L=0.5u
Xopr_18 nrelu1_18 nrelu1_18 vdd vdd sky130_fd_pr__pfet_01v8 W=2.0u L=0.5u
Xopm_18 vout1_18 nrelu1_18 vdd vdd sky130_fd_pr__pfet_01v8 W=2.0u L=0.5u

* --- Ch 19: b1=+0.5260, I_bias=+3.838uA ---
Ibr1_19 pbr1_19 0 3.838292e-06
Xbr1_19 pbr1_19 pbr1_19 vdd vdd sky130_fd_pr__pfet_01v8 W=2.0u L=0.5u
Xbm1_19 nmac1_19 pbr1_19 vdd vdd sky130_fd_pr__pfet_01v8 W=2.0u L=0.5u
Xr1a_19 nmac1_19 nmac1_19 0 0 sky130_fd_pr__nfet_01v8 W=4.0u L=0.5u
Xr1b_19 nrelu1_19 nmac1_19 0 0 sky130_fd_pr__nfet_01v8 W=4.0u L=0.5u
Xopr_19 nrelu1_19 nrelu1_19 vdd vdd sky130_fd_pr__pfet_01v8 W=2.0u L=0.5u
Xopm_19 vout1_19 nrelu1_19 vdd vdd sky130_fd_pr__pfet_01v8 W=2.0u L=0.5u

* --- Ch 20: b1=+0.2476, I_bias=+1.807uA ---
Ibr1_20 pbr1_20 0 1.806949e-06
Xbr1_20 pbr1_20 pbr1_20 vdd vdd sky130_fd_pr__pfet_01v8 W=2.0u L=0.5u
Xbm1_20 nmac1_20 pbr1_20 vdd vdd sky130_fd_pr__pfet_01v8 W=2.0u L=0.5u
Xr1a_20 nmac1_20 nmac1_20 0 0 sky130_fd_pr__nfet_01v8 W=4.0u L=0.5u
Xr1b_20 nrelu1_20 nmac1_20 0 0 sky130_fd_pr__nfet_01v8 W=4.0u L=0.5u
Xopr_20 nrelu1_20 nrelu1_20 vdd vdd sky130_fd_pr__pfet_01v8 W=2.0u L=0.5u
Xopm_20 vout1_20 nrelu1_20 vdd vdd sky130_fd_pr__pfet_01v8 W=2.0u L=0.5u

* --- Ch 21: b1=+0.4029, I_bias=+2.940uA ---
Ibr1_21 pbr1_21 0 2.939844e-06
Xbr1_21 pbr1_21 pbr1_21 vdd vdd sky130_fd_pr__pfet_01v8 W=2.0u L=0.5u
Xbm1_21 nmac1_21 pbr1_21 vdd vdd sky130_fd_pr__pfet_01v8 W=2.0u L=0.5u
Xr1a_21 nmac1_21 nmac1_21 0 0 sky130_fd_pr__nfet_01v8 W=4.0u L=0.5u
Xr1b_21 nrelu1_21 nmac1_21 0 0 sky130_fd_pr__nfet_01v8 W=4.0u L=0.5u
Xopr_21 nrelu1_21 nrelu1_21 vdd vdd sky130_fd_pr__pfet_01v8 W=2.0u L=0.5u
Xopm_21 vout1_21 nrelu1_21 vdd vdd sky130_fd_pr__pfet_01v8 W=2.0u L=0.5u

* --- Ch 22: b1=+0.3913, I_bias=+2.855uA ---
Ibr1_22 pbr1_22 0 2.855161e-06
Xbr1_22 pbr1_22 pbr1_22 vdd vdd sky130_fd_pr__pfet_01v8 W=2.0u L=0.5u
Xbm1_22 nmac1_22 pbr1_22 vdd vdd sky130_fd_pr__pfet_01v8 W=2.0u L=0.5u
Xr1a_22 nmac1_22 nmac1_22 0 0 sky130_fd_pr__nfet_01v8 W=4.0u L=0.5u
Xr1b_22 nrelu1_22 nmac1_22 0 0 sky130_fd_pr__nfet_01v8 W=4.0u L=0.5u
Xopr_22 nrelu1_22 nrelu1_22 vdd vdd sky130_fd_pr__pfet_01v8 W=2.0u L=0.5u
Xopm_22 vout1_22 nrelu1_22 vdd vdd sky130_fd_pr__pfet_01v8 W=2.0u L=0.5u

* --- Ch 23: b1=-0.1100, I_bias=-0.803uA ---
Ibr1_23 vdd nbr1_23 8.029714e-07
Xbr1_23 nbr1_23 nbr1_23 0 0 sky130_fd_pr__nfet_01v8 W=2.0u L=0.5u
Xbm1_23 nmac1_23 nbr1_23 0 0 sky130_fd_pr__nfet_01v8 W=2.0u L=0.5u
Xr1a_23 nmac1_23 nmac1_23 0 0 sky130_fd_pr__nfet_01v8 W=4.0u L=0.5u
Xr1b_23 nrelu1_23 nmac1_23 0 0 sky130_fd_pr__nfet_01v8 W=4.0u L=0.5u
Xopr_23 nrelu1_23 nrelu1_23 vdd vdd sky130_fd_pr__pfet_01v8 W=2.0u L=0.5u
Xopm_23 vout1_23 nrelu1_23 vdd vdd sky130_fd_pr__pfet_01v8 W=2.0u L=0.5u

* --- Ch 24: b1=-0.6038, I_bias=-4.406uA ---
Ibr1_24 vdd nbr1_24 4.406052e-06
Xbr1_24 nbr1_24 nbr1_24 0 0 sky130_fd_pr__nfet_01v8 W=2.0u L=0.5u
Xbm1_24 nmac1_24 nbr1_24 0 0 sky130_fd_pr__nfet_01v8 W=2.0u L=0.5u
Xr1a_24 nmac1_24 nmac1_24 0 0 sky130_fd_pr__nfet_01v8 W=4.0u L=0.5u
Xr1b_24 nrelu1_24 nmac1_24 0 0 sky130_fd_pr__nfet_01v8 W=4.0u L=0.5u
Xopr_24 nrelu1_24 nrelu1_24 vdd vdd sky130_fd_pr__pfet_01v8 W=2.0u L=0.5u
Xopm_24 vout1_24 nrelu1_24 vdd vdd sky130_fd_pr__pfet_01v8 W=2.0u L=0.5u

* --- Ch 25: b1=-0.4903, I_bias=-3.577uA ---
Ibr1_25 vdd nbr1_25 3.577431e-06
Xbr1_25 nbr1_25 nbr1_25 0 0 sky130_fd_pr__nfet_01v8 W=2.0u L=0.5u
Xbm1_25 nmac1_25 nbr1_25 0 0 sky130_fd_pr__nfet_01v8 W=2.0u L=0.5u
Xr1a_25 nmac1_25 nmac1_25 0 0 sky130_fd_pr__nfet_01v8 W=4.0u L=0.5u
Xr1b_25 nrelu1_25 nmac1_25 0 0 sky130_fd_pr__nfet_01v8 W=4.0u L=0.5u
Xopr_25 nrelu1_25 nrelu1_25 vdd vdd sky130_fd_pr__pfet_01v8 W=2.0u L=0.5u
Xopm_25 vout1_25 nrelu1_25 vdd vdd sky130_fd_pr__pfet_01v8 W=2.0u L=0.5u

* --- Ch 26: b1=-0.3717, I_bias=-2.712uA ---
Ibr1_26 vdd nbr1_26 2.712245e-06
Xbr1_26 nbr1_26 nbr1_26 0 0 sky130_fd_pr__nfet_01v8 W=2.0u L=0.5u
Xbm1_26 nmac1_26 nbr1_26 0 0 sky130_fd_pr__nfet_01v8 W=2.0u L=0.5u
Xr1a_26 nmac1_26 nmac1_26 0 0 sky130_fd_pr__nfet_01v8 W=4.0u L=0.5u
Xr1b_26 nrelu1_26 nmac1_26 0 0 sky130_fd_pr__nfet_01v8 W=4.0u L=0.5u
Xopr_26 nrelu1_26 nrelu1_26 vdd vdd sky130_fd_pr__pfet_01v8 W=2.0u L=0.5u
Xopm_26 vout1_26 nrelu1_26 vdd vdd sky130_fd_pr__pfet_01v8 W=2.0u L=0.5u

* --- Ch 27: b1=-0.1676, I_bias=-1.223uA ---
Ibr1_27 vdd nbr1_27 1.222814e-06
Xbr1_27 nbr1_27 nbr1_27 0 0 sky130_fd_pr__nfet_01v8 W=2.0u L=0.5u
Xbm1_27 nmac1_27 nbr1_27 0 0 sky130_fd_pr__nfet_01v8 W=2.0u L=0.5u
Xr1a_27 nmac1_27 nmac1_27 0 0 sky130_fd_pr__nfet_01v8 W=4.0u L=0.5u
Xr1b_27 nrelu1_27 nmac1_27 0 0 sky130_fd_pr__nfet_01v8 W=4.0u L=0.5u
Xopr_27 nrelu1_27 nrelu1_27 vdd vdd sky130_fd_pr__pfet_01v8 W=2.0u L=0.5u
Xopm_27 vout1_27 nrelu1_27 vdd vdd sky130_fd_pr__pfet_01v8 W=2.0u L=0.5u

* --- Ch 28: b1=-0.0447, I_bias=-0.326uA ---
Ibr1_28 vdd nbr1_28 3.258976e-07
Xbr1_28 nbr1_28 nbr1_28 0 0 sky130_fd_pr__nfet_01v8 W=2.0u L=0.5u
Xbm1_28 nmac1_28 nbr1_28 0 0 sky130_fd_pr__nfet_01v8 W=2.0u L=0.5u
Xr1a_28 nmac1_28 nmac1_28 0 0 sky130_fd_pr__nfet_01v8 W=4.0u L=0.5u
Xr1b_28 nrelu1_28 nmac1_28 0 0 sky130_fd_pr__nfet_01v8 W=4.0u L=0.5u
Xopr_28 nrelu1_28 nrelu1_28 vdd vdd sky130_fd_pr__pfet_01v8 W=2.0u L=0.5u
Xopm_28 vout1_28 nrelu1_28 vdd vdd sky130_fd_pr__pfet_01v8 W=2.0u L=0.5u

* --- Ch 29: b1=+0.5772, I_bias=+4.212uA ---
Ibr1_29 pbr1_29 0 4.211540e-06
Xbr1_29 pbr1_29 pbr1_29 vdd vdd sky130_fd_pr__pfet_01v8 W=2.0u L=0.5u
Xbm1_29 nmac1_29 pbr1_29 vdd vdd sky130_fd_pr__pfet_01v8 W=2.0u L=0.5u
Xr1a_29 nmac1_29 nmac1_29 0 0 sky130_fd_pr__nfet_01v8 W=4.0u L=0.5u
Xr1b_29 nrelu1_29 nmac1_29 0 0 sky130_fd_pr__nfet_01v8 W=4.0u L=0.5u
Xopr_29 nrelu1_29 nrelu1_29 vdd vdd sky130_fd_pr__pfet_01v8 W=2.0u L=0.5u
Xopm_29 vout1_29 nrelu1_29 vdd vdd sky130_fd_pr__pfet_01v8 W=2.0u L=0.5u

* --- Ch 30: b1=-0.0683, I_bias=-0.498uA ---
Ibr1_30 vdd nbr1_30 4.981289e-07
Xbr1_30 nbr1_30 nbr1_30 0 0 sky130_fd_pr__nfet_01v8 W=2.0u L=0.5u
Xbm1_30 nmac1_30 nbr1_30 0 0 sky130_fd_pr__nfet_01v8 W=2.0u L=0.5u
Xr1a_30 nmac1_30 nmac1_30 0 0 sky130_fd_pr__nfet_01v8 W=4.0u L=0.5u
Xr1b_30 nrelu1_30 nmac1_30 0 0 sky130_fd_pr__nfet_01v8 W=4.0u L=0.5u
Xopr_30 nrelu1_30 nrelu1_30 vdd vdd sky130_fd_pr__pfet_01v8 W=2.0u L=0.5u
Xopm_30 vout1_30 nrelu1_30 vdd vdd sky130_fd_pr__pfet_01v8 W=2.0u L=0.5u

* --- Ch 31: b1=-0.5201, I_bias=-3.795uA ---
Ibr1_31 vdd nbr1_31 3.794640e-06
Xbr1_31 nbr1_31 nbr1_31 0 0 sky130_fd_pr__nfet_01v8 W=2.0u L=0.5u
Xbm1_31 nmac1_31 nbr1_31 0 0 sky130_fd_pr__nfet_01v8 W=2.0u L=0.5u
Xr1a_31 nmac1_31 nmac1_31 0 0 sky130_fd_pr__nfet_01v8 W=4.0u L=0.5u
Xr1b_31 nrelu1_31 nmac1_31 0 0 sky130_fd_pr__nfet_01v8 W=4.0u L=0.5u
Xopr_31 nrelu1_31 nrelu1_31 vdd vdd sky130_fd_pr__pfet_01v8 W=2.0u L=0.5u
Xopm_31 vout1_31 nrelu1_31 vdd vdd sky130_fd_pr__pfet_01v8 W=2.0u L=0.5u

* --- Ch 32: b1=-0.3467, I_bias=-2.530uA ---
Ibr1_32 vdd nbr1_32 2.530065e-06
Xbr1_32 nbr1_32 nbr1_32 0 0 sky130_fd_pr__nfet_01v8 W=2.0u L=0.5u
Xbm1_32 nmac1_32 nbr1_32 0 0 sky130_fd_pr__nfet_01v8 W=2.0u L=0.5u
Xr1a_32 nmac1_32 nmac1_32 0 0 sky130_fd_pr__nfet_01v8 W=4.0u L=0.5u
Xr1b_32 nrelu1_32 nmac1_32 0 0 sky130_fd_pr__nfet_01v8 W=4.0u L=0.5u
Xopr_32 nrelu1_32 nrelu1_32 vdd vdd sky130_fd_pr__pfet_01v8 W=2.0u L=0.5u
Xopm_32 vout1_32 nrelu1_32 vdd vdd sky130_fd_pr__pfet_01v8 W=2.0u L=0.5u

* --- Ch 33: b1=-0.1307, I_bias=-0.953uA ---
Ibr1_33 vdd nbr1_33 9.534147e-07
Xbr1_33 nbr1_33 nbr1_33 0 0 sky130_fd_pr__nfet_01v8 W=2.0u L=0.5u
Xbm1_33 nmac1_33 nbr1_33 0 0 sky130_fd_pr__nfet_01v8 W=2.0u L=0.5u
Xr1a_33 nmac1_33 nmac1_33 0 0 sky130_fd_pr__nfet_01v8 W=4.0u L=0.5u
Xr1b_33 nrelu1_33 nmac1_33 0 0 sky130_fd_pr__nfet_01v8 W=4.0u L=0.5u
Xopr_33 nrelu1_33 nrelu1_33 vdd vdd sky130_fd_pr__pfet_01v8 W=2.0u L=0.5u
Xopm_33 vout1_33 nrelu1_33 vdd vdd sky130_fd_pr__pfet_01v8 W=2.0u L=0.5u

* --- Ch 34: b1=-0.3553, I_bias=-2.592uA ---
Ibr1_34 vdd nbr1_34 2.592139e-06
Xbr1_34 nbr1_34 nbr1_34 0 0 sky130_fd_pr__nfet_01v8 W=2.0u L=0.5u
Xbm1_34 nmac1_34 nbr1_34 0 0 sky130_fd_pr__nfet_01v8 W=2.0u L=0.5u
Xr1a_34 nmac1_34 nmac1_34 0 0 sky130_fd_pr__nfet_01v8 W=4.0u L=0.5u
Xr1b_34 nrelu1_34 nmac1_34 0 0 sky130_fd_pr__nfet_01v8 W=4.0u L=0.5u
Xopr_34 nrelu1_34 nrelu1_34 vdd vdd sky130_fd_pr__pfet_01v8 W=2.0u L=0.5u
Xopm_34 vout1_34 nrelu1_34 vdd vdd sky130_fd_pr__pfet_01v8 W=2.0u L=0.5u

* --- Ch 35: b1=+0.6304, I_bias=+4.600uA ---
Ibr1_35 pbr1_35 0 4.600161e-06
Xbr1_35 pbr1_35 pbr1_35 vdd vdd sky130_fd_pr__pfet_01v8 W=2.0u L=0.5u
Xbm1_35 nmac1_35 pbr1_35 vdd vdd sky130_fd_pr__pfet_01v8 W=2.0u L=0.5u
Xr1a_35 nmac1_35 nmac1_35 0 0 sky130_fd_pr__nfet_01v8 W=4.0u L=0.5u
Xr1b_35 nrelu1_35 nmac1_35 0 0 sky130_fd_pr__nfet_01v8 W=4.0u L=0.5u
Xopr_35 nrelu1_35 nrelu1_35 vdd vdd sky130_fd_pr__pfet_01v8 W=2.0u L=0.5u
Xopm_35 vout1_35 nrelu1_35 vdd vdd sky130_fd_pr__pfet_01v8 W=2.0u L=0.5u

* --- Ch 36: b1=+0.2845, I_bias=+2.076uA ---
Ibr1_36 pbr1_36 0 2.075596e-06
Xbr1_36 pbr1_36 pbr1_36 vdd vdd sky130_fd_pr__pfet_01v8 W=2.0u L=0.5u
Xbm1_36 nmac1_36 pbr1_36 vdd vdd sky130_fd_pr__pfet_01v8 W=2.0u L=0.5u
Xr1a_36 nmac1_36 nmac1_36 0 0 sky130_fd_pr__nfet_01v8 W=4.0u L=0.5u
Xr1b_36 nrelu1_36 nmac1_36 0 0 sky130_fd_pr__nfet_01v8 W=4.0u L=0.5u
Xopr_36 nrelu1_36 nrelu1_36 vdd vdd sky130_fd_pr__pfet_01v8 W=2.0u L=0.5u
Xopm_36 vout1_36 nrelu1_36 vdd vdd sky130_fd_pr__pfet_01v8 W=2.0u L=0.5u

* --- Ch 37: b1=+0.4677, I_bias=+3.412uA ---
Ibr1_37 pbr1_37 0 3.412357e-06
Xbr1_37 pbr1_37 pbr1_37 vdd vdd sky130_fd_pr__pfet_01v8 W=2.0u L=0.5u
Xbm1_37 nmac1_37 pbr1_37 vdd vdd sky130_fd_pr__pfet_01v8 W=2.0u L=0.5u
Xr1a_37 nmac1_37 nmac1_37 0 0 sky130_fd_pr__nfet_01v8 W=4.0u L=0.5u
Xr1b_37 nrelu1_37 nmac1_37 0 0 sky130_fd_pr__nfet_01v8 W=4.0u L=0.5u
Xopr_37 nrelu1_37 nrelu1_37 vdd vdd sky130_fd_pr__pfet_01v8 W=2.0u L=0.5u
Xopm_37 vout1_37 nrelu1_37 vdd vdd sky130_fd_pr__pfet_01v8 W=2.0u L=0.5u

* --- Ch 38: b1=+0.1709, I_bias=+1.247uA ---
Ibr1_38 pbr1_38 0 1.246815e-06
Xbr1_38 pbr1_38 pbr1_38 vdd vdd sky130_fd_pr__pfet_01v8 W=2.0u L=0.5u
Xbm1_38 nmac1_38 pbr1_38 vdd vdd sky130_fd_pr__pfet_01v8 W=2.0u L=0.5u
Xr1a_38 nmac1_38 nmac1_38 0 0 sky130_fd_pr__nfet_01v8 W=4.0u L=0.5u
Xr1b_38 nrelu1_38 nmac1_38 0 0 sky130_fd_pr__nfet_01v8 W=4.0u L=0.5u
Xopr_38 nrelu1_38 nrelu1_38 vdd vdd sky130_fd_pr__pfet_01v8 W=2.0u L=0.5u
Xopm_38 vout1_38 nrelu1_38 vdd vdd sky130_fd_pr__pfet_01v8 W=2.0u L=0.5u

* --- Ch 39: b1=+0.9210, I_bias=+6.720uA ---
Ibr1_39 pbr1_39 0 6.720176e-06
Xbr1_39 pbr1_39 pbr1_39 vdd vdd sky130_fd_pr__pfet_01v8 W=2.0u L=0.5u
Xbm1_39 nmac1_39 pbr1_39 vdd vdd sky130_fd_pr__pfet_01v8 W=2.0u L=0.5u
Xr1a_39 nmac1_39 nmac1_39 0 0 sky130_fd_pr__nfet_01v8 W=4.0u L=0.5u
Xr1b_39 nrelu1_39 nmac1_39 0 0 sky130_fd_pr__nfet_01v8 W=4.0u L=0.5u
Xopr_39 nrelu1_39 nrelu1_39 vdd vdd sky130_fd_pr__pfet_01v8 W=2.0u L=0.5u
Xopm_39 vout1_39 nrelu1_39 vdd vdd sky130_fd_pr__pfet_01v8 W=2.0u L=0.5u

* --- Ch 40: b1=+0.2586, I_bias=+1.887uA ---
Ibr1_40 pbr1_40 0 1.886644e-06
Xbr1_40 pbr1_40 pbr1_40 vdd vdd sky130_fd_pr__pfet_01v8 W=2.0u L=0.5u
Xbm1_40 nmac1_40 pbr1_40 vdd vdd sky130_fd_pr__pfet_01v8 W=2.0u L=0.5u
Xr1a_40 nmac1_40 nmac1_40 0 0 sky130_fd_pr__nfet_01v8 W=4.0u L=0.5u
Xr1b_40 nrelu1_40 nmac1_40 0 0 sky130_fd_pr__nfet_01v8 W=4.0u L=0.5u
Xopr_40 nrelu1_40 nrelu1_40 vdd vdd sky130_fd_pr__pfet_01v8 W=2.0u L=0.5u
Xopm_40 vout1_40 nrelu1_40 vdd vdd sky130_fd_pr__pfet_01v8 W=2.0u L=0.5u

* --- Ch 41: b1=+0.0132, I_bias=+0.096uA ---
Ibr1_41 pbr1_41 0 9.638369e-08
Xbr1_41 pbr1_41 pbr1_41 vdd vdd sky130_fd_pr__pfet_01v8 W=2.0u L=0.5u
Xbm1_41 nmac1_41 pbr1_41 vdd vdd sky130_fd_pr__pfet_01v8 W=2.0u L=0.5u
Xr1a_41 nmac1_41 nmac1_41 0 0 sky130_fd_pr__nfet_01v8 W=4.0u L=0.5u
Xr1b_41 nrelu1_41 nmac1_41 0 0 sky130_fd_pr__nfet_01v8 W=4.0u L=0.5u
Xopr_41 nrelu1_41 nrelu1_41 vdd vdd sky130_fd_pr__pfet_01v8 W=2.0u L=0.5u
Xopm_41 vout1_41 nrelu1_41 vdd vdd sky130_fd_pr__pfet_01v8 W=2.0u L=0.5u

* --- Ch 42: b1=+0.2657, I_bias=+1.939uA ---
Ibr1_42 pbr1_42 0 1.938971e-06
Xbr1_42 pbr1_42 pbr1_42 vdd vdd sky130_fd_pr__pfet_01v8 W=2.0u L=0.5u
Xbm1_42 nmac1_42 pbr1_42 vdd vdd sky130_fd_pr__pfet_01v8 W=2.0u L=0.5u
Xr1a_42 nmac1_42 nmac1_42 0 0 sky130_fd_pr__nfet_01v8 W=4.0u L=0.5u
Xr1b_42 nrelu1_42 nmac1_42 0 0 sky130_fd_pr__nfet_01v8 W=4.0u L=0.5u
Xopr_42 nrelu1_42 nrelu1_42 vdd vdd sky130_fd_pr__pfet_01v8 W=2.0u L=0.5u
Xopm_42 vout1_42 nrelu1_42 vdd vdd sky130_fd_pr__pfet_01v8 W=2.0u L=0.5u

* --- Ch 43: b1=+0.4071, I_bias=+2.970uA ---
Ibr1_43 pbr1_43 0 2.970488e-06
Xbr1_43 pbr1_43 pbr1_43 vdd vdd sky130_fd_pr__pfet_01v8 W=2.0u L=0.5u
Xbm1_43 nmac1_43 pbr1_43 vdd vdd sky130_fd_pr__pfet_01v8 W=2.0u L=0.5u
Xr1a_43 nmac1_43 nmac1_43 0 0 sky130_fd_pr__nfet_01v8 W=4.0u L=0.5u
Xr1b_43 nrelu1_43 nmac1_43 0 0 sky130_fd_pr__nfet_01v8 W=4.0u L=0.5u
Xopr_43 nrelu1_43 nrelu1_43 vdd vdd sky130_fd_pr__pfet_01v8 W=2.0u L=0.5u
Xopm_43 vout1_43 nrelu1_43 vdd vdd sky130_fd_pr__pfet_01v8 W=2.0u L=0.5u

* --- Ch 44: b1=+0.7960, I_bias=+5.808uA ---
Ibr1_44 pbr1_44 0 5.808172e-06
Xbr1_44 pbr1_44 pbr1_44 vdd vdd sky130_fd_pr__pfet_01v8 W=2.0u L=0.5u
Xbm1_44 nmac1_44 pbr1_44 vdd vdd sky130_fd_pr__pfet_01v8 W=2.0u L=0.5u
Xr1a_44 nmac1_44 nmac1_44 0 0 sky130_fd_pr__nfet_01v8 W=4.0u L=0.5u
Xr1b_44 nrelu1_44 nmac1_44 0 0 sky130_fd_pr__nfet_01v8 W=4.0u L=0.5u
Xopr_44 nrelu1_44 nrelu1_44 vdd vdd sky130_fd_pr__pfet_01v8 W=2.0u L=0.5u
Xopm_44 vout1_44 nrelu1_44 vdd vdd sky130_fd_pr__pfet_01v8 W=2.0u L=0.5u

* --- Ch 45: b1=+0.4527, I_bias=+3.303uA ---
Ibr1_45 pbr1_45 0 3.303167e-06
Xbr1_45 pbr1_45 pbr1_45 vdd vdd sky130_fd_pr__pfet_01v8 W=2.0u L=0.5u
Xbm1_45 nmac1_45 pbr1_45 vdd vdd sky130_fd_pr__pfet_01v8 W=2.0u L=0.5u
Xr1a_45 nmac1_45 nmac1_45 0 0 sky130_fd_pr__nfet_01v8 W=4.0u L=0.5u
Xr1b_45 nrelu1_45 nmac1_45 0 0 sky130_fd_pr__nfet_01v8 W=4.0u L=0.5u
Xopr_45 nrelu1_45 nrelu1_45 vdd vdd sky130_fd_pr__pfet_01v8 W=2.0u L=0.5u
Xopm_45 vout1_45 nrelu1_45 vdd vdd sky130_fd_pr__pfet_01v8 W=2.0u L=0.5u

* --- Ch 46: b1=+0.7408, I_bias=+5.405uA ---
Ibr1_46 pbr1_46 0 5.405056e-06
Xbr1_46 pbr1_46 pbr1_46 vdd vdd sky130_fd_pr__pfet_01v8 W=2.0u L=0.5u
Xbm1_46 nmac1_46 pbr1_46 vdd vdd sky130_fd_pr__pfet_01v8 W=2.0u L=0.5u
Xr1a_46 nmac1_46 nmac1_46 0 0 sky130_fd_pr__nfet_01v8 W=4.0u L=0.5u
Xr1b_46 nrelu1_46 nmac1_46 0 0 sky130_fd_pr__nfet_01v8 W=4.0u L=0.5u
Xopr_46 nrelu1_46 nrelu1_46 vdd vdd sky130_fd_pr__pfet_01v8 W=2.0u L=0.5u
Xopm_46 vout1_46 nrelu1_46 vdd vdd sky130_fd_pr__pfet_01v8 W=2.0u L=0.5u

* --- Ch 47: b1=+0.0333, I_bias=+0.243uA ---
Ibr1_47 pbr1_47 0 2.429735e-07
Xbr1_47 pbr1_47 pbr1_47 vdd vdd sky130_fd_pr__pfet_01v8 W=2.0u L=0.5u
Xbm1_47 nmac1_47 pbr1_47 vdd vdd sky130_fd_pr__pfet_01v8 W=2.0u L=0.5u
Xr1a_47 nmac1_47 nmac1_47 0 0 sky130_fd_pr__nfet_01v8 W=4.0u L=0.5u
Xr1b_47 nrelu1_47 nmac1_47 0 0 sky130_fd_pr__nfet_01v8 W=4.0u L=0.5u
Xopr_47 nrelu1_47 nrelu1_47 vdd vdd sky130_fd_pr__pfet_01v8 W=2.0u L=0.5u
Xopm_47 vout1_47 nrelu1_47 vdd vdd sky130_fd_pr__pfet_01v8 W=2.0u L=0.5u

* --- Ch 48: b1=+0.0742, I_bias=+0.541uA ---
Ibr1_48 pbr1_48 0 5.414562e-07
Xbr1_48 pbr1_48 pbr1_48 vdd vdd sky130_fd_pr__pfet_01v8 W=2.0u L=0.5u
Xbm1_48 nmac1_48 pbr1_48 vdd vdd sky130_fd_pr__pfet_01v8 W=2.0u L=0.5u
Xr1a_48 nmac1_48 nmac1_48 0 0 sky130_fd_pr__nfet_01v8 W=4.0u L=0.5u
Xr1b_48 nrelu1_48 nmac1_48 0 0 sky130_fd_pr__nfet_01v8 W=4.0u L=0.5u
Xopr_48 nrelu1_48 nrelu1_48 vdd vdd sky130_fd_pr__pfet_01v8 W=2.0u L=0.5u
Xopm_48 vout1_48 nrelu1_48 vdd vdd sky130_fd_pr__pfet_01v8 W=2.0u L=0.5u

* --- Ch 49: b1=+0.1182, I_bias=+0.862uA ---
Ibr1_49 pbr1_49 0 8.621545e-07
Xbr1_49 pbr1_49 pbr1_49 vdd vdd sky130_fd_pr__pfet_01v8 W=2.0u L=0.5u
Xbm1_49 nmac1_49 pbr1_49 vdd vdd sky130_fd_pr__pfet_01v8 W=2.0u L=0.5u
Xr1a_49 nmac1_49 nmac1_49 0 0 sky130_fd_pr__nfet_01v8 W=4.0u L=0.5u
Xr1b_49 nrelu1_49 nmac1_49 0 0 sky130_fd_pr__nfet_01v8 W=4.0u L=0.5u
Xopr_49 nrelu1_49 nrelu1_49 vdd vdd sky130_fd_pr__pfet_01v8 W=2.0u L=0.5u
Xopm_49 vout1_49 nrelu1_49 vdd vdd sky130_fd_pr__pfet_01v8 W=2.0u L=0.5u

* --- Ch 50: b1=-0.0862, I_bias=-0.629uA ---
Ibr1_50 vdd nbr1_50 6.287543e-07
Xbr1_50 nbr1_50 nbr1_50 0 0 sky130_fd_pr__nfet_01v8 W=2.0u L=0.5u
Xbm1_50 nmac1_50 nbr1_50 0 0 sky130_fd_pr__nfet_01v8 W=2.0u L=0.5u
Xr1a_50 nmac1_50 nmac1_50 0 0 sky130_fd_pr__nfet_01v8 W=4.0u L=0.5u
Xr1b_50 nrelu1_50 nmac1_50 0 0 sky130_fd_pr__nfet_01v8 W=4.0u L=0.5u
Xopr_50 nrelu1_50 nrelu1_50 vdd vdd sky130_fd_pr__pfet_01v8 W=2.0u L=0.5u
Xopm_50 vout1_50 nrelu1_50 vdd vdd sky130_fd_pr__pfet_01v8 W=2.0u L=0.5u

* --- Ch 51: b1=-0.4081, I_bias=-2.978uA ---
Ibr1_51 vdd nbr1_51 2.977827e-06
Xbr1_51 nbr1_51 nbr1_51 0 0 sky130_fd_pr__nfet_01v8 W=2.0u L=0.5u
Xbm1_51 nmac1_51 nbr1_51 0 0 sky130_fd_pr__nfet_01v8 W=2.0u L=0.5u
Xr1a_51 nmac1_51 nmac1_51 0 0 sky130_fd_pr__nfet_01v8 W=4.0u L=0.5u
Xr1b_51 nrelu1_51 nmac1_51 0 0 sky130_fd_pr__nfet_01v8 W=4.0u L=0.5u
Xopr_51 nrelu1_51 nrelu1_51 vdd vdd sky130_fd_pr__pfet_01v8 W=2.0u L=0.5u
Xopm_51 vout1_51 nrelu1_51 vdd vdd sky130_fd_pr__pfet_01v8 W=2.0u L=0.5u

* --- Ch 52: b1=+0.0822, I_bias=+0.600uA ---
Ibr1_52 pbr1_52 0 5.996255e-07
Xbr1_52 pbr1_52 pbr1_52 vdd vdd sky130_fd_pr__pfet_01v8 W=2.0u L=0.5u
Xbm1_52 nmac1_52 pbr1_52 vdd vdd sky130_fd_pr__pfet_01v8 W=2.0u L=0.5u
Xr1a_52 nmac1_52 nmac1_52 0 0 sky130_fd_pr__nfet_01v8 W=4.0u L=0.5u
Xr1b_52 nrelu1_52 nmac1_52 0 0 sky130_fd_pr__nfet_01v8 W=4.0u L=0.5u
Xopr_52 nrelu1_52 nrelu1_52 vdd vdd sky130_fd_pr__pfet_01v8 W=2.0u L=0.5u
Xopm_52 vout1_52 nrelu1_52 vdd vdd sky130_fd_pr__pfet_01v8 W=2.0u L=0.5u

* --- Ch 53: b1=-0.1767, I_bias=-1.289uA ---
Ibr1_53 vdd nbr1_53 1.289007e-06
Xbr1_53 nbr1_53 nbr1_53 0 0 sky130_fd_pr__nfet_01v8 W=2.0u L=0.5u
Xbm1_53 nmac1_53 nbr1_53 0 0 sky130_fd_pr__nfet_01v8 W=2.0u L=0.5u
Xr1a_53 nmac1_53 nmac1_53 0 0 sky130_fd_pr__nfet_01v8 W=4.0u L=0.5u
Xr1b_53 nrelu1_53 nmac1_53 0 0 sky130_fd_pr__nfet_01v8 W=4.0u L=0.5u
Xopr_53 nrelu1_53 nrelu1_53 vdd vdd sky130_fd_pr__pfet_01v8 W=2.0u L=0.5u
Xopm_53 vout1_53 nrelu1_53 vdd vdd sky130_fd_pr__pfet_01v8 W=2.0u L=0.5u

* --- Ch 54: b1=+0.3008, I_bias=+2.195uA ---
Ibr1_54 pbr1_54 0 2.194992e-06
Xbr1_54 pbr1_54 pbr1_54 vdd vdd sky130_fd_pr__pfet_01v8 W=2.0u L=0.5u
Xbm1_54 nmac1_54 pbr1_54 vdd vdd sky130_fd_pr__pfet_01v8 W=2.0u L=0.5u
Xr1a_54 nmac1_54 nmac1_54 0 0 sky130_fd_pr__nfet_01v8 W=4.0u L=0.5u
Xr1b_54 nrelu1_54 nmac1_54 0 0 sky130_fd_pr__nfet_01v8 W=4.0u L=0.5u
Xopr_54 nrelu1_54 nrelu1_54 vdd vdd sky130_fd_pr__pfet_01v8 W=2.0u L=0.5u
Xopm_54 vout1_54 nrelu1_54 vdd vdd sky130_fd_pr__pfet_01v8 W=2.0u L=0.5u

* --- Ch 55: b1=-0.0986, I_bias=-0.719uA ---
Ibr1_55 vdd nbr1_55 7.191024e-07
Xbr1_55 nbr1_55 nbr1_55 0 0 sky130_fd_pr__nfet_01v8 W=2.0u L=0.5u
Xbm1_55 nmac1_55 nbr1_55 0 0 sky130_fd_pr__nfet_01v8 W=2.0u L=0.5u
Xr1a_55 nmac1_55 nmac1_55 0 0 sky130_fd_pr__nfet_01v8 W=4.0u L=0.5u
Xr1b_55 nrelu1_55 nmac1_55 0 0 sky130_fd_pr__nfet_01v8 W=4.0u L=0.5u
Xopr_55 nrelu1_55 nrelu1_55 vdd vdd sky130_fd_pr__pfet_01v8 W=2.0u L=0.5u
Xopm_55 vout1_55 nrelu1_55 vdd vdd sky130_fd_pr__pfet_01v8 W=2.0u L=0.5u

* --- Ch 56: b1=-0.4694, I_bias=-3.425uA ---
Ibr1_56 vdd nbr1_56 3.425092e-06
Xbr1_56 nbr1_56 nbr1_56 0 0 sky130_fd_pr__nfet_01v8 W=2.0u L=0.5u
Xbm1_56 nmac1_56 nbr1_56 0 0 sky130_fd_pr__nfet_01v8 W=2.0u L=0.5u
Xr1a_56 nmac1_56 nmac1_56 0 0 sky130_fd_pr__nfet_01v8 W=4.0u L=0.5u
Xr1b_56 nrelu1_56 nmac1_56 0 0 sky130_fd_pr__nfet_01v8 W=4.0u L=0.5u
Xopr_56 nrelu1_56 nrelu1_56 vdd vdd sky130_fd_pr__pfet_01v8 W=2.0u L=0.5u
Xopm_56 vout1_56 nrelu1_56 vdd vdd sky130_fd_pr__pfet_01v8 W=2.0u L=0.5u

* --- Ch 57: b1=+0.4170, I_bias=+3.043uA ---
Ibr1_57 pbr1_57 0 3.042702e-06
Xbr1_57 pbr1_57 pbr1_57 vdd vdd sky130_fd_pr__pfet_01v8 W=2.0u L=0.5u
Xbm1_57 nmac1_57 pbr1_57 vdd vdd sky130_fd_pr__pfet_01v8 W=2.0u L=0.5u
Xr1a_57 nmac1_57 nmac1_57 0 0 sky130_fd_pr__nfet_01v8 W=4.0u L=0.5u
Xr1b_57 nrelu1_57 nmac1_57 0 0 sky130_fd_pr__nfet_01v8 W=4.0u L=0.5u
Xopr_57 nrelu1_57 nrelu1_57 vdd vdd sky130_fd_pr__pfet_01v8 W=2.0u L=0.5u
Xopm_57 vout1_57 nrelu1_57 vdd vdd sky130_fd_pr__pfet_01v8 W=2.0u L=0.5u

* --- Ch 58: b1=+0.7332, I_bias=+5.350uA ---
Ibr1_58 pbr1_58 0 5.349800e-06
Xbr1_58 pbr1_58 pbr1_58 vdd vdd sky130_fd_pr__pfet_01v8 W=2.0u L=0.5u
Xbm1_58 nmac1_58 pbr1_58 vdd vdd sky130_fd_pr__pfet_01v8 W=2.0u L=0.5u
Xr1a_58 nmac1_58 nmac1_58 0 0 sky130_fd_pr__nfet_01v8 W=4.0u L=0.5u
Xr1b_58 nrelu1_58 nmac1_58 0 0 sky130_fd_pr__nfet_01v8 W=4.0u L=0.5u
Xopr_58 nrelu1_58 nrelu1_58 vdd vdd sky130_fd_pr__pfet_01v8 W=2.0u L=0.5u
Xopm_58 vout1_58 nrelu1_58 vdd vdd sky130_fd_pr__pfet_01v8 W=2.0u L=0.5u

* --- Ch 59: b1=+0.4019, I_bias=+2.932uA ---
Ibr1_59 pbr1_59 0 2.932241e-06
Xbr1_59 pbr1_59 pbr1_59 vdd vdd sky130_fd_pr__pfet_01v8 W=2.0u L=0.5u
Xbm1_59 nmac1_59 pbr1_59 vdd vdd sky130_fd_pr__pfet_01v8 W=2.0u L=0.5u
Xr1a_59 nmac1_59 nmac1_59 0 0 sky130_fd_pr__nfet_01v8 W=4.0u L=0.5u
Xr1b_59 nrelu1_59 nmac1_59 0 0 sky130_fd_pr__nfet_01v8 W=4.0u L=0.5u
Xopr_59 nrelu1_59 nrelu1_59 vdd vdd sky130_fd_pr__pfet_01v8 W=2.0u L=0.5u
Xopm_59 vout1_59 nrelu1_59 vdd vdd sky130_fd_pr__pfet_01v8 W=2.0u L=0.5u

* --- Ch 60: b1=-0.1938, I_bias=-1.414uA ---
Ibr1_60 vdd nbr1_60 1.414283e-06
Xbr1_60 nbr1_60 nbr1_60 0 0 sky130_fd_pr__nfet_01v8 W=2.0u L=0.5u
Xbm1_60 nmac1_60 nbr1_60 0 0 sky130_fd_pr__nfet_01v8 W=2.0u L=0.5u
Xr1a_60 nmac1_60 nmac1_60 0 0 sky130_fd_pr__nfet_01v8 W=4.0u L=0.5u
Xr1b_60 nrelu1_60 nmac1_60 0 0 sky130_fd_pr__nfet_01v8 W=4.0u L=0.5u
Xopr_60 nrelu1_60 nrelu1_60 vdd vdd sky130_fd_pr__pfet_01v8 W=2.0u L=0.5u
Xopm_60 vout1_60 nrelu1_60 vdd vdd sky130_fd_pr__pfet_01v8 W=2.0u L=0.5u

* --- Ch 61: b1=-0.1137, I_bias=-0.829uA ---
Ibr1_61 vdd nbr1_61 8.293915e-07
Xbr1_61 nbr1_61 nbr1_61 0 0 sky130_fd_pr__nfet_01v8 W=2.0u L=0.5u
Xbm1_61 nmac1_61 nbr1_61 0 0 sky130_fd_pr__nfet_01v8 W=2.0u L=0.5u
Xr1a_61 nmac1_61 nmac1_61 0 0 sky130_fd_pr__nfet_01v8 W=4.0u L=0.5u
Xr1b_61 nrelu1_61 nmac1_61 0 0 sky130_fd_pr__nfet_01v8 W=4.0u L=0.5u
Xopr_61 nrelu1_61 nrelu1_61 vdd vdd sky130_fd_pr__pfet_01v8 W=2.0u L=0.5u
Xopm_61 vout1_61 nrelu1_61 vdd vdd sky130_fd_pr__pfet_01v8 W=2.0u L=0.5u

* --- Ch 62: b1=+0.1141, I_bias=+0.832uA ---
Ibr1_62 pbr1_62 0 8.323904e-07
Xbr1_62 pbr1_62 pbr1_62 vdd vdd sky130_fd_pr__pfet_01v8 W=2.0u L=0.5u
Xbm1_62 nmac1_62 pbr1_62 vdd vdd sky130_fd_pr__pfet_01v8 W=2.0u L=0.5u
Xr1a_62 nmac1_62 nmac1_62 0 0 sky130_fd_pr__nfet_01v8 W=4.0u L=0.5u
Xr1b_62 nrelu1_62 nmac1_62 0 0 sky130_fd_pr__nfet_01v8 W=4.0u L=0.5u
Xopr_62 nrelu1_62 nrelu1_62 vdd vdd sky130_fd_pr__pfet_01v8 W=2.0u L=0.5u
Xopm_62 vout1_62 nrelu1_62 vdd vdd sky130_fd_pr__pfet_01v8 W=2.0u L=0.5u

* --- Ch 63: b1=+0.4799, I_bias=+3.502uA ---
Ibr1_63 pbr1_63 0 3.501654e-06
Xbr1_63 pbr1_63 pbr1_63 vdd vdd sky130_fd_pr__pfet_01v8 W=2.0u L=0.5u
Xbm1_63 nmac1_63 pbr1_63 vdd vdd sky130_fd_pr__pfet_01v8 W=2.0u L=0.5u
Xr1a_63 nmac1_63 nmac1_63 0 0 sky130_fd_pr__nfet_01v8 W=4.0u L=0.5u
Xr1b_63 nrelu1_63 nmac1_63 0 0 sky130_fd_pr__nfet_01v8 W=4.0u L=0.5u
Xopr_63 nrelu1_63 nrelu1_63 vdd vdd sky130_fd_pr__pfet_01v8 W=2.0u L=0.5u
Xopm_63 vout1_63 nrelu1_63 vdd vdd sky130_fd_pr__pfet_01v8 W=2.0u L=0.5u

* ===== LAYER 2: 64x5 DIFFERENTIAL 1T1R ReRAM CROSSBAR =====
Vgate_l2 gate_l2 0 1.8

* --- Positive conductance array ---
XTpl2_0_0 vout1_0 gate_l2 mpl2_0_0 0 sky130_fd_pr__nfet_01v8 W=1.0u L=0.15u
Rrpl2_0_0 mpl2_0_0 cpl2_0 198919.4688
XTpl2_0_1 vout1_0 gate_l2 mpl2_0_1 0 sky130_fd_pr__nfet_01v8 W=1.0u L=0.15u
Rrpl2_0_1 mpl2_0_1 cpl2_1 3378378.2500
XTpl2_0_2 vout1_0 gate_l2 mpl2_0_2 0 sky130_fd_pr__nfet_01v8 W=1.0u L=0.15u
Rrpl2_0_2 mpl2_0_2 cpl2_2 3378378.2500
XTpl2_0_3 vout1_0 gate_l2 mpl2_0_3 0 sky130_fd_pr__nfet_01v8 W=1.0u L=0.15u
Rrpl2_0_3 mpl2_0_3 cpl2_3 3378378.2500
XTpl2_0_4 vout1_0 gate_l2 mpl2_0_4 0 sky130_fd_pr__nfet_01v8 W=1.0u L=0.15u
Rrpl2_0_4 mpl2_0_4 cpl2_4 3378378.2500
XTpl2_1_0 vout1_1 gate_l2 mpl2_1_0 0 sky130_fd_pr__nfet_01v8 W=1.0u L=0.15u
Rrpl2_1_0 mpl2_1_0 cpl2_0 3378378.2500
XTpl2_1_1 vout1_1 gate_l2 mpl2_1_1 0 sky130_fd_pr__nfet_01v8 W=1.0u L=0.15u
Rrpl2_1_1 mpl2_1_1 cpl2_1 3378378.2500
XTpl2_1_2 vout1_1 gate_l2 mpl2_1_2 0 sky130_fd_pr__nfet_01v8 W=1.0u L=0.15u
Rrpl2_1_2 mpl2_1_2 cpl2_2 40346.9062
XTpl2_1_3 vout1_1 gate_l2 mpl2_1_3 0 sky130_fd_pr__nfet_01v8 W=1.0u L=0.15u
Rrpl2_1_3 mpl2_1_3 cpl2_3 1203866.6250
XTpl2_1_4 vout1_1 gate_l2 mpl2_1_4 0 sky130_fd_pr__nfet_01v8 W=1.0u L=0.15u
Rrpl2_1_4 mpl2_1_4 cpl2_4 147156.1562
XTpl2_2_0 vout1_2 gate_l2 mpl2_2_0 0 sky130_fd_pr__nfet_01v8 W=1.0u L=0.15u
Rrpl2_2_0 mpl2_2_0 cpl2_0 76554.6406
XTpl2_2_1 vout1_2 gate_l2 mpl2_2_1 0 sky130_fd_pr__nfet_01v8 W=1.0u L=0.15u
Rrpl2_2_1 mpl2_2_1 cpl2_1 49641.3203
XTpl2_2_2 vout1_2 gate_l2 mpl2_2_2 0 sky130_fd_pr__nfet_01v8 W=1.0u L=0.15u
Rrpl2_2_2 mpl2_2_2 cpl2_2 3378378.2500
XTpl2_2_3 vout1_2 gate_l2 mpl2_2_3 0 sky130_fd_pr__nfet_01v8 W=1.0u L=0.15u
Rrpl2_2_3 mpl2_2_3 cpl2_3 3378378.2500
XTpl2_2_4 vout1_2 gate_l2 mpl2_2_4 0 sky130_fd_pr__nfet_01v8 W=1.0u L=0.15u
Rrpl2_2_4 mpl2_2_4 cpl2_4 3378378.2500
XTpl2_3_0 vout1_3 gate_l2 mpl2_3_0 0 sky130_fd_pr__nfet_01v8 W=1.0u L=0.15u
Rrpl2_3_0 mpl2_3_0 cpl2_0 3378378.2500
XTpl2_3_1 vout1_3 gate_l2 mpl2_3_1 0 sky130_fd_pr__nfet_01v8 W=1.0u L=0.15u
Rrpl2_3_1 mpl2_3_1 cpl2_1 3378378.2500
XTpl2_3_2 vout1_3 gate_l2 mpl2_3_2 0 sky130_fd_pr__nfet_01v8 W=1.0u L=0.15u
Rrpl2_3_2 mpl2_3_2 cpl2_2 58669.2305
XTpl2_3_3 vout1_3 gate_l2 mpl2_3_3 0 sky130_fd_pr__nfet_01v8 W=1.0u L=0.15u
Rrpl2_3_3 mpl2_3_3 cpl2_3 73311.7500
XTpl2_3_4 vout1_3 gate_l2 mpl2_3_4 0 sky130_fd_pr__nfet_01v8 W=1.0u L=0.15u
Rrpl2_3_4 mpl2_3_4 cpl2_4 3378378.2500
XTpl2_4_0 vout1_4 gate_l2 mpl2_4_0 0 sky130_fd_pr__nfet_01v8 W=1.0u L=0.15u
Rrpl2_4_0 mpl2_4_0 cpl2_0 3378378.2500
XTpl2_4_1 vout1_4 gate_l2 mpl2_4_1 0 sky130_fd_pr__nfet_01v8 W=1.0u L=0.15u
Rrpl2_4_1 mpl2_4_1 cpl2_1 3378378.2500
XTpl2_4_2 vout1_4 gate_l2 mpl2_4_2 0 sky130_fd_pr__nfet_01v8 W=1.0u L=0.15u
Rrpl2_4_2 mpl2_4_2 cpl2_2 121682.4609
XTpl2_4_3 vout1_4 gate_l2 mpl2_4_3 0 sky130_fd_pr__nfet_01v8 W=1.0u L=0.15u
Rrpl2_4_3 mpl2_4_3 cpl2_3 43040.7656
XTpl2_4_4 vout1_4 gate_l2 mpl2_4_4 0 sky130_fd_pr__nfet_01v8 W=1.0u L=0.15u
Rrpl2_4_4 mpl2_4_4 cpl2_4 115455.4922
XTpl2_5_0 vout1_5 gate_l2 mpl2_5_0 0 sky130_fd_pr__nfet_01v8 W=1.0u L=0.15u
Rrpl2_5_0 mpl2_5_0 cpl2_0 238425.7031
XTpl2_5_1 vout1_5 gate_l2 mpl2_5_1 0 sky130_fd_pr__nfet_01v8 W=1.0u L=0.15u
Rrpl2_5_1 mpl2_5_1 cpl2_1 110869.8750
XTpl2_5_2 vout1_5 gate_l2 mpl2_5_2 0 sky130_fd_pr__nfet_01v8 W=1.0u L=0.15u
Rrpl2_5_2 mpl2_5_2 cpl2_2 3378378.2500
XTpl2_5_3 vout1_5 gate_l2 mpl2_5_3 0 sky130_fd_pr__nfet_01v8 W=1.0u L=0.15u
Rrpl2_5_3 mpl2_5_3 cpl2_3 3378378.2500
XTpl2_5_4 vout1_5 gate_l2 mpl2_5_4 0 sky130_fd_pr__nfet_01v8 W=1.0u L=0.15u
Rrpl2_5_4 mpl2_5_4 cpl2_4 3378378.2500
XTpl2_6_0 vout1_6 gate_l2 mpl2_6_0 0 sky130_fd_pr__nfet_01v8 W=1.0u L=0.15u
Rrpl2_6_0 mpl2_6_0 cpl2_0 34435.1758
XTpl2_6_1 vout1_6 gate_l2 mpl2_6_1 0 sky130_fd_pr__nfet_01v8 W=1.0u L=0.15u
Rrpl2_6_1 mpl2_6_1 cpl2_1 3378378.2500
XTpl2_6_2 vout1_6 gate_l2 mpl2_6_2 0 sky130_fd_pr__nfet_01v8 W=1.0u L=0.15u
Rrpl2_6_2 mpl2_6_2 cpl2_2 3378378.2500
XTpl2_6_3 vout1_6 gate_l2 mpl2_6_3 0 sky130_fd_pr__nfet_01v8 W=1.0u L=0.15u
Rrpl2_6_3 mpl2_6_3 cpl2_3 3378378.2500
XTpl2_6_4 vout1_6 gate_l2 mpl2_6_4 0 sky130_fd_pr__nfet_01v8 W=1.0u L=0.15u
Rrpl2_6_4 mpl2_6_4 cpl2_4 3378378.2500
XTpl2_7_0 vout1_7 gate_l2 mpl2_7_0 0 sky130_fd_pr__nfet_01v8 W=1.0u L=0.15u
Rrpl2_7_0 mpl2_7_0 cpl2_0 38327.8789
XTpl2_7_1 vout1_7 gate_l2 mpl2_7_1 0 sky130_fd_pr__nfet_01v8 W=1.0u L=0.15u
Rrpl2_7_1 mpl2_7_1 cpl2_1 81931.0625
XTpl2_7_2 vout1_7 gate_l2 mpl2_7_2 0 sky130_fd_pr__nfet_01v8 W=1.0u L=0.15u
Rrpl2_7_2 mpl2_7_2 cpl2_2 3378378.2500
XTpl2_7_3 vout1_7 gate_l2 mpl2_7_3 0 sky130_fd_pr__nfet_01v8 W=1.0u L=0.15u
Rrpl2_7_3 mpl2_7_3 cpl2_3 3378378.2500
XTpl2_7_4 vout1_7 gate_l2 mpl2_7_4 0 sky130_fd_pr__nfet_01v8 W=1.0u L=0.15u
Rrpl2_7_4 mpl2_7_4 cpl2_4 3378378.2500
XTpl2_8_0 vout1_8 gate_l2 mpl2_8_0 0 sky130_fd_pr__nfet_01v8 W=1.0u L=0.15u
Rrpl2_8_0 mpl2_8_0 cpl2_0 205973.4062
XTpl2_8_1 vout1_8 gate_l2 mpl2_8_1 0 sky130_fd_pr__nfet_01v8 W=1.0u L=0.15u
Rrpl2_8_1 mpl2_8_1 cpl2_1 3378378.2500
XTpl2_8_2 vout1_8 gate_l2 mpl2_8_2 0 sky130_fd_pr__nfet_01v8 W=1.0u L=0.15u
Rrpl2_8_2 mpl2_8_2 cpl2_2 59048.3555
XTpl2_8_3 vout1_8 gate_l2 mpl2_8_3 0 sky130_fd_pr__nfet_01v8 W=1.0u L=0.15u
Rrpl2_8_3 mpl2_8_3 cpl2_3 3378378.2500
XTpl2_8_4 vout1_8 gate_l2 mpl2_8_4 0 sky130_fd_pr__nfet_01v8 W=1.0u L=0.15u
Rrpl2_8_4 mpl2_8_4 cpl2_4 315083.9688
XTpl2_9_0 vout1_9 gate_l2 mpl2_9_0 0 sky130_fd_pr__nfet_01v8 W=1.0u L=0.15u
Rrpl2_9_0 mpl2_9_0 cpl2_0 155866.6250
XTpl2_9_1 vout1_9 gate_l2 mpl2_9_1 0 sky130_fd_pr__nfet_01v8 W=1.0u L=0.15u
Rrpl2_9_1 mpl2_9_1 cpl2_1 47006.8867
XTpl2_9_2 vout1_9 gate_l2 mpl2_9_2 0 sky130_fd_pr__nfet_01v8 W=1.0u L=0.15u
Rrpl2_9_2 mpl2_9_2 cpl2_2 3378378.2500
XTpl2_9_3 vout1_9 gate_l2 mpl2_9_3 0 sky130_fd_pr__nfet_01v8 W=1.0u L=0.15u
Rrpl2_9_3 mpl2_9_3 cpl2_3 133660.0156
XTpl2_9_4 vout1_9 gate_l2 mpl2_9_4 0 sky130_fd_pr__nfet_01v8 W=1.0u L=0.15u
Rrpl2_9_4 mpl2_9_4 cpl2_4 3378378.2500
XTpl2_10_0 vout1_10 gate_l2 mpl2_10_0 0 sky130_fd_pr__nfet_01v8 W=1.0u L=0.15u
Rrpl2_10_0 mpl2_10_0 cpl2_0 3378378.2500
XTpl2_10_1 vout1_10 gate_l2 mpl2_10_1 0 sky130_fd_pr__nfet_01v8 W=1.0u L=0.15u
Rrpl2_10_1 mpl2_10_1 cpl2_1 3378378.2500
XTpl2_10_2 vout1_10 gate_l2 mpl2_10_2 0 sky130_fd_pr__nfet_01v8 W=1.0u L=0.15u
Rrpl2_10_2 mpl2_10_2 cpl2_2 57477.4023
XTpl2_10_3 vout1_10 gate_l2 mpl2_10_3 0 sky130_fd_pr__nfet_01v8 W=1.0u L=0.15u
Rrpl2_10_3 mpl2_10_3 cpl2_3 72989.1641
XTpl2_10_4 vout1_10 gate_l2 mpl2_10_4 0 sky130_fd_pr__nfet_01v8 W=1.0u L=0.15u
Rrpl2_10_4 mpl2_10_4 cpl2_4 222609.5156
XTpl2_11_0 vout1_11 gate_l2 mpl2_11_0 0 sky130_fd_pr__nfet_01v8 W=1.0u L=0.15u
Rrpl2_11_0 mpl2_11_0 cpl2_0 87986.4609
XTpl2_11_1 vout1_11 gate_l2 mpl2_11_1 0 sky130_fd_pr__nfet_01v8 W=1.0u L=0.15u
Rrpl2_11_1 mpl2_11_1 cpl2_1 3378378.2500
XTpl2_11_2 vout1_11 gate_l2 mpl2_11_2 0 sky130_fd_pr__nfet_01v8 W=1.0u L=0.15u
Rrpl2_11_2 mpl2_11_2 cpl2_2 3378378.2500
XTpl2_11_3 vout1_11 gate_l2 mpl2_11_3 0 sky130_fd_pr__nfet_01v8 W=1.0u L=0.15u
Rrpl2_11_3 mpl2_11_3 cpl2_3 3378378.2500
XTpl2_11_4 vout1_11 gate_l2 mpl2_11_4 0 sky130_fd_pr__nfet_01v8 W=1.0u L=0.15u
Rrpl2_11_4 mpl2_11_4 cpl2_4 915924.0000
XTpl2_12_0 vout1_12 gate_l2 mpl2_12_0 0 sky130_fd_pr__nfet_01v8 W=1.0u L=0.15u
Rrpl2_12_0 mpl2_12_0 cpl2_0 3378378.2500
XTpl2_12_1 vout1_12 gate_l2 mpl2_12_1 0 sky130_fd_pr__nfet_01v8 W=1.0u L=0.15u
Rrpl2_12_1 mpl2_12_1 cpl2_1 80761.8906
XTpl2_12_2 vout1_12 gate_l2 mpl2_12_2 0 sky130_fd_pr__nfet_01v8 W=1.0u L=0.15u
Rrpl2_12_2 mpl2_12_2 cpl2_2 40998.4883
XTpl2_12_3 vout1_12 gate_l2 mpl2_12_3 0 sky130_fd_pr__nfet_01v8 W=1.0u L=0.15u
Rrpl2_12_3 mpl2_12_3 cpl2_3 3378378.2500
XTpl2_12_4 vout1_12 gate_l2 mpl2_12_4 0 sky130_fd_pr__nfet_01v8 W=1.0u L=0.15u
Rrpl2_12_4 mpl2_12_4 cpl2_4 3378378.2500
XTpl2_13_0 vout1_13 gate_l2 mpl2_13_0 0 sky130_fd_pr__nfet_01v8 W=1.0u L=0.15u
Rrpl2_13_0 mpl2_13_0 cpl2_0 3378378.2500
XTpl2_13_1 vout1_13 gate_l2 mpl2_13_1 0 sky130_fd_pr__nfet_01v8 W=1.0u L=0.15u
Rrpl2_13_1 mpl2_13_1 cpl2_1 3378378.2500
XTpl2_13_2 vout1_13 gate_l2 mpl2_13_2 0 sky130_fd_pr__nfet_01v8 W=1.0u L=0.15u
Rrpl2_13_2 mpl2_13_2 cpl2_2 3378378.2500
XTpl2_13_3 vout1_13 gate_l2 mpl2_13_3 0 sky130_fd_pr__nfet_01v8 W=1.0u L=0.15u
Rrpl2_13_3 mpl2_13_3 cpl2_3 111115.7734
XTpl2_13_4 vout1_13 gate_l2 mpl2_13_4 0 sky130_fd_pr__nfet_01v8 W=1.0u L=0.15u
Rrpl2_13_4 mpl2_13_4 cpl2_4 148147.2344
XTpl2_14_0 vout1_14 gate_l2 mpl2_14_0 0 sky130_fd_pr__nfet_01v8 W=1.0u L=0.15u
Rrpl2_14_0 mpl2_14_0 cpl2_0 213557.2031
XTpl2_14_1 vout1_14 gate_l2 mpl2_14_1 0 sky130_fd_pr__nfet_01v8 W=1.0u L=0.15u
Rrpl2_14_1 mpl2_14_1 cpl2_1 3378378.2500
XTpl2_14_2 vout1_14 gate_l2 mpl2_14_2 0 sky130_fd_pr__nfet_01v8 W=1.0u L=0.15u
Rrpl2_14_2 mpl2_14_2 cpl2_2 3378378.2500
XTpl2_14_3 vout1_14 gate_l2 mpl2_14_3 0 sky130_fd_pr__nfet_01v8 W=1.0u L=0.15u
Rrpl2_14_3 mpl2_14_3 cpl2_3 127185.5000
XTpl2_14_4 vout1_14 gate_l2 mpl2_14_4 0 sky130_fd_pr__nfet_01v8 W=1.0u L=0.15u
Rrpl2_14_4 mpl2_14_4 cpl2_4 2441416.0000
XTpl2_15_0 vout1_15 gate_l2 mpl2_15_0 0 sky130_fd_pr__nfet_01v8 W=1.0u L=0.15u
Rrpl2_15_0 mpl2_15_0 cpl2_0 101921.3281
XTpl2_15_1 vout1_15 gate_l2 mpl2_15_1 0 sky130_fd_pr__nfet_01v8 W=1.0u L=0.15u
Rrpl2_15_1 mpl2_15_1 cpl2_1 3378378.2500
XTpl2_15_2 vout1_15 gate_l2 mpl2_15_2 0 sky130_fd_pr__nfet_01v8 W=1.0u L=0.15u
Rrpl2_15_2 mpl2_15_2 cpl2_2 3378378.2500
XTpl2_15_3 vout1_15 gate_l2 mpl2_15_3 0 sky130_fd_pr__nfet_01v8 W=1.0u L=0.15u
Rrpl2_15_3 mpl2_15_3 cpl2_3 127805.9141
XTpl2_15_4 vout1_15 gate_l2 mpl2_15_4 0 sky130_fd_pr__nfet_01v8 W=1.0u L=0.15u
Rrpl2_15_4 mpl2_15_4 cpl2_4 215352.0625
XTpl2_16_0 vout1_16 gate_l2 mpl2_16_0 0 sky130_fd_pr__nfet_01v8 W=1.0u L=0.15u
Rrpl2_16_0 mpl2_16_0 cpl2_0 3378378.2500
XTpl2_16_1 vout1_16 gate_l2 mpl2_16_1 0 sky130_fd_pr__nfet_01v8 W=1.0u L=0.15u
Rrpl2_16_1 mpl2_16_1 cpl2_1 48896.1094
XTpl2_16_2 vout1_16 gate_l2 mpl2_16_2 0 sky130_fd_pr__nfet_01v8 W=1.0u L=0.15u
Rrpl2_16_2 mpl2_16_2 cpl2_2 56720.3359
XTpl2_16_3 vout1_16 gate_l2 mpl2_16_3 0 sky130_fd_pr__nfet_01v8 W=1.0u L=0.15u
Rrpl2_16_3 mpl2_16_3 cpl2_3 1713835.3750
XTpl2_16_4 vout1_16 gate_l2 mpl2_16_4 0 sky130_fd_pr__nfet_01v8 W=1.0u L=0.15u
Rrpl2_16_4 mpl2_16_4 cpl2_4 3378378.2500
XTpl2_17_0 vout1_17 gate_l2 mpl2_17_0 0 sky130_fd_pr__nfet_01v8 W=1.0u L=0.15u
Rrpl2_17_0 mpl2_17_0 cpl2_0 3378378.2500
XTpl2_17_1 vout1_17 gate_l2 mpl2_17_1 0 sky130_fd_pr__nfet_01v8 W=1.0u L=0.15u
Rrpl2_17_1 mpl2_17_1 cpl2_1 51938.3359
XTpl2_17_2 vout1_17 gate_l2 mpl2_17_2 0 sky130_fd_pr__nfet_01v8 W=1.0u L=0.15u
Rrpl2_17_2 mpl2_17_2 cpl2_2 3378378.2500
XTpl2_17_3 vout1_17 gate_l2 mpl2_17_3 0 sky130_fd_pr__nfet_01v8 W=1.0u L=0.15u
Rrpl2_17_3 mpl2_17_3 cpl2_3 47993.1758
XTpl2_17_4 vout1_17 gate_l2 mpl2_17_4 0 sky130_fd_pr__nfet_01v8 W=1.0u L=0.15u
Rrpl2_17_4 mpl2_17_4 cpl2_4 3378378.2500
XTpl2_18_0 vout1_18 gate_l2 mpl2_18_0 0 sky130_fd_pr__nfet_01v8 W=1.0u L=0.15u
Rrpl2_18_0 mpl2_18_0 cpl2_0 3378378.2500
XTpl2_18_1 vout1_18 gate_l2 mpl2_18_1 0 sky130_fd_pr__nfet_01v8 W=1.0u L=0.15u
Rrpl2_18_1 mpl2_18_1 cpl2_1 3378378.2500
XTpl2_18_2 vout1_18 gate_l2 mpl2_18_2 0 sky130_fd_pr__nfet_01v8 W=1.0u L=0.15u
Rrpl2_18_2 mpl2_18_2 cpl2_2 53624.3594
XTpl2_18_3 vout1_18 gate_l2 mpl2_18_3 0 sky130_fd_pr__nfet_01v8 W=1.0u L=0.15u
Rrpl2_18_3 mpl2_18_3 cpl2_3 3378378.2500
XTpl2_18_4 vout1_18 gate_l2 mpl2_18_4 0 sky130_fd_pr__nfet_01v8 W=1.0u L=0.15u
Rrpl2_18_4 mpl2_18_4 cpl2_4 295543.3125
XTpl2_19_0 vout1_19 gate_l2 mpl2_19_0 0 sky130_fd_pr__nfet_01v8 W=1.0u L=0.15u
Rrpl2_19_0 mpl2_19_0 cpl2_0 65949.6250
XTpl2_19_1 vout1_19 gate_l2 mpl2_19_1 0 sky130_fd_pr__nfet_01v8 W=1.0u L=0.15u
Rrpl2_19_1 mpl2_19_1 cpl2_1 327217.0000
XTpl2_19_2 vout1_19 gate_l2 mpl2_19_2 0 sky130_fd_pr__nfet_01v8 W=1.0u L=0.15u
Rrpl2_19_2 mpl2_19_2 cpl2_2 3378378.2500
XTpl2_19_3 vout1_19 gate_l2 mpl2_19_3 0 sky130_fd_pr__nfet_01v8 W=1.0u L=0.15u
Rrpl2_19_3 mpl2_19_3 cpl2_3 64547.8594
XTpl2_19_4 vout1_19 gate_l2 mpl2_19_4 0 sky130_fd_pr__nfet_01v8 W=1.0u L=0.15u
Rrpl2_19_4 mpl2_19_4 cpl2_4 3378378.2500
XTpl2_20_0 vout1_20 gate_l2 mpl2_20_0 0 sky130_fd_pr__nfet_01v8 W=1.0u L=0.15u
Rrpl2_20_0 mpl2_20_0 cpl2_0 117950.0859
XTpl2_20_1 vout1_20 gate_l2 mpl2_20_1 0 sky130_fd_pr__nfet_01v8 W=1.0u L=0.15u
Rrpl2_20_1 mpl2_20_1 cpl2_1 3378378.2500
XTpl2_20_2 vout1_20 gate_l2 mpl2_20_2 0 sky130_fd_pr__nfet_01v8 W=1.0u L=0.15u
Rrpl2_20_2 mpl2_20_2 cpl2_2 140680.5156
XTpl2_20_3 vout1_20 gate_l2 mpl2_20_3 0 sky130_fd_pr__nfet_01v8 W=1.0u L=0.15u
Rrpl2_20_3 mpl2_20_3 cpl2_3 3378378.2500
XTpl2_20_4 vout1_20 gate_l2 mpl2_20_4 0 sky130_fd_pr__nfet_01v8 W=1.0u L=0.15u
Rrpl2_20_4 mpl2_20_4 cpl2_4 3378378.2500
XTpl2_21_0 vout1_21 gate_l2 mpl2_21_0 0 sky130_fd_pr__nfet_01v8 W=1.0u L=0.15u
Rrpl2_21_0 mpl2_21_0 cpl2_0 86574.0469
XTpl2_21_1 vout1_21 gate_l2 mpl2_21_1 0 sky130_fd_pr__nfet_01v8 W=1.0u L=0.15u
Rrpl2_21_1 mpl2_21_1 cpl2_1 3378378.2500
XTpl2_21_2 vout1_21 gate_l2 mpl2_21_2 0 sky130_fd_pr__nfet_01v8 W=1.0u L=0.15u
Rrpl2_21_2 mpl2_21_2 cpl2_2 3378378.2500
XTpl2_21_3 vout1_21 gate_l2 mpl2_21_3 0 sky130_fd_pr__nfet_01v8 W=1.0u L=0.15u
Rrpl2_21_3 mpl2_21_3 cpl2_3 101943.0469
XTpl2_21_4 vout1_21 gate_l2 mpl2_21_4 0 sky130_fd_pr__nfet_01v8 W=1.0u L=0.15u
Rrpl2_21_4 mpl2_21_4 cpl2_4 3378378.2500
XTpl2_22_0 vout1_22 gate_l2 mpl2_22_0 0 sky130_fd_pr__nfet_01v8 W=1.0u L=0.15u
Rrpl2_22_0 mpl2_22_0 cpl2_0 294861.5312
XTpl2_22_1 vout1_22 gate_l2 mpl2_22_1 0 sky130_fd_pr__nfet_01v8 W=1.0u L=0.15u
Rrpl2_22_1 mpl2_22_1 cpl2_1 37231.3984
XTpl2_22_2 vout1_22 gate_l2 mpl2_22_2 0 sky130_fd_pr__nfet_01v8 W=1.0u L=0.15u
Rrpl2_22_2 mpl2_22_2 cpl2_2 3378378.2500
XTpl2_22_3 vout1_22 gate_l2 mpl2_22_3 0 sky130_fd_pr__nfet_01v8 W=1.0u L=0.15u
Rrpl2_22_3 mpl2_22_3 cpl2_3 3378378.2500
XTpl2_22_4 vout1_22 gate_l2 mpl2_22_4 0 sky130_fd_pr__nfet_01v8 W=1.0u L=0.15u
Rrpl2_22_4 mpl2_22_4 cpl2_4 3378378.2500
XTpl2_23_0 vout1_23 gate_l2 mpl2_23_0 0 sky130_fd_pr__nfet_01v8 W=1.0u L=0.15u
Rrpl2_23_0 mpl2_23_0 cpl2_0 149764.7656
XTpl2_23_1 vout1_23 gate_l2 mpl2_23_1 0 sky130_fd_pr__nfet_01v8 W=1.0u L=0.15u
Rrpl2_23_1 mpl2_23_1 cpl2_1 30823.4121
XTpl2_23_2 vout1_23 gate_l2 mpl2_23_2 0 sky130_fd_pr__nfet_01v8 W=1.0u L=0.15u
Rrpl2_23_2 mpl2_23_2 cpl2_2 3378378.2500
XTpl2_23_3 vout1_23 gate_l2 mpl2_23_3 0 sky130_fd_pr__nfet_01v8 W=1.0u L=0.15u
Rrpl2_23_3 mpl2_23_3 cpl2_3 56875.8320
XTpl2_23_4 vout1_23 gate_l2 mpl2_23_4 0 sky130_fd_pr__nfet_01v8 W=1.0u L=0.15u
Rrpl2_23_4 mpl2_23_4 cpl2_4 200820.5312
XTpl2_24_0 vout1_24 gate_l2 mpl2_24_0 0 sky130_fd_pr__nfet_01v8 W=1.0u L=0.15u
Rrpl2_24_0 mpl2_24_0 cpl2_0 3378378.2500
XTpl2_24_1 vout1_24 gate_l2 mpl2_24_1 0 sky130_fd_pr__nfet_01v8 W=1.0u L=0.15u
Rrpl2_24_1 mpl2_24_1 cpl2_1 3378378.2500
XTpl2_24_2 vout1_24 gate_l2 mpl2_24_2 0 sky130_fd_pr__nfet_01v8 W=1.0u L=0.15u
Rrpl2_24_2 mpl2_24_2 cpl2_2 77406.9219
XTpl2_24_3 vout1_24 gate_l2 mpl2_24_3 0 sky130_fd_pr__nfet_01v8 W=1.0u L=0.15u
Rrpl2_24_3 mpl2_24_3 cpl2_3 43283.2188
XTpl2_24_4 vout1_24 gate_l2 mpl2_24_4 0 sky130_fd_pr__nfet_01v8 W=1.0u L=0.15u
Rrpl2_24_4 mpl2_24_4 cpl2_4 71927.1094
XTpl2_25_0 vout1_25 gate_l2 mpl2_25_0 0 sky130_fd_pr__nfet_01v8 W=1.0u L=0.15u
Rrpl2_25_0 mpl2_25_0 cpl2_0 83908.4844
XTpl2_25_1 vout1_25 gate_l2 mpl2_25_1 0 sky130_fd_pr__nfet_01v8 W=1.0u L=0.15u
Rrpl2_25_1 mpl2_25_1 cpl2_1 3378378.2500
XTpl2_25_2 vout1_25 gate_l2 mpl2_25_2 0 sky130_fd_pr__nfet_01v8 W=1.0u L=0.15u
Rrpl2_25_2 mpl2_25_2 cpl2_2 3378378.2500
XTpl2_25_3 vout1_25 gate_l2 mpl2_25_3 0 sky130_fd_pr__nfet_01v8 W=1.0u L=0.15u
Rrpl2_25_3 mpl2_25_3 cpl2_3 66579.5625
XTpl2_25_4 vout1_25 gate_l2 mpl2_25_4 0 sky130_fd_pr__nfet_01v8 W=1.0u L=0.15u
Rrpl2_25_4 mpl2_25_4 cpl2_4 745470.9375
XTpl2_26_0 vout1_26 gate_l2 mpl2_26_0 0 sky130_fd_pr__nfet_01v8 W=1.0u L=0.15u
Rrpl2_26_0 mpl2_26_0 cpl2_0 3378378.2500
XTpl2_26_1 vout1_26 gate_l2 mpl2_26_1 0 sky130_fd_pr__nfet_01v8 W=1.0u L=0.15u
Rrpl2_26_1 mpl2_26_1 cpl2_1 52498.8008
XTpl2_26_2 vout1_26 gate_l2 mpl2_26_2 0 sky130_fd_pr__nfet_01v8 W=1.0u L=0.15u
Rrpl2_26_2 mpl2_26_2 cpl2_2 3378378.2500
XTpl2_26_3 vout1_26 gate_l2 mpl2_26_3 0 sky130_fd_pr__nfet_01v8 W=1.0u L=0.15u
Rrpl2_26_3 mpl2_26_3 cpl2_3 40813.2188
XTpl2_26_4 vout1_26 gate_l2 mpl2_26_4 0 sky130_fd_pr__nfet_01v8 W=1.0u L=0.15u
Rrpl2_26_4 mpl2_26_4 cpl2_4 3378378.2500
XTpl2_27_0 vout1_27 gate_l2 mpl2_27_0 0 sky130_fd_pr__nfet_01v8 W=1.0u L=0.15u
Rrpl2_27_0 mpl2_27_0 cpl2_0 3378378.2500
XTpl2_27_1 vout1_27 gate_l2 mpl2_27_1 0 sky130_fd_pr__nfet_01v8 W=1.0u L=0.15u
Rrpl2_27_1 mpl2_27_1 cpl2_1 3378378.2500
XTpl2_27_2 vout1_27 gate_l2 mpl2_27_2 0 sky130_fd_pr__nfet_01v8 W=1.0u L=0.15u
Rrpl2_27_2 mpl2_27_2 cpl2_2 45317.4648
XTpl2_27_3 vout1_27 gate_l2 mpl2_27_3 0 sky130_fd_pr__nfet_01v8 W=1.0u L=0.15u
Rrpl2_27_3 mpl2_27_3 cpl2_3 57803.8906
XTpl2_27_4 vout1_27 gate_l2 mpl2_27_4 0 sky130_fd_pr__nfet_01v8 W=1.0u L=0.15u
Rrpl2_27_4 mpl2_27_4 cpl2_4 3378378.2500
XTpl2_28_0 vout1_28 gate_l2 mpl2_28_0 0 sky130_fd_pr__nfet_01v8 W=1.0u L=0.15u
Rrpl2_28_0 mpl2_28_0 cpl2_0 62028.9375
XTpl2_28_1 vout1_28 gate_l2 mpl2_28_1 0 sky130_fd_pr__nfet_01v8 W=1.0u L=0.15u
Rrpl2_28_1 mpl2_28_1 cpl2_1 3378378.2500
XTpl2_28_2 vout1_28 gate_l2 mpl2_28_2 0 sky130_fd_pr__nfet_01v8 W=1.0u L=0.15u
Rrpl2_28_2 mpl2_28_2 cpl2_2 3378378.2500
XTpl2_28_3 vout1_28 gate_l2 mpl2_28_3 0 sky130_fd_pr__nfet_01v8 W=1.0u L=0.15u
Rrpl2_28_3 mpl2_28_3 cpl2_3 3378378.2500
XTpl2_28_4 vout1_28 gate_l2 mpl2_28_4 0 sky130_fd_pr__nfet_01v8 W=1.0u L=0.15u
Rrpl2_28_4 mpl2_28_4 cpl2_4 1977934.2500
XTpl2_29_0 vout1_29 gate_l2 mpl2_29_0 0 sky130_fd_pr__nfet_01v8 W=1.0u L=0.15u
Rrpl2_29_0 mpl2_29_0 cpl2_0 78047.7734
XTpl2_29_1 vout1_29 gate_l2 mpl2_29_1 0 sky130_fd_pr__nfet_01v8 W=1.0u L=0.15u
Rrpl2_29_1 mpl2_29_1 cpl2_1 3378378.2500
XTpl2_29_2 vout1_29 gate_l2 mpl2_29_2 0 sky130_fd_pr__nfet_01v8 W=1.0u L=0.15u
Rrpl2_29_2 mpl2_29_2 cpl2_2 236881.7969
XTpl2_29_3 vout1_29 gate_l2 mpl2_29_3 0 sky130_fd_pr__nfet_01v8 W=1.0u L=0.15u
Rrpl2_29_3 mpl2_29_3 cpl2_3 3378378.2500
XTpl2_29_4 vout1_29 gate_l2 mpl2_29_4 0 sky130_fd_pr__nfet_01v8 W=1.0u L=0.15u
Rrpl2_29_4 mpl2_29_4 cpl2_4 3378378.2500
XTpl2_30_0 vout1_30 gate_l2 mpl2_30_0 0 sky130_fd_pr__nfet_01v8 W=1.0u L=0.15u
Rrpl2_30_0 mpl2_30_0 cpl2_0 3378378.2500
XTpl2_30_1 vout1_30 gate_l2 mpl2_30_1 0 sky130_fd_pr__nfet_01v8 W=1.0u L=0.15u
Rrpl2_30_1 mpl2_30_1 cpl2_1 84837.5469
XTpl2_30_2 vout1_30 gate_l2 mpl2_30_2 0 sky130_fd_pr__nfet_01v8 W=1.0u L=0.15u
Rrpl2_30_2 mpl2_30_2 cpl2_2 81508.4062
XTpl2_30_3 vout1_30 gate_l2 mpl2_30_3 0 sky130_fd_pr__nfet_01v8 W=1.0u L=0.15u
Rrpl2_30_3 mpl2_30_3 cpl2_3 3378378.2500
XTpl2_30_4 vout1_30 gate_l2 mpl2_30_4 0 sky130_fd_pr__nfet_01v8 W=1.0u L=0.15u
Rrpl2_30_4 mpl2_30_4 cpl2_4 3378378.2500
XTpl2_31_0 vout1_31 gate_l2 mpl2_31_0 0 sky130_fd_pr__nfet_01v8 W=1.0u L=0.15u
Rrpl2_31_0 mpl2_31_0 cpl2_0 146964.1875
XTpl2_31_1 vout1_31 gate_l2 mpl2_31_1 0 sky130_fd_pr__nfet_01v8 W=1.0u L=0.15u
Rrpl2_31_1 mpl2_31_1 cpl2_1 29420.4824
XTpl2_31_2 vout1_31 gate_l2 mpl2_31_2 0 sky130_fd_pr__nfet_01v8 W=1.0u L=0.15u
Rrpl2_31_2 mpl2_31_2 cpl2_2 3378378.2500
XTpl2_31_3 vout1_31 gate_l2 mpl2_31_3 0 sky130_fd_pr__nfet_01v8 W=1.0u L=0.15u
Rrpl2_31_3 mpl2_31_3 cpl2_3 3378378.2500
XTpl2_31_4 vout1_31 gate_l2 mpl2_31_4 0 sky130_fd_pr__nfet_01v8 W=1.0u L=0.15u
Rrpl2_31_4 mpl2_31_4 cpl2_4 3378378.2500
XTpl2_32_0 vout1_32 gate_l2 mpl2_32_0 0 sky130_fd_pr__nfet_01v8 W=1.0u L=0.15u
Rrpl2_32_0 mpl2_32_0 cpl2_0 100825.0781
XTpl2_32_1 vout1_32 gate_l2 mpl2_32_1 0 sky130_fd_pr__nfet_01v8 W=1.0u L=0.15u
Rrpl2_32_1 mpl2_32_1 cpl2_1 47979.8750
XTpl2_32_2 vout1_32 gate_l2 mpl2_32_2 0 sky130_fd_pr__nfet_01v8 W=1.0u L=0.15u
Rrpl2_32_2 mpl2_32_2 cpl2_2 3378378.2500
XTpl2_32_3 vout1_32 gate_l2 mpl2_32_3 0 sky130_fd_pr__nfet_01v8 W=1.0u L=0.15u
Rrpl2_32_3 mpl2_32_3 cpl2_3 3378378.2500
XTpl2_32_4 vout1_32 gate_l2 mpl2_32_4 0 sky130_fd_pr__nfet_01v8 W=1.0u L=0.15u
Rrpl2_32_4 mpl2_32_4 cpl2_4 3378378.2500
XTpl2_33_0 vout1_33 gate_l2 mpl2_33_0 0 sky130_fd_pr__nfet_01v8 W=1.0u L=0.15u
Rrpl2_33_0 mpl2_33_0 cpl2_0 3378378.2500
XTpl2_33_1 vout1_33 gate_l2 mpl2_33_1 0 sky130_fd_pr__nfet_01v8 W=1.0u L=0.15u
Rrpl2_33_1 mpl2_33_1 cpl2_1 147713.5312
XTpl2_33_2 vout1_33 gate_l2 mpl2_33_2 0 sky130_fd_pr__nfet_01v8 W=1.0u L=0.15u
Rrpl2_33_2 mpl2_33_2 cpl2_2 88196.9531
XTpl2_33_3 vout1_33 gate_l2 mpl2_33_3 0 sky130_fd_pr__nfet_01v8 W=1.0u L=0.15u
Rrpl2_33_3 mpl2_33_3 cpl2_3 3378378.2500
XTpl2_33_4 vout1_33 gate_l2 mpl2_33_4 0 sky130_fd_pr__nfet_01v8 W=1.0u L=0.15u
Rrpl2_33_4 mpl2_33_4 cpl2_4 48934.0859
XTpl2_34_0 vout1_34 gate_l2 mpl2_34_0 0 sky130_fd_pr__nfet_01v8 W=1.0u L=0.15u
Rrpl2_34_0 mpl2_34_0 cpl2_0 61540.8750
XTpl2_34_1 vout1_34 gate_l2 mpl2_34_1 0 sky130_fd_pr__nfet_01v8 W=1.0u L=0.15u
Rrpl2_34_1 mpl2_34_1 cpl2_1 76626.5000
XTpl2_34_2 vout1_34 gate_l2 mpl2_34_2 0 sky130_fd_pr__nfet_01v8 W=1.0u L=0.15u
Rrpl2_34_2 mpl2_34_2 cpl2_2 3378378.2500
XTpl2_34_3 vout1_34 gate_l2 mpl2_34_3 0 sky130_fd_pr__nfet_01v8 W=1.0u L=0.15u
Rrpl2_34_3 mpl2_34_3 cpl2_3 538531.8125
XTpl2_34_4 vout1_34 gate_l2 mpl2_34_4 0 sky130_fd_pr__nfet_01v8 W=1.0u L=0.15u
Rrpl2_34_4 mpl2_34_4 cpl2_4 3378378.2500
XTpl2_35_0 vout1_35 gate_l2 mpl2_35_0 0 sky130_fd_pr__nfet_01v8 W=1.0u L=0.15u
Rrpl2_35_0 mpl2_35_0 cpl2_0 42173.8633
XTpl2_35_1 vout1_35 gate_l2 mpl2_35_1 0 sky130_fd_pr__nfet_01v8 W=1.0u L=0.15u
Rrpl2_35_1 mpl2_35_1 cpl2_1 3378378.2500
XTpl2_35_2 vout1_35 gate_l2 mpl2_35_2 0 sky130_fd_pr__nfet_01v8 W=1.0u L=0.15u
Rrpl2_35_2 mpl2_35_2 cpl2_2 3378378.2500
XTpl2_35_3 vout1_35 gate_l2 mpl2_35_3 0 sky130_fd_pr__nfet_01v8 W=1.0u L=0.15u
Rrpl2_35_3 mpl2_35_3 cpl2_3 3378378.2500
XTpl2_35_4 vout1_35 gate_l2 mpl2_35_4 0 sky130_fd_pr__nfet_01v8 W=1.0u L=0.15u
Rrpl2_35_4 mpl2_35_4 cpl2_4 3378378.2500
XTpl2_36_0 vout1_36 gate_l2 mpl2_36_0 0 sky130_fd_pr__nfet_01v8 W=1.0u L=0.15u
Rrpl2_36_0 mpl2_36_0 cpl2_0 3378378.2500
XTpl2_36_1 vout1_36 gate_l2 mpl2_36_1 0 sky130_fd_pr__nfet_01v8 W=1.0u L=0.15u
Rrpl2_36_1 mpl2_36_1 cpl2_1 29299.4512
XTpl2_36_2 vout1_36 gate_l2 mpl2_36_2 0 sky130_fd_pr__nfet_01v8 W=1.0u L=0.15u
Rrpl2_36_2 mpl2_36_2 cpl2_2 72282.1172
XTpl2_36_3 vout1_36 gate_l2 mpl2_36_3 0 sky130_fd_pr__nfet_01v8 W=1.0u L=0.15u
Rrpl2_36_3 mpl2_36_3 cpl2_3 3378378.2500
XTpl2_36_4 vout1_36 gate_l2 mpl2_36_4 0 sky130_fd_pr__nfet_01v8 W=1.0u L=0.15u
Rrpl2_36_4 mpl2_36_4 cpl2_4 62681.4492
XTpl2_37_0 vout1_37 gate_l2 mpl2_37_0 0 sky130_fd_pr__nfet_01v8 W=1.0u L=0.15u
Rrpl2_37_0 mpl2_37_0 cpl2_0 54115.6172
XTpl2_37_1 vout1_37 gate_l2 mpl2_37_1 0 sky130_fd_pr__nfet_01v8 W=1.0u L=0.15u
Rrpl2_37_1 mpl2_37_1 cpl2_1 3378378.2500
XTpl2_37_2 vout1_37 gate_l2 mpl2_37_2 0 sky130_fd_pr__nfet_01v8 W=1.0u L=0.15u
Rrpl2_37_2 mpl2_37_2 cpl2_2 3378378.2500
XTpl2_37_3 vout1_37 gate_l2 mpl2_37_3 0 sky130_fd_pr__nfet_01v8 W=1.0u L=0.15u
Rrpl2_37_3 mpl2_37_3 cpl2_3 3378378.2500
XTpl2_37_4 vout1_37 gate_l2 mpl2_37_4 0 sky130_fd_pr__nfet_01v8 W=1.0u L=0.15u
Rrpl2_37_4 mpl2_37_4 cpl2_4 3378378.2500
XTpl2_38_0 vout1_38 gate_l2 mpl2_38_0 0 sky130_fd_pr__nfet_01v8 W=1.0u L=0.15u
Rrpl2_38_0 mpl2_38_0 cpl2_0 110575.6641
XTpl2_38_1 vout1_38 gate_l2 mpl2_38_1 0 sky130_fd_pr__nfet_01v8 W=1.0u L=0.15u
Rrpl2_38_1 mpl2_38_1 cpl2_1 72261.5469
XTpl2_38_2 vout1_38 gate_l2 mpl2_38_2 0 sky130_fd_pr__nfet_01v8 W=1.0u L=0.15u
Rrpl2_38_2 mpl2_38_2 cpl2_2 3378378.2500
XTpl2_38_3 vout1_38 gate_l2 mpl2_38_3 0 sky130_fd_pr__nfet_01v8 W=1.0u L=0.15u
Rrpl2_38_3 mpl2_38_3 cpl2_3 3378378.2500
XTpl2_38_4 vout1_38 gate_l2 mpl2_38_4 0 sky130_fd_pr__nfet_01v8 W=1.0u L=0.15u
Rrpl2_38_4 mpl2_38_4 cpl2_4 3378378.2500
XTpl2_39_0 vout1_39 gate_l2 mpl2_39_0 0 sky130_fd_pr__nfet_01v8 W=1.0u L=0.15u
Rrpl2_39_0 mpl2_39_0 cpl2_0 275943.2188
XTpl2_39_1 vout1_39 gate_l2 mpl2_39_1 0 sky130_fd_pr__nfet_01v8 W=1.0u L=0.15u
Rrpl2_39_1 mpl2_39_1 cpl2_1 3378378.2500
XTpl2_39_2 vout1_39 gate_l2 mpl2_39_2 0 sky130_fd_pr__nfet_01v8 W=1.0u L=0.15u
Rrpl2_39_2 mpl2_39_2 cpl2_2 3378378.2500
XTpl2_39_3 vout1_39 gate_l2 mpl2_39_3 0 sky130_fd_pr__nfet_01v8 W=1.0u L=0.15u
Rrpl2_39_3 mpl2_39_3 cpl2_3 62892.2070
XTpl2_39_4 vout1_39 gate_l2 mpl2_39_4 0 sky130_fd_pr__nfet_01v8 W=1.0u L=0.15u
Rrpl2_39_4 mpl2_39_4 cpl2_4 3378378.2500
XTpl2_40_0 vout1_40 gate_l2 mpl2_40_0 0 sky130_fd_pr__nfet_01v8 W=1.0u L=0.15u
Rrpl2_40_0 mpl2_40_0 cpl2_0 3378378.2500
XTpl2_40_1 vout1_40 gate_l2 mpl2_40_1 0 sky130_fd_pr__nfet_01v8 W=1.0u L=0.15u
Rrpl2_40_1 mpl2_40_1 cpl2_1 86043.9766
XTpl2_40_2 vout1_40 gate_l2 mpl2_40_2 0 sky130_fd_pr__nfet_01v8 W=1.0u L=0.15u
Rrpl2_40_2 mpl2_40_2 cpl2_2 3378378.2500
XTpl2_40_3 vout1_40 gate_l2 mpl2_40_3 0 sky130_fd_pr__nfet_01v8 W=1.0u L=0.15u
Rrpl2_40_3 mpl2_40_3 cpl2_3 3378378.2500
XTpl2_40_4 vout1_40 gate_l2 mpl2_40_4 0 sky130_fd_pr__nfet_01v8 W=1.0u L=0.15u
Rrpl2_40_4 mpl2_40_4 cpl2_4 3378378.2500
XTpl2_41_0 vout1_41 gate_l2 mpl2_41_0 0 sky130_fd_pr__nfet_01v8 W=1.0u L=0.15u
Rrpl2_41_0 mpl2_41_0 cpl2_0 3378378.2500
XTpl2_41_1 vout1_41 gate_l2 mpl2_41_1 0 sky130_fd_pr__nfet_01v8 W=1.0u L=0.15u
Rrpl2_41_1 mpl2_41_1 cpl2_1 266020.8438
XTpl2_41_2 vout1_41 gate_l2 mpl2_41_2 0 sky130_fd_pr__nfet_01v8 W=1.0u L=0.15u
Rrpl2_41_2 mpl2_41_2 cpl2_2 69542.7109
XTpl2_41_3 vout1_41 gate_l2 mpl2_41_3 0 sky130_fd_pr__nfet_01v8 W=1.0u L=0.15u
Rrpl2_41_3 mpl2_41_3 cpl2_3 3378378.2500
XTpl2_41_4 vout1_41 gate_l2 mpl2_41_4 0 sky130_fd_pr__nfet_01v8 W=1.0u L=0.15u
Rrpl2_41_4 mpl2_41_4 cpl2_4 3378378.2500
XTpl2_42_0 vout1_42 gate_l2 mpl2_42_0 0 sky130_fd_pr__nfet_01v8 W=1.0u L=0.15u
Rrpl2_42_0 mpl2_42_0 cpl2_0 3378378.2500
XTpl2_42_1 vout1_42 gate_l2 mpl2_42_1 0 sky130_fd_pr__nfet_01v8 W=1.0u L=0.15u
Rrpl2_42_1 mpl2_42_1 cpl2_1 141094.3750
XTpl2_42_2 vout1_42 gate_l2 mpl2_42_2 0 sky130_fd_pr__nfet_01v8 W=1.0u L=0.15u
Rrpl2_42_2 mpl2_42_2 cpl2_2 3378378.2500
XTpl2_42_3 vout1_42 gate_l2 mpl2_42_3 0 sky130_fd_pr__nfet_01v8 W=1.0u L=0.15u
Rrpl2_42_3 mpl2_42_3 cpl2_3 218965.6719
XTpl2_42_4 vout1_42 gate_l2 mpl2_42_4 0 sky130_fd_pr__nfet_01v8 W=1.0u L=0.15u
Rrpl2_42_4 mpl2_42_4 cpl2_4 3378378.2500
XTpl2_43_0 vout1_43 gate_l2 mpl2_43_0 0 sky130_fd_pr__nfet_01v8 W=1.0u L=0.15u
Rrpl2_43_0 mpl2_43_0 cpl2_0 69684.3750
XTpl2_43_1 vout1_43 gate_l2 mpl2_43_1 0 sky130_fd_pr__nfet_01v8 W=1.0u L=0.15u
Rrpl2_43_1 mpl2_43_1 cpl2_1 3378378.2500
XTpl2_43_2 vout1_43 gate_l2 mpl2_43_2 0 sky130_fd_pr__nfet_01v8 W=1.0u L=0.15u
Rrpl2_43_2 mpl2_43_2 cpl2_2 3378378.2500
XTpl2_43_3 vout1_43 gate_l2 mpl2_43_3 0 sky130_fd_pr__nfet_01v8 W=1.0u L=0.15u
Rrpl2_43_3 mpl2_43_3 cpl2_3 3378378.2500
XTpl2_43_4 vout1_43 gate_l2 mpl2_43_4 0 sky130_fd_pr__nfet_01v8 W=1.0u L=0.15u
Rrpl2_43_4 mpl2_43_4 cpl2_4 3378378.2500
XTpl2_44_0 vout1_44 gate_l2 mpl2_44_0 0 sky130_fd_pr__nfet_01v8 W=1.0u L=0.15u
Rrpl2_44_0 mpl2_44_0 cpl2_0 3378378.2500
XTpl2_44_1 vout1_44 gate_l2 mpl2_44_1 0 sky130_fd_pr__nfet_01v8 W=1.0u L=0.15u
Rrpl2_44_1 mpl2_44_1 cpl2_1 3378378.2500
XTpl2_44_2 vout1_44 gate_l2 mpl2_44_2 0 sky130_fd_pr__nfet_01v8 W=1.0u L=0.15u
Rrpl2_44_2 mpl2_44_2 cpl2_2 136963.0625
XTpl2_44_3 vout1_44 gate_l2 mpl2_44_3 0 sky130_fd_pr__nfet_01v8 W=1.0u L=0.15u
Rrpl2_44_3 mpl2_44_3 cpl2_3 3378378.2500
XTpl2_44_4 vout1_44 gate_l2 mpl2_44_4 0 sky130_fd_pr__nfet_01v8 W=1.0u L=0.15u
Rrpl2_44_4 mpl2_44_4 cpl2_4 3378378.2500
XTpl2_45_0 vout1_45 gate_l2 mpl2_45_0 0 sky130_fd_pr__nfet_01v8 W=1.0u L=0.15u
Rrpl2_45_0 mpl2_45_0 cpl2_0 73370.7422
XTpl2_45_1 vout1_45 gate_l2 mpl2_45_1 0 sky130_fd_pr__nfet_01v8 W=1.0u L=0.15u
Rrpl2_45_1 mpl2_45_1 cpl2_1 3378378.2500
XTpl2_45_2 vout1_45 gate_l2 mpl2_45_2 0 sky130_fd_pr__nfet_01v8 W=1.0u L=0.15u
Rrpl2_45_2 mpl2_45_2 cpl2_2 301003.7500
XTpl2_45_3 vout1_45 gate_l2 mpl2_45_3 0 sky130_fd_pr__nfet_01v8 W=1.0u L=0.15u
Rrpl2_45_3 mpl2_45_3 cpl2_3 3378378.2500
XTpl2_45_4 vout1_45 gate_l2 mpl2_45_4 0 sky130_fd_pr__nfet_01v8 W=1.0u L=0.15u
Rrpl2_45_4 mpl2_45_4 cpl2_4 76742.1172
XTpl2_46_0 vout1_46 gate_l2 mpl2_46_0 0 sky130_fd_pr__nfet_01v8 W=1.0u L=0.15u
Rrpl2_46_0 mpl2_46_0 cpl2_0 3378378.2500
XTpl2_46_1 vout1_46 gate_l2 mpl2_46_1 0 sky130_fd_pr__nfet_01v8 W=1.0u L=0.15u
Rrpl2_46_1 mpl2_46_1 cpl2_1 3378378.2500
XTpl2_46_2 vout1_46 gate_l2 mpl2_46_2 0 sky130_fd_pr__nfet_01v8 W=1.0u L=0.15u
Rrpl2_46_2 mpl2_46_2 cpl2_2 49348.6992
XTpl2_46_3 vout1_46 gate_l2 mpl2_46_3 0 sky130_fd_pr__nfet_01v8 W=1.0u L=0.15u
Rrpl2_46_3 mpl2_46_3 cpl2_3 116336.8828
XTpl2_46_4 vout1_46 gate_l2 mpl2_46_4 0 sky130_fd_pr__nfet_01v8 W=1.0u L=0.15u
Rrpl2_46_4 mpl2_46_4 cpl2_4 3378378.2500
XTpl2_47_0 vout1_47 gate_l2 mpl2_47_0 0 sky130_fd_pr__nfet_01v8 W=1.0u L=0.15u
Rrpl2_47_0 mpl2_47_0 cpl2_0 3378378.2500
XTpl2_47_1 vout1_47 gate_l2 mpl2_47_1 0 sky130_fd_pr__nfet_01v8 W=1.0u L=0.15u
Rrpl2_47_1 mpl2_47_1 cpl2_1 42519.2773
XTpl2_47_2 vout1_47 gate_l2 mpl2_47_2 0 sky130_fd_pr__nfet_01v8 W=1.0u L=0.15u
Rrpl2_47_2 mpl2_47_2 cpl2_2 52309.1914
XTpl2_47_3 vout1_47 gate_l2 mpl2_47_3 0 sky130_fd_pr__nfet_01v8 W=1.0u L=0.15u
Rrpl2_47_3 mpl2_47_3 cpl2_3 3378378.2500
XTpl2_47_4 vout1_47 gate_l2 mpl2_47_4 0 sky130_fd_pr__nfet_01v8 W=1.0u L=0.15u
Rrpl2_47_4 mpl2_47_4 cpl2_4 64576.2773
XTpl2_48_0 vout1_48 gate_l2 mpl2_48_0 0 sky130_fd_pr__nfet_01v8 W=1.0u L=0.15u
Rrpl2_48_0 mpl2_48_0 cpl2_0 3378378.2500
XTpl2_48_1 vout1_48 gate_l2 mpl2_48_1 0 sky130_fd_pr__nfet_01v8 W=1.0u L=0.15u
Rrpl2_48_1 mpl2_48_1 cpl2_1 25800.9785
XTpl2_48_2 vout1_48 gate_l2 mpl2_48_2 0 sky130_fd_pr__nfet_01v8 W=1.0u L=0.15u
Rrpl2_48_2 mpl2_48_2 cpl2_2 3378378.2500
XTpl2_48_3 vout1_48 gate_l2 mpl2_48_3 0 sky130_fd_pr__nfet_01v8 W=1.0u L=0.15u
Rrpl2_48_3 mpl2_48_3 cpl2_3 58945.0195
XTpl2_48_4 vout1_48 gate_l2 mpl2_48_4 0 sky130_fd_pr__nfet_01v8 W=1.0u L=0.15u
Rrpl2_48_4 mpl2_48_4 cpl2_4 139917.0625
XTpl2_49_0 vout1_49 gate_l2 mpl2_49_0 0 sky130_fd_pr__nfet_01v8 W=1.0u L=0.15u
Rrpl2_49_0 mpl2_49_0 cpl2_0 52674.4297
XTpl2_49_1 vout1_49 gate_l2 mpl2_49_1 0 sky130_fd_pr__nfet_01v8 W=1.0u L=0.15u
Rrpl2_49_1 mpl2_49_1 cpl2_1 3378378.2500
XTpl2_49_2 vout1_49 gate_l2 mpl2_49_2 0 sky130_fd_pr__nfet_01v8 W=1.0u L=0.15u
Rrpl2_49_2 mpl2_49_2 cpl2_2 105018.7422
XTpl2_49_3 vout1_49 gate_l2 mpl2_49_3 0 sky130_fd_pr__nfet_01v8 W=1.0u L=0.15u
Rrpl2_49_3 mpl2_49_3 cpl2_3 3378378.2500
XTpl2_49_4 vout1_49 gate_l2 mpl2_49_4 0 sky130_fd_pr__nfet_01v8 W=1.0u L=0.15u
Rrpl2_49_4 mpl2_49_4 cpl2_4 3378378.2500
XTpl2_50_0 vout1_50 gate_l2 mpl2_50_0 0 sky130_fd_pr__nfet_01v8 W=1.0u L=0.15u
Rrpl2_50_0 mpl2_50_0 cpl2_0 50650.8477
XTpl2_50_1 vout1_50 gate_l2 mpl2_50_1 0 sky130_fd_pr__nfet_01v8 W=1.0u L=0.15u
Rrpl2_50_1 mpl2_50_1 cpl2_1 3378378.2500
XTpl2_50_2 vout1_50 gate_l2 mpl2_50_2 0 sky130_fd_pr__nfet_01v8 W=1.0u L=0.15u
Rrpl2_50_2 mpl2_50_2 cpl2_2 489429.1562
XTpl2_50_3 vout1_50 gate_l2 mpl2_50_3 0 sky130_fd_pr__nfet_01v8 W=1.0u L=0.15u
Rrpl2_50_3 mpl2_50_3 cpl2_3 63584.1875
XTpl2_50_4 vout1_50 gate_l2 mpl2_50_4 0 sky130_fd_pr__nfet_01v8 W=1.0u L=0.15u
Rrpl2_50_4 mpl2_50_4 cpl2_4 3378378.2500
XTpl2_51_0 vout1_51 gate_l2 mpl2_51_0 0 sky130_fd_pr__nfet_01v8 W=1.0u L=0.15u
Rrpl2_51_0 mpl2_51_0 cpl2_0 34523.1680
XTpl2_51_1 vout1_51 gate_l2 mpl2_51_1 0 sky130_fd_pr__nfet_01v8 W=1.0u L=0.15u
Rrpl2_51_1 mpl2_51_1 cpl2_1 3378378.2500
XTpl2_51_2 vout1_51 gate_l2 mpl2_51_2 0 sky130_fd_pr__nfet_01v8 W=1.0u L=0.15u
Rrpl2_51_2 mpl2_51_2 cpl2_2 3378378.2500
XTpl2_51_3 vout1_51 gate_l2 mpl2_51_3 0 sky130_fd_pr__nfet_01v8 W=1.0u L=0.15u
Rrpl2_51_3 mpl2_51_3 cpl2_3 3378378.2500
XTpl2_51_4 vout1_51 gate_l2 mpl2_51_4 0 sky130_fd_pr__nfet_01v8 W=1.0u L=0.15u
Rrpl2_51_4 mpl2_51_4 cpl2_4 3378378.2500
XTpl2_52_0 vout1_52 gate_l2 mpl2_52_0 0 sky130_fd_pr__nfet_01v8 W=1.0u L=0.15u
Rrpl2_52_0 mpl2_52_0 cpl2_0 48851.2383
XTpl2_52_1 vout1_52 gate_l2 mpl2_52_1 0 sky130_fd_pr__nfet_01v8 W=1.0u L=0.15u
Rrpl2_52_1 mpl2_52_1 cpl2_1 84835.5469
XTpl2_52_2 vout1_52 gate_l2 mpl2_52_2 0 sky130_fd_pr__nfet_01v8 W=1.0u L=0.15u
Rrpl2_52_2 mpl2_52_2 cpl2_2 3378378.2500
XTpl2_52_3 vout1_52 gate_l2 mpl2_52_3 0 sky130_fd_pr__nfet_01v8 W=1.0u L=0.15u
Rrpl2_52_3 mpl2_52_3 cpl2_3 3378378.2500
XTpl2_52_4 vout1_52 gate_l2 mpl2_52_4 0 sky130_fd_pr__nfet_01v8 W=1.0u L=0.15u
Rrpl2_52_4 mpl2_52_4 cpl2_4 3378378.2500
XTpl2_53_0 vout1_53 gate_l2 mpl2_53_0 0 sky130_fd_pr__nfet_01v8 W=1.0u L=0.15u
Rrpl2_53_0 mpl2_53_0 cpl2_0 3378378.2500
XTpl2_53_1 vout1_53 gate_l2 mpl2_53_1 0 sky130_fd_pr__nfet_01v8 W=1.0u L=0.15u
Rrpl2_53_1 mpl2_53_1 cpl2_1 53309.3906
XTpl2_53_2 vout1_53 gate_l2 mpl2_53_2 0 sky130_fd_pr__nfet_01v8 W=1.0u L=0.15u
Rrpl2_53_2 mpl2_53_2 cpl2_2 95711.8516
XTpl2_53_3 vout1_53 gate_l2 mpl2_53_3 0 sky130_fd_pr__nfet_01v8 W=1.0u L=0.15u
Rrpl2_53_3 mpl2_53_3 cpl2_3 3378378.2500
XTpl2_53_4 vout1_53 gate_l2 mpl2_53_4 0 sky130_fd_pr__nfet_01v8 W=1.0u L=0.15u
Rrpl2_53_4 mpl2_53_4 cpl2_4 3378378.2500
XTpl2_54_0 vout1_54 gate_l2 mpl2_54_0 0 sky130_fd_pr__nfet_01v8 W=1.0u L=0.15u
Rrpl2_54_0 mpl2_54_0 cpl2_0 171481.5312
XTpl2_54_1 vout1_54 gate_l2 mpl2_54_1 0 sky130_fd_pr__nfet_01v8 W=1.0u L=0.15u
Rrpl2_54_1 mpl2_54_1 cpl2_1 280562.5938
XTpl2_54_2 vout1_54 gate_l2 mpl2_54_2 0 sky130_fd_pr__nfet_01v8 W=1.0u L=0.15u
Rrpl2_54_2 mpl2_54_2 cpl2_2 3378378.2500
XTpl2_54_3 vout1_54 gate_l2 mpl2_54_3 0 sky130_fd_pr__nfet_01v8 W=1.0u L=0.15u
Rrpl2_54_3 mpl2_54_3 cpl2_3 3378378.2500
XTpl2_54_4 vout1_54 gate_l2 mpl2_54_4 0 sky130_fd_pr__nfet_01v8 W=1.0u L=0.15u
Rrpl2_54_4 mpl2_54_4 cpl2_4 125661.1562
XTpl2_55_0 vout1_55 gate_l2 mpl2_55_0 0 sky130_fd_pr__nfet_01v8 W=1.0u L=0.15u
Rrpl2_55_0 mpl2_55_0 cpl2_0 3378378.2500
XTpl2_55_1 vout1_55 gate_l2 mpl2_55_1 0 sky130_fd_pr__nfet_01v8 W=1.0u L=0.15u
Rrpl2_55_1 mpl2_55_1 cpl2_1 3378378.2500
XTpl2_55_2 vout1_55 gate_l2 mpl2_55_2 0 sky130_fd_pr__nfet_01v8 W=1.0u L=0.15u
Rrpl2_55_2 mpl2_55_2 cpl2_2 76790.1172
XTpl2_55_3 vout1_55 gate_l2 mpl2_55_3 0 sky130_fd_pr__nfet_01v8 W=1.0u L=0.15u
Rrpl2_55_3 mpl2_55_3 cpl2_3 52156.2148
XTpl2_55_4 vout1_55 gate_l2 mpl2_55_4 0 sky130_fd_pr__nfet_01v8 W=1.0u L=0.15u
Rrpl2_55_4 mpl2_55_4 cpl2_4 3378378.2500
XTpl2_56_0 vout1_56 gate_l2 mpl2_56_0 0 sky130_fd_pr__nfet_01v8 W=1.0u L=0.15u
Rrpl2_56_0 mpl2_56_0 cpl2_0 3378378.2500
XTpl2_56_1 vout1_56 gate_l2 mpl2_56_1 0 sky130_fd_pr__nfet_01v8 W=1.0u L=0.15u
Rrpl2_56_1 mpl2_56_1 cpl2_1 3378378.2500
XTpl2_56_2 vout1_56 gate_l2 mpl2_56_2 0 sky130_fd_pr__nfet_01v8 W=1.0u L=0.15u
Rrpl2_56_2 mpl2_56_2 cpl2_2 24572.6758
XTpl2_56_3 vout1_56 gate_l2 mpl2_56_3 0 sky130_fd_pr__nfet_01v8 W=1.0u L=0.15u
Rrpl2_56_3 mpl2_56_3 cpl2_3 317711.3438
XTpl2_56_4 vout1_56 gate_l2 mpl2_56_4 0 sky130_fd_pr__nfet_01v8 W=1.0u L=0.15u
Rrpl2_56_4 mpl2_56_4 cpl2_4 177247.2969
XTpl2_57_0 vout1_57 gate_l2 mpl2_57_0 0 sky130_fd_pr__nfet_01v8 W=1.0u L=0.15u
Rrpl2_57_0 mpl2_57_0 cpl2_0 490887.5312
XTpl2_57_1 vout1_57 gate_l2 mpl2_57_1 0 sky130_fd_pr__nfet_01v8 W=1.0u L=0.15u
Rrpl2_57_1 mpl2_57_1 cpl2_1 3378378.2500
XTpl2_57_2 vout1_57 gate_l2 mpl2_57_2 0 sky130_fd_pr__nfet_01v8 W=1.0u L=0.15u
Rrpl2_57_2 mpl2_57_2 cpl2_2 118807.7422
XTpl2_57_3 vout1_57 gate_l2 mpl2_57_3 0 sky130_fd_pr__nfet_01v8 W=1.0u L=0.15u
Rrpl2_57_3 mpl2_57_3 cpl2_3 3378378.2500
XTpl2_57_4 vout1_57 gate_l2 mpl2_57_4 0 sky130_fd_pr__nfet_01v8 W=1.0u L=0.15u
Rrpl2_57_4 mpl2_57_4 cpl2_4 187068.6719
XTpl2_58_0 vout1_58 gate_l2 mpl2_58_0 0 sky130_fd_pr__nfet_01v8 W=1.0u L=0.15u
Rrpl2_58_0 mpl2_58_0 cpl2_0 3378378.2500
XTpl2_58_1 vout1_58 gate_l2 mpl2_58_1 0 sky130_fd_pr__nfet_01v8 W=1.0u L=0.15u
Rrpl2_58_1 mpl2_58_1 cpl2_1 3378378.2500
XTpl2_58_2 vout1_58 gate_l2 mpl2_58_2 0 sky130_fd_pr__nfet_01v8 W=1.0u L=0.15u
Rrpl2_58_2 mpl2_58_2 cpl2_2 76580.5312
XTpl2_58_3 vout1_58 gate_l2 mpl2_58_3 0 sky130_fd_pr__nfet_01v8 W=1.0u L=0.15u
Rrpl2_58_3 mpl2_58_3 cpl2_3 172152.5312
XTpl2_58_4 vout1_58 gate_l2 mpl2_58_4 0 sky130_fd_pr__nfet_01v8 W=1.0u L=0.15u
Rrpl2_58_4 mpl2_58_4 cpl2_4 3378378.2500
XTpl2_59_0 vout1_59 gate_l2 mpl2_59_0 0 sky130_fd_pr__nfet_01v8 W=1.0u L=0.15u
Rrpl2_59_0 mpl2_59_0 cpl2_0 55877.3672
XTpl2_59_1 vout1_59 gate_l2 mpl2_59_1 0 sky130_fd_pr__nfet_01v8 W=1.0u L=0.15u
Rrpl2_59_1 mpl2_59_1 cpl2_1 3378378.2500
XTpl2_59_2 vout1_59 gate_l2 mpl2_59_2 0 sky130_fd_pr__nfet_01v8 W=1.0u L=0.15u
Rrpl2_59_2 mpl2_59_2 cpl2_2 3378378.2500
XTpl2_59_3 vout1_59 gate_l2 mpl2_59_3 0 sky130_fd_pr__nfet_01v8 W=1.0u L=0.15u
Rrpl2_59_3 mpl2_59_3 cpl2_3 3378378.2500
XTpl2_59_4 vout1_59 gate_l2 mpl2_59_4 0 sky130_fd_pr__nfet_01v8 W=1.0u L=0.15u
Rrpl2_59_4 mpl2_59_4 cpl2_4 3378378.2500
XTpl2_60_0 vout1_60 gate_l2 mpl2_60_0 0 sky130_fd_pr__nfet_01v8 W=1.0u L=0.15u
Rrpl2_60_0 mpl2_60_0 cpl2_0 55133.8477
XTpl2_60_1 vout1_60 gate_l2 mpl2_60_1 0 sky130_fd_pr__nfet_01v8 W=1.0u L=0.15u
Rrpl2_60_1 mpl2_60_1 cpl2_1 3378378.2500
XTpl2_60_2 vout1_60 gate_l2 mpl2_60_2 0 sky130_fd_pr__nfet_01v8 W=1.0u L=0.15u
Rrpl2_60_2 mpl2_60_2 cpl2_2 3378378.2500
XTpl2_60_3 vout1_60 gate_l2 mpl2_60_3 0 sky130_fd_pr__nfet_01v8 W=1.0u L=0.15u
Rrpl2_60_3 mpl2_60_3 cpl2_3 123315.5703
XTpl2_60_4 vout1_60 gate_l2 mpl2_60_4 0 sky130_fd_pr__nfet_01v8 W=1.0u L=0.15u
Rrpl2_60_4 mpl2_60_4 cpl2_4 3378378.2500
XTpl2_61_0 vout1_61 gate_l2 mpl2_61_0 0 sky130_fd_pr__nfet_01v8 W=1.0u L=0.15u
Rrpl2_61_0 mpl2_61_0 cpl2_0 3378378.2500
XTpl2_61_1 vout1_61 gate_l2 mpl2_61_1 0 sky130_fd_pr__nfet_01v8 W=1.0u L=0.15u
Rrpl2_61_1 mpl2_61_1 cpl2_1 47035.1953
XTpl2_61_2 vout1_61 gate_l2 mpl2_61_2 0 sky130_fd_pr__nfet_01v8 W=1.0u L=0.15u
Rrpl2_61_2 mpl2_61_2 cpl2_2 3378378.2500
XTpl2_61_3 vout1_61 gate_l2 mpl2_61_3 0 sky130_fd_pr__nfet_01v8 W=1.0u L=0.15u
Rrpl2_61_3 mpl2_61_3 cpl2_3 3378378.2500
XTpl2_61_4 vout1_61 gate_l2 mpl2_61_4 0 sky130_fd_pr__nfet_01v8 W=1.0u L=0.15u
Rrpl2_61_4 mpl2_61_4 cpl2_4 183853.5938
XTpl2_62_0 vout1_62 gate_l2 mpl2_62_0 0 sky130_fd_pr__nfet_01v8 W=1.0u L=0.15u
Rrpl2_62_0 mpl2_62_0 cpl2_0 107162.5156
XTpl2_62_1 vout1_62 gate_l2 mpl2_62_1 0 sky130_fd_pr__nfet_01v8 W=1.0u L=0.15u
Rrpl2_62_1 mpl2_62_1 cpl2_1 32741.0703
XTpl2_62_2 vout1_62 gate_l2 mpl2_62_2 0 sky130_fd_pr__nfet_01v8 W=1.0u L=0.15u
Rrpl2_62_2 mpl2_62_2 cpl2_2 3378378.2500
XTpl2_62_3 vout1_62 gate_l2 mpl2_62_3 0 sky130_fd_pr__nfet_01v8 W=1.0u L=0.15u
Rrpl2_62_3 mpl2_62_3 cpl2_3 3378378.2500
XTpl2_62_4 vout1_62 gate_l2 mpl2_62_4 0 sky130_fd_pr__nfet_01v8 W=1.0u L=0.15u
Rrpl2_62_4 mpl2_62_4 cpl2_4 3378378.2500
XTpl2_63_0 vout1_63 gate_l2 mpl2_63_0 0 sky130_fd_pr__nfet_01v8 W=1.0u L=0.15u
Rrpl2_63_0 mpl2_63_0 cpl2_0 41359.9062
XTpl2_63_1 vout1_63 gate_l2 mpl2_63_1 0 sky130_fd_pr__nfet_01v8 W=1.0u L=0.15u
Rrpl2_63_1 mpl2_63_1 cpl2_1 169632.3594
XTpl2_63_2 vout1_63 gate_l2 mpl2_63_2 0 sky130_fd_pr__nfet_01v8 W=1.0u L=0.15u
Rrpl2_63_2 mpl2_63_2 cpl2_2 3378378.2500
XTpl2_63_3 vout1_63 gate_l2 mpl2_63_3 0 sky130_fd_pr__nfet_01v8 W=1.0u L=0.15u
Rrpl2_63_3 mpl2_63_3 cpl2_3 3378378.2500
XTpl2_63_4 vout1_63 gate_l2 mpl2_63_4 0 sky130_fd_pr__nfet_01v8 W=1.0u L=0.15u
Rrpl2_63_4 mpl2_63_4 cpl2_4 3378378.2500

* --- Negative conductance array ---
XTnl2_0_0 vout1_0 gate_l2 mnl2_0_0 0 sky130_fd_pr__nfet_01v8 W=1.0u L=0.15u
Rrnl2_0_0 mnl2_0_0 cnl2_0 3378378.2500
XTnl2_0_1 vout1_0 gate_l2 mnl2_0_1 0 sky130_fd_pr__nfet_01v8 W=1.0u L=0.15u
Rrnl2_0_1 mnl2_0_1 cnl2_1 142231.3125
XTnl2_0_2 vout1_0 gate_l2 mnl2_0_2 0 sky130_fd_pr__nfet_01v8 W=1.0u L=0.15u
Rrnl2_0_2 mnl2_0_2 cnl2_2 609492.5000
XTnl2_0_3 vout1_0 gate_l2 mnl2_0_3 0 sky130_fd_pr__nfet_01v8 W=1.0u L=0.15u
Rrnl2_0_3 mnl2_0_3 cnl2_3 64037.7734
XTnl2_0_4 vout1_0 gate_l2 mnl2_0_4 0 sky130_fd_pr__nfet_01v8 W=1.0u L=0.15u
Rrnl2_0_4 mnl2_0_4 cnl2_4 170667.1719
XTnl2_1_0 vout1_1 gate_l2 mnl2_1_0 0 sky130_fd_pr__nfet_01v8 W=1.0u L=0.15u
Rrnl2_1_0 mnl2_1_0 cnl2_0 1230621.1250
XTnl2_1_1 vout1_1 gate_l2 mnl2_1_1 0 sky130_fd_pr__nfet_01v8 W=1.0u L=0.15u
Rrnl2_1_1 mnl2_1_1 cnl2_1 44855.5586
XTnl2_1_2 vout1_1 gate_l2 mnl2_1_2 0 sky130_fd_pr__nfet_01v8 W=1.0u L=0.15u
Rrnl2_1_2 mnl2_1_2 cnl2_2 3378378.2500
XTnl2_1_3 vout1_1 gate_l2 mnl2_1_3 0 sky130_fd_pr__nfet_01v8 W=1.0u L=0.15u
Rrnl2_1_3 mnl2_1_3 cnl2_3 3378378.2500
XTnl2_1_4 vout1_1 gate_l2 mnl2_1_4 0 sky130_fd_pr__nfet_01v8 W=1.0u L=0.15u
Rrnl2_1_4 mnl2_1_4 cnl2_4 3378378.2500
XTnl2_2_0 vout1_2 gate_l2 mnl2_2_0 0 sky130_fd_pr__nfet_01v8 W=1.0u L=0.15u
Rrnl2_2_0 mnl2_2_0 cnl2_0 3378378.2500
XTnl2_2_1 vout1_2 gate_l2 mnl2_2_1 0 sky130_fd_pr__nfet_01v8 W=1.0u L=0.15u
Rrnl2_2_1 mnl2_2_1 cnl2_1 3378378.2500
XTnl2_2_2 vout1_2 gate_l2 mnl2_2_2 0 sky130_fd_pr__nfet_01v8 W=1.0u L=0.15u
Rrnl2_2_2 mnl2_2_2 cnl2_2 97808.9219
XTnl2_2_3 vout1_2 gate_l2 mnl2_2_3 0 sky130_fd_pr__nfet_01v8 W=1.0u L=0.15u
Rrnl2_2_3 mnl2_2_3 cnl2_3 34125.6250
XTnl2_2_4 vout1_2 gate_l2 mnl2_2_4 0 sky130_fd_pr__nfet_01v8 W=1.0u L=0.15u
Rrnl2_2_4 mnl2_2_4 cnl2_4 63253.1758
XTnl2_3_0 vout1_3 gate_l2 mnl2_3_0 0 sky130_fd_pr__nfet_01v8 W=1.0u L=0.15u
Rrnl2_3_0 mnl2_3_0 cnl2_0 40467.8711
XTnl2_3_1 vout1_3 gate_l2 mnl2_3_1 0 sky130_fd_pr__nfet_01v8 W=1.0u L=0.15u
Rrnl2_3_1 mnl2_3_1 cnl2_1 186260.6562
XTnl2_3_2 vout1_3 gate_l2 mnl2_3_2 0 sky130_fd_pr__nfet_01v8 W=1.0u L=0.15u
Rrnl2_3_2 mnl2_3_2 cnl2_2 3378378.2500
XTnl2_3_3 vout1_3 gate_l2 mnl2_3_3 0 sky130_fd_pr__nfet_01v8 W=1.0u L=0.15u
Rrnl2_3_3 mnl2_3_3 cnl2_3 3378378.2500
XTnl2_3_4 vout1_3 gate_l2 mnl2_3_4 0 sky130_fd_pr__nfet_01v8 W=1.0u L=0.15u
Rrnl2_3_4 mnl2_3_4 cnl2_4 285589.9688
XTnl2_4_0 vout1_4 gate_l2 mnl2_4_0 0 sky130_fd_pr__nfet_01v8 W=1.0u L=0.15u
Rrnl2_4_0 mnl2_4_0 cnl2_0 44898.0117
XTnl2_4_1 vout1_4 gate_l2 mnl2_4_1 0 sky130_fd_pr__nfet_01v8 W=1.0u L=0.15u
Rrnl2_4_1 mnl2_4_1 cnl2_1 227919.4688
XTnl2_4_2 vout1_4 gate_l2 mnl2_4_2 0 sky130_fd_pr__nfet_01v8 W=1.0u L=0.15u
Rrnl2_4_2 mnl2_4_2 cnl2_2 3378378.2500
XTnl2_4_3 vout1_4 gate_l2 mnl2_4_3 0 sky130_fd_pr__nfet_01v8 W=1.0u L=0.15u
Rrnl2_4_3 mnl2_4_3 cnl2_3 3378378.2500
XTnl2_4_4 vout1_4 gate_l2 mnl2_4_4 0 sky130_fd_pr__nfet_01v8 W=1.0u L=0.15u
Rrnl2_4_4 mnl2_4_4 cnl2_4 3378378.2500
XTnl2_5_0 vout1_5 gate_l2 mnl2_5_0 0 sky130_fd_pr__nfet_01v8 W=1.0u L=0.15u
Rrnl2_5_0 mnl2_5_0 cnl2_0 3378378.2500
XTnl2_5_1 vout1_5 gate_l2 mnl2_5_1 0 sky130_fd_pr__nfet_01v8 W=1.0u L=0.15u
Rrnl2_5_1 mnl2_5_1 cnl2_1 3378378.2500
XTnl2_5_2 vout1_5 gate_l2 mnl2_5_2 0 sky130_fd_pr__nfet_01v8 W=1.0u L=0.15u
Rrnl2_5_2 mnl2_5_2 cnl2_2 35549.0117
XTnl2_5_3 vout1_5 gate_l2 mnl2_5_3 0 sky130_fd_pr__nfet_01v8 W=1.0u L=0.15u
Rrnl2_5_3 mnl2_5_3 cnl2_3 74314.1250
XTnl2_5_4 vout1_5 gate_l2 mnl2_5_4 0 sky130_fd_pr__nfet_01v8 W=1.0u L=0.15u
Rrnl2_5_4 mnl2_5_4 cnl2_4 57883.3945
XTnl2_6_0 vout1_6 gate_l2 mnl2_6_0 0 sky130_fd_pr__nfet_01v8 W=1.0u L=0.15u
Rrnl2_6_0 mnl2_6_0 cnl2_0 3378378.2500
XTnl2_6_1 vout1_6 gate_l2 mnl2_6_1 0 sky130_fd_pr__nfet_01v8 W=1.0u L=0.15u
Rrnl2_6_1 mnl2_6_1 cnl2_1 52773.1875
XTnl2_6_2 vout1_6 gate_l2 mnl2_6_2 0 sky130_fd_pr__nfet_01v8 W=1.0u L=0.15u
Rrnl2_6_2 mnl2_6_2 cnl2_2 134992.4844
XTnl2_6_3 vout1_6 gate_l2 mnl2_6_3 0 sky130_fd_pr__nfet_01v8 W=1.0u L=0.15u
Rrnl2_6_3 mnl2_6_3 cnl2_3 303592.6875
XTnl2_6_4 vout1_6 gate_l2 mnl2_6_4 0 sky130_fd_pr__nfet_01v8 W=1.0u L=0.15u
Rrnl2_6_4 mnl2_6_4 cnl2_4 685480.7500
XTnl2_7_0 vout1_7 gate_l2 mnl2_7_0 0 sky130_fd_pr__nfet_01v8 W=1.0u L=0.15u
Rrnl2_7_0 mnl2_7_0 cnl2_0 3378378.2500
XTnl2_7_1 vout1_7 gate_l2 mnl2_7_1 0 sky130_fd_pr__nfet_01v8 W=1.0u L=0.15u
Rrnl2_7_1 mnl2_7_1 cnl2_1 3378378.2500
XTnl2_7_2 vout1_7 gate_l2 mnl2_7_2 0 sky130_fd_pr__nfet_01v8 W=1.0u L=0.15u
Rrnl2_7_2 mnl2_7_2 cnl2_2 44769.7578
XTnl2_7_3 vout1_7 gate_l2 mnl2_7_3 0 sky130_fd_pr__nfet_01v8 W=1.0u L=0.15u
Rrnl2_7_3 mnl2_7_3 cnl2_3 238919.9688
XTnl2_7_4 vout1_7 gate_l2 mnl2_7_4 0 sky130_fd_pr__nfet_01v8 W=1.0u L=0.15u
Rrnl2_7_4 mnl2_7_4 cnl2_4 119996.8047
XTnl2_8_0 vout1_8 gate_l2 mnl2_8_0 0 sky130_fd_pr__nfet_01v8 W=1.0u L=0.15u
Rrnl2_8_0 mnl2_8_0 cnl2_0 3378378.2500
XTnl2_8_1 vout1_8 gate_l2 mnl2_8_1 0 sky130_fd_pr__nfet_01v8 W=1.0u L=0.15u
Rrnl2_8_1 mnl2_8_1 cnl2_1 22170.8711
XTnl2_8_2 vout1_8 gate_l2 mnl2_8_2 0 sky130_fd_pr__nfet_01v8 W=1.0u L=0.15u
Rrnl2_8_2 mnl2_8_2 cnl2_2 3378378.2500
XTnl2_8_3 vout1_8 gate_l2 mnl2_8_3 0 sky130_fd_pr__nfet_01v8 W=1.0u L=0.15u
Rrnl2_8_3 mnl2_8_3 cnl2_3 47837.3633
XTnl2_8_4 vout1_8 gate_l2 mnl2_8_4 0 sky130_fd_pr__nfet_01v8 W=1.0u L=0.15u
Rrnl2_8_4 mnl2_8_4 cnl2_4 3378378.2500
XTnl2_9_0 vout1_9 gate_l2 mnl2_9_0 0 sky130_fd_pr__nfet_01v8 W=1.0u L=0.15u
Rrnl2_9_0 mnl2_9_0 cnl2_0 3378378.2500
XTnl2_9_1 vout1_9 gate_l2 mnl2_9_1 0 sky130_fd_pr__nfet_01v8 W=1.0u L=0.15u
Rrnl2_9_1 mnl2_9_1 cnl2_1 3378378.2500
XTnl2_9_2 vout1_9 gate_l2 mnl2_9_2 0 sky130_fd_pr__nfet_01v8 W=1.0u L=0.15u
Rrnl2_9_2 mnl2_9_2 cnl2_2 133724.5781
XTnl2_9_3 vout1_9 gate_l2 mnl2_9_3 0 sky130_fd_pr__nfet_01v8 W=1.0u L=0.15u
Rrnl2_9_3 mnl2_9_3 cnl2_3 3378378.2500
XTnl2_9_4 vout1_9 gate_l2 mnl2_9_4 0 sky130_fd_pr__nfet_01v8 W=1.0u L=0.15u
Rrnl2_9_4 mnl2_9_4 cnl2_4 76063.6562
XTnl2_10_0 vout1_10 gate_l2 mnl2_10_0 0 sky130_fd_pr__nfet_01v8 W=1.0u L=0.15u
Rrnl2_10_0 mnl2_10_0 cnl2_0 248769.3438
XTnl2_10_1 vout1_10 gate_l2 mnl2_10_1 0 sky130_fd_pr__nfet_01v8 W=1.0u L=0.15u
Rrnl2_10_1 mnl2_10_1 cnl2_1 78575.2812
XTnl2_10_2 vout1_10 gate_l2 mnl2_10_2 0 sky130_fd_pr__nfet_01v8 W=1.0u L=0.15u
Rrnl2_10_2 mnl2_10_2 cnl2_2 3378378.2500
XTnl2_10_3 vout1_10 gate_l2 mnl2_10_3 0 sky130_fd_pr__nfet_01v8 W=1.0u L=0.15u
Rrnl2_10_3 mnl2_10_3 cnl2_3 3378378.2500
XTnl2_10_4 vout1_10 gate_l2 mnl2_10_4 0 sky130_fd_pr__nfet_01v8 W=1.0u L=0.15u
Rrnl2_10_4 mnl2_10_4 cnl2_4 3378378.2500
XTnl2_11_0 vout1_11 gate_l2 mnl2_11_0 0 sky130_fd_pr__nfet_01v8 W=1.0u L=0.15u
Rrnl2_11_0 mnl2_11_0 cnl2_0 3378378.2500
XTnl2_11_1 vout1_11 gate_l2 mnl2_11_1 0 sky130_fd_pr__nfet_01v8 W=1.0u L=0.15u
Rrnl2_11_1 mnl2_11_1 cnl2_1 40722.4023
XTnl2_11_2 vout1_11 gate_l2 mnl2_11_2 0 sky130_fd_pr__nfet_01v8 W=1.0u L=0.15u
Rrnl2_11_2 mnl2_11_2 cnl2_2 429191.5000
XTnl2_11_3 vout1_11 gate_l2 mnl2_11_3 0 sky130_fd_pr__nfet_01v8 W=1.0u L=0.15u
Rrnl2_11_3 mnl2_11_3 cnl2_3 316455.9375
XTnl2_11_4 vout1_11 gate_l2 mnl2_11_4 0 sky130_fd_pr__nfet_01v8 W=1.0u L=0.15u
Rrnl2_11_4 mnl2_11_4 cnl2_4 3378378.2500
XTnl2_12_0 vout1_12 gate_l2 mnl2_12_0 0 sky130_fd_pr__nfet_01v8 W=1.0u L=0.15u
Rrnl2_12_0 mnl2_12_0 cnl2_0 288834.8750
XTnl2_12_1 vout1_12 gate_l2 mnl2_12_1 0 sky130_fd_pr__nfet_01v8 W=1.0u L=0.15u
Rrnl2_12_1 mnl2_12_1 cnl2_1 3378378.2500
XTnl2_12_2 vout1_12 gate_l2 mnl2_12_2 0 sky130_fd_pr__nfet_01v8 W=1.0u L=0.15u
Rrnl2_12_2 mnl2_12_2 cnl2_2 3378378.2500
XTnl2_12_3 vout1_12 gate_l2 mnl2_12_3 0 sky130_fd_pr__nfet_01v8 W=1.0u L=0.15u
Rrnl2_12_3 mnl2_12_3 cnl2_3 28672.9062
XTnl2_12_4 vout1_12 gate_l2 mnl2_12_4 0 sky130_fd_pr__nfet_01v8 W=1.0u L=0.15u
Rrnl2_12_4 mnl2_12_4 cnl2_4 24528.2500
XTnl2_13_0 vout1_13 gate_l2 mnl2_13_0 0 sky130_fd_pr__nfet_01v8 W=1.0u L=0.15u
Rrnl2_13_0 mnl2_13_0 cnl2_0 2450343.0000
XTnl2_13_1 vout1_13 gate_l2 mnl2_13_1 0 sky130_fd_pr__nfet_01v8 W=1.0u L=0.15u
Rrnl2_13_1 mnl2_13_1 cnl2_1 43085.7617
XTnl2_13_2 vout1_13 gate_l2 mnl2_13_2 0 sky130_fd_pr__nfet_01v8 W=1.0u L=0.15u
Rrnl2_13_2 mnl2_13_2 cnl2_2 299899.1250
XTnl2_13_3 vout1_13 gate_l2 mnl2_13_3 0 sky130_fd_pr__nfet_01v8 W=1.0u L=0.15u
Rrnl2_13_3 mnl2_13_3 cnl2_3 3378378.2500
XTnl2_13_4 vout1_13 gate_l2 mnl2_13_4 0 sky130_fd_pr__nfet_01v8 W=1.0u L=0.15u
Rrnl2_13_4 mnl2_13_4 cnl2_4 3378378.2500
XTnl2_14_0 vout1_14 gate_l2 mnl2_14_0 0 sky130_fd_pr__nfet_01v8 W=1.0u L=0.15u
Rrnl2_14_0 mnl2_14_0 cnl2_0 3378378.2500
XTnl2_14_1 vout1_14 gate_l2 mnl2_14_1 0 sky130_fd_pr__nfet_01v8 W=1.0u L=0.15u
Rrnl2_14_1 mnl2_14_1 cnl2_1 41653.6680
XTnl2_14_2 vout1_14 gate_l2 mnl2_14_2 0 sky130_fd_pr__nfet_01v8 W=1.0u L=0.15u
Rrnl2_14_2 mnl2_14_2 cnl2_2 107658.8594
XTnl2_14_3 vout1_14 gate_l2 mnl2_14_3 0 sky130_fd_pr__nfet_01v8 W=1.0u L=0.15u
Rrnl2_14_3 mnl2_14_3 cnl2_3 3378378.2500
XTnl2_14_4 vout1_14 gate_l2 mnl2_14_4 0 sky130_fd_pr__nfet_01v8 W=1.0u L=0.15u
Rrnl2_14_4 mnl2_14_4 cnl2_4 3378378.2500
XTnl2_15_0 vout1_15 gate_l2 mnl2_15_0 0 sky130_fd_pr__nfet_01v8 W=1.0u L=0.15u
Rrnl2_15_0 mnl2_15_0 cnl2_0 3378378.2500
XTnl2_15_1 vout1_15 gate_l2 mnl2_15_1 0 sky130_fd_pr__nfet_01v8 W=1.0u L=0.15u
Rrnl2_15_1 mnl2_15_1 cnl2_1 34881.8125
XTnl2_15_2 vout1_15 gate_l2 mnl2_15_2 0 sky130_fd_pr__nfet_01v8 W=1.0u L=0.15u
Rrnl2_15_2 mnl2_15_2 cnl2_2 271006.1875
XTnl2_15_3 vout1_15 gate_l2 mnl2_15_3 0 sky130_fd_pr__nfet_01v8 W=1.0u L=0.15u
Rrnl2_15_3 mnl2_15_3 cnl2_3 3378378.2500
XTnl2_15_4 vout1_15 gate_l2 mnl2_15_4 0 sky130_fd_pr__nfet_01v8 W=1.0u L=0.15u
Rrnl2_15_4 mnl2_15_4 cnl2_4 3378378.2500
XTnl2_16_0 vout1_16 gate_l2 mnl2_16_0 0 sky130_fd_pr__nfet_01v8 W=1.0u L=0.15u
Rrnl2_16_0 mnl2_16_0 cnl2_0 42534.5469
XTnl2_16_1 vout1_16 gate_l2 mnl2_16_1 0 sky130_fd_pr__nfet_01v8 W=1.0u L=0.15u
Rrnl2_16_1 mnl2_16_1 cnl2_1 3378378.2500
XTnl2_16_2 vout1_16 gate_l2 mnl2_16_2 0 sky130_fd_pr__nfet_01v8 W=1.0u L=0.15u
Rrnl2_16_2 mnl2_16_2 cnl2_2 3378378.2500
XTnl2_16_3 vout1_16 gate_l2 mnl2_16_3 0 sky130_fd_pr__nfet_01v8 W=1.0u L=0.15u
Rrnl2_16_3 mnl2_16_3 cnl2_3 3378378.2500
XTnl2_16_4 vout1_16 gate_l2 mnl2_16_4 0 sky130_fd_pr__nfet_01v8 W=1.0u L=0.15u
Rrnl2_16_4 mnl2_16_4 cnl2_4 125964.7656
XTnl2_17_0 vout1_17 gate_l2 mnl2_17_0 0 sky130_fd_pr__nfet_01v8 W=1.0u L=0.15u
Rrnl2_17_0 mnl2_17_0 cnl2_0 99598.7812
XTnl2_17_1 vout1_17 gate_l2 mnl2_17_1 0 sky130_fd_pr__nfet_01v8 W=1.0u L=0.15u
Rrnl2_17_1 mnl2_17_1 cnl2_1 3378378.2500
XTnl2_17_2 vout1_17 gate_l2 mnl2_17_2 0 sky130_fd_pr__nfet_01v8 W=1.0u L=0.15u
Rrnl2_17_2 mnl2_17_2 cnl2_2 80307.6016
XTnl2_17_3 vout1_17 gate_l2 mnl2_17_3 0 sky130_fd_pr__nfet_01v8 W=1.0u L=0.15u
Rrnl2_17_3 mnl2_17_3 cnl2_3 3378378.2500
XTnl2_17_4 vout1_17 gate_l2 mnl2_17_4 0 sky130_fd_pr__nfet_01v8 W=1.0u L=0.15u
Rrnl2_17_4 mnl2_17_4 cnl2_4 82837.4922
XTnl2_18_0 vout1_18 gate_l2 mnl2_18_0 0 sky130_fd_pr__nfet_01v8 W=1.0u L=0.15u
Rrnl2_18_0 mnl2_18_0 cnl2_0 156538.1719
XTnl2_18_1 vout1_18 gate_l2 mnl2_18_1 0 sky130_fd_pr__nfet_01v8 W=1.0u L=0.15u
Rrnl2_18_1 mnl2_18_1 cnl2_1 67084.0078
XTnl2_18_2 vout1_18 gate_l2 mnl2_18_2 0 sky130_fd_pr__nfet_01v8 W=1.0u L=0.15u
Rrnl2_18_2 mnl2_18_2 cnl2_2 3378378.2500
XTnl2_18_3 vout1_18 gate_l2 mnl2_18_3 0 sky130_fd_pr__nfet_01v8 W=1.0u L=0.15u
Rrnl2_18_3 mnl2_18_3 cnl2_3 230596.6719
XTnl2_18_4 vout1_18 gate_l2 mnl2_18_4 0 sky130_fd_pr__nfet_01v8 W=1.0u L=0.15u
Rrnl2_18_4 mnl2_18_4 cnl2_4 3378378.2500
XTnl2_19_0 vout1_19 gate_l2 mnl2_19_0 0 sky130_fd_pr__nfet_01v8 W=1.0u L=0.15u
Rrnl2_19_0 mnl2_19_0 cnl2_0 3378378.2500
XTnl2_19_1 vout1_19 gate_l2 mnl2_19_1 0 sky130_fd_pr__nfet_01v8 W=1.0u L=0.15u
Rrnl2_19_1 mnl2_19_1 cnl2_1 3378378.2500
XTnl2_19_2 vout1_19 gate_l2 mnl2_19_2 0 sky130_fd_pr__nfet_01v8 W=1.0u L=0.15u
Rrnl2_19_2 mnl2_19_2 cnl2_2 64280.5352
XTnl2_19_3 vout1_19 gate_l2 mnl2_19_3 0 sky130_fd_pr__nfet_01v8 W=1.0u L=0.15u
Rrnl2_19_3 mnl2_19_3 cnl2_3 3378378.2500
XTnl2_19_4 vout1_19 gate_l2 mnl2_19_4 0 sky130_fd_pr__nfet_01v8 W=1.0u L=0.15u
Rrnl2_19_4 mnl2_19_4 cnl2_4 31228.6758
XTnl2_20_0 vout1_20 gate_l2 mnl2_20_0 0 sky130_fd_pr__nfet_01v8 W=1.0u L=0.15u
Rrnl2_20_0 mnl2_20_0 cnl2_0 3378378.2500
XTnl2_20_1 vout1_20 gate_l2 mnl2_20_1 0 sky130_fd_pr__nfet_01v8 W=1.0u L=0.15u
Rrnl2_20_1 mnl2_20_1 cnl2_1 41487.3906
XTnl2_20_2 vout1_20 gate_l2 mnl2_20_2 0 sky130_fd_pr__nfet_01v8 W=1.0u L=0.15u
Rrnl2_20_2 mnl2_20_2 cnl2_2 3378378.2500
XTnl2_20_3 vout1_20 gate_l2 mnl2_20_3 0 sky130_fd_pr__nfet_01v8 W=1.0u L=0.15u
Rrnl2_20_3 mnl2_20_3 cnl2_3 18487.4414
XTnl2_20_4 vout1_20 gate_l2 mnl2_20_4 0 sky130_fd_pr__nfet_01v8 W=1.0u L=0.15u
Rrnl2_20_4 mnl2_20_4 cnl2_4 42216.9844
XTnl2_21_0 vout1_21 gate_l2 mnl2_21_0 0 sky130_fd_pr__nfet_01v8 W=1.0u L=0.15u
Rrnl2_21_0 mnl2_21_0 cnl2_0 3378378.2500
XTnl2_21_1 vout1_21 gate_l2 mnl2_21_1 0 sky130_fd_pr__nfet_01v8 W=1.0u L=0.15u
Rrnl2_21_1 mnl2_21_1 cnl2_1 91330.9844
XTnl2_21_2 vout1_21 gate_l2 mnl2_21_2 0 sky130_fd_pr__nfet_01v8 W=1.0u L=0.15u
Rrnl2_21_2 mnl2_21_2 cnl2_2 32100.2969
XTnl2_21_3 vout1_21 gate_l2 mnl2_21_3 0 sky130_fd_pr__nfet_01v8 W=1.0u L=0.15u
Rrnl2_21_3 mnl2_21_3 cnl2_3 3378378.2500
XTnl2_21_4 vout1_21 gate_l2 mnl2_21_4 0 sky130_fd_pr__nfet_01v8 W=1.0u L=0.15u
Rrnl2_21_4 mnl2_21_4 cnl2_4 335068.4062
XTnl2_22_0 vout1_22 gate_l2 mnl2_22_0 0 sky130_fd_pr__nfet_01v8 W=1.0u L=0.15u
Rrnl2_22_0 mnl2_22_0 cnl2_0 3378378.2500
XTnl2_22_1 vout1_22 gate_l2 mnl2_22_1 0 sky130_fd_pr__nfet_01v8 W=1.0u L=0.15u
Rrnl2_22_1 mnl2_22_1 cnl2_1 3378378.2500
XTnl2_22_2 vout1_22 gate_l2 mnl2_22_2 0 sky130_fd_pr__nfet_01v8 W=1.0u L=0.15u
Rrnl2_22_2 mnl2_22_2 cnl2_2 113599.0938
XTnl2_22_3 vout1_22 gate_l2 mnl2_22_3 0 sky130_fd_pr__nfet_01v8 W=1.0u L=0.15u
Rrnl2_22_3 mnl2_22_3 cnl2_3 325665.5938
XTnl2_22_4 vout1_22 gate_l2 mnl2_22_4 0 sky130_fd_pr__nfet_01v8 W=1.0u L=0.15u
Rrnl2_22_4 mnl2_22_4 cnl2_4 10073.2324
XTnl2_23_0 vout1_23 gate_l2 mnl2_23_0 0 sky130_fd_pr__nfet_01v8 W=1.0u L=0.15u
Rrnl2_23_0 mnl2_23_0 cnl2_0 3378378.2500
XTnl2_23_1 vout1_23 gate_l2 mnl2_23_1 0 sky130_fd_pr__nfet_01v8 W=1.0u L=0.15u
Rrnl2_23_1 mnl2_23_1 cnl2_1 3378378.2500
XTnl2_23_2 vout1_23 gate_l2 mnl2_23_2 0 sky130_fd_pr__nfet_01v8 W=1.0u L=0.15u
Rrnl2_23_2 mnl2_23_2 cnl2_2 55283.4883
XTnl2_23_3 vout1_23 gate_l2 mnl2_23_3 0 sky130_fd_pr__nfet_01v8 W=1.0u L=0.15u
Rrnl2_23_3 mnl2_23_3 cnl2_3 3378378.2500
XTnl2_23_4 vout1_23 gate_l2 mnl2_23_4 0 sky130_fd_pr__nfet_01v8 W=1.0u L=0.15u
Rrnl2_23_4 mnl2_23_4 cnl2_4 3378378.2500
XTnl2_24_0 vout1_24 gate_l2 mnl2_24_0 0 sky130_fd_pr__nfet_01v8 W=1.0u L=0.15u
Rrnl2_24_0 mnl2_24_0 cnl2_0 64782.7383
XTnl2_24_1 vout1_24 gate_l2 mnl2_24_1 0 sky130_fd_pr__nfet_01v8 W=1.0u L=0.15u
Rrnl2_24_1 mnl2_24_1 cnl2_1 15392.1494
XTnl2_24_2 vout1_24 gate_l2 mnl2_24_2 0 sky130_fd_pr__nfet_01v8 W=1.0u L=0.15u
Rrnl2_24_2 mnl2_24_2 cnl2_2 3378378.2500
XTnl2_24_3 vout1_24 gate_l2 mnl2_24_3 0 sky130_fd_pr__nfet_01v8 W=1.0u L=0.15u
Rrnl2_24_3 mnl2_24_3 cnl2_3 3378378.2500
XTnl2_24_4 vout1_24 gate_l2 mnl2_24_4 0 sky130_fd_pr__nfet_01v8 W=1.0u L=0.15u
Rrnl2_24_4 mnl2_24_4 cnl2_4 3378378.2500
XTnl2_25_0 vout1_25 gate_l2 mnl2_25_0 0 sky130_fd_pr__nfet_01v8 W=1.0u L=0.15u
Rrnl2_25_0 mnl2_25_0 cnl2_0 3378378.2500
XTnl2_25_1 vout1_25 gate_l2 mnl2_25_1 0 sky130_fd_pr__nfet_01v8 W=1.0u L=0.15u
Rrnl2_25_1 mnl2_25_1 cnl2_1 969457.6250
XTnl2_25_2 vout1_25 gate_l2 mnl2_25_2 0 sky130_fd_pr__nfet_01v8 W=1.0u L=0.15u
Rrnl2_25_2 mnl2_25_2 cnl2_2 111426.6250
XTnl2_25_3 vout1_25 gate_l2 mnl2_25_3 0 sky130_fd_pr__nfet_01v8 W=1.0u L=0.15u
Rrnl2_25_3 mnl2_25_3 cnl2_3 3378378.2500
XTnl2_25_4 vout1_25 gate_l2 mnl2_25_4 0 sky130_fd_pr__nfet_01v8 W=1.0u L=0.15u
Rrnl2_25_4 mnl2_25_4 cnl2_4 3378378.2500
XTnl2_26_0 vout1_26 gate_l2 mnl2_26_0 0 sky130_fd_pr__nfet_01v8 W=1.0u L=0.15u
Rrnl2_26_0 mnl2_26_0 cnl2_0 58722.1602
XTnl2_26_1 vout1_26 gate_l2 mnl2_26_1 0 sky130_fd_pr__nfet_01v8 W=1.0u L=0.15u
Rrnl2_26_1 mnl2_26_1 cnl2_1 3378378.2500
XTnl2_26_2 vout1_26 gate_l2 mnl2_26_2 0 sky130_fd_pr__nfet_01v8 W=1.0u L=0.15u
Rrnl2_26_2 mnl2_26_2 cnl2_2 120177.2109
XTnl2_26_3 vout1_26 gate_l2 mnl2_26_3 0 sky130_fd_pr__nfet_01v8 W=1.0u L=0.15u
Rrnl2_26_3 mnl2_26_3 cnl2_3 3378378.2500
XTnl2_26_4 vout1_26 gate_l2 mnl2_26_4 0 sky130_fd_pr__nfet_01v8 W=1.0u L=0.15u
Rrnl2_26_4 mnl2_26_4 cnl2_4 294126.7812
XTnl2_27_0 vout1_27 gate_l2 mnl2_27_0 0 sky130_fd_pr__nfet_01v8 W=1.0u L=0.15u
Rrnl2_27_0 mnl2_27_0 cnl2_0 86699.0859
XTnl2_27_1 vout1_27 gate_l2 mnl2_27_1 0 sky130_fd_pr__nfet_01v8 W=1.0u L=0.15u
Rrnl2_27_1 mnl2_27_1 cnl2_1 221549.5781
XTnl2_27_2 vout1_27 gate_l2 mnl2_27_2 0 sky130_fd_pr__nfet_01v8 W=1.0u L=0.15u
Rrnl2_27_2 mnl2_27_2 cnl2_2 3378378.2500
XTnl2_27_3 vout1_27 gate_l2 mnl2_27_3 0 sky130_fd_pr__nfet_01v8 W=1.0u L=0.15u
Rrnl2_27_3 mnl2_27_3 cnl2_3 3378378.2500
XTnl2_27_4 vout1_27 gate_l2 mnl2_27_4 0 sky130_fd_pr__nfet_01v8 W=1.0u L=0.15u
Rrnl2_27_4 mnl2_27_4 cnl2_4 51731.1172
XTnl2_28_0 vout1_28 gate_l2 mnl2_28_0 0 sky130_fd_pr__nfet_01v8 W=1.0u L=0.15u
Rrnl2_28_0 mnl2_28_0 cnl2_0 3378378.2500
XTnl2_28_1 vout1_28 gate_l2 mnl2_28_1 0 sky130_fd_pr__nfet_01v8 W=1.0u L=0.15u
Rrnl2_28_1 mnl2_28_1 cnl2_1 153005.5625
XTnl2_28_2 vout1_28 gate_l2 mnl2_28_2 0 sky130_fd_pr__nfet_01v8 W=1.0u L=0.15u
Rrnl2_28_2 mnl2_28_2 cnl2_2 351987.4062
XTnl2_28_3 vout1_28 gate_l2 mnl2_28_3 0 sky130_fd_pr__nfet_01v8 W=1.0u L=0.15u
Rrnl2_28_3 mnl2_28_3 cnl2_3 57140.2344
XTnl2_28_4 vout1_28 gate_l2 mnl2_28_4 0 sky130_fd_pr__nfet_01v8 W=1.0u L=0.15u
Rrnl2_28_4 mnl2_28_4 cnl2_4 3378378.2500
XTnl2_29_0 vout1_29 gate_l2 mnl2_29_0 0 sky130_fd_pr__nfet_01v8 W=1.0u L=0.15u
Rrnl2_29_0 mnl2_29_0 cnl2_0 3378378.2500
XTnl2_29_1 vout1_29 gate_l2 mnl2_29_1 0 sky130_fd_pr__nfet_01v8 W=1.0u L=0.15u
Rrnl2_29_1 mnl2_29_1 cnl2_1 39922.4180
XTnl2_29_2 vout1_29 gate_l2 mnl2_29_2 0 sky130_fd_pr__nfet_01v8 W=1.0u L=0.15u
Rrnl2_29_2 mnl2_29_2 cnl2_2 3378378.2500
XTnl2_29_3 vout1_29 gate_l2 mnl2_29_3 0 sky130_fd_pr__nfet_01v8 W=1.0u L=0.15u
Rrnl2_29_3 mnl2_29_3 cnl2_3 1484446.2500
XTnl2_29_4 vout1_29 gate_l2 mnl2_29_4 0 sky130_fd_pr__nfet_01v8 W=1.0u L=0.15u
Rrnl2_29_4 mnl2_29_4 cnl2_4 32402.1094
XTnl2_30_0 vout1_30 gate_l2 mnl2_30_0 0 sky130_fd_pr__nfet_01v8 W=1.0u L=0.15u
Rrnl2_30_0 mnl2_30_0 cnl2_0 185252.8281
XTnl2_30_1 vout1_30 gate_l2 mnl2_30_1 0 sky130_fd_pr__nfet_01v8 W=1.0u L=0.15u
Rrnl2_30_1 mnl2_30_1 cnl2_1 3378378.2500
XTnl2_30_2 vout1_30 gate_l2 mnl2_30_2 0 sky130_fd_pr__nfet_01v8 W=1.0u L=0.15u
Rrnl2_30_2 mnl2_30_2 cnl2_2 3378378.2500
XTnl2_30_3 vout1_30 gate_l2 mnl2_30_3 0 sky130_fd_pr__nfet_01v8 W=1.0u L=0.15u
Rrnl2_30_3 mnl2_30_3 cnl2_3 32272.8730
XTnl2_30_4 vout1_30 gate_l2 mnl2_30_4 0 sky130_fd_pr__nfet_01v8 W=1.0u L=0.15u
Rrnl2_30_4 mnl2_30_4 cnl2_4 28311.9355
XTnl2_31_0 vout1_31 gate_l2 mnl2_31_0 0 sky130_fd_pr__nfet_01v8 W=1.0u L=0.15u
Rrnl2_31_0 mnl2_31_0 cnl2_0 3378378.2500
XTnl2_31_1 vout1_31 gate_l2 mnl2_31_1 0 sky130_fd_pr__nfet_01v8 W=1.0u L=0.15u
Rrnl2_31_1 mnl2_31_1 cnl2_1 3378378.2500
XTnl2_31_2 vout1_31 gate_l2 mnl2_31_2 0 sky130_fd_pr__nfet_01v8 W=1.0u L=0.15u
Rrnl2_31_2 mnl2_31_2 cnl2_2 20053.7910
XTnl2_31_3 vout1_31 gate_l2 mnl2_31_3 0 sky130_fd_pr__nfet_01v8 W=1.0u L=0.15u
Rrnl2_31_3 mnl2_31_3 cnl2_3 45285.5195
XTnl2_31_4 vout1_31 gate_l2 mnl2_31_4 0 sky130_fd_pr__nfet_01v8 W=1.0u L=0.15u
Rrnl2_31_4 mnl2_31_4 cnl2_4 143855.6250
XTnl2_32_0 vout1_32 gate_l2 mnl2_32_0 0 sky130_fd_pr__nfet_01v8 W=1.0u L=0.15u
Rrnl2_32_0 mnl2_32_0 cnl2_0 3378378.2500
XTnl2_32_1 vout1_32 gate_l2 mnl2_32_1 0 sky130_fd_pr__nfet_01v8 W=1.0u L=0.15u
Rrnl2_32_1 mnl2_32_1 cnl2_1 3378378.2500
XTnl2_32_2 vout1_32 gate_l2 mnl2_32_2 0 sky130_fd_pr__nfet_01v8 W=1.0u L=0.15u
Rrnl2_32_2 mnl2_32_2 cnl2_2 31497.3125
XTnl2_32_3 vout1_32 gate_l2 mnl2_32_3 0 sky130_fd_pr__nfet_01v8 W=1.0u L=0.15u
Rrnl2_32_3 mnl2_32_3 cnl2_3 73941.6797
XTnl2_32_4 vout1_32 gate_l2 mnl2_32_4 0 sky130_fd_pr__nfet_01v8 W=1.0u L=0.15u
Rrnl2_32_4 mnl2_32_4 cnl2_4 90183.4062
XTnl2_33_0 vout1_33 gate_l2 mnl2_33_0 0 sky130_fd_pr__nfet_01v8 W=1.0u L=0.15u
Rrnl2_33_0 mnl2_33_0 cnl2_0 43248.9766
XTnl2_33_1 vout1_33 gate_l2 mnl2_33_1 0 sky130_fd_pr__nfet_01v8 W=1.0u L=0.15u
Rrnl2_33_1 mnl2_33_1 cnl2_1 3378378.2500
XTnl2_33_2 vout1_33 gate_l2 mnl2_33_2 0 sky130_fd_pr__nfet_01v8 W=1.0u L=0.15u
Rrnl2_33_2 mnl2_33_2 cnl2_2 3378378.2500
XTnl2_33_3 vout1_33 gate_l2 mnl2_33_3 0 sky130_fd_pr__nfet_01v8 W=1.0u L=0.15u
Rrnl2_33_3 mnl2_33_3 cnl2_3 348587.7500
XTnl2_33_4 vout1_33 gate_l2 mnl2_33_4 0 sky130_fd_pr__nfet_01v8 W=1.0u L=0.15u
Rrnl2_33_4 mnl2_33_4 cnl2_4 3378378.2500
XTnl2_34_0 vout1_34 gate_l2 mnl2_34_0 0 sky130_fd_pr__nfet_01v8 W=1.0u L=0.15u
Rrnl2_34_0 mnl2_34_0 cnl2_0 3378378.2500
XTnl2_34_1 vout1_34 gate_l2 mnl2_34_1 0 sky130_fd_pr__nfet_01v8 W=1.0u L=0.15u
Rrnl2_34_1 mnl2_34_1 cnl2_1 3378378.2500
XTnl2_34_2 vout1_34 gate_l2 mnl2_34_2 0 sky130_fd_pr__nfet_01v8 W=1.0u L=0.15u
Rrnl2_34_2 mnl2_34_2 cnl2_2 42632.8047
XTnl2_34_3 vout1_34 gate_l2 mnl2_34_3 0 sky130_fd_pr__nfet_01v8 W=1.0u L=0.15u
Rrnl2_34_3 mnl2_34_3 cnl2_3 3378378.2500
XTnl2_34_4 vout1_34 gate_l2 mnl2_34_4 0 sky130_fd_pr__nfet_01v8 W=1.0u L=0.15u
Rrnl2_34_4 mnl2_34_4 cnl2_4 58687.7031
XTnl2_35_0 vout1_35 gate_l2 mnl2_35_0 0 sky130_fd_pr__nfet_01v8 W=1.0u L=0.15u
Rrnl2_35_0 mnl2_35_0 cnl2_0 3378378.2500
XTnl2_35_1 vout1_35 gate_l2 mnl2_35_1 0 sky130_fd_pr__nfet_01v8 W=1.0u L=0.15u
Rrnl2_35_1 mnl2_35_1 cnl2_1 29099.1621
XTnl2_35_2 vout1_35 gate_l2 mnl2_35_2 0 sky130_fd_pr__nfet_01v8 W=1.0u L=0.15u
Rrnl2_35_2 mnl2_35_2 cnl2_2 273085.1875
XTnl2_35_3 vout1_35 gate_l2 mnl2_35_3 0 sky130_fd_pr__nfet_01v8 W=1.0u L=0.15u
Rrnl2_35_3 mnl2_35_3 cnl2_3 45948.9531
XTnl2_35_4 vout1_35 gate_l2 mnl2_35_4 0 sky130_fd_pr__nfet_01v8 W=1.0u L=0.15u
Rrnl2_35_4 mnl2_35_4 cnl2_4 446801.6875
XTnl2_36_0 vout1_36 gate_l2 mnl2_36_0 0 sky130_fd_pr__nfet_01v8 W=1.0u L=0.15u
Rrnl2_36_0 mnl2_36_0 cnl2_0 39033.5508
XTnl2_36_1 vout1_36 gate_l2 mnl2_36_1 0 sky130_fd_pr__nfet_01v8 W=1.0u L=0.15u
Rrnl2_36_1 mnl2_36_1 cnl2_1 3378378.2500
XTnl2_36_2 vout1_36 gate_l2 mnl2_36_2 0 sky130_fd_pr__nfet_01v8 W=1.0u L=0.15u
Rrnl2_36_2 mnl2_36_2 cnl2_2 3378378.2500
XTnl2_36_3 vout1_36 gate_l2 mnl2_36_3 0 sky130_fd_pr__nfet_01v8 W=1.0u L=0.15u
Rrnl2_36_3 mnl2_36_3 cnl2_3 1915994.8750
XTnl2_36_4 vout1_36 gate_l2 mnl2_36_4 0 sky130_fd_pr__nfet_01v8 W=1.0u L=0.15u
Rrnl2_36_4 mnl2_36_4 cnl2_4 3378378.2500
XTnl2_37_0 vout1_37 gate_l2 mnl2_37_0 0 sky130_fd_pr__nfet_01v8 W=1.0u L=0.15u
Rrnl2_37_0 mnl2_37_0 cnl2_0 3378378.2500
XTnl2_37_1 vout1_37 gate_l2 mnl2_37_1 0 sky130_fd_pr__nfet_01v8 W=1.0u L=0.15u
Rrnl2_37_1 mnl2_37_1 cnl2_1 129199.1875
XTnl2_37_2 vout1_37 gate_l2 mnl2_37_2 0 sky130_fd_pr__nfet_01v8 W=1.0u L=0.15u
Rrnl2_37_2 mnl2_37_2 cnl2_2 109116.4609
XTnl2_37_3 vout1_37 gate_l2 mnl2_37_3 0 sky130_fd_pr__nfet_01v8 W=1.0u L=0.15u
Rrnl2_37_3 mnl2_37_3 cnl2_3 291894.4688
XTnl2_37_4 vout1_37 gate_l2 mnl2_37_4 0 sky130_fd_pr__nfet_01v8 W=1.0u L=0.15u
Rrnl2_37_4 mnl2_37_4 cnl2_4 107727.1016
XTnl2_38_0 vout1_38 gate_l2 mnl2_38_0 0 sky130_fd_pr__nfet_01v8 W=1.0u L=0.15u
Rrnl2_38_0 mnl2_38_0 cnl2_0 3378378.2500
XTnl2_38_1 vout1_38 gate_l2 mnl2_38_1 0 sky130_fd_pr__nfet_01v8 W=1.0u L=0.15u
Rrnl2_38_1 mnl2_38_1 cnl2_1 3378378.2500
XTnl2_38_2 vout1_38 gate_l2 mnl2_38_2 0 sky130_fd_pr__nfet_01v8 W=1.0u L=0.15u
Rrnl2_38_2 mnl2_38_2 cnl2_2 62219.6680
XTnl2_38_3 vout1_38 gate_l2 mnl2_38_3 0 sky130_fd_pr__nfet_01v8 W=1.0u L=0.15u
Rrnl2_38_3 mnl2_38_3 cnl2_3 60988.5117
XTnl2_38_4 vout1_38 gate_l2 mnl2_38_4 0 sky130_fd_pr__nfet_01v8 W=1.0u L=0.15u
Rrnl2_38_4 mnl2_38_4 cnl2_4 95692.9531
XTnl2_39_0 vout1_39 gate_l2 mnl2_39_0 0 sky130_fd_pr__nfet_01v8 W=1.0u L=0.15u
Rrnl2_39_0 mnl2_39_0 cnl2_0 3378378.2500
XTnl2_39_1 vout1_39 gate_l2 mnl2_39_1 0 sky130_fd_pr__nfet_01v8 W=1.0u L=0.15u
Rrnl2_39_1 mnl2_39_1 cnl2_1 33242.4336
XTnl2_39_2 vout1_39 gate_l2 mnl2_39_2 0 sky130_fd_pr__nfet_01v8 W=1.0u L=0.15u
Rrnl2_39_2 mnl2_39_2 cnl2_2 149659.8750
XTnl2_39_3 vout1_39 gate_l2 mnl2_39_3 0 sky130_fd_pr__nfet_01v8 W=1.0u L=0.15u
Rrnl2_39_3 mnl2_39_3 cnl2_3 3378378.2500
XTnl2_39_4 vout1_39 gate_l2 mnl2_39_4 0 sky130_fd_pr__nfet_01v8 W=1.0u L=0.15u
Rrnl2_39_4 mnl2_39_4 cnl2_4 259727.4375
XTnl2_40_0 vout1_40 gate_l2 mnl2_40_0 0 sky130_fd_pr__nfet_01v8 W=1.0u L=0.15u
Rrnl2_40_0 mnl2_40_0 cnl2_0 318456.6875
XTnl2_40_1 vout1_40 gate_l2 mnl2_40_1 0 sky130_fd_pr__nfet_01v8 W=1.0u L=0.15u
Rrnl2_40_1 mnl2_40_1 cnl2_1 3378378.2500
XTnl2_40_2 vout1_40 gate_l2 mnl2_40_2 0 sky130_fd_pr__nfet_01v8 W=1.0u L=0.15u
Rrnl2_40_2 mnl2_40_2 cnl2_2 52634.1836
XTnl2_40_3 vout1_40 gate_l2 mnl2_40_3 0 sky130_fd_pr__nfet_01v8 W=1.0u L=0.15u
Rrnl2_40_3 mnl2_40_3 cnl2_3 48994.4414
XTnl2_40_4 vout1_40 gate_l2 mnl2_40_4 0 sky130_fd_pr__nfet_01v8 W=1.0u L=0.15u
Rrnl2_40_4 mnl2_40_4 cnl2_4 12902.5312
XTnl2_41_0 vout1_41 gate_l2 mnl2_41_0 0 sky130_fd_pr__nfet_01v8 W=1.0u L=0.15u
Rrnl2_41_0 mnl2_41_0 cnl2_0 35972.5391
XTnl2_41_1 vout1_41 gate_l2 mnl2_41_1 0 sky130_fd_pr__nfet_01v8 W=1.0u L=0.15u
Rrnl2_41_1 mnl2_41_1 cnl2_1 3378378.2500
XTnl2_41_2 vout1_41 gate_l2 mnl2_41_2 0 sky130_fd_pr__nfet_01v8 W=1.0u L=0.15u
Rrnl2_41_2 mnl2_41_2 cnl2_2 3378378.2500
XTnl2_41_3 vout1_41 gate_l2 mnl2_41_3 0 sky130_fd_pr__nfet_01v8 W=1.0u L=0.15u
Rrnl2_41_3 mnl2_41_3 cnl2_3 142928.9531
XTnl2_41_4 vout1_41 gate_l2 mnl2_41_4 0 sky130_fd_pr__nfet_01v8 W=1.0u L=0.15u
Rrnl2_41_4 mnl2_41_4 cnl2_4 117476.6094
XTnl2_42_0 vout1_42 gate_l2 mnl2_42_0 0 sky130_fd_pr__nfet_01v8 W=1.0u L=0.15u
Rrnl2_42_0 mnl2_42_0 cnl2_0 841603.9375
XTnl2_42_1 vout1_42 gate_l2 mnl2_42_1 0 sky130_fd_pr__nfet_01v8 W=1.0u L=0.15u
Rrnl2_42_1 mnl2_42_1 cnl2_1 3378378.2500
XTnl2_42_2 vout1_42 gate_l2 mnl2_42_2 0 sky130_fd_pr__nfet_01v8 W=1.0u L=0.15u
Rrnl2_42_2 mnl2_42_2 cnl2_2 41452.1680
XTnl2_42_3 vout1_42 gate_l2 mnl2_42_3 0 sky130_fd_pr__nfet_01v8 W=1.0u L=0.15u
Rrnl2_42_3 mnl2_42_3 cnl2_3 3378378.2500
XTnl2_42_4 vout1_42 gate_l2 mnl2_42_4 0 sky130_fd_pr__nfet_01v8 W=1.0u L=0.15u
Rrnl2_42_4 mnl2_42_4 cnl2_4 800880.1875
XTnl2_43_0 vout1_43 gate_l2 mnl2_43_0 0 sky130_fd_pr__nfet_01v8 W=1.0u L=0.15u
Rrnl2_43_0 mnl2_43_0 cnl2_0 3378378.2500
XTnl2_43_1 vout1_43 gate_l2 mnl2_43_1 0 sky130_fd_pr__nfet_01v8 W=1.0u L=0.15u
Rrnl2_43_1 mnl2_43_1 cnl2_1 54233.8555
XTnl2_43_2 vout1_43 gate_l2 mnl2_43_2 0 sky130_fd_pr__nfet_01v8 W=1.0u L=0.15u
Rrnl2_43_2 mnl2_43_2 cnl2_2 199006.5156
XTnl2_43_3 vout1_43 gate_l2 mnl2_43_3 0 sky130_fd_pr__nfet_01v8 W=1.0u L=0.15u
Rrnl2_43_3 mnl2_43_3 cnl2_3 47463.6484
XTnl2_43_4 vout1_43 gate_l2 mnl2_43_4 0 sky130_fd_pr__nfet_01v8 W=1.0u L=0.15u
Rrnl2_43_4 mnl2_43_4 cnl2_4 210435.5625
XTnl2_44_0 vout1_44 gate_l2 mnl2_44_0 0 sky130_fd_pr__nfet_01v8 W=1.0u L=0.15u
Rrnl2_44_0 mnl2_44_0 cnl2_0 402762.6562
XTnl2_44_1 vout1_44 gate_l2 mnl2_44_1 0 sky130_fd_pr__nfet_01v8 W=1.0u L=0.15u
Rrnl2_44_1 mnl2_44_1 cnl2_1 401734.4688
XTnl2_44_2 vout1_44 gate_l2 mnl2_44_2 0 sky130_fd_pr__nfet_01v8 W=1.0u L=0.15u
Rrnl2_44_2 mnl2_44_2 cnl2_2 3378378.2500
XTnl2_44_3 vout1_44 gate_l2 mnl2_44_3 0 sky130_fd_pr__nfet_01v8 W=1.0u L=0.15u
Rrnl2_44_3 mnl2_44_3 cnl2_3 189266.2969
XTnl2_44_4 vout1_44 gate_l2 mnl2_44_4 0 sky130_fd_pr__nfet_01v8 W=1.0u L=0.15u
Rrnl2_44_4 mnl2_44_4 cnl2_4 36393.9492
XTnl2_45_0 vout1_45 gate_l2 mnl2_45_0 0 sky130_fd_pr__nfet_01v8 W=1.0u L=0.15u
Rrnl2_45_0 mnl2_45_0 cnl2_0 3378378.2500
XTnl2_45_1 vout1_45 gate_l2 mnl2_45_1 0 sky130_fd_pr__nfet_01v8 W=1.0u L=0.15u
Rrnl2_45_1 mnl2_45_1 cnl2_1 24800.3809
XTnl2_45_2 vout1_45 gate_l2 mnl2_45_2 0 sky130_fd_pr__nfet_01v8 W=1.0u L=0.15u
Rrnl2_45_2 mnl2_45_2 cnl2_2 3378378.2500
XTnl2_45_3 vout1_45 gate_l2 mnl2_45_3 0 sky130_fd_pr__nfet_01v8 W=1.0u L=0.15u
Rrnl2_45_3 mnl2_45_3 cnl2_3 48448.4258
XTnl2_45_4 vout1_45 gate_l2 mnl2_45_4 0 sky130_fd_pr__nfet_01v8 W=1.0u L=0.15u
Rrnl2_45_4 mnl2_45_4 cnl2_4 3378378.2500
XTnl2_46_0 vout1_46 gate_l2 mnl2_46_0 0 sky130_fd_pr__nfet_01v8 W=1.0u L=0.15u
Rrnl2_46_0 mnl2_46_0 cnl2_0 167782.8906
XTnl2_46_1 vout1_46 gate_l2 mnl2_46_1 0 sky130_fd_pr__nfet_01v8 W=1.0u L=0.15u
Rrnl2_46_1 mnl2_46_1 cnl2_1 39221.6523
XTnl2_46_2 vout1_46 gate_l2 mnl2_46_2 0 sky130_fd_pr__nfet_01v8 W=1.0u L=0.15u
Rrnl2_46_2 mnl2_46_2 cnl2_2 3378378.2500
XTnl2_46_3 vout1_46 gate_l2 mnl2_46_3 0 sky130_fd_pr__nfet_01v8 W=1.0u L=0.15u
Rrnl2_46_3 mnl2_46_3 cnl2_3 3378378.2500
XTnl2_46_4 vout1_46 gate_l2 mnl2_46_4 0 sky130_fd_pr__nfet_01v8 W=1.0u L=0.15u
Rrnl2_46_4 mnl2_46_4 cnl2_4 1025705.0625
XTnl2_47_0 vout1_47 gate_l2 mnl2_47_0 0 sky130_fd_pr__nfet_01v8 W=1.0u L=0.15u
Rrnl2_47_0 mnl2_47_0 cnl2_0 64803.6445
XTnl2_47_1 vout1_47 gate_l2 mnl2_47_1 0 sky130_fd_pr__nfet_01v8 W=1.0u L=0.15u
Rrnl2_47_1 mnl2_47_1 cnl2_1 3378378.2500
XTnl2_47_2 vout1_47 gate_l2 mnl2_47_2 0 sky130_fd_pr__nfet_01v8 W=1.0u L=0.15u
Rrnl2_47_2 mnl2_47_2 cnl2_2 3378378.2500
XTnl2_47_3 vout1_47 gate_l2 mnl2_47_3 0 sky130_fd_pr__nfet_01v8 W=1.0u L=0.15u
Rrnl2_47_3 mnl2_47_3 cnl2_3 39011.2461
XTnl2_47_4 vout1_47 gate_l2 mnl2_47_4 0 sky130_fd_pr__nfet_01v8 W=1.0u L=0.15u
Rrnl2_47_4 mnl2_47_4 cnl2_4 3378378.2500
XTnl2_48_0 vout1_48 gate_l2 mnl2_48_0 0 sky130_fd_pr__nfet_01v8 W=1.0u L=0.15u
Rrnl2_48_0 mnl2_48_0 cnl2_0 138878.7344
XTnl2_48_1 vout1_48 gate_l2 mnl2_48_1 0 sky130_fd_pr__nfet_01v8 W=1.0u L=0.15u
Rrnl2_48_1 mnl2_48_1 cnl2_1 3378378.2500
XTnl2_48_2 vout1_48 gate_l2 mnl2_48_2 0 sky130_fd_pr__nfet_01v8 W=1.0u L=0.15u
Rrnl2_48_2 mnl2_48_2 cnl2_2 78326.3516
XTnl2_48_3 vout1_48 gate_l2 mnl2_48_3 0 sky130_fd_pr__nfet_01v8 W=1.0u L=0.15u
Rrnl2_48_3 mnl2_48_3 cnl2_3 3378378.2500
XTnl2_48_4 vout1_48 gate_l2 mnl2_48_4 0 sky130_fd_pr__nfet_01v8 W=1.0u L=0.15u
Rrnl2_48_4 mnl2_48_4 cnl2_4 3378378.2500
XTnl2_49_0 vout1_49 gate_l2 mnl2_49_0 0 sky130_fd_pr__nfet_01v8 W=1.0u L=0.15u
Rrnl2_49_0 mnl2_49_0 cnl2_0 3378378.2500
XTnl2_49_1 vout1_49 gate_l2 mnl2_49_1 0 sky130_fd_pr__nfet_01v8 W=1.0u L=0.15u
Rrnl2_49_1 mnl2_49_1 cnl2_1 555447.5625
XTnl2_49_2 vout1_49 gate_l2 mnl2_49_2 0 sky130_fd_pr__nfet_01v8 W=1.0u L=0.15u
Rrnl2_49_2 mnl2_49_2 cnl2_2 3378378.2500
XTnl2_49_3 vout1_49 gate_l2 mnl2_49_3 0 sky130_fd_pr__nfet_01v8 W=1.0u L=0.15u
Rrnl2_49_3 mnl2_49_3 cnl2_3 34614.3359
XTnl2_49_4 vout1_49 gate_l2 mnl2_49_4 0 sky130_fd_pr__nfet_01v8 W=1.0u L=0.15u
Rrnl2_49_4 mnl2_49_4 cnl2_4 17005.0293
XTnl2_50_0 vout1_50 gate_l2 mnl2_50_0 0 sky130_fd_pr__nfet_01v8 W=1.0u L=0.15u
Rrnl2_50_0 mnl2_50_0 cnl2_0 3378378.2500
XTnl2_50_1 vout1_50 gate_l2 mnl2_50_1 0 sky130_fd_pr__nfet_01v8 W=1.0u L=0.15u
Rrnl2_50_1 mnl2_50_1 cnl2_1 24454.1348
XTnl2_50_2 vout1_50 gate_l2 mnl2_50_2 0 sky130_fd_pr__nfet_01v8 W=1.0u L=0.15u
Rrnl2_50_2 mnl2_50_2 cnl2_2 3378378.2500
XTnl2_50_3 vout1_50 gate_l2 mnl2_50_3 0 sky130_fd_pr__nfet_01v8 W=1.0u L=0.15u
Rrnl2_50_3 mnl2_50_3 cnl2_3 3378378.2500
XTnl2_50_4 vout1_50 gate_l2 mnl2_50_4 0 sky130_fd_pr__nfet_01v8 W=1.0u L=0.15u
Rrnl2_50_4 mnl2_50_4 cnl2_4 112222.0156
XTnl2_51_0 vout1_51 gate_l2 mnl2_51_0 0 sky130_fd_pr__nfet_01v8 W=1.0u L=0.15u
Rrnl2_51_0 mnl2_51_0 cnl2_0 3378378.2500
XTnl2_51_1 vout1_51 gate_l2 mnl2_51_1 0 sky130_fd_pr__nfet_01v8 W=1.0u L=0.15u
Rrnl2_51_1 mnl2_51_1 cnl2_1 84567.6172
XTnl2_51_2 vout1_51 gate_l2 mnl2_51_2 0 sky130_fd_pr__nfet_01v8 W=1.0u L=0.15u
Rrnl2_51_2 mnl2_51_2 cnl2_2 45674.8867
XTnl2_51_3 vout1_51 gate_l2 mnl2_51_3 0 sky130_fd_pr__nfet_01v8 W=1.0u L=0.15u
Rrnl2_51_3 mnl2_51_3 cnl2_3 36118.8516
XTnl2_51_4 vout1_51 gate_l2 mnl2_51_4 0 sky130_fd_pr__nfet_01v8 W=1.0u L=0.15u
Rrnl2_51_4 mnl2_51_4 cnl2_4 39088.9727
XTnl2_52_0 vout1_52 gate_l2 mnl2_52_0 0 sky130_fd_pr__nfet_01v8 W=1.0u L=0.15u
Rrnl2_52_0 mnl2_52_0 cnl2_0 3378378.2500
XTnl2_52_1 vout1_52 gate_l2 mnl2_52_1 0 sky130_fd_pr__nfet_01v8 W=1.0u L=0.15u
Rrnl2_52_1 mnl2_52_1 cnl2_1 3378378.2500
XTnl2_52_2 vout1_52 gate_l2 mnl2_52_2 0 sky130_fd_pr__nfet_01v8 W=1.0u L=0.15u
Rrnl2_52_2 mnl2_52_2 cnl2_2 28732.0391
XTnl2_52_3 vout1_52 gate_l2 mnl2_52_3 0 sky130_fd_pr__nfet_01v8 W=1.0u L=0.15u
Rrnl2_52_3 mnl2_52_3 cnl2_3 58749.2695
XTnl2_52_4 vout1_52 gate_l2 mnl2_52_4 0 sky130_fd_pr__nfet_01v8 W=1.0u L=0.15u
Rrnl2_52_4 mnl2_52_4 cnl2_4 14667.4209
XTnl2_53_0 vout1_53 gate_l2 mnl2_53_0 0 sky130_fd_pr__nfet_01v8 W=1.0u L=0.15u
Rrnl2_53_0 mnl2_53_0 cnl2_0 50894.9102
XTnl2_53_1 vout1_53 gate_l2 mnl2_53_1 0 sky130_fd_pr__nfet_01v8 W=1.0u L=0.15u
Rrnl2_53_1 mnl2_53_1 cnl2_1 3378378.2500
XTnl2_53_2 vout1_53 gate_l2 mnl2_53_2 0 sky130_fd_pr__nfet_01v8 W=1.0u L=0.15u
Rrnl2_53_2 mnl2_53_2 cnl2_2 3378378.2500
XTnl2_53_3 vout1_53 gate_l2 mnl2_53_3 0 sky130_fd_pr__nfet_01v8 W=1.0u L=0.15u
Rrnl2_53_3 mnl2_53_3 cnl2_3 89854.4453
XTnl2_53_4 vout1_53 gate_l2 mnl2_53_4 0 sky130_fd_pr__nfet_01v8 W=1.0u L=0.15u
Rrnl2_53_4 mnl2_53_4 cnl2_4 241863.0625
XTnl2_54_0 vout1_54 gate_l2 mnl2_54_0 0 sky130_fd_pr__nfet_01v8 W=1.0u L=0.15u
Rrnl2_54_0 mnl2_54_0 cnl2_0 3378378.2500
XTnl2_54_1 vout1_54 gate_l2 mnl2_54_1 0 sky130_fd_pr__nfet_01v8 W=1.0u L=0.15u
Rrnl2_54_1 mnl2_54_1 cnl2_1 3378378.2500
XTnl2_54_2 vout1_54 gate_l2 mnl2_54_2 0 sky130_fd_pr__nfet_01v8 W=1.0u L=0.15u
Rrnl2_54_2 mnl2_54_2 cnl2_2 85429.5000
XTnl2_54_3 vout1_54 gate_l2 mnl2_54_3 0 sky130_fd_pr__nfet_01v8 W=1.0u L=0.15u
Rrnl2_54_3 mnl2_54_3 cnl2_3 511176.7500
XTnl2_54_4 vout1_54 gate_l2 mnl2_54_4 0 sky130_fd_pr__nfet_01v8 W=1.0u L=0.15u
Rrnl2_54_4 mnl2_54_4 cnl2_4 3378378.2500
XTnl2_55_0 vout1_55 gate_l2 mnl2_55_0 0 sky130_fd_pr__nfet_01v8 W=1.0u L=0.15u
Rrnl2_55_0 mnl2_55_0 cnl2_0 85801.8672
XTnl2_55_1 vout1_55 gate_l2 mnl2_55_1 0 sky130_fd_pr__nfet_01v8 W=1.0u L=0.15u
Rrnl2_55_1 mnl2_55_1 cnl2_1 85723.4531
XTnl2_55_2 vout1_55 gate_l2 mnl2_55_2 0 sky130_fd_pr__nfet_01v8 W=1.0u L=0.15u
Rrnl2_55_2 mnl2_55_2 cnl2_2 3378378.2500
XTnl2_55_3 vout1_55 gate_l2 mnl2_55_3 0 sky130_fd_pr__nfet_01v8 W=1.0u L=0.15u
Rrnl2_55_3 mnl2_55_3 cnl2_3 3378378.2500
XTnl2_55_4 vout1_55 gate_l2 mnl2_55_4 0 sky130_fd_pr__nfet_01v8 W=1.0u L=0.15u
Rrnl2_55_4 mnl2_55_4 cnl2_4 18488.7305
XTnl2_56_0 vout1_56 gate_l2 mnl2_56_0 0 sky130_fd_pr__nfet_01v8 W=1.0u L=0.15u
Rrnl2_56_0 mnl2_56_0 cnl2_0 26037.7012
XTnl2_56_1 vout1_56 gate_l2 mnl2_56_1 0 sky130_fd_pr__nfet_01v8 W=1.0u L=0.15u
Rrnl2_56_1 mnl2_56_1 cnl2_1 86132.7656
XTnl2_56_2 vout1_56 gate_l2 mnl2_56_2 0 sky130_fd_pr__nfet_01v8 W=1.0u L=0.15u
Rrnl2_56_2 mnl2_56_2 cnl2_2 3378378.2500
XTnl2_56_3 vout1_56 gate_l2 mnl2_56_3 0 sky130_fd_pr__nfet_01v8 W=1.0u L=0.15u
Rrnl2_56_3 mnl2_56_3 cnl2_3 3378378.2500
XTnl2_56_4 vout1_56 gate_l2 mnl2_56_4 0 sky130_fd_pr__nfet_01v8 W=1.0u L=0.15u
Rrnl2_56_4 mnl2_56_4 cnl2_4 3378378.2500
XTnl2_57_0 vout1_57 gate_l2 mnl2_57_0 0 sky130_fd_pr__nfet_01v8 W=1.0u L=0.15u
Rrnl2_57_0 mnl2_57_0 cnl2_0 3378378.2500
XTnl2_57_1 vout1_57 gate_l2 mnl2_57_1 0 sky130_fd_pr__nfet_01v8 W=1.0u L=0.15u
Rrnl2_57_1 mnl2_57_1 cnl2_1 42832.6133
XTnl2_57_2 vout1_57 gate_l2 mnl2_57_2 0 sky130_fd_pr__nfet_01v8 W=1.0u L=0.15u
Rrnl2_57_2 mnl2_57_2 cnl2_2 3378378.2500
XTnl2_57_3 vout1_57 gate_l2 mnl2_57_3 0 sky130_fd_pr__nfet_01v8 W=1.0u L=0.15u
Rrnl2_57_3 mnl2_57_3 cnl2_3 25764.4570
XTnl2_57_4 vout1_57 gate_l2 mnl2_57_4 0 sky130_fd_pr__nfet_01v8 W=1.0u L=0.15u
Rrnl2_57_4 mnl2_57_4 cnl2_4 3378378.2500
XTnl2_58_0 vout1_58 gate_l2 mnl2_58_0 0 sky130_fd_pr__nfet_01v8 W=1.0u L=0.15u
Rrnl2_58_0 mnl2_58_0 cnl2_0 251763.7656
XTnl2_58_1 vout1_58 gate_l2 mnl2_58_1 0 sky130_fd_pr__nfet_01v8 W=1.0u L=0.15u
Rrnl2_58_1 mnl2_58_1 cnl2_1 832815.5625
XTnl2_58_2 vout1_58 gate_l2 mnl2_58_2 0 sky130_fd_pr__nfet_01v8 W=1.0u L=0.15u
Rrnl2_58_2 mnl2_58_2 cnl2_2 3378378.2500
XTnl2_58_3 vout1_58 gate_l2 mnl2_58_3 0 sky130_fd_pr__nfet_01v8 W=1.0u L=0.15u
Rrnl2_58_3 mnl2_58_3 cnl2_3 3378378.2500
XTnl2_58_4 vout1_58 gate_l2 mnl2_58_4 0 sky130_fd_pr__nfet_01v8 W=1.0u L=0.15u
Rrnl2_58_4 mnl2_58_4 cnl2_4 32245.2480
XTnl2_59_0 vout1_59 gate_l2 mnl2_59_0 0 sky130_fd_pr__nfet_01v8 W=1.0u L=0.15u
Rrnl2_59_0 mnl2_59_0 cnl2_0 3378378.2500
XTnl2_59_1 vout1_59 gate_l2 mnl2_59_1 0 sky130_fd_pr__nfet_01v8 W=1.0u L=0.15u
Rrnl2_59_1 mnl2_59_1 cnl2_1 1055693.2500
XTnl2_59_2 vout1_59 gate_l2 mnl2_59_2 0 sky130_fd_pr__nfet_01v8 W=1.0u L=0.15u
Rrnl2_59_2 mnl2_59_2 cnl2_2 65886.8125
XTnl2_59_3 vout1_59 gate_l2 mnl2_59_3 0 sky130_fd_pr__nfet_01v8 W=1.0u L=0.15u
Rrnl2_59_3 mnl2_59_3 cnl2_3 1506111.0000
XTnl2_59_4 vout1_59 gate_l2 mnl2_59_4 0 sky130_fd_pr__nfet_01v8 W=1.0u L=0.15u
Rrnl2_59_4 mnl2_59_4 cnl2_4 23848.9082
XTnl2_60_0 vout1_60 gate_l2 mnl2_60_0 0 sky130_fd_pr__nfet_01v8 W=1.0u L=0.15u
Rrnl2_60_0 mnl2_60_0 cnl2_0 3378378.2500
XTnl2_60_1 vout1_60 gate_l2 mnl2_60_1 0 sky130_fd_pr__nfet_01v8 W=1.0u L=0.15u
Rrnl2_60_1 mnl2_60_1 cnl2_1 166362.7031
XTnl2_60_2 vout1_60 gate_l2 mnl2_60_2 0 sky130_fd_pr__nfet_01v8 W=1.0u L=0.15u
Rrnl2_60_2 mnl2_60_2 cnl2_2 38312.5000
XTnl2_60_3 vout1_60 gate_l2 mnl2_60_3 0 sky130_fd_pr__nfet_01v8 W=1.0u L=0.15u
Rrnl2_60_3 mnl2_60_3 cnl2_3 3378378.2500
XTnl2_60_4 vout1_60 gate_l2 mnl2_60_4 0 sky130_fd_pr__nfet_01v8 W=1.0u L=0.15u
Rrnl2_60_4 mnl2_60_4 cnl2_4 53659.1328
XTnl2_61_0 vout1_61 gate_l2 mnl2_61_0 0 sky130_fd_pr__nfet_01v8 W=1.0u L=0.15u
Rrnl2_61_0 mnl2_61_0 cnl2_0 406556.2188
XTnl2_61_1 vout1_61 gate_l2 mnl2_61_1 0 sky130_fd_pr__nfet_01v8 W=1.0u L=0.15u
Rrnl2_61_1 mnl2_61_1 cnl2_1 3378378.2500
XTnl2_61_2 vout1_61 gate_l2 mnl2_61_2 0 sky130_fd_pr__nfet_01v8 W=1.0u L=0.15u
Rrnl2_61_2 mnl2_61_2 cnl2_2 54653.6641
XTnl2_61_3 vout1_61 gate_l2 mnl2_61_3 0 sky130_fd_pr__nfet_01v8 W=1.0u L=0.15u
Rrnl2_61_3 mnl2_61_3 cnl2_3 59819.6914
XTnl2_61_4 vout1_61 gate_l2 mnl2_61_4 0 sky130_fd_pr__nfet_01v8 W=1.0u L=0.15u
Rrnl2_61_4 mnl2_61_4 cnl2_4 3378378.2500
XTnl2_62_0 vout1_62 gate_l2 mnl2_62_0 0 sky130_fd_pr__nfet_01v8 W=1.0u L=0.15u
Rrnl2_62_0 mnl2_62_0 cnl2_0 3378378.2500
XTnl2_62_1 vout1_62 gate_l2 mnl2_62_1 0 sky130_fd_pr__nfet_01v8 W=1.0u L=0.15u
Rrnl2_62_1 mnl2_62_1 cnl2_1 3378378.2500
XTnl2_62_2 vout1_62 gate_l2 mnl2_62_2 0 sky130_fd_pr__nfet_01v8 W=1.0u L=0.15u
Rrnl2_62_2 mnl2_62_2 cnl2_2 27824.2715
XTnl2_62_3 vout1_62 gate_l2 mnl2_62_3 0 sky130_fd_pr__nfet_01v8 W=1.0u L=0.15u
Rrnl2_62_3 mnl2_62_3 cnl2_3 1399651.5000
XTnl2_62_4 vout1_62 gate_l2 mnl2_62_4 0 sky130_fd_pr__nfet_01v8 W=1.0u L=0.15u
Rrnl2_62_4 mnl2_62_4 cnl2_4 181445.3438
XTnl2_63_0 vout1_63 gate_l2 mnl2_63_0 0 sky130_fd_pr__nfet_01v8 W=1.0u L=0.15u
Rrnl2_63_0 mnl2_63_0 cnl2_0 3378378.2500
XTnl2_63_1 vout1_63 gate_l2 mnl2_63_1 0 sky130_fd_pr__nfet_01v8 W=1.0u L=0.15u
Rrnl2_63_1 mnl2_63_1 cnl2_1 3378378.2500
XTnl2_63_2 vout1_63 gate_l2 mnl2_63_2 0 sky130_fd_pr__nfet_01v8 W=1.0u L=0.15u
Rrnl2_63_2 mnl2_63_2 cnl2_2 69317.7266
XTnl2_63_3 vout1_63 gate_l2 mnl2_63_3 0 sky130_fd_pr__nfet_01v8 W=1.0u L=0.15u
Rrnl2_63_3 mnl2_63_3 cnl2_3 50466.6953
XTnl2_63_4 vout1_63 gate_l2 mnl2_63_4 0 sky130_fd_pr__nfet_01v8 W=1.0u L=0.15u
Rrnl2_63_4 mnl2_63_4 cnl2_4 531337.1250

* --- Column current sensing (virtual ground) ---
Vspl2_0 cpl2_0 0 0
Vsnl2_0 cnl2_0 0 0
Vspl2_1 cpl2_1 0 0
Vsnl2_1 cnl2_1 0 0
Vspl2_2 cpl2_2 0 0
Vsnl2_2 cnl2_2 0 0
Vspl2_3 cpl2_3 0 0
Vsnl2_3 cnl2_3 0 0
Vspl2_4 cpl2_4 0 0
Vsnl2_4 cnl2_4 0 0

* ===== L2 CROSSBAR -> WTA CONNECTIONS =====
* CCCS transfers differential MAC current to WTA input nodes

Fmac2p_0 nwta_0 0 Vspl2_0 1.0
Fmac2n_0 0 nwta_0 Vsnl2_0 1.0
Fmac2p_1 nwta_1 0 Vspl2_1 1.0
Fmac2n_1 0 nwta_1 Vsnl2_1 1.0
Fmac2p_2 nwta_2 0 Vspl2_2 1.0
Fmac2n_2 0 nwta_2 Vsnl2_2 1.0
Fmac2p_3 nwta_3 0 Vspl2_3 1.0
Fmac2n_3 0 nwta_3 Vsnl2_3 1.0
Fmac2p_4 nwta_4 0 Vspl2_4 1.0
Fmac2n_4 0 nwta_4 Vsnl2_4 1.0

* ===== L2->WTA BIAS INJECTION (5 channels) =====

* --- Class N: b2=+0.2182, I_bias=+1.103uA ---
Ibr2_0 pbr2_0 0 1.102701e-06
Xbr2_0 pbr2_0 pbr2_0 vdd vdd sky130_fd_pr__pfet_01v8 W=2.0u L=0.5u
Xbm2_0 nwta_0 pbr2_0 vdd vdd sky130_fd_pr__pfet_01v8 W=2.0u L=0.5u

* --- Class S: b2=-0.4362, I_bias=-2.205uA ---
Ibr2_1 vdd nbr2_1 2.204724e-06
Xbr2_1 nbr2_1 nbr2_1 0 0 sky130_fd_pr__nfet_01v8 W=2.0u L=0.5u
Xbm2_1 nwta_1 nbr2_1 0 0 sky130_fd_pr__nfet_01v8 W=2.0u L=0.5u

* --- Class V: b2=+0.4409, I_bias=+2.228uA ---
Ibr2_2 pbr2_2 0 2.228454e-06
Xbr2_2 pbr2_2 pbr2_2 vdd vdd sky130_fd_pr__pfet_01v8 W=2.0u L=0.5u
Xbm2_2 nwta_2 pbr2_2 vdd vdd sky130_fd_pr__pfet_01v8 W=2.0u L=0.5u

* --- Class F: b2=-0.3110, I_bias=-1.572uA ---
Ibr2_3 vdd nbr2_3 1.572038e-06
Xbr2_3 nbr2_3 nbr2_3 0 0 sky130_fd_pr__nfet_01v8 W=2.0u L=0.5u
Xbm2_3 nwta_3 nbr2_3 0 0 sky130_fd_pr__nfet_01v8 W=2.0u L=0.5u

* --- Class Q: b2=-1.0853, I_bias=-5.486uA ---
Ibr2_4 vdd nbr2_4 5.485632e-06
Xbr2_4 nbr2_4 nbr2_4 0 0 sky130_fd_pr__nfet_01v8 W=2.0u L=0.5u
Xbm2_4 nwta_4 nbr2_4 0 0 sky130_fd_pr__nfet_01v8 W=2.0u L=0.5u

* ===== WINNER-TAKE-ALL: 5-Input Lazzaro WTA =====
Ibias_wta vdd nbias_wta 10u
Xbias_wta nbias_wta nbias_wta 0 0 sky130_fd_pr__nfet_01v8 W=2.0u L=0.5u

* Cell 0 (N)
Xwi0 wcomm0 nwta_0 0 0 sky130_fd_pr__nfet_01v8 W=2.0u L=0.5u
Xwf0 wcomm0 wcomm0 winhib 0 sky130_fd_pr__nfet_01v8 W=2.0u L=0.5u
Xwl0 out0 wcomm0 vdd vdd sky130_fd_pr__pfet_01v8 W=4.0u L=0.5u
Xwd0 out0 nbias_wta 0 0 sky130_fd_pr__nfet_01v8 W=1.0u L=0.5u

* Cell 1 (S)
Xwi1 wcomm1 nwta_1 0 0 sky130_fd_pr__nfet_01v8 W=2.0u L=0.5u
Xwf1 wcomm1 wcomm1 winhib 0 sky130_fd_pr__nfet_01v8 W=2.0u L=0.5u
Xwl1 out1 wcomm1 vdd vdd sky130_fd_pr__pfet_01v8 W=4.0u L=0.5u
Xwd1 out1 nbias_wta 0 0 sky130_fd_pr__nfet_01v8 W=1.0u L=0.5u

* Cell 2 (V)
Xwi2 wcomm2 nwta_2 0 0 sky130_fd_pr__nfet_01v8 W=2.0u L=0.5u
Xwf2 wcomm2 wcomm2 winhib 0 sky130_fd_pr__nfet_01v8 W=2.0u L=0.5u
Xwl2 out2 wcomm2 vdd vdd sky130_fd_pr__pfet_01v8 W=4.0u L=0.5u
Xwd2 out2 nbias_wta 0 0 sky130_fd_pr__nfet_01v8 W=1.0u L=0.5u

* Cell 3 (F)
Xwi3 wcomm3 nwta_3 0 0 sky130_fd_pr__nfet_01v8 W=2.0u L=0.5u
Xwf3 wcomm3 wcomm3 winhib 0 sky130_fd_pr__nfet_01v8 W=2.0u L=0.5u
Xwl3 out3 wcomm3 vdd vdd sky130_fd_pr__pfet_01v8 W=4.0u L=0.5u
Xwd3 out3 nbias_wta 0 0 sky130_fd_pr__nfet_01v8 W=1.0u L=0.5u

* Cell 4 (Q)
Xwi4 wcomm4 nwta_4 0 0 sky130_fd_pr__nfet_01v8 W=2.0u L=0.5u
Xwf4 wcomm4 wcomm4 winhib 0 sky130_fd_pr__nfet_01v8 W=2.0u L=0.5u
Xwl4 out4 wcomm4 vdd vdd sky130_fd_pr__pfet_01v8 W=4.0u L=0.5u
Xwd4 out4 nbias_wta 0 0 sky130_fd_pr__nfet_01v8 W=1.0u L=0.5u

Xwinh winhib nbias_wta 0 0 sky130_fd_pr__nfet_01v8 W=10.0u L=0.5u

* ===== ANALYSIS =====
.op

.control
run
print v(out0)
print v(out1)
print v(out2)
print v(out3)
print v(out4)
quit
.endc

.end
