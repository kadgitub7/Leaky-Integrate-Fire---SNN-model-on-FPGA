* =================================================================
* 5-Input Winner-Take-All (WTA) -- Analog Argmax
* Architecture: 8 -> 64 -> 5 MLP Classifier (output stage)
* Technology: SKY130 sky130_fd_pr__nfet_01v8 / sky130_fd_pr__pfet_01v8
* =================================================================
*
* This circuit takes 5 input currents (or voltages proportional to
* Layer 2 output scores) and produces a one-hot output indicating
* which input is largest -- the analog equivalent of argmax().
*
* Topology: Lazzaro current-mode WTA
*   - 5 NMOS input transistors share a common inhibitory node
*   - Current mirror bias sets the total current budget
*   - The cell with the largest input current wins the competition
*   - Winner draws most of the bias current; losers are suppressed
*
*   Vin_k ---[M_in_k]---+---[M_fb_k]--- Vout_k
*                       |
*                   common_inhibit
*                       |
*                   [M_bias] --- Ibias
*
* Inputs:  Vin0..Vin4 (class scores from Layer 2 crossbar + bias)
* Outputs: Vout0..Vout4 (winner is HIGH, losers are LOW)
* =================================================================

.include "C:/src/skywater-pdk-libs-sky130_fd_pr/cells/nfet_01v8/sky130_fd_pr__nfet_01v8__tt.corner.spice"
.include "C:/src/skywater-pdk-libs-sky130_fd_pr/cells/nfet_01v8/sky130_fd_pr__nfet_01v8__mismatch.corner.spice"
.include "C:/src/skywater-pdk-libs-sky130_fd_pr/cells/pfet_01v8/sky130_fd_pr__pfet_01v8__tt.corner.spice"
.include "C:/src/skywater-pdk-libs-sky130_fd_pr/cells/pfet_01v8/sky130_fd_pr__pfet_01v8__mismatch.corner.spice"

* --- PFET mismatch parameter fix (undefined in corner files) ---
.param sky130_fd_pr__pfet_01v8__a0_diff = 0
.param sky130_fd_pr__pfet_01v8__agidl_diff = 0
.param sky130_fd_pr__pfet_01v8__ags_diff = 0
.param sky130_fd_pr__pfet_01v8__b0_diff = 0
.param sky130_fd_pr__pfet_01v8__b1_diff = 0
.param sky130_fd_pr__pfet_01v8__bgidl_diff = 0
.param sky130_fd_pr__pfet_01v8__cgidl_diff = 0
.param sky130_fd_pr__pfet_01v8__dlc_diff = 0
.param sky130_fd_pr__pfet_01v8__dwc_diff = 0
.param sky130_fd_pr__pfet_01v8__eta0_diff = 0
.param sky130_fd_pr__pfet_01v8__k2_diff = 0
.param sky130_fd_pr__pfet_01v8__keta_diff = 0
.param sky130_fd_pr__pfet_01v8__kt1_diff = 0
.param sky130_fd_pr__pfet_01v8__ku0_diff = 0
.param sky130_fd_pr__pfet_01v8__kvsat_diff = 0
.param sky130_fd_pr__pfet_01v8__kvth0_diff = 0
.param sky130_fd_pr__pfet_01v8__lint_diff = 0
.param sky130_fd_pr__pfet_01v8__lku0_diff = 0
.param sky130_fd_pr__pfet_01v8__lkvth0_diff = 0
.param sky130_fd_pr__pfet_01v8__nfactor_diff = 0
.param sky130_fd_pr__pfet_01v8__pclm_diff = 0
.param sky130_fd_pr__pfet_01v8__pdits_diff = 0
.param sky130_fd_pr__pfet_01v8__pditsd_diff = 0
.param sky130_fd_pr__pfet_01v8__rdsw_diff = 0
.param sky130_fd_pr__pfet_01v8__tvoff_diff = 0
.param sky130_fd_pr__pfet_01v8__u0_diff = 0
.param sky130_fd_pr__pfet_01v8__ua_diff = 0
.param sky130_fd_pr__pfet_01v8__ub_diff = 0
.param sky130_fd_pr__pfet_01v8__voff_diff = 0
.param sky130_fd_pr__pfet_01v8__vsat_diff = 0
.param sky130_fd_pr__pfet_01v8__vth0_diff = 0
.param sky130_fd_pr__pfet_01v8__wint_diff = 0
.param sky130_fd_pr__pfet_01v8__wku0_diff = 0
.param sky130_fd_pr__pfet_01v8__wkvth0_diff = 0
.param sky130_fd_pr__pfet_01v8__wlod_diff = 0

* --- Supply ---
VDD vdd 0 1.8

* --- Bias current source (sets competition strength) ---
Ibias vdd nbias 10u
Xbias nbias nbias 0 0 sky130_fd_pr__nfet_01v8 W=2.0u L=0.5u

* --- 5 WTA cells ---
* Cell 0 (N)
Xin0 comm0 in0 0 0 sky130_fd_pr__nfet_01v8 W=2.0u L=0.5u
Xfb0 comm0 comm0 inhib 0 sky130_fd_pr__nfet_01v8 W=2.0u L=0.5u
Xload0 out0 comm0 vdd vdd sky130_fd_pr__pfet_01v8 W=4.0u L=0.5u
Xpd0 out0 nbias 0 0 sky130_fd_pr__nfet_01v8 W=1.0u L=0.5u

* Cell 1 (S)
Xin1 comm1 in1 0 0 sky130_fd_pr__nfet_01v8 W=2.0u L=0.5u
Xfb1 comm1 comm1 inhib 0 sky130_fd_pr__nfet_01v8 W=2.0u L=0.5u
Xload1 out1 comm1 vdd vdd sky130_fd_pr__pfet_01v8 W=4.0u L=0.5u
Xpd1 out1 nbias 0 0 sky130_fd_pr__nfet_01v8 W=1.0u L=0.5u

* Cell 2 (V)
Xin2 comm2 in2 0 0 sky130_fd_pr__nfet_01v8 W=2.0u L=0.5u
Xfb2 comm2 comm2 inhib 0 sky130_fd_pr__nfet_01v8 W=2.0u L=0.5u
Xload2 out2 comm2 vdd vdd sky130_fd_pr__pfet_01v8 W=4.0u L=0.5u
Xpd2 out2 nbias 0 0 sky130_fd_pr__nfet_01v8 W=1.0u L=0.5u

* Cell 3 (F)
Xin3 comm3 in3 0 0 sky130_fd_pr__nfet_01v8 W=2.0u L=0.5u
Xfb3 comm3 comm3 inhib 0 sky130_fd_pr__nfet_01v8 W=2.0u L=0.5u
Xload3 out3 comm3 vdd vdd sky130_fd_pr__pfet_01v8 W=4.0u L=0.5u
Xpd3 out3 nbias 0 0 sky130_fd_pr__nfet_01v8 W=1.0u L=0.5u

* Cell 4 (Q)
Xin4 comm4 in4 0 0 sky130_fd_pr__nfet_01v8 W=2.0u L=0.5u
Xfb4 comm4 comm4 inhib 0 sky130_fd_pr__nfet_01v8 W=2.0u L=0.5u
Xload4 out4 comm4 vdd vdd sky130_fd_pr__pfet_01v8 W=4.0u L=0.5u
Xpd4 out4 nbias 0 0 sky130_fd_pr__nfet_01v8 W=1.0u L=0.5u

* --- Common inhibition node bias ---
Xinh inhib nbias 0 0 sky130_fd_pr__nfet_01v8 W=10.0u L=0.5u

* --- Inputs (set to Layer 2 output scores, shifted to positive range) ---
* In practice these come from TIA outputs of Layer 2 crossbar
Vin0 in0 0 0.9  $ class N score
Vin1 in1 0 0.9  $ class S score
Vin2 in2 0 0.9  $ class V score
Vin3 in3 0 0.9  $ class F score
Vin4 in4 0 0.9  $ class Q score

* --- Analysis ---
.op

.control
run
print v(out0)
print v(out1)
print v(out2)
print v(out3)
print v(out4)
quit
.endc

.end
