* =================================================================
* WTA Isolation Test — Verify Lazzaro WTA with differentiated inputs
* Uses .tran analysis with ramped inputs to prove discrimination
* =================================================================

.include "C:/src/skywater-pdk-libs-sky130_fd_pr/cells/nfet_01v8/sky130_fd_pr__nfet_01v8__tt.corner.spice"
.include "C:/src/skywater-pdk-libs-sky130_fd_pr/cells/nfet_01v8/sky130_fd_pr__nfet_01v8__mismatch.corner.spice"
.include "C:/src/skywater-pdk-libs-sky130_fd_pr/cells/pfet_01v8/sky130_fd_pr__pfet_01v8__tt.corner.spice"
.include "C:/src/skywater-pdk-libs-sky130_fd_pr/cells/pfet_01v8/sky130_fd_pr__pfet_01v8__mismatch.corner.spice"
.param sky130_fd_pr__pfet_01v8__a0_diff = 0
.param sky130_fd_pr__pfet_01v8__agidl_diff = 0
.param sky130_fd_pr__pfet_01v8__ags_diff = 0
.param sky130_fd_pr__pfet_01v8__b0_diff = 0
.param sky130_fd_pr__pfet_01v8__b1_diff = 0
.param sky130_fd_pr__pfet_01v8__bgidl_diff = 0
.param sky130_fd_pr__pfet_01v8__cgidl_diff = 0
.param sky130_fd_pr__pfet_01v8__dlc_diff = 0
.param sky130_fd_pr__pfet_01v8__dwc_diff = 0
.param sky130_fd_pr__pfet_01v8__eta0_diff = 0
.param sky130_fd_pr__pfet_01v8__k2_diff = 0
.param sky130_fd_pr__pfet_01v8__keta_diff = 0
.param sky130_fd_pr__pfet_01v8__kt1_diff = 0
.param sky130_fd_pr__pfet_01v8__ku0_diff = 0
.param sky130_fd_pr__pfet_01v8__kvsat_diff = 0
.param sky130_fd_pr__pfet_01v8__kvth0_diff = 0
.param sky130_fd_pr__pfet_01v8__lint_diff = 0
.param sky130_fd_pr__pfet_01v8__lku0_diff = 0
.param sky130_fd_pr__pfet_01v8__lkvth0_diff = 0
.param sky130_fd_pr__pfet_01v8__nfactor_diff = 0
.param sky130_fd_pr__pfet_01v8__pclm_diff = 0
.param sky130_fd_pr__pfet_01v8__pdits_diff = 0
.param sky130_fd_pr__pfet_01v8__pditsd_diff = 0
.param sky130_fd_pr__pfet_01v8__rdsw_diff = 0
.param sky130_fd_pr__pfet_01v8__tvoff_diff = 0
.param sky130_fd_pr__pfet_01v8__u0_diff = 0
.param sky130_fd_pr__pfet_01v8__ua_diff = 0
.param sky130_fd_pr__pfet_01v8__ub_diff = 0
.param sky130_fd_pr__pfet_01v8__voff_diff = 0
.param sky130_fd_pr__pfet_01v8__vsat_diff = 0
.param sky130_fd_pr__pfet_01v8__vth0_diff = 0
.param sky130_fd_pr__pfet_01v8__wint_diff = 0
.param sky130_fd_pr__pfet_01v8__wku0_diff = 0
.param sky130_fd_pr__pfet_01v8__wkvth0_diff = 0
.param sky130_fd_pr__pfet_01v8__wlod_diff = 0

* --- Supply ---
VDD vdd 0 1.8

* --- Bias ---
Ibias vdd nbias 10u
Xbias nbias nbias 0 0 sky130_fd_pr__nfet_01v8 W=2.0u L=0.5u

* --- 5 WTA cells (Lazzaro topology) ---
* Cell 0 (N) — WINNER for test case 1
Xin0 comm0 in0 0 0 sky130_fd_pr__nfet_01v8 W=2.0u L=0.5u
Xfb0 comm0 comm0 inhib 0 sky130_fd_pr__nfet_01v8 W=2.0u L=0.5u
Xload0 out0 comm0 vdd vdd sky130_fd_pr__pfet_01v8 W=4.0u L=0.5u
Xpd0 out0 nbias 0 0 sky130_fd_pr__nfet_01v8 W=1.0u L=0.5u

* Cell 1 (S)
Xin1 comm1 in1 0 0 sky130_fd_pr__nfet_01v8 W=2.0u L=0.5u
Xfb1 comm1 comm1 inhib 0 sky130_fd_pr__nfet_01v8 W=2.0u L=0.5u
Xload1 out1 comm1 vdd vdd sky130_fd_pr__pfet_01v8 W=4.0u L=0.5u
Xpd1 out1 nbias 0 0 sky130_fd_pr__nfet_01v8 W=1.0u L=0.5u

* Cell 2 (V)
Xin2 comm2 in2 0 0 sky130_fd_pr__nfet_01v8 W=2.0u L=0.5u
Xfb2 comm2 comm2 inhib 0 sky130_fd_pr__nfet_01v8 W=2.0u L=0.5u
Xload2 out2 comm2 vdd vdd sky130_fd_pr__pfet_01v8 W=4.0u L=0.5u
Xpd2 out2 nbias 0 0 sky130_fd_pr__nfet_01v8 W=1.0u L=0.5u

* Cell 3 (F)
Xin3 comm3 in3 0 0 sky130_fd_pr__nfet_01v8 W=2.0u L=0.5u
Xfb3 comm3 comm3 inhib 0 sky130_fd_pr__nfet_01v8 W=2.0u L=0.5u
Xload3 out3 comm3 vdd vdd sky130_fd_pr__pfet_01v8 W=4.0u L=0.5u
Xpd3 out3 nbias 0 0 sky130_fd_pr__nfet_01v8 W=1.0u L=0.5u

* Cell 4 (Q)
Xin4 comm4 in4 0 0 sky130_fd_pr__nfet_01v8 W=2.0u L=0.5u
Xfb4 comm4 comm4 inhib 0 sky130_fd_pr__nfet_01v8 W=2.0u L=0.5u
Xload4 out4 comm4 vdd vdd sky130_fd_pr__pfet_01v8 W=4.0u L=0.5u
Xpd4 out4 nbias 0 0 sky130_fd_pr__nfet_01v8 W=1.0u L=0.5u

* --- Common inhibition ---
Xinh inhib nbias 0 0 sky130_fd_pr__nfet_01v8 W=10.0u L=0.5u

* =================================================================
* TEST CASE 1: Cell 0 wins (highest voltage = 0.95V)
* Inputs: in0=0.95, in1=0.70, in2=0.80, in3=0.75, in4=0.60
* Expected: out0=HIGH, out1-4=LOW
* =================================================================
Vin0 in0 0 PWL(0 0.0 1u 0.95)
Vin1 in1 0 PWL(0 0.0 1u 0.70)
Vin2 in2 0 PWL(0 0.0 1u 0.80)
Vin3 in3 0 PWL(0 0.0 1u 0.75)
Vin4 in4 0 PWL(0 0.0 1u 0.60)

.tran 10n 20u

.control
run

echo "=== WTA ISOLATION TEST ==="
echo "Test Case 1: in0=0.95V (winner), in1=0.70, in2=0.80, in3=0.75, in4=0.60"
echo "Expected: out0=HIGH, others=LOW"
echo ""

* Measure steady-state outputs (at end of sim)
meas tran v_out0 FIND v(out0) AT=19u
meas tran v_out1 FIND v(out1) AT=19u
meas tran v_out2 FIND v(out2) AT=19u
meas tran v_out3 FIND v(out3) AT=19u
meas tran v_out4 FIND v(out4) AT=19u

meas tran v_in0 FIND v(in0) AT=19u
meas tran v_in1 FIND v(in1) AT=19u
meas tran v_in2 FIND v(in2) AT=19u
meas tran v_in3 FIND v(in3) AT=19u
meas tran v_in4 FIND v(in4) AT=19u

meas tran v_inhib FIND v(inhib) AT=19u
meas tran v_nbias FIND v(nbias) AT=19u

echo ""
echo "=== OUTPUT VOLTAGES ==="
print v_out0 v_out1 v_out2 v_out3 v_out4
echo ""
echo "=== INPUT VOLTAGES ==="
print v_in0 v_in1 v_in2 v_in3 v_in4
echo ""
echo "=== INTERNAL NODES ==="
print v_inhib v_nbias

* Check discrimination
let winner_margin = v_out0 - maximum(v_out1, maximum(v_out2, maximum(v_out3, v_out4)))
echo ""
echo "Winner margin (out0 - max(others)):"
print winner_margin

quit
.endc

.end
