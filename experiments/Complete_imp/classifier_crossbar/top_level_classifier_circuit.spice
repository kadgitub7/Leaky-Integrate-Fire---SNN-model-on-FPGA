* =================================================================
* TOP-LEVEL: Complete Analog ECG Classifier
* Architecture: 8 -> 64 -> 5 MLP on ReRAM Crossbar
* Technology: SKY130 (NFET/PFET 01v8 + ReRAM)
* Column readout: real NFET/PFET mirrors (col_readout subcircuit)
* Input conditioning: B-source with V_COL_OFFSET
* =================================================================
*
* L1 scale: 1.4706e+05,  L2 scale: 2.2396e+05
* V_READ: 0.15V,  V_COL_OFFSET: 0.52V,  VDD: 1.8V
* L1 cells: 1024 1T1R,  L2 cells: 640 1T1R
* =================================================================

.include "C:/src/skywater-pdk-libs-sky130_fd_pr/cells/nfet_01v8/sky130_fd_pr__nfet_01v8__tt.corner.spice"
.include "C:/src/skywater-pdk-libs-sky130_fd_pr/cells/nfet_01v8/sky130_fd_pr__nfet_01v8__mismatch.corner.spice"
.include "C:/src/skywater-pdk-libs-sky130_fd_pr/cells/pfet_01v8/sky130_fd_pr__pfet_01v8__tt.corner.spice"
.include "C:/src/skywater-pdk-libs-sky130_fd_pr/cells/pfet_01v8/sky130_fd_pr__pfet_01v8__mismatch.corner.spice"
.param sky130_fd_pr__pfet_01v8__a0_diff = 0
.param sky130_fd_pr__pfet_01v8__agidl_diff = 0
.param sky130_fd_pr__pfet_01v8__ags_diff = 0
.param sky130_fd_pr__pfet_01v8__b0_diff = 0
.param sky130_fd_pr__pfet_01v8__b1_diff = 0
.param sky130_fd_pr__pfet_01v8__bgidl_diff = 0
.param sky130_fd_pr__pfet_01v8__cgidl_diff = 0
.param sky130_fd_pr__pfet_01v8__dlc_diff = 0
.param sky130_fd_pr__pfet_01v8__dwc_diff = 0
.param sky130_fd_pr__pfet_01v8__eta0_diff = 0
.param sky130_fd_pr__pfet_01v8__k2_diff = 0
.param sky130_fd_pr__pfet_01v8__keta_diff = 0
.param sky130_fd_pr__pfet_01v8__kt1_diff = 0
.param sky130_fd_pr__pfet_01v8__ku0_diff = 0
.param sky130_fd_pr__pfet_01v8__kvsat_diff = 0
.param sky130_fd_pr__pfet_01v8__kvth0_diff = 0
.param sky130_fd_pr__pfet_01v8__lint_diff = 0
.param sky130_fd_pr__pfet_01v8__lku0_diff = 0
.param sky130_fd_pr__pfet_01v8__lkvth0_diff = 0
.param sky130_fd_pr__pfet_01v8__nfactor_diff = 0
.param sky130_fd_pr__pfet_01v8__pclm_diff = 0
.param sky130_fd_pr__pfet_01v8__pdits_diff = 0
.param sky130_fd_pr__pfet_01v8__pditsd_diff = 0
.param sky130_fd_pr__pfet_01v8__rdsw_diff = 0
.param sky130_fd_pr__pfet_01v8__tvoff_diff = 0
.param sky130_fd_pr__pfet_01v8__u0_diff = 0
.param sky130_fd_pr__pfet_01v8__ua_diff = 0
.param sky130_fd_pr__pfet_01v8__ub_diff = 0
.param sky130_fd_pr__pfet_01v8__uc_diff = 0
.param sky130_fd_pr__pfet_01v8__ute_diff = 0
.param sky130_fd_pr__pfet_01v8__voff_diff = 0
.param sky130_fd_pr__pfet_01v8__vsat_diff = 0
.param sky130_fd_pr__pfet_01v8__vth0_diff = 0
.param sky130_fd_pr__pfet_01v8__wint_diff = 0
.param sky130_fd_pr__pfet_01v8__wku0_diff = 0
.param sky130_fd_pr__pfet_01v8__wkvth0_diff = 0
.param sky130_fd_pr__pfet_01v8__wlod_diff = 0

* === 1T1R ReRAM cell (SKY130 PDK behavioral I-V) ===
.subckt reram_1t1r row gate col gnd Tf0=3.3e-9
.param Ik1=6.14e-05
.param Tox=5e-09
.param Tfref=4.7249e-09
.param Vref=0.43
Xacc row gate mid gnd sky130_fd_pr__nfet_01v8 W=1.0u L=0.15u
Breram mid col I = Ik1*exp(-(Tox-Tf0)/(Tox-Tfref))*sinh(v(mid,col)/Vref)
.ends reram_1t1r

* === Differential column readout (replaces Vsource + CCCS) ===
.subckt col_readout col_p col_n nmac vdd gnd
Xpd col_p col_p gnd gnd sky130_fd_pr__nfet_01v8 W=50.0u L=1.0u
Xpm nmac col_p gnd gnd sky130_fd_pr__nfet_01v8 W=50.0u L=1.0u
Xnd col_n col_n gnd gnd sky130_fd_pr__nfet_01v8 W=50.0u L=1.0u
Xnm mid_n col_n gnd gnd sky130_fd_pr__nfet_01v8 W=50.0u L=1.0u
Xpcd mid_n mid_n vdd vdd sky130_fd_pr__pfet_01v8 W=50.0u L=1.0u
Xpcm nmac mid_n vdd vdd sky130_fd_pr__pfet_01v8 W=50.0u L=1.0u
.ends col_readout

* ===== SUPPLY =====
VDD vdd 0 1.8

* ===== FEATURE INPUTS =====
Vfeat0 feat0 0 0.0
Vfeat1 feat1 0 0.0
Vfeat2 feat2 0 0.0
Vfeat3 feat3 0 0.0
Vfeat4 feat4 0 0.0
Vfeat5 feat5 0 0.0
Vfeat6 feat6 0 0.0
Vfeat7 feat7 0 0.0

* ===== INPUT CONDITIONING (8 channels) =====
* B-source: V_row = gain*V_feat + offset + V_COL_OFFSET
* gain = V_READ/(8*scale), offset = V_READ*(4-mean/scale)/8
* V_COL_OFFSET = 0.52V compensates NFET diode column voltage

* --- Feature 0 (F1_rr_deviation): mean=-0.001966, scale=0.469741 ---
* gain=3.99155737e-02 V/V, offset_base=7.50784630e-02, +V_COL_OFFSET=0.52
Bcond0 row0 0 V = v(feat0)*3.99155737e-02 + 5.95078463e-01

* --- Feature 1 (F4_bi_L1): mean=-0.000008, scale=0.384009 ---
* gain=4.88270111e-02 V/V, offset_base=7.50003880e-02, +V_COL_OFFSET=0.52
Bcond1 row1 0 V = v(feat1)*4.88270111e-02 + 5.95000388e-01

* --- Feature 2 (F2_rr_asymmetry): mean=-0.000038, scale=0.658086 ---
* gain=2.84917140e-02 V/V, offset_base=7.50010917e-02, +V_COL_OFFSET=0.52
Bcond2 row2 0 V = v(feat2)*2.84917140e-02 + 5.95001092e-01

* --- Feature 3 (F5_pwave_diff): mean=0.013629, scale=0.140897 ---
* gain=1.33076214e-01 V/V, offset_base=7.31862608e-02, +V_COL_OFFSET=0.52
Bcond3 row3 0 V = v(feat3)*1.33076214e-01 + 5.93186261e-01

* --- Feature 4 (F6_width_proxy): mean=-0.573710, scale=0.381370 ---
* gain=4.91648705e-02 V/V, offset_base=1.03206391e-01, +V_COL_OFFSET=0.52
Bcond4 row4 0 V = v(feat4)*4.91648705e-02 + 6.23206391e-01

* --- Feature 5 (F3_bi_L0): mean=0.000029, scale=0.512142 ---
* gain=3.66109250e-02 V/V, offset_base=7.49989512e-02, +V_COL_OFFSET=0.52
Bcond5 row5 0 V = v(feat5)*3.66109250e-02 + 5.94998951e-01

* --- Feature 6 (F7_slope): mean=0.814082, scale=0.743661 ---
* gain=2.52131149e-02 V/V, offset_base=5.44744521e-02, +V_COL_OFFSET=0.52
Bcond6 row6 0 V = v(feat6)*2.52131149e-02 + 5.74474452e-01

* --- Feature 7 (F8_rpeak_voltage): mean=0.901827, scale=0.837629 ---
* gain=2.23846220e-02 V/V, offset_base=5.48129528e-02, +V_COL_OFFSET=0.52
Bcond7 row7 0 V = v(feat7)*2.23846220e-02 + 5.74812953e-01

* ===== LAYER 1: 8x64 DIFFERENTIAL 1T1R ReRAM CROSSBAR =====
Vgate_l1 gate_l1 0 1.8

* --- Positive conductance array ---
Xrpl1_0_0 row0 gate_l1 cpl1_0 0 reram_1t1r Tf0=3.300000e-09  $ G+=0.296uS
Xrpl1_0_1 row0 gate_l1 cpl1_1 0 reram_1t1r Tf0=4.803596e-09  $ G+=71.353uS
Xrpl1_0_2 row0 gate_l1 cpl1_2 0 reram_1t1r Tf0=4.484956e-09  $ G+=22.407uS
Xrpl1_0_3 row0 gate_l1 cpl1_3 0 reram_1t1r Tf0=4.613434e-09  $ G+=35.744uS
Xrpl1_0_4 row0 gate_l1 cpl1_4 0 reram_1t1r Tf0=3.300000e-09  $ G+=0.296uS
Xrpl1_0_5 row0 gate_l1 cpl1_5 0 reram_1t1r Tf0=3.300000e-09  $ G+=0.296uS
Xrpl1_0_6 row0 gate_l1 cpl1_6 0 reram_1t1r Tf0=3.300000e-09  $ G+=0.296uS
Xrpl1_0_7 row0 gate_l1 cpl1_7 0 reram_1t1r Tf0=4.894443e-09  $ G+=99.273uS
Xrpl1_0_8 row0 gate_l1 cpl1_8 0 reram_1t1r Tf0=4.481435e-09  $ G+=22.122uS
Xrpl1_0_9 row0 gate_l1 cpl1_9 0 reram_1t1r Tf0=3.300000e-09  $ G+=0.296uS
Xrpl1_0_10 row0 gate_l1 cpl1_10 0 reram_1t1r Tf0=3.300000e-09  $ G+=0.296uS
Xrpl1_0_11 row0 gate_l1 cpl1_11 0 reram_1t1r Tf0=4.621973e-09  $ G+=36.871uS
Xrpl1_0_12 row0 gate_l1 cpl1_12 0 reram_1t1r Tf0=4.829367e-09  $ G+=78.361uS
Xrpl1_0_13 row0 gate_l1 cpl1_13 0 reram_1t1r Tf0=4.564477e-09  $ G+=29.917uS
Xrpl1_0_14 row0 gate_l1 cpl1_14 0 reram_1t1r Tf0=3.300000e-09  $ G+=0.296uS
Xrpl1_0_15 row0 gate_l1 cpl1_15 0 reram_1t1r Tf0=3.300000e-09  $ G+=0.296uS
Xrpl1_0_16 row0 gate_l1 cpl1_16 0 reram_1t1r Tf0=3.300000e-09  $ G+=0.296uS
Xrpl1_0_17 row0 gate_l1 cpl1_17 0 reram_1t1r Tf0=4.307516e-09  $ G+=11.756uS
Xrpl1_0_18 row0 gate_l1 cpl1_18 0 reram_1t1r Tf0=4.669676e-09  $ G+=43.853uS
Xrpl1_0_19 row0 gate_l1 cpl1_19 0 reram_1t1r Tf0=4.089955e-09  $ G+=5.331uS
Xrpl1_0_20 row0 gate_l1 cpl1_20 0 reram_1t1r Tf0=4.347709e-09  $ G+=13.606uS
Xrpl1_0_21 row0 gate_l1 cpl1_21 0 reram_1t1r Tf0=3.300000e-09  $ G+=0.296uS
Xrpl1_0_22 row0 gate_l1 cpl1_22 0 reram_1t1r Tf0=3.300000e-09  $ G+=0.296uS
Xrpl1_0_23 row0 gate_l1 cpl1_23 0 reram_1t1r Tf0=4.515089e-09  $ G+=25.001uS
Xrpl1_0_24 row0 gate_l1 cpl1_24 0 reram_1t1r Tf0=3.300000e-09  $ G+=0.296uS
Xrpl1_0_25 row0 gate_l1 cpl1_25 0 reram_1t1r Tf0=4.053176e-09  $ G+=4.664uS
Xrpl1_0_26 row0 gate_l1 cpl1_26 0 reram_1t1r Tf0=3.300000e-09  $ G+=0.296uS
Xrpl1_0_27 row0 gate_l1 cpl1_27 0 reram_1t1r Tf0=4.644574e-09  $ G+=40.029uS
Xrpl1_0_28 row0 gate_l1 cpl1_28 0 reram_1t1r Tf0=3.300000e-09  $ G+=0.296uS
Xrpl1_0_29 row0 gate_l1 cpl1_29 0 reram_1t1r Tf0=3.300000e-09  $ G+=0.296uS
Xrpl1_0_30 row0 gate_l1 cpl1_30 0 reram_1t1r Tf0=3.300000e-09  $ G+=0.296uS
Xrpl1_0_31 row0 gate_l1 cpl1_31 0 reram_1t1r Tf0=4.130987e-09  $ G+=6.188uS
Xrpl1_0_32 row0 gate_l1 cpl1_32 0 reram_1t1r Tf0=3.300000e-09  $ G+=0.296uS
Xrpl1_0_33 row0 gate_l1 cpl1_33 0 reram_1t1r Tf0=4.555036e-09  $ G+=28.908uS
Xrpl1_0_34 row0 gate_l1 cpl1_34 0 reram_1t1r Tf0=4.587940e-09  $ G+=32.581uS
Xrpl1_0_35 row0 gate_l1 cpl1_35 0 reram_1t1r Tf0=4.552567e-09  $ G+=28.650uS
Xrpl1_0_36 row0 gate_l1 cpl1_36 0 reram_1t1r Tf0=3.319512e-09  $ G+=0.324uS
Xrpl1_0_37 row0 gate_l1 cpl1_37 0 reram_1t1r Tf0=3.300000e-09  $ G+=0.296uS
Xrpl1_0_38 row0 gate_l1 cpl1_38 0 reram_1t1r Tf0=3.300000e-09  $ G+=0.296uS
Xrpl1_0_39 row0 gate_l1 cpl1_39 0 reram_1t1r Tf0=4.614648e-09  $ G+=35.903uS
Xrpl1_0_40 row0 gate_l1 cpl1_40 0 reram_1t1r Tf0=3.300000e-09  $ G+=0.296uS
Xrpl1_0_41 row0 gate_l1 cpl1_41 0 reram_1t1r Tf0=4.792540e-09  $ G+=68.542uS
Xrpl1_0_42 row0 gate_l1 cpl1_42 0 reram_1t1r Tf0=3.300000e-09  $ G+=0.296uS
Xrpl1_0_43 row0 gate_l1 cpl1_43 0 reram_1t1r Tf0=4.778869e-09  $ G+=65.219uS
Xrpl1_0_44 row0 gate_l1 cpl1_44 0 reram_1t1r Tf0=3.300000e-09  $ G+=0.296uS
Xrpl1_0_45 row0 gate_l1 cpl1_45 0 reram_1t1r Tf0=3.300000e-09  $ G+=0.296uS
Xrpl1_0_46 row0 gate_l1 cpl1_46 0 reram_1t1r Tf0=3.300000e-09  $ G+=0.296uS
Xrpl1_0_47 row0 gate_l1 cpl1_47 0 reram_1t1r Tf0=4.540237e-09  $ G+=27.394uS
Xrpl1_0_48 row0 gate_l1 cpl1_48 0 reram_1t1r Tf0=3.949319e-09  $ G+=3.197uS
Xrpl1_0_49 row0 gate_l1 cpl1_49 0 reram_1t1r Tf0=4.401370e-09  $ G+=16.536uS
Xrpl1_0_50 row0 gate_l1 cpl1_50 0 reram_1t1r Tf0=4.642248e-09  $ G+=39.691uS
Xrpl1_0_51 row0 gate_l1 cpl1_51 0 reram_1t1r Tf0=4.597641e-09  $ G+=33.750uS
Xrpl1_0_52 row0 gate_l1 cpl1_52 0 reram_1t1r Tf0=4.697796e-09  $ G+=48.572uS
Xrpl1_0_53 row0 gate_l1 cpl1_53 0 reram_1t1r Tf0=4.722515e-09  $ G+=53.139uS
Xrpl1_0_54 row0 gate_l1 cpl1_54 0 reram_1t1r Tf0=4.241426e-09  $ G+=9.245uS
Xrpl1_0_55 row0 gate_l1 cpl1_55 0 reram_1t1r Tf0=4.470013e-09  $ G+=21.222uS
Xrpl1_0_56 row0 gate_l1 cpl1_56 0 reram_1t1r Tf0=3.938558e-09  $ G+=3.075uS
Xrpl1_0_57 row0 gate_l1 cpl1_57 0 reram_1t1r Tf0=3.300000e-09  $ G+=0.296uS
Xrpl1_0_58 row0 gate_l1 cpl1_58 0 reram_1t1r Tf0=3.300000e-09  $ G+=0.296uS
Xrpl1_0_59 row0 gate_l1 cpl1_59 0 reram_1t1r Tf0=3.300000e-09  $ G+=0.296uS
Xrpl1_0_60 row0 gate_l1 cpl1_60 0 reram_1t1r Tf0=3.300000e-09  $ G+=0.296uS
Xrpl1_0_61 row0 gate_l1 cpl1_61 0 reram_1t1r Tf0=4.634832e-09  $ G+=38.636uS
Xrpl1_0_62 row0 gate_l1 cpl1_62 0 reram_1t1r Tf0=4.744029e-09  $ G+=57.461uS
Xrpl1_0_63 row0 gate_l1 cpl1_63 0 reram_1t1r Tf0=3.300000e-09  $ G+=0.296uS
Xrpl1_1_0 row1 gate_l1 cpl1_0 0 reram_1t1r Tf0=3.300000e-09  $ G+=0.296uS
Xrpl1_1_1 row1 gate_l1 cpl1_1 0 reram_1t1r Tf0=4.047423e-09  $ G+=4.567uS
Xrpl1_1_2 row1 gate_l1 cpl1_2 0 reram_1t1r Tf0=3.300000e-09  $ G+=0.296uS
Xrpl1_1_3 row1 gate_l1 cpl1_3 0 reram_1t1r Tf0=4.133824e-09  $ G+=6.253uS
Xrpl1_1_4 row1 gate_l1 cpl1_4 0 reram_1t1r Tf0=3.300000e-09  $ G+=0.296uS
Xrpl1_1_5 row1 gate_l1 cpl1_5 0 reram_1t1r Tf0=4.562471e-09  $ G+=29.700uS
Xrpl1_1_6 row1 gate_l1 cpl1_6 0 reram_1t1r Tf0=3.959662e-09  $ G+=3.320uS
Xrpl1_1_7 row1 gate_l1 cpl1_7 0 reram_1t1r Tf0=3.300000e-09  $ G+=0.296uS
Xrpl1_1_8 row1 gate_l1 cpl1_8 0 reram_1t1r Tf0=3.300000e-09  $ G+=0.296uS
Xrpl1_1_9 row1 gate_l1 cpl1_9 0 reram_1t1r Tf0=4.329131e-09  $ G+=12.717uS
Xrpl1_1_10 row1 gate_l1 cpl1_10 0 reram_1t1r Tf0=4.365381e-09  $ G+=14.508uS
Xrpl1_1_11 row1 gate_l1 cpl1_11 0 reram_1t1r Tf0=4.492650e-09  $ G+=23.043uS
Xrpl1_1_12 row1 gate_l1 cpl1_12 0 reram_1t1r Tf0=4.102983e-09  $ G+=5.589uS
Xrpl1_1_13 row1 gate_l1 cpl1_13 0 reram_1t1r Tf0=3.300000e-09  $ G+=0.296uS
Xrpl1_1_14 row1 gate_l1 cpl1_14 0 reram_1t1r Tf0=4.024094e-09  $ G+=4.196uS
Xrpl1_1_15 row1 gate_l1 cpl1_15 0 reram_1t1r Tf0=3.300000e-09  $ G+=0.296uS
Xrpl1_1_16 row1 gate_l1 cpl1_16 0 reram_1t1r Tf0=4.580043e-09  $ G+=31.659uS
Xrpl1_1_17 row1 gate_l1 cpl1_17 0 reram_1t1r Tf0=4.112454e-09  $ G+=5.785uS
Xrpl1_1_18 row1 gate_l1 cpl1_18 0 reram_1t1r Tf0=3.300000e-09  $ G+=0.296uS
Xrpl1_1_19 row1 gate_l1 cpl1_19 0 reram_1t1r Tf0=3.300000e-09  $ G+=0.296uS
Xrpl1_1_20 row1 gate_l1 cpl1_20 0 reram_1t1r Tf0=3.300000e-09  $ G+=0.296uS
Xrpl1_1_21 row1 gate_l1 cpl1_21 0 reram_1t1r Tf0=3.662736e-09  $ G+=1.128uS
Xrpl1_1_22 row1 gate_l1 cpl1_22 0 reram_1t1r Tf0=4.230758e-09  $ G+=8.894uS
Xrpl1_1_23 row1 gate_l1 cpl1_23 0 reram_1t1r Tf0=4.298940e-09  $ G+=11.395uS
Xrpl1_1_24 row1 gate_l1 cpl1_24 0 reram_1t1r Tf0=3.749762e-09  $ G+=1.548uS
Xrpl1_1_25 row1 gate_l1 cpl1_25 0 reram_1t1r Tf0=3.300000e-09  $ G+=0.296uS
Xrpl1_1_26 row1 gate_l1 cpl1_26 0 reram_1t1r Tf0=3.300000e-09  $ G+=0.296uS
Xrpl1_1_27 row1 gate_l1 cpl1_27 0 reram_1t1r Tf0=3.639701e-09  $ G+=1.038uS
Xrpl1_1_28 row1 gate_l1 cpl1_28 0 reram_1t1r Tf0=3.300000e-09  $ G+=0.296uS
Xrpl1_1_29 row1 gate_l1 cpl1_29 0 reram_1t1r Tf0=3.300000e-09  $ G+=0.296uS
Xrpl1_1_30 row1 gate_l1 cpl1_30 0 reram_1t1r Tf0=4.494607e-09  $ G+=23.207uS
Xrpl1_1_31 row1 gate_l1 cpl1_31 0 reram_1t1r Tf0=3.300000e-09  $ G+=0.296uS
Xrpl1_1_32 row1 gate_l1 cpl1_32 0 reram_1t1r Tf0=3.300000e-09  $ G+=0.296uS
Xrpl1_1_33 row1 gate_l1 cpl1_33 0 reram_1t1r Tf0=3.649245e-09  $ G+=1.074uS
Xrpl1_1_34 row1 gate_l1 cpl1_34 0 reram_1t1r Tf0=3.300000e-09  $ G+=0.296uS
Xrpl1_1_35 row1 gate_l1 cpl1_35 0 reram_1t1r Tf0=3.300000e-09  $ G+=0.296uS
Xrpl1_1_36 row1 gate_l1 cpl1_36 0 reram_1t1r Tf0=3.300000e-09  $ G+=0.296uS
Xrpl1_1_37 row1 gate_l1 cpl1_37 0 reram_1t1r Tf0=4.541166e-09  $ G+=27.487uS
Xrpl1_1_38 row1 gate_l1 cpl1_38 0 reram_1t1r Tf0=3.300000e-09  $ G+=0.296uS
Xrpl1_1_39 row1 gate_l1 cpl1_39 0 reram_1t1r Tf0=3.300000e-09  $ G+=0.296uS
Xrpl1_1_40 row1 gate_l1 cpl1_40 0 reram_1t1r Tf0=4.579355e-09  $ G+=31.580uS
Xrpl1_1_41 row1 gate_l1 cpl1_41 0 reram_1t1r Tf0=3.300000e-09  $ G+=0.296uS
Xrpl1_1_42 row1 gate_l1 cpl1_42 0 reram_1t1r Tf0=3.300000e-09  $ G+=0.296uS
Xrpl1_1_43 row1 gate_l1 cpl1_43 0 reram_1t1r Tf0=4.315221e-09  $ G+=12.090uS
Xrpl1_1_44 row1 gate_l1 cpl1_44 0 reram_1t1r Tf0=3.300000e-09  $ G+=0.296uS
Xrpl1_1_45 row1 gate_l1 cpl1_45 0 reram_1t1r Tf0=3.300000e-09  $ G+=0.296uS
Xrpl1_1_46 row1 gate_l1 cpl1_46 0 reram_1t1r Tf0=3.300000e-09  $ G+=0.296uS
Xrpl1_1_47 row1 gate_l1 cpl1_47 0 reram_1t1r Tf0=3.300000e-09  $ G+=0.296uS
Xrpl1_1_48 row1 gate_l1 cpl1_48 0 reram_1t1r Tf0=4.313248e-09  $ G+=12.004uS
Xrpl1_1_49 row1 gate_l1 cpl1_49 0 reram_1t1r Tf0=4.381036e-09  $ G+=15.358uS
Xrpl1_1_50 row1 gate_l1 cpl1_50 0 reram_1t1r Tf0=3.300000e-09  $ G+=0.296uS
Xrpl1_1_51 row1 gate_l1 cpl1_51 0 reram_1t1r Tf0=4.222401e-09  $ G+=8.628uS
Xrpl1_1_52 row1 gate_l1 cpl1_52 0 reram_1t1r Tf0=4.240502e-09  $ G+=9.214uS
Xrpl1_1_53 row1 gate_l1 cpl1_53 0 reram_1t1r Tf0=3.300000e-09  $ G+=0.296uS
Xrpl1_1_54 row1 gate_l1 cpl1_54 0 reram_1t1r Tf0=4.561388e-09  $ G+=29.583uS
Xrpl1_1_55 row1 gate_l1 cpl1_55 0 reram_1t1r Tf0=4.217769e-09  $ G+=8.484uS
Xrpl1_1_56 row1 gate_l1 cpl1_56 0 reram_1t1r Tf0=4.150916e-09  $ G+=6.653uS
Xrpl1_1_57 row1 gate_l1 cpl1_57 0 reram_1t1r Tf0=4.631721e-09  $ G+=38.201uS
Xrpl1_1_58 row1 gate_l1 cpl1_58 0 reram_1t1r Tf0=3.300000e-09  $ G+=0.296uS
Xrpl1_1_59 row1 gate_l1 cpl1_59 0 reram_1t1r Tf0=3.300000e-09  $ G+=0.296uS
Xrpl1_1_60 row1 gate_l1 cpl1_60 0 reram_1t1r Tf0=4.175890e-09  $ G+=7.286uS
Xrpl1_1_61 row1 gate_l1 cpl1_61 0 reram_1t1r Tf0=4.093241e-09  $ G+=5.395uS
Xrpl1_1_62 row1 gate_l1 cpl1_62 0 reram_1t1r Tf0=4.296161e-09  $ G+=11.281uS
Xrpl1_1_63 row1 gate_l1 cpl1_63 0 reram_1t1r Tf0=4.354735e-09  $ G+=13.957uS
Xrpl1_2_0 row2 gate_l1 cpl1_0 0 reram_1t1r Tf0=3.300000e-09  $ G+=0.296uS
Xrpl1_2_1 row2 gate_l1 cpl1_1 0 reram_1t1r Tf0=3.300000e-09  $ G+=0.296uS
Xrpl1_2_2 row2 gate_l1 cpl1_2 0 reram_1t1r Tf0=3.300000e-09  $ G+=0.296uS
Xrpl1_2_3 row2 gate_l1 cpl1_3 0 reram_1t1r Tf0=3.300000e-09  $ G+=0.296uS
Xrpl1_2_4 row2 gate_l1 cpl1_4 0 reram_1t1r Tf0=3.911546e-09  $ G+=2.787uS
Xrpl1_2_5 row2 gate_l1 cpl1_5 0 reram_1t1r Tf0=3.300000e-09  $ G+=0.296uS
Xrpl1_2_6 row2 gate_l1 cpl1_6 0 reram_1t1r Tf0=3.300000e-09  $ G+=0.296uS
Xrpl1_2_7 row2 gate_l1 cpl1_7 0 reram_1t1r Tf0=3.300000e-09  $ G+=0.296uS
Xrpl1_2_8 row2 gate_l1 cpl1_8 0 reram_1t1r Tf0=3.300000e-09  $ G+=0.296uS
Xrpl1_2_9 row2 gate_l1 cpl1_9 0 reram_1t1r Tf0=4.484737e-09  $ G+=22.389uS
Xrpl1_2_10 row2 gate_l1 cpl1_10 0 reram_1t1r Tf0=3.300000e-09  $ G+=0.296uS
Xrpl1_2_11 row2 gate_l1 cpl1_11 0 reram_1t1r Tf0=4.031919e-09  $ G+=4.317uS
Xrpl1_2_12 row2 gate_l1 cpl1_12 0 reram_1t1r Tf0=4.237267e-09  $ G+=9.107uS
Xrpl1_2_13 row2 gate_l1 cpl1_13 0 reram_1t1r Tf0=3.300000e-09  $ G+=0.296uS
Xrpl1_2_14 row2 gate_l1 cpl1_14 0 reram_1t1r Tf0=3.300000e-09  $ G+=0.296uS
Xrpl1_2_15 row2 gate_l1 cpl1_15 0 reram_1t1r Tf0=3.300000e-09  $ G+=0.296uS
Xrpl1_2_16 row2 gate_l1 cpl1_16 0 reram_1t1r Tf0=3.300000e-09  $ G+=0.296uS
Xrpl1_2_17 row2 gate_l1 cpl1_17 0 reram_1t1r Tf0=3.300000e-09  $ G+=0.296uS
Xrpl1_2_18 row2 gate_l1 cpl1_18 0 reram_1t1r Tf0=4.288713e-09  $ G+=10.979uS
Xrpl1_2_19 row2 gate_l1 cpl1_19 0 reram_1t1r Tf0=4.066986e-09  $ G+=4.904uS
Xrpl1_2_20 row2 gate_l1 cpl1_20 0 reram_1t1r Tf0=4.347882e-09  $ G+=13.614uS
Xrpl1_2_21 row2 gate_l1 cpl1_21 0 reram_1t1r Tf0=3.844422e-09  $ G+=2.184uS
Xrpl1_2_22 row2 gate_l1 cpl1_22 0 reram_1t1r Tf0=4.471974e-09  $ G+=21.374uS
Xrpl1_2_23 row2 gate_l1 cpl1_23 0 reram_1t1r Tf0=3.300000e-09  $ G+=0.296uS
Xrpl1_2_24 row2 gate_l1 cpl1_24 0 reram_1t1r Tf0=3.300000e-09  $ G+=0.296uS
Xrpl1_2_25 row2 gate_l1 cpl1_25 0 reram_1t1r Tf0=4.696494e-09  $ G+=48.343uS
Xrpl1_2_26 row2 gate_l1 cpl1_26 0 reram_1t1r Tf0=3.300000e-09  $ G+=0.296uS
Xrpl1_2_27 row2 gate_l1 cpl1_27 0 reram_1t1r Tf0=4.642716e-09  $ G+=39.759uS
Xrpl1_2_28 row2 gate_l1 cpl1_28 0 reram_1t1r Tf0=4.291913e-09  $ G+=11.108uS
Xrpl1_2_29 row2 gate_l1 cpl1_29 0 reram_1t1r Tf0=3.415963e-09  $ G+=0.460uS
Xrpl1_2_30 row2 gate_l1 cpl1_30 0 reram_1t1r Tf0=3.300000e-09  $ G+=0.296uS
Xrpl1_2_31 row2 gate_l1 cpl1_31 0 reram_1t1r Tf0=4.605834e-09  $ G+=34.770uS
Xrpl1_2_32 row2 gate_l1 cpl1_32 0 reram_1t1r Tf0=3.300000e-09  $ G+=0.296uS
Xrpl1_2_33 row2 gate_l1 cpl1_33 0 reram_1t1r Tf0=4.390817e-09  $ G+=15.914uS
Xrpl1_2_34 row2 gate_l1 cpl1_34 0 reram_1t1r Tf0=3.300000e-09  $ G+=0.296uS
Xrpl1_2_35 row2 gate_l1 cpl1_35 0 reram_1t1r Tf0=4.646007e-09  $ G+=40.237uS
Xrpl1_2_36 row2 gate_l1 cpl1_36 0 reram_1t1r Tf0=4.398655e-09  $ G+=16.374uS
Xrpl1_2_37 row2 gate_l1 cpl1_37 0 reram_1t1r Tf0=4.356422e-09  $ G+=14.043uS
Xrpl1_2_38 row2 gate_l1 cpl1_38 0 reram_1t1r Tf0=3.300000e-09  $ G+=0.296uS
Xrpl1_2_39 row2 gate_l1 cpl1_39 0 reram_1t1r Tf0=3.300000e-09  $ G+=0.296uS
Xrpl1_2_40 row2 gate_l1 cpl1_40 0 reram_1t1r Tf0=3.300000e-09  $ G+=0.296uS
Xrpl1_2_41 row2 gate_l1 cpl1_41 0 reram_1t1r Tf0=4.692111e-09  $ G+=47.579uS
Xrpl1_2_42 row2 gate_l1 cpl1_42 0 reram_1t1r Tf0=4.434703e-09  $ G+=18.666uS
Xrpl1_2_43 row2 gate_l1 cpl1_43 0 reram_1t1r Tf0=3.300000e-09  $ G+=0.296uS
Xrpl1_2_44 row2 gate_l1 cpl1_44 0 reram_1t1r Tf0=4.569784e-09  $ G+=30.500uS
Xrpl1_2_45 row2 gate_l1 cpl1_45 0 reram_1t1r Tf0=3.300000e-09  $ G+=0.296uS
Xrpl1_2_46 row2 gate_l1 cpl1_46 0 reram_1t1r Tf0=4.516483e-09  $ G+=25.128uS
Xrpl1_2_47 row2 gate_l1 cpl1_47 0 reram_1t1r Tf0=3.300000e-09  $ G+=0.296uS
Xrpl1_2_48 row2 gate_l1 cpl1_48 0 reram_1t1r Tf0=3.300000e-09  $ G+=0.296uS
Xrpl1_2_49 row2 gate_l1 cpl1_49 0 reram_1t1r Tf0=3.300000e-09  $ G+=0.296uS
Xrpl1_2_50 row2 gate_l1 cpl1_50 0 reram_1t1r Tf0=3.300000e-09  $ G+=0.296uS
Xrpl1_2_51 row2 gate_l1 cpl1_51 0 reram_1t1r Tf0=3.300000e-09  $ G+=0.296uS
Xrpl1_2_52 row2 gate_l1 cpl1_52 0 reram_1t1r Tf0=3.300000e-09  $ G+=0.296uS
Xrpl1_2_53 row2 gate_l1 cpl1_53 0 reram_1t1r Tf0=3.300000e-09  $ G+=0.296uS
Xrpl1_2_54 row2 gate_l1 cpl1_54 0 reram_1t1r Tf0=3.300000e-09  $ G+=0.296uS
Xrpl1_2_55 row2 gate_l1 cpl1_55 0 reram_1t1r Tf0=4.075687e-09  $ G+=5.062uS
Xrpl1_2_56 row2 gate_l1 cpl1_56 0 reram_1t1r Tf0=3.385469e-09  $ G+=0.412uS
Xrpl1_2_57 row2 gate_l1 cpl1_57 0 reram_1t1r Tf0=4.319064e-09  $ G+=12.260uS
Xrpl1_2_58 row2 gate_l1 cpl1_58 0 reram_1t1r Tf0=4.101748e-09  $ G+=5.564uS
Xrpl1_2_59 row2 gate_l1 cpl1_59 0 reram_1t1r Tf0=3.997574e-09  $ G+=3.810uS
Xrpl1_2_60 row2 gate_l1 cpl1_60 0 reram_1t1r Tf0=4.268172e-09  $ G+=10.189uS
Xrpl1_2_61 row2 gate_l1 cpl1_61 0 reram_1t1r Tf0=3.300000e-09  $ G+=0.296uS
Xrpl1_2_62 row2 gate_l1 cpl1_62 0 reram_1t1r Tf0=3.300000e-09  $ G+=0.296uS
Xrpl1_2_63 row2 gate_l1 cpl1_63 0 reram_1t1r Tf0=3.300000e-09  $ G+=0.296uS
Xrpl1_3_0 row3 gate_l1 cpl1_0 0 reram_1t1r Tf0=3.300000e-09  $ G+=0.296uS
Xrpl1_3_1 row3 gate_l1 cpl1_1 0 reram_1t1r Tf0=3.549371e-09  $ G+=0.747uS
Xrpl1_3_2 row3 gate_l1 cpl1_2 0 reram_1t1r Tf0=3.300000e-09  $ G+=0.296uS
Xrpl1_3_3 row3 gate_l1 cpl1_3 0 reram_1t1r Tf0=3.300000e-09  $ G+=0.296uS
Xrpl1_3_4 row3 gate_l1 cpl1_4 0 reram_1t1r Tf0=4.331419e-09  $ G+=12.823uS
Xrpl1_3_5 row3 gate_l1 cpl1_5 0 reram_1t1r Tf0=3.893259e-09  $ G+=2.608uS
Xrpl1_3_6 row3 gate_l1 cpl1_6 0 reram_1t1r Tf0=3.618352e-09  $ G+=0.960uS
Xrpl1_3_7 row3 gate_l1 cpl1_7 0 reram_1t1r Tf0=3.968089e-09  $ G+=3.423uS
Xrpl1_3_8 row3 gate_l1 cpl1_8 0 reram_1t1r Tf0=3.300000e-09  $ G+=0.296uS
Xrpl1_3_9 row3 gate_l1 cpl1_9 0 reram_1t1r Tf0=3.300000e-09  $ G+=0.296uS
Xrpl1_3_10 row3 gate_l1 cpl1_10 0 reram_1t1r Tf0=3.300000e-09  $ G+=0.296uS
Xrpl1_3_11 row3 gate_l1 cpl1_11 0 reram_1t1r Tf0=4.332480e-09  $ G+=12.873uS
Xrpl1_3_12 row3 gate_l1 cpl1_12 0 reram_1t1r Tf0=3.881909e-09  $ G+=2.502uS
Xrpl1_3_13 row3 gate_l1 cpl1_13 0 reram_1t1r Tf0=3.300000e-09  $ G+=0.296uS
Xrpl1_3_14 row3 gate_l1 cpl1_14 0 reram_1t1r Tf0=3.300000e-09  $ G+=0.296uS
Xrpl1_3_15 row3 gate_l1 cpl1_15 0 reram_1t1r Tf0=3.300000e-09  $ G+=0.296uS
Xrpl1_3_16 row3 gate_l1 cpl1_16 0 reram_1t1r Tf0=3.300000e-09  $ G+=0.296uS
Xrpl1_3_17 row3 gate_l1 cpl1_17 0 reram_1t1r Tf0=3.300000e-09  $ G+=0.296uS
Xrpl1_3_18 row3 gate_l1 cpl1_18 0 reram_1t1r Tf0=3.710128e-09  $ G+=1.340uS
Xrpl1_3_19 row3 gate_l1 cpl1_19 0 reram_1t1r Tf0=3.779104e-09  $ G+=1.722uS
Xrpl1_3_20 row3 gate_l1 cpl1_20 0 reram_1t1r Tf0=3.300000e-09  $ G+=0.296uS
Xrpl1_3_21 row3 gate_l1 cpl1_21 0 reram_1t1r Tf0=3.644376e-09  $ G+=1.055uS
Xrpl1_3_22 row3 gate_l1 cpl1_22 0 reram_1t1r Tf0=4.465250e-09  $ G+=20.858uS
Xrpl1_3_23 row3 gate_l1 cpl1_23 0 reram_1t1r Tf0=3.300000e-09  $ G+=0.296uS
Xrpl1_3_24 row3 gate_l1 cpl1_24 0 reram_1t1r Tf0=3.300000e-09  $ G+=0.296uS
Xrpl1_3_25 row3 gate_l1 cpl1_25 0 reram_1t1r Tf0=3.300000e-09  $ G+=0.296uS
Xrpl1_3_26 row3 gate_l1 cpl1_26 0 reram_1t1r Tf0=4.619411e-09  $ G+=36.530uS
Xrpl1_3_27 row3 gate_l1 cpl1_27 0 reram_1t1r Tf0=3.300000e-09  $ G+=0.296uS
Xrpl1_3_28 row3 gate_l1 cpl1_28 0 reram_1t1r Tf0=3.620273e-09  $ G+=0.967uS
Xrpl1_3_29 row3 gate_l1 cpl1_29 0 reram_1t1r Tf0=3.300000e-09  $ G+=0.296uS
Xrpl1_3_30 row3 gate_l1 cpl1_30 0 reram_1t1r Tf0=3.300000e-09  $ G+=0.296uS
Xrpl1_3_31 row3 gate_l1 cpl1_31 0 reram_1t1r Tf0=3.300000e-09  $ G+=0.296uS
Xrpl1_3_32 row3 gate_l1 cpl1_32 0 reram_1t1r Tf0=3.300000e-09  $ G+=0.296uS
Xrpl1_3_33 row3 gate_l1 cpl1_33 0 reram_1t1r Tf0=3.825622e-09  $ G+=2.039uS
Xrpl1_3_34 row3 gate_l1 cpl1_34 0 reram_1t1r Tf0=4.050458e-09  $ G+=4.618uS
Xrpl1_3_35 row3 gate_l1 cpl1_35 0 reram_1t1r Tf0=3.300000e-09  $ G+=0.296uS
Xrpl1_3_36 row3 gate_l1 cpl1_36 0 reram_1t1r Tf0=4.180081e-09  $ G+=7.397uS
Xrpl1_3_37 row3 gate_l1 cpl1_37 0 reram_1t1r Tf0=3.965512e-09  $ G+=3.391uS
Xrpl1_3_38 row3 gate_l1 cpl1_38 0 reram_1t1r Tf0=4.283769e-09  $ G+=10.784uS
Xrpl1_3_39 row3 gate_l1 cpl1_39 0 reram_1t1r Tf0=3.915840e-09  $ G+=2.831uS
Xrpl1_3_40 row3 gate_l1 cpl1_40 0 reram_1t1r Tf0=3.300000e-09  $ G+=0.296uS
Xrpl1_3_41 row3 gate_l1 cpl1_41 0 reram_1t1r Tf0=3.300000e-09  $ G+=0.296uS
Xrpl1_3_42 row3 gate_l1 cpl1_42 0 reram_1t1r Tf0=3.300000e-09  $ G+=0.296uS
Xrpl1_3_43 row3 gate_l1 cpl1_43 0 reram_1t1r Tf0=3.300000e-09  $ G+=0.296uS
Xrpl1_3_44 row3 gate_l1 cpl1_44 0 reram_1t1r Tf0=3.300000e-09  $ G+=0.296uS
Xrpl1_3_45 row3 gate_l1 cpl1_45 0 reram_1t1r Tf0=3.300000e-09  $ G+=0.296uS
Xrpl1_3_46 row3 gate_l1 cpl1_46 0 reram_1t1r Tf0=3.447297e-09  $ G+=0.516uS
Xrpl1_3_47 row3 gate_l1 cpl1_47 0 reram_1t1r Tf0=3.300000e-09  $ G+=0.296uS
Xrpl1_3_48 row3 gate_l1 cpl1_48 0 reram_1t1r Tf0=4.273285e-09  $ G+=10.381uS
Xrpl1_3_49 row3 gate_l1 cpl1_49 0 reram_1t1r Tf0=4.331943e-09  $ G+=12.848uS
Xrpl1_3_50 row3 gate_l1 cpl1_50 0 reram_1t1r Tf0=4.430579e-09  $ G+=18.388uS
Xrpl1_3_51 row3 gate_l1 cpl1_51 0 reram_1t1r Tf0=3.353331e-09  $ G+=0.366uS
Xrpl1_3_52 row3 gate_l1 cpl1_52 0 reram_1t1r Tf0=3.300000e-09  $ G+=0.296uS
Xrpl1_3_53 row3 gate_l1 cpl1_53 0 reram_1t1r Tf0=4.473357e-09  $ G+=21.482uS
Xrpl1_3_54 row3 gate_l1 cpl1_54 0 reram_1t1r Tf0=3.762272e-09  $ G+=1.620uS
Xrpl1_3_55 row3 gate_l1 cpl1_55 0 reram_1t1r Tf0=4.279338e-09  $ G+=10.612uS
Xrpl1_3_56 row3 gate_l1 cpl1_56 0 reram_1t1r Tf0=4.527370e-09  $ G+=26.142uS
Xrpl1_3_57 row3 gate_l1 cpl1_57 0 reram_1t1r Tf0=4.319491e-09  $ G+=12.279uS
Xrpl1_3_58 row3 gate_l1 cpl1_58 0 reram_1t1r Tf0=3.300000e-09  $ G+=0.296uS
Xrpl1_3_59 row3 gate_l1 cpl1_59 0 reram_1t1r Tf0=3.300000e-09  $ G+=0.296uS
Xrpl1_3_60 row3 gate_l1 cpl1_60 0 reram_1t1r Tf0=4.451642e-09  $ G+=19.851uS
Xrpl1_3_61 row3 gate_l1 cpl1_61 0 reram_1t1r Tf0=3.304296e-09  $ G+=0.307uS
Xrpl1_3_62 row3 gate_l1 cpl1_62 0 reram_1t1r Tf0=3.443884e-09  $ G+=0.509uS
Xrpl1_3_63 row3 gate_l1 cpl1_63 0 reram_1t1r Tf0=3.441971e-09  $ G+=0.506uS
Xrpl1_4_0 row4 gate_l1 cpl1_0 0 reram_1t1r Tf0=3.300000e-09  $ G+=0.296uS
Xrpl1_4_1 row4 gate_l1 cpl1_1 0 reram_1t1r Tf0=3.839800e-09  $ G+=2.147uS
Xrpl1_4_2 row4 gate_l1 cpl1_2 0 reram_1t1r Tf0=3.300000e-09  $ G+=0.296uS
Xrpl1_4_3 row4 gate_l1 cpl1_3 0 reram_1t1r Tf0=3.300000e-09  $ G+=0.296uS
Xrpl1_4_4 row4 gate_l1 cpl1_4 0 reram_1t1r Tf0=4.554425e-09  $ G+=28.844uS
Xrpl1_4_5 row4 gate_l1 cpl1_5 0 reram_1t1r Tf0=4.297920e-09  $ G+=11.353uS
Xrpl1_4_6 row4 gate_l1 cpl1_6 0 reram_1t1r Tf0=3.300000e-09  $ G+=0.296uS
Xrpl1_4_7 row4 gate_l1 cpl1_7 0 reram_1t1r Tf0=3.300000e-09  $ G+=0.296uS
Xrpl1_4_8 row4 gate_l1 cpl1_8 0 reram_1t1r Tf0=3.300000e-09  $ G+=0.296uS
Xrpl1_4_9 row4 gate_l1 cpl1_9 0 reram_1t1r Tf0=4.430238e-09  $ G+=18.365uS
Xrpl1_4_10 row4 gate_l1 cpl1_10 0 reram_1t1r Tf0=3.300000e-09  $ G+=0.296uS
Xrpl1_4_11 row4 gate_l1 cpl1_11 0 reram_1t1r Tf0=4.155244e-09  $ G+=6.759uS
Xrpl1_4_12 row4 gate_l1 cpl1_12 0 reram_1t1r Tf0=3.300000e-09  $ G+=0.296uS
Xrpl1_4_13 row4 gate_l1 cpl1_13 0 reram_1t1r Tf0=3.300000e-09  $ G+=0.296uS
Xrpl1_4_14 row4 gate_l1 cpl1_14 0 reram_1t1r Tf0=4.453802e-09  $ G+=20.008uS
Xrpl1_4_15 row4 gate_l1 cpl1_15 0 reram_1t1r Tf0=3.967547e-09  $ G+=3.416uS
Xrpl1_4_16 row4 gate_l1 cpl1_16 0 reram_1t1r Tf0=3.300000e-09  $ G+=0.296uS
Xrpl1_4_17 row4 gate_l1 cpl1_17 0 reram_1t1r Tf0=4.212719e-09  $ G+=8.329uS
Xrpl1_4_18 row4 gate_l1 cpl1_18 0 reram_1t1r Tf0=3.300000e-09  $ G+=0.296uS
Xrpl1_4_19 row4 gate_l1 cpl1_19 0 reram_1t1r Tf0=3.898178e-09  $ G+=2.655uS
Xrpl1_4_20 row4 gate_l1 cpl1_20 0 reram_1t1r Tf0=4.362043e-09  $ G+=14.333uS
Xrpl1_4_21 row4 gate_l1 cpl1_21 0 reram_1t1r Tf0=4.613684e-09  $ G+=35.777uS
Xrpl1_4_22 row4 gate_l1 cpl1_22 0 reram_1t1r Tf0=4.465984e-09  $ G+=20.914uS
Xrpl1_4_23 row4 gate_l1 cpl1_23 0 reram_1t1r Tf0=4.629153e-09  $ G+=37.846uS
Xrpl1_4_24 row4 gate_l1 cpl1_24 0 reram_1t1r Tf0=4.379352e-09  $ G+=15.264uS
Xrpl1_4_25 row4 gate_l1 cpl1_25 0 reram_1t1r Tf0=4.299232e-09  $ G+=11.407uS
Xrpl1_4_26 row4 gate_l1 cpl1_26 0 reram_1t1r Tf0=4.356652e-09  $ G+=14.055uS
Xrpl1_4_27 row4 gate_l1 cpl1_27 0 reram_1t1r Tf0=3.300000e-09  $ G+=0.296uS
Xrpl1_4_28 row4 gate_l1 cpl1_28 0 reram_1t1r Tf0=3.885348e-09  $ G+=2.534uS
Xrpl1_4_29 row4 gate_l1 cpl1_29 0 reram_1t1r Tf0=3.300000e-09  $ G+=0.296uS
Xrpl1_4_30 row4 gate_l1 cpl1_30 0 reram_1t1r Tf0=3.300000e-09  $ G+=0.296uS
Xrpl1_4_31 row4 gate_l1 cpl1_31 0 reram_1t1r Tf0=3.300000e-09  $ G+=0.296uS
Xrpl1_4_32 row4 gate_l1 cpl1_32 0 reram_1t1r Tf0=3.300000e-09  $ G+=0.296uS
Xrpl1_4_33 row4 gate_l1 cpl1_33 0 reram_1t1r Tf0=4.144438e-09  $ G+=6.499uS
Xrpl1_4_34 row4 gate_l1 cpl1_34 0 reram_1t1r Tf0=3.300000e-09  $ G+=0.296uS
Xrpl1_4_35 row4 gate_l1 cpl1_35 0 reram_1t1r Tf0=3.300000e-09  $ G+=0.296uS
Xrpl1_4_36 row4 gate_l1 cpl1_36 0 reram_1t1r Tf0=4.476384e-09  $ G+=21.720uS
Xrpl1_4_37 row4 gate_l1 cpl1_37 0 reram_1t1r Tf0=3.989108e-09  $ G+=3.695uS
Xrpl1_4_38 row4 gate_l1 cpl1_38 0 reram_1t1r Tf0=3.300000e-09  $ G+=0.296uS
Xrpl1_4_39 row4 gate_l1 cpl1_39 0 reram_1t1r Tf0=4.153226e-09  $ G+=6.709uS
Xrpl1_4_40 row4 gate_l1 cpl1_40 0 reram_1t1r Tf0=3.300000e-09  $ G+=0.296uS
Xrpl1_4_41 row4 gate_l1 cpl1_41 0 reram_1t1r Tf0=3.300000e-09  $ G+=0.296uS
Xrpl1_4_42 row4 gate_l1 cpl1_42 0 reram_1t1r Tf0=3.300000e-09  $ G+=0.296uS
Xrpl1_4_43 row4 gate_l1 cpl1_43 0 reram_1t1r Tf0=3.300000e-09  $ G+=0.296uS
Xrpl1_4_44 row4 gate_l1 cpl1_44 0 reram_1t1r Tf0=3.300000e-09  $ G+=0.296uS
Xrpl1_4_45 row4 gate_l1 cpl1_45 0 reram_1t1r Tf0=3.459993e-09  $ G+=0.540uS
Xrpl1_4_46 row4 gate_l1 cpl1_46 0 reram_1t1r Tf0=4.478199e-09  $ G+=21.863uS
Xrpl1_4_47 row4 gate_l1 cpl1_47 0 reram_1t1r Tf0=4.511062e-09  $ G+=24.638uS
Xrpl1_4_48 row4 gate_l1 cpl1_48 0 reram_1t1r Tf0=3.300000e-09  $ G+=0.296uS
Xrpl1_4_49 row4 gate_l1 cpl1_49 0 reram_1t1r Tf0=4.206353e-09  $ G+=8.139uS
Xrpl1_4_50 row4 gate_l1 cpl1_50 0 reram_1t1r Tf0=3.300000e-09  $ G+=0.296uS
Xrpl1_4_51 row4 gate_l1 cpl1_51 0 reram_1t1r Tf0=3.389451e-09  $ G+=0.418uS
Xrpl1_4_52 row4 gate_l1 cpl1_52 0 reram_1t1r Tf0=4.449334e-09  $ G+=19.686uS
Xrpl1_4_53 row4 gate_l1 cpl1_53 0 reram_1t1r Tf0=3.300000e-09  $ G+=0.296uS
Xrpl1_4_54 row4 gate_l1 cpl1_54 0 reram_1t1r Tf0=3.300000e-09  $ G+=0.296uS
Xrpl1_4_55 row4 gate_l1 cpl1_55 0 reram_1t1r Tf0=3.300000e-09  $ G+=0.296uS
Xrpl1_4_56 row4 gate_l1 cpl1_56 0 reram_1t1r Tf0=3.300000e-09  $ G+=0.296uS
Xrpl1_4_57 row4 gate_l1 cpl1_57 0 reram_1t1r Tf0=4.473157e-09  $ G+=21.466uS
Xrpl1_4_58 row4 gate_l1 cpl1_58 0 reram_1t1r Tf0=3.890545e-09  $ G+=2.582uS
Xrpl1_4_59 row4 gate_l1 cpl1_59 0 reram_1t1r Tf0=3.300000e-09  $ G+=0.296uS
Xrpl1_4_60 row4 gate_l1 cpl1_60 0 reram_1t1r Tf0=3.300000e-09  $ G+=0.296uS
Xrpl1_4_61 row4 gate_l1 cpl1_61 0 reram_1t1r Tf0=3.300000e-09  $ G+=0.296uS
Xrpl1_4_62 row4 gate_l1 cpl1_62 0 reram_1t1r Tf0=3.784168e-09  $ G+=1.754uS
Xrpl1_4_63 row4 gate_l1 cpl1_63 0 reram_1t1r Tf0=3.300000e-09  $ G+=0.296uS
Xrpl1_5_0 row5 gate_l1 cpl1_0 0 reram_1t1r Tf0=3.300000e-09  $ G+=0.296uS
Xrpl1_5_1 row5 gate_l1 cpl1_1 0 reram_1t1r Tf0=4.367591e-09  $ G+=14.625uS
Xrpl1_5_2 row5 gate_l1 cpl1_2 0 reram_1t1r Tf0=4.189670e-09  $ G+=7.660uS
Xrpl1_5_3 row5 gate_l1 cpl1_3 0 reram_1t1r Tf0=3.300000e-09  $ G+=0.296uS
Xrpl1_5_4 row5 gate_l1 cpl1_4 0 reram_1t1r Tf0=4.373745e-09  $ G+=14.956uS
Xrpl1_5_5 row5 gate_l1 cpl1_5 0 reram_1t1r Tf0=3.300000e-09  $ G+=0.296uS
Xrpl1_5_6 row5 gate_l1 cpl1_6 0 reram_1t1r Tf0=3.300000e-09  $ G+=0.296uS
Xrpl1_5_7 row5 gate_l1 cpl1_7 0 reram_1t1r Tf0=3.300000e-09  $ G+=0.296uS
Xrpl1_5_8 row5 gate_l1 cpl1_8 0 reram_1t1r Tf0=3.300000e-09  $ G+=0.296uS
Xrpl1_5_9 row5 gate_l1 cpl1_9 0 reram_1t1r Tf0=3.300000e-09  $ G+=0.296uS
Xrpl1_5_10 row5 gate_l1 cpl1_10 0 reram_1t1r Tf0=3.300000e-09  $ G+=0.296uS
Xrpl1_5_11 row5 gate_l1 cpl1_11 0 reram_1t1r Tf0=4.187337e-09  $ G+=7.595uS
Xrpl1_5_12 row5 gate_l1 cpl1_12 0 reram_1t1r Tf0=3.300000e-09  $ G+=0.296uS
Xrpl1_5_13 row5 gate_l1 cpl1_13 0 reram_1t1r Tf0=3.300000e-09  $ G+=0.296uS
Xrpl1_5_14 row5 gate_l1 cpl1_14 0 reram_1t1r Tf0=3.300000e-09  $ G+=0.296uS
Xrpl1_5_15 row5 gate_l1 cpl1_15 0 reram_1t1r Tf0=3.300000e-09  $ G+=0.296uS
Xrpl1_5_16 row5 gate_l1 cpl1_16 0 reram_1t1r Tf0=4.562517e-09  $ G+=29.705uS
Xrpl1_5_17 row5 gate_l1 cpl1_17 0 reram_1t1r Tf0=4.402053e-09  $ G+=16.577uS
Xrpl1_5_18 row5 gate_l1 cpl1_18 0 reram_1t1r Tf0=4.003281e-09  $ G+=3.890uS
Xrpl1_5_19 row5 gate_l1 cpl1_19 0 reram_1t1r Tf0=3.300000e-09  $ G+=0.296uS
Xrpl1_5_20 row5 gate_l1 cpl1_20 0 reram_1t1r Tf0=3.300000e-09  $ G+=0.296uS
Xrpl1_5_21 row5 gate_l1 cpl1_21 0 reram_1t1r Tf0=4.157232e-09  $ G+=6.808uS
Xrpl1_5_22 row5 gate_l1 cpl1_22 0 reram_1t1r Tf0=3.300000e-09  $ G+=0.296uS
Xrpl1_5_23 row5 gate_l1 cpl1_23 0 reram_1t1r Tf0=4.243341e-09  $ G+=9.310uS
Xrpl1_5_24 row5 gate_l1 cpl1_24 0 reram_1t1r Tf0=3.300000e-09  $ G+=0.296uS
Xrpl1_5_25 row5 gate_l1 cpl1_25 0 reram_1t1r Tf0=3.300000e-09  $ G+=0.296uS
Xrpl1_5_26 row5 gate_l1 cpl1_26 0 reram_1t1r Tf0=3.300000e-09  $ G+=0.296uS
Xrpl1_5_27 row5 gate_l1 cpl1_27 0 reram_1t1r Tf0=3.300000e-09  $ G+=0.296uS
Xrpl1_5_28 row5 gate_l1 cpl1_28 0 reram_1t1r Tf0=3.300000e-09  $ G+=0.296uS
Xrpl1_5_29 row5 gate_l1 cpl1_29 0 reram_1t1r Tf0=4.609868e-09  $ G+=35.284uS
Xrpl1_5_30 row5 gate_l1 cpl1_30 0 reram_1t1r Tf0=4.120578e-09  $ G+=5.959uS
Xrpl1_5_31 row5 gate_l1 cpl1_31 0 reram_1t1r Tf0=4.194575e-09  $ G+=7.798uS
Xrpl1_5_32 row5 gate_l1 cpl1_32 0 reram_1t1r Tf0=3.726321e-09  $ G+=1.421uS
Xrpl1_5_33 row5 gate_l1 cpl1_33 0 reram_1t1r Tf0=3.300000e-09  $ G+=0.296uS
Xrpl1_5_34 row5 gate_l1 cpl1_34 0 reram_1t1r Tf0=3.300000e-09  $ G+=0.296uS
Xrpl1_5_35 row5 gate_l1 cpl1_35 0 reram_1t1r Tf0=3.300000e-09  $ G+=0.296uS
Xrpl1_5_36 row5 gate_l1 cpl1_36 0 reram_1t1r Tf0=3.300000e-09  $ G+=0.296uS
Xrpl1_5_37 row5 gate_l1 cpl1_37 0 reram_1t1r Tf0=4.076827e-09  $ G+=5.083uS
Xrpl1_5_38 row5 gate_l1 cpl1_38 0 reram_1t1r Tf0=4.411659e-09  $ G+=17.166uS
Xrpl1_5_39 row5 gate_l1 cpl1_39 0 reram_1t1r Tf0=4.240407e-09  $ G+=9.211uS
Xrpl1_5_40 row5 gate_l1 cpl1_40 0 reram_1t1r Tf0=3.300000e-09  $ G+=0.296uS
Xrpl1_5_41 row5 gate_l1 cpl1_41 0 reram_1t1r Tf0=3.300000e-09  $ G+=0.296uS
Xrpl1_5_42 row5 gate_l1 cpl1_42 0 reram_1t1r Tf0=3.886365e-09  $ G+=2.543uS
Xrpl1_5_43 row5 gate_l1 cpl1_43 0 reram_1t1r Tf0=3.300000e-09  $ G+=0.296uS
Xrpl1_5_44 row5 gate_l1 cpl1_44 0 reram_1t1r Tf0=4.018835e-09  $ G+=4.116uS
Xrpl1_5_45 row5 gate_l1 cpl1_45 0 reram_1t1r Tf0=3.300000e-09  $ G+=0.296uS
Xrpl1_5_46 row5 gate_l1 cpl1_46 0 reram_1t1r Tf0=4.307302e-09  $ G+=11.747uS
Xrpl1_5_47 row5 gate_l1 cpl1_47 0 reram_1t1r Tf0=3.300000e-09  $ G+=0.296uS
Xrpl1_5_48 row5 gate_l1 cpl1_48 0 reram_1t1r Tf0=3.300000e-09  $ G+=0.296uS
Xrpl1_5_49 row5 gate_l1 cpl1_49 0 reram_1t1r Tf0=3.300000e-09  $ G+=0.296uS
Xrpl1_5_50 row5 gate_l1 cpl1_50 0 reram_1t1r Tf0=3.300000e-09  $ G+=0.296uS
Xrpl1_5_51 row5 gate_l1 cpl1_51 0 reram_1t1r Tf0=3.300000e-09  $ G+=0.296uS
Xrpl1_5_52 row5 gate_l1 cpl1_52 0 reram_1t1r Tf0=3.717338e-09  $ G+=1.376uS
Xrpl1_5_53 row5 gate_l1 cpl1_53 0 reram_1t1r Tf0=3.806026e-09  $ G+=1.899uS
Xrpl1_5_54 row5 gate_l1 cpl1_54 0 reram_1t1r Tf0=3.300000e-09  $ G+=0.296uS
Xrpl1_5_55 row5 gate_l1 cpl1_55 0 reram_1t1r Tf0=3.300000e-09  $ G+=0.296uS
Xrpl1_5_56 row5 gate_l1 cpl1_56 0 reram_1t1r Tf0=4.545440e-09  $ G+=27.917uS
Xrpl1_5_57 row5 gate_l1 cpl1_57 0 reram_1t1r Tf0=3.300000e-09  $ G+=0.296uS
Xrpl1_5_58 row5 gate_l1 cpl1_58 0 reram_1t1r Tf0=4.536288e-09  $ G+=27.003uS
Xrpl1_5_59 row5 gate_l1 cpl1_59 0 reram_1t1r Tf0=3.300000e-09  $ G+=0.296uS
Xrpl1_5_60 row5 gate_l1 cpl1_60 0 reram_1t1r Tf0=3.300000e-09  $ G+=0.296uS
Xrpl1_5_61 row5 gate_l1 cpl1_61 0 reram_1t1r Tf0=4.439701e-09  $ G+=19.008uS
Xrpl1_5_62 row5 gate_l1 cpl1_62 0 reram_1t1r Tf0=3.300000e-09  $ G+=0.296uS
Xrpl1_5_63 row5 gate_l1 cpl1_63 0 reram_1t1r Tf0=4.515010e-09  $ G+=24.994uS
Xrpl1_6_0 row6 gate_l1 cpl1_0 0 reram_1t1r Tf0=4.177780e-09  $ G+=7.336uS
Xrpl1_6_1 row6 gate_l1 cpl1_1 0 reram_1t1r Tf0=4.100057e-09  $ G+=5.530uS
Xrpl1_6_2 row6 gate_l1 cpl1_2 0 reram_1t1r Tf0=3.823350e-09  $ G+=2.023uS
Xrpl1_6_3 row6 gate_l1 cpl1_3 0 reram_1t1r Tf0=3.300000e-09  $ G+=0.296uS
Xrpl1_6_4 row6 gate_l1 cpl1_4 0 reram_1t1r Tf0=4.497898e-09  $ G+=23.486uS
Xrpl1_6_5 row6 gate_l1 cpl1_5 0 reram_1t1r Tf0=4.375284e-09  $ G+=15.040uS
Xrpl1_6_6 row6 gate_l1 cpl1_6 0 reram_1t1r Tf0=4.703093e-09  $ G+=49.517uS
Xrpl1_6_7 row6 gate_l1 cpl1_7 0 reram_1t1r Tf0=3.300000e-09  $ G+=0.296uS
Xrpl1_6_8 row6 gate_l1 cpl1_8 0 reram_1t1r Tf0=3.300000e-09  $ G+=0.296uS
Xrpl1_6_9 row6 gate_l1 cpl1_9 0 reram_1t1r Tf0=4.389824e-09  $ G+=15.856uS
Xrpl1_6_10 row6 gate_l1 cpl1_10 0 reram_1t1r Tf0=3.300000e-09  $ G+=0.296uS
Xrpl1_6_11 row6 gate_l1 cpl1_11 0 reram_1t1r Tf0=4.272043e-09  $ G+=10.334uS
Xrpl1_6_12 row6 gate_l1 cpl1_12 0 reram_1t1r Tf0=3.300000e-09  $ G+=0.296uS
Xrpl1_6_13 row6 gate_l1 cpl1_13 0 reram_1t1r Tf0=3.300000e-09  $ G+=0.296uS
Xrpl1_6_14 row6 gate_l1 cpl1_14 0 reram_1t1r Tf0=3.300000e-09  $ G+=0.296uS
Xrpl1_6_15 row6 gate_l1 cpl1_15 0 reram_1t1r Tf0=4.556828e-09  $ G+=29.097uS
Xrpl1_6_16 row6 gate_l1 cpl1_16 0 reram_1t1r Tf0=4.248713e-09  $ G+=9.494uS
Xrpl1_6_17 row6 gate_l1 cpl1_17 0 reram_1t1r Tf0=4.139287e-09  $ G+=6.378uS
Xrpl1_6_18 row6 gate_l1 cpl1_18 0 reram_1t1r Tf0=3.808437e-09  $ G+=1.916uS
Xrpl1_6_19 row6 gate_l1 cpl1_19 0 reram_1t1r Tf0=4.373223e-09  $ G+=14.928uS
Xrpl1_6_20 row6 gate_l1 cpl1_20 0 reram_1t1r Tf0=3.300000e-09  $ G+=0.296uS
Xrpl1_6_21 row6 gate_l1 cpl1_21 0 reram_1t1r Tf0=4.693220e-09  $ G+=47.771uS
Xrpl1_6_22 row6 gate_l1 cpl1_22 0 reram_1t1r Tf0=4.035865e-09  $ G+=4.379uS
Xrpl1_6_23 row6 gate_l1 cpl1_23 0 reram_1t1r Tf0=3.300000e-09  $ G+=0.296uS
Xrpl1_6_24 row6 gate_l1 cpl1_24 0 reram_1t1r Tf0=4.598405e-09  $ G+=33.844uS
Xrpl1_6_25 row6 gate_l1 cpl1_25 0 reram_1t1r Tf0=3.300000e-09  $ G+=0.296uS
Xrpl1_6_26 row6 gate_l1 cpl1_26 0 reram_1t1r Tf0=3.300000e-09  $ G+=0.296uS
Xrpl1_6_27 row6 gate_l1 cpl1_27 0 reram_1t1r Tf0=3.300000e-09  $ G+=0.296uS
Xrpl1_6_28 row6 gate_l1 cpl1_28 0 reram_1t1r Tf0=4.390460e-09  $ G+=15.893uS
Xrpl1_6_29 row6 gate_l1 cpl1_29 0 reram_1t1r Tf0=4.049472e-09  $ G+=4.601uS
Xrpl1_6_30 row6 gate_l1 cpl1_30 0 reram_1t1r Tf0=3.300000e-09  $ G+=0.296uS
Xrpl1_6_31 row6 gate_l1 cpl1_31 0 reram_1t1r Tf0=4.202303e-09  $ G+=8.020uS
Xrpl1_6_32 row6 gate_l1 cpl1_32 0 reram_1t1r Tf0=3.300000e-09  $ G+=0.296uS
Xrpl1_6_33 row6 gate_l1 cpl1_33 0 reram_1t1r Tf0=3.300000e-09  $ G+=0.296uS
Xrpl1_6_34 row6 gate_l1 cpl1_34 0 reram_1t1r Tf0=3.300000e-09  $ G+=0.296uS
Xrpl1_6_35 row6 gate_l1 cpl1_35 0 reram_1t1r Tf0=3.300000e-09  $ G+=0.296uS
Xrpl1_6_36 row6 gate_l1 cpl1_36 0 reram_1t1r Tf0=4.368325e-09  $ G+=14.664uS
Xrpl1_6_37 row6 gate_l1 cpl1_37 0 reram_1t1r Tf0=4.496783e-09  $ G+=23.391uS
Xrpl1_6_38 row6 gate_l1 cpl1_38 0 reram_1t1r Tf0=3.300000e-09  $ G+=0.296uS
Xrpl1_6_39 row6 gate_l1 cpl1_39 0 reram_1t1r Tf0=4.074276e-09  $ G+=5.036uS
Xrpl1_6_40 row6 gate_l1 cpl1_40 0 reram_1t1r Tf0=3.300000e-09  $ G+=0.296uS
Xrpl1_6_41 row6 gate_l1 cpl1_41 0 reram_1t1r Tf0=3.300000e-09  $ G+=0.296uS
Xrpl1_6_42 row6 gate_l1 cpl1_42 0 reram_1t1r Tf0=4.143367e-09  $ G+=6.473uS
Xrpl1_6_43 row6 gate_l1 cpl1_43 0 reram_1t1r Tf0=3.300000e-09  $ G+=0.296uS
Xrpl1_6_44 row6 gate_l1 cpl1_44 0 reram_1t1r Tf0=3.300000e-09  $ G+=0.296uS
Xrpl1_6_45 row6 gate_l1 cpl1_45 0 reram_1t1r Tf0=3.300000e-09  $ G+=0.296uS
Xrpl1_6_46 row6 gate_l1 cpl1_46 0 reram_1t1r Tf0=3.300000e-09  $ G+=0.296uS
Xrpl1_6_47 row6 gate_l1 cpl1_47 0 reram_1t1r Tf0=4.520437e-09  $ G+=25.492uS
Xrpl1_6_48 row6 gate_l1 cpl1_48 0 reram_1t1r Tf0=4.009232e-09  $ G+=3.975uS
Xrpl1_6_49 row6 gate_l1 cpl1_49 0 reram_1t1r Tf0=3.300000e-09  $ G+=0.296uS
Xrpl1_6_50 row6 gate_l1 cpl1_50 0 reram_1t1r Tf0=3.300000e-09  $ G+=0.296uS
Xrpl1_6_51 row6 gate_l1 cpl1_51 0 reram_1t1r Tf0=3.300000e-09  $ G+=0.296uS
Xrpl1_6_52 row6 gate_l1 cpl1_52 0 reram_1t1r Tf0=3.300000e-09  $ G+=0.296uS
Xrpl1_6_53 row6 gate_l1 cpl1_53 0 reram_1t1r Tf0=3.300000e-09  $ G+=0.296uS
Xrpl1_6_54 row6 gate_l1 cpl1_54 0 reram_1t1r Tf0=4.105044e-09  $ G+=5.632uS
Xrpl1_6_55 row6 gate_l1 cpl1_55 0 reram_1t1r Tf0=3.300000e-09  $ G+=0.296uS
Xrpl1_6_56 row6 gate_l1 cpl1_56 0 reram_1t1r Tf0=4.255491e-09  $ G+=9.730uS
Xrpl1_6_57 row6 gate_l1 cpl1_57 0 reram_1t1r Tf0=4.152617e-09  $ G+=6.695uS
Xrpl1_6_58 row6 gate_l1 cpl1_58 0 reram_1t1r Tf0=4.115949e-09  $ G+=5.859uS
Xrpl1_6_59 row6 gate_l1 cpl1_59 0 reram_1t1r Tf0=3.300000e-09  $ G+=0.296uS
Xrpl1_6_60 row6 gate_l1 cpl1_60 0 reram_1t1r Tf0=3.300000e-09  $ G+=0.296uS
Xrpl1_6_61 row6 gate_l1 cpl1_61 0 reram_1t1r Tf0=3.300000e-09  $ G+=0.296uS
Xrpl1_6_62 row6 gate_l1 cpl1_62 0 reram_1t1r Tf0=3.487029e-09  $ G+=0.596uS
Xrpl1_6_63 row6 gate_l1 cpl1_63 0 reram_1t1r Tf0=3.300000e-09  $ G+=0.296uS
Xrpl1_7_0 row7 gate_l1 cpl1_0 0 reram_1t1r Tf0=4.327652e-09  $ G+=12.649uS
Xrpl1_7_1 row7 gate_l1 cpl1_1 0 reram_1t1r Tf0=3.300000e-09  $ G+=0.296uS
Xrpl1_7_2 row7 gate_l1 cpl1_2 0 reram_1t1r Tf0=4.466758e-09  $ G+=20.973uS
Xrpl1_7_3 row7 gate_l1 cpl1_3 0 reram_1t1r Tf0=3.300000e-09  $ G+=0.296uS
Xrpl1_7_4 row7 gate_l1 cpl1_4 0 reram_1t1r Tf0=3.300000e-09  $ G+=0.296uS
Xrpl1_7_5 row7 gate_l1 cpl1_5 0 reram_1t1r Tf0=4.308368e-09  $ G+=11.793uS
Xrpl1_7_6 row7 gate_l1 cpl1_6 0 reram_1t1r Tf0=4.367943e-09  $ G+=14.644uS
Xrpl1_7_7 row7 gate_l1 cpl1_7 0 reram_1t1r Tf0=4.379431e-09  $ G+=15.268uS
Xrpl1_7_8 row7 gate_l1 cpl1_8 0 reram_1t1r Tf0=3.300000e-09  $ G+=0.296uS
Xrpl1_7_9 row7 gate_l1 cpl1_9 0 reram_1t1r Tf0=4.376785e-09  $ G+=15.122uS
Xrpl1_7_10 row7 gate_l1 cpl1_10 0 reram_1t1r Tf0=3.300000e-09  $ G+=0.296uS
Xrpl1_7_11 row7 gate_l1 cpl1_11 0 reram_1t1r Tf0=3.300000e-09  $ G+=0.296uS
Xrpl1_7_12 row7 gate_l1 cpl1_12 0 reram_1t1r Tf0=3.300000e-09  $ G+=0.296uS
Xrpl1_7_13 row7 gate_l1 cpl1_13 0 reram_1t1r Tf0=3.937007e-09  $ G+=3.057uS
Xrpl1_7_14 row7 gate_l1 cpl1_14 0 reram_1t1r Tf0=4.543444e-09  $ G+=27.715uS
Xrpl1_7_15 row7 gate_l1 cpl1_15 0 reram_1t1r Tf0=4.469689e-09  $ G+=21.197uS
Xrpl1_7_16 row7 gate_l1 cpl1_16 0 reram_1t1r Tf0=4.225191e-09  $ G+=8.716uS
Xrpl1_7_17 row7 gate_l1 cpl1_17 0 reram_1t1r Tf0=3.300000e-09  $ G+=0.296uS
Xrpl1_7_18 row7 gate_l1 cpl1_18 0 reram_1t1r Tf0=3.300000e-09  $ G+=0.296uS
Xrpl1_7_19 row7 gate_l1 cpl1_19 0 reram_1t1r Tf0=3.300000e-09  $ G+=0.296uS
Xrpl1_7_20 row7 gate_l1 cpl1_20 0 reram_1t1r Tf0=3.300000e-09  $ G+=0.296uS
Xrpl1_7_21 row7 gate_l1 cpl1_21 0 reram_1t1r Tf0=4.600782e-09  $ G+=34.138uS
Xrpl1_7_22 row7 gate_l1 cpl1_22 0 reram_1t1r Tf0=3.300000e-09  $ G+=0.296uS
Xrpl1_7_23 row7 gate_l1 cpl1_23 0 reram_1t1r Tf0=4.500086e-09  $ G+=23.674uS
Xrpl1_7_24 row7 gate_l1 cpl1_24 0 reram_1t1r Tf0=3.300000e-09  $ G+=0.296uS
Xrpl1_7_25 row7 gate_l1 cpl1_25 0 reram_1t1r Tf0=4.264534e-09  $ G+=10.056uS
Xrpl1_7_26 row7 gate_l1 cpl1_26 0 reram_1t1r Tf0=4.600703e-09  $ G+=34.128uS
Xrpl1_7_27 row7 gate_l1 cpl1_27 0 reram_1t1r Tf0=4.720578e-09  $ G+=52.766uS
Xrpl1_7_28 row7 gate_l1 cpl1_28 0 reram_1t1r Tf0=3.300000e-09  $ G+=0.296uS
Xrpl1_7_29 row7 gate_l1 cpl1_29 0 reram_1t1r Tf0=3.300000e-09  $ G+=0.296uS
Xrpl1_7_30 row7 gate_l1 cpl1_30 0 reram_1t1r Tf0=4.632507e-09  $ G+=38.311uS
Xrpl1_7_31 row7 gate_l1 cpl1_31 0 reram_1t1r Tf0=3.300000e-09  $ G+=0.296uS
Xrpl1_7_32 row7 gate_l1 cpl1_32 0 reram_1t1r Tf0=4.444929e-09  $ G+=19.373uS
Xrpl1_7_33 row7 gate_l1 cpl1_33 0 reram_1t1r Tf0=4.605767e-09  $ G+=34.762uS
Xrpl1_7_34 row7 gate_l1 cpl1_34 0 reram_1t1r Tf0=3.300000e-09  $ G+=0.296uS
Xrpl1_7_35 row7 gate_l1 cpl1_35 0 reram_1t1r Tf0=4.378324e-09  $ G+=15.207uS
Xrpl1_7_36 row7 gate_l1 cpl1_36 0 reram_1t1r Tf0=3.300000e-09  $ G+=0.296uS
Xrpl1_7_37 row7 gate_l1 cpl1_37 0 reram_1t1r Tf0=4.418096e-09  $ G+=17.572uS
Xrpl1_7_38 row7 gate_l1 cpl1_38 0 reram_1t1r Tf0=3.300000e-09  $ G+=0.296uS
Xrpl1_7_39 row7 gate_l1 cpl1_39 0 reram_1t1r Tf0=3.300000e-09  $ G+=0.296uS
Xrpl1_7_40 row7 gate_l1 cpl1_40 0 reram_1t1r Tf0=3.435049e-09  $ G+=0.493uS
Xrpl1_7_41 row7 gate_l1 cpl1_41 0 reram_1t1r Tf0=3.776707e-09  $ G+=1.707uS
Xrpl1_7_42 row7 gate_l1 cpl1_42 0 reram_1t1r Tf0=4.225309e-09  $ G+=8.719uS
Xrpl1_7_43 row7 gate_l1 cpl1_43 0 reram_1t1r Tf0=4.337914e-09  $ G+=13.130uS
Xrpl1_7_44 row7 gate_l1 cpl1_44 0 reram_1t1r Tf0=3.300000e-09  $ G+=0.296uS
Xrpl1_7_45 row7 gate_l1 cpl1_45 0 reram_1t1r Tf0=3.300000e-09  $ G+=0.296uS
Xrpl1_7_46 row7 gate_l1 cpl1_46 0 reram_1t1r Tf0=4.082267e-09  $ G+=5.184uS
Xrpl1_7_47 row7 gate_l1 cpl1_47 0 reram_1t1r Tf0=3.300000e-09  $ G+=0.296uS
Xrpl1_7_48 row7 gate_l1 cpl1_48 0 reram_1t1r Tf0=4.340808e-09  $ G+=13.268uS
Xrpl1_7_49 row7 gate_l1 cpl1_49 0 reram_1t1r Tf0=3.300000e-09  $ G+=0.296uS
Xrpl1_7_50 row7 gate_l1 cpl1_50 0 reram_1t1r Tf0=3.975262e-09  $ G+=3.514uS
Xrpl1_7_51 row7 gate_l1 cpl1_51 0 reram_1t1r Tf0=4.754940e-09  $ G+=59.786uS
Xrpl1_7_52 row7 gate_l1 cpl1_52 0 reram_1t1r Tf0=4.284590e-09  $ G+=10.816uS
Xrpl1_7_53 row7 gate_l1 cpl1_53 0 reram_1t1r Tf0=3.300000e-09  $ G+=0.296uS
Xrpl1_7_54 row7 gate_l1 cpl1_54 0 reram_1t1r Tf0=3.300000e-09  $ G+=0.296uS
Xrpl1_7_55 row7 gate_l1 cpl1_55 0 reram_1t1r Tf0=4.604617e-09  $ G+=34.617uS
Xrpl1_7_56 row7 gate_l1 cpl1_56 0 reram_1t1r Tf0=3.300000e-09  $ G+=0.296uS
Xrpl1_7_57 row7 gate_l1 cpl1_57 0 reram_1t1r Tf0=3.300000e-09  $ G+=0.296uS
Xrpl1_7_58 row7 gate_l1 cpl1_58 0 reram_1t1r Tf0=3.795417e-09  $ G+=1.827uS
Xrpl1_7_59 row7 gate_l1 cpl1_59 0 reram_1t1r Tf0=3.990062e-09  $ G+=3.708uS
Xrpl1_7_60 row7 gate_l1 cpl1_60 0 reram_1t1r Tf0=4.603435e-09  $ G+=34.469uS
Xrpl1_7_61 row7 gate_l1 cpl1_61 0 reram_1t1r Tf0=4.411944e-09  $ G+=17.184uS
Xrpl1_7_62 row7 gate_l1 cpl1_62 0 reram_1t1r Tf0=3.300000e-09  $ G+=0.296uS
Xrpl1_7_63 row7 gate_l1 cpl1_63 0 reram_1t1r Tf0=4.377861e-09  $ G+=15.181uS

* --- Negative conductance array ---
Xrnl1_0_0 row0 gate_l1 cnl1_0 0 reram_1t1r Tf0=4.561113e-09  $ G-=29.554uS
Xrnl1_0_1 row0 gate_l1 cnl1_1 0 reram_1t1r Tf0=3.300000e-09  $ G-=0.296uS
Xrnl1_0_2 row0 gate_l1 cnl1_2 0 reram_1t1r Tf0=3.300000e-09  $ G-=0.296uS
Xrnl1_0_3 row0 gate_l1 cnl1_3 0 reram_1t1r Tf0=3.300000e-09  $ G-=0.296uS
Xrnl1_0_4 row0 gate_l1 cnl1_4 0 reram_1t1r Tf0=4.202811e-09  $ G-=8.035uS
Xrnl1_0_5 row0 gate_l1 cnl1_5 0 reram_1t1r Tf0=4.277936e-09  $ G-=10.558uS
Xrnl1_0_6 row0 gate_l1 cnl1_6 0 reram_1t1r Tf0=4.237389e-09  $ G-=9.111uS
Xrnl1_0_7 row0 gate_l1 cnl1_7 0 reram_1t1r Tf0=3.300000e-09  $ G-=0.296uS
Xrnl1_0_8 row0 gate_l1 cnl1_8 0 reram_1t1r Tf0=3.300000e-09  $ G-=0.296uS
Xrnl1_0_9 row0 gate_l1 cnl1_9 0 reram_1t1r Tf0=4.467528e-09  $ G-=21.032uS
Xrnl1_0_10 row0 gate_l1 cnl1_10 0 reram_1t1r Tf0=4.579036e-09  $ G-=31.543uS
Xrnl1_0_11 row0 gate_l1 cnl1_11 0 reram_1t1r Tf0=3.300000e-09  $ G-=0.296uS
Xrnl1_0_12 row0 gate_l1 cnl1_12 0 reram_1t1r Tf0=3.300000e-09  $ G-=0.296uS
Xrnl1_0_13 row0 gate_l1 cnl1_13 0 reram_1t1r Tf0=3.300000e-09  $ G-=0.296uS
Xrnl1_0_14 row0 gate_l1 cnl1_14 0 reram_1t1r Tf0=4.599660e-09  $ G-=33.999uS
Xrnl1_0_15 row0 gate_l1 cnl1_15 0 reram_1t1r Tf0=4.478286e-09  $ G-=21.870uS
Xrnl1_0_16 row0 gate_l1 cnl1_16 0 reram_1t1r Tf0=4.358477e-09  $ G-=14.149uS
Xrnl1_0_17 row0 gate_l1 cnl1_17 0 reram_1t1r Tf0=3.300000e-09  $ G-=0.296uS
Xrnl1_0_18 row0 gate_l1 cnl1_18 0 reram_1t1r Tf0=3.300000e-09  $ G-=0.296uS
Xrnl1_0_19 row0 gate_l1 cnl1_19 0 reram_1t1r Tf0=3.300000e-09  $ G-=0.296uS
Xrnl1_0_20 row0 gate_l1 cnl1_20 0 reram_1t1r Tf0=3.300000e-09  $ G-=0.296uS
Xrnl1_0_21 row0 gate_l1 cnl1_21 0 reram_1t1r Tf0=4.410181e-09  $ G-=17.074uS
Xrnl1_0_22 row0 gate_l1 cnl1_22 0 reram_1t1r Tf0=4.415439e-09  $ G-=17.404uS
Xrnl1_0_23 row0 gate_l1 cnl1_23 0 reram_1t1r Tf0=3.300000e-09  $ G-=0.296uS
Xrnl1_0_24 row0 gate_l1 cnl1_24 0 reram_1t1r Tf0=4.319045e-09  $ G-=12.259uS
Xrnl1_0_25 row0 gate_l1 cnl1_25 0 reram_1t1r Tf0=3.300000e-09  $ G-=0.296uS
Xrnl1_0_26 row0 gate_l1 cnl1_26 0 reram_1t1r Tf0=4.113370e-09  $ G-=5.805uS
Xrnl1_0_27 row0 gate_l1 cnl1_27 0 reram_1t1r Tf0=3.300000e-09  $ G-=0.296uS
Xrnl1_0_28 row0 gate_l1 cnl1_28 0 reram_1t1r Tf0=3.916056e-09  $ G-=2.833uS
Xrnl1_0_29 row0 gate_l1 cnl1_29 0 reram_1t1r Tf0=4.628757e-09  $ G-=37.792uS
Xrnl1_0_30 row0 gate_l1 cnl1_30 0 reram_1t1r Tf0=4.423629e-09  $ G-=17.929uS
Xrnl1_0_31 row0 gate_l1 cnl1_31 0 reram_1t1r Tf0=3.300000e-09  $ G-=0.296uS
Xrnl1_0_32 row0 gate_l1 cnl1_32 0 reram_1t1r Tf0=4.700970e-09  $ G-=49.136uS
Xrnl1_0_33 row0 gate_l1 cnl1_33 0 reram_1t1r Tf0=3.300000e-09  $ G-=0.296uS
Xrnl1_0_34 row0 gate_l1 cnl1_34 0 reram_1t1r Tf0=3.300000e-09  $ G-=0.296uS
Xrnl1_0_35 row0 gate_l1 cnl1_35 0 reram_1t1r Tf0=3.300000e-09  $ G-=0.296uS
Xrnl1_0_36 row0 gate_l1 cnl1_36 0 reram_1t1r Tf0=3.300000e-09  $ G-=0.296uS
Xrnl1_0_37 row0 gate_l1 cnl1_37 0 reram_1t1r Tf0=4.536328e-09  $ G-=27.007uS
Xrnl1_0_38 row0 gate_l1 cnl1_38 0 reram_1t1r Tf0=4.379166e-09  $ G-=15.254uS
Xrnl1_0_39 row0 gate_l1 cnl1_39 0 reram_1t1r Tf0=3.300000e-09  $ G-=0.296uS
Xrnl1_0_40 row0 gate_l1 cnl1_40 0 reram_1t1r Tf0=4.560988e-09  $ G-=29.540uS
Xrnl1_0_41 row0 gate_l1 cnl1_41 0 reram_1t1r Tf0=3.300000e-09  $ G-=0.296uS
Xrnl1_0_42 row0 gate_l1 cnl1_42 0 reram_1t1r Tf0=4.372707e-09  $ G-=14.900uS
Xrnl1_0_43 row0 gate_l1 cnl1_43 0 reram_1t1r Tf0=3.300000e-09  $ G-=0.296uS
Xrnl1_0_44 row0 gate_l1 cnl1_44 0 reram_1t1r Tf0=4.411345e-09  $ G-=17.146uS
Xrnl1_0_45 row0 gate_l1 cnl1_45 0 reram_1t1r Tf0=3.326761e-09  $ G-=0.333uS
Xrnl1_0_46 row0 gate_l1 cnl1_46 0 reram_1t1r Tf0=4.271418e-09  $ G-=10.310uS
Xrnl1_0_47 row0 gate_l1 cnl1_47 0 reram_1t1r Tf0=3.300000e-09  $ G-=0.296uS
Xrnl1_0_48 row0 gate_l1 cnl1_48 0 reram_1t1r Tf0=3.300000e-09  $ G-=0.296uS
Xrnl1_0_49 row0 gate_l1 cnl1_49 0 reram_1t1r Tf0=3.300000e-09  $ G-=0.296uS
Xrnl1_0_50 row0 gate_l1 cnl1_50 0 reram_1t1r Tf0=3.300000e-09  $ G-=0.296uS
Xrnl1_0_51 row0 gate_l1 cnl1_51 0 reram_1t1r Tf0=3.300000e-09  $ G-=0.296uS
Xrnl1_0_52 row0 gate_l1 cnl1_52 0 reram_1t1r Tf0=3.300000e-09  $ G-=0.296uS
Xrnl1_0_53 row0 gate_l1 cnl1_53 0 reram_1t1r Tf0=3.300000e-09  $ G-=0.296uS
Xrnl1_0_54 row0 gate_l1 cnl1_54 0 reram_1t1r Tf0=3.300000e-09  $ G-=0.296uS
Xrnl1_0_55 row0 gate_l1 cnl1_55 0 reram_1t1r Tf0=3.300000e-09  $ G-=0.296uS
Xrnl1_0_56 row0 gate_l1 cnl1_56 0 reram_1t1r Tf0=3.300000e-09  $ G-=0.296uS
Xrnl1_0_57 row0 gate_l1 cnl1_57 0 reram_1t1r Tf0=4.360324e-09  $ G-=14.244uS
Xrnl1_0_58 row0 gate_l1 cnl1_58 0 reram_1t1r Tf0=4.390650e-09  $ G-=15.904uS
Xrnl1_0_59 row0 gate_l1 cnl1_59 0 reram_1t1r Tf0=4.787322e-09  $ G-=67.255uS
Xrnl1_0_60 row0 gate_l1 cnl1_60 0 reram_1t1r Tf0=4.334484e-09  $ G-=12.967uS
Xrnl1_0_61 row0 gate_l1 cnl1_61 0 reram_1t1r Tf0=3.300000e-09  $ G-=0.296uS
Xrnl1_0_62 row0 gate_l1 cnl1_62 0 reram_1t1r Tf0=3.300000e-09  $ G-=0.296uS
Xrnl1_0_63 row0 gate_l1 cnl1_63 0 reram_1t1r Tf0=3.776701e-09  $ G-=1.707uS
Xrnl1_1_0 row1 gate_l1 cnl1_0 0 reram_1t1r Tf0=3.676986e-09  $ G-=1.188uS
Xrnl1_1_1 row1 gate_l1 cnl1_1 0 reram_1t1r Tf0=3.300000e-09  $ G-=0.296uS
Xrnl1_1_2 row1 gate_l1 cnl1_2 0 reram_1t1r Tf0=4.651670e-09  $ G-=41.074uS
Xrnl1_1_3 row1 gate_l1 cnl1_3 0 reram_1t1r Tf0=3.300000e-09  $ G-=0.296uS
Xrnl1_1_4 row1 gate_l1 cnl1_4 0 reram_1t1r Tf0=4.125443e-09  $ G-=6.065uS
Xrnl1_1_5 row1 gate_l1 cnl1_5 0 reram_1t1r Tf0=3.300000e-09  $ G-=0.296uS
Xrnl1_1_6 row1 gate_l1 cnl1_6 0 reram_1t1r Tf0=3.300000e-09  $ G-=0.296uS
Xrnl1_1_7 row1 gate_l1 cnl1_7 0 reram_1t1r Tf0=4.068712e-09  $ G-=4.935uS
Xrnl1_1_8 row1 gate_l1 cnl1_8 0 reram_1t1r Tf0=4.575354e-09  $ G-=31.124uS
Xrnl1_1_9 row1 gate_l1 cnl1_9 0 reram_1t1r Tf0=3.300000e-09  $ G-=0.296uS
Xrnl1_1_10 row1 gate_l1 cnl1_10 0 reram_1t1r Tf0=3.300000e-09  $ G-=0.296uS
Xrnl1_1_11 row1 gate_l1 cnl1_11 0 reram_1t1r Tf0=3.300000e-09  $ G-=0.296uS
Xrnl1_1_12 row1 gate_l1 cnl1_12 0 reram_1t1r Tf0=3.300000e-09  $ G-=0.296uS
Xrnl1_1_13 row1 gate_l1 cnl1_13 0 reram_1t1r Tf0=4.472087e-09  $ G-=21.383uS
Xrnl1_1_14 row1 gate_l1 cnl1_14 0 reram_1t1r Tf0=3.300000e-09  $ G-=0.296uS
Xrnl1_1_15 row1 gate_l1 cnl1_15 0 reram_1t1r Tf0=3.406109e-09  $ G-=0.444uS
Xrnl1_1_16 row1 gate_l1 cnl1_16 0 reram_1t1r Tf0=3.300000e-09  $ G-=0.296uS
Xrnl1_1_17 row1 gate_l1 cnl1_17 0 reram_1t1r Tf0=3.300000e-09  $ G-=0.296uS
Xrnl1_1_18 row1 gate_l1 cnl1_18 0 reram_1t1r Tf0=4.398628e-09  $ G-=16.372uS
Xrnl1_1_19 row1 gate_l1 cnl1_19 0 reram_1t1r Tf0=4.266604e-09  $ G-=10.132uS
Xrnl1_1_20 row1 gate_l1 cnl1_20 0 reram_1t1r Tf0=4.405608e-09  $ G-=16.793uS
Xrnl1_1_21 row1 gate_l1 cnl1_21 0 reram_1t1r Tf0=3.300000e-09  $ G-=0.296uS
Xrnl1_1_22 row1 gate_l1 cnl1_22 0 reram_1t1r Tf0=3.300000e-09  $ G-=0.296uS
Xrnl1_1_23 row1 gate_l1 cnl1_23 0 reram_1t1r Tf0=3.300000e-09  $ G-=0.296uS
Xrnl1_1_24 row1 gate_l1 cnl1_24 0 reram_1t1r Tf0=3.300000e-09  $ G-=0.296uS
Xrnl1_1_25 row1 gate_l1 cnl1_25 0 reram_1t1r Tf0=4.329703e-09  $ G-=12.744uS
Xrnl1_1_26 row1 gate_l1 cnl1_26 0 reram_1t1r Tf0=4.071531e-09  $ G-=4.986uS
Xrnl1_1_27 row1 gate_l1 cnl1_27 0 reram_1t1r Tf0=3.300000e-09  $ G-=0.296uS
Xrnl1_1_28 row1 gate_l1 cnl1_28 0 reram_1t1r Tf0=4.252541e-09  $ G-=9.627uS
Xrnl1_1_29 row1 gate_l1 cnl1_29 0 reram_1t1r Tf0=3.792949e-09  $ G-=1.811uS
Xrnl1_1_30 row1 gate_l1 cnl1_30 0 reram_1t1r Tf0=3.300000e-09  $ G-=0.296uS
Xrnl1_1_31 row1 gate_l1 cnl1_31 0 reram_1t1r Tf0=3.881922e-09  $ G-=2.503uS
Xrnl1_1_32 row1 gate_l1 cnl1_32 0 reram_1t1r Tf0=4.263549e-09  $ G-=10.020uS
Xrnl1_1_33 row1 gate_l1 cnl1_33 0 reram_1t1r Tf0=3.300000e-09  $ G-=0.296uS
Xrnl1_1_34 row1 gate_l1 cnl1_34 0 reram_1t1r Tf0=4.500206e-09  $ G-=23.684uS
Xrnl1_1_35 row1 gate_l1 cnl1_35 0 reram_1t1r Tf0=4.212486e-09  $ G-=8.322uS
Xrnl1_1_36 row1 gate_l1 cnl1_36 0 reram_1t1r Tf0=4.536434e-09  $ G-=27.018uS
Xrnl1_1_37 row1 gate_l1 cnl1_37 0 reram_1t1r Tf0=3.300000e-09  $ G-=0.296uS
Xrnl1_1_38 row1 gate_l1 cnl1_38 0 reram_1t1r Tf0=4.460502e-09  $ G-=20.501uS
Xrnl1_1_39 row1 gate_l1 cnl1_39 0 reram_1t1r Tf0=4.403884e-09  $ G-=16.688uS
Xrnl1_1_40 row1 gate_l1 cnl1_40 0 reram_1t1r Tf0=3.300000e-09  $ G-=0.296uS
Xrnl1_1_41 row1 gate_l1 cnl1_41 0 reram_1t1r Tf0=4.097854e-09  $ G-=5.486uS
Xrnl1_1_42 row1 gate_l1 cnl1_42 0 reram_1t1r Tf0=4.561076e-09  $ G-=29.550uS
Xrnl1_1_43 row1 gate_l1 cnl1_43 0 reram_1t1r Tf0=3.300000e-09  $ G-=0.296uS
Xrnl1_1_44 row1 gate_l1 cnl1_44 0 reram_1t1r Tf0=4.390721e-09  $ G-=15.908uS
Xrnl1_1_45 row1 gate_l1 cnl1_45 0 reram_1t1r Tf0=4.556345e-09  $ G-=29.046uS
Xrnl1_1_46 row1 gate_l1 cnl1_46 0 reram_1t1r Tf0=4.404292e-09  $ G-=16.712uS
Xrnl1_1_47 row1 gate_l1 cnl1_47 0 reram_1t1r Tf0=3.902635e-09  $ G-=2.698uS
Xrnl1_1_48 row1 gate_l1 cnl1_48 0 reram_1t1r Tf0=3.300000e-09  $ G-=0.296uS
Xrnl1_1_49 row1 gate_l1 cnl1_49 0 reram_1t1r Tf0=3.300000e-09  $ G-=0.296uS
Xrnl1_1_50 row1 gate_l1 cnl1_50 0 reram_1t1r Tf0=3.791701e-09  $ G-=1.803uS
Xrnl1_1_51 row1 gate_l1 cnl1_51 0 reram_1t1r Tf0=3.300000e-09  $ G-=0.296uS
Xrnl1_1_52 row1 gate_l1 cnl1_52 0 reram_1t1r Tf0=3.300000e-09  $ G-=0.296uS
Xrnl1_1_53 row1 gate_l1 cnl1_53 0 reram_1t1r Tf0=3.616692e-09  $ G-=0.954uS
Xrnl1_1_54 row1 gate_l1 cnl1_54 0 reram_1t1r Tf0=3.300000e-09  $ G-=0.296uS
Xrnl1_1_55 row1 gate_l1 cnl1_55 0 reram_1t1r Tf0=3.300000e-09  $ G-=0.296uS
Xrnl1_1_56 row1 gate_l1 cnl1_56 0 reram_1t1r Tf0=3.300000e-09  $ G-=0.296uS
Xrnl1_1_57 row1 gate_l1 cnl1_57 0 reram_1t1r Tf0=3.300000e-09  $ G-=0.296uS
Xrnl1_1_58 row1 gate_l1 cnl1_58 0 reram_1t1r Tf0=4.349852e-09  $ G-=13.712uS
Xrnl1_1_59 row1 gate_l1 cnl1_59 0 reram_1t1r Tf0=4.036896e-09  $ G-=4.396uS
Xrnl1_1_60 row1 gate_l1 cnl1_60 0 reram_1t1r Tf0=3.300000e-09  $ G-=0.296uS
Xrnl1_1_61 row1 gate_l1 cnl1_61 0 reram_1t1r Tf0=3.300000e-09  $ G-=0.296uS
Xrnl1_1_62 row1 gate_l1 cnl1_62 0 reram_1t1r Tf0=3.300000e-09  $ G-=0.296uS
Xrnl1_1_63 row1 gate_l1 cnl1_63 0 reram_1t1r Tf0=3.300000e-09  $ G-=0.296uS
Xrnl1_2_0 row2 gate_l1 cnl1_0 0 reram_1t1r Tf0=4.699068e-09  $ G-=48.797uS
Xrnl1_2_1 row2 gate_l1 cnl1_1 0 reram_1t1r Tf0=4.254136e-09  $ G-=9.683uS
Xrnl1_2_2 row2 gate_l1 cnl1_2 0 reram_1t1r Tf0=4.435990e-09  $ G-=18.754uS
Xrnl1_2_3 row2 gate_l1 cnl1_3 0 reram_1t1r Tf0=4.243581e-09  $ G-=9.318uS
Xrnl1_2_4 row2 gate_l1 cnl1_4 0 reram_1t1r Tf0=3.300000e-09  $ G-=0.296uS
Xrnl1_2_5 row2 gate_l1 cnl1_5 0 reram_1t1r Tf0=4.481052e-09  $ G-=22.091uS
Xrnl1_2_6 row2 gate_l1 cnl1_6 0 reram_1t1r Tf0=4.330075e-09  $ G-=12.761uS
Xrnl1_2_7 row2 gate_l1 cnl1_7 0 reram_1t1r Tf0=4.464748e-09  $ G-=20.820uS
Xrnl1_2_8 row2 gate_l1 cnl1_8 0 reram_1t1r Tf0=4.015377e-09  $ G-=4.065uS
Xrnl1_2_9 row2 gate_l1 cnl1_9 0 reram_1t1r Tf0=3.300000e-09  $ G-=0.296uS
Xrnl1_2_10 row2 gate_l1 cnl1_10 0 reram_1t1r Tf0=3.478612e-09  $ G-=0.578uS
Xrnl1_2_11 row2 gate_l1 cnl1_11 0 reram_1t1r Tf0=3.300000e-09  $ G-=0.296uS
Xrnl1_2_12 row2 gate_l1 cnl1_12 0 reram_1t1r Tf0=3.300000e-09  $ G-=0.296uS
Xrnl1_2_13 row2 gate_l1 cnl1_13 0 reram_1t1r Tf0=4.391072e-09  $ G-=15.928uS
Xrnl1_2_14 row2 gate_l1 cnl1_14 0 reram_1t1r Tf0=4.236243e-09  $ G-=9.073uS
Xrnl1_2_15 row2 gate_l1 cnl1_15 0 reram_1t1r Tf0=4.500205e-09  $ G-=23.684uS
Xrnl1_2_16 row2 gate_l1 cnl1_16 0 reram_1t1r Tf0=4.471066e-09  $ G-=21.304uS
Xrnl1_2_17 row2 gate_l1 cnl1_17 0 reram_1t1r Tf0=4.391623e-09  $ G-=15.960uS
Xrnl1_2_18 row2 gate_l1 cnl1_18 0 reram_1t1r Tf0=3.300000e-09  $ G-=0.296uS
Xrnl1_2_19 row2 gate_l1 cnl1_19 0 reram_1t1r Tf0=3.300000e-09  $ G-=0.296uS
Xrnl1_2_20 row2 gate_l1 cnl1_20 0 reram_1t1r Tf0=3.300000e-09  $ G-=0.296uS
Xrnl1_2_21 row2 gate_l1 cnl1_21 0 reram_1t1r Tf0=3.300000e-09  $ G-=0.296uS
Xrnl1_2_22 row2 gate_l1 cnl1_22 0 reram_1t1r Tf0=3.300000e-09  $ G-=0.296uS
Xrnl1_2_23 row2 gate_l1 cnl1_23 0 reram_1t1r Tf0=4.336278e-09  $ G-=13.052uS
Xrnl1_2_24 row2 gate_l1 cnl1_24 0 reram_1t1r Tf0=4.389215e-09  $ G-=15.821uS
Xrnl1_2_25 row2 gate_l1 cnl1_25 0 reram_1t1r Tf0=3.300000e-09  $ G-=0.296uS
Xrnl1_2_26 row2 gate_l1 cnl1_26 0 reram_1t1r Tf0=3.340947e-09  $ G-=0.350uS
Xrnl1_2_27 row2 gate_l1 cnl1_27 0 reram_1t1r Tf0=3.300000e-09  $ G-=0.296uS
Xrnl1_2_28 row2 gate_l1 cnl1_28 0 reram_1t1r Tf0=3.300000e-09  $ G-=0.296uS
Xrnl1_2_29 row2 gate_l1 cnl1_29 0 reram_1t1r Tf0=3.300000e-09  $ G-=0.296uS
Xrnl1_2_30 row2 gate_l1 cnl1_30 0 reram_1t1r Tf0=4.369311e-09  $ G-=14.717uS
Xrnl1_2_31 row2 gate_l1 cnl1_31 0 reram_1t1r Tf0=3.300000e-09  $ G-=0.296uS
Xrnl1_2_32 row2 gate_l1 cnl1_32 0 reram_1t1r Tf0=4.672000e-09  $ G-=44.225uS
Xrnl1_2_33 row2 gate_l1 cnl1_33 0 reram_1t1r Tf0=3.300000e-09  $ G-=0.296uS
Xrnl1_2_34 row2 gate_l1 cnl1_34 0 reram_1t1r Tf0=4.497347e-09  $ G-=23.439uS
Xrnl1_2_35 row2 gate_l1 cnl1_35 0 reram_1t1r Tf0=3.300000e-09  $ G-=0.296uS
Xrnl1_2_36 row2 gate_l1 cnl1_36 0 reram_1t1r Tf0=3.300000e-09  $ G-=0.296uS
Xrnl1_2_37 row2 gate_l1 cnl1_37 0 reram_1t1r Tf0=3.300000e-09  $ G-=0.296uS
Xrnl1_2_38 row2 gate_l1 cnl1_38 0 reram_1t1r Tf0=3.672796e-09  $ G-=1.170uS
Xrnl1_2_39 row2 gate_l1 cnl1_39 0 reram_1t1r Tf0=4.507778e-09  $ G-=24.345uS
Xrnl1_2_40 row2 gate_l1 cnl1_40 0 reram_1t1r Tf0=4.353584e-09  $ G-=13.899uS
Xrnl1_2_41 row2 gate_l1 cnl1_41 0 reram_1t1r Tf0=3.300000e-09  $ G-=0.296uS
Xrnl1_2_42 row2 gate_l1 cnl1_42 0 reram_1t1r Tf0=3.300000e-09  $ G-=0.296uS
Xrnl1_2_43 row2 gate_l1 cnl1_43 0 reram_1t1r Tf0=4.399459e-09  $ G-=16.421uS
Xrnl1_2_44 row2 gate_l1 cnl1_44 0 reram_1t1r Tf0=3.300000e-09  $ G-=0.296uS
Xrnl1_2_45 row2 gate_l1 cnl1_45 0 reram_1t1r Tf0=4.403447e-09  $ G-=16.661uS
Xrnl1_2_46 row2 gate_l1 cnl1_46 0 reram_1t1r Tf0=3.300000e-09  $ G-=0.296uS
Xrnl1_2_47 row2 gate_l1 cnl1_47 0 reram_1t1r Tf0=4.378044e-09  $ G-=15.192uS
Xrnl1_2_48 row2 gate_l1 cnl1_48 0 reram_1t1r Tf0=4.023782e-09  $ G-=4.191uS
Xrnl1_2_49 row2 gate_l1 cnl1_49 0 reram_1t1r Tf0=4.284986e-09  $ G-=10.832uS
Xrnl1_2_50 row2 gate_l1 cnl1_50 0 reram_1t1r Tf0=3.884756e-09  $ G-=2.528uS
Xrnl1_2_51 row2 gate_l1 cnl1_51 0 reram_1t1r Tf0=4.045911e-09  $ G-=4.542uS
Xrnl1_2_52 row2 gate_l1 cnl1_52 0 reram_1t1r Tf0=4.573361e-09  $ G-=30.899uS
Xrnl1_2_53 row2 gate_l1 cnl1_53 0 reram_1t1r Tf0=4.404087e-09  $ G-=16.700uS
Xrnl1_2_54 row2 gate_l1 cnl1_54 0 reram_1t1r Tf0=4.029931e-09  $ G-=4.286uS
Xrnl1_2_55 row2 gate_l1 cnl1_55 0 reram_1t1r Tf0=3.300000e-09  $ G-=0.296uS
Xrnl1_2_56 row2 gate_l1 cnl1_56 0 reram_1t1r Tf0=3.300000e-09  $ G-=0.296uS
Xrnl1_2_57 row2 gate_l1 cnl1_57 0 reram_1t1r Tf0=3.300000e-09  $ G-=0.296uS
Xrnl1_2_58 row2 gate_l1 cnl1_58 0 reram_1t1r Tf0=3.300000e-09  $ G-=0.296uS
Xrnl1_2_59 row2 gate_l1 cnl1_59 0 reram_1t1r Tf0=3.300000e-09  $ G-=0.296uS
Xrnl1_2_60 row2 gate_l1 cnl1_60 0 reram_1t1r Tf0=3.300000e-09  $ G-=0.296uS
Xrnl1_2_61 row2 gate_l1 cnl1_61 0 reram_1t1r Tf0=3.721995e-09  $ G-=1.399uS
Xrnl1_2_62 row2 gate_l1 cnl1_62 0 reram_1t1r Tf0=4.477556e-09  $ G-=21.812uS
Xrnl1_2_63 row2 gate_l1 cnl1_63 0 reram_1t1r Tf0=3.920425e-09  $ G-=2.879uS
Xrnl1_3_0 row3 gate_l1 cnl1_0 0 reram_1t1r Tf0=3.884587e-09  $ G-=2.527uS
Xrnl1_3_1 row3 gate_l1 cnl1_1 0 reram_1t1r Tf0=3.300000e-09  $ G-=0.296uS
Xrnl1_3_2 row3 gate_l1 cnl1_2 0 reram_1t1r Tf0=3.386968e-09  $ G-=0.414uS
Xrnl1_3_3 row3 gate_l1 cnl1_3 0 reram_1t1r Tf0=4.198357e-09  $ G-=7.906uS
Xrnl1_3_4 row3 gate_l1 cnl1_4 0 reram_1t1r Tf0=3.300000e-09  $ G-=0.296uS
Xrnl1_3_5 row3 gate_l1 cnl1_5 0 reram_1t1r Tf0=3.300000e-09  $ G-=0.296uS
Xrnl1_3_6 row3 gate_l1 cnl1_6 0 reram_1t1r Tf0=3.300000e-09  $ G-=0.296uS
Xrnl1_3_7 row3 gate_l1 cnl1_7 0 reram_1t1r Tf0=3.300000e-09  $ G-=0.296uS
Xrnl1_3_8 row3 gate_l1 cnl1_8 0 reram_1t1r Tf0=3.910007e-09  $ G-=2.772uS
Xrnl1_3_9 row3 gate_l1 cnl1_9 0 reram_1t1r Tf0=4.244405e-09  $ G-=9.346uS
Xrnl1_3_10 row3 gate_l1 cnl1_10 0 reram_1t1r Tf0=3.862172e-09  $ G-=2.329uS
Xrnl1_3_11 row3 gate_l1 cnl1_11 0 reram_1t1r Tf0=3.300000e-09  $ G-=0.296uS
Xrnl1_3_12 row3 gate_l1 cnl1_12 0 reram_1t1r Tf0=3.300000e-09  $ G-=0.296uS
Xrnl1_3_13 row3 gate_l1 cnl1_13 0 reram_1t1r Tf0=4.360804e-09  $ G-=14.269uS
Xrnl1_3_14 row3 gate_l1 cnl1_14 0 reram_1t1r Tf0=4.611054e-09  $ G-=35.437uS
Xrnl1_3_15 row3 gate_l1 cnl1_15 0 reram_1t1r Tf0=4.018132e-09  $ G-=4.106uS
Xrnl1_3_16 row3 gate_l1 cnl1_16 0 reram_1t1r Tf0=4.343169e-09  $ G-=13.383uS
Xrnl1_3_17 row3 gate_l1 cnl1_17 0 reram_1t1r Tf0=4.548112e-09  $ G-=28.189uS
Xrnl1_3_18 row3 gate_l1 cnl1_18 0 reram_1t1r Tf0=3.300000e-09  $ G-=0.296uS
Xrnl1_3_19 row3 gate_l1 cnl1_19 0 reram_1t1r Tf0=3.300000e-09  $ G-=0.296uS
Xrnl1_3_20 row3 gate_l1 cnl1_20 0 reram_1t1r Tf0=3.935899e-09  $ G-=3.045uS
Xrnl1_3_21 row3 gate_l1 cnl1_21 0 reram_1t1r Tf0=3.300000e-09  $ G-=0.296uS
Xrnl1_3_22 row3 gate_l1 cnl1_22 0 reram_1t1r Tf0=3.300000e-09  $ G-=0.296uS
Xrnl1_3_23 row3 gate_l1 cnl1_23 0 reram_1t1r Tf0=4.306952e-09  $ G-=11.732uS
Xrnl1_3_24 row3 gate_l1 cnl1_24 0 reram_1t1r Tf0=4.287768e-09  $ G-=10.942uS
Xrnl1_3_25 row3 gate_l1 cnl1_25 0 reram_1t1r Tf0=4.410920e-09  $ G-=17.120uS
Xrnl1_3_26 row3 gate_l1 cnl1_26 0 reram_1t1r Tf0=3.300000e-09  $ G-=0.296uS
Xrnl1_3_27 row3 gate_l1 cnl1_27 0 reram_1t1r Tf0=3.934881e-09  $ G-=3.034uS
Xrnl1_3_28 row3 gate_l1 cnl1_28 0 reram_1t1r Tf0=3.300000e-09  $ G-=0.296uS
Xrnl1_3_29 row3 gate_l1 cnl1_29 0 reram_1t1r Tf0=4.284905e-09  $ G-=10.828uS
Xrnl1_3_30 row3 gate_l1 cnl1_30 0 reram_1t1r Tf0=3.653864e-09  $ G-=1.092uS
Xrnl1_3_31 row3 gate_l1 cnl1_31 0 reram_1t1r Tf0=4.376115e-09  $ G-=15.085uS
Xrnl1_3_32 row3 gate_l1 cnl1_32 0 reram_1t1r Tf0=4.450645e-09  $ G-=19.780uS
Xrnl1_3_33 row3 gate_l1 cnl1_33 0 reram_1t1r Tf0=3.300000e-09  $ G-=0.296uS
Xrnl1_3_34 row3 gate_l1 cnl1_34 0 reram_1t1r Tf0=3.300000e-09  $ G-=0.296uS
Xrnl1_3_35 row3 gate_l1 cnl1_35 0 reram_1t1r Tf0=4.335243e-09  $ G-=13.003uS
Xrnl1_3_36 row3 gate_l1 cnl1_36 0 reram_1t1r Tf0=3.300000e-09  $ G-=0.296uS
Xrnl1_3_37 row3 gate_l1 cnl1_37 0 reram_1t1r Tf0=3.300000e-09  $ G-=0.296uS
Xrnl1_3_38 row3 gate_l1 cnl1_38 0 reram_1t1r Tf0=3.300000e-09  $ G-=0.296uS
Xrnl1_3_39 row3 gate_l1 cnl1_39 0 reram_1t1r Tf0=3.300000e-09  $ G-=0.296uS
Xrnl1_3_40 row3 gate_l1 cnl1_40 0 reram_1t1r Tf0=4.334278e-09  $ G-=12.957uS
Xrnl1_3_41 row3 gate_l1 cnl1_41 0 reram_1t1r Tf0=3.894336e-09  $ G-=2.618uS
Xrnl1_3_42 row3 gate_l1 cnl1_42 0 reram_1t1r Tf0=4.096019e-09  $ G-=5.450uS
Xrnl1_3_43 row3 gate_l1 cnl1_43 0 reram_1t1r Tf0=3.804513e-09  $ G-=1.889uS
Xrnl1_3_44 row3 gate_l1 cnl1_44 0 reram_1t1r Tf0=4.180893e-09  $ G-=7.419uS
Xrnl1_3_45 row3 gate_l1 cnl1_45 0 reram_1t1r Tf0=4.358707e-09  $ G-=14.160uS
Xrnl1_3_46 row3 gate_l1 cnl1_46 0 reram_1t1r Tf0=3.300000e-09  $ G-=0.296uS
Xrnl1_3_47 row3 gate_l1 cnl1_47 0 reram_1t1r Tf0=4.485524e-09  $ G-=22.453uS
Xrnl1_3_48 row3 gate_l1 cnl1_48 0 reram_1t1r Tf0=3.300000e-09  $ G-=0.296uS
Xrnl1_3_49 row3 gate_l1 cnl1_49 0 reram_1t1r Tf0=3.300000e-09  $ G-=0.296uS
Xrnl1_3_50 row3 gate_l1 cnl1_50 0 reram_1t1r Tf0=3.300000e-09  $ G-=0.296uS
Xrnl1_3_51 row3 gate_l1 cnl1_51 0 reram_1t1r Tf0=3.300000e-09  $ G-=0.296uS
Xrnl1_3_52 row3 gate_l1 cnl1_52 0 reram_1t1r Tf0=3.837493e-09  $ G-=2.129uS
Xrnl1_3_53 row3 gate_l1 cnl1_53 0 reram_1t1r Tf0=3.300000e-09  $ G-=0.296uS
Xrnl1_3_54 row3 gate_l1 cnl1_54 0 reram_1t1r Tf0=3.300000e-09  $ G-=0.296uS
Xrnl1_3_55 row3 gate_l1 cnl1_55 0 reram_1t1r Tf0=3.300000e-09  $ G-=0.296uS
Xrnl1_3_56 row3 gate_l1 cnl1_56 0 reram_1t1r Tf0=3.300000e-09  $ G-=0.296uS
Xrnl1_3_57 row3 gate_l1 cnl1_57 0 reram_1t1r Tf0=3.300000e-09  $ G-=0.296uS
Xrnl1_3_58 row3 gate_l1 cnl1_58 0 reram_1t1r Tf0=3.958232e-09  $ G-=3.303uS
Xrnl1_3_59 row3 gate_l1 cnl1_59 0 reram_1t1r Tf0=3.970109e-09  $ G-=3.448uS
Xrnl1_3_60 row3 gate_l1 cnl1_60 0 reram_1t1r Tf0=3.300000e-09  $ G-=0.296uS
Xrnl1_3_61 row3 gate_l1 cnl1_61 0 reram_1t1r Tf0=3.300000e-09  $ G-=0.296uS
Xrnl1_3_62 row3 gate_l1 cnl1_62 0 reram_1t1r Tf0=3.300000e-09  $ G-=0.296uS
Xrnl1_3_63 row3 gate_l1 cnl1_63 0 reram_1t1r Tf0=3.300000e-09  $ G-=0.296uS
Xrnl1_4_0 row4 gate_l1 cnl1_0 0 reram_1t1r Tf0=3.965835e-09  $ G-=3.395uS
Xrnl1_4_1 row4 gate_l1 cnl1_1 0 reram_1t1r Tf0=3.300000e-09  $ G-=0.296uS
Xrnl1_4_2 row4 gate_l1 cnl1_2 0 reram_1t1r Tf0=4.340962e-09  $ G-=13.276uS
Xrnl1_4_3 row4 gate_l1 cnl1_3 0 reram_1t1r Tf0=4.600995e-09  $ G-=34.164uS
Xrnl1_4_4 row4 gate_l1 cnl1_4 0 reram_1t1r Tf0=3.300000e-09  $ G-=0.296uS
Xrnl1_4_5 row4 gate_l1 cnl1_5 0 reram_1t1r Tf0=3.300000e-09  $ G-=0.296uS
Xrnl1_4_6 row4 gate_l1 cnl1_6 0 reram_1t1r Tf0=4.391947e-09  $ G-=15.979uS
Xrnl1_4_7 row4 gate_l1 cnl1_7 0 reram_1t1r Tf0=4.162366e-09  $ G-=6.936uS
Xrnl1_4_8 row4 gate_l1 cnl1_8 0 reram_1t1r Tf0=3.536318e-09  $ G-=0.713uS
Xrnl1_4_9 row4 gate_l1 cnl1_9 0 reram_1t1r Tf0=3.300000e-09  $ G-=0.296uS
Xrnl1_4_10 row4 gate_l1 cnl1_10 0 reram_1t1r Tf0=3.913935e-09  $ G-=2.811uS
Xrnl1_4_11 row4 gate_l1 cnl1_11 0 reram_1t1r Tf0=3.300000e-09  $ G-=0.296uS
Xrnl1_4_12 row4 gate_l1 cnl1_12 0 reram_1t1r Tf0=3.816923e-09  $ G-=1.976uS
Xrnl1_4_13 row4 gate_l1 cnl1_13 0 reram_1t1r Tf0=4.466699e-09  $ G-=20.968uS
Xrnl1_4_14 row4 gate_l1 cnl1_14 0 reram_1t1r Tf0=3.300000e-09  $ G-=0.296uS
Xrnl1_4_15 row4 gate_l1 cnl1_15 0 reram_1t1r Tf0=3.300000e-09  $ G-=0.296uS
Xrnl1_4_16 row4 gate_l1 cnl1_16 0 reram_1t1r Tf0=4.556976e-09  $ G-=29.113uS
Xrnl1_4_17 row4 gate_l1 cnl1_17 0 reram_1t1r Tf0=3.300000e-09  $ G-=0.296uS
Xrnl1_4_18 row4 gate_l1 cnl1_18 0 reram_1t1r Tf0=3.592960e-09  $ G-=0.875uS
Xrnl1_4_19 row4 gate_l1 cnl1_19 0 reram_1t1r Tf0=3.300000e-09  $ G-=0.296uS
Xrnl1_4_20 row4 gate_l1 cnl1_20 0 reram_1t1r Tf0=3.300000e-09  $ G-=0.296uS
Xrnl1_4_21 row4 gate_l1 cnl1_21 0 reram_1t1r Tf0=3.300000e-09  $ G-=0.296uS
Xrnl1_4_22 row4 gate_l1 cnl1_22 0 reram_1t1r Tf0=3.300000e-09  $ G-=0.296uS
Xrnl1_4_23 row4 gate_l1 cnl1_23 0 reram_1t1r Tf0=3.300000e-09  $ G-=0.296uS
Xrnl1_4_24 row4 gate_l1 cnl1_24 0 reram_1t1r Tf0=3.300000e-09  $ G-=0.296uS
Xrnl1_4_25 row4 gate_l1 cnl1_25 0 reram_1t1r Tf0=3.300000e-09  $ G-=0.296uS
Xrnl1_4_26 row4 gate_l1 cnl1_26 0 reram_1t1r Tf0=3.300000e-09  $ G-=0.296uS
Xrnl1_4_27 row4 gate_l1 cnl1_27 0 reram_1t1r Tf0=4.108925e-09  $ G-=5.712uS
Xrnl1_4_28 row4 gate_l1 cnl1_28 0 reram_1t1r Tf0=3.300000e-09  $ G-=0.296uS
Xrnl1_4_29 row4 gate_l1 cnl1_29 0 reram_1t1r Tf0=4.245483e-09  $ G-=9.383uS
Xrnl1_4_30 row4 gate_l1 cnl1_30 0 reram_1t1r Tf0=4.337091e-09  $ G-=13.090uS
Xrnl1_4_31 row4 gate_l1 cnl1_31 0 reram_1t1r Tf0=3.712493e-09  $ G-=1.352uS
Xrnl1_4_32 row4 gate_l1 cnl1_32 0 reram_1t1r Tf0=4.361975e-09  $ G-=14.330uS
Xrnl1_4_33 row4 gate_l1 cnl1_33 0 reram_1t1r Tf0=3.300000e-09  $ G-=0.296uS
Xrnl1_4_34 row4 gate_l1 cnl1_34 0 reram_1t1r Tf0=4.461799e-09  $ G-=20.598uS
Xrnl1_4_35 row4 gate_l1 cnl1_35 0 reram_1t1r Tf0=4.622888e-09  $ G-=36.994uS
Xrnl1_4_36 row4 gate_l1 cnl1_36 0 reram_1t1r Tf0=3.300000e-09  $ G-=0.296uS
Xrnl1_4_37 row4 gate_l1 cnl1_37 0 reram_1t1r Tf0=3.300000e-09  $ G-=0.296uS
Xrnl1_4_38 row4 gate_l1 cnl1_38 0 reram_1t1r Tf0=4.325166e-09  $ G-=12.535uS
Xrnl1_4_39 row4 gate_l1 cnl1_39 0 reram_1t1r Tf0=3.300000e-09  $ G-=0.296uS
Xrnl1_4_40 row4 gate_l1 cnl1_40 0 reram_1t1r Tf0=4.102799e-09  $ G-=5.586uS
Xrnl1_4_41 row4 gate_l1 cnl1_41 0 reram_1t1r Tf0=4.141226e-09  $ G-=6.423uS
Xrnl1_4_42 row4 gate_l1 cnl1_42 0 reram_1t1r Tf0=4.125231e-09  $ G-=6.060uS
Xrnl1_4_43 row4 gate_l1 cnl1_43 0 reram_1t1r Tf0=4.403848e-09  $ G-=16.686uS
Xrnl1_4_44 row4 gate_l1 cnl1_44 0 reram_1t1r Tf0=4.600157e-09  $ G-=34.060uS
Xrnl1_4_45 row4 gate_l1 cnl1_45 0 reram_1t1r Tf0=3.300000e-09  $ G-=0.296uS
Xrnl1_4_46 row4 gate_l1 cnl1_46 0 reram_1t1r Tf0=3.300000e-09  $ G-=0.296uS
Xrnl1_4_47 row4 gate_l1 cnl1_47 0 reram_1t1r Tf0=3.300000e-09  $ G-=0.296uS
Xrnl1_4_48 row4 gate_l1 cnl1_48 0 reram_1t1r Tf0=3.985529e-09  $ G-=3.647uS
Xrnl1_4_49 row4 gate_l1 cnl1_49 0 reram_1t1r Tf0=3.300000e-09  $ G-=0.296uS
Xrnl1_4_50 row4 gate_l1 cnl1_50 0 reram_1t1r Tf0=4.004026e-09  $ G-=3.901uS
Xrnl1_4_51 row4 gate_l1 cnl1_51 0 reram_1t1r Tf0=3.300000e-09  $ G-=0.296uS
Xrnl1_4_52 row4 gate_l1 cnl1_52 0 reram_1t1r Tf0=3.300000e-09  $ G-=0.296uS
Xrnl1_4_53 row4 gate_l1 cnl1_53 0 reram_1t1r Tf0=3.659591e-09  $ G-=1.115uS
Xrnl1_4_54 row4 gate_l1 cnl1_54 0 reram_1t1r Tf0=3.689998e-09  $ G-=1.246uS
Xrnl1_4_55 row4 gate_l1 cnl1_55 0 reram_1t1r Tf0=4.568286e-09  $ G-=30.334uS
Xrnl1_4_56 row4 gate_l1 cnl1_56 0 reram_1t1r Tf0=4.614682e-09  $ G-=35.907uS
Xrnl1_4_57 row4 gate_l1 cnl1_57 0 reram_1t1r Tf0=3.300000e-09  $ G-=0.296uS
Xrnl1_4_58 row4 gate_l1 cnl1_58 0 reram_1t1r Tf0=3.300000e-09  $ G-=0.296uS
Xrnl1_4_59 row4 gate_l1 cnl1_59 0 reram_1t1r Tf0=4.519358e-09  $ G-=25.392uS
Xrnl1_4_60 row4 gate_l1 cnl1_60 0 reram_1t1r Tf0=4.343431e-09  $ G-=13.396uS
Xrnl1_4_61 row4 gate_l1 cnl1_61 0 reram_1t1r Tf0=4.338265e-09  $ G-=13.146uS
Xrnl1_4_62 row4 gate_l1 cnl1_62 0 reram_1t1r Tf0=3.300000e-09  $ G-=0.296uS
Xrnl1_4_63 row4 gate_l1 cnl1_63 0 reram_1t1r Tf0=4.285030e-09  $ G-=10.833uS
Xrnl1_5_0 row5 gate_l1 cnl1_0 0 reram_1t1r Tf0=3.789942e-09  $ G-=1.791uS
Xrnl1_5_1 row5 gate_l1 cnl1_1 0 reram_1t1r Tf0=3.300000e-09  $ G-=0.296uS
Xrnl1_5_2 row5 gate_l1 cnl1_2 0 reram_1t1r Tf0=3.300000e-09  $ G-=0.296uS
Xrnl1_5_3 row5 gate_l1 cnl1_3 0 reram_1t1r Tf0=4.562915e-09  $ G-=29.748uS
Xrnl1_5_4 row5 gate_l1 cnl1_4 0 reram_1t1r Tf0=3.300000e-09  $ G-=0.296uS
Xrnl1_5_5 row5 gate_l1 cnl1_5 0 reram_1t1r Tf0=4.005281e-09  $ G-=3.919uS
Xrnl1_5_6 row5 gate_l1 cnl1_6 0 reram_1t1r Tf0=4.462032e-09  $ G-=20.615uS
Xrnl1_5_7 row5 gate_l1 cnl1_7 0 reram_1t1r Tf0=4.010866e-09  $ G-=3.999uS
Xrnl1_5_8 row5 gate_l1 cnl1_8 0 reram_1t1r Tf0=4.329262e-09  $ G-=12.723uS
Xrnl1_5_9 row5 gate_l1 cnl1_9 0 reram_1t1r Tf0=4.141934e-09  $ G-=6.440uS
Xrnl1_5_10 row5 gate_l1 cnl1_10 0 reram_1t1r Tf0=4.335964e-09  $ G-=13.037uS
Xrnl1_5_11 row5 gate_l1 cnl1_11 0 reram_1t1r Tf0=3.300000e-09  $ G-=0.296uS
Xrnl1_5_12 row5 gate_l1 cnl1_12 0 reram_1t1r Tf0=4.090780e-09  $ G-=5.347uS
Xrnl1_5_13 row5 gate_l1 cnl1_13 0 reram_1t1r Tf0=4.592926e-09  $ G-=33.177uS
Xrnl1_5_14 row5 gate_l1 cnl1_14 0 reram_1t1r Tf0=4.567662e-09  $ G-=30.266uS
Xrnl1_5_15 row5 gate_l1 cnl1_15 0 reram_1t1r Tf0=4.431519e-09  $ G-=18.451uS
Xrnl1_5_16 row5 gate_l1 cnl1_16 0 reram_1t1r Tf0=3.300000e-09  $ G-=0.296uS
Xrnl1_5_17 row5 gate_l1 cnl1_17 0 reram_1t1r Tf0=3.300000e-09  $ G-=0.296uS
Xrnl1_5_18 row5 gate_l1 cnl1_18 0 reram_1t1r Tf0=3.300000e-09  $ G-=0.296uS
Xrnl1_5_19 row5 gate_l1 cnl1_19 0 reram_1t1r Tf0=4.383897e-09  $ G-=15.518uS
Xrnl1_5_20 row5 gate_l1 cnl1_20 0 reram_1t1r Tf0=4.172535e-09  $ G-=7.197uS
Xrnl1_5_21 row5 gate_l1 cnl1_21 0 reram_1t1r Tf0=3.300000e-09  $ G-=0.296uS
Xrnl1_5_22 row5 gate_l1 cnl1_22 0 reram_1t1r Tf0=3.997725e-09  $ G-=3.812uS
Xrnl1_5_23 row5 gate_l1 cnl1_23 0 reram_1t1r Tf0=3.300000e-09  $ G-=0.296uS
Xrnl1_5_24 row5 gate_l1 cnl1_24 0 reram_1t1r Tf0=3.450500e-09  $ G-=0.522uS
Xrnl1_5_25 row5 gate_l1 cnl1_25 0 reram_1t1r Tf0=4.585869e-09  $ G-=32.336uS
Xrnl1_5_26 row5 gate_l1 cnl1_26 0 reram_1t1r Tf0=3.816954e-09  $ G-=1.976uS
Xrnl1_5_27 row5 gate_l1 cnl1_27 0 reram_1t1r Tf0=4.398039e-09  $ G-=16.337uS
Xrnl1_5_28 row5 gate_l1 cnl1_28 0 reram_1t1r Tf0=4.329969e-09  $ G-=12.756uS
Xrnl1_5_29 row5 gate_l1 cnl1_29 0 reram_1t1r Tf0=3.300000e-09  $ G-=0.296uS
Xrnl1_5_30 row5 gate_l1 cnl1_30 0 reram_1t1r Tf0=3.300000e-09  $ G-=0.296uS
Xrnl1_5_31 row5 gate_l1 cnl1_31 0 reram_1t1r Tf0=3.300000e-09  $ G-=0.296uS
Xrnl1_5_32 row5 gate_l1 cnl1_32 0 reram_1t1r Tf0=3.300000e-09  $ G-=0.296uS
Xrnl1_5_33 row5 gate_l1 cnl1_33 0 reram_1t1r Tf0=4.541654e-09  $ G-=27.535uS
Xrnl1_5_34 row5 gate_l1 cnl1_34 0 reram_1t1r Tf0=4.524079e-09  $ G-=25.831uS
Xrnl1_5_35 row5 gate_l1 cnl1_35 0 reram_1t1r Tf0=4.127954e-09  $ G-=6.121uS
Xrnl1_5_36 row5 gate_l1 cnl1_36 0 reram_1t1r Tf0=4.597773e-09  $ G-=33.766uS
Xrnl1_5_37 row5 gate_l1 cnl1_37 0 reram_1t1r Tf0=3.300000e-09  $ G-=0.296uS
Xrnl1_5_38 row5 gate_l1 cnl1_38 0 reram_1t1r Tf0=3.300000e-09  $ G-=0.296uS
Xrnl1_5_39 row5 gate_l1 cnl1_39 0 reram_1t1r Tf0=3.300000e-09  $ G-=0.296uS
Xrnl1_5_40 row5 gate_l1 cnl1_40 0 reram_1t1r Tf0=4.373731e-09  $ G-=14.955uS
Xrnl1_5_41 row5 gate_l1 cnl1_41 0 reram_1t1r Tf0=4.163382e-09  $ G-=6.962uS
Xrnl1_5_42 row5 gate_l1 cnl1_42 0 reram_1t1r Tf0=3.300000e-09  $ G-=0.296uS
Xrnl1_5_43 row5 gate_l1 cnl1_43 0 reram_1t1r Tf0=4.300683e-09  $ G-=11.468uS
Xrnl1_5_44 row5 gate_l1 cnl1_44 0 reram_1t1r Tf0=3.300000e-09  $ G-=0.296uS
Xrnl1_5_45 row5 gate_l1 cnl1_45 0 reram_1t1r Tf0=4.220235e-09  $ G-=8.560uS
Xrnl1_5_46 row5 gate_l1 cnl1_46 0 reram_1t1r Tf0=3.300000e-09  $ G-=0.296uS
Xrnl1_5_47 row5 gate_l1 cnl1_47 0 reram_1t1r Tf0=3.719994e-09  $ G-=1.389uS
Xrnl1_5_48 row5 gate_l1 cnl1_48 0 reram_1t1r Tf0=4.008916e-09  $ G-=3.971uS
Xrnl1_5_49 row5 gate_l1 cnl1_49 0 reram_1t1r Tf0=4.498644e-09  $ G-=23.550uS
Xrnl1_5_50 row5 gate_l1 cnl1_50 0 reram_1t1r Tf0=4.507841e-09  $ G-=24.351uS
Xrnl1_5_51 row5 gate_l1 cnl1_51 0 reram_1t1r Tf0=4.514490e-09  $ G-=24.946uS
Xrnl1_5_52 row5 gate_l1 cnl1_52 0 reram_1t1r Tf0=3.300000e-09  $ G-=0.296uS
Xrnl1_5_53 row5 gate_l1 cnl1_53 0 reram_1t1r Tf0=3.300000e-09  $ G-=0.296uS
Xrnl1_5_54 row5 gate_l1 cnl1_54 0 reram_1t1r Tf0=4.429804e-09  $ G-=18.336uS
Xrnl1_5_55 row5 gate_l1 cnl1_55 0 reram_1t1r Tf0=3.828844e-09  $ G-=2.063uS
Xrnl1_5_56 row5 gate_l1 cnl1_56 0 reram_1t1r Tf0=3.300000e-09  $ G-=0.296uS
Xrnl1_5_57 row5 gate_l1 cnl1_57 0 reram_1t1r Tf0=4.263341e-09  $ G-=10.012uS
Xrnl1_5_58 row5 gate_l1 cnl1_58 0 reram_1t1r Tf0=3.300000e-09  $ G-=0.296uS
Xrnl1_5_59 row5 gate_l1 cnl1_59 0 reram_1t1r Tf0=4.606704e-09  $ G-=34.881uS
Xrnl1_5_60 row5 gate_l1 cnl1_60 0 reram_1t1r Tf0=4.447873e-09  $ G-=19.581uS
Xrnl1_5_61 row5 gate_l1 cnl1_61 0 reram_1t1r Tf0=3.300000e-09  $ G-=0.296uS
Xrnl1_5_62 row5 gate_l1 cnl1_62 0 reram_1t1r Tf0=4.239167e-09  $ G-=9.170uS
Xrnl1_5_63 row5 gate_l1 cnl1_63 0 reram_1t1r Tf0=3.300000e-09  $ G-=0.296uS
Xrnl1_6_0 row6 gate_l1 cnl1_0 0 reram_1t1r Tf0=3.300000e-09  $ G-=0.296uS
Xrnl1_6_1 row6 gate_l1 cnl1_1 0 reram_1t1r Tf0=3.300000e-09  $ G-=0.296uS
Xrnl1_6_2 row6 gate_l1 cnl1_2 0 reram_1t1r Tf0=3.300000e-09  $ G-=0.296uS
Xrnl1_6_3 row6 gate_l1 cnl1_3 0 reram_1t1r Tf0=4.542408e-09  $ G-=27.611uS
Xrnl1_6_4 row6 gate_l1 cnl1_4 0 reram_1t1r Tf0=3.300000e-09  $ G-=0.296uS
Xrnl1_6_5 row6 gate_l1 cnl1_5 0 reram_1t1r Tf0=3.300000e-09  $ G-=0.296uS
Xrnl1_6_6 row6 gate_l1 cnl1_6 0 reram_1t1r Tf0=3.300000e-09  $ G-=0.296uS
Xrnl1_6_7 row6 gate_l1 cnl1_7 0 reram_1t1r Tf0=4.192956e-09  $ G-=7.752uS
Xrnl1_6_8 row6 gate_l1 cnl1_8 0 reram_1t1r Tf0=3.780314e-09  $ G-=1.730uS
Xrnl1_6_9 row6 gate_l1 cnl1_9 0 reram_1t1r Tf0=3.300000e-09  $ G-=0.296uS
Xrnl1_6_10 row6 gate_l1 cnl1_10 0 reram_1t1r Tf0=4.021778e-09  $ G-=4.161uS
Xrnl1_6_11 row6 gate_l1 cnl1_11 0 reram_1t1r Tf0=3.300000e-09  $ G-=0.296uS
Xrnl1_6_12 row6 gate_l1 cnl1_12 0 reram_1t1r Tf0=3.685159e-09  $ G-=1.224uS
Xrnl1_6_13 row6 gate_l1 cnl1_13 0 reram_1t1r Tf0=4.427883e-09  $ G-=18.209uS
Xrnl1_6_14 row6 gate_l1 cnl1_14 0 reram_1t1r Tf0=4.100573e-09  $ G-=5.541uS
Xrnl1_6_15 row6 gate_l1 cnl1_15 0 reram_1t1r Tf0=3.300000e-09  $ G-=0.296uS
Xrnl1_6_16 row6 gate_l1 cnl1_16 0 reram_1t1r Tf0=3.300000e-09  $ G-=0.296uS
Xrnl1_6_17 row6 gate_l1 cnl1_17 0 reram_1t1r Tf0=3.300000e-09  $ G-=0.296uS
Xrnl1_6_18 row6 gate_l1 cnl1_18 0 reram_1t1r Tf0=3.300000e-09  $ G-=0.296uS
Xrnl1_6_19 row6 gate_l1 cnl1_19 0 reram_1t1r Tf0=3.300000e-09  $ G-=0.296uS
Xrnl1_6_20 row6 gate_l1 cnl1_20 0 reram_1t1r Tf0=3.942579e-09  $ G-=3.120uS
Xrnl1_6_21 row6 gate_l1 cnl1_21 0 reram_1t1r Tf0=3.300000e-09  $ G-=0.296uS
Xrnl1_6_22 row6 gate_l1 cnl1_22 0 reram_1t1r Tf0=3.300000e-09  $ G-=0.296uS
Xrnl1_6_23 row6 gate_l1 cnl1_23 0 reram_1t1r Tf0=4.589691e-09  $ G-=32.789uS
Xrnl1_6_24 row6 gate_l1 cnl1_24 0 reram_1t1r Tf0=3.300000e-09  $ G-=0.296uS
Xrnl1_6_25 row6 gate_l1 cnl1_25 0 reram_1t1r Tf0=4.597074e-09  $ G-=33.681uS
Xrnl1_6_26 row6 gate_l1 cnl1_26 0 reram_1t1r Tf0=4.407629e-09  $ G-=16.916uS
Xrnl1_6_27 row6 gate_l1 cnl1_27 0 reram_1t1r Tf0=4.461539e-09  $ G-=20.579uS
Xrnl1_6_28 row6 gate_l1 cnl1_28 0 reram_1t1r Tf0=3.300000e-09  $ G-=0.296uS
Xrnl1_6_29 row6 gate_l1 cnl1_29 0 reram_1t1r Tf0=3.300000e-09  $ G-=0.296uS
Xrnl1_6_30 row6 gate_l1 cnl1_30 0 reram_1t1r Tf0=4.562798e-09  $ G-=29.735uS
Xrnl1_6_31 row6 gate_l1 cnl1_31 0 reram_1t1r Tf0=3.300000e-09  $ G-=0.296uS
Xrnl1_6_32 row6 gate_l1 cnl1_32 0 reram_1t1r Tf0=4.233270e-09  $ G-=8.975uS
Xrnl1_6_33 row6 gate_l1 cnl1_33 0 reram_1t1r Tf0=4.402160e-09  $ G-=16.583uS
Xrnl1_6_34 row6 gate_l1 cnl1_34 0 reram_1t1r Tf0=3.768461e-09  $ G-=1.657uS
Xrnl1_6_35 row6 gate_l1 cnl1_35 0 reram_1t1r Tf0=4.144086e-09  $ G-=6.490uS
Xrnl1_6_36 row6 gate_l1 cnl1_36 0 reram_1t1r Tf0=3.300000e-09  $ G-=0.296uS
Xrnl1_6_37 row6 gate_l1 cnl1_37 0 reram_1t1r Tf0=3.300000e-09  $ G-=0.296uS
Xrnl1_6_38 row6 gate_l1 cnl1_38 0 reram_1t1r Tf0=4.449718e-09  $ G-=19.713uS
Xrnl1_6_39 row6 gate_l1 cnl1_39 0 reram_1t1r Tf0=3.300000e-09  $ G-=0.296uS
Xrnl1_6_40 row6 gate_l1 cnl1_40 0 reram_1t1r Tf0=4.209671e-09  $ G-=8.238uS
Xrnl1_6_41 row6 gate_l1 cnl1_41 0 reram_1t1r Tf0=4.091318e-09  $ G-=5.357uS
Xrnl1_6_42 row6 gate_l1 cnl1_42 0 reram_1t1r Tf0=3.300000e-09  $ G-=0.296uS
Xrnl1_6_43 row6 gate_l1 cnl1_43 0 reram_1t1r Tf0=4.209910e-09  $ G-=8.245uS
Xrnl1_6_44 row6 gate_l1 cnl1_44 0 reram_1t1r Tf0=4.229252e-09  $ G-=8.845uS
Xrnl1_6_45 row6 gate_l1 cnl1_45 0 reram_1t1r Tf0=4.527759e-09  $ G-=26.179uS
Xrnl1_6_46 row6 gate_l1 cnl1_46 0 reram_1t1r Tf0=4.402429e-09  $ G-=16.600uS
Xrnl1_6_47 row6 gate_l1 cnl1_47 0 reram_1t1r Tf0=3.300000e-09  $ G-=0.296uS
Xrnl1_6_48 row6 gate_l1 cnl1_48 0 reram_1t1r Tf0=3.300000e-09  $ G-=0.296uS
Xrnl1_6_49 row6 gate_l1 cnl1_49 0 reram_1t1r Tf0=4.045437e-09  $ G-=4.534uS
Xrnl1_6_50 row6 gate_l1 cnl1_50 0 reram_1t1r Tf0=4.360181e-09  $ G-=14.237uS
Xrnl1_6_51 row6 gate_l1 cnl1_51 0 reram_1t1r Tf0=3.978976e-09  $ G-=3.561uS
Xrnl1_6_52 row6 gate_l1 cnl1_52 0 reram_1t1r Tf0=4.316794e-09  $ G-=12.159uS
Xrnl1_6_53 row6 gate_l1 cnl1_53 0 reram_1t1r Tf0=3.954751e-09  $ G-=3.261uS
Xrnl1_6_54 row6 gate_l1 cnl1_54 0 reram_1t1r Tf0=3.300000e-09  $ G-=0.296uS
Xrnl1_6_55 row6 gate_l1 cnl1_55 0 reram_1t1r Tf0=4.626409e-09  $ G-=37.471uS
Xrnl1_6_56 row6 gate_l1 cnl1_56 0 reram_1t1r Tf0=3.300000e-09  $ G-=0.296uS
Xrnl1_6_57 row6 gate_l1 cnl1_57 0 reram_1t1r Tf0=3.300000e-09  $ G-=0.296uS
Xrnl1_6_58 row6 gate_l1 cnl1_58 0 reram_1t1r Tf0=3.300000e-09  $ G-=0.296uS
Xrnl1_6_59 row6 gate_l1 cnl1_59 0 reram_1t1r Tf0=4.463190e-09  $ G-=20.702uS
Xrnl1_6_60 row6 gate_l1 cnl1_60 0 reram_1t1r Tf0=3.926892e-09  $ G-=2.947uS
Xrnl1_6_61 row6 gate_l1 cnl1_61 0 reram_1t1r Tf0=4.380145e-09  $ G-=15.308uS
Xrnl1_6_62 row6 gate_l1 cnl1_62 0 reram_1t1r Tf0=3.300000e-09  $ G-=0.296uS
Xrnl1_6_63 row6 gate_l1 cnl1_63 0 reram_1t1r Tf0=3.635531e-09  $ G-=1.022uS
Xrnl1_7_0 row7 gate_l1 cnl1_0 0 reram_1t1r Tf0=3.300000e-09  $ G-=0.296uS
Xrnl1_7_1 row7 gate_l1 cnl1_1 0 reram_1t1r Tf0=4.147781e-09  $ G-=6.578uS
Xrnl1_7_2 row7 gate_l1 cnl1_2 0 reram_1t1r Tf0=3.300000e-09  $ G-=0.296uS
Xrnl1_7_3 row7 gate_l1 cnl1_3 0 reram_1t1r Tf0=3.652587e-09  $ G-=1.087uS
Xrnl1_7_4 row7 gate_l1 cnl1_4 0 reram_1t1r Tf0=4.056220e-09  $ G-=4.716uS
Xrnl1_7_5 row7 gate_l1 cnl1_5 0 reram_1t1r Tf0=3.300000e-09  $ G-=0.296uS
Xrnl1_7_6 row7 gate_l1 cnl1_6 0 reram_1t1r Tf0=3.300000e-09  $ G-=0.296uS
Xrnl1_7_7 row7 gate_l1 cnl1_7 0 reram_1t1r Tf0=3.300000e-09  $ G-=0.296uS
Xrnl1_7_8 row7 gate_l1 cnl1_8 0 reram_1t1r Tf0=4.167578e-09  $ G-=7.069uS
Xrnl1_7_9 row7 gate_l1 cnl1_9 0 reram_1t1r Tf0=3.300000e-09  $ G-=0.296uS
Xrnl1_7_10 row7 gate_l1 cnl1_10 0 reram_1t1r Tf0=4.154749e-09  $ G-=6.747uS
Xrnl1_7_11 row7 gate_l1 cnl1_11 0 reram_1t1r Tf0=4.300988e-09  $ G-=11.480uS
Xrnl1_7_12 row7 gate_l1 cnl1_12 0 reram_1t1r Tf0=4.117198e-09  $ G-=5.886uS
Xrnl1_7_13 row7 gate_l1 cnl1_13 0 reram_1t1r Tf0=3.300000e-09  $ G-=0.296uS
Xrnl1_7_14 row7 gate_l1 cnl1_14 0 reram_1t1r Tf0=3.300000e-09  $ G-=0.296uS
Xrnl1_7_15 row7 gate_l1 cnl1_15 0 reram_1t1r Tf0=3.300000e-09  $ G-=0.296uS
Xrnl1_7_16 row7 gate_l1 cnl1_16 0 reram_1t1r Tf0=3.300000e-09  $ G-=0.296uS
Xrnl1_7_17 row7 gate_l1 cnl1_17 0 reram_1t1r Tf0=4.297850e-09  $ G-=11.350uS
Xrnl1_7_18 row7 gate_l1 cnl1_18 0 reram_1t1r Tf0=3.663072e-09  $ G-=1.130uS
Xrnl1_7_19 row7 gate_l1 cnl1_19 0 reram_1t1r Tf0=4.220369e-09  $ G-=8.564uS
Xrnl1_7_20 row7 gate_l1 cnl1_20 0 reram_1t1r Tf0=4.254332e-09  $ G-=9.690uS
Xrnl1_7_21 row7 gate_l1 cnl1_21 0 reram_1t1r Tf0=3.300000e-09  $ G-=0.296uS
Xrnl1_7_22 row7 gate_l1 cnl1_22 0 reram_1t1r Tf0=4.478912e-09  $ G-=21.920uS
Xrnl1_7_23 row7 gate_l1 cnl1_23 0 reram_1t1r Tf0=3.300000e-09  $ G-=0.296uS
Xrnl1_7_24 row7 gate_l1 cnl1_24 0 reram_1t1r Tf0=4.568081e-09  $ G-=30.312uS
Xrnl1_7_25 row7 gate_l1 cnl1_25 0 reram_1t1r Tf0=3.300000e-09  $ G-=0.296uS
Xrnl1_7_26 row7 gate_l1 cnl1_26 0 reram_1t1r Tf0=3.300000e-09  $ G-=0.296uS
Xrnl1_7_27 row7 gate_l1 cnl1_27 0 reram_1t1r Tf0=3.300000e-09  $ G-=0.296uS
Xrnl1_7_28 row7 gate_l1 cnl1_28 0 reram_1t1r Tf0=4.239290e-09  $ G-=9.174uS
Xrnl1_7_29 row7 gate_l1 cnl1_29 0 reram_1t1r Tf0=4.388604e-09  $ G-=15.786uS
Xrnl1_7_30 row7 gate_l1 cnl1_30 0 reram_1t1r Tf0=3.300000e-09  $ G-=0.296uS
Xrnl1_7_31 row7 gate_l1 cnl1_31 0 reram_1t1r Tf0=4.091019e-09  $ G-=5.352uS
Xrnl1_7_32 row7 gate_l1 cnl1_32 0 reram_1t1r Tf0=3.300000e-09  $ G-=0.296uS
Xrnl1_7_33 row7 gate_l1 cnl1_33 0 reram_1t1r Tf0=3.300000e-09  $ G-=0.296uS
Xrnl1_7_34 row7 gate_l1 cnl1_34 0 reram_1t1r Tf0=4.135869e-09  $ G-=6.299uS
Xrnl1_7_35 row7 gate_l1 cnl1_35 0 reram_1t1r Tf0=3.300000e-09  $ G-=0.296uS
Xrnl1_7_36 row7 gate_l1 cnl1_36 0 reram_1t1r Tf0=4.007079e-09  $ G-=3.944uS
Xrnl1_7_37 row7 gate_l1 cnl1_37 0 reram_1t1r Tf0=3.300000e-09  $ G-=0.296uS
Xrnl1_7_38 row7 gate_l1 cnl1_38 0 reram_1t1r Tf0=4.179422e-09  $ G-=7.380uS
Xrnl1_7_39 row7 gate_l1 cnl1_39 0 reram_1t1r Tf0=3.894981e-09  $ G-=2.624uS
Xrnl1_7_40 row7 gate_l1 cnl1_40 0 reram_1t1r Tf0=3.300000e-09  $ G-=0.296uS
Xrnl1_7_41 row7 gate_l1 cnl1_41 0 reram_1t1r Tf0=3.300000e-09  $ G-=0.296uS
Xrnl1_7_42 row7 gate_l1 cnl1_42 0 reram_1t1r Tf0=3.300000e-09  $ G-=0.296uS
Xrnl1_7_43 row7 gate_l1 cnl1_43 0 reram_1t1r Tf0=3.300000e-09  $ G-=0.296uS
Xrnl1_7_44 row7 gate_l1 cnl1_44 0 reram_1t1r Tf0=3.358239e-09  $ G-=0.373uS
Xrnl1_7_45 row7 gate_l1 cnl1_45 0 reram_1t1r Tf0=4.075847e-09  $ G-=5.064uS
Xrnl1_7_46 row7 gate_l1 cnl1_46 0 reram_1t1r Tf0=3.300000e-09  $ G-=0.296uS
Xrnl1_7_47 row7 gate_l1 cnl1_47 0 reram_1t1r Tf0=4.105403e-09  $ G-=5.639uS
Xrnl1_7_48 row7 gate_l1 cnl1_48 0 reram_1t1r Tf0=3.300000e-09  $ G-=0.296uS
Xrnl1_7_49 row7 gate_l1 cnl1_49 0 reram_1t1r Tf0=4.416382e-09  $ G-=17.463uS
Xrnl1_7_50 row7 gate_l1 cnl1_50 0 reram_1t1r Tf0=3.300000e-09  $ G-=0.296uS
Xrnl1_7_51 row7 gate_l1 cnl1_51 0 reram_1t1r Tf0=3.300000e-09  $ G-=0.296uS
Xrnl1_7_52 row7 gate_l1 cnl1_52 0 reram_1t1r Tf0=3.300000e-09  $ G-=0.296uS
Xrnl1_7_53 row7 gate_l1 cnl1_53 0 reram_1t1r Tf0=4.087456e-09  $ G-=5.283uS
Xrnl1_7_54 row7 gate_l1 cnl1_54 0 reram_1t1r Tf0=3.942908e-09  $ G-=3.124uS
Xrnl1_7_55 row7 gate_l1 cnl1_55 0 reram_1t1r Tf0=3.300000e-09  $ G-=0.296uS
Xrnl1_7_56 row7 gate_l1 cnl1_56 0 reram_1t1r Tf0=4.365551e-09  $ G-=14.517uS
Xrnl1_7_57 row7 gate_l1 cnl1_57 0 reram_1t1r Tf0=4.420327e-09  $ G-=17.716uS
Xrnl1_7_58 row7 gate_l1 cnl1_58 0 reram_1t1r Tf0=3.300000e-09  $ G-=0.296uS
Xrnl1_7_59 row7 gate_l1 cnl1_59 0 reram_1t1r Tf0=3.300000e-09  $ G-=0.296uS
Xrnl1_7_60 row7 gate_l1 cnl1_60 0 reram_1t1r Tf0=3.300000e-09  $ G-=0.296uS
Xrnl1_7_61 row7 gate_l1 cnl1_61 0 reram_1t1r Tf0=3.300000e-09  $ G-=0.296uS
Xrnl1_7_62 row7 gate_l1 cnl1_62 0 reram_1t1r Tf0=3.524980e-09  $ G-=0.684uS
Xrnl1_7_63 row7 gate_l1 cnl1_63 0 reram_1t1r Tf0=3.300000e-09  $ G-=0.296uS

* ===== L1 COLUMN READOUT (64 col_readout instances) =====
* Replaces 128 Vsource(0V) + 128 CCCS with real transistor mirrors
Xcolrd1_0 cpl1_0 cnl1_0 nmac1_0 vdd 0 col_readout
Xcolrd1_1 cpl1_1 cnl1_1 nmac1_1 vdd 0 col_readout
Xcolrd1_2 cpl1_2 cnl1_2 nmac1_2 vdd 0 col_readout
Xcolrd1_3 cpl1_3 cnl1_3 nmac1_3 vdd 0 col_readout
Xcolrd1_4 cpl1_4 cnl1_4 nmac1_4 vdd 0 col_readout
Xcolrd1_5 cpl1_5 cnl1_5 nmac1_5 vdd 0 col_readout
Xcolrd1_6 cpl1_6 cnl1_6 nmac1_6 vdd 0 col_readout
Xcolrd1_7 cpl1_7 cnl1_7 nmac1_7 vdd 0 col_readout
Xcolrd1_8 cpl1_8 cnl1_8 nmac1_8 vdd 0 col_readout
Xcolrd1_9 cpl1_9 cnl1_9 nmac1_9 vdd 0 col_readout
Xcolrd1_10 cpl1_10 cnl1_10 nmac1_10 vdd 0 col_readout
Xcolrd1_11 cpl1_11 cnl1_11 nmac1_11 vdd 0 col_readout
Xcolrd1_12 cpl1_12 cnl1_12 nmac1_12 vdd 0 col_readout
Xcolrd1_13 cpl1_13 cnl1_13 nmac1_13 vdd 0 col_readout
Xcolrd1_14 cpl1_14 cnl1_14 nmac1_14 vdd 0 col_readout
Xcolrd1_15 cpl1_15 cnl1_15 nmac1_15 vdd 0 col_readout
Xcolrd1_16 cpl1_16 cnl1_16 nmac1_16 vdd 0 col_readout
Xcolrd1_17 cpl1_17 cnl1_17 nmac1_17 vdd 0 col_readout
Xcolrd1_18 cpl1_18 cnl1_18 nmac1_18 vdd 0 col_readout
Xcolrd1_19 cpl1_19 cnl1_19 nmac1_19 vdd 0 col_readout
Xcolrd1_20 cpl1_20 cnl1_20 nmac1_20 vdd 0 col_readout
Xcolrd1_21 cpl1_21 cnl1_21 nmac1_21 vdd 0 col_readout
Xcolrd1_22 cpl1_22 cnl1_22 nmac1_22 vdd 0 col_readout
Xcolrd1_23 cpl1_23 cnl1_23 nmac1_23 vdd 0 col_readout
Xcolrd1_24 cpl1_24 cnl1_24 nmac1_24 vdd 0 col_readout
Xcolrd1_25 cpl1_25 cnl1_25 nmac1_25 vdd 0 col_readout
Xcolrd1_26 cpl1_26 cnl1_26 nmac1_26 vdd 0 col_readout
Xcolrd1_27 cpl1_27 cnl1_27 nmac1_27 vdd 0 col_readout
Xcolrd1_28 cpl1_28 cnl1_28 nmac1_28 vdd 0 col_readout
Xcolrd1_29 cpl1_29 cnl1_29 nmac1_29 vdd 0 col_readout
Xcolrd1_30 cpl1_30 cnl1_30 nmac1_30 vdd 0 col_readout
Xcolrd1_31 cpl1_31 cnl1_31 nmac1_31 vdd 0 col_readout
Xcolrd1_32 cpl1_32 cnl1_32 nmac1_32 vdd 0 col_readout
Xcolrd1_33 cpl1_33 cnl1_33 nmac1_33 vdd 0 col_readout
Xcolrd1_34 cpl1_34 cnl1_34 nmac1_34 vdd 0 col_readout
Xcolrd1_35 cpl1_35 cnl1_35 nmac1_35 vdd 0 col_readout
Xcolrd1_36 cpl1_36 cnl1_36 nmac1_36 vdd 0 col_readout
Xcolrd1_37 cpl1_37 cnl1_37 nmac1_37 vdd 0 col_readout
Xcolrd1_38 cpl1_38 cnl1_38 nmac1_38 vdd 0 col_readout
Xcolrd1_39 cpl1_39 cnl1_39 nmac1_39 vdd 0 col_readout
Xcolrd1_40 cpl1_40 cnl1_40 nmac1_40 vdd 0 col_readout
Xcolrd1_41 cpl1_41 cnl1_41 nmac1_41 vdd 0 col_readout
Xcolrd1_42 cpl1_42 cnl1_42 nmac1_42 vdd 0 col_readout
Xcolrd1_43 cpl1_43 cnl1_43 nmac1_43 vdd 0 col_readout
Xcolrd1_44 cpl1_44 cnl1_44 nmac1_44 vdd 0 col_readout
Xcolrd1_45 cpl1_45 cnl1_45 nmac1_45 vdd 0 col_readout
Xcolrd1_46 cpl1_46 cnl1_46 nmac1_46 vdd 0 col_readout
Xcolrd1_47 cpl1_47 cnl1_47 nmac1_47 vdd 0 col_readout
Xcolrd1_48 cpl1_48 cnl1_48 nmac1_48 vdd 0 col_readout
Xcolrd1_49 cpl1_49 cnl1_49 nmac1_49 vdd 0 col_readout
Xcolrd1_50 cpl1_50 cnl1_50 nmac1_50 vdd 0 col_readout
Xcolrd1_51 cpl1_51 cnl1_51 nmac1_51 vdd 0 col_readout
Xcolrd1_52 cpl1_52 cnl1_52 nmac1_52 vdd 0 col_readout
Xcolrd1_53 cpl1_53 cnl1_53 nmac1_53 vdd 0 col_readout
Xcolrd1_54 cpl1_54 cnl1_54 nmac1_54 vdd 0 col_readout
Xcolrd1_55 cpl1_55 cnl1_55 nmac1_55 vdd 0 col_readout
Xcolrd1_56 cpl1_56 cnl1_56 nmac1_56 vdd 0 col_readout
Xcolrd1_57 cpl1_57 cnl1_57 nmac1_57 vdd 0 col_readout
Xcolrd1_58 cpl1_58 cnl1_58 nmac1_58 vdd 0 col_readout
Xcolrd1_59 cpl1_59 cnl1_59 nmac1_59 vdd 0 col_readout
Xcolrd1_60 cpl1_60 cnl1_60 nmac1_60 vdd 0 col_readout
Xcolrd1_61 cpl1_61 cnl1_61 nmac1_61 vdd 0 col_readout
Xcolrd1_62 cpl1_62 cnl1_62 nmac1_62 vdd 0 col_readout
Xcolrd1_63 cpl1_63 cnl1_63 nmac1_63 vdd 0 col_readout

* ===== L1->L2 INTERSTAGE: BIAS + ReLU + OUTPUT (64 channels) =====

* --- Ch 0: b1=+0.4012, I_bias=+59004244747.969uA ---
Ibr1_0 pbr1_0 0 5.900424e+04
Xbr1_0 pbr1_0 pbr1_0 vdd vdd sky130_fd_pr__pfet_01v8 W=2.0u L=0.5u
Xbm1_0 nmac1_0 pbr1_0 vdd vdd sky130_fd_pr__pfet_01v8 W=2.0u L=0.5u
Xr1a_0 nmac1_0 nmac1_0 0 0 sky130_fd_pr__nfet_01v8 W=4.0u L=0.5u
Xr1b_0 nrelu1_0 nmac1_0 0 0 sky130_fd_pr__nfet_01v8 W=4.0u L=0.5u
Xopr_0 nrelu1_0 nrelu1_0 vdd vdd sky130_fd_pr__pfet_01v8 W=2.0u L=0.5u
Xopm_0 vout1_0 nrelu1_0 vdd vdd sky130_fd_pr__pfet_01v8 W=2.0u L=0.5u

* --- Ch 1: b1=+0.4583, I_bias=+67394490432.880uA ---
Ibr1_1 pbr1_1 0 6.739449e+04
Xbr1_1 pbr1_1 pbr1_1 vdd vdd sky130_fd_pr__pfet_01v8 W=2.0u L=0.5u
Xbm1_1 nmac1_1 pbr1_1 vdd vdd sky130_fd_pr__pfet_01v8 W=2.0u L=0.5u
Xr1a_1 nmac1_1 nmac1_1 0 0 sky130_fd_pr__nfet_01v8 W=4.0u L=0.5u
Xr1b_1 nrelu1_1 nmac1_1 0 0 sky130_fd_pr__nfet_01v8 W=4.0u L=0.5u
Xopr_1 nrelu1_1 nrelu1_1 vdd vdd sky130_fd_pr__pfet_01v8 W=2.0u L=0.5u
Xopm_1 vout1_1 nrelu1_1 vdd vdd sky130_fd_pr__pfet_01v8 W=2.0u L=0.5u

* --- Ch 2: b1=-0.2722, I_bias=-40030673092.376uA ---
Ibr1_2 vdd nbr1_2 4.003067e+04
Xbr1_2 nbr1_2 nbr1_2 0 0 sky130_fd_pr__nfet_01v8 W=2.0u L=0.5u
Xbm1_2 nmac1_2 nbr1_2 0 0 sky130_fd_pr__nfet_01v8 W=2.0u L=0.5u
Xr1a_2 nmac1_2 nmac1_2 0 0 sky130_fd_pr__nfet_01v8 W=4.0u L=0.5u
Xr1b_2 nrelu1_2 nmac1_2 0 0 sky130_fd_pr__nfet_01v8 W=4.0u L=0.5u
Xopr_2 nrelu1_2 nrelu1_2 vdd vdd sky130_fd_pr__pfet_01v8 W=2.0u L=0.5u
Xopm_2 vout1_2 nrelu1_2 vdd vdd sky130_fd_pr__pfet_01v8 W=2.0u L=0.5u

* --- Ch 3: b1=+0.0533, I_bias=+7837269735.236uA ---
Ibr1_3 pbr1_3 0 7.837270e+03
Xbr1_3 pbr1_3 pbr1_3 vdd vdd sky130_fd_pr__pfet_01v8 W=2.0u L=0.5u
Xbm1_3 nmac1_3 pbr1_3 vdd vdd sky130_fd_pr__pfet_01v8 W=2.0u L=0.5u
Xr1a_3 nmac1_3 nmac1_3 0 0 sky130_fd_pr__nfet_01v8 W=4.0u L=0.5u
Xr1b_3 nrelu1_3 nmac1_3 0 0 sky130_fd_pr__nfet_01v8 W=4.0u L=0.5u
Xopr_3 nrelu1_3 nrelu1_3 vdd vdd sky130_fd_pr__pfet_01v8 W=2.0u L=0.5u
Xopm_3 vout1_3 nrelu1_3 vdd vdd sky130_fd_pr__pfet_01v8 W=2.0u L=0.5u

* --- Ch 4: b1=+0.2311, I_bias=+33978728592.142uA ---
Ibr1_4 pbr1_4 0 3.397873e+04
Xbr1_4 pbr1_4 pbr1_4 vdd vdd sky130_fd_pr__pfet_01v8 W=2.0u L=0.5u
Xbm1_4 nmac1_4 pbr1_4 vdd vdd sky130_fd_pr__pfet_01v8 W=2.0u L=0.5u
Xr1a_4 nmac1_4 nmac1_4 0 0 sky130_fd_pr__nfet_01v8 W=4.0u L=0.5u
Xr1b_4 nrelu1_4 nmac1_4 0 0 sky130_fd_pr__nfet_01v8 W=4.0u L=0.5u
Xopr_4 nrelu1_4 nrelu1_4 vdd vdd sky130_fd_pr__pfet_01v8 W=2.0u L=0.5u
Xopm_4 vout1_4 nrelu1_4 vdd vdd sky130_fd_pr__pfet_01v8 W=2.0u L=0.5u

* --- Ch 5: b1=+0.7988, I_bias=+117475162330.999uA ---
Ibr1_5 pbr1_5 0 1.174752e+05
Xbr1_5 pbr1_5 pbr1_5 vdd vdd sky130_fd_pr__pfet_01v8 W=2.0u L=0.5u
Xbm1_5 nmac1_5 pbr1_5 vdd vdd sky130_fd_pr__pfet_01v8 W=2.0u L=0.5u
Xr1a_5 nmac1_5 nmac1_5 0 0 sky130_fd_pr__nfet_01v8 W=4.0u L=0.5u
Xr1b_5 nrelu1_5 nmac1_5 0 0 sky130_fd_pr__nfet_01v8 W=4.0u L=0.5u
Xopr_5 nrelu1_5 nrelu1_5 vdd vdd sky130_fd_pr__pfet_01v8 W=2.0u L=0.5u
Xopm_5 vout1_5 nrelu1_5 vdd vdd sky130_fd_pr__pfet_01v8 W=2.0u L=0.5u

* --- Ch 6: b1=+0.8398, I_bias=+123501775173.048uA ---
Ibr1_6 pbr1_6 0 1.235018e+05
Xbr1_6 pbr1_6 pbr1_6 vdd vdd sky130_fd_pr__pfet_01v8 W=2.0u L=0.5u
Xbm1_6 nmac1_6 pbr1_6 vdd vdd sky130_fd_pr__pfet_01v8 W=2.0u L=0.5u
Xr1a_6 nmac1_6 nmac1_6 0 0 sky130_fd_pr__nfet_01v8 W=4.0u L=0.5u
Xr1b_6 nrelu1_6 nmac1_6 0 0 sky130_fd_pr__nfet_01v8 W=4.0u L=0.5u
Xopr_6 nrelu1_6 nrelu1_6 vdd vdd sky130_fd_pr__pfet_01v8 W=2.0u L=0.5u
Xopm_6 vout1_6 nrelu1_6 vdd vdd sky130_fd_pr__pfet_01v8 W=2.0u L=0.5u

* --- Ch 7: b1=+0.4226, I_bias=+62152222177.917uA ---
Ibr1_7 pbr1_7 0 6.215222e+04
Xbr1_7 pbr1_7 pbr1_7 vdd vdd sky130_fd_pr__pfet_01v8 W=2.0u L=0.5u
Xbm1_7 nmac1_7 pbr1_7 vdd vdd sky130_fd_pr__pfet_01v8 W=2.0u L=0.5u
Xr1a_7 nmac1_7 nmac1_7 0 0 sky130_fd_pr__nfet_01v8 W=4.0u L=0.5u
Xr1b_7 nrelu1_7 nmac1_7 0 0 sky130_fd_pr__nfet_01v8 W=4.0u L=0.5u
Xopr_7 nrelu1_7 nrelu1_7 vdd vdd sky130_fd_pr__pfet_01v8 W=2.0u L=0.5u
Xopm_7 vout1_7 nrelu1_7 vdd vdd sky130_fd_pr__pfet_01v8 W=2.0u L=0.5u

* --- Ch 8: b1=+0.0604, I_bias=+8887928890.372uA ---
Ibr1_8 pbr1_8 0 8.887929e+03
Xbr1_8 pbr1_8 pbr1_8 vdd vdd sky130_fd_pr__pfet_01v8 W=2.0u L=0.5u
Xbm1_8 nmac1_8 pbr1_8 vdd vdd sky130_fd_pr__pfet_01v8 W=2.0u L=0.5u
Xr1a_8 nmac1_8 nmac1_8 0 0 sky130_fd_pr__nfet_01v8 W=4.0u L=0.5u
Xr1b_8 nrelu1_8 nmac1_8 0 0 sky130_fd_pr__nfet_01v8 W=4.0u L=0.5u
Xopr_8 nrelu1_8 nrelu1_8 vdd vdd sky130_fd_pr__pfet_01v8 W=2.0u L=0.5u
Xopm_8 vout1_8 nrelu1_8 vdd vdd sky130_fd_pr__pfet_01v8 W=2.0u L=0.5u

* --- Ch 9: b1=-0.1588, I_bias=-23352046203.612uA ---
Ibr1_9 vdd nbr1_9 2.335205e+04
Xbr1_9 nbr1_9 nbr1_9 0 0 sky130_fd_pr__nfet_01v8 W=2.0u L=0.5u
Xbm1_9 nmac1_9 nbr1_9 0 0 sky130_fd_pr__nfet_01v8 W=2.0u L=0.5u
Xr1a_9 nmac1_9 nmac1_9 0 0 sky130_fd_pr__nfet_01v8 W=4.0u L=0.5u
Xr1b_9 nrelu1_9 nmac1_9 0 0 sky130_fd_pr__nfet_01v8 W=4.0u L=0.5u
Xopr_9 nrelu1_9 nrelu1_9 vdd vdd sky130_fd_pr__pfet_01v8 W=2.0u L=0.5u
Xopm_9 vout1_9 nrelu1_9 vdd vdd sky130_fd_pr__pfet_01v8 W=2.0u L=0.5u

* --- Ch 10: b1=+0.8163, I_bias=+120049417794.354uA ---
Ibr1_10 pbr1_10 0 1.200494e+05
Xbr1_10 pbr1_10 pbr1_10 vdd vdd sky130_fd_pr__pfet_01v8 W=2.0u L=0.5u
Xbm1_10 nmac1_10 pbr1_10 vdd vdd sky130_fd_pr__pfet_01v8 W=2.0u L=0.5u
Xr1a_10 nmac1_10 nmac1_10 0 0 sky130_fd_pr__nfet_01v8 W=4.0u L=0.5u
Xr1b_10 nrelu1_10 nmac1_10 0 0 sky130_fd_pr__nfet_01v8 W=4.0u L=0.5u
Xopr_10 nrelu1_10 nrelu1_10 vdd vdd sky130_fd_pr__pfet_01v8 W=2.0u L=0.5u
Xopm_10 vout1_10 nrelu1_10 vdd vdd sky130_fd_pr__pfet_01v8 W=2.0u L=0.5u

* --- Ch 11: b1=+0.5040, I_bias=+74112576213.468uA ---
Ibr1_11 pbr1_11 0 7.411258e+04
Xbr1_11 pbr1_11 pbr1_11 vdd vdd sky130_fd_pr__pfet_01v8 W=2.0u L=0.5u
Xbm1_11 nmac1_11 pbr1_11 vdd vdd sky130_fd_pr__pfet_01v8 W=2.0u L=0.5u
Xr1a_11 nmac1_11 nmac1_11 0 0 sky130_fd_pr__nfet_01v8 W=4.0u L=0.5u
Xr1b_11 nrelu1_11 nmac1_11 0 0 sky130_fd_pr__nfet_01v8 W=4.0u L=0.5u
Xopr_11 nrelu1_11 nrelu1_11 vdd vdd sky130_fd_pr__pfet_01v8 W=2.0u L=0.5u
Xopm_11 vout1_11 nrelu1_11 vdd vdd sky130_fd_pr__pfet_01v8 W=2.0u L=0.5u

* --- Ch 12: b1=+0.4302, I_bias=+63258686482.705uA ---
Ibr1_12 pbr1_12 0 6.325869e+04
Xbr1_12 pbr1_12 pbr1_12 vdd vdd sky130_fd_pr__pfet_01v8 W=2.0u L=0.5u
Xbm1_12 nmac1_12 pbr1_12 vdd vdd sky130_fd_pr__pfet_01v8 W=2.0u L=0.5u
Xr1a_12 nmac1_12 nmac1_12 0 0 sky130_fd_pr__nfet_01v8 W=4.0u L=0.5u
Xr1b_12 nrelu1_12 nmac1_12 0 0 sky130_fd_pr__nfet_01v8 W=4.0u L=0.5u
Xopr_12 nrelu1_12 nrelu1_12 vdd vdd sky130_fd_pr__pfet_01v8 W=2.0u L=0.5u
Xopm_12 vout1_12 nrelu1_12 vdd vdd sky130_fd_pr__pfet_01v8 W=2.0u L=0.5u

* --- Ch 13: b1=-0.0512, I_bias=-7527916742.057uA ---
Ibr1_13 vdd nbr1_13 7.527917e+03
Xbr1_13 nbr1_13 nbr1_13 0 0 sky130_fd_pr__nfet_01v8 W=2.0u L=0.5u
Xbm1_13 nmac1_13 nbr1_13 0 0 sky130_fd_pr__nfet_01v8 W=2.0u L=0.5u
Xr1a_13 nmac1_13 nmac1_13 0 0 sky130_fd_pr__nfet_01v8 W=4.0u L=0.5u
Xr1b_13 nrelu1_13 nmac1_13 0 0 sky130_fd_pr__nfet_01v8 W=4.0u L=0.5u
Xopr_13 nrelu1_13 nrelu1_13 vdd vdd sky130_fd_pr__pfet_01v8 W=2.0u L=0.5u
Xopm_13 vout1_13 nrelu1_13 vdd vdd sky130_fd_pr__pfet_01v8 W=2.0u L=0.5u

* --- Ch 14: b1=+0.3789, I_bias=+55718131846.170uA ---
Ibr1_14 pbr1_14 0 5.571813e+04
Xbr1_14 pbr1_14 pbr1_14 vdd vdd sky130_fd_pr__pfet_01v8 W=2.0u L=0.5u
Xbm1_14 nmac1_14 pbr1_14 vdd vdd sky130_fd_pr__pfet_01v8 W=2.0u L=0.5u
Xr1a_14 nmac1_14 nmac1_14 0 0 sky130_fd_pr__nfet_01v8 W=4.0u L=0.5u
Xr1b_14 nrelu1_14 nmac1_14 0 0 sky130_fd_pr__nfet_01v8 W=4.0u L=0.5u
Xopr_14 nrelu1_14 nrelu1_14 vdd vdd sky130_fd_pr__pfet_01v8 W=2.0u L=0.5u
Xopm_14 vout1_14 nrelu1_14 vdd vdd sky130_fd_pr__pfet_01v8 W=2.0u L=0.5u

* --- Ch 15: b1=+0.4368, I_bias=+64233366364.285uA ---
Ibr1_15 pbr1_15 0 6.423337e+04
Xbr1_15 pbr1_15 pbr1_15 vdd vdd sky130_fd_pr__pfet_01v8 W=2.0u L=0.5u
Xbm1_15 nmac1_15 pbr1_15 vdd vdd sky130_fd_pr__pfet_01v8 W=2.0u L=0.5u
Xr1a_15 nmac1_15 nmac1_15 0 0 sky130_fd_pr__nfet_01v8 W=4.0u L=0.5u
Xr1b_15 nrelu1_15 nmac1_15 0 0 sky130_fd_pr__nfet_01v8 W=4.0u L=0.5u
Xopr_15 nrelu1_15 nrelu1_15 vdd vdd sky130_fd_pr__pfet_01v8 W=2.0u L=0.5u
Xopm_15 vout1_15 nrelu1_15 vdd vdd sky130_fd_pr__pfet_01v8 W=2.0u L=0.5u

* --- Ch 16: b1=-0.7094, I_bias=-104326042680.936uA ---
Ibr1_16 vdd nbr1_16 1.043260e+05
Xbr1_16 nbr1_16 nbr1_16 0 0 sky130_fd_pr__nfet_01v8 W=2.0u L=0.5u
Xbm1_16 nmac1_16 nbr1_16 0 0 sky130_fd_pr__nfet_01v8 W=2.0u L=0.5u
Xr1a_16 nmac1_16 nmac1_16 0 0 sky130_fd_pr__nfet_01v8 W=4.0u L=0.5u
Xr1b_16 nrelu1_16 nmac1_16 0 0 sky130_fd_pr__nfet_01v8 W=4.0u L=0.5u
Xopr_16 nrelu1_16 nrelu1_16 vdd vdd sky130_fd_pr__pfet_01v8 W=2.0u L=0.5u
Xopm_16 vout1_16 nrelu1_16 vdd vdd sky130_fd_pr__pfet_01v8 W=2.0u L=0.5u

* --- Ch 17: b1=+0.4055, I_bias=+59626904110.479uA ---
Ibr1_17 pbr1_17 0 5.962690e+04
Xbr1_17 pbr1_17 pbr1_17 vdd vdd sky130_fd_pr__pfet_01v8 W=2.0u L=0.5u
Xbm1_17 nmac1_17 pbr1_17 vdd vdd sky130_fd_pr__pfet_01v8 W=2.0u L=0.5u
Xr1a_17 nmac1_17 nmac1_17 0 0 sky130_fd_pr__nfet_01v8 W=4.0u L=0.5u
Xr1b_17 nrelu1_17 nmac1_17 0 0 sky130_fd_pr__nfet_01v8 W=4.0u L=0.5u
Xopr_17 nrelu1_17 nrelu1_17 vdd vdd sky130_fd_pr__pfet_01v8 W=2.0u L=0.5u
Xopm_17 vout1_17 nrelu1_17 vdd vdd sky130_fd_pr__pfet_01v8 W=2.0u L=0.5u

* --- Ch 18: b1=+0.3677, I_bias=+54072991246.255uA ---
Ibr1_18 pbr1_18 0 5.407299e+04
Xbr1_18 pbr1_18 pbr1_18 vdd vdd sky130_fd_pr__pfet_01v8 W=2.0u L=0.5u
Xbm1_18 nmac1_18 pbr1_18 vdd vdd sky130_fd_pr__pfet_01v8 W=2.0u L=0.5u
Xr1a_18 nmac1_18 nmac1_18 0 0 sky130_fd_pr__nfet_01v8 W=4.0u L=0.5u
Xr1b_18 nrelu1_18 nmac1_18 0 0 sky130_fd_pr__nfet_01v8 W=4.0u L=0.5u
Xopr_18 nrelu1_18 nrelu1_18 vdd vdd sky130_fd_pr__pfet_01v8 W=2.0u L=0.5u
Xopm_18 vout1_18 nrelu1_18 vdd vdd sky130_fd_pr__pfet_01v8 W=2.0u L=0.5u

* --- Ch 19: b1=+0.5812, I_bias=+85471363622.795uA ---
Ibr1_19 pbr1_19 0 8.547136e+04
Xbr1_19 pbr1_19 pbr1_19 vdd vdd sky130_fd_pr__pfet_01v8 W=2.0u L=0.5u
Xbm1_19 nmac1_19 pbr1_19 vdd vdd sky130_fd_pr__pfet_01v8 W=2.0u L=0.5u
Xr1a_19 nmac1_19 nmac1_19 0 0 sky130_fd_pr__nfet_01v8 W=4.0u L=0.5u
Xr1b_19 nrelu1_19 nmac1_19 0 0 sky130_fd_pr__nfet_01v8 W=4.0u L=0.5u
Xopr_19 nrelu1_19 nrelu1_19 vdd vdd sky130_fd_pr__pfet_01v8 W=2.0u L=0.5u
Xopm_19 vout1_19 nrelu1_19 vdd vdd sky130_fd_pr__pfet_01v8 W=2.0u L=0.5u

* --- Ch 20: b1=+0.4234, I_bias=+62264401583.361uA ---
Ibr1_20 pbr1_20 0 6.226440e+04
Xbr1_20 pbr1_20 pbr1_20 vdd vdd sky130_fd_pr__pfet_01v8 W=2.0u L=0.5u
Xbm1_20 nmac1_20 pbr1_20 vdd vdd sky130_fd_pr__pfet_01v8 W=2.0u L=0.5u
Xr1a_20 nmac1_20 nmac1_20 0 0 sky130_fd_pr__nfet_01v8 W=4.0u L=0.5u
Xr1b_20 nrelu1_20 nmac1_20 0 0 sky130_fd_pr__nfet_01v8 W=4.0u L=0.5u
Xopr_20 nrelu1_20 nrelu1_20 vdd vdd sky130_fd_pr__pfet_01v8 W=2.0u L=0.5u
Xopm_20 vout1_20 nrelu1_20 vdd vdd sky130_fd_pr__pfet_01v8 W=2.0u L=0.5u

* --- Ch 21: b1=+0.2189, I_bias=+32191962392.127uA ---
Ibr1_21 pbr1_21 0 3.219196e+04
Xbr1_21 pbr1_21 pbr1_21 vdd vdd sky130_fd_pr__pfet_01v8 W=2.0u L=0.5u
Xbm1_21 nmac1_21 pbr1_21 vdd vdd sky130_fd_pr__pfet_01v8 W=2.0u L=0.5u
Xr1a_21 nmac1_21 nmac1_21 0 0 sky130_fd_pr__nfet_01v8 W=4.0u L=0.5u
Xr1b_21 nrelu1_21 nmac1_21 0 0 sky130_fd_pr__nfet_01v8 W=4.0u L=0.5u
Xopr_21 nrelu1_21 nrelu1_21 vdd vdd sky130_fd_pr__pfet_01v8 W=2.0u L=0.5u
Xopm_21 vout1_21 nrelu1_21 vdd vdd sky130_fd_pr__pfet_01v8 W=2.0u L=0.5u

* --- Ch 22: b1=+0.6190, I_bias=+91031128593.353uA ---
Ibr1_22 pbr1_22 0 9.103113e+04
Xbr1_22 pbr1_22 pbr1_22 vdd vdd sky130_fd_pr__pfet_01v8 W=2.0u L=0.5u
Xbm1_22 nmac1_22 pbr1_22 vdd vdd sky130_fd_pr__pfet_01v8 W=2.0u L=0.5u
Xr1a_22 nmac1_22 nmac1_22 0 0 sky130_fd_pr__nfet_01v8 W=4.0u L=0.5u
Xr1b_22 nrelu1_22 nmac1_22 0 0 sky130_fd_pr__nfet_01v8 W=4.0u L=0.5u
Xopr_22 nrelu1_22 nrelu1_22 vdd vdd sky130_fd_pr__pfet_01v8 W=2.0u L=0.5u
Xopm_22 vout1_22 nrelu1_22 vdd vdd sky130_fd_pr__pfet_01v8 W=2.0u L=0.5u

* --- Ch 23: b1=+0.0204, I_bias=+3005199795.467uA ---
Ibr1_23 pbr1_23 0 3.005200e+03
Xbr1_23 pbr1_23 pbr1_23 vdd vdd sky130_fd_pr__pfet_01v8 W=2.0u L=0.5u
Xbm1_23 nmac1_23 pbr1_23 vdd vdd sky130_fd_pr__pfet_01v8 W=2.0u L=0.5u
Xr1a_23 nmac1_23 nmac1_23 0 0 sky130_fd_pr__nfet_01v8 W=4.0u L=0.5u
Xr1b_23 nrelu1_23 nmac1_23 0 0 sky130_fd_pr__nfet_01v8 W=4.0u L=0.5u
Xopr_23 nrelu1_23 nrelu1_23 vdd vdd sky130_fd_pr__pfet_01v8 W=2.0u L=0.5u
Xopm_23 vout1_23 nrelu1_23 vdd vdd sky130_fd_pr__pfet_01v8 W=2.0u L=0.5u

* --- Ch 24: b1=-0.1552, I_bias=-22817976335.725uA ---
Ibr1_24 vdd nbr1_24 2.281798e+04
Xbr1_24 nbr1_24 nbr1_24 0 0 sky130_fd_pr__nfet_01v8 W=2.0u L=0.5u
Xbm1_24 nmac1_24 nbr1_24 0 0 sky130_fd_pr__nfet_01v8 W=2.0u L=0.5u
Xr1a_24 nmac1_24 nmac1_24 0 0 sky130_fd_pr__nfet_01v8 W=4.0u L=0.5u
Xr1b_24 nrelu1_24 nmac1_24 0 0 sky130_fd_pr__nfet_01v8 W=4.0u L=0.5u
Xopr_24 nrelu1_24 nrelu1_24 vdd vdd sky130_fd_pr__pfet_01v8 W=2.0u L=0.5u
Xopm_24 vout1_24 nrelu1_24 vdd vdd sky130_fd_pr__pfet_01v8 W=2.0u L=0.5u

* --- Ch 25: b1=-0.5765, I_bias=-84781816738.255uA ---
Ibr1_25 vdd nbr1_25 8.478182e+04
Xbr1_25 nbr1_25 nbr1_25 0 0 sky130_fd_pr__nfet_01v8 W=2.0u L=0.5u
Xbm1_25 nmac1_25 nbr1_25 0 0 sky130_fd_pr__nfet_01v8 W=2.0u L=0.5u
Xr1a_25 nmac1_25 nmac1_25 0 0 sky130_fd_pr__nfet_01v8 W=4.0u L=0.5u
Xr1b_25 nrelu1_25 nmac1_25 0 0 sky130_fd_pr__nfet_01v8 W=4.0u L=0.5u
Xopr_25 nrelu1_25 nrelu1_25 vdd vdd sky130_fd_pr__pfet_01v8 W=2.0u L=0.5u
Xopm_25 vout1_25 nrelu1_25 vdd vdd sky130_fd_pr__pfet_01v8 W=2.0u L=0.5u

* --- Ch 26: b1=-0.1567, I_bias=-23046472854.222uA ---
Ibr1_26 vdd nbr1_26 2.304647e+04
Xbr1_26 nbr1_26 nbr1_26 0 0 sky130_fd_pr__nfet_01v8 W=2.0u L=0.5u
Xbm1_26 nmac1_26 nbr1_26 0 0 sky130_fd_pr__nfet_01v8 W=2.0u L=0.5u
Xr1a_26 nmac1_26 nmac1_26 0 0 sky130_fd_pr__nfet_01v8 W=4.0u L=0.5u
Xr1b_26 nrelu1_26 nmac1_26 0 0 sky130_fd_pr__nfet_01v8 W=4.0u L=0.5u
Xopr_26 nrelu1_26 nrelu1_26 vdd vdd sky130_fd_pr__pfet_01v8 W=2.0u L=0.5u
Xopm_26 vout1_26 nrelu1_26 vdd vdd sky130_fd_pr__pfet_01v8 W=2.0u L=0.5u

* --- Ch 27: b1=-0.2202, I_bias=-32386752842.043uA ---
Ibr1_27 vdd nbr1_27 3.238675e+04
Xbr1_27 nbr1_27 nbr1_27 0 0 sky130_fd_pr__nfet_01v8 W=2.0u L=0.5u
Xbm1_27 nmac1_27 nbr1_27 0 0 sky130_fd_pr__nfet_01v8 W=2.0u L=0.5u
Xr1a_27 nmac1_27 nmac1_27 0 0 sky130_fd_pr__nfet_01v8 W=4.0u L=0.5u
Xr1b_27 nrelu1_27 nmac1_27 0 0 sky130_fd_pr__nfet_01v8 W=4.0u L=0.5u
Xopr_27 nrelu1_27 nrelu1_27 vdd vdd sky130_fd_pr__pfet_01v8 W=2.0u L=0.5u
Xopm_27 vout1_27 nrelu1_27 vdd vdd sky130_fd_pr__pfet_01v8 W=2.0u L=0.5u

* --- Ch 28: b1=+0.6382, I_bias=+93850136197.447uA ---
Ibr1_28 pbr1_28 0 9.385014e+04
Xbr1_28 pbr1_28 pbr1_28 vdd vdd sky130_fd_pr__pfet_01v8 W=2.0u L=0.5u
Xbm1_28 nmac1_28 pbr1_28 vdd vdd sky130_fd_pr__pfet_01v8 W=2.0u L=0.5u
Xr1a_28 nmac1_28 nmac1_28 0 0 sky130_fd_pr__nfet_01v8 W=4.0u L=0.5u
Xr1b_28 nrelu1_28 nmac1_28 0 0 sky130_fd_pr__nfet_01v8 W=4.0u L=0.5u
Xopr_28 nrelu1_28 nrelu1_28 vdd vdd sky130_fd_pr__pfet_01v8 W=2.0u L=0.5u
Xopm_28 vout1_28 nrelu1_28 vdd vdd sky130_fd_pr__pfet_01v8 W=2.0u L=0.5u

* --- Ch 29: b1=-0.2248, I_bias=-33062297180.624uA ---
Ibr1_29 vdd nbr1_29 3.306230e+04
Xbr1_29 nbr1_29 nbr1_29 0 0 sky130_fd_pr__nfet_01v8 W=2.0u L=0.5u
Xbm1_29 nmac1_29 nbr1_29 0 0 sky130_fd_pr__nfet_01v8 W=2.0u L=0.5u
Xr1a_29 nmac1_29 nmac1_29 0 0 sky130_fd_pr__nfet_01v8 W=4.0u L=0.5u
Xr1b_29 nrelu1_29 nmac1_29 0 0 sky130_fd_pr__nfet_01v8 W=4.0u L=0.5u
Xopr_29 nrelu1_29 nrelu1_29 vdd vdd sky130_fd_pr__pfet_01v8 W=2.0u L=0.5u
Xopm_29 vout1_29 nrelu1_29 vdd vdd sky130_fd_pr__pfet_01v8 W=2.0u L=0.5u

* --- Ch 30: b1=+0.1317, I_bias=+19369089635.433uA ---
Ibr1_30 pbr1_30 0 1.936909e+04
Xbr1_30 pbr1_30 pbr1_30 vdd vdd sky130_fd_pr__pfet_01v8 W=2.0u L=0.5u
Xbm1_30 nmac1_30 pbr1_30 vdd vdd sky130_fd_pr__pfet_01v8 W=2.0u L=0.5u
Xr1a_30 nmac1_30 nmac1_30 0 0 sky130_fd_pr__nfet_01v8 W=4.0u L=0.5u
Xr1b_30 nrelu1_30 nmac1_30 0 0 sky130_fd_pr__nfet_01v8 W=4.0u L=0.5u
Xopr_30 nrelu1_30 nrelu1_30 vdd vdd sky130_fd_pr__pfet_01v8 W=2.0u L=0.5u
Xopm_30 vout1_30 nrelu1_30 vdd vdd sky130_fd_pr__pfet_01v8 W=2.0u L=0.5u

* --- Ch 31: b1=+0.3776, I_bias=+55535785271.243uA ---
Ibr1_31 pbr1_31 0 5.553579e+04
Xbr1_31 pbr1_31 pbr1_31 vdd vdd sky130_fd_pr__pfet_01v8 W=2.0u L=0.5u
Xbm1_31 nmac1_31 pbr1_31 vdd vdd sky130_fd_pr__pfet_01v8 W=2.0u L=0.5u
Xr1a_31 nmac1_31 nmac1_31 0 0 sky130_fd_pr__nfet_01v8 W=4.0u L=0.5u
Xr1b_31 nrelu1_31 nmac1_31 0 0 sky130_fd_pr__nfet_01v8 W=4.0u L=0.5u
Xopr_31 nrelu1_31 nrelu1_31 vdd vdd sky130_fd_pr__pfet_01v8 W=2.0u L=0.5u
Xopm_31 vout1_31 nrelu1_31 vdd vdd sky130_fd_pr__pfet_01v8 W=2.0u L=0.5u

* --- Ch 32: b1=+0.4588, I_bias=+67469236334.103uA ---
Ibr1_32 pbr1_32 0 6.746924e+04
Xbr1_32 pbr1_32 pbr1_32 vdd vdd sky130_fd_pr__pfet_01v8 W=2.0u L=0.5u
Xbm1_32 nmac1_32 pbr1_32 vdd vdd sky130_fd_pr__pfet_01v8 W=2.0u L=0.5u
Xr1a_32 nmac1_32 nmac1_32 0 0 sky130_fd_pr__nfet_01v8 W=4.0u L=0.5u
Xr1b_32 nrelu1_32 nmac1_32 0 0 sky130_fd_pr__nfet_01v8 W=4.0u L=0.5u
Xopr_32 nrelu1_32 nrelu1_32 vdd vdd sky130_fd_pr__pfet_01v8 W=2.0u L=0.5u
Xopm_32 vout1_32 nrelu1_32 vdd vdd sky130_fd_pr__pfet_01v8 W=2.0u L=0.5u

* --- Ch 33: b1=+0.3676, I_bias=+54061205554.666uA ---
Ibr1_33 pbr1_33 0 5.406121e+04
Xbr1_33 pbr1_33 pbr1_33 vdd vdd sky130_fd_pr__pfet_01v8 W=2.0u L=0.5u
Xbm1_33 nmac1_33 pbr1_33 vdd vdd sky130_fd_pr__pfet_01v8 W=2.0u L=0.5u
Xr1a_33 nmac1_33 nmac1_33 0 0 sky130_fd_pr__nfet_01v8 W=4.0u L=0.5u
Xr1b_33 nrelu1_33 nmac1_33 0 0 sky130_fd_pr__nfet_01v8 W=4.0u L=0.5u
Xopr_33 nrelu1_33 nrelu1_33 vdd vdd sky130_fd_pr__pfet_01v8 W=2.0u L=0.5u
Xopm_33 vout1_33 nrelu1_33 vdd vdd sky130_fd_pr__pfet_01v8 W=2.0u L=0.5u

* --- Ch 34: b1=-0.0481, I_bias=-7072867649.361uA ---
Ibr1_34 vdd nbr1_34 7.072868e+03
Xbr1_34 nbr1_34 nbr1_34 0 0 sky130_fd_pr__nfet_01v8 W=2.0u L=0.5u
Xbm1_34 nmac1_34 nbr1_34 0 0 sky130_fd_pr__nfet_01v8 W=2.0u L=0.5u
Xr1a_34 nmac1_34 nmac1_34 0 0 sky130_fd_pr__nfet_01v8 W=4.0u L=0.5u
Xr1b_34 nrelu1_34 nmac1_34 0 0 sky130_fd_pr__nfet_01v8 W=4.0u L=0.5u
Xopr_34 nrelu1_34 nrelu1_34 vdd vdd sky130_fd_pr__pfet_01v8 W=2.0u L=0.5u
Xopm_34 vout1_34 nrelu1_34 vdd vdd sky130_fd_pr__pfet_01v8 W=2.0u L=0.5u

* --- Ch 35: b1=+0.0270, I_bias=+3975841381.188uA ---
Ibr1_35 pbr1_35 0 3.975841e+03
Xbr1_35 pbr1_35 pbr1_35 vdd vdd sky130_fd_pr__pfet_01v8 W=2.0u L=0.5u
Xbm1_35 nmac1_35 pbr1_35 vdd vdd sky130_fd_pr__pfet_01v8 W=2.0u L=0.5u
Xr1a_35 nmac1_35 nmac1_35 0 0 sky130_fd_pr__nfet_01v8 W=4.0u L=0.5u
Xr1b_35 nrelu1_35 nmac1_35 0 0 sky130_fd_pr__nfet_01v8 W=4.0u L=0.5u
Xopr_35 nrelu1_35 nrelu1_35 vdd vdd sky130_fd_pr__pfet_01v8 W=2.0u L=0.5u
Xopm_35 vout1_35 nrelu1_35 vdd vdd sky130_fd_pr__pfet_01v8 W=2.0u L=0.5u

* --- Ch 36: b1=+0.0576, I_bias=+8465863379.332uA ---
Ibr1_36 pbr1_36 0 8.465863e+03
Xbr1_36 pbr1_36 pbr1_36 vdd vdd sky130_fd_pr__pfet_01v8 W=2.0u L=0.5u
Xbm1_36 nmac1_36 pbr1_36 vdd vdd sky130_fd_pr__pfet_01v8 W=2.0u L=0.5u
Xr1a_36 nmac1_36 nmac1_36 0 0 sky130_fd_pr__nfet_01v8 W=4.0u L=0.5u
Xr1b_36 nrelu1_36 nmac1_36 0 0 sky130_fd_pr__nfet_01v8 W=4.0u L=0.5u
Xopr_36 nrelu1_36 nrelu1_36 vdd vdd sky130_fd_pr__pfet_01v8 W=2.0u L=0.5u
Xopm_36 vout1_36 nrelu1_36 vdd vdd sky130_fd_pr__pfet_01v8 W=2.0u L=0.5u

* --- Ch 37: b1=+0.1223, I_bias=+17992807927.803uA ---
Ibr1_37 pbr1_37 0 1.799281e+04
Xbr1_37 pbr1_37 pbr1_37 vdd vdd sky130_fd_pr__pfet_01v8 W=2.0u L=0.5u
Xbm1_37 nmac1_37 pbr1_37 vdd vdd sky130_fd_pr__pfet_01v8 W=2.0u L=0.5u
Xr1a_37 nmac1_37 nmac1_37 0 0 sky130_fd_pr__nfet_01v8 W=4.0u L=0.5u
Xr1b_37 nrelu1_37 nmac1_37 0 0 sky130_fd_pr__nfet_01v8 W=4.0u L=0.5u
Xopr_37 nrelu1_37 nrelu1_37 vdd vdd sky130_fd_pr__pfet_01v8 W=2.0u L=0.5u
Xopm_37 vout1_37 nrelu1_37 vdd vdd sky130_fd_pr__pfet_01v8 W=2.0u L=0.5u

* --- Ch 38: b1=+0.5294, I_bias=+77856243625.629uA ---
Ibr1_38 pbr1_38 0 7.785624e+04
Xbr1_38 pbr1_38 pbr1_38 vdd vdd sky130_fd_pr__pfet_01v8 W=2.0u L=0.5u
Xbm1_38 nmac1_38 pbr1_38 vdd vdd sky130_fd_pr__pfet_01v8 W=2.0u L=0.5u
Xr1a_38 nmac1_38 nmac1_38 0 0 sky130_fd_pr__nfet_01v8 W=4.0u L=0.5u
Xr1b_38 nrelu1_38 nmac1_38 0 0 sky130_fd_pr__nfet_01v8 W=4.0u L=0.5u
Xopr_38 nrelu1_38 nrelu1_38 vdd vdd sky130_fd_pr__pfet_01v8 W=2.0u L=0.5u
Xopm_38 vout1_38 nrelu1_38 vdd vdd sky130_fd_pr__pfet_01v8 W=2.0u L=0.5u

* --- Ch 39: b1=+0.2765, I_bias=+40658414478.169uA ---
Ibr1_39 pbr1_39 0 4.065841e+04
Xbr1_39 pbr1_39 pbr1_39 vdd vdd sky130_fd_pr__pfet_01v8 W=2.0u L=0.5u
Xbm1_39 nmac1_39 pbr1_39 vdd vdd sky130_fd_pr__pfet_01v8 W=2.0u L=0.5u
Xr1a_39 nmac1_39 nmac1_39 0 0 sky130_fd_pr__nfet_01v8 W=4.0u L=0.5u
Xr1b_39 nrelu1_39 nmac1_39 0 0 sky130_fd_pr__nfet_01v8 W=4.0u L=0.5u
Xopr_39 nrelu1_39 nrelu1_39 vdd vdd sky130_fd_pr__pfet_01v8 W=2.0u L=0.5u
Xopm_39 vout1_39 nrelu1_39 vdd vdd sky130_fd_pr__pfet_01v8 W=2.0u L=0.5u

* --- Ch 40: b1=+0.1136, I_bias=+16710843850.744uA ---
Ibr1_40 pbr1_40 0 1.671084e+04
Xbr1_40 pbr1_40 pbr1_40 vdd vdd sky130_fd_pr__pfet_01v8 W=2.0u L=0.5u
Xbm1_40 nmac1_40 pbr1_40 vdd vdd sky130_fd_pr__pfet_01v8 W=2.0u L=0.5u
Xr1a_40 nmac1_40 nmac1_40 0 0 sky130_fd_pr__nfet_01v8 W=4.0u L=0.5u
Xr1b_40 nrelu1_40 nmac1_40 0 0 sky130_fd_pr__nfet_01v8 W=4.0u L=0.5u
Xopr_40 nrelu1_40 nrelu1_40 vdd vdd sky130_fd_pr__pfet_01v8 W=2.0u L=0.5u
Xopm_40 vout1_40 nrelu1_40 vdd vdd sky130_fd_pr__pfet_01v8 W=2.0u L=0.5u

* --- Ch 41: b1=+0.5225, I_bias=+76841681206.487uA ---
Ibr1_41 pbr1_41 0 7.684168e+04
Xbr1_41 pbr1_41 pbr1_41 vdd vdd sky130_fd_pr__pfet_01v8 W=2.0u L=0.5u
Xbm1_41 nmac1_41 pbr1_41 vdd vdd sky130_fd_pr__pfet_01v8 W=2.0u L=0.5u
Xr1a_41 nmac1_41 nmac1_41 0 0 sky130_fd_pr__nfet_01v8 W=4.0u L=0.5u
Xr1b_41 nrelu1_41 nmac1_41 0 0 sky130_fd_pr__nfet_01v8 W=4.0u L=0.5u
Xopr_41 nrelu1_41 nrelu1_41 vdd vdd sky130_fd_pr__pfet_01v8 W=2.0u L=0.5u
Xopm_41 vout1_41 nrelu1_41 vdd vdd sky130_fd_pr__pfet_01v8 W=2.0u L=0.5u

* --- Ch 42: b1=+0.8267, I_bias=+121579562818.218uA ---
Ibr1_42 pbr1_42 0 1.215796e+05
Xbr1_42 pbr1_42 pbr1_42 vdd vdd sky130_fd_pr__pfet_01v8 W=2.0u L=0.5u
Xbm1_42 nmac1_42 pbr1_42 vdd vdd sky130_fd_pr__pfet_01v8 W=2.0u L=0.5u
Xr1a_42 nmac1_42 nmac1_42 0 0 sky130_fd_pr__nfet_01v8 W=4.0u L=0.5u
Xr1b_42 nrelu1_42 nmac1_42 0 0 sky130_fd_pr__nfet_01v8 W=4.0u L=0.5u
Xopr_42 nrelu1_42 nrelu1_42 vdd vdd sky130_fd_pr__pfet_01v8 W=2.0u L=0.5u
Xopm_42 vout1_42 nrelu1_42 vdd vdd sky130_fd_pr__pfet_01v8 W=2.0u L=0.5u

* --- Ch 43: b1=+0.3599, I_bias=+52924241410.987uA ---
Ibr1_43 pbr1_43 0 5.292424e+04
Xbr1_43 pbr1_43 pbr1_43 vdd vdd sky130_fd_pr__pfet_01v8 W=2.0u L=0.5u
Xbm1_43 nmac1_43 pbr1_43 vdd vdd sky130_fd_pr__pfet_01v8 W=2.0u L=0.5u
Xr1a_43 nmac1_43 nmac1_43 0 0 sky130_fd_pr__nfet_01v8 W=4.0u L=0.5u
Xr1b_43 nrelu1_43 nmac1_43 0 0 sky130_fd_pr__nfet_01v8 W=4.0u L=0.5u
Xopr_43 nrelu1_43 nrelu1_43 vdd vdd sky130_fd_pr__pfet_01v8 W=2.0u L=0.5u
Xopm_43 vout1_43 nrelu1_43 vdd vdd sky130_fd_pr__pfet_01v8 W=2.0u L=0.5u

* --- Ch 44: b1=+0.0323, I_bias=+4743049049.904uA ---
Ibr1_44 pbr1_44 0 4.743049e+03
Xbr1_44 pbr1_44 pbr1_44 vdd vdd sky130_fd_pr__pfet_01v8 W=2.0u L=0.5u
Xbm1_44 nmac1_44 pbr1_44 vdd vdd sky130_fd_pr__pfet_01v8 W=2.0u L=0.5u
Xr1a_44 nmac1_44 nmac1_44 0 0 sky130_fd_pr__nfet_01v8 W=4.0u L=0.5u
Xr1b_44 nrelu1_44 nmac1_44 0 0 sky130_fd_pr__nfet_01v8 W=4.0u L=0.5u
Xopr_44 nrelu1_44 nrelu1_44 vdd vdd sky130_fd_pr__pfet_01v8 W=2.0u L=0.5u
Xopm_44 vout1_44 nrelu1_44 vdd vdd sky130_fd_pr__pfet_01v8 W=2.0u L=0.5u

* --- Ch 45: b1=-0.0618, I_bias=-9088989959.184uA ---
Ibr1_45 vdd nbr1_45 9.088990e+03
Xbr1_45 nbr1_45 nbr1_45 0 0 sky130_fd_pr__nfet_01v8 W=2.0u L=0.5u
Xbm1_45 nmac1_45 nbr1_45 0 0 sky130_fd_pr__nfet_01v8 W=2.0u L=0.5u
Xr1a_45 nmac1_45 nmac1_45 0 0 sky130_fd_pr__nfet_01v8 W=4.0u L=0.5u
Xr1b_45 nrelu1_45 nmac1_45 0 0 sky130_fd_pr__nfet_01v8 W=4.0u L=0.5u
Xopr_45 nrelu1_45 nrelu1_45 vdd vdd sky130_fd_pr__pfet_01v8 W=2.0u L=0.5u
Xopm_45 vout1_45 nrelu1_45 vdd vdd sky130_fd_pr__pfet_01v8 W=2.0u L=0.5u

* --- Ch 46: b1=-0.0053, I_bias=-783417644.840uA ---
Ibr1_46 vdd nbr1_46 7.834176e+02
Xbr1_46 nbr1_46 nbr1_46 0 0 sky130_fd_pr__nfet_01v8 W=2.0u L=0.5u
Xbm1_46 nmac1_46 nbr1_46 0 0 sky130_fd_pr__nfet_01v8 W=2.0u L=0.5u
Xr1a_46 nmac1_46 nmac1_46 0 0 sky130_fd_pr__nfet_01v8 W=4.0u L=0.5u
Xr1b_46 nrelu1_46 nmac1_46 0 0 sky130_fd_pr__nfet_01v8 W=4.0u L=0.5u
Xopr_46 nrelu1_46 nrelu1_46 vdd vdd sky130_fd_pr__pfet_01v8 W=2.0u L=0.5u
Xopm_46 vout1_46 nrelu1_46 vdd vdd sky130_fd_pr__pfet_01v8 W=2.0u L=0.5u

* --- Ch 47: b1=-0.0320, I_bias=-4706691382.702uA ---
Ibr1_47 vdd nbr1_47 4.706691e+03
Xbr1_47 nbr1_47 nbr1_47 0 0 sky130_fd_pr__nfet_01v8 W=2.0u L=0.5u
Xbm1_47 nmac1_47 nbr1_47 0 0 sky130_fd_pr__nfet_01v8 W=2.0u L=0.5u
Xr1a_47 nmac1_47 nmac1_47 0 0 sky130_fd_pr__nfet_01v8 W=4.0u L=0.5u
Xr1b_47 nrelu1_47 nmac1_47 0 0 sky130_fd_pr__nfet_01v8 W=4.0u L=0.5u
Xopr_47 nrelu1_47 nrelu1_47 vdd vdd sky130_fd_pr__pfet_01v8 W=2.0u L=0.5u
Xopm_47 vout1_47 nrelu1_47 vdd vdd sky130_fd_pr__pfet_01v8 W=2.0u L=0.5u

* --- Ch 48: b1=+0.4393, I_bias=+64607320249.601uA ---
Ibr1_48 pbr1_48 0 6.460732e+04
Xbr1_48 pbr1_48 pbr1_48 vdd vdd sky130_fd_pr__pfet_01v8 W=2.0u L=0.5u
Xbm1_48 nmac1_48 pbr1_48 vdd vdd sky130_fd_pr__pfet_01v8 W=2.0u L=0.5u
Xr1a_48 nmac1_48 nmac1_48 0 0 sky130_fd_pr__nfet_01v8 W=4.0u L=0.5u
Xr1b_48 nrelu1_48 nmac1_48 0 0 sky130_fd_pr__nfet_01v8 W=4.0u L=0.5u
Xopr_48 nrelu1_48 nrelu1_48 vdd vdd sky130_fd_pr__pfet_01v8 W=2.0u L=0.5u
Xopm_48 vout1_48 nrelu1_48 vdd vdd sky130_fd_pr__pfet_01v8 W=2.0u L=0.5u

* --- Ch 49: b1=-0.3513, I_bias=-51660862015.615uA ---
Ibr1_49 vdd nbr1_49 5.166086e+04
Xbr1_49 nbr1_49 nbr1_49 0 0 sky130_fd_pr__nfet_01v8 W=2.0u L=0.5u
Xbm1_49 nmac1_49 nbr1_49 0 0 sky130_fd_pr__nfet_01v8 W=2.0u L=0.5u
Xr1a_49 nmac1_49 nmac1_49 0 0 sky130_fd_pr__nfet_01v8 W=4.0u L=0.5u
Xr1b_49 nrelu1_49 nmac1_49 0 0 sky130_fd_pr__nfet_01v8 W=4.0u L=0.5u
Xopr_49 nrelu1_49 nrelu1_49 vdd vdd sky130_fd_pr__pfet_01v8 W=2.0u L=0.5u
Xopm_49 vout1_49 nrelu1_49 vdd vdd sky130_fd_pr__pfet_01v8 W=2.0u L=0.5u

* --- Ch 50: b1=+0.5185, I_bias=+76245404012.968uA ---
Ibr1_50 pbr1_50 0 7.624540e+04
Xbr1_50 pbr1_50 pbr1_50 vdd vdd sky130_fd_pr__pfet_01v8 W=2.0u L=0.5u
Xbm1_50 nmac1_50 pbr1_50 vdd vdd sky130_fd_pr__pfet_01v8 W=2.0u L=0.5u
Xr1a_50 nmac1_50 nmac1_50 0 0 sky130_fd_pr__nfet_01v8 W=4.0u L=0.5u
Xr1b_50 nrelu1_50 nmac1_50 0 0 sky130_fd_pr__nfet_01v8 W=4.0u L=0.5u
Xopr_50 nrelu1_50 nrelu1_50 vdd vdd sky130_fd_pr__pfet_01v8 W=2.0u L=0.5u
Xopm_50 vout1_50 nrelu1_50 vdd vdd sky130_fd_pr__pfet_01v8 W=2.0u L=0.5u

* --- Ch 51: b1=-0.2754, I_bias=-40494651652.486uA ---
Ibr1_51 vdd nbr1_51 4.049465e+04
Xbr1_51 nbr1_51 nbr1_51 0 0 sky130_fd_pr__nfet_01v8 W=2.0u L=0.5u
Xbm1_51 nmac1_51 nbr1_51 0 0 sky130_fd_pr__nfet_01v8 W=2.0u L=0.5u
Xr1a_51 nmac1_51 nmac1_51 0 0 sky130_fd_pr__nfet_01v8 W=4.0u L=0.5u
Xr1b_51 nrelu1_51 nmac1_51 0 0 sky130_fd_pr__nfet_01v8 W=4.0u L=0.5u
Xopr_51 nrelu1_51 nrelu1_51 vdd vdd sky130_fd_pr__pfet_01v8 W=2.0u L=0.5u
Xopm_51 vout1_51 nrelu1_51 vdd vdd sky130_fd_pr__pfet_01v8 W=2.0u L=0.5u

* --- Ch 52: b1=+0.0117, I_bias=+1720092520.726uA ---
Ibr1_52 pbr1_52 0 1.720093e+03
Xbr1_52 pbr1_52 pbr1_52 vdd vdd sky130_fd_pr__pfet_01v8 W=2.0u L=0.5u
Xbm1_52 nmac1_52 pbr1_52 vdd vdd sky130_fd_pr__pfet_01v8 W=2.0u L=0.5u
Xr1a_52 nmac1_52 nmac1_52 0 0 sky130_fd_pr__nfet_01v8 W=4.0u L=0.5u
Xr1b_52 nrelu1_52 nmac1_52 0 0 sky130_fd_pr__nfet_01v8 W=4.0u L=0.5u
Xopr_52 nrelu1_52 nrelu1_52 vdd vdd sky130_fd_pr__pfet_01v8 W=2.0u L=0.5u
Xopm_52 vout1_52 nrelu1_52 vdd vdd sky130_fd_pr__pfet_01v8 W=2.0u L=0.5u

* --- Ch 53: b1=+0.6000, I_bias=+88230712237.551uA ---
Ibr1_53 pbr1_53 0 8.823071e+04
Xbr1_53 pbr1_53 pbr1_53 vdd vdd sky130_fd_pr__pfet_01v8 W=2.0u L=0.5u
Xbm1_53 nmac1_53 pbr1_53 vdd vdd sky130_fd_pr__pfet_01v8 W=2.0u L=0.5u
Xr1a_53 nmac1_53 nmac1_53 0 0 sky130_fd_pr__nfet_01v8 W=4.0u L=0.5u
Xr1b_53 nrelu1_53 nmac1_53 0 0 sky130_fd_pr__nfet_01v8 W=4.0u L=0.5u
Xopr_53 nrelu1_53 nrelu1_53 vdd vdd sky130_fd_pr__pfet_01v8 W=2.0u L=0.5u
Xopm_53 vout1_53 nrelu1_53 vdd vdd sky130_fd_pr__pfet_01v8 W=2.0u L=0.5u

* --- Ch 54: b1=+0.0239, I_bias=+3512927466.857uA ---
Ibr1_54 pbr1_54 0 3.512927e+03
Xbr1_54 pbr1_54 pbr1_54 vdd vdd sky130_fd_pr__pfet_01v8 W=2.0u L=0.5u
Xbm1_54 nmac1_54 pbr1_54 vdd vdd sky130_fd_pr__pfet_01v8 W=2.0u L=0.5u
Xr1a_54 nmac1_54 nmac1_54 0 0 sky130_fd_pr__nfet_01v8 W=4.0u L=0.5u
Xr1b_54 nrelu1_54 nmac1_54 0 0 sky130_fd_pr__nfet_01v8 W=4.0u L=0.5u
Xopr_54 nrelu1_54 nrelu1_54 vdd vdd sky130_fd_pr__pfet_01v8 W=2.0u L=0.5u
Xopm_54 vout1_54 nrelu1_54 vdd vdd sky130_fd_pr__pfet_01v8 W=2.0u L=0.5u

* --- Ch 55: b1=-0.0028, I_bias=-416302006.941uA ---
Ibr1_55 vdd nbr1_55 4.163020e+02
Xbr1_55 nbr1_55 nbr1_55 0 0 sky130_fd_pr__nfet_01v8 W=2.0u L=0.5u
Xbm1_55 nmac1_55 nbr1_55 0 0 sky130_fd_pr__nfet_01v8 W=2.0u L=0.5u
Xr1a_55 nmac1_55 nmac1_55 0 0 sky130_fd_pr__nfet_01v8 W=4.0u L=0.5u
Xr1b_55 nrelu1_55 nmac1_55 0 0 sky130_fd_pr__nfet_01v8 W=4.0u L=0.5u
Xopr_55 nrelu1_55 nrelu1_55 vdd vdd sky130_fd_pr__pfet_01v8 W=2.0u L=0.5u
Xopm_55 vout1_55 nrelu1_55 vdd vdd sky130_fd_pr__pfet_01v8 W=2.0u L=0.5u

* --- Ch 56: b1=-0.0003, I_bias=-45656419.231uA ---
Ibr1_56 vdd nbr1_56 4.565642e+01
Xbr1_56 nbr1_56 nbr1_56 0 0 sky130_fd_pr__nfet_01v8 W=2.0u L=0.5u
Xbm1_56 nmac1_56 nbr1_56 0 0 sky130_fd_pr__nfet_01v8 W=2.0u L=0.5u
Xr1a_56 nmac1_56 nmac1_56 0 0 sky130_fd_pr__nfet_01v8 W=4.0u L=0.5u
Xr1b_56 nrelu1_56 nmac1_56 0 0 sky130_fd_pr__nfet_01v8 W=4.0u L=0.5u
Xopr_56 nrelu1_56 nrelu1_56 vdd vdd sky130_fd_pr__pfet_01v8 W=2.0u L=0.5u
Xopm_56 vout1_56 nrelu1_56 vdd vdd sky130_fd_pr__pfet_01v8 W=2.0u L=0.5u

* --- Ch 57: b1=+0.1561, I_bias=+22954171170.798uA ---
Ibr1_57 pbr1_57 0 2.295417e+04
Xbr1_57 pbr1_57 pbr1_57 vdd vdd sky130_fd_pr__pfet_01v8 W=2.0u L=0.5u
Xbm1_57 nmac1_57 pbr1_57 vdd vdd sky130_fd_pr__pfet_01v8 W=2.0u L=0.5u
Xr1a_57 nmac1_57 nmac1_57 0 0 sky130_fd_pr__nfet_01v8 W=4.0u L=0.5u
Xr1b_57 nrelu1_57 nmac1_57 0 0 sky130_fd_pr__nfet_01v8 W=4.0u L=0.5u
Xopr_57 nrelu1_57 nrelu1_57 vdd vdd sky130_fd_pr__pfet_01v8 W=2.0u L=0.5u
Xopm_57 vout1_57 nrelu1_57 vdd vdd sky130_fd_pr__pfet_01v8 W=2.0u L=0.5u

* --- Ch 58: b1=-0.0822, I_bias=-12084984587.455uA ---
Ibr1_58 vdd nbr1_58 1.208498e+04
Xbr1_58 nbr1_58 nbr1_58 0 0 sky130_fd_pr__nfet_01v8 W=2.0u L=0.5u
Xbm1_58 nmac1_58 nbr1_58 0 0 sky130_fd_pr__nfet_01v8 W=2.0u L=0.5u
Xr1a_58 nmac1_58 nmac1_58 0 0 sky130_fd_pr__nfet_01v8 W=4.0u L=0.5u
Xr1b_58 nrelu1_58 nmac1_58 0 0 sky130_fd_pr__nfet_01v8 W=4.0u L=0.5u
Xopr_58 nrelu1_58 nrelu1_58 vdd vdd sky130_fd_pr__pfet_01v8 W=2.0u L=0.5u
Xopm_58 vout1_58 nrelu1_58 vdd vdd sky130_fd_pr__pfet_01v8 W=2.0u L=0.5u

* --- Ch 59: b1=+0.9709, I_bias=+142774136136.501uA ---
Ibr1_59 pbr1_59 0 1.427741e+05
Xbr1_59 pbr1_59 pbr1_59 vdd vdd sky130_fd_pr__pfet_01v8 W=2.0u L=0.5u
Xbm1_59 nmac1_59 pbr1_59 vdd vdd sky130_fd_pr__pfet_01v8 W=2.0u L=0.5u
Xr1a_59 nmac1_59 nmac1_59 0 0 sky130_fd_pr__nfet_01v8 W=4.0u L=0.5u
Xr1b_59 nrelu1_59 nmac1_59 0 0 sky130_fd_pr__nfet_01v8 W=4.0u L=0.5u
Xopr_59 nrelu1_59 nrelu1_59 vdd vdd sky130_fd_pr__pfet_01v8 W=2.0u L=0.5u
Xopm_59 vout1_59 nrelu1_59 vdd vdd sky130_fd_pr__pfet_01v8 W=2.0u L=0.5u

* --- Ch 60: b1=-0.0117, I_bias=-1715080014.933uA ---
Ibr1_60 vdd nbr1_60 1.715080e+03
Xbr1_60 nbr1_60 nbr1_60 0 0 sky130_fd_pr__nfet_01v8 W=2.0u L=0.5u
Xbm1_60 nmac1_60 nbr1_60 0 0 sky130_fd_pr__nfet_01v8 W=2.0u L=0.5u
Xr1a_60 nmac1_60 nmac1_60 0 0 sky130_fd_pr__nfet_01v8 W=4.0u L=0.5u
Xr1b_60 nrelu1_60 nmac1_60 0 0 sky130_fd_pr__nfet_01v8 W=4.0u L=0.5u
Xopr_60 nrelu1_60 nrelu1_60 vdd vdd sky130_fd_pr__pfet_01v8 W=2.0u L=0.5u
Xopm_60 vout1_60 nrelu1_60 vdd vdd sky130_fd_pr__pfet_01v8 W=2.0u L=0.5u

* --- Ch 61: b1=+0.3147, I_bias=+46281212749.988uA ---
Ibr1_61 pbr1_61 0 4.628121e+04
Xbr1_61 pbr1_61 pbr1_61 vdd vdd sky130_fd_pr__pfet_01v8 W=2.0u L=0.5u
Xbm1_61 nmac1_61 pbr1_61 vdd vdd sky130_fd_pr__pfet_01v8 W=2.0u L=0.5u
Xr1a_61 nmac1_61 nmac1_61 0 0 sky130_fd_pr__nfet_01v8 W=4.0u L=0.5u
Xr1b_61 nrelu1_61 nmac1_61 0 0 sky130_fd_pr__nfet_01v8 W=4.0u L=0.5u
Xopr_61 nrelu1_61 nrelu1_61 vdd vdd sky130_fd_pr__pfet_01v8 W=2.0u L=0.5u
Xopm_61 vout1_61 nrelu1_61 vdd vdd sky130_fd_pr__pfet_01v8 W=2.0u L=0.5u

* --- Ch 62: b1=+0.4429, I_bias=+65134380167.260uA ---
Ibr1_62 pbr1_62 0 6.513438e+04
Xbr1_62 pbr1_62 pbr1_62 vdd vdd sky130_fd_pr__pfet_01v8 W=2.0u L=0.5u
Xbm1_62 nmac1_62 pbr1_62 vdd vdd sky130_fd_pr__pfet_01v8 W=2.0u L=0.5u
Xr1a_62 nmac1_62 nmac1_62 0 0 sky130_fd_pr__nfet_01v8 W=4.0u L=0.5u
Xr1b_62 nrelu1_62 nmac1_62 0 0 sky130_fd_pr__nfet_01v8 W=4.0u L=0.5u
Xopr_62 nrelu1_62 nrelu1_62 vdd vdd sky130_fd_pr__pfet_01v8 W=2.0u L=0.5u
Xopm_62 vout1_62 nrelu1_62 vdd vdd sky130_fd_pr__pfet_01v8 W=2.0u L=0.5u

* --- Ch 63: b1=+0.8163, I_bias=+120046346844.772uA ---
Ibr1_63 pbr1_63 0 1.200463e+05
Xbr1_63 pbr1_63 pbr1_63 vdd vdd sky130_fd_pr__pfet_01v8 W=2.0u L=0.5u
Xbm1_63 nmac1_63 pbr1_63 vdd vdd sky130_fd_pr__pfet_01v8 W=2.0u L=0.5u
Xr1a_63 nmac1_63 nmac1_63 0 0 sky130_fd_pr__nfet_01v8 W=4.0u L=0.5u
Xr1b_63 nrelu1_63 nmac1_63 0 0 sky130_fd_pr__nfet_01v8 W=4.0u L=0.5u
Xopr_63 nrelu1_63 nrelu1_63 vdd vdd sky130_fd_pr__pfet_01v8 W=2.0u L=0.5u
Xopm_63 vout1_63 nrelu1_63 vdd vdd sky130_fd_pr__pfet_01v8 W=2.0u L=0.5u

* ===== LAYER 2: 64x5 DIFFERENTIAL 1T1R ReRAM CROSSBAR =====
Vgate_l2 gate_l2 0 1.8

* --- Positive conductance array ---
Xrpl2_0_0 vout1_0 gate_l2 cpl2_0 0 reram_1t1r Tf0=3.300000e-09  $ G+=0.296uS
Xrpl2_0_1 vout1_0 gate_l2 cpl2_1 0 reram_1t1r Tf0=4.314027e-09  $ G+=12.038uS
Xrpl2_0_2 vout1_0 gate_l2 cpl2_2 0 reram_1t1r Tf0=4.155991e-09  $ G+=6.777uS
Xrpl2_0_3 vout1_0 gate_l2 cpl2_3 0 reram_1t1r Tf0=3.300000e-09  $ G+=0.296uS
Xrpl2_0_4 vout1_0 gate_l2 cpl2_4 0 reram_1t1r Tf0=3.300000e-09  $ G+=0.296uS
Xrpl2_1_0 vout1_1 gate_l2 cpl2_0 0 reram_1t1r Tf0=4.485717e-09  $ G+=22.469uS
Xrpl2_1_1 vout1_1 gate_l2 cpl2_1 0 reram_1t1r Tf0=3.300000e-09  $ G+=0.296uS
Xrpl2_1_2 vout1_1 gate_l2 cpl2_2 0 reram_1t1r Tf0=3.300000e-09  $ G+=0.296uS
Xrpl2_1_3 vout1_1 gate_l2 cpl2_3 0 reram_1t1r Tf0=4.316569e-09  $ G+=12.149uS
Xrpl2_1_4 vout1_1 gate_l2 cpl2_4 0 reram_1t1r Tf0=3.300000e-09  $ G+=0.296uS
Xrpl2_2_0 vout1_2 gate_l2 cpl2_0 0 reram_1t1r Tf0=3.300000e-09  $ G+=0.296uS
Xrpl2_2_1 vout1_2 gate_l2 cpl2_1 0 reram_1t1r Tf0=3.300000e-09  $ G+=0.296uS
Xrpl2_2_2 vout1_2 gate_l2 cpl2_2 0 reram_1t1r Tf0=4.206825e-09  $ G+=8.153uS
Xrpl2_2_3 vout1_2 gate_l2 cpl2_3 0 reram_1t1r Tf0=4.124997e-09  $ G+=6.055uS
Xrpl2_2_4 vout1_2 gate_l2 cpl2_4 0 reram_1t1r Tf0=3.300000e-09  $ G+=0.296uS
Xrpl2_3_0 vout1_3 gate_l2 cpl2_0 0 reram_1t1r Tf0=4.077392e-09  $ G+=5.093uS
Xrpl2_3_1 vout1_3 gate_l2 cpl2_1 0 reram_1t1r Tf0=3.300000e-09  $ G+=0.296uS
Xrpl2_3_2 vout1_3 gate_l2 cpl2_2 0 reram_1t1r Tf0=4.172548e-09  $ G+=7.198uS
Xrpl2_3_3 vout1_3 gate_l2 cpl2_3 0 reram_1t1r Tf0=4.428510e-09  $ G+=18.250uS
Xrpl2_3_4 vout1_3 gate_l2 cpl2_4 0 reram_1t1r Tf0=3.638481e-09  $ G+=1.033uS
Xrpl2_4_0 vout1_4 gate_l2 cpl2_0 0 reram_1t1r Tf0=4.099321e-09  $ G+=5.516uS
Xrpl2_4_1 vout1_4 gate_l2 cpl2_1 0 reram_1t1r Tf0=3.300000e-09  $ G+=0.296uS
Xrpl2_4_2 vout1_4 gate_l2 cpl2_2 0 reram_1t1r Tf0=3.720731e-09  $ G+=1.393uS
Xrpl2_4_3 vout1_4 gate_l2 cpl2_3 0 reram_1t1r Tf0=3.300000e-09  $ G+=0.296uS
Xrpl2_4_4 vout1_4 gate_l2 cpl2_4 0 reram_1t1r Tf0=3.300000e-09  $ G+=0.296uS
Xrpl2_5_0 vout1_5 gate_l2 cpl2_0 0 reram_1t1r Tf0=4.212597e-09  $ G+=8.326uS
Xrpl2_5_1 vout1_5 gate_l2 cpl2_1 0 reram_1t1r Tf0=3.300000e-09  $ G+=0.296uS
Xrpl2_5_2 vout1_5 gate_l2 cpl2_2 0 reram_1t1r Tf0=3.300000e-09  $ G+=0.296uS
Xrpl2_5_3 vout1_5 gate_l2 cpl2_3 0 reram_1t1r Tf0=3.300000e-09  $ G+=0.296uS
Xrpl2_5_4 vout1_5 gate_l2 cpl2_4 0 reram_1t1r Tf0=3.300000e-09  $ G+=0.296uS
Xrpl2_6_0 vout1_6 gate_l2 cpl2_0 0 reram_1t1r Tf0=3.300000e-09  $ G+=0.296uS
Xrpl2_6_1 vout1_6 gate_l2 cpl2_1 0 reram_1t1r Tf0=3.300000e-09  $ G+=0.296uS
Xrpl2_6_2 vout1_6 gate_l2 cpl2_2 0 reram_1t1r Tf0=4.369677e-09  $ G+=14.737uS
Xrpl2_6_3 vout1_6 gate_l2 cpl2_3 0 reram_1t1r Tf0=4.039008e-09  $ G+=4.430uS
Xrpl2_6_4 vout1_6 gate_l2 cpl2_4 0 reram_1t1r Tf0=3.300000e-09  $ G+=0.296uS
Xrpl2_7_0 vout1_7 gate_l2 cpl2_0 0 reram_1t1r Tf0=4.293086e-09  $ G+=11.155uS
Xrpl2_7_1 vout1_7 gate_l2 cpl2_1 0 reram_1t1r Tf0=3.300000e-09  $ G+=0.296uS
Xrpl2_7_2 vout1_7 gate_l2 cpl2_2 0 reram_1t1r Tf0=3.300000e-09  $ G+=0.296uS
Xrpl2_7_3 vout1_7 gate_l2 cpl2_3 0 reram_1t1r Tf0=4.519673e-09  $ G+=25.421uS
Xrpl2_7_4 vout1_7 gate_l2 cpl2_4 0 reram_1t1r Tf0=4.196232e-09  $ G+=7.845uS
Xrpl2_8_0 vout1_8 gate_l2 cpl2_0 0 reram_1t1r Tf0=3.300000e-09  $ G+=0.296uS
Xrpl2_8_1 vout1_8 gate_l2 cpl2_1 0 reram_1t1r Tf0=3.300000e-09  $ G+=0.296uS
Xrpl2_8_2 vout1_8 gate_l2 cpl2_2 0 reram_1t1r Tf0=4.253559e-09  $ G+=9.662uS
Xrpl2_8_3 vout1_8 gate_l2 cpl2_3 0 reram_1t1r Tf0=4.326233e-09  $ G+=12.584uS
Xrpl2_8_4 vout1_8 gate_l2 cpl2_4 0 reram_1t1r Tf0=3.638603e-09  $ G+=1.033uS
Xrpl2_9_0 vout1_9 gate_l2 cpl2_0 0 reram_1t1r Tf0=3.300000e-09  $ G+=0.296uS
Xrpl2_9_1 vout1_9 gate_l2 cpl2_1 0 reram_1t1r Tf0=3.300000e-09  $ G+=0.296uS
Xrpl2_9_2 vout1_9 gate_l2 cpl2_2 0 reram_1t1r Tf0=4.343667e-09  $ G+=13.407uS
Xrpl2_9_3 vout1_9 gate_l2 cpl2_3 0 reram_1t1r Tf0=3.300000e-09  $ G+=0.296uS
Xrpl2_9_4 vout1_9 gate_l2 cpl2_4 0 reram_1t1r Tf0=3.300000e-09  $ G+=0.296uS
Xrpl2_10_0 vout1_10 gate_l2 cpl2_0 0 reram_1t1r Tf0=4.270610e-09  $ G+=10.280uS
Xrpl2_10_1 vout1_10 gate_l2 cpl2_1 0 reram_1t1r Tf0=3.945390e-09  $ G+=3.152uS
Xrpl2_10_2 vout1_10 gate_l2 cpl2_2 0 reram_1t1r Tf0=3.300000e-09  $ G+=0.296uS
Xrpl2_10_3 vout1_10 gate_l2 cpl2_3 0 reram_1t1r Tf0=3.300000e-09  $ G+=0.296uS
Xrpl2_10_4 vout1_10 gate_l2 cpl2_4 0 reram_1t1r Tf0=3.300000e-09  $ G+=0.296uS
Xrpl2_11_0 vout1_11 gate_l2 cpl2_0 0 reram_1t1r Tf0=4.118593e-09  $ G+=5.916uS
Xrpl2_11_1 vout1_11 gate_l2 cpl2_1 0 reram_1t1r Tf0=3.300000e-09  $ G+=0.296uS
Xrpl2_11_2 vout1_11 gate_l2 cpl2_2 0 reram_1t1r Tf0=4.387350e-09  $ G+=15.714uS
Xrpl2_11_3 vout1_11 gate_l2 cpl2_3 0 reram_1t1r Tf0=3.300000e-09  $ G+=0.296uS
Xrpl2_11_4 vout1_11 gate_l2 cpl2_4 0 reram_1t1r Tf0=3.898566e-09  $ G+=2.659uS
Xrpl2_12_0 vout1_12 gate_l2 cpl2_0 0 reram_1t1r Tf0=4.364033e-09  $ G+=14.437uS
Xrpl2_12_1 vout1_12 gate_l2 cpl2_1 0 reram_1t1r Tf0=3.300000e-09  $ G+=0.296uS
Xrpl2_12_2 vout1_12 gate_l2 cpl2_2 0 reram_1t1r Tf0=3.300000e-09  $ G+=0.296uS
Xrpl2_12_3 vout1_12 gate_l2 cpl2_3 0 reram_1t1r Tf0=3.300000e-09  $ G+=0.296uS
Xrpl2_12_4 vout1_12 gate_l2 cpl2_4 0 reram_1t1r Tf0=3.300000e-09  $ G+=0.296uS
Xrpl2_13_0 vout1_13 gate_l2 cpl2_0 0 reram_1t1r Tf0=3.300000e-09  $ G+=0.296uS
Xrpl2_13_1 vout1_13 gate_l2 cpl2_1 0 reram_1t1r Tf0=3.300000e-09  $ G+=0.296uS
Xrpl2_13_2 vout1_13 gate_l2 cpl2_2 0 reram_1t1r Tf0=4.290686e-09  $ G+=11.058uS
Xrpl2_13_3 vout1_13 gate_l2 cpl2_3 0 reram_1t1r Tf0=3.300000e-09  $ G+=0.296uS
Xrpl2_13_4 vout1_13 gate_l2 cpl2_4 0 reram_1t1r Tf0=4.363726e-09  $ G+=14.421uS
Xrpl2_14_0 vout1_14 gate_l2 cpl2_0 0 reram_1t1r Tf0=3.320863e-09  $ G+=0.326uS
Xrpl2_14_1 vout1_14 gate_l2 cpl2_1 0 reram_1t1r Tf0=3.300000e-09  $ G+=0.296uS
Xrpl2_14_2 vout1_14 gate_l2 cpl2_2 0 reram_1t1r Tf0=4.512780e-09  $ G+=24.792uS
Xrpl2_14_3 vout1_14 gate_l2 cpl2_3 0 reram_1t1r Tf0=3.300000e-09  $ G+=0.296uS
Xrpl2_14_4 vout1_14 gate_l2 cpl2_4 0 reram_1t1r Tf0=3.300000e-09  $ G+=0.296uS
Xrpl2_15_0 vout1_15 gate_l2 cpl2_0 0 reram_1t1r Tf0=3.300000e-09  $ G+=0.296uS
Xrpl2_15_1 vout1_15 gate_l2 cpl2_1 0 reram_1t1r Tf0=3.300000e-09  $ G+=0.296uS
Xrpl2_15_2 vout1_15 gate_l2 cpl2_2 0 reram_1t1r Tf0=4.389063e-09  $ G+=15.812uS
Xrpl2_15_3 vout1_15 gate_l2 cpl2_3 0 reram_1t1r Tf0=3.889719e-09  $ G+=2.575uS
Xrpl2_15_4 vout1_15 gate_l2 cpl2_4 0 reram_1t1r Tf0=3.300000e-09  $ G+=0.296uS
Xrpl2_16_0 vout1_16 gate_l2 cpl2_0 0 reram_1t1r Tf0=3.300000e-09  $ G+=0.296uS
Xrpl2_16_1 vout1_16 gate_l2 cpl2_1 0 reram_1t1r Tf0=3.300000e-09  $ G+=0.296uS
Xrpl2_16_2 vout1_16 gate_l2 cpl2_2 0 reram_1t1r Tf0=4.463095e-09  $ G+=20.695uS
Xrpl2_16_3 vout1_16 gate_l2 cpl2_3 0 reram_1t1r Tf0=4.328848e-09  $ G+=12.704uS
Xrpl2_16_4 vout1_16 gate_l2 cpl2_4 0 reram_1t1r Tf0=3.300000e-09  $ G+=0.296uS
Xrpl2_17_0 vout1_17 gate_l2 cpl2_0 0 reram_1t1r Tf0=4.432238e-09  $ G+=18.499uS
Xrpl2_17_1 vout1_17 gate_l2 cpl2_1 0 reram_1t1r Tf0=3.300000e-09  $ G+=0.296uS
Xrpl2_17_2 vout1_17 gate_l2 cpl2_2 0 reram_1t1r Tf0=3.300000e-09  $ G+=0.296uS
Xrpl2_17_3 vout1_17 gate_l2 cpl2_3 0 reram_1t1r Tf0=3.300000e-09  $ G+=0.296uS
Xrpl2_17_4 vout1_17 gate_l2 cpl2_4 0 reram_1t1r Tf0=3.300000e-09  $ G+=0.296uS
Xrpl2_18_0 vout1_18 gate_l2 cpl2_0 0 reram_1t1r Tf0=3.950970e-09  $ G+=3.217uS
Xrpl2_18_1 vout1_18 gate_l2 cpl2_1 0 reram_1t1r Tf0=3.300000e-09  $ G+=0.296uS
Xrpl2_18_2 vout1_18 gate_l2 cpl2_2 0 reram_1t1r Tf0=3.300000e-09  $ G+=0.296uS
Xrpl2_18_3 vout1_18 gate_l2 cpl2_3 0 reram_1t1r Tf0=3.300000e-09  $ G+=0.296uS
Xrpl2_18_4 vout1_18 gate_l2 cpl2_4 0 reram_1t1r Tf0=3.300000e-09  $ G+=0.296uS
Xrpl2_19_0 vout1_19 gate_l2 cpl2_0 0 reram_1t1r Tf0=4.402913e-09  $ G+=16.629uS
Xrpl2_19_1 vout1_19 gate_l2 cpl2_1 0 reram_1t1r Tf0=3.300000e-09  $ G+=0.296uS
Xrpl2_19_2 vout1_19 gate_l2 cpl2_2 0 reram_1t1r Tf0=3.300000e-09  $ G+=0.296uS
Xrpl2_19_3 vout1_19 gate_l2 cpl2_3 0 reram_1t1r Tf0=3.300000e-09  $ G+=0.296uS
Xrpl2_19_4 vout1_19 gate_l2 cpl2_4 0 reram_1t1r Tf0=3.941115e-09  $ G+=3.103uS
Xrpl2_20_0 vout1_20 gate_l2 cpl2_0 0 reram_1t1r Tf0=3.300000e-09  $ G+=0.296uS
Xrpl2_20_1 vout1_20 gate_l2 cpl2_1 0 reram_1t1r Tf0=3.300000e-09  $ G+=0.296uS
Xrpl2_20_2 vout1_20 gate_l2 cpl2_2 0 reram_1t1r Tf0=4.305882e-09  $ G+=11.686uS
Xrpl2_20_3 vout1_20 gate_l2 cpl2_3 0 reram_1t1r Tf0=4.242006e-09  $ G+=9.265uS
Xrpl2_20_4 vout1_20 gate_l2 cpl2_4 0 reram_1t1r Tf0=4.037379e-09  $ G+=4.404uS
Xrpl2_21_0 vout1_21 gate_l2 cpl2_0 0 reram_1t1r Tf0=3.300000e-09  $ G+=0.296uS
Xrpl2_21_1 vout1_21 gate_l2 cpl2_1 0 reram_1t1r Tf0=3.300000e-09  $ G+=0.296uS
Xrpl2_21_2 vout1_21 gate_l2 cpl2_2 0 reram_1t1r Tf0=4.411586e-09  $ G+=17.162uS
Xrpl2_21_3 vout1_21 gate_l2 cpl2_3 0 reram_1t1r Tf0=4.449404e-09  $ G+=19.691uS
Xrpl2_21_4 vout1_21 gate_l2 cpl2_4 0 reram_1t1r Tf0=3.300000e-09  $ G+=0.296uS
Xrpl2_22_0 vout1_22 gate_l2 cpl2_0 0 reram_1t1r Tf0=4.261584e-09  $ G+=9.948uS
Xrpl2_22_1 vout1_22 gate_l2 cpl2_1 0 reram_1t1r Tf0=3.300000e-09  $ G+=0.296uS
Xrpl2_22_2 vout1_22 gate_l2 cpl2_2 0 reram_1t1r Tf0=4.207414e-09  $ G+=8.170uS
Xrpl2_22_3 vout1_22 gate_l2 cpl2_3 0 reram_1t1r Tf0=3.300000e-09  $ G+=0.296uS
Xrpl2_22_4 vout1_22 gate_l2 cpl2_4 0 reram_1t1r Tf0=3.300000e-09  $ G+=0.296uS
Xrpl2_23_0 vout1_23 gate_l2 cpl2_0 0 reram_1t1r Tf0=3.449893e-09  $ G+=0.520uS
Xrpl2_23_1 vout1_23 gate_l2 cpl2_1 0 reram_1t1r Tf0=4.352194e-09  $ G+=13.829uS
Xrpl2_23_2 vout1_23 gate_l2 cpl2_2 0 reram_1t1r Tf0=3.300000e-09  $ G+=0.296uS
Xrpl2_23_3 vout1_23 gate_l2 cpl2_3 0 reram_1t1r Tf0=3.300000e-09  $ G+=0.296uS
Xrpl2_23_4 vout1_23 gate_l2 cpl2_4 0 reram_1t1r Tf0=3.300000e-09  $ G+=0.296uS
Xrpl2_24_0 vout1_24 gate_l2 cpl2_0 0 reram_1t1r Tf0=4.320710e-09  $ G+=12.334uS
Xrpl2_24_1 vout1_24 gate_l2 cpl2_1 0 reram_1t1r Tf0=3.300000e-09  $ G+=0.296uS
Xrpl2_24_2 vout1_24 gate_l2 cpl2_2 0 reram_1t1r Tf0=3.300000e-09  $ G+=0.296uS
Xrpl2_24_3 vout1_24 gate_l2 cpl2_3 0 reram_1t1r Tf0=4.606958e-09  $ G+=34.913uS
Xrpl2_24_4 vout1_24 gate_l2 cpl2_4 0 reram_1t1r Tf0=3.868407e-09  $ G+=2.383uS
Xrpl2_25_0 vout1_25 gate_l2 cpl2_0 0 reram_1t1r Tf0=3.300000e-09  $ G+=0.296uS
Xrpl2_25_1 vout1_25 gate_l2 cpl2_1 0 reram_1t1r Tf0=4.536229e-09  $ G+=26.998uS
Xrpl2_25_2 vout1_25 gate_l2 cpl2_2 0 reram_1t1r Tf0=3.300000e-09  $ G+=0.296uS
Xrpl2_25_3 vout1_25 gate_l2 cpl2_3 0 reram_1t1r Tf0=4.427589e-09  $ G+=18.189uS
Xrpl2_25_4 vout1_25 gate_l2 cpl2_4 0 reram_1t1r Tf0=4.457785e-09  $ G+=20.300uS
Xrpl2_26_0 vout1_26 gate_l2 cpl2_0 0 reram_1t1r Tf0=3.300000e-09  $ G+=0.296uS
Xrpl2_26_1 vout1_26 gate_l2 cpl2_1 0 reram_1t1r Tf0=4.592101e-09  $ G+=33.077uS
Xrpl2_26_2 vout1_26 gate_l2 cpl2_2 0 reram_1t1r Tf0=3.300000e-09  $ G+=0.296uS
Xrpl2_26_3 vout1_26 gate_l2 cpl2_3 0 reram_1t1r Tf0=4.294349e-09  $ G+=11.207uS
Xrpl2_26_4 vout1_26 gate_l2 cpl2_4 0 reram_1t1r Tf0=4.350366e-09  $ G+=13.738uS
Xrpl2_27_0 vout1_27 gate_l2 cpl2_0 0 reram_1t1r Tf0=4.538798e-09  $ G+=27.251uS
Xrpl2_27_1 vout1_27 gate_l2 cpl2_1 0 reram_1t1r Tf0=3.300000e-09  $ G+=0.296uS
Xrpl2_27_2 vout1_27 gate_l2 cpl2_2 0 reram_1t1r Tf0=3.300000e-09  $ G+=0.296uS
Xrpl2_27_3 vout1_27 gate_l2 cpl2_3 0 reram_1t1r Tf0=3.300000e-09  $ G+=0.296uS
Xrpl2_27_4 vout1_27 gate_l2 cpl2_4 0 reram_1t1r Tf0=4.373265e-09  $ G+=14.930uS
Xrpl2_28_0 vout1_28 gate_l2 cpl2_0 0 reram_1t1r Tf0=4.390639e-09  $ G+=15.903uS
Xrpl2_28_1 vout1_28 gate_l2 cpl2_1 0 reram_1t1r Tf0=4.128054e-09  $ G+=6.123uS
Xrpl2_28_2 vout1_28 gate_l2 cpl2_2 0 reram_1t1r Tf0=3.300000e-09  $ G+=0.296uS
Xrpl2_28_3 vout1_28 gate_l2 cpl2_3 0 reram_1t1r Tf0=3.300000e-09  $ G+=0.296uS
Xrpl2_28_4 vout1_28 gate_l2 cpl2_4 0 reram_1t1r Tf0=3.588556e-09  $ G+=0.862uS
Xrpl2_29_0 vout1_29 gate_l2 cpl2_0 0 reram_1t1r Tf0=3.300000e-09  $ G+=0.296uS
Xrpl2_29_1 vout1_29 gate_l2 cpl2_1 0 reram_1t1r Tf0=3.300000e-09  $ G+=0.296uS
Xrpl2_29_2 vout1_29 gate_l2 cpl2_2 0 reram_1t1r Tf0=4.547957e-09  $ G+=28.174uS
Xrpl2_29_3 vout1_29 gate_l2 cpl2_3 0 reram_1t1r Tf0=3.300000e-09  $ G+=0.296uS
Xrpl2_29_4 vout1_29 gate_l2 cpl2_4 0 reram_1t1r Tf0=3.300000e-09  $ G+=0.296uS
Xrpl2_30_0 vout1_30 gate_l2 cpl2_0 0 reram_1t1r Tf0=3.300000e-09  $ G+=0.296uS
Xrpl2_30_1 vout1_30 gate_l2 cpl2_1 0 reram_1t1r Tf0=4.511926e-09  $ G+=24.715uS
Xrpl2_30_2 vout1_30 gate_l2 cpl2_2 0 reram_1t1r Tf0=3.300000e-09  $ G+=0.296uS
Xrpl2_30_3 vout1_30 gate_l2 cpl2_3 0 reram_1t1r Tf0=4.063332e-09  $ G+=4.839uS
Xrpl2_30_4 vout1_30 gate_l2 cpl2_4 0 reram_1t1r Tf0=3.300000e-09  $ G+=0.296uS
Xrpl2_31_0 vout1_31 gate_l2 cpl2_0 0 reram_1t1r Tf0=4.159174e-09  $ G+=6.856uS
Xrpl2_31_1 vout1_31 gate_l2 cpl2_1 0 reram_1t1r Tf0=4.391194e-09  $ G+=15.935uS
Xrpl2_31_2 vout1_31 gate_l2 cpl2_2 0 reram_1t1r Tf0=3.300000e-09  $ G+=0.296uS
Xrpl2_31_3 vout1_31 gate_l2 cpl2_3 0 reram_1t1r Tf0=3.300000e-09  $ G+=0.296uS
Xrpl2_31_4 vout1_31 gate_l2 cpl2_4 0 reram_1t1r Tf0=3.836677e-09  $ G+=2.123uS
Xrpl2_32_0 vout1_32 gate_l2 cpl2_0 0 reram_1t1r Tf0=3.300000e-09  $ G+=0.296uS
Xrpl2_32_1 vout1_32 gate_l2 cpl2_1 0 reram_1t1r Tf0=4.497218e-09  $ G+=23.428uS
Xrpl2_32_2 vout1_32 gate_l2 cpl2_2 0 reram_1t1r Tf0=4.176826e-09  $ G+=7.310uS
Xrpl2_32_3 vout1_32 gate_l2 cpl2_3 0 reram_1t1r Tf0=3.300000e-09  $ G+=0.296uS
Xrpl2_32_4 vout1_32 gate_l2 cpl2_4 0 reram_1t1r Tf0=3.300000e-09  $ G+=0.296uS
Xrpl2_33_0 vout1_33 gate_l2 cpl2_0 0 reram_1t1r Tf0=3.300000e-09  $ G+=0.296uS
Xrpl2_33_1 vout1_33 gate_l2 cpl2_1 0 reram_1t1r Tf0=4.494865e-09  $ G+=23.229uS
Xrpl2_33_2 vout1_33 gate_l2 cpl2_2 0 reram_1t1r Tf0=4.451103e-09  $ G+=19.813uS
Xrpl2_33_3 vout1_33 gate_l2 cpl2_3 0 reram_1t1r Tf0=3.300000e-09  $ G+=0.296uS
Xrpl2_33_4 vout1_33 gate_l2 cpl2_4 0 reram_1t1r Tf0=4.407749e-09  $ G+=16.924uS
Xrpl2_34_0 vout1_34 gate_l2 cpl2_0 0 reram_1t1r Tf0=3.300000e-09  $ G+=0.296uS
Xrpl2_34_1 vout1_34 gate_l2 cpl2_1 0 reram_1t1r Tf0=3.300000e-09  $ G+=0.296uS
Xrpl2_34_2 vout1_34 gate_l2 cpl2_2 0 reram_1t1r Tf0=4.316161e-09  $ G+=12.131uS
Xrpl2_34_3 vout1_34 gate_l2 cpl2_3 0 reram_1t1r Tf0=4.350229e-09  $ G+=13.731uS
Xrpl2_34_4 vout1_34 gate_l2 cpl2_4 0 reram_1t1r Tf0=3.892760e-09  $ G+=2.603uS
Xrpl2_35_0 vout1_35 gate_l2 cpl2_0 0 reram_1t1r Tf0=4.430637e-09  $ G+=18.392uS
Xrpl2_35_1 vout1_35 gate_l2 cpl2_1 0 reram_1t1r Tf0=4.019996e-09  $ G+=4.134uS
Xrpl2_35_2 vout1_35 gate_l2 cpl2_2 0 reram_1t1r Tf0=3.300000e-09  $ G+=0.296uS
Xrpl2_35_3 vout1_35 gate_l2 cpl2_3 0 reram_1t1r Tf0=3.300000e-09  $ G+=0.296uS
Xrpl2_35_4 vout1_35 gate_l2 cpl2_4 0 reram_1t1r Tf0=4.331263e-09  $ G+=12.816uS
Xrpl2_36_0 vout1_36 gate_l2 cpl2_0 0 reram_1t1r Tf0=3.929389e-09  $ G+=2.974uS
Xrpl2_36_1 vout1_36 gate_l2 cpl2_1 0 reram_1t1r Tf0=3.300000e-09  $ G+=0.296uS
Xrpl2_36_2 vout1_36 gate_l2 cpl2_2 0 reram_1t1r Tf0=4.298100e-09  $ G+=11.361uS
Xrpl2_36_3 vout1_36 gate_l2 cpl2_3 0 reram_1t1r Tf0=4.366591e-09  $ G+=14.572uS
Xrpl2_36_4 vout1_36 gate_l2 cpl2_4 0 reram_1t1r Tf0=3.300000e-09  $ G+=0.296uS
Xrpl2_37_0 vout1_37 gate_l2 cpl2_0 0 reram_1t1r Tf0=3.743770e-09  $ G+=1.515uS
Xrpl2_37_1 vout1_37 gate_l2 cpl2_1 0 reram_1t1r Tf0=3.300000e-09  $ G+=0.296uS
Xrpl2_37_2 vout1_37 gate_l2 cpl2_2 0 reram_1t1r Tf0=4.313341e-09  $ G+=12.008uS
Xrpl2_37_3 vout1_37 gate_l2 cpl2_3 0 reram_1t1r Tf0=3.300000e-09  $ G+=0.296uS
Xrpl2_37_4 vout1_37 gate_l2 cpl2_4 0 reram_1t1r Tf0=3.300000e-09  $ G+=0.296uS
Xrpl2_38_0 vout1_38 gate_l2 cpl2_0 0 reram_1t1r Tf0=4.295095e-09  $ G+=11.237uS
Xrpl2_38_1 vout1_38 gate_l2 cpl2_1 0 reram_1t1r Tf0=4.236250e-09  $ G+=9.073uS
Xrpl2_38_2 vout1_38 gate_l2 cpl2_2 0 reram_1t1r Tf0=3.300000e-09  $ G+=0.296uS
Xrpl2_38_3 vout1_38 gate_l2 cpl2_3 0 reram_1t1r Tf0=3.300000e-09  $ G+=0.296uS
Xrpl2_38_4 vout1_38 gate_l2 cpl2_4 0 reram_1t1r Tf0=3.300000e-09  $ G+=0.296uS
Xrpl2_39_0 vout1_39 gate_l2 cpl2_0 0 reram_1t1r Tf0=4.427846e-09  $ G+=18.206uS
Xrpl2_39_1 vout1_39 gate_l2 cpl2_1 0 reram_1t1r Tf0=3.300000e-09  $ G+=0.296uS
Xrpl2_39_2 vout1_39 gate_l2 cpl2_2 0 reram_1t1r Tf0=3.300000e-09  $ G+=0.296uS
Xrpl2_39_3 vout1_39 gate_l2 cpl2_3 0 reram_1t1r Tf0=3.904088e-09  $ G+=2.713uS
Xrpl2_39_4 vout1_39 gate_l2 cpl2_4 0 reram_1t1r Tf0=3.300000e-09  $ G+=0.296uS
Xrpl2_40_0 vout1_40 gate_l2 cpl2_0 0 reram_1t1r Tf0=3.300000e-09  $ G+=0.296uS
Xrpl2_40_1 vout1_40 gate_l2 cpl2_1 0 reram_1t1r Tf0=4.238425e-09  $ G+=9.145uS
Xrpl2_40_2 vout1_40 gate_l2 cpl2_2 0 reram_1t1r Tf0=4.212143e-09  $ G+=8.312uS
Xrpl2_40_3 vout1_40 gate_l2 cpl2_3 0 reram_1t1r Tf0=4.499434e-09  $ G+=23.618uS
Xrpl2_40_4 vout1_40 gate_l2 cpl2_4 0 reram_1t1r Tf0=3.300000e-09  $ G+=0.296uS
Xrpl2_41_0 vout1_41 gate_l2 cpl2_0 0 reram_1t1r Tf0=4.395567e-09  $ G+=16.191uS
Xrpl2_41_1 vout1_41 gate_l2 cpl2_1 0 reram_1t1r Tf0=3.300000e-09  $ G+=0.296uS
Xrpl2_41_2 vout1_41 gate_l2 cpl2_2 0 reram_1t1r Tf0=3.300000e-09  $ G+=0.296uS
Xrpl2_41_3 vout1_41 gate_l2 cpl2_3 0 reram_1t1r Tf0=3.300000e-09  $ G+=0.296uS
Xrpl2_41_4 vout1_41 gate_l2 cpl2_4 0 reram_1t1r Tf0=4.266665e-09  $ G+=10.134uS
Xrpl2_42_0 vout1_42 gate_l2 cpl2_0 0 reram_1t1r Tf0=4.415272e-09  $ G+=17.393uS
Xrpl2_42_1 vout1_42 gate_l2 cpl2_1 0 reram_1t1r Tf0=4.162868e-09  $ G+=6.949uS
Xrpl2_42_2 vout1_42 gate_l2 cpl2_2 0 reram_1t1r Tf0=3.300000e-09  $ G+=0.296uS
Xrpl2_42_3 vout1_42 gate_l2 cpl2_3 0 reram_1t1r Tf0=3.300000e-09  $ G+=0.296uS
Xrpl2_42_4 vout1_42 gate_l2 cpl2_4 0 reram_1t1r Tf0=3.300000e-09  $ G+=0.296uS
Xrpl2_43_0 vout1_43 gate_l2 cpl2_0 0 reram_1t1r Tf0=4.334920e-09  $ G+=12.987uS
Xrpl2_43_1 vout1_43 gate_l2 cpl2_1 0 reram_1t1r Tf0=3.300000e-09  $ G+=0.296uS
Xrpl2_43_2 vout1_43 gate_l2 cpl2_2 0 reram_1t1r Tf0=3.300000e-09  $ G+=0.296uS
Xrpl2_43_3 vout1_43 gate_l2 cpl2_3 0 reram_1t1r Tf0=3.300000e-09  $ G+=0.296uS
Xrpl2_43_4 vout1_43 gate_l2 cpl2_4 0 reram_1t1r Tf0=4.263301e-09  $ G+=10.011uS
Xrpl2_44_0 vout1_44 gate_l2 cpl2_0 0 reram_1t1r Tf0=4.407670e-09  $ G+=16.919uS
Xrpl2_44_1 vout1_44 gate_l2 cpl2_1 0 reram_1t1r Tf0=3.300000e-09  $ G+=0.296uS
Xrpl2_44_2 vout1_44 gate_l2 cpl2_2 0 reram_1t1r Tf0=4.000146e-09  $ G+=3.846uS
Xrpl2_44_3 vout1_44 gate_l2 cpl2_3 0 reram_1t1r Tf0=3.300000e-09  $ G+=0.296uS
Xrpl2_44_4 vout1_44 gate_l2 cpl2_4 0 reram_1t1r Tf0=4.090711e-09  $ G+=5.346uS
Xrpl2_45_0 vout1_45 gate_l2 cpl2_0 0 reram_1t1r Tf0=3.300000e-09  $ G+=0.296uS
Xrpl2_45_1 vout1_45 gate_l2 cpl2_1 0 reram_1t1r Tf0=4.303134e-09  $ G+=11.570uS
Xrpl2_45_2 vout1_45 gate_l2 cpl2_2 0 reram_1t1r Tf0=4.314332e-09  $ G+=12.051uS
Xrpl2_45_3 vout1_45 gate_l2 cpl2_3 0 reram_1t1r Tf0=3.300000e-09  $ G+=0.296uS
Xrpl2_45_4 vout1_45 gate_l2 cpl2_4 0 reram_1t1r Tf0=3.817473e-09  $ G+=1.980uS
Xrpl2_46_0 vout1_46 gate_l2 cpl2_0 0 reram_1t1r Tf0=4.277839e-09  $ G+=10.554uS
Xrpl2_46_1 vout1_46 gate_l2 cpl2_1 0 reram_1t1r Tf0=4.396108e-09  $ G+=16.223uS
Xrpl2_46_2 vout1_46 gate_l2 cpl2_2 0 reram_1t1r Tf0=3.300000e-09  $ G+=0.296uS
Xrpl2_46_3 vout1_46 gate_l2 cpl2_3 0 reram_1t1r Tf0=3.300000e-09  $ G+=0.296uS
Xrpl2_46_4 vout1_46 gate_l2 cpl2_4 0 reram_1t1r Tf0=3.300000e-09  $ G+=0.296uS
Xrpl2_47_0 vout1_47 gate_l2 cpl2_0 0 reram_1t1r Tf0=4.440515e-09  $ G+=19.064uS
Xrpl2_47_1 vout1_47 gate_l2 cpl2_1 0 reram_1t1r Tf0=3.300000e-09  $ G+=0.296uS
Xrpl2_47_2 vout1_47 gate_l2 cpl2_2 0 reram_1t1r Tf0=4.122899e-09  $ G+=6.009uS
Xrpl2_47_3 vout1_47 gate_l2 cpl2_3 0 reram_1t1r Tf0=4.174738e-09  $ G+=7.255uS
Xrpl2_47_4 vout1_47 gate_l2 cpl2_4 0 reram_1t1r Tf0=3.300000e-09  $ G+=0.296uS
Xrpl2_48_0 vout1_48 gate_l2 cpl2_0 0 reram_1t1r Tf0=4.031445e-09  $ G+=4.310uS
Xrpl2_48_1 vout1_48 gate_l2 cpl2_1 0 reram_1t1r Tf0=3.300000e-09  $ G+=0.296uS
Xrpl2_48_2 vout1_48 gate_l2 cpl2_2 0 reram_1t1r Tf0=3.300000e-09  $ G+=0.296uS
Xrpl2_48_3 vout1_48 gate_l2 cpl2_3 0 reram_1t1r Tf0=3.514131e-09  $ G+=0.657uS
Xrpl2_48_4 vout1_48 gate_l2 cpl2_4 0 reram_1t1r Tf0=4.082126e-09  $ G+=5.181uS
Xrpl2_49_0 vout1_49 gate_l2 cpl2_0 0 reram_1t1r Tf0=3.300000e-09  $ G+=0.296uS
Xrpl2_49_1 vout1_49 gate_l2 cpl2_1 0 reram_1t1r Tf0=4.046607e-09  $ G+=4.554uS
Xrpl2_49_2 vout1_49 gate_l2 cpl2_2 0 reram_1t1r Tf0=3.300000e-09  $ G+=0.296uS
Xrpl2_49_3 vout1_49 gate_l2 cpl2_3 0 reram_1t1r Tf0=4.345709e-09  $ G+=13.507uS
Xrpl2_49_4 vout1_49 gate_l2 cpl2_4 0 reram_1t1r Tf0=4.357355e-09  $ G+=14.091uS
Xrpl2_50_0 vout1_50 gate_l2 cpl2_0 0 reram_1t1r Tf0=3.300000e-09  $ G+=0.296uS
Xrpl2_50_1 vout1_50 gate_l2 cpl2_1 0 reram_1t1r Tf0=3.300000e-09  $ G+=0.296uS
Xrpl2_50_2 vout1_50 gate_l2 cpl2_2 0 reram_1t1r Tf0=4.328986e-09  $ G+=12.710uS
Xrpl2_50_3 vout1_50 gate_l2 cpl2_3 0 reram_1t1r Tf0=3.300000e-09  $ G+=0.296uS
Xrpl2_50_4 vout1_50 gate_l2 cpl2_4 0 reram_1t1r Tf0=3.482224e-09  $ G+=0.585uS
Xrpl2_51_0 vout1_51 gate_l2 cpl2_0 0 reram_1t1r Tf0=4.557286e-09  $ G+=29.145uS
Xrpl2_51_1 vout1_51 gate_l2 cpl2_1 0 reram_1t1r Tf0=3.300000e-09  $ G+=0.296uS
Xrpl2_51_2 vout1_51 gate_l2 cpl2_2 0 reram_1t1r Tf0=3.300000e-09  $ G+=0.296uS
Xrpl2_51_3 vout1_51 gate_l2 cpl2_3 0 reram_1t1r Tf0=3.300000e-09  $ G+=0.296uS
Xrpl2_51_4 vout1_51 gate_l2 cpl2_4 0 reram_1t1r Tf0=3.795381e-09  $ G+=1.827uS
Xrpl2_52_0 vout1_52 gate_l2 cpl2_0 0 reram_1t1r Tf0=4.334836e-09  $ G+=12.984uS
Xrpl2_52_1 vout1_52 gate_l2 cpl2_1 0 reram_1t1r Tf0=4.319176e-09  $ G+=12.265uS
Xrpl2_52_2 vout1_52 gate_l2 cpl2_2 0 reram_1t1r Tf0=3.300000e-09  $ G+=0.296uS
Xrpl2_52_3 vout1_52 gate_l2 cpl2_3 0 reram_1t1r Tf0=3.437430e-09  $ G+=0.497uS
Xrpl2_52_4 vout1_52 gate_l2 cpl2_4 0 reram_1t1r Tf0=3.300000e-09  $ G+=0.296uS
Xrpl2_53_0 vout1_53 gate_l2 cpl2_0 0 reram_1t1r Tf0=3.300000e-09  $ G+=0.296uS
Xrpl2_53_1 vout1_53 gate_l2 cpl2_1 0 reram_1t1r Tf0=3.300000e-09  $ G+=0.296uS
Xrpl2_53_2 vout1_53 gate_l2 cpl2_2 0 reram_1t1r Tf0=4.485028e-09  $ G+=22.413uS
Xrpl2_53_3 vout1_53 gate_l2 cpl2_3 0 reram_1t1r Tf0=4.166707e-09  $ G+=7.046uS
Xrpl2_53_4 vout1_53 gate_l2 cpl2_4 0 reram_1t1r Tf0=3.813881e-09  $ G+=1.954uS
Xrpl2_54_0 vout1_54 gate_l2 cpl2_0 0 reram_1t1r Tf0=3.300000e-09  $ G+=0.296uS
Xrpl2_54_1 vout1_54 gate_l2 cpl2_1 0 reram_1t1r Tf0=3.976341e-09  $ G+=3.527uS
Xrpl2_54_2 vout1_54 gate_l2 cpl2_2 0 reram_1t1r Tf0=4.180043e-09  $ G+=7.396uS
Xrpl2_54_3 vout1_54 gate_l2 cpl2_3 0 reram_1t1r Tf0=4.533993e-09  $ G+=26.779uS
Xrpl2_54_4 vout1_54 gate_l2 cpl2_4 0 reram_1t1r Tf0=3.300000e-09  $ G+=0.296uS
Xrpl2_55_0 vout1_55 gate_l2 cpl2_0 0 reram_1t1r Tf0=4.481378e-09  $ G+=22.117uS
Xrpl2_55_1 vout1_55 gate_l2 cpl2_1 0 reram_1t1r Tf0=3.300000e-09  $ G+=0.296uS
Xrpl2_55_2 vout1_55 gate_l2 cpl2_2 0 reram_1t1r Tf0=3.300000e-09  $ G+=0.296uS
Xrpl2_55_3 vout1_55 gate_l2 cpl2_3 0 reram_1t1r Tf0=3.300000e-09  $ G+=0.296uS
Xrpl2_55_4 vout1_55 gate_l2 cpl2_4 0 reram_1t1r Tf0=3.982119e-09  $ G+=3.602uS
Xrpl2_56_0 vout1_56 gate_l2 cpl2_0 0 reram_1t1r Tf0=3.300000e-09  $ G+=0.296uS
Xrpl2_56_1 vout1_56 gate_l2 cpl2_1 0 reram_1t1r Tf0=4.363038e-09  $ G+=14.385uS
Xrpl2_56_2 vout1_56 gate_l2 cpl2_2 0 reram_1t1r Tf0=4.103878e-09  $ G+=5.608uS
Xrpl2_56_3 vout1_56 gate_l2 cpl2_3 0 reram_1t1r Tf0=3.300000e-09  $ G+=0.296uS
Xrpl2_56_4 vout1_56 gate_l2 cpl2_4 0 reram_1t1r Tf0=4.197747e-09  $ G+=7.888uS
Xrpl2_57_0 vout1_57 gate_l2 cpl2_0 0 reram_1t1r Tf0=3.300000e-09  $ G+=0.296uS
Xrpl2_57_1 vout1_57 gate_l2 cpl2_1 0 reram_1t1r Tf0=3.300000e-09  $ G+=0.296uS
Xrpl2_57_2 vout1_57 gate_l2 cpl2_2 0 reram_1t1r Tf0=4.273359e-09  $ G+=10.383uS
Xrpl2_57_3 vout1_57 gate_l2 cpl2_3 0 reram_1t1r Tf0=3.911877e-09  $ G+=2.790uS
Xrpl2_57_4 vout1_57 gate_l2 cpl2_4 0 reram_1t1r Tf0=3.754789e-09  $ G+=1.576uS
Xrpl2_58_0 vout1_58 gate_l2 cpl2_0 0 reram_1t1r Tf0=3.300000e-09  $ G+=0.296uS
Xrpl2_58_1 vout1_58 gate_l2 cpl2_1 0 reram_1t1r Tf0=3.300000e-09  $ G+=0.296uS
Xrpl2_58_2 vout1_58 gate_l2 cpl2_2 0 reram_1t1r Tf0=4.356568e-09  $ G+=14.051uS
Xrpl2_58_3 vout1_58 gate_l2 cpl2_3 0 reram_1t1r Tf0=4.274836e-09  $ G+=10.439uS
Xrpl2_58_4 vout1_58 gate_l2 cpl2_4 0 reram_1t1r Tf0=3.300000e-09  $ G+=0.296uS
Xrpl2_59_0 vout1_59 gate_l2 cpl2_0 0 reram_1t1r Tf0=4.065885e-09  $ G+=4.884uS
Xrpl2_59_1 vout1_59 gate_l2 cpl2_1 0 reram_1t1r Tf0=4.242507e-09  $ G+=9.282uS
Xrpl2_59_2 vout1_59 gate_l2 cpl2_2 0 reram_1t1r Tf0=3.300000e-09  $ G+=0.296uS
Xrpl2_59_3 vout1_59 gate_l2 cpl2_3 0 reram_1t1r Tf0=3.300000e-09  $ G+=0.296uS
Xrpl2_59_4 vout1_59 gate_l2 cpl2_4 0 reram_1t1r Tf0=3.300000e-09  $ G+=0.296uS
Xrpl2_60_0 vout1_60 gate_l2 cpl2_0 0 reram_1t1r Tf0=4.387388e-09  $ G+=15.716uS
Xrpl2_60_1 vout1_60 gate_l2 cpl2_1 0 reram_1t1r Tf0=3.300000e-09  $ G+=0.296uS
Xrpl2_60_2 vout1_60 gate_l2 cpl2_2 0 reram_1t1r Tf0=3.300000e-09  $ G+=0.296uS
Xrpl2_60_3 vout1_60 gate_l2 cpl2_3 0 reram_1t1r Tf0=3.808009e-09  $ G+=1.913uS
Xrpl2_60_4 vout1_60 gate_l2 cpl2_4 0 reram_1t1r Tf0=3.300000e-09  $ G+=0.296uS
Xrpl2_61_0 vout1_61 gate_l2 cpl2_0 0 reram_1t1r Tf0=3.960568e-09  $ G+=3.331uS
Xrpl2_61_1 vout1_61 gate_l2 cpl2_1 0 reram_1t1r Tf0=3.300000e-09  $ G+=0.296uS
Xrpl2_61_2 vout1_61 gate_l2 cpl2_2 0 reram_1t1r Tf0=3.300000e-09  $ G+=0.296uS
Xrpl2_61_3 vout1_61 gate_l2 cpl2_3 0 reram_1t1r Tf0=4.556744e-09  $ G+=29.088uS
Xrpl2_61_4 vout1_61 gate_l2 cpl2_4 0 reram_1t1r Tf0=3.300000e-09  $ G+=0.296uS
Xrpl2_62_0 vout1_62 gate_l2 cpl2_0 0 reram_1t1r Tf0=4.337664e-09  $ G+=13.118uS
Xrpl2_62_1 vout1_62 gate_l2 cpl2_1 0 reram_1t1r Tf0=3.300000e-09  $ G+=0.296uS
Xrpl2_62_2 vout1_62 gate_l2 cpl2_2 0 reram_1t1r Tf0=3.300000e-09  $ G+=0.296uS
Xrpl2_62_3 vout1_62 gate_l2 cpl2_3 0 reram_1t1r Tf0=3.300000e-09  $ G+=0.296uS
Xrpl2_62_4 vout1_62 gate_l2 cpl2_4 0 reram_1t1r Tf0=4.045084e-09  $ G+=4.529uS
Xrpl2_63_0 vout1_63 gate_l2 cpl2_0 0 reram_1t1r Tf0=4.427823e-09  $ G+=18.205uS
Xrpl2_63_1 vout1_63 gate_l2 cpl2_1 0 reram_1t1r Tf0=4.262965e-09  $ G+=9.998uS
Xrpl2_63_2 vout1_63 gate_l2 cpl2_2 0 reram_1t1r Tf0=3.300000e-09  $ G+=0.296uS
Xrpl2_63_3 vout1_63 gate_l2 cpl2_3 0 reram_1t1r Tf0=4.251334e-09  $ G+=9.585uS
Xrpl2_63_4 vout1_63 gate_l2 cpl2_4 0 reram_1t1r Tf0=3.300000e-09  $ G+=0.296uS

* --- Negative conductance array ---
Xrnl2_0_0 vout1_0 gate_l2 cnl2_0 0 reram_1t1r Tf0=4.320911e-09  $ G-=12.343uS
Xrnl2_0_1 vout1_0 gate_l2 cnl2_1 0 reram_1t1r Tf0=3.300000e-09  $ G-=0.296uS
Xrnl2_0_2 vout1_0 gate_l2 cnl2_2 0 reram_1t1r Tf0=3.300000e-09  $ G-=0.296uS
Xrnl2_0_3 vout1_0 gate_l2 cnl2_3 0 reram_1t1r Tf0=4.132225e-09  $ G-=6.216uS
Xrnl2_0_4 vout1_0 gate_l2 cnl2_4 0 reram_1t1r Tf0=4.393409e-09  $ G-=16.064uS
Xrnl2_1_0 vout1_1 gate_l2 cnl2_0 0 reram_1t1r Tf0=3.300000e-09  $ G-=0.296uS
Xrnl2_1_1 vout1_1 gate_l2 cnl2_1 0 reram_1t1r Tf0=4.516456e-09  $ G-=25.125uS
Xrnl2_1_2 vout1_1 gate_l2 cnl2_2 0 reram_1t1r Tf0=4.490212e-09  $ G-=22.839uS
Xrnl2_1_3 vout1_1 gate_l2 cnl2_3 0 reram_1t1r Tf0=3.300000e-09  $ G-=0.296uS
Xrnl2_1_4 vout1_1 gate_l2 cnl2_4 0 reram_1t1r Tf0=3.675093e-09  $ G-=1.180uS
Xrnl2_2_0 vout1_2 gate_l2 cnl2_0 0 reram_1t1r Tf0=4.533189e-09  $ G-=26.701uS
Xrnl2_2_1 vout1_2 gate_l2 cnl2_1 0 reram_1t1r Tf0=4.211641e-09  $ G-=8.297uS
Xrnl2_2_2 vout1_2 gate_l2 cnl2_2 0 reram_1t1r Tf0=3.300000e-09  $ G-=0.296uS
Xrnl2_2_3 vout1_2 gate_l2 cnl2_3 0 reram_1t1r Tf0=3.300000e-09  $ G-=0.296uS
Xrnl2_2_4 vout1_2 gate_l2 cnl2_4 0 reram_1t1r Tf0=4.170108e-09  $ G-=7.134uS
Xrnl2_3_0 vout1_3 gate_l2 cnl2_0 0 reram_1t1r Tf0=3.300000e-09  $ G-=0.296uS
Xrnl2_3_1 vout1_3 gate_l2 cnl2_1 0 reram_1t1r Tf0=4.721550e-09  $ G-=52.953uS
Xrnl2_3_2 vout1_3 gate_l2 cnl2_2 0 reram_1t1r Tf0=3.300000e-09  $ G-=0.296uS
Xrnl2_3_3 vout1_3 gate_l2 cnl2_3 0 reram_1t1r Tf0=3.300000e-09  $ G-=0.296uS
Xrnl2_3_4 vout1_3 gate_l2 cnl2_4 0 reram_1t1r Tf0=3.300000e-09  $ G-=0.296uS
Xrnl2_4_0 vout1_4 gate_l2 cnl2_0 0 reram_1t1r Tf0=3.300000e-09  $ G-=0.296uS
Xrnl2_4_1 vout1_4 gate_l2 cnl2_1 0 reram_1t1r Tf0=4.604559e-09  $ G-=34.610uS
Xrnl2_4_2 vout1_4 gate_l2 cnl2_2 0 reram_1t1r Tf0=3.300000e-09  $ G-=0.296uS
Xrnl2_4_3 vout1_4 gate_l2 cnl2_3 0 reram_1t1r Tf0=4.027652e-09  $ G-=4.251uS
Xrnl2_4_4 vout1_4 gate_l2 cnl2_4 0 reram_1t1r Tf0=4.132474e-09  $ G-=6.222uS
Xrnl2_5_0 vout1_5 gate_l2 cnl2_0 0 reram_1t1r Tf0=3.300000e-09  $ G-=0.296uS
Xrnl2_5_1 vout1_5 gate_l2 cnl2_1 0 reram_1t1r Tf0=4.053084e-09  $ G-=4.662uS
Xrnl2_5_2 vout1_5 gate_l2 cnl2_2 0 reram_1t1r Tf0=4.479747e-09  $ G-=21.987uS
Xrnl2_5_3 vout1_5 gate_l2 cnl2_3 0 reram_1t1r Tf0=4.342178e-09  $ G-=13.335uS
Xrnl2_5_4 vout1_5 gate_l2 cnl2_4 0 reram_1t1r Tf0=4.207637e-09  $ G-=8.177uS
Xrnl2_6_0 vout1_6 gate_l2 cnl2_0 0 reram_1t1r Tf0=4.402110e-09  $ G-=16.580uS
Xrnl2_6_1 vout1_6 gate_l2 cnl2_1 0 reram_1t1r Tf0=3.373642e-09  $ G-=0.394uS
Xrnl2_6_2 vout1_6 gate_l2 cnl2_2 0 reram_1t1r Tf0=3.300000e-09  $ G-=0.296uS
Xrnl2_6_3 vout1_6 gate_l2 cnl2_3 0 reram_1t1r Tf0=3.300000e-09  $ G-=0.296uS
Xrnl2_6_4 vout1_6 gate_l2 cnl2_4 0 reram_1t1r Tf0=4.442088e-09  $ G-=19.174uS
Xrnl2_7_0 vout1_7 gate_l2 cnl2_0 0 reram_1t1r Tf0=3.300000e-09  $ G-=0.296uS
Xrnl2_7_1 vout1_7 gate_l2 cnl2_1 0 reram_1t1r Tf0=4.757021e-09  $ G-=60.240uS
Xrnl2_7_2 vout1_7 gate_l2 cnl2_2 0 reram_1t1r Tf0=4.469707e-09  $ G-=21.199uS
Xrnl2_7_3 vout1_7 gate_l2 cnl2_3 0 reram_1t1r Tf0=3.300000e-09  $ G-=0.296uS
Xrnl2_7_4 vout1_7 gate_l2 cnl2_4 0 reram_1t1r Tf0=3.300000e-09  $ G-=0.296uS
Xrnl2_8_0 vout1_8 gate_l2 cnl2_0 0 reram_1t1r Tf0=4.317522e-09  $ G-=12.192uS
Xrnl2_8_1 vout1_8 gate_l2 cnl2_1 0 reram_1t1r Tf0=4.385735e-09  $ G-=15.622uS
Xrnl2_8_2 vout1_8 gate_l2 cnl2_2 0 reram_1t1r Tf0=3.300000e-09  $ G-=0.296uS
Xrnl2_8_3 vout1_8 gate_l2 cnl2_3 0 reram_1t1r Tf0=3.300000e-09  $ G-=0.296uS
Xrnl2_8_4 vout1_8 gate_l2 cnl2_4 0 reram_1t1r Tf0=3.300000e-09  $ G-=0.296uS
Xrnl2_9_0 vout1_9 gate_l2 cnl2_0 0 reram_1t1r Tf0=4.172544e-09  $ G-=7.198uS
Xrnl2_9_1 vout1_9 gate_l2 cnl2_1 0 reram_1t1r Tf0=4.317392e-09  $ G-=12.186uS
Xrnl2_9_2 vout1_9 gate_l2 cnl2_2 0 reram_1t1r Tf0=3.300000e-09  $ G-=0.296uS
Xrnl2_9_3 vout1_9 gate_l2 cnl2_3 0 reram_1t1r Tf0=4.052821e-09  $ G-=4.658uS
Xrnl2_9_4 vout1_9 gate_l2 cnl2_4 0 reram_1t1r Tf0=3.642486e-09  $ G-=1.048uS
Xrnl2_10_0 vout1_10 gate_l2 cnl2_0 0 reram_1t1r Tf0=3.300000e-09  $ G-=0.296uS
Xrnl2_10_1 vout1_10 gate_l2 cnl2_1 0 reram_1t1r Tf0=3.300000e-09  $ G-=0.296uS
Xrnl2_10_2 vout1_10 gate_l2 cnl2_2 0 reram_1t1r Tf0=4.286659e-09  $ G-=10.898uS
Xrnl2_10_3 vout1_10 gate_l2 cnl2_3 0 reram_1t1r Tf0=4.467767e-09  $ G-=21.050uS
Xrnl2_10_4 vout1_10 gate_l2 cnl2_4 0 reram_1t1r Tf0=4.469476e-09  $ G-=21.181uS
Xrnl2_11_0 vout1_11 gate_l2 cnl2_0 0 reram_1t1r Tf0=3.300000e-09  $ G-=0.296uS
Xrnl2_11_1 vout1_11 gate_l2 cnl2_1 0 reram_1t1r Tf0=4.427906e-09  $ G-=18.210uS
Xrnl2_11_2 vout1_11 gate_l2 cnl2_2 0 reram_1t1r Tf0=3.300000e-09  $ G-=0.296uS
Xrnl2_11_3 vout1_11 gate_l2 cnl2_3 0 reram_1t1r Tf0=4.471037e-09  $ G-=21.302uS
Xrnl2_11_4 vout1_11 gate_l2 cnl2_4 0 reram_1t1r Tf0=3.300000e-09  $ G-=0.296uS
Xrnl2_12_0 vout1_12 gate_l2 cnl2_0 0 reram_1t1r Tf0=3.300000e-09  $ G-=0.296uS
Xrnl2_12_1 vout1_12 gate_l2 cnl2_1 0 reram_1t1r Tf0=4.544658e-09  $ G-=27.838uS
Xrnl2_12_2 vout1_12 gate_l2 cnl2_2 0 reram_1t1r Tf0=4.440045e-09  $ G-=19.032uS
Xrnl2_12_3 vout1_12 gate_l2 cnl2_3 0 reram_1t1r Tf0=3.972060e-09  $ G-=3.473uS
Xrnl2_12_4 vout1_12 gate_l2 cnl2_4 0 reram_1t1r Tf0=4.044543e-09  $ G-=4.520uS
Xrnl2_13_0 vout1_13 gate_l2 cnl2_0 0 reram_1t1r Tf0=4.312785e-09  $ G-=11.983uS
Xrnl2_13_1 vout1_13 gate_l2 cnl2_1 0 reram_1t1r Tf0=4.529551e-09  $ G-=26.350uS
Xrnl2_13_2 vout1_13 gate_l2 cnl2_2 0 reram_1t1r Tf0=3.300000e-09  $ G-=0.296uS
Xrnl2_13_3 vout1_13 gate_l2 cnl2_3 0 reram_1t1r Tf0=4.241063e-09  $ G-=9.233uS
Xrnl2_13_4 vout1_13 gate_l2 cnl2_4 0 reram_1t1r Tf0=3.300000e-09  $ G-=0.296uS
Xrnl2_14_0 vout1_14 gate_l2 cnl2_0 0 reram_1t1r Tf0=3.300000e-09  $ G-=0.296uS
Xrnl2_14_1 vout1_14 gate_l2 cnl2_1 0 reram_1t1r Tf0=4.207205e-09  $ G-=8.164uS
Xrnl2_14_2 vout1_14 gate_l2 cnl2_2 0 reram_1t1r Tf0=3.300000e-09  $ G-=0.296uS
Xrnl2_14_3 vout1_14 gate_l2 cnl2_3 0 reram_1t1r Tf0=4.404979e-09  $ G-=16.754uS
Xrnl2_14_4 vout1_14 gate_l2 cnl2_4 0 reram_1t1r Tf0=4.359635e-09  $ G-=14.208uS
Xrnl2_15_0 vout1_15 gate_l2 cnl2_0 0 reram_1t1r Tf0=4.163068e-09  $ G-=6.954uS
Xrnl2_15_1 vout1_15 gate_l2 cnl2_1 0 reram_1t1r Tf0=4.173381e-09  $ G-=7.219uS
Xrnl2_15_2 vout1_15 gate_l2 cnl2_2 0 reram_1t1r Tf0=3.300000e-09  $ G-=0.296uS
Xrnl2_15_3 vout1_15 gate_l2 cnl2_3 0 reram_1t1r Tf0=3.300000e-09  $ G-=0.296uS
Xrnl2_15_4 vout1_15 gate_l2 cnl2_4 0 reram_1t1r Tf0=4.577363e-09  $ G-=31.352uS
Xrnl2_16_0 vout1_16 gate_l2 cnl2_0 0 reram_1t1r Tf0=4.485092e-09  $ G-=22.418uS
Xrnl2_16_1 vout1_16 gate_l2 cnl2_1 0 reram_1t1r Tf0=3.439082e-09  $ G-=0.500uS
Xrnl2_16_2 vout1_16 gate_l2 cnl2_2 0 reram_1t1r Tf0=3.300000e-09  $ G-=0.296uS
Xrnl2_16_3 vout1_16 gate_l2 cnl2_3 0 reram_1t1r Tf0=3.300000e-09  $ G-=0.296uS
Xrnl2_16_4 vout1_16 gate_l2 cnl2_4 0 reram_1t1r Tf0=4.339921e-09  $ G-=13.226uS
Xrnl2_17_0 vout1_17 gate_l2 cnl2_0 0 reram_1t1r Tf0=3.300000e-09  $ G-=0.296uS
Xrnl2_17_1 vout1_17 gate_l2 cnl2_1 0 reram_1t1r Tf0=3.341961e-09  $ G-=0.352uS
Xrnl2_17_2 vout1_17 gate_l2 cnl2_2 0 reram_1t1r Tf0=4.274152e-09  $ G-=10.413uS
Xrnl2_17_3 vout1_17 gate_l2 cnl2_3 0 reram_1t1r Tf0=4.451347e-09  $ G-=19.830uS
Xrnl2_17_4 vout1_17 gate_l2 cnl2_4 0 reram_1t1r Tf0=4.462365e-09  $ G-=20.641uS
Xrnl2_18_0 vout1_18 gate_l2 cnl2_0 0 reram_1t1r Tf0=3.300000e-09  $ G-=0.296uS
Xrnl2_18_1 vout1_18 gate_l2 cnl2_1 0 reram_1t1r Tf0=4.519020e-09  $ G-=25.361uS
Xrnl2_18_2 vout1_18 gate_l2 cnl2_2 0 reram_1t1r Tf0=4.428660e-09  $ G-=18.260uS
Xrnl2_18_3 vout1_18 gate_l2 cnl2_3 0 reram_1t1r Tf0=4.168788e-09  $ G-=7.100uS
Xrnl2_18_4 vout1_18 gate_l2 cnl2_4 0 reram_1t1r Tf0=4.036693e-09  $ G-=4.393uS
Xrnl2_19_0 vout1_19 gate_l2 cnl2_0 0 reram_1t1r Tf0=3.300000e-09  $ G-=0.296uS
Xrnl2_19_1 vout1_19 gate_l2 cnl2_1 0 reram_1t1r Tf0=4.159521e-09  $ G-=6.865uS
Xrnl2_19_2 vout1_19 gate_l2 cnl2_2 0 reram_1t1r Tf0=4.344355e-09  $ G-=13.441uS
Xrnl2_19_3 vout1_19 gate_l2 cnl2_3 0 reram_1t1r Tf0=3.872062e-09  $ G-=2.414uS
Xrnl2_19_4 vout1_19 gate_l2 cnl2_4 0 reram_1t1r Tf0=3.300000e-09  $ G-=0.296uS
Xrnl2_20_0 vout1_20 gate_l2 cnl2_0 0 reram_1t1r Tf0=4.219794e-09  $ G-=8.546uS
Xrnl2_20_1 vout1_20 gate_l2 cnl2_1 0 reram_1t1r Tf0=4.205895e-09  $ G-=8.125uS
Xrnl2_20_2 vout1_20 gate_l2 cnl2_2 0 reram_1t1r Tf0=3.300000e-09  $ G-=0.296uS
Xrnl2_20_3 vout1_20 gate_l2 cnl2_3 0 reram_1t1r Tf0=3.300000e-09  $ G-=0.296uS
Xrnl2_20_4 vout1_20 gate_l2 cnl2_4 0 reram_1t1r Tf0=3.300000e-09  $ G-=0.296uS
Xrnl2_21_0 vout1_21 gate_l2 cnl2_0 0 reram_1t1r Tf0=4.313357e-09  $ G-=12.008uS
Xrnl2_21_1 vout1_21 gate_l2 cnl2_1 0 reram_1t1r Tf0=4.537672e-09  $ G-=27.140uS
Xrnl2_21_2 vout1_21 gate_l2 cnl2_2 0 reram_1t1r Tf0=3.300000e-09  $ G-=0.296uS
Xrnl2_21_3 vout1_21 gate_l2 cnl2_3 0 reram_1t1r Tf0=3.300000e-09  $ G-=0.296uS
Xrnl2_21_4 vout1_21 gate_l2 cnl2_4 0 reram_1t1r Tf0=4.253067e-09  $ G-=9.645uS
Xrnl2_22_0 vout1_22 gate_l2 cnl2_0 0 reram_1t1r Tf0=3.300000e-09  $ G-=0.296uS
Xrnl2_22_1 vout1_22 gate_l2 cnl2_1 0 reram_1t1r Tf0=4.369326e-09  $ G-=14.718uS
Xrnl2_22_2 vout1_22 gate_l2 cnl2_2 0 reram_1t1r Tf0=3.300000e-09  $ G-=0.296uS
Xrnl2_22_3 vout1_22 gate_l2 cnl2_3 0 reram_1t1r Tf0=4.425991e-09  $ G-=18.084uS
Xrnl2_22_4 vout1_22 gate_l2 cnl2_4 0 reram_1t1r Tf0=4.221135e-09  $ G-=8.588uS
Xrnl2_23_0 vout1_23 gate_l2 cnl2_0 0 reram_1t1r Tf0=3.300000e-09  $ G-=0.296uS
Xrnl2_23_1 vout1_23 gate_l2 cnl2_1 0 reram_1t1r Tf0=3.300000e-09  $ G-=0.296uS
Xrnl2_23_2 vout1_23 gate_l2 cnl2_2 0 reram_1t1r Tf0=4.511548e-09  $ G-=24.681uS
Xrnl2_23_3 vout1_23 gate_l2 cnl2_3 0 reram_1t1r Tf0=4.166366e-09  $ G-=7.038uS
Xrnl2_23_4 vout1_23 gate_l2 cnl2_4 0 reram_1t1r Tf0=4.146804e-09  $ G-=6.555uS
Xrnl2_24_0 vout1_24 gate_l2 cnl2_0 0 reram_1t1r Tf0=3.300000e-09  $ G-=0.296uS
Xrnl2_24_1 vout1_24 gate_l2 cnl2_1 0 reram_1t1r Tf0=4.232323e-09  $ G-=8.945uS
Xrnl2_24_2 vout1_24 gate_l2 cnl2_2 0 reram_1t1r Tf0=4.541490e-09  $ G-=27.519uS
Xrnl2_24_3 vout1_24 gate_l2 cnl2_3 0 reram_1t1r Tf0=3.300000e-09  $ G-=0.296uS
Xrnl2_24_4 vout1_24 gate_l2 cnl2_4 0 reram_1t1r Tf0=3.300000e-09  $ G-=0.296uS
Xrnl2_25_0 vout1_25 gate_l2 cnl2_0 0 reram_1t1r Tf0=4.032968e-09  $ G-=4.334uS
Xrnl2_25_1 vout1_25 gate_l2 cnl2_1 0 reram_1t1r Tf0=3.300000e-09  $ G-=0.296uS
Xrnl2_25_2 vout1_25 gate_l2 cnl2_2 0 reram_1t1r Tf0=4.667713e-09  $ G-=43.541uS
Xrnl2_25_3 vout1_25 gate_l2 cnl2_3 0 reram_1t1r Tf0=3.300000e-09  $ G-=0.296uS
Xrnl2_25_4 vout1_25 gate_l2 cnl2_4 0 reram_1t1r Tf0=3.300000e-09  $ G-=0.296uS
Xrnl2_26_0 vout1_26 gate_l2 cnl2_0 0 reram_1t1r Tf0=4.347533e-09  $ G-=13.597uS
Xrnl2_26_1 vout1_26 gate_l2 cnl2_1 0 reram_1t1r Tf0=3.300000e-09  $ G-=0.296uS
Xrnl2_26_2 vout1_26 gate_l2 cnl2_2 0 reram_1t1r Tf0=4.261139e-09  $ G-=9.932uS
Xrnl2_26_3 vout1_26 gate_l2 cnl2_3 0 reram_1t1r Tf0=3.300000e-09  $ G-=0.296uS
Xrnl2_26_4 vout1_26 gate_l2 cnl2_4 0 reram_1t1r Tf0=3.300000e-09  $ G-=0.296uS
Xrnl2_27_0 vout1_27 gate_l2 cnl2_0 0 reram_1t1r Tf0=3.300000e-09  $ G-=0.296uS
Xrnl2_27_1 vout1_27 gate_l2 cnl2_1 0 reram_1t1r Tf0=4.635344e-09  $ G-=38.708uS
Xrnl2_27_2 vout1_27 gate_l2 cnl2_2 0 reram_1t1r Tf0=4.662589e-09  $ G-=42.738uS
Xrnl2_27_3 vout1_27 gate_l2 cnl2_3 0 reram_1t1r Tf0=3.924008e-09  $ G-=2.916uS
Xrnl2_27_4 vout1_27 gate_l2 cnl2_4 0 reram_1t1r Tf0=3.300000e-09  $ G-=0.296uS
Xrnl2_28_0 vout1_28 gate_l2 cnl2_0 0 reram_1t1r Tf0=3.300000e-09  $ G-=0.296uS
Xrnl2_28_1 vout1_28 gate_l2 cnl2_1 0 reram_1t1r Tf0=3.300000e-09  $ G-=0.296uS
Xrnl2_28_2 vout1_28 gate_l2 cnl2_2 0 reram_1t1r Tf0=4.416172e-09  $ G-=17.450uS
Xrnl2_28_3 vout1_28 gate_l2 cnl2_3 0 reram_1t1r Tf0=3.621610e-09  $ G-=0.971uS
Xrnl2_28_4 vout1_28 gate_l2 cnl2_4 0 reram_1t1r Tf0=3.300000e-09  $ G-=0.296uS
Xrnl2_29_0 vout1_29 gate_l2 cnl2_0 0 reram_1t1r Tf0=4.397011e-09  $ G-=16.276uS
Xrnl2_29_1 vout1_29 gate_l2 cnl2_1 0 reram_1t1r Tf0=4.386430e-09  $ G-=15.662uS
Xrnl2_29_2 vout1_29 gate_l2 cnl2_2 0 reram_1t1r Tf0=3.300000e-09  $ G-=0.296uS
Xrnl2_29_3 vout1_29 gate_l2 cnl2_3 0 reram_1t1r Tf0=4.369475e-09  $ G-=14.726uS
Xrnl2_29_4 vout1_29 gate_l2 cnl2_4 0 reram_1t1r Tf0=4.479012e-09  $ G-=21.928uS
Xrnl2_30_0 vout1_30 gate_l2 cnl2_0 0 reram_1t1r Tf0=4.390312e-09  $ G-=15.884uS
Xrnl2_30_1 vout1_30 gate_l2 cnl2_1 0 reram_1t1r Tf0=3.300000e-09  $ G-=0.296uS
Xrnl2_30_2 vout1_30 gate_l2 cnl2_2 0 reram_1t1r Tf0=4.188316e-09  $ G-=7.622uS
Xrnl2_30_3 vout1_30 gate_l2 cnl2_3 0 reram_1t1r Tf0=3.300000e-09  $ G-=0.296uS
Xrnl2_30_4 vout1_30 gate_l2 cnl2_4 0 reram_1t1r Tf0=4.894443e-09  $ G-=99.273uS
Xrnl2_31_0 vout1_31 gate_l2 cnl2_0 0 reram_1t1r Tf0=3.300000e-09  $ G-=0.296uS
Xrnl2_31_1 vout1_31 gate_l2 cnl2_1 0 reram_1t1r Tf0=3.300000e-09  $ G-=0.296uS
Xrnl2_31_2 vout1_31 gate_l2 cnl2_2 0 reram_1t1r Tf0=4.099336e-09  $ G-=5.516uS
Xrnl2_31_3 vout1_31 gate_l2 cnl2_3 0 reram_1t1r Tf0=4.480693e-09  $ G-=22.062uS
Xrnl2_31_4 vout1_31 gate_l2 cnl2_4 0 reram_1t1r Tf0=3.300000e-09  $ G-=0.296uS
Xrnl2_32_0 vout1_32 gate_l2 cnl2_0 0 reram_1t1r Tf0=4.268459e-09  $ G-=10.200uS
Xrnl2_32_1 vout1_32 gate_l2 cnl2_1 0 reram_1t1r Tf0=3.300000e-09  $ G-=0.296uS
Xrnl2_32_2 vout1_32 gate_l2 cnl2_2 0 reram_1t1r Tf0=3.300000e-09  $ G-=0.296uS
Xrnl2_32_3 vout1_32 gate_l2 cnl2_3 0 reram_1t1r Tf0=4.518165e-09  $ G-=25.282uS
Xrnl2_32_4 vout1_32 gate_l2 cnl2_4 0 reram_1t1r Tf0=4.718135e-09  $ G-=52.300uS
Xrnl2_33_0 vout1_33 gate_l2 cnl2_0 0 reram_1t1r Tf0=4.533750e-09  $ G-=26.756uS
Xrnl2_33_1 vout1_33 gate_l2 cnl2_1 0 reram_1t1r Tf0=3.300000e-09  $ G-=0.296uS
Xrnl2_33_2 vout1_33 gate_l2 cnl2_2 0 reram_1t1r Tf0=3.300000e-09  $ G-=0.296uS
Xrnl2_33_3 vout1_33 gate_l2 cnl2_3 0 reram_1t1r Tf0=4.462461e-09  $ G-=20.648uS
Xrnl2_33_4 vout1_33 gate_l2 cnl2_4 0 reram_1t1r Tf0=3.300000e-09  $ G-=0.296uS
Xrnl2_34_0 vout1_34 gate_l2 cnl2_0 0 reram_1t1r Tf0=4.328522e-09  $ G-=12.689uS
Xrnl2_34_1 vout1_34 gate_l2 cnl2_1 0 reram_1t1r Tf0=3.960691e-09  $ G-=3.332uS
Xrnl2_34_2 vout1_34 gate_l2 cnl2_2 0 reram_1t1r Tf0=3.300000e-09  $ G-=0.296uS
Xrnl2_34_3 vout1_34 gate_l2 cnl2_3 0 reram_1t1r Tf0=3.300000e-09  $ G-=0.296uS
Xrnl2_34_4 vout1_34 gate_l2 cnl2_4 0 reram_1t1r Tf0=3.300000e-09  $ G-=0.296uS
Xrnl2_35_0 vout1_35 gate_l2 cnl2_0 0 reram_1t1r Tf0=3.300000e-09  $ G-=0.296uS
Xrnl2_35_1 vout1_35 gate_l2 cnl2_1 0 reram_1t1r Tf0=3.300000e-09  $ G-=0.296uS
Xrnl2_35_2 vout1_35 gate_l2 cnl2_2 0 reram_1t1r Tf0=4.510437e-09  $ G-=24.582uS
Xrnl2_35_3 vout1_35 gate_l2 cnl2_3 0 reram_1t1r Tf0=4.464673e-09  $ G-=20.814uS
Xrnl2_35_4 vout1_35 gate_l2 cnl2_4 0 reram_1t1r Tf0=3.300000e-09  $ G-=0.296uS
Xrnl2_36_0 vout1_36 gate_l2 cnl2_0 0 reram_1t1r Tf0=3.300000e-09  $ G-=0.296uS
Xrnl2_36_1 vout1_36 gate_l2 cnl2_1 0 reram_1t1r Tf0=4.453717e-09  $ G-=20.002uS
Xrnl2_36_2 vout1_36 gate_l2 cnl2_2 0 reram_1t1r Tf0=3.300000e-09  $ G-=0.296uS
Xrnl2_36_3 vout1_36 gate_l2 cnl2_3 0 reram_1t1r Tf0=3.300000e-09  $ G-=0.296uS
Xrnl2_36_4 vout1_36 gate_l2 cnl2_4 0 reram_1t1r Tf0=3.945782e-09  $ G-=3.156uS
Xrnl2_37_0 vout1_37 gate_l2 cnl2_0 0 reram_1t1r Tf0=3.300000e-09  $ G-=0.296uS
Xrnl2_37_1 vout1_37 gate_l2 cnl2_1 0 reram_1t1r Tf0=4.150465e-09  $ G-=6.642uS
Xrnl2_37_2 vout1_37 gate_l2 cnl2_2 0 reram_1t1r Tf0=3.300000e-09  $ G-=0.296uS
Xrnl2_37_3 vout1_37 gate_l2 cnl2_3 0 reram_1t1r Tf0=4.569090e-09  $ G-=30.423uS
Xrnl2_37_4 vout1_37 gate_l2 cnl2_4 0 reram_1t1r Tf0=3.819448e-09  $ G-=1.994uS
Xrnl2_38_0 vout1_38 gate_l2 cnl2_0 0 reram_1t1r Tf0=3.300000e-09  $ G-=0.296uS
Xrnl2_38_1 vout1_38 gate_l2 cnl2_1 0 reram_1t1r Tf0=3.300000e-09  $ G-=0.296uS
Xrnl2_38_2 vout1_38 gate_l2 cnl2_2 0 reram_1t1r Tf0=4.139285e-09  $ G-=6.378uS
Xrnl2_38_3 vout1_38 gate_l2 cnl2_3 0 reram_1t1r Tf0=3.819503e-09  $ G-=1.995uS
Xrnl2_38_4 vout1_38 gate_l2 cnl2_4 0 reram_1t1r Tf0=4.575339e-09  $ G-=31.122uS
Xrnl2_39_0 vout1_39 gate_l2 cnl2_0 0 reram_1t1r Tf0=3.300000e-09  $ G-=0.296uS
Xrnl2_39_1 vout1_39 gate_l2 cnl2_1 0 reram_1t1r Tf0=4.492100e-09  $ G-=22.996uS
Xrnl2_39_2 vout1_39 gate_l2 cnl2_2 0 reram_1t1r Tf0=4.366600e-09  $ G-=14.573uS
Xrnl2_39_3 vout1_39 gate_l2 cnl2_3 0 reram_1t1r Tf0=3.300000e-09  $ G-=0.296uS
Xrnl2_39_4 vout1_39 gate_l2 cnl2_4 0 reram_1t1r Tf0=4.064995e-09  $ G-=4.869uS
Xrnl2_40_0 vout1_40 gate_l2 cnl2_0 0 reram_1t1r Tf0=4.331208e-09  $ G-=12.813uS
Xrnl2_40_1 vout1_40 gate_l2 cnl2_1 0 reram_1t1r Tf0=3.300000e-09  $ G-=0.296uS
Xrnl2_40_2 vout1_40 gate_l2 cnl2_2 0 reram_1t1r Tf0=3.300000e-09  $ G-=0.296uS
Xrnl2_40_3 vout1_40 gate_l2 cnl2_3 0 reram_1t1r Tf0=3.300000e-09  $ G-=0.296uS
Xrnl2_40_4 vout1_40 gate_l2 cnl2_4 0 reram_1t1r Tf0=3.780858e-09  $ G-=1.733uS
Xrnl2_41_0 vout1_41 gate_l2 cnl2_0 0 reram_1t1r Tf0=3.300000e-09  $ G-=0.296uS
Xrnl2_41_1 vout1_41 gate_l2 cnl2_1 0 reram_1t1r Tf0=4.653455e-09  $ G-=41.342uS
Xrnl2_41_2 vout1_41 gate_l2 cnl2_2 0 reram_1t1r Tf0=4.424865e-09  $ G-=18.010uS
Xrnl2_41_3 vout1_41 gate_l2 cnl2_3 0 reram_1t1r Tf0=4.443378e-09  $ G-=19.264uS
Xrnl2_41_4 vout1_41 gate_l2 cnl2_4 0 reram_1t1r Tf0=3.300000e-09  $ G-=0.296uS
Xrnl2_42_0 vout1_42 gate_l2 cnl2_0 0 reram_1t1r Tf0=3.300000e-09  $ G-=0.296uS
Xrnl2_42_1 vout1_42 gate_l2 cnl2_1 0 reram_1t1r Tf0=3.300000e-09  $ G-=0.296uS
Xrnl2_42_2 vout1_42 gate_l2 cnl2_2 0 reram_1t1r Tf0=4.494287e-09  $ G-=23.180uS
Xrnl2_42_3 vout1_42 gate_l2 cnl2_3 0 reram_1t1r Tf0=3.643612e-09  $ G-=1.052uS
Xrnl2_42_4 vout1_42 gate_l2 cnl2_4 0 reram_1t1r Tf0=4.490182e-09  $ G-=22.837uS
Xrnl2_43_0 vout1_43 gate_l2 cnl2_0 0 reram_1t1r Tf0=3.300000e-09  $ G-=0.296uS
Xrnl2_43_1 vout1_43 gate_l2 cnl2_1 0 reram_1t1r Tf0=4.137907e-09  $ G-=6.346uS
Xrnl2_43_2 vout1_43 gate_l2 cnl2_2 0 reram_1t1r Tf0=4.243699e-09  $ G-=9.322uS
Xrnl2_43_3 vout1_43 gate_l2 cnl2_3 0 reram_1t1r Tf0=4.512350e-09  $ G-=24.753uS
Xrnl2_43_4 vout1_43 gate_l2 cnl2_4 0 reram_1t1r Tf0=3.300000e-09  $ G-=0.296uS
Xrnl2_44_0 vout1_44 gate_l2 cnl2_0 0 reram_1t1r Tf0=3.300000e-09  $ G-=0.296uS
Xrnl2_44_1 vout1_44 gate_l2 cnl2_1 0 reram_1t1r Tf0=3.309781e-09  $ G-=0.313uS
Xrnl2_44_2 vout1_44 gate_l2 cnl2_2 0 reram_1t1r Tf0=3.300000e-09  $ G-=0.296uS
Xrnl2_44_3 vout1_44 gate_l2 cnl2_3 0 reram_1t1r Tf0=4.353882e-09  $ G-=13.914uS
Xrnl2_44_4 vout1_44 gate_l2 cnl2_4 0 reram_1t1r Tf0=3.300000e-09  $ G-=0.296uS
Xrnl2_45_0 vout1_45 gate_l2 cnl2_0 0 reram_1t1r Tf0=4.296992e-09  $ G-=11.315uS
Xrnl2_45_1 vout1_45 gate_l2 cnl2_1 0 reram_1t1r Tf0=3.300000e-09  $ G-=0.296uS
Xrnl2_45_2 vout1_45 gate_l2 cnl2_2 0 reram_1t1r Tf0=3.300000e-09  $ G-=0.296uS
Xrnl2_45_3 vout1_45 gate_l2 cnl2_3 0 reram_1t1r Tf0=4.391479e-09  $ G-=15.952uS
Xrnl2_45_4 vout1_45 gate_l2 cnl2_4 0 reram_1t1r Tf0=3.300000e-09  $ G-=0.296uS
Xrnl2_46_0 vout1_46 gate_l2 cnl2_0 0 reram_1t1r Tf0=3.300000e-09  $ G-=0.296uS
Xrnl2_46_1 vout1_46 gate_l2 cnl2_1 0 reram_1t1r Tf0=3.300000e-09  $ G-=0.296uS
Xrnl2_46_2 vout1_46 gate_l2 cnl2_2 0 reram_1t1r Tf0=3.979385e-09  $ G-=3.567uS
Xrnl2_46_3 vout1_46 gate_l2 cnl2_3 0 reram_1t1r Tf0=4.458391e-09  $ G-=20.344uS
Xrnl2_46_4 vout1_46 gate_l2 cnl2_4 0 reram_1t1r Tf0=4.400261e-09  $ G-=16.469uS
Xrnl2_47_0 vout1_47 gate_l2 cnl2_0 0 reram_1t1r Tf0=3.300000e-09  $ G-=0.296uS
Xrnl2_47_1 vout1_47 gate_l2 cnl2_1 0 reram_1t1r Tf0=4.519234e-09  $ G-=25.380uS
Xrnl2_47_2 vout1_47 gate_l2 cnl2_2 0 reram_1t1r Tf0=3.300000e-09  $ G-=0.296uS
Xrnl2_47_3 vout1_47 gate_l2 cnl2_3 0 reram_1t1r Tf0=3.300000e-09  $ G-=0.296uS
Xrnl2_47_4 vout1_47 gate_l2 cnl2_4 0 reram_1t1r Tf0=4.061611e-09  $ G-=4.809uS
Xrnl2_48_0 vout1_48 gate_l2 cnl2_0 0 reram_1t1r Tf0=3.300000e-09  $ G-=0.296uS
Xrnl2_48_1 vout1_48 gate_l2 cnl2_1 0 reram_1t1r Tf0=3.973745e-09  $ G-=3.494uS
Xrnl2_48_2 vout1_48 gate_l2 cnl2_2 0 reram_1t1r Tf0=4.364014e-09  $ G-=14.436uS
Xrnl2_48_3 vout1_48 gate_l2 cnl2_3 0 reram_1t1r Tf0=3.300000e-09  $ G-=0.296uS
Xrnl2_48_4 vout1_48 gate_l2 cnl2_4 0 reram_1t1r Tf0=3.300000e-09  $ G-=0.296uS
Xrnl2_49_0 vout1_49 gate_l2 cnl2_0 0 reram_1t1r Tf0=4.313651e-09  $ G-=12.021uS
Xrnl2_49_1 vout1_49 gate_l2 cnl2_1 0 reram_1t1r Tf0=3.300000e-09  $ G-=0.296uS
Xrnl2_49_2 vout1_49 gate_l2 cnl2_2 0 reram_1t1r Tf0=4.059337e-09  $ G-=4.769uS
Xrnl2_49_3 vout1_49 gate_l2 cnl2_3 0 reram_1t1r Tf0=3.300000e-09  $ G-=0.296uS
Xrnl2_49_4 vout1_49 gate_l2 cnl2_4 0 reram_1t1r Tf0=3.300000e-09  $ G-=0.296uS
Xrnl2_50_0 vout1_50 gate_l2 cnl2_0 0 reram_1t1r Tf0=4.020314e-09  $ G-=4.139uS
Xrnl2_50_1 vout1_50 gate_l2 cnl2_1 0 reram_1t1r Tf0=4.469327e-09  $ G-=21.169uS
Xrnl2_50_2 vout1_50 gate_l2 cnl2_2 0 reram_1t1r Tf0=3.300000e-09  $ G-=0.296uS
Xrnl2_50_3 vout1_50 gate_l2 cnl2_3 0 reram_1t1r Tf0=4.293757e-09  $ G-=11.183uS
Xrnl2_50_4 vout1_50 gate_l2 cnl2_4 0 reram_1t1r Tf0=3.300000e-09  $ G-=0.296uS
Xrnl2_51_0 vout1_51 gate_l2 cnl2_0 0 reram_1t1r Tf0=3.300000e-09  $ G-=0.296uS
Xrnl2_51_1 vout1_51 gate_l2 cnl2_1 0 reram_1t1r Tf0=4.666754e-09  $ G-=43.389uS
Xrnl2_51_2 vout1_51 gate_l2 cnl2_2 0 reram_1t1r Tf0=4.548991e-09  $ G-=28.280uS
Xrnl2_51_3 vout1_51 gate_l2 cnl2_3 0 reram_1t1r Tf0=3.850375e-09  $ G-=2.231uS
Xrnl2_51_4 vout1_51 gate_l2 cnl2_4 0 reram_1t1r Tf0=3.300000e-09  $ G-=0.296uS
Xrnl2_52_0 vout1_52 gate_l2 cnl2_0 0 reram_1t1r Tf0=3.300000e-09  $ G-=0.296uS
Xrnl2_52_1 vout1_52 gate_l2 cnl2_1 0 reram_1t1r Tf0=3.300000e-09  $ G-=0.296uS
Xrnl2_52_2 vout1_52 gate_l2 cnl2_2 0 reram_1t1r Tf0=4.479021e-09  $ G-=21.929uS
Xrnl2_52_3 vout1_52 gate_l2 cnl2_3 0 reram_1t1r Tf0=3.300000e-09  $ G-=0.296uS
Xrnl2_52_4 vout1_52 gate_l2 cnl2_4 0 reram_1t1r Tf0=4.138717e-09  $ G-=6.365uS
Xrnl2_53_0 vout1_53 gate_l2 cnl2_0 0 reram_1t1r Tf0=4.198831e-09  $ G-=7.919uS
Xrnl2_53_1 vout1_53 gate_l2 cnl2_1 0 reram_1t1r Tf0=4.564390e-09  $ G-=29.908uS
Xrnl2_53_2 vout1_53 gate_l2 cnl2_2 0 reram_1t1r Tf0=3.300000e-09  $ G-=0.296uS
Xrnl2_53_3 vout1_53 gate_l2 cnl2_3 0 reram_1t1r Tf0=3.300000e-09  $ G-=0.296uS
Xrnl2_53_4 vout1_53 gate_l2 cnl2_4 0 reram_1t1r Tf0=3.300000e-09  $ G-=0.296uS
Xrnl2_54_0 vout1_54 gate_l2 cnl2_0 0 reram_1t1r Tf0=4.385072e-09  $ G-=15.585uS
Xrnl2_54_1 vout1_54 gate_l2 cnl2_1 0 reram_1t1r Tf0=3.300000e-09  $ G-=0.296uS
Xrnl2_54_2 vout1_54 gate_l2 cnl2_2 0 reram_1t1r Tf0=3.300000e-09  $ G-=0.296uS
Xrnl2_54_3 vout1_54 gate_l2 cnl2_3 0 reram_1t1r Tf0=3.300000e-09  $ G-=0.296uS
Xrnl2_54_4 vout1_54 gate_l2 cnl2_4 0 reram_1t1r Tf0=4.204785e-09  $ G-=8.093uS
Xrnl2_55_0 vout1_55 gate_l2 cnl2_0 0 reram_1t1r Tf0=3.300000e-09  $ G-=0.296uS
Xrnl2_55_1 vout1_55 gate_l2 cnl2_1 0 reram_1t1r Tf0=4.595740e-09  $ G-=33.518uS
Xrnl2_55_2 vout1_55 gate_l2 cnl2_2 0 reram_1t1r Tf0=4.422894e-09  $ G-=17.882uS
Xrnl2_55_3 vout1_55 gate_l2 cnl2_3 0 reram_1t1r Tf0=3.595095e-09  $ G-=0.882uS
Xrnl2_55_4 vout1_55 gate_l2 cnl2_4 0 reram_1t1r Tf0=3.300000e-09  $ G-=0.296uS
Xrnl2_56_0 vout1_56 gate_l2 cnl2_0 0 reram_1t1r Tf0=4.369777e-09  $ G-=14.742uS
Xrnl2_56_1 vout1_56 gate_l2 cnl2_1 0 reram_1t1r Tf0=3.300000e-09  $ G-=0.296uS
Xrnl2_56_2 vout1_56 gate_l2 cnl2_2 0 reram_1t1r Tf0=3.300000e-09  $ G-=0.296uS
Xrnl2_56_3 vout1_56 gate_l2 cnl2_3 0 reram_1t1r Tf0=4.486971e-09  $ G-=22.572uS
Xrnl2_56_4 vout1_56 gate_l2 cnl2_4 0 reram_1t1r Tf0=3.300000e-09  $ G-=0.296uS
Xrnl2_57_0 vout1_57 gate_l2 cnl2_0 0 reram_1t1r Tf0=4.218274e-09  $ G-=8.499uS
Xrnl2_57_1 vout1_57 gate_l2 cnl2_1 0 reram_1t1r Tf0=4.152311e-09  $ G-=6.687uS
Xrnl2_57_2 vout1_57 gate_l2 cnl2_2 0 reram_1t1r Tf0=3.300000e-09  $ G-=0.296uS
Xrnl2_57_3 vout1_57 gate_l2 cnl2_3 0 reram_1t1r Tf0=3.300000e-09  $ G-=0.296uS
Xrnl2_57_4 vout1_57 gate_l2 cnl2_4 0 reram_1t1r Tf0=3.300000e-09  $ G-=0.296uS
Xrnl2_58_0 vout1_58 gate_l2 cnl2_0 0 reram_1t1r Tf0=4.187068e-09  $ G-=7.588uS
Xrnl2_58_1 vout1_58 gate_l2 cnl2_1 0 reram_1t1r Tf0=4.396881e-09  $ G-=16.268uS
Xrnl2_58_2 vout1_58 gate_l2 cnl2_2 0 reram_1t1r Tf0=3.300000e-09  $ G-=0.296uS
Xrnl2_58_3 vout1_58 gate_l2 cnl2_3 0 reram_1t1r Tf0=3.300000e-09  $ G-=0.296uS
Xrnl2_58_4 vout1_58 gate_l2 cnl2_4 0 reram_1t1r Tf0=3.917714e-09  $ G-=2.850uS
Xrnl2_59_0 vout1_59 gate_l2 cnl2_0 0 reram_1t1r Tf0=3.300000e-09  $ G-=0.296uS
Xrnl2_59_1 vout1_59 gate_l2 cnl2_1 0 reram_1t1r Tf0=3.300000e-09  $ G-=0.296uS
Xrnl2_59_2 vout1_59 gate_l2 cnl2_2 0 reram_1t1r Tf0=3.925533e-09  $ G-=2.932uS
Xrnl2_59_3 vout1_59 gate_l2 cnl2_3 0 reram_1t1r Tf0=4.612574e-09  $ G-=35.633uS
Xrnl2_59_4 vout1_59 gate_l2 cnl2_4 0 reram_1t1r Tf0=4.616100e-09  $ G-=36.093uS
Xrnl2_60_0 vout1_60 gate_l2 cnl2_0 0 reram_1t1r Tf0=3.300000e-09  $ G-=0.296uS
Xrnl2_60_1 vout1_60 gate_l2 cnl2_1 0 reram_1t1r Tf0=3.797835e-09  $ G-=1.843uS
Xrnl2_60_2 vout1_60 gate_l2 cnl2_2 0 reram_1t1r Tf0=4.545508e-09  $ G-=27.924uS
Xrnl2_60_3 vout1_60 gate_l2 cnl2_3 0 reram_1t1r Tf0=3.300000e-09  $ G-=0.296uS
Xrnl2_60_4 vout1_60 gate_l2 cnl2_4 0 reram_1t1r Tf0=3.597128e-09  $ G-=0.889uS
Xrnl2_61_0 vout1_61 gate_l2 cnl2_0 0 reram_1t1r Tf0=3.300000e-09  $ G-=0.296uS
Xrnl2_61_1 vout1_61 gate_l2 cnl2_1 0 reram_1t1r Tf0=4.392891e-09  $ G-=16.034uS
Xrnl2_61_2 vout1_61 gate_l2 cnl2_2 0 reram_1t1r Tf0=4.304819e-09  $ G-=11.641uS
Xrnl2_61_3 vout1_61 gate_l2 cnl2_3 0 reram_1t1r Tf0=3.300000e-09  $ G-=0.296uS
Xrnl2_61_4 vout1_61 gate_l2 cnl2_4 0 reram_1t1r Tf0=4.011101e-09  $ G-=4.002uS
Xrnl2_62_0 vout1_62 gate_l2 cnl2_0 0 reram_1t1r Tf0=3.300000e-09  $ G-=0.296uS
Xrnl2_62_1 vout1_62 gate_l2 cnl2_1 0 reram_1t1r Tf0=4.476628e-09  $ G-=21.739uS
Xrnl2_62_2 vout1_62 gate_l2 cnl2_2 0 reram_1t1r Tf0=4.209985e-09  $ G-=8.247uS
Xrnl2_62_3 vout1_62 gate_l2 cnl2_3 0 reram_1t1r Tf0=4.379740e-09  $ G-=15.286uS
Xrnl2_62_4 vout1_62 gate_l2 cnl2_4 0 reram_1t1r Tf0=3.300000e-09  $ G-=0.296uS
Xrnl2_63_0 vout1_63 gate_l2 cnl2_0 0 reram_1t1r Tf0=3.300000e-09  $ G-=0.296uS
Xrnl2_63_1 vout1_63 gate_l2 cnl2_1 0 reram_1t1r Tf0=3.300000e-09  $ G-=0.296uS
Xrnl2_63_2 vout1_63 gate_l2 cnl2_2 0 reram_1t1r Tf0=4.477118e-09  $ G-=21.778uS
Xrnl2_63_3 vout1_63 gate_l2 cnl2_3 0 reram_1t1r Tf0=3.300000e-09  $ G-=0.296uS
Xrnl2_63_4 vout1_63 gate_l2 cnl2_4 0 reram_1t1r Tf0=4.458825e-09  $ G-=20.377uS

* ===== L2 COLUMN READOUT (5 col_readout instances) =====
Xcolrd2_0 cpl2_0 cnl2_0 nwta_0 vdd 0 col_readout
Xcolrd2_1 cpl2_1 cnl2_1 nwta_1 vdd 0 col_readout
Xcolrd2_2 cpl2_2 cnl2_2 nwta_2 vdd 0 col_readout
Xcolrd2_3 cpl2_3 cnl2_3 nwta_3 vdd 0 col_readout
Xcolrd2_4 cpl2_4 cnl2_4 nwta_4 vdd 0 col_readout

* ===== L2->WTA BIAS INJECTION (5 channels) =====

* --- Class N: b2=+0.0396, I_bias=+8864972930.182uA ---
Ibr2_0 pbr2_0 0 8.864973e+03
Xbr2_0 pbr2_0 pbr2_0 vdd vdd sky130_fd_pr__pfet_01v8 W=2.0u L=0.5u
Xbm2_0 nwta_0 pbr2_0 vdd vdd sky130_fd_pr__pfet_01v8 W=2.0u L=0.5u

* --- Class S: b2=+0.2212, I_bias=+49536499697.815uA ---
Ibr2_1 pbr2_1 0 4.953650e+04
Xbr2_1 pbr2_1 pbr2_1 vdd vdd sky130_fd_pr__pfet_01v8 W=2.0u L=0.5u
Xbm2_1 nwta_1 pbr2_1 vdd vdd sky130_fd_pr__pfet_01v8 W=2.0u L=0.5u

* --- Class V: b2=-0.3914, I_bias=-87647963852.453uA ---
Ibr2_2 vdd nbr2_2 8.764796e+04
Xbr2_2 nbr2_2 nbr2_2 0 0 sky130_fd_pr__nfet_01v8 W=2.0u L=0.5u
Xbm2_2 nwta_2 nbr2_2 0 0 sky130_fd_pr__nfet_01v8 W=2.0u L=0.5u

* --- Class F: b2=-0.4507, I_bias=-100943744144.560uA ---
Ibr2_3 vdd nbr2_3 1.009437e+05
Xbr2_3 nbr2_3 nbr2_3 0 0 sky130_fd_pr__nfet_01v8 W=2.0u L=0.5u
Xbm2_3 nwta_3 nbr2_3 0 0 sky130_fd_pr__nfet_01v8 W=2.0u L=0.5u

* --- Class Q: b2=-0.8405, I_bias=-188244319451.298uA ---
Ibr2_4 vdd nbr2_4 1.882443e+05
Xbr2_4 nbr2_4 nbr2_4 0 0 sky130_fd_pr__nfet_01v8 W=2.0u L=0.5u
Xbm2_4 nwta_4 nbr2_4 0 0 sky130_fd_pr__nfet_01v8 W=2.0u L=0.5u

* ===== WINNER-TAKE-ALL: PFET-Input Max Detector =====
* Winner = LOWEST output (argmin).
* NFET bias
Ibias_wta vdd nbias_wta 10u
Xbias_wta nbias_wta nbias_wta 0 0 sky130_fd_pr__nfet_01v8 W=2.0u L=0.5u
* PFET bias (tail current ~10uA)
Ibias_wta_p pbias_wta 0 10u
Xbias_wta_p pbias_wta pbias_wta vdd vdd sky130_fd_pr__pfet_01v8 W=4.0u L=0.5u

.include "wta_5class_fixed.spice"
XWTA nwta_0 nwta_1 nwta_2 nwta_3 nwta_4 out0 out1 out2 out3 out4 vdd 0 nbias_wta pbias_wta wta_5class

* ===== ANALYSIS =====
.op

.control
run
print v(out0)
print v(out1)
print v(out2)
print v(out3)
print v(out4)
quit
.endc

.end
