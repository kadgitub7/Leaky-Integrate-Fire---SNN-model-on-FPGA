* ============================================================
* Phase 1A: Detection Logic Test
* ============================================================
* Tests noise gate + threshold comp + AND + hold
* with Python-computed env_fast and env_avg as inputs.
*
* Record 100, 10.0s, 13 Python detections
* Python det 1: t=0.0222s
* Python det 2: t=1.0278s
* Python det 3: t=1.8417s
* Python det 4: t=2.6306s
* Python det 5: t=3.4194s
* Python det 6: t=4.2083s
* Python det 7: t=5.0250s
* Python det 8: t=5.6806s
* Python det 9: t=6.6750s
* Python det 10: t=7.5167s
* Python det 11: t=8.3278s
* Python det 12: t=9.1194s
* Python det 13: t=9.8889s
* ============================================================

.lib C:/Users/kadhi/OneDrive/Desktop/amux/verilogLearning/Leaky-Integrate-Fire---SNN-model-on-FPGA/experiments/frontend_optimization/ngspice_frontend/sky130_minimal.lib.spice tt

.include C:/Users/kadhi/OneDrive/Desktop/amux/verilogLearning/Leaky-Integrate-Fire---SNN-model-on-FPGA/experiments/frontend_optimization/complete_frontend_v9b/inverter.spice
.include C:/Users/kadhi/OneDrive/Desktop/amux/verilogLearning/Leaky-Integrate-Fire---SNN-model-on-FPGA/experiments/frontend_optimization/complete_frontend_v9b/rpeak_hold.spice
.include C:/Users/kadhi/OneDrive/Desktop/amux/verilogLearning/Leaky-Integrate-Fire---SNN-model-on-FPGA/experiments/frontend_optimization/complete_frontend_v9b/rpeak_detector_v2.spice

.option scale=1.0u method=gear reltol=0.01 gmin=1e-15

Vdd vdd 0 0.9
Vss vss 0 0.0
Vbias vbias 0 0.300

* ---- Python-computed envelope signals as PWL ----
Vef env_fast 0 PWL(
+ 0.0000000 0.301919 0.0027778 0.302423 0.0055556 0.302914 0.0083333 0.303412
+ 0.0111111 0.303897 0.0138889 0.304383 0.0166667 0.304856 0.0194444 0.304894
+ 0.0222222 0.304916 0.0250000 0.304936 0.0277778 0.304961 0.0305556 0.304995
+ 0.0333333 0.305047 0.0361111 0.305076 0.0388889 0.305105 0.0416667 0.305117
+ 0.0444444 0.305130 0.0472222 0.305113 0.0500000 0.305075 0.0527778 0.305010
+ 0.0555556 0.304918 0.0583333 0.304802 0.0611111 0.304852 0.0638889 0.305086
+ 0.0666667 0.305472 0.0694444 0.305968 0.0722222 0.306525 0.0750000 0.307068
+ 0.0777778 0.307595 0.0805556 0.308108 0.0833333 0.308607 0.0861111 0.309092
+ 0.0888889 0.309382 0.0916667 0.309479 0.0944444 0.309415 0.0972222 0.309233
+ 0.1000000 0.308980 0.1027778 0.308734 0.1055556 0.308495 0.1083333 0.308262
+ 0.1111111 0.308036 0.1138889 0.307815 0.1166667 0.307601 0.1194444 0.307393
+ 0.1222222 0.307307 0.1250000 0.307690 0.1277778 0.308587 0.1305556 0.310021
+ 0.1333333 0.311983 0.1361111 0.314434 0.1388889 0.317298 0.1416667 0.320464
+ 0.1444444 0.323784 0.1472222 0.327014 0.1500000 0.330038 0.1527778 0.332512
+ 0.1555556 0.334394 0.1583333 0.335664 0.1611111 0.336331 0.1638889 0.336437
+ 0.1666667 0.336060 0.1694444 0.336975 0.1722222 0.339529 0.1750000 0.343882
+ 0.1777778 0.349833 0.1805556 0.357057 0.1833333 0.365109 0.1861111 0.373441
+ 0.1888889 0.381545 0.1916667 0.389427 0.1944444 0.397093 0.1972222 0.402887
+ 0.2000000 0.406618 0.2027778 0.408377 0.2055556 0.408371 0.2083333 0.406929
+ 0.2111111 0.404501 0.2138889 0.402037 0.2166667 0.401047 0.2194444 0.400879
+ 0.2222222 0.400716 0.2250000 0.400557 0.2277778 0.400403 0.2305556 0.400252
+ 0.2333333 0.400106 0.2361111 0.399964 0.2388889 0.399826 0.2416667 0.399292
+ 0.2444444 0.397367 0.2472222 0.394700 0.2500000 0.392105 0.2527778 0.389582
+ 0.2555556 0.387128 0.2583333 0.384741 0.2611111 0.382420 0.2638889 0.380162
+ 0.2666667 0.377966 0.2694444 0.375830 0.2722222 0.373752 0.2750000 0.371732
+ 0.2777778 0.369767 0.2805556 0.367855 0.2833333 0.365996 0.2861111 0.364188
+ 0.2888889 0.362430 0.2916667 0.360720 0.2944444 0.359056 0.2972222 0.357438
+ 0.3000000 0.355865 0.3027778 0.354334 0.3055556 0.352846 0.3083333 0.351398
+ 0.3111111 0.349990 0.3138889 0.348620 0.3166667 0.347289 0.3194444 0.345993
+ 0.3222222 0.344733 0.3250000 0.343508 0.3277778 0.342316 0.3305556 0.341156
+ 0.3333333 0.340029 0.3361111 0.338932 0.3388889 0.337866 0.3416667 0.336828
+ 0.3444444 0.335819 0.3472222 0.334838 0.3500000 0.333884 0.3527778 0.332955
+ 0.3555556 0.332053 0.3583333 0.331175 0.3611111 0.330320 0.3638889 0.329490
+ 0.3666667 0.328682 0.3694444 0.327896 0.3722222 0.327132 0.3750000 0.326389
+ 0.3777778 0.325666 0.3805556 0.324963 0.3833333 0.324279 0.3861111 0.323614
+ 0.3888889 0.322967 0.3916667 0.322338 0.3944444 0.321726 0.3972222 0.321130
+ 0.4000000 0.320552 0.4027778 0.319988 0.4055556 0.319441 0.4083333 0.318908
+ 0.4111111 0.318390 0.4138889 0.317886 0.4166667 0.317396 0.4194444 0.316920
+ 0.4222222 0.316456 0.4250000 0.316006 0.4277778 0.315567 0.4305556 0.315141
+ 0.4333333 0.314726 0.4361111 0.314322 0.4388889 0.313930 0.4416667 0.313548
+ 0.4444444 0.313177 0.4472222 0.312816 0.4500000 0.312465 0.4527778 0.312124
+ 0.4555556 0.311791 0.4583333 0.311468 0.4611111 0.311154 0.4638889 0.310849
+ 0.4666667 0.310551 0.4694444 0.310262 0.4722222 0.309981 0.4750000 0.309708
+ 0.4777778 0.309442 0.4805556 0.309183 0.4833333 0.308932 0.4861111 0.308687
+ 0.4888889 0.308449 0.4916667 0.308218 0.4944444 0.307992 0.4972222 0.307773
+ 0.5000000 0.307560 0.5027778 0.307353 0.5055556 0.307152 0.5083333 0.306956
+ 0.5111111 0.306765 0.5138889 0.306580 0.5166667 0.306420 0.5194444 0.306317
+ 0.5222222 0.306259 0.5250000 0.306236 0.5277778 0.306234 0.5305556 0.306232
+ 0.5333333 0.306230 0.5361111 0.306228 0.5388889 0.306226 0.5416667 0.306224
+ 0.5444444 0.306201 0.5472222 0.306128 0.5500000 0.306013 0.5527778 0.305869
+ 0.5555556 0.305708 0.5583333 0.305552 0.5611111 0.305399 0.5638889 0.305252
+ 0.5666667 0.305108 0.5694444 0.304968 0.5722222 0.304832 0.5750000 0.304734
+ 0.5777778 0.304686 0.5805556 0.304676 0.5833333 0.304691 0.5861111 0.304723
+ 0.5888889 0.304753 0.5916667 0.304783 0.5944444 0.304811 0.5972222 0.304839
+ 0.6000000 0.304867 0.6027778 0.304858 0.6055556 0.304803 0.6083333 0.304714
+ 0.6111111 0.304601 0.6138889 0.304475 0.6166667 0.304352 0.6194444 0.304233
+ 0.6222222 0.304117 0.6250000 0.304004 0.6277778 0.303894 0.6305556 0.303788
+ 0.6333333 0.303684 0.6361111 0.303583 0.6388889 0.303485 0.6416667 0.303389
+ 0.6444444 0.303297 0.6472222 0.303206 0.6500000 0.303118 0.6527778 0.303033
+ 0.6555556 0.302950 0.6583333 0.302869 0.6611111 0.302790 0.6638889 0.302714
+ 0.6666667 0.302640 0.6694444 0.302567 0.6722222 0.302497 0.6750000 0.302429
+ 0.6777778 0.302362 0.6805556 0.302310 0.6833333 0.302288 0.6861111 0.302286
+ 0.6888889 0.302293 0.6916667 0.302299 0.6944444 0.302305 0.6972222 0.302311
+ 0.7000000 0.302316 0.7027778 0.302322 0.7055556 0.302327 0.7083333 0.302320
+ 0.7111111 0.302284 0.7138889 0.302229 0.7166667 0.302185 0.7194444 0.302186
+ 0.7222222 0.302226 0.7250000 0.302297 0.7277778 0.302392 0.7305556 0.302504
+ 0.7333333 0.302623 0.7361111 0.302739 0.7388889 0.302852 0.7416667 0.302962
+ 0.7444444 0.303052 0.7472222 0.303095 0.7500000 0.303099 0.7527778 0.303070
+ 0.7555556 0.303016 0.7583333 0.302944 0.7611111 0.302863 0.7638889 0.302785
+ 0.7666667 0.302708 0.7694444 0.302634 0.7722222 0.302562 0.7750000 0.302504
+ 0.7777778 0.302479 0.7805556 0.302485 0.7833333 0.302512 0.7861111 0.302549
+ 0.7888889 0.302585 0.7916667 0.302620 0.7944444 0.302655 0.7972222 0.302688
+ 0.8000000 0.302720 0.8027778 0.302739 0.8055556 0.302726 0.8083333 0.302794
+ 0.8111111 0.303002 0.8138889 0.303362 0.8166667 0.303882 0.8194444 0.304554
+ 0.8222222 0.305364 0.8250000 0.306294 0.8277778 0.307320 0.8305556 0.308414
+ 0.8333333 0.309546 0.8361111 0.310536 0.8388889 0.311336 0.8416667 0.311945
+ 0.8444444 0.312368 0.8472222 0.312613 0.8500000 0.312696 0.8527778 0.312633
+ 0.8555556 0.312451 0.8583333 0.312177 0.8611111 0.311843 0.8638889 0.311519
+ 0.8666667 0.311203 0.8694444 0.310896 0.8722222 0.310598 0.8750000 0.310308
+ 0.8777778 0.310177 0.8805556 0.310242 0.8833333 0.310473 0.8861111 0.310828
+ 0.8888889 0.311254 0.8916667 0.311668 0.8944444 0.312071 0.8972222 0.312463
+ 0.9000000 0.312844 0.9027778 0.313215 0.9055556 0.313423 0.9083333 0.313434
+ 0.9111111 0.313277 0.9138889 0.312994 0.9166667 0.312638 0.9194444 0.312292
+ 0.9222222 0.311955 0.9250000 0.311628 0.9277778 0.311309 0.9305556 0.310999
+ 0.9333333 0.310698 0.9361111 0.310578 0.9388889 0.310983 0.9416667 0.311968
+ 0.9444444 0.313561 0.9472222 0.315757 0.9500000 0.318513 0.9527778 0.321742
+ 0.9555556 0.325314 0.9583333 0.329054 0.9611111 0.332691 0.9638889 0.336056
+ 0.9666667 0.338806 0.9694444 0.340890 0.9722222 0.342283 0.9750000 0.342990
+ 0.9777778 0.343058 0.9805556 0.342719 0.9833333 0.344239 0.9861111 0.347821
+ 0.9888889 0.353640 0.9916667 0.361454 0.9944444 0.370872 0.9972222 0.381361
+ 1.0000000 0.392264 1.0027778 0.402869 1.0055556 0.413182 1.0083333 0.423070
+ 1.0111111 0.430407 1.0138889 0.435172 1.0166667 0.437472 1.0194444 0.437554
+ 1.0222222 0.435816 1.0250000 0.432796 1.0277778 0.429158 1.0305556 0.427621
+ 1.0333333 0.427572 1.0361111 0.428237 1.0388889 0.428883 1.0416667 0.429512
+ 1.0444444 0.430124 1.0472222 0.430719 1.0500000 0.431297 1.0527778 0.431860
+ 1.0555556 0.432407 1.0583333 0.430939 1.0611111 0.428063 1.0638889 0.424555
+ 1.0666667 0.421143 1.0694444 0.417824 1.0722222 0.414596 1.0750000 0.411457
+ 1.0777778 0.408403 1.0805556 0.405434 1.0833333 0.402545 1.0861111 0.399736
+ 1.0888889 0.397004 1.0916667 0.394346 1.0944444 0.391761 1.0972222 0.389248
+ 1.1000000 0.386803 1.1027778 0.384425 1.1055556 0.382112 1.1083333 0.379862
+ 1.1111111 0.377674 1.1138889 0.375546 1.1166667 0.373477 1.1194444 0.371464
+ 1.1222222 0.369506 1.1250000 0.367602 1.1277778 0.365750 1.1305556 0.363949
+ 1.1333333 0.362197 1.1361111 0.360493 1.1388889 0.358836 1.1416667 0.357224
+ 1.1444444 0.355656 1.1472222 0.354131 1.1500000 0.352648 1.1527778 0.351206
+ 1.1555556 0.349803 1.1583333 0.348439 1.1611111 0.347112 1.1638889 0.345821
+ 1.1666667 0.344566 1.1694444 0.343345 1.1722222 0.342158 1.1750000 0.341003
+ 1.1777778 0.339879 1.1805556 0.338787 1.1833333 0.337724 1.1861111 0.336691
+ 1.1888889 0.335686 1.1916667 0.334708 1.1944444 0.333757 1.1972222 0.332832
+ 1.2000000 0.331933 1.2027778 0.331058 1.2055556 0.330207 1.2083333 0.329380
+ 1.2111111 0.328575 1.2138889 0.327792 1.2166667 0.327031 1.2194444 0.326290
+ 1.2222222 0.325570 1.2250000 0.324869 1.2277778 0.324188 1.2305556 0.323525
+ 1.2333333 0.322881 1.2361111 0.322254 1.2388889 0.321644 1.2416667 0.321051
+ 1.2444444 0.320475 1.2472222 0.319914 1.2500000 0.319368 1.2527778 0.318838
+ 1.2555556 0.318322 1.2583333 0.317820 1.2611111 0.317331 1.2638889 0.316857
+ 1.2666667 0.316395 1.2694444 0.315946 1.2722222 0.315509 1.2750000 0.315084
+ 1.2777778 0.314671 1.2805556 0.314269 1.2833333 0.313878 1.2861111 0.313498
+ 1.2888889 0.313128 1.2916667 0.312768 1.2944444 0.312419 1.2972222 0.312078
+ 1.3000000 0.311747 1.3027778 0.311426 1.3055556 0.311113 1.3083333 0.310808
+ 1.3111111 0.310512 1.3138889 0.310224 1.3166667 0.310071 1.3194444 0.310065
+ 1.3222222 0.310172 1.3250000 0.310357 1.3277778 0.310577 1.3305556 0.310792
+ 1.3333333 0.311001 1.3361111 0.311204 1.3388889 0.311401 1.3416667 0.311593
+ 1.3444444 0.311653 1.3472222 0.311569 1.3500000 0.311373 1.3527778 0.311103
+ 1.3555556 0.310799 1.3583333 0.310503 1.3611111 0.310215 1.3638889 0.309935
+ 1.3666667 0.309663 1.3694444 0.309398 1.3722222 0.309141 1.3750000 0.308890
+ 1.3777778 0.308647 1.3805556 0.308410 1.3833333 0.308180 1.3861111 0.307955
+ 1.3888889 0.307738 1.3916667 0.307526 1.3944444 0.307319 1.3972222 0.307119
+ 1.4000000 0.306924 1.4027778 0.306734 1.4055556 0.306550 1.4083333 0.306370
+ 1.4111111 0.306196 1.4138889 0.306026 1.4166667 0.305861 1.4194444 0.305700
+ 1.4222222 0.305544 1.4250000 0.305392 1.4277778 0.305245 1.4305556 0.305101
+ 1.4333333 0.304961 1.4361111 0.304825 1.4388889 0.304693 1.4416667 0.304564
+ 1.4444444 0.304439 1.4472222 0.304318 1.4500000 0.304200 1.4527778 0.304084
+ 1.4555556 0.303973 1.4583333 0.303864 1.4611111 0.303758 1.4638889 0.303655
+ 1.4666667 0.303555 1.4694444 0.303457 1.4722222 0.303363 1.4750000 0.303271
+ 1.4777778 0.303181 1.4805556 0.303094 1.4833333 0.303009 1.4861111 0.302927
+ 1.4888889 0.302872 1.4916667 0.302845 1.4944444 0.302836 1.4972222 0.302826
+ 1.5000000 0.302817 1.5027778 0.302809 1.5055556 0.302800 1.5083333 0.302792
+ 1.5111111 0.302784 1.5138889 0.302776 1.5166667 0.302743 1.5194444 0.302684
+ 1.5222222 0.302610 1.5250000 0.302539 1.5277778 0.302469 1.5305556 0.302402
+ 1.5333333 0.302336 1.5361111 0.302272 1.5388889 0.302210 1.5416667 0.302149
+ 1.5444444 0.302090 1.5472222 0.302033 1.5500000 0.301977 1.5527778 0.301923
+ 1.5555556 0.301870 1.5583333 0.301848 1.5611111 0.301864 1.5638889 0.301923
+ 1.5666667 0.302027 1.5694444 0.302174 1.5722222 0.302364 1.5750000 0.302593
+ 1.5777778 0.302859 1.5805556 0.303157 1.5833333 0.303480 1.5861111 0.303791
+ 1.5888889 0.304071 1.5916667 0.304301 1.5944444 0.304478 1.5972222 0.304604
+ 1.6000000 0.304680 1.6027778 0.304709 1.6055556 0.304695 1.6083333 0.304641
+ 1.6111111 0.304556 1.6138889 0.304448 1.6166667 0.304326 1.6194444 0.304207
+ 1.6222222 0.304202 1.6250000 0.304360 1.6277778 0.304672 1.6305556 0.305124
+ 1.6333333 0.305696 1.6361111 0.306367 1.6388889 0.307113 1.6416667 0.307911
+ 1.6444444 0.308734 1.6472222 0.309534 1.6500000 0.310202 1.6527778 0.310689
+ 1.6555556 0.311004 1.6583333 0.311163 1.6611111 0.311185 1.6638889 0.311091
+ 1.6666667 0.310906 1.6694444 0.310654 1.6722222 0.310362 1.6750000 0.310078
+ 1.6777778 0.309802 1.6805556 0.309534 1.6833333 0.309272 1.6861111 0.309018
+ 1.6888889 0.308771 1.6916667 0.308531 1.6944444 0.308297 1.6972222 0.308070
+ 1.7000000 0.307946 1.7027778 0.307943 1.7055556 0.308041 1.7083333 0.308209
+ 1.7111111 0.308413 1.7138889 0.308613 1.7166667 0.308806 1.7194444 0.308995
+ 1.7222222 0.309178 1.7250000 0.309356 1.7277778 0.309433 1.7305556 0.309389
+ 1.7333333 0.309246 1.7361111 0.309034 1.7388889 0.308787 1.7416667 0.308546
+ 1.7444444 0.308312 1.7472222 0.308312 1.7500000 0.308660 1.7527778 0.309411
+ 1.7555556 0.310606 1.7583333 0.312264 1.7611111 0.314378 1.7638889 0.316911
+ 1.7666667 0.319789 1.7694444 0.322900 1.7722222 0.326096 1.7750000 0.328976
+ 1.7777778 0.331429 1.7805556 0.333402 1.7833333 0.334857 1.7861111 0.335777
+ 1.7888889 0.336169 1.7916667 0.336074 1.7944444 0.336262 1.7972222 0.338124
+ 1.8000000 0.341826 1.8027778 0.347441 1.8055556 0.354742 1.8083333 0.363369
+ 1.8111111 0.372825 1.8138889 0.382498 1.8166667 0.391907 1.8194444 0.401058
+ 1.8222222 0.409265 1.8250000 0.415253 1.8277778 0.419018 1.8305556 0.420666
+ 1.8333333 0.420428 1.8361111 0.418672 1.8388889 0.415898 1.8416667 0.413386
+ 1.8444444 0.412391 1.8472222 0.412202 1.8500000 0.412017 1.8527778 0.411838
+ 1.8555556 0.411663 1.8583333 0.411493 1.8611111 0.411328 1.8638889 0.411168
+ 1.8666667 0.411012 1.8694444 0.410197 1.8722222 0.407955 1.8750000 0.404998
+ 1.8777778 0.402121 1.8805556 0.399324 1.8833333 0.396603 1.8861111 0.393956
+ 1.8888889 0.391382 1.8916667 0.388879 1.8944444 0.386444 1.8972222 0.384076
+ 1.9000000 0.381772 1.9027778 0.379532 1.9055556 0.377353 1.9083333 0.375234
+ 1.9111111 0.373173 1.9138889 0.371169 1.9166667 0.369219 1.9194444 0.367323
+ 1.9222222 0.365478 1.9250000 0.363684 1.9277778 0.361940 1.9305556 0.360243
+ 1.9333333 0.358592 1.9361111 0.356987 1.9388889 0.355426 1.9416667 0.353908
+ 1.9444444 0.352431 1.9472222 0.350994 1.9500000 0.349597 1.9527778 0.348239
+ 1.9555556 0.346917 1.9583333 0.345632 1.9611111 0.344382 1.9638889 0.343166
+ 1.9666667 0.341983 1.9694444 0.340833 1.9722222 0.339715 1.9750000 0.338627
+ 1.9777778 0.337568 1.9805556 0.336539 1.9833333 0.335538 1.9861111 0.334565
+ 1.9888889 0.333618 1.9916667 0.332697 1.9944444 0.331801 1.9972222 0.330930
+ 2.0000000 0.330082 2.0027778 0.329258 2.0055556 0.328457 2.0083333 0.327677
+ 2.0111111 0.326919 2.0138889 0.326181 2.0166667 0.325464 2.0194444 0.324767
+ 2.0222222 0.324088 2.0250000 0.323428 2.0277778 0.322786 2.0305556 0.322162
+ 2.0333333 0.321555 2.0361111 0.320964 2.0388889 0.320390 2.0416667 0.319832
+ 2.0444444 0.319288 2.0472222 0.318760 2.0500000 0.318246 2.0527778 0.317746
+ 2.0555556 0.317260 2.0583333 0.316787 2.0611111 0.316327 2.0638889 0.315880
+ 2.0666667 0.315445 2.0694444 0.315022 2.0722222 0.314610 2.0750000 0.314210
+ 2.0777778 0.313821 2.0805556 0.313442 2.0833333 0.313074 2.0861111 0.312716
+ 2.0888889 0.312367 2.0916667 0.312028 2.0944444 0.311699 2.0972222 0.311378
+ 2.1000000 0.311067 2.1027778 0.310764 2.1055556 0.310469 2.1083333 0.310182
+ 2.1111111 0.309903 2.1138889 0.309702 2.1166667 0.309600 2.1194444 0.309567
+ 2.1222222 0.309569 2.1250000 0.309571 2.1277778 0.309573 2.1305556 0.309575
+ 2.1333333 0.309577 2.1361111 0.309579 2.1388889 0.309581 2.1416667 0.309512
+ 2.1444444 0.309352 2.1472222 0.309130 2.1500000 0.308880 2.1527778 0.308637
+ 2.1555556 0.308400 2.1583333 0.308170 2.1611111 0.307946 2.1638889 0.307729
+ 2.1666667 0.307517 2.1694444 0.307311 2.1722222 0.307111 2.1750000 0.306916
+ 2.1777778 0.306726 2.1805556 0.306542 2.1833333 0.306363 2.1861111 0.306189
+ 2.1888889 0.306019 2.1916667 0.305854 2.1944444 0.305694 2.1972222 0.305538
+ 2.2000000 0.305386 2.2027778 0.305239 2.2055556 0.305095 2.2083333 0.304955
+ 2.2111111 0.304820 2.2138889 0.304688 2.2166667 0.304559 2.2194444 0.304434
+ 2.2222222 0.304313 2.2250000 0.304195 2.2277778 0.304080 2.2305556 0.303968
+ 2.2333333 0.303859 2.2361111 0.303754 2.2388889 0.303651 2.2416667 0.303551
+ 2.2444444 0.303453 2.2472222 0.303359 2.2500000 0.303267 2.2527778 0.303177
+ 2.2555556 0.303090 2.2583333 0.303006 2.2611111 0.302923 2.2638889 0.302843
+ 2.2666667 0.302765 2.2694444 0.302690 2.2722222 0.302616 2.2750000 0.302544
+ 2.2777778 0.302475 2.2805556 0.302407 2.2833333 0.302341 2.2861111 0.302277
+ 2.2888889 0.302214 2.2916667 0.302154 2.2944444 0.302095 2.2972222 0.302037
+ 2.3000000 0.301981 2.3027778 0.301927 2.3055556 0.301874 2.3083333 0.301823
+ 2.3111111 0.301773 2.3138889 0.301724 2.3166667 0.301677 2.3194444 0.301631
+ 2.3222222 0.301587 2.3250000 0.301543 2.3277778 0.301501 2.3305556 0.301460
+ 2.3333333 0.301420 2.3361111 0.301381 2.3388889 0.301371 2.3416667 0.301440
+ 2.3444444 0.301592 2.3472222 0.301830 2.3500000 0.302148 2.3527778 0.302540
+ 2.3555556 0.302994 2.3583333 0.303495 2.3611111 0.304029 2.3638889 0.304577
+ 2.3666667 0.305083 2.3694444 0.305496 2.3722222 0.305812 2.3750000 0.306030
+ 2.3777778 0.306155 2.3805556 0.306194 2.3833333 0.306160 2.3861111 0.306066
+ 2.3888889 0.305929 2.3916667 0.305766 2.3944444 0.305609 2.3972222 0.305455
+ 2.4000000 0.305305 2.4027778 0.305231 2.4055556 0.305265 2.4083333 0.305394
+ 2.4111111 0.305601 2.4138889 0.305873 2.4166667 0.306196 2.4194444 0.306558
+ 2.4222222 0.306948 2.4250000 0.307355 2.4277778 0.307752 2.4305556 0.308097
+ 2.4333333 0.308326 2.4361111 0.308453 2.4388889 0.308495 2.4416667 0.308465
+ 2.4444444 0.308378 2.4472222 0.308244 2.4500000 0.308077 2.4527778 0.307886
+ 2.4555556 0.307701 2.4583333 0.307490 2.4611111 0.307284 2.4638889 0.307085
+ 2.4666667 0.306891 2.4694444 0.306702 2.4722222 0.306518 2.4750000 0.306340
+ 2.4777778 0.306166 2.4805556 0.306206 2.4833333 0.306447 2.4861111 0.306869
+ 2.4888889 0.307433 2.4916667 0.308088 2.4944444 0.308775 2.4972222 0.309442
+ 2.5000000 0.310092 2.5027778 0.310724 2.5055556 0.311338 2.5083333 0.311727
+ 2.5111111 0.311902 2.5138889 0.311886 2.5166667 0.311716 2.5194444 0.311444
+ 2.5222222 0.311131 2.5250000 0.310826 2.5277778 0.310529 2.5305556 0.310241
+ 2.5333333 0.309960 2.5361111 0.309687 2.5388889 0.309550 2.5416667 0.309993
+ 2.5444444 0.311070 2.5472222 0.312804 2.5500000 0.315183 2.5527778 0.318152
+ 2.5555556 0.321612 2.5583333 0.325420 2.5611111 0.329391 2.5638889 0.333253
+ 2.5666667 0.336881 2.5694444 0.339834 2.5722222 0.342059 2.5750000 0.343536
+ 2.5777778 0.344281 2.5805556 0.344350 2.5833333 0.343845 2.5861111 0.345018
+ 2.5888889 0.348103 2.5916667 0.353233 2.5944444 0.360134 2.5972222 0.368394
+ 2.6000000 0.377476 2.6027778 0.386745 2.6055556 0.395759 2.6083333 0.404527
+ 2.6111111 0.413054 2.6138889 0.419240 2.6166667 0.423047 2.6194444 0.424618
+ 2.6222222 0.424236 2.6250000 0.422316 2.6277778 0.419400 2.6305556 0.416129
+ 2.6333333 0.414548 2.6361111 0.413819 2.6388889 0.413109 2.6416667 0.412418
+ 2.6444444 0.411747 2.6472222 0.411093 2.6500000 0.410458 2.6527778 0.409840
+ 2.6555556 0.409239 2.6583333 0.408655 2.6611111 0.406486 2.6638889 0.403568
+ 2.6666667 0.400731 2.6694444 0.397972 2.6722222 0.395288 2.6750000 0.392677
+ 2.6777778 0.390138 2.6805556 0.387669 2.6833333 0.385267 2.6861111 0.382931
+ 2.6888889 0.380659 2.6916667 0.378449 2.6944444 0.376300 2.6972222 0.374210
+ 2.7000000 0.372177 2.7027778 0.370200 2.7055556 0.368277 2.7083333 0.366406
+ 2.7111111 0.364587 2.7138889 0.362817 2.7166667 0.361097 2.7194444 0.359423
+ 2.7222222 0.357795 2.7250000 0.356212 2.7277778 0.354672 2.7305556 0.353174
+ 2.7333333 0.351717 2.7361111 0.350300 2.7388889 0.348922 2.7416667 0.347582
+ 2.7444444 0.346278 2.7472222 0.345011 2.7500000 0.343778 2.7527778 0.342578
+ 2.7555556 0.341412 2.7583333 0.340277 2.7611111 0.339174 2.7638889 0.338101
+ 2.7666667 0.337057 2.7694444 0.336042 2.7722222 0.335054 2.7750000 0.334094
+ 2.7777778 0.333160 2.7805556 0.332252 2.7833333 0.331368 2.7861111 0.330509
+ 2.7888889 0.329673 2.7916667 0.328860 2.7944444 0.328069 2.7972222 0.327300
+ 2.8000000 0.326552 2.8027778 0.325825 2.8055556 0.325118 2.8083333 0.324429
+ 2.8111111 0.323760 2.8138889 0.323109 2.8166667 0.322476 2.8194444 0.321860
+ 2.8222222 0.321262 2.8250000 0.320679 2.8277778 0.320113 2.8305556 0.319562
+ 2.8333333 0.319026 2.8361111 0.318504 2.8388889 0.317997 2.8416667 0.317504
+ 2.8444444 0.317025 2.8472222 0.316558 2.8500000 0.316105 2.8527778 0.315664
+ 2.8555556 0.315235 2.8583333 0.314817 2.8611111 0.314411 2.8638889 0.314016
+ 2.8666667 0.313632 2.8694444 0.313259 2.8722222 0.312896 2.8750000 0.312542
+ 2.8777778 0.312199 2.8805556 0.311865 2.8833333 0.311540 2.8861111 0.311224
+ 2.8888889 0.310916 2.8916667 0.310617 2.8944444 0.310326 2.8972222 0.310043
+ 2.9000000 0.309768 2.9027778 0.309500 2.9055556 0.309240 2.9083333 0.309012
+ 2.9111111 0.308791 2.9138889 0.308575 2.9166667 0.308365 2.9194444 0.308161
+ 2.9222222 0.307963 2.9250000 0.307770 2.9277778 0.307582 2.9305556 0.307400
+ 2.9333333 0.307222 2.9361111 0.307024 2.9388889 0.306832 2.9416667 0.306645
+ 2.9444444 0.306463 2.9472222 0.306286 2.9500000 0.306114 2.9527778 0.305946
+ 2.9555556 0.305783 2.9583333 0.305625 2.9611111 0.305471 2.9638889 0.305321
+ 2.9666667 0.305175 2.9694444 0.305033 2.9722222 0.304895 2.9750000 0.304761
+ 2.9777778 0.304631 2.9805556 0.304504 2.9833333 0.304381 2.9861111 0.304261
+ 2.9888889 0.304144 2.9916667 0.304030 2.9944444 0.303920 2.9972222 0.303812
+ 3.0000000 0.303708 3.0027778 0.303606 3.0055556 0.303508 3.0083333 0.303412
+ 3.0111111 0.303318 3.0138889 0.303227 3.0166667 0.303139 3.0194444 0.303053
+ 3.0222222 0.302969 3.0250000 0.302888 3.0277778 0.302809 3.0305556 0.302732
+ 3.0333333 0.302657 3.0361111 0.302584 3.0388889 0.302513 3.0416667 0.302444
+ 3.0444444 0.302378 3.0472222 0.302312 3.0500000 0.302249 3.0527778 0.302187
+ 3.0555556 0.302127 3.0583333 0.302069 3.0611111 0.302013 3.0638889 0.301957
+ 3.0666667 0.301904 3.0694444 0.301852 3.0722222 0.301801 3.0750000 0.301764
+ 3.0777778 0.301735 3.0805556 0.301714 3.0833333 0.301693 3.0861111 0.301673
+ 3.0888889 0.301654 3.0916667 0.301635 3.0944444 0.301617 3.0972222 0.301599
+ 3.1000000 0.301581 3.1027778 0.301552 3.1055556 0.301517 3.1083333 0.301487
+ 3.1111111 0.301518 3.1138889 0.301606 3.1166667 0.301743 3.1194444 0.301922
+ 3.1222222 0.302137 3.1250000 0.302384 3.1277778 0.302659 3.1305556 0.302959
+ 3.1333333 0.303281 3.1361111 0.303610 3.1388889 0.303892 3.1416667 0.304127
+ 3.1444444 0.304303 3.1472222 0.304428 3.1500000 0.304509 3.1527778 0.304550
+ 3.1555556 0.304556 3.1583333 0.304528 3.1611111 0.304471 3.1638889 0.304388
+ 3.1666667 0.304285 3.1694444 0.304167 3.1722222 0.304053 3.1750000 0.303942
+ 3.1777778 0.303834 3.1805556 0.303729 3.1833333 0.303678 3.1861111 0.303712
+ 3.1888889 0.303824 3.1916667 0.304006 3.1944444 0.304247 3.1972222 0.304542
+ 3.2000000 0.304882 3.2027778 0.305261 3.2055556 0.305673 3.2083333 0.306110
+ 3.2111111 0.306513 3.2138889 0.306843 3.2166667 0.307085 3.2194444 0.307248
+ 3.2222222 0.307342 3.2250000 0.307373 3.2277778 0.307350 3.2305556 0.307279
+ 3.2333333 0.307167 3.2361111 0.307022 3.2388889 0.306852 3.2416667 0.306664
+ 3.2444444 0.306481 3.2472222 0.306304 3.2500000 0.306131 3.2527778 0.305963
+ 3.2555556 0.305800 3.2583333 0.305641 3.2611111 0.305486 3.2638889 0.305421
+ 3.2666667 0.305498 3.2694444 0.305712 3.2722222 0.306044 3.2750000 0.306472
+ 3.2777778 0.306959 3.2805556 0.307469 3.2833333 0.307965 3.2861111 0.308447
+ 3.2888889 0.308916 3.2916667 0.309287 3.2944444 0.309507 3.2972222 0.309583
+ 3.3000000 0.309532 3.3027778 0.309379 3.3055556 0.309157 3.3083333 0.308906
+ 3.3111111 0.308662 3.3138889 0.308425 3.3166667 0.308194 3.3194444 0.307970
+ 3.3222222 0.307751 3.3250000 0.307539 3.3277778 0.307332 3.3305556 0.307479
+ 3.3333333 0.308024 3.3361111 0.308994 3.3388889 0.310395 3.3416667 0.312212
+ 3.3444444 0.314398 3.3472222 0.316876 3.3500000 0.319537 3.3527778 0.322237
+ 3.3555556 0.324862 3.3583333 0.327068 3.3611111 0.328811 3.3638889 0.330067
+ 3.3666667 0.330830 3.3694444 0.331119 3.3722222 0.330981 3.3750000 0.331703
+ 3.3777778 0.333932 3.3805556 0.337793 3.3833333 0.343271 3.3861111 0.350121
+ 3.3888889 0.357970 3.3916667 0.366330 3.3944444 0.374462 3.3972222 0.382370
+ 3.4000000 0.390062 3.4027778 0.396334 3.4055556 0.400657 3.4083333 0.403058
+ 3.4111111 0.403670 3.4138889 0.402743 3.4166667 0.400654 3.4194444 0.397896
+ 3.4222222 0.396919 3.4250000 0.396937 3.4277778 0.397350 3.4305556 0.397751
+ 3.4333333 0.398142 3.4361111 0.398522 3.4388889 0.398891 3.4416667 0.399250
+ 3.4444444 0.399600 3.4472222 0.399939 3.4500000 0.398565 3.4527778 0.396260
+ 3.4555556 0.393623 3.4583333 0.391058 3.4611111 0.388564 3.4638889 0.386138
+ 3.4666667 0.383778 3.4694444 0.381483 3.4722222 0.379250 3.4750000 0.377079
+ 3.4777778 0.374968 3.4805556 0.372914 3.4833333 0.370916 3.4861111 0.368974
+ 3.4888889 0.367084 3.4916667 0.365246 3.4944444 0.363459 3.4972222 0.361720
+ 3.5000000 0.360029 3.5027778 0.358385 3.5055556 0.356785 3.5083333 0.355230
+ 3.5111111 0.353717 3.5138889 0.352245 3.5166667 0.350814 3.5194444 0.349422
+ 3.5222222 0.348068 3.5250000 0.346751 3.5277778 0.345470 3.5305556 0.344224
+ 3.5333333 0.343013 3.5361111 0.341835 3.5388889 0.340689 3.5416667 0.339574
+ 3.5444444 0.338490 3.5472222 0.337435 3.5500000 0.336410 3.5527778 0.335412
+ 3.5555556 0.334442 3.5583333 0.333499 3.5611111 0.332581 3.5638889 0.331688
+ 3.5666667 0.330820 3.5694444 0.329976 3.5722222 0.329155 3.5750000 0.328356
+ 3.5777778 0.327579 3.5805556 0.326824 3.5833333 0.326089 3.5861111 0.325374
+ 3.5888889 0.324679 3.5916667 0.324003 3.5944444 0.323345 3.5972222 0.322706
+ 3.6000000 0.322084 3.6027778 0.321479 3.6055556 0.320890 3.6083333 0.320318
+ 3.6111111 0.319761 3.6138889 0.319220 3.6166667 0.318693 3.6194444 0.318181
+ 3.6222222 0.317683 3.6250000 0.317199 3.6277778 0.316728 3.6305556 0.316269
+ 3.6333333 0.315824 3.6361111 0.315390 3.6388889 0.314968 3.6416667 0.314558
+ 3.6444444 0.314160 3.6472222 0.313772 3.6500000 0.313394 3.6527778 0.313027
+ 3.6555556 0.312671 3.6583333 0.312323 3.6611111 0.311986 3.6638889 0.311657
+ 3.6666667 0.311338 3.6694444 0.311027 3.6722222 0.310725 3.6750000 0.310432
+ 3.6777778 0.310146 3.6805556 0.309868 3.6833333 0.309597 3.6861111 0.309335
+ 3.6888889 0.309079 3.6916667 0.308830 3.6944444 0.308588 3.6972222 0.308415
+ 3.7000000 0.308343 3.7027778 0.308355 3.7055556 0.308427 3.7083333 0.308532
+ 3.7111111 0.308634 3.7138889 0.308733 3.7166667 0.308830 3.7194444 0.308924
+ 3.7222222 0.309015 3.7250000 0.309042 3.7277778 0.308971 3.7305556 0.308821
+ 3.7333333 0.308614 3.7361111 0.308378 3.7388889 0.308149 3.7416667 0.307925
+ 3.7444444 0.307708 3.7472222 0.307497 3.7500000 0.307292 3.7527778 0.307092
+ 3.7555556 0.306898 3.7583333 0.306709 3.7611111 0.306525 3.7638889 0.306346
+ 3.7666667 0.306172 3.7694444 0.306003 3.7722222 0.305839 3.7750000 0.305679
+ 3.7777778 0.305523 3.7805556 0.305372 3.7833333 0.305225 3.7861111 0.305082
+ 3.7888889 0.304942 3.7916667 0.304807 3.7944444 0.304675 3.7972222 0.304547
+ 3.8000000 0.304423 3.8027778 0.304301 3.8055556 0.304184 3.8083333 0.304069
+ 3.8111111 0.303958 3.8138889 0.303849 3.8166667 0.303744 3.8194444 0.303641
+ 3.8222222 0.303541 3.8250000 0.303444 3.8277778 0.303350 3.8305556 0.303258
+ 3.8333333 0.303169 3.8361111 0.303082 3.8388889 0.302998 3.8416667 0.302916
+ 3.8444444 0.302836 3.8472222 0.302793 3.8500000 0.302775 3.8527778 0.302777
+ 3.8555556 0.302790 3.8583333 0.302803 3.8611111 0.302816 3.8638889 0.302829
+ 3.8666667 0.302841 3.8694444 0.302853 3.8722222 0.302864 3.8750000 0.302840
+ 3.8777778 0.302793 3.8805556 0.302729 3.8833333 0.302654 3.8861111 0.302581
+ 3.8888889 0.302510 3.8916667 0.302442 3.8944444 0.302375 3.8972222 0.302310
+ 3.9000000 0.302246 3.9027778 0.302185 3.9055556 0.302125 3.9083333 0.302067
+ 3.9111111 0.302010 3.9138889 0.301955 3.9166667 0.301941 3.9194444 0.301985
+ 3.9222222 0.302095 3.9250000 0.302275 3.9277778 0.302526 3.9305556 0.302845
+ 3.9333333 0.303225 3.9361111 0.303656 3.9388889 0.304125 3.9416667 0.304616
+ 3.9444444 0.305054 3.9472222 0.305422 3.9500000 0.305714 3.9527778 0.305924
+ 3.9555556 0.306053 3.9583333 0.306103 3.9611111 0.306081 3.9638889 0.306000
+ 3.9666667 0.305871 3.9694444 0.305710 3.9722222 0.305553 3.9750000 0.305429
+ 3.9777778 0.305453 3.9805556 0.305607 3.9833333 0.305866 3.9861111 0.306205
+ 3.9888889 0.306598 3.9916667 0.307019 3.9944444 0.307429 3.9972222 0.307827
+ 4.0000000 0.308214 4.0027778 0.308563 4.0055556 0.308757 4.0083333 0.308816
+ 4.0111111 0.308763 4.0138889 0.308625 4.0166667 0.308428 4.0194444 0.308197
+ 4.0222222 0.307972 4.0250000 0.307754 4.0277778 0.307541 4.0305556 0.307335
+ 4.0333333 0.307134 4.0361111 0.306938 4.0388889 0.306748 4.0416667 0.306564
+ 4.0444444 0.306384 4.0472222 0.306209 4.0500000 0.306039 4.0527778 0.305873
+ 4.0555556 0.305712 4.0583333 0.305722 4.0611111 0.305950 4.0638889 0.306376
+ 4.0666667 0.306967 4.0694444 0.307675 4.0722222 0.308446 4.0750000 0.309196
+ 4.0777778 0.309926 4.0805556 0.310635 4.0833333 0.311325 4.0861111 0.311830
+ 4.0888889 0.312103 4.0916667 0.312164 4.0944444 0.312046 4.0972222 0.311799
+ 4.1000000 0.311476 4.1027778 0.311161 4.1055556 0.310856 4.1083333 0.310558
+ 4.1111111 0.310269 4.1138889 0.309988 4.1166667 0.309714 4.1194444 0.309712
+ 4.1222222 0.310194 4.1250000 0.311189 4.1277778 0.312699 4.1305556 0.314694
+ 4.1333333 0.317107 4.1361111 0.319837 4.1388889 0.322743 4.1416667 0.325569
+ 4.1444444 0.328318 4.1472222 0.330728 4.1500000 0.332587 4.1527778 0.333869
+ 4.1555556 0.334574 4.1583333 0.334734 4.1611111 0.334416 4.1638889 0.335620
+ 4.1666667 0.338503 4.1694444 0.343250 4.1722222 0.349668 4.1750000 0.357436
+ 4.1777778 0.366107 4.1805556 0.375124 4.1833333 0.383894 4.1861111 0.392423
+ 4.1888889 0.400718 4.1916667 0.406891 4.1944444 0.410932 4.1972222 0.412919
+ 4.2000000 0.413050 4.2027778 0.411652 4.2055556 0.409175 4.2083333 0.406573
+ 4.2111111 0.405560 4.2138889 0.405452 4.2166667 0.405347 4.2194444 0.405244
+ 4.2222222 0.405145 4.2250000 0.405048 4.2277778 0.404954 4.2305556 0.404862
+ 4.2333333 0.404773 4.2361111 0.404298 4.2388889 0.402317 4.2416667 0.399514
+ 4.2444444 0.396788 4.2472222 0.394136 4.2500000 0.391557 4.2527778 0.389049
+ 4.2555556 0.386610 4.2583333 0.384237 4.2611111 0.381929 4.2638889 0.379685
+ 4.2666667 0.377502 4.2694444 0.375378 4.2722222 0.373313 4.2750000 0.371305
+ 4.2777778 0.369352 4.2805556 0.367452 4.2833333 0.365604 4.2861111 0.363806
+ 4.2888889 0.362058 4.2916667 0.360358 4.2944444 0.358705 4.2972222 0.357097
+ 4.3000000 0.355532 4.3027778 0.354011 4.3055556 0.352531 4.3083333 0.351092
+ 4.3111111 0.349693 4.3138889 0.348331 4.3166667 0.347007 4.3194444 0.345719
+ 4.3222222 0.344467 4.3250000 0.343249 4.3277778 0.342064 4.3305556 0.340911
+ 4.3333333 0.339791 4.3361111 0.338701 4.3388889 0.337640 4.3416667 0.336609
+ 4.3444444 0.335606 4.3472222 0.334631 4.3500000 0.333682 4.3527778 0.332759
+ 4.3555556 0.331862 4.3583333 0.330989 4.3611111 0.330140 4.3638889 0.329314
+ 4.3666667 0.328511 4.3694444 0.327730 4.3722222 0.326971 4.3750000 0.326232
+ 4.3777778 0.325513 4.3805556 0.324814 4.3833333 0.324134 4.3861111 0.323473
+ 4.3888889 0.322830 4.3916667 0.322205 4.3944444 0.321596 4.3972222 0.321005
+ 4.4000000 0.320429 4.4027778 0.319870 4.4055556 0.319325 4.4083333 0.318796
+ 4.4111111 0.318281 4.4138889 0.317780 4.4166667 0.317293 4.4194444 0.316819
+ 4.4222222 0.316358 4.4250000 0.315910 4.4277778 0.315474 4.4305556 0.315050
+ 4.4333333 0.314638 4.4361111 0.314237 4.4388889 0.313847 4.4416667 0.313468
+ 4.4444444 0.313099 4.4472222 0.312740 4.4500000 0.312391 4.4527778 0.312051
+ 4.4555556 0.311721 4.4583333 0.311400 4.4611111 0.311088 4.4638889 0.310784
+ 4.4666667 0.310489 4.4694444 0.310201 4.4722222 0.309922 4.4750000 0.309650
+ 4.4777778 0.309386 4.4805556 0.309129 4.4833333 0.308879 4.4861111 0.308635
+ 4.4888889 0.308482 4.4916667 0.308503 4.4944444 0.308670 4.4972222 0.308950
+ 4.5000000 0.309303 4.5027778 0.309690 4.5055556 0.310066 4.5083333 0.310432
+ 4.5111111 0.310788 4.5138889 0.311135 4.5166667 0.311388 4.5194444 0.311465
+ 4.5222222 0.311392 4.5250000 0.311205 4.5277778 0.310941 4.5305556 0.310641
+ 4.5333333 0.310350 4.5361111 0.310066 4.5388889 0.309790 4.5416667 0.309522
+ 4.5444444 0.309261 4.5472222 0.309008 4.5500000 0.308761 4.5527778 0.308521
+ 4.5555556 0.308287 4.5583333 0.308060 4.5611111 0.307839 4.5638889 0.307625
+ 4.5666667 0.307416 4.5694444 0.307213 4.5722222 0.307015 4.5750000 0.306823
+ 4.5777778 0.306636 4.5805556 0.306454 4.5833333 0.306277 4.5861111 0.306105
+ 4.5888889 0.305938 4.5916667 0.305775 4.5944444 0.305617 4.5972222 0.305463
+ 4.6000000 0.305314 4.6027778 0.305168 4.6055556 0.305027 4.6083333 0.304889
+ 4.6111111 0.304755 4.6138889 0.304625 4.6166667 0.304498 4.6194444 0.304375
+ 4.6222222 0.304255 4.6250000 0.304138 4.6277778 0.304025 4.6305556 0.303915
+ 4.6333333 0.303807 4.6361111 0.303703 4.6388889 0.303602 4.6416667 0.303503
+ 4.6444444 0.303407 4.6472222 0.303314 4.6500000 0.303223 4.6527778 0.303135
+ 4.6555556 0.303061 4.6583333 0.302997 4.6611111 0.302935 4.6638889 0.302875
+ 4.6666667 0.302816 4.6694444 0.302759 4.6722222 0.302704 4.6750000 0.302650
+ 4.6777778 0.302598 4.6805556 0.302547 4.6833333 0.302485 4.6861111 0.302417
+ 4.6888889 0.302351 4.6916667 0.302287 4.6944444 0.302224 4.6972222 0.302163
+ 4.7000000 0.302104 4.7027778 0.302046 4.7055556 0.301990 4.7083333 0.301936
+ 4.7111111 0.301883 4.7138889 0.301831 4.7166667 0.301781 4.7194444 0.301732
+ 4.7222222 0.301685 4.7250000 0.301658 4.7277778 0.301690 4.7305556 0.301783
+ 4.7333333 0.301934 4.7361111 0.302139 4.7388889 0.302396 4.7416667 0.302700
+ 4.7444444 0.303043 4.7472222 0.303418 4.7500000 0.303817 4.7527778 0.304212
+ 4.7555556 0.304556 4.7583333 0.304830 4.7611111 0.305052 4.7638889 0.305208
+ 4.7666667 0.305303 4.7694444 0.305342 4.7722222 0.305331 4.7750000 0.305280
+ 4.7777778 0.305196 4.7805556 0.305088 4.7833333 0.304964 4.7861111 0.304843
+ 4.7888889 0.304711 4.7916667 0.304582 4.7944444 0.304481 4.7972222 0.304520
+ 4.8000000 0.304692 4.8027778 0.304990 4.8055556 0.305399 4.8083333 0.305903
+ 4.8111111 0.306484 4.8138889 0.307125 4.8166667 0.307809 4.8194444 0.308518
+ 4.8222222 0.309182 4.8250000 0.309727 4.8277778 0.310121 4.8305556 0.310375
+ 4.8333333 0.310502 4.8361111 0.310520 4.8388889 0.310446 4.8416667 0.310298
+ 4.8444444 0.310094 4.8472222 0.309852 4.8500000 0.309616 4.8527778 0.309353
+ 4.8555556 0.309097 4.8583333 0.308848 4.8611111 0.308605 4.8638889 0.308369
+ 4.8666667 0.308140 4.8694444 0.307917 4.8722222 0.307856 4.8750000 0.307976
+ 4.8777778 0.308259 4.8805556 0.308674 4.8833333 0.309175 4.8861111 0.309714
+ 4.8888889 0.310237 4.8916667 0.310747 4.8944444 0.311242 4.8972222 0.311724
+ 4.9000000 0.312037 4.9027778 0.312161 4.9055556 0.312116 4.9083333 0.311933
+ 4.9111111 0.311657 4.9138889 0.311337 4.9166667 0.311027 4.9194444 0.310725
+ 4.9222222 0.310431 4.9250000 0.310145 4.9277778 0.309867 4.9305556 0.309597
+ 4.9333333 0.309334 4.9361111 0.309510 4.9388889 0.310233 4.9416667 0.311532
+ 4.9444444 0.313408 4.9472222 0.315828 4.9500000 0.318727 4.9527778 0.321996
+ 4.9555556 0.325491 4.9583333 0.329026 4.9611111 0.332463 4.9638889 0.335375
+ 4.9666667 0.337655 4.9694444 0.339277 4.9722222 0.340242 4.9750000 0.340584
+ 4.9777778 0.340373 4.9805556 0.340918 4.9833333 0.343287 4.9861111 0.347624
+ 4.9888889 0.353896 4.9916667 0.361795 4.9944444 0.370873 4.9972222 0.380556
+ 5.0000000 0.389975 5.0027778 0.399135 5.0055556 0.408044 5.0083333 0.415508
+ 5.0111111 0.420614 5.0138889 0.423412 5.0166667 0.424079 5.0194444 0.422929
+ 5.0222222 0.420416 5.0250000 0.417117 5.0277778 0.415366 5.0305556 0.414950
+ 5.0333333 0.415156 5.0361111 0.415356 5.0388889 0.415551 5.0416667 0.415741
+ 5.0444444 0.415926 5.0472222 0.416105 5.0500000 0.416279 5.0527778 0.416449
+ 5.0555556 0.415157 5.0583333 0.412613 5.0611111 0.409528 5.0638889 0.406527
+ 5.0666667 0.403609 5.0694444 0.400770 5.0722222 0.398010 5.0750000 0.395325
+ 5.0777778 0.392713 5.0805556 0.390173 5.0833333 0.387703 5.0861111 0.385300
+ 5.0888889 0.382963 5.0916667 0.380690 5.0944444 0.378480 5.0972222 0.376330
+ 5.1000000 0.374239 5.1027778 0.372205 5.1055556 0.370227 5.1083333 0.368303
+ 5.1111111 0.366432 5.1138889 0.364612 5.1166667 0.362842 5.1194444 0.361120
+ 5.1222222 0.359446 5.1250000 0.357817 5.1277778 0.356233 5.1305556 0.354693
+ 5.1333333 0.353194 5.1361111 0.351737 5.1388889 0.350320 5.1416667 0.348941
+ 5.1444444 0.347600 5.1472222 0.346296 5.1500000 0.345028 5.1527778 0.343795
+ 5.1555556 0.342595 5.1583333 0.341428 5.1611111 0.340293 5.1638889 0.339189
+ 5.1666667 0.338115 5.1694444 0.337071 5.1722222 0.336056 5.1750000 0.335068
+ 5.1777778 0.334107 5.1805556 0.333173 5.1833333 0.332264 5.1861111 0.331380
+ 5.1888889 0.330520 5.1916667 0.329684 5.1944444 0.328871 5.1972222 0.328080
+ 5.2000000 0.327311 5.2027778 0.326563 5.2055556 0.325835 5.2083333 0.325127
+ 5.2111111 0.324439 5.2138889 0.323769 5.2166667 0.323118 5.2194444 0.322485
+ 5.2222222 0.321869 5.2250000 0.321270 5.2277778 0.320687 5.2305556 0.320120
+ 5.2333333 0.319569 5.2361111 0.319033 5.2388889 0.318512 5.2416667 0.318004
+ 5.2444444 0.317511 5.2472222 0.317032 5.2500000 0.316565 5.2527778 0.316111
+ 5.2555556 0.315670 5.2583333 0.315240 5.2611111 0.314823 5.2638889 0.314417
+ 5.2666667 0.314022 5.2694444 0.313638 5.2722222 0.313264 5.2750000 0.312901
+ 5.2777778 0.312547 5.2805556 0.312204 5.2833333 0.311869 5.2861111 0.311544
+ 5.2888889 0.311228 5.2916667 0.310920 5.2944444 0.310621 5.2972222 0.310330
+ 5.3000000 0.310047 5.3027778 0.309772 5.3055556 0.309504 5.3083333 0.309244
+ 5.3111111 0.308991 5.3138889 0.308744 5.3166667 0.308505 5.3194444 0.308272
+ 5.3222222 0.308074 5.3250000 0.307971 5.3277778 0.307940 5.3305556 0.307956
+ 5.3333333 0.307971 5.3361111 0.307986 5.3388889 0.308000 5.3416667 0.308014
+ 5.3444444 0.308027 5.3472222 0.308041 5.3500000 0.308024 5.3527778 0.307919
+ 5.3555556 0.307748 5.3583333 0.307536 5.3611111 0.307329 5.3638889 0.307129
+ 5.3666667 0.306933 5.3694444 0.306743 5.3722222 0.306559 5.3750000 0.306454
+ 5.3777778 0.306400 5.3805556 0.306380 5.3833333 0.306379 5.3861111 0.306379
+ 5.3888889 0.306378 5.3916667 0.306378 5.3944444 0.306377 5.3972222 0.306377
+ 5.4000000 0.306376 5.4027778 0.306301 5.4055556 0.306179 5.4083333 0.306029
+ 5.4111111 0.305864 5.4138889 0.305703 5.4166667 0.305547 5.4194444 0.305395
+ 5.4222222 0.305247 5.4250000 0.305103 5.4277778 0.304964 5.4305556 0.304828
+ 5.4333333 0.304695 5.4361111 0.304567 5.4388889 0.304442 5.4416667 0.304320
+ 5.4444444 0.304202 5.4472222 0.304087 5.4500000 0.303975 5.4527778 0.303898
+ 5.4555556 0.303932 5.4583333 0.304081 5.4611111 0.304347 5.4638889 0.304728
+ 5.4666667 0.305224 5.4694444 0.305827 5.4722222 0.306527 5.4750000 0.307308
+ 5.4777778 0.308153 5.4805556 0.309010 5.4833333 0.309782 5.4861111 0.310417
+ 5.4888889 0.310914 5.4916667 0.311273 5.4944444 0.311499 5.4972222 0.311597
+ 5.5000000 0.311580 5.5027778 0.311462 5.5055556 0.311263 5.5083333 0.311001
+ 5.5111111 0.310700 5.5138889 0.310407 5.5166667 0.310122 5.5194444 0.309880
+ 5.5222222 0.309875 5.5250000 0.310072 5.5277778 0.310428 5.5305556 0.310893
+ 5.5333333 0.311418 5.5361111 0.311927 5.5388889 0.312423 5.5416667 0.312906
+ 5.5444444 0.313375 5.5472222 0.313795 5.5500000 0.313974 5.5527778 0.313947
+ 5.5555556 0.313756 5.5583333 0.313450 5.5611111 0.313082 5.5638889 0.312723
+ 5.5666667 0.312375 5.5694444 0.312036 5.5722222 0.311706 5.5750000 0.311385
+ 5.5777778 0.311074 5.5805556 0.310770 5.5833333 0.310475 5.5861111 0.310188
+ 5.5888889 0.309909 5.5916667 0.310191 5.5944444 0.311089 5.5972222 0.312615
+ 5.6000000 0.314748 5.6027778 0.317428 5.6055556 0.320556 5.6083333 0.323989
+ 5.6111111 0.327543 5.6138889 0.331000 5.6166667 0.334361 5.6194444 0.337077
+ 5.6222222 0.339095 5.6250000 0.340406 5.6277778 0.341032 5.6305556 0.341034
+ 5.6333333 0.341124 5.6361111 0.342946 5.6388889 0.346653 5.6416667 0.352302
+ 5.6444444 0.359594 5.6472222 0.368093 5.6500000 0.377237 5.6527778 0.386131
+ 5.6555556 0.394781 5.6583333 0.403194 5.6611111 0.410768 5.6638889 0.416008
+ 5.6666667 0.418957 5.6694444 0.419780 5.6722222 0.418783 5.6750000 0.416407
+ 5.6777778 0.413218 5.6805556 0.411345 5.6833333 0.410783 5.6861111 0.410850
+ 5.6888889 0.410914 5.6916667 0.410977 5.6944444 0.411039 5.6972222 0.411098
+ 5.7000000 0.411156 5.7027778 0.411213 5.7055556 0.411267 5.7083333 0.410092
+ 5.7111111 0.407689 5.7138889 0.404739 5.7166667 0.401870 5.7194444 0.399079
+ 5.7222222 0.396364 5.7250000 0.393725 5.7277778 0.391157 5.7305556 0.388660
+ 5.7333333 0.386231 5.7361111 0.383868 5.7388889 0.381571 5.7416667 0.379336
+ 5.7444444 0.377163 5.7472222 0.375049 5.7500000 0.372993 5.7527778 0.370993
+ 5.7555556 0.369048 5.7583333 0.367157 5.7611111 0.365317 5.7638889 0.363527
+ 5.7666667 0.361787 5.7694444 0.360094 5.7722222 0.358448 5.7750000 0.356847
+ 5.7777778 0.355289 5.7805556 0.353775 5.7833333 0.352302 5.7861111 0.350869
+ 5.7888889 0.349475 5.7916667 0.348120 5.7944444 0.346802 5.7972222 0.345519
+ 5.8000000 0.344272 5.8027778 0.343059 5.8055556 0.341880 5.8083333 0.340733
+ 5.8111111 0.339617 5.8138889 0.338531 5.8166667 0.337476 5.8194444 0.336449
+ 5.8222222 0.335451 5.8250000 0.334479 5.8277778 0.333535 5.8305556 0.332616
+ 5.8333333 0.331723 5.8361111 0.330853 5.8388889 0.330008 5.8416667 0.329186
+ 5.8444444 0.328387 5.8472222 0.327609 5.8500000 0.326853 5.8527778 0.326117
+ 5.8555556 0.325401 5.8583333 0.324706 5.8611111 0.324029 5.8638889 0.323370
+ 5.8666667 0.322730 5.8694444 0.322107 5.8722222 0.321502 5.8750000 0.320913
+ 5.8777778 0.320340 5.8805556 0.319783 5.8833333 0.319241 5.8861111 0.318714
+ 5.8888889 0.318201 5.8916667 0.317702 5.8944444 0.317217 5.8972222 0.316746
+ 5.9000000 0.316287 5.9027778 0.315841 5.9055556 0.315407 5.9083333 0.314985
+ 5.9111111 0.314574 5.9138889 0.314175 5.9166667 0.313787 5.9194444 0.313409
+ 5.9222222 0.313042 5.9250000 0.312684 5.9277778 0.312337 5.9305556 0.311999
+ 5.9333333 0.311670 5.9361111 0.311350 5.9388889 0.311039 5.9416667 0.310737
+ 5.9444444 0.310443 5.9472222 0.310157 5.9500000 0.309878 5.9527778 0.309608
+ 5.9555556 0.309345 5.9583333 0.309089 5.9611111 0.308840 5.9638889 0.308597
+ 5.9666667 0.308362 5.9694444 0.308133 5.9722222 0.307910 5.9750000 0.307693
+ 5.9777778 0.307483 5.9805556 0.307278 5.9833333 0.307078 5.9861111 0.306884
+ 5.9888889 0.306696 5.9916667 0.306512 5.9944444 0.306334 5.9972222 0.306160
+ 6.0000000 0.305992 6.0027778 0.305827 6.0055556 0.305668 6.0083333 0.305513
+ 6.0111111 0.305362 6.0138889 0.305215 6.0166667 0.305072 6.0194444 0.304933
+ 6.0222222 0.304798 6.0250000 0.304666 6.0277778 0.304538 6.0305556 0.304414
+ 6.0333333 0.304293 6.0361111 0.304176 6.0388889 0.304061 6.0416667 0.303950
+ 6.0444444 0.303842 6.0472222 0.303736 6.0500000 0.303634 6.0527778 0.303535
+ 6.0555556 0.303438 6.0583333 0.303344 6.0611111 0.303252 6.0638889 0.303163
+ 6.0666667 0.303076 6.0694444 0.302992 6.0722222 0.302910 6.0750000 0.302830
+ 6.0777778 0.302753 6.0805556 0.302677 6.0833333 0.302604 6.0861111 0.302533
+ 6.0888889 0.302463 6.0916667 0.302423 6.0944444 0.302417 6.0972222 0.302439
+ 6.1000000 0.302480 6.1027778 0.302528 6.1055556 0.302575 6.1083333 0.302621
+ 6.1111111 0.302666 6.1138889 0.302709 6.1166667 0.302751 6.1194444 0.302765
+ 6.1222222 0.302745 6.1250000 0.302698 6.1277778 0.302632 6.1305556 0.302560
+ 6.1333333 0.302490 6.1361111 0.302422 6.1388889 0.302387 6.1416667 0.302391
+ 6.1444444 0.302426 6.1472222 0.302485 6.1500000 0.302561 6.1527778 0.302644
+ 6.1555556 0.302725 6.1583333 0.302804 6.1611111 0.302881 6.1638889 0.302956
+ 6.1666667 0.302997 6.1694444 0.302999 6.1722222 0.302970 6.1750000 0.302917
+ 6.1777778 0.302847 6.1805556 0.302769 6.1833333 0.302693 6.1861111 0.302619
+ 6.1888889 0.302548 6.1916667 0.302478 6.1944444 0.302418 6.1972222 0.302393
+ 6.2000000 0.302393 6.2027778 0.302408 6.2055556 0.302423 6.2083333 0.302438
+ 6.2111111 0.302453 6.2138889 0.302467 6.2166667 0.302480 6.2194444 0.302494
+ 6.2222222 0.302499 6.2250000 0.302470 6.2277778 0.302418 6.2305556 0.302352
+ 6.2333333 0.302288 6.2361111 0.302263 6.2388889 0.302266 6.2416667 0.302275
+ 6.2444444 0.302284 6.2472222 0.302293 6.2500000 0.302302 6.2527778 0.302310
+ 6.2555556 0.302318 6.2583333 0.302326 6.2611111 0.302334 6.2638889 0.302303
+ 6.2666667 0.302299 6.2694444 0.302329 6.2722222 0.302382 6.2750000 0.302434
+ 6.2777778 0.302484 6.2805556 0.302532 6.2833333 0.302580 6.2861111 0.302626
+ 6.2888889 0.302671 6.2916667 0.302714 6.2944444 0.302704 6.2972222 0.302654
+ 6.3000000 0.302658 6.3027778 0.302732 6.3055556 0.302861 6.3083333 0.303027
+ 6.3111111 0.303215 6.3138889 0.303399 6.3166667 0.303577 6.3194444 0.303750
+ 6.3222222 0.303918 6.3250000 0.304082 6.3277778 0.304164 6.3305556 0.304175
+ 6.3333333 0.304128 6.3361111 0.304042 6.3388889 0.303931 6.3416667 0.303823
+ 6.3444444 0.303718 6.3472222 0.303617 6.3500000 0.303517 6.3527778 0.303451
+ 6.3555556 0.303400 6.3583333 0.303350 6.3611111 0.303301 6.3638889 0.303254
+ 6.3666667 0.303208 6.3694444 0.303163 6.3722222 0.303119 6.3750000 0.303077
+ 6.3777778 0.303036 6.3805556 0.302965 6.3833333 0.302884 6.3861111 0.302805
+ 6.3888889 0.302728 6.3916667 0.302653 6.3944444 0.302581 6.3972222 0.302510
+ 6.4000000 0.302496 6.4027778 0.302538 6.4055556 0.302636 6.4083333 0.302786
+ 6.4111111 0.302978 6.4138889 0.303199 6.4166667 0.303430 6.4194444 0.303655
+ 6.4222222 0.303874 6.4250000 0.304086 6.4277778 0.304238 6.4305556 0.304330
+ 6.4333333 0.304363 6.4361111 0.304341 6.4388889 0.304272 6.4416667 0.304171
+ 6.4444444 0.304177 6.4472222 0.304323 6.4500000 0.304596 6.4527778 0.304980
+ 6.4555556 0.305457 6.4583333 0.306007 6.4611111 0.306610 6.4638889 0.307246
+ 6.4666667 0.307897 6.4694444 0.308530 6.4722222 0.309025 6.4750000 0.309366
+ 6.4777778 0.309567 6.4805556 0.309644 6.4833333 0.309615 6.4861111 0.309502
+ 6.4888889 0.309323 6.4916667 0.309099 6.4944444 0.308850 6.4972222 0.308607
+ 6.5000000 0.308371 6.5027778 0.308142 6.5055556 0.307919 6.5083333 0.307702
+ 6.5111111 0.307491 6.5138889 0.307286 6.5166667 0.307086 6.5194444 0.306892
+ 6.5222222 0.306703 6.5250000 0.306520 6.5277778 0.306393 6.5305556 0.306379
+ 6.5333333 0.306466 6.5361111 0.306630 6.5388889 0.306843 6.5416667 0.307050
+ 6.5444444 0.307252 6.5472222 0.307447 6.5500000 0.307638 6.5527778 0.307823
+ 6.5555556 0.307952 6.5583333 0.307967 6.5611111 0.307882 6.5638889 0.307719
+ 6.5666667 0.307507 6.5694444 0.307301 6.5722222 0.307101 6.5750000 0.306907
+ 6.5777778 0.306975 6.5805556 0.307414 6.5833333 0.308283 6.5861111 0.309628
+ 6.5888889 0.311480 6.5916667 0.313846 6.5944444 0.316703 6.5972222 0.319990
+ 6.6000000 0.323606 6.6027778 0.327411 6.6055556 0.330854 6.6083333 0.333830
+ 6.6111111 0.336283 6.6138889 0.338168 6.6166667 0.339457 6.6194444 0.340147
+ 6.6222222 0.340263 6.6250000 0.339867 6.6277778 0.340497 6.6305556 0.343026
+ 6.6333333 0.347719 6.6361111 0.354419 6.6388889 0.362834 6.6416667 0.372533
+ 6.6444444 0.382952 6.6472222 0.393085 6.6500000 0.402941 6.6527778 0.412527
+ 6.6555556 0.420415 6.6583333 0.425883 6.6611111 0.428970 6.6638889 0.429835
+ 6.6666667 0.428778 6.6694444 0.426236 6.6722222 0.422778 6.6750000 0.420803
+ 6.6777778 0.420603 6.6805556 0.421399 6.6833333 0.422173 6.6861111 0.422926
+ 6.6888889 0.423658 6.6916667 0.424370 6.6944444 0.425063 6.6972222 0.425736
+ 6.7000000 0.426392 6.7027778 0.425640 6.7055556 0.423188 6.7083333 0.419813
+ 6.7111111 0.416531 6.7138889 0.413339 6.7166667 0.410234 6.7194444 0.407214
+ 6.7222222 0.404277 6.7250000 0.401420 6.7277778 0.398641 6.7305556 0.395939
+ 6.7333333 0.393311 6.7361111 0.390754 6.7388889 0.388268 6.7416667 0.385850
+ 6.7444444 0.383498 6.7472222 0.381211 6.7500000 0.378986 6.7527778 0.376822
+ 6.7555556 0.374717 6.7583333 0.372671 6.7611111 0.370680 6.7638889 0.368743
+ 6.7666667 0.366860 6.7694444 0.365028 6.7722222 0.363247 6.7750000 0.361514
+ 6.7777778 0.359829 6.7805556 0.358190 6.7833333 0.356596 6.7861111 0.355045
+ 6.7888889 0.353537 6.7916667 0.352071 6.7944444 0.350644 6.7972222 0.349257
+ 6.8000000 0.347907 6.8027778 0.346595 6.8055556 0.345318 6.8083333 0.344077
+ 6.8111111 0.342869 6.8138889 0.341695 6.8166667 0.340553 6.8194444 0.339442
+ 6.8222222 0.338361 6.8250000 0.337310 6.8277778 0.336288 6.8305556 0.335294
+ 6.8333333 0.334327 6.8361111 0.333387 6.8388889 0.332472 6.8416667 0.331582
+ 6.8444444 0.330717 6.8472222 0.329876 6.8500000 0.329057 6.8527778 0.328261
+ 6.8555556 0.327487 6.8583333 0.326734 6.8611111 0.326002 6.8638889 0.325289
+ 6.8666667 0.324596 6.8694444 0.323923 6.8722222 0.323267 6.8750000 0.322630
+ 6.8777778 0.322010 6.8805556 0.321407 6.8833333 0.320820 6.8861111 0.320250
+ 6.8888889 0.319695 6.8916667 0.319156 6.8944444 0.318631 6.8972222 0.318121
+ 6.9000000 0.317624 6.9027778 0.317141 6.9055556 0.316672 6.9083333 0.316215
+ 6.9111111 0.315771 6.9138889 0.315339 6.9166667 0.314919 6.9194444 0.314510
+ 6.9222222 0.314112 6.9250000 0.313726 6.9277778 0.313350 6.9305556 0.312984
+ 6.9333333 0.312628 6.9361111 0.312282 6.9388889 0.311946 6.9416667 0.311619
+ 6.9444444 0.311300 6.9472222 0.310991 6.9500000 0.310690 6.9527778 0.310397
+ 6.9555556 0.310112 6.9583333 0.309835 6.9611111 0.309565 6.9638889 0.309303
+ 6.9666667 0.309049 6.9694444 0.308801 6.9722222 0.308560 6.9750000 0.308325
+ 6.9777778 0.308097 6.9805556 0.307938 6.9833333 0.307882 6.9861111 0.307915
+ 6.9888889 0.308023 6.9916667 0.308191 6.9944444 0.308401 6.9972222 0.308636
+ 7.0000000 0.308864 7.0027778 0.309086 7.0055556 0.309302 7.0083333 0.309449
+ 7.0111111 0.309494 7.0138889 0.309450 7.0166667 0.309331 7.0194444 0.309153
+ 7.0222222 0.308933 7.0250000 0.308688 7.0277778 0.308450 7.0305556 0.308218
+ 7.0333333 0.307993 7.0361111 0.307774 7.0388889 0.307561 7.0416667 0.307354
+ 7.0444444 0.307153 7.0472222 0.307013 7.0500000 0.306931 7.0527778 0.306883
+ 7.0555556 0.306837 7.0583333 0.306791 7.0611111 0.306747 7.0638889 0.306705
+ 7.0666667 0.306663 7.0694444 0.306623 7.0722222 0.306584 7.0750000 0.306489
+ 7.0777778 0.306344 7.0805556 0.306170 7.0833333 0.306001 7.0861111 0.305837
+ 7.0888889 0.305677 7.0916667 0.305521 7.0944444 0.305370 7.0972222 0.305223
+ 7.1000000 0.305080 7.1027778 0.304941 7.1055556 0.304805 7.1083333 0.304674
+ 7.1111111 0.304545 7.1138889 0.304421 7.1166667 0.304300 7.1194444 0.304182
+ 7.1222222 0.304067 7.1250000 0.303956 7.1277778 0.303848 7.1305556 0.303742
+ 7.1333333 0.303640 7.1361111 0.303540 7.1388889 0.303443 7.1416667 0.303349
+ 7.1444444 0.303257 7.1472222 0.303168 7.1500000 0.303081 7.1527778 0.303018
+ 7.1555556 0.303005 7.1583333 0.303032 7.1611111 0.303088 7.1638889 0.303159
+ 7.1666667 0.303228 7.1694444 0.303295 7.1722222 0.303361 7.1750000 0.303424
+ 7.1777778 0.303486 7.1805556 0.303525 7.1833333 0.303515 7.1861111 0.303465
+ 7.1888889 0.303387 7.1916667 0.303294 7.1944444 0.303204 7.1972222 0.303116
+ 7.2000000 0.303031 7.2027778 0.302948 7.2055556 0.302867 7.2083333 0.302823
+ 7.2111111 0.302802 7.2138889 0.302793 7.2166667 0.302784 7.2194444 0.302776
+ 7.2222222 0.302777 7.2250000 0.302777 7.2277778 0.302793 7.2305556 0.302822
+ 7.2333333 0.302870 7.2361111 0.302906 7.2388889 0.302948 7.2416667 0.303009
+ 7.2444444 0.303104 7.2472222 0.303230 7.2500000 0.303375 7.2527778 0.303541
+ 7.2555556 0.303707 7.2583333 0.303853 7.2611111 0.303976 7.2638889 0.304072
+ 7.2666667 0.304137 7.2694444 0.304168 7.2722222 0.304163 7.2750000 0.304124
+ 7.2777778 0.304055 7.2805556 0.303962 7.2833333 0.303853 7.2861111 0.303836
+ 7.2888889 0.303964 7.2916667 0.304223 7.2944444 0.304598 7.2972222 0.305070
+ 7.3000000 0.305618 7.3027778 0.306223 7.3055556 0.306865 7.3083333 0.307527
+ 7.3111111 0.308171 7.3138889 0.308708 7.3166667 0.309087 7.3194444 0.309320
+ 7.3222222 0.309424 7.3250000 0.309418 7.3277778 0.309323 7.3305556 0.309159
+ 7.3333333 0.308945 7.3361111 0.308699 7.3388889 0.308461 7.3416667 0.308229
+ 7.3444444 0.308004 7.3472222 0.307785 7.3500000 0.307571 7.3527778 0.307364
+ 7.3555556 0.307162 7.3583333 0.306966 7.3611111 0.306775 7.3638889 0.306696
+ 7.3666667 0.306798 7.3694444 0.307069 7.3722222 0.307480 7.3750000 0.307994
+ 7.3777778 0.308564 7.3805556 0.309118 7.3833333 0.309658 7.3861111 0.310182
+ 7.3888889 0.310693 7.3916667 0.311083 7.3944444 0.311282 7.3972222 0.311306
+ 7.4000000 0.311181 7.4027778 0.310945 7.4055556 0.310645 7.4083333 0.310353
+ 7.4111111 0.310070 7.4138889 0.309794 7.4166667 0.309526 7.4194444 0.309265
+ 7.4222222 0.309011 7.4250000 0.308879 7.4277778 0.309261 7.4305556 0.310199
+ 7.4333333 0.311712 7.4361111 0.313785 7.4388889 0.316376 7.4416667 0.319400
+ 7.4444444 0.322736 7.4472222 0.326219 7.4500000 0.329607 7.4527778 0.332787
+ 7.4555556 0.335370 7.4583333 0.337316 7.4611111 0.338608 7.4638889 0.339262
+ 7.4666667 0.339325 7.4694444 0.338881 7.4722222 0.340129 7.4750000 0.343216
+ 7.4777778 0.348292 7.4805556 0.355135 7.4833333 0.363386 7.4861111 0.372554
+ 7.4888889 0.382029 7.4916667 0.391245 7.4944444 0.400208 7.4972222 0.408925
+ 7.5000000 0.415331 7.5027778 0.419448 7.5055556 0.421378 7.5083333 0.421350
+ 7.5111111 0.419727 7.5138889 0.417006 7.5166667 0.414276 7.5194444 0.413247
+ 7.5222222 0.413191 7.5250000 0.413136 7.5277778 0.413084 7.5305556 0.413032
+ 7.5333333 0.412982 7.5361111 0.412933 7.5388889 0.412886 7.5416667 0.412840
+ 7.5444444 0.412319 7.5472222 0.410187 7.5500000 0.407168 7.5527778 0.404232
+ 7.5555556 0.401377 7.5583333 0.398600 7.5611111 0.395898 7.5638889 0.393271
+ 7.5666667 0.390716 7.5694444 0.388231 7.5722222 0.385814 7.5750000 0.383463
+ 7.5777778 0.381176 7.5805556 0.378952 7.5833333 0.376789 7.5861111 0.374686
+ 7.5888889 0.372640 7.5916667 0.370650 7.5944444 0.368714 7.5972222 0.366832
+ 7.6000000 0.365001 7.6027778 0.363220 7.6055556 0.361488 7.6083333 0.359804
+ 7.6111111 0.358165 7.6138889 0.356572 7.6166667 0.355022 7.6194444 0.353515
+ 7.6222222 0.352049 7.6250000 0.350623 7.6277778 0.349236 7.6305556 0.347887
+ 7.6333333 0.346575 7.6361111 0.345299 7.6388889 0.344058 7.6416667 0.342851
+ 7.6444444 0.341677 7.6472222 0.340535 7.6500000 0.339425 7.6527778 0.338345
+ 7.6555556 0.337294 7.6583333 0.336273 7.6611111 0.335279 7.6638889 0.334313
+ 7.6666667 0.333373 7.6694444 0.332458 7.6722222 0.331569 7.6750000 0.330704
+ 7.6777778 0.329863 7.6805556 0.329045 7.6833333 0.328249 7.6861111 0.327475
+ 7.6888889 0.326723 7.6916667 0.325991 7.6944444 0.325279 7.6972222 0.324586
+ 7.7000000 0.323912 7.7027778 0.323257 7.7055556 0.322620 7.7083333 0.322001
+ 7.7111111 0.321398 7.7138889 0.320812 7.7166667 0.320241 7.7194444 0.319687
+ 7.7222222 0.319148 7.7250000 0.318623 7.7277778 0.318113 7.7305556 0.317617
+ 7.7333333 0.317134 7.7361111 0.316665 7.7388889 0.316208 7.7416667 0.315764
+ 7.7444444 0.315332 7.7472222 0.314912 7.7500000 0.314504 7.7527778 0.314106
+ 7.7555556 0.313720 7.7583333 0.313344 7.7611111 0.312978 7.7638889 0.312623
+ 7.7666667 0.312277 7.7694444 0.311941 7.7722222 0.311614 7.7750000 0.311295
+ 7.7777778 0.310986 7.7805556 0.310685 7.7833333 0.310392 7.7861111 0.310108
+ 7.7888889 0.309831 7.7916667 0.309561 7.7944444 0.309299 7.7972222 0.309045
+ 7.8000000 0.308797 7.8027778 0.308556 7.8055556 0.308365 7.8083333 0.308244
+ 7.8111111 0.308168 7.8138889 0.308094 7.8166667 0.308022 7.8194444 0.307952
+ 7.8222222 0.307883 7.8250000 0.307817 7.8277778 0.307753 7.8305556 0.307690
+ 7.8333333 0.307586 7.8361111 0.307419 7.8388889 0.307216 7.8416667 0.307018
+ 7.8444444 0.306826 7.8472222 0.306639 7.8500000 0.306457 7.8527778 0.306280
+ 7.8555556 0.306108 7.8583333 0.305941 7.8611111 0.305778 7.8638889 0.305620
+ 7.8666667 0.305466 7.8694444 0.305316 7.8722222 0.305170 7.8750000 0.305029
+ 7.8777778 0.304891 7.8805556 0.304757 7.8833333 0.304627 7.8861111 0.304500
+ 7.8888889 0.304377 7.8916667 0.304257 7.8944444 0.304140 7.8972222 0.304027
+ 7.9000000 0.303916 7.9027778 0.303809 7.9055556 0.303705 7.9083333 0.303603
+ 7.9111111 0.303504 7.9138889 0.303408 7.9166667 0.303315 7.9194444 0.303224
+ 7.9222222 0.303136 7.9250000 0.303050 7.9277778 0.302966 7.9305556 0.302885
+ 7.9333333 0.302806 7.9361111 0.302729 7.9388889 0.302654 7.9416667 0.302582
+ 7.9444444 0.302511 7.9472222 0.302442 7.9500000 0.302375 7.9527778 0.302310
+ 7.9555556 0.302247 7.9583333 0.302185 7.9611111 0.302126 7.9638889 0.302067
+ 7.9666667 0.302011 7.9694444 0.301956 7.9722222 0.301907 7.9750000 0.301860
+ 7.9777778 0.301815 7.9805556 0.301770 7.9833333 0.301727 7.9861111 0.301685
+ 7.9888889 0.301644 7.9916667 0.301605 7.9944444 0.301566 7.9972222 0.301529
+ 8.0000000 0.301487 8.0027778 0.301446 8.0055556 0.301406 8.0083333 0.301368
+ 8.0111111 0.301330 8.0138889 0.301294 8.0166667 0.301258 8.0194444 0.301224
+ 8.0222222 0.301190 8.0250000 0.301158 8.0277778 0.301126 8.0305556 0.301095
+ 8.0333333 0.301065 8.0361111 0.301036 8.0388889 0.301008 8.0416667 0.300980
+ 8.0444444 0.300953 8.0472222 0.300956 8.0500000 0.301004 8.0527778 0.301103
+ 8.0555556 0.301257 8.0583333 0.301472 8.0611111 0.301748 8.0638889 0.302084
+ 8.0666667 0.302473 8.0694444 0.302909 8.0722222 0.303380 8.0750000 0.303848
+ 8.0777778 0.304279 8.0805556 0.304646 8.0833333 0.304945 8.0861111 0.305171
+ 8.0888889 0.305323 8.0916667 0.305405 8.0944444 0.305421 8.0972222 0.305380
+ 8.1000000 0.305292 8.1027778 0.305169 8.1055556 0.305028 8.1083333 0.305022
+ 8.1111111 0.305181 8.1138889 0.305489 8.1166667 0.305926 8.1194444 0.306465
+ 8.1222222 0.307077 8.1250000 0.307734 8.1277778 0.308407 8.1305556 0.309062
+ 8.1333333 0.309699 8.1361111 0.310187 8.1388889 0.310497 8.1416667 0.310644
+ 8.1444444 0.310651 8.1472222 0.310543 8.1500000 0.310350 8.1527778 0.310102
+ 8.1555556 0.309825 8.1583333 0.309556 8.1611111 0.309294 8.1638889 0.309039
+ 8.1666667 0.308792 8.1694444 0.308551 8.1722222 0.308317 8.1750000 0.308089
+ 8.1777778 0.307867 8.1805556 0.307652 8.1833333 0.307478 8.1861111 0.307467
+ 8.1888889 0.307604 8.1916667 0.307864 8.1944444 0.308212 8.1972222 0.308605
+ 8.2000000 0.308988 8.2027778 0.309361 8.2055556 0.309723 8.2083333 0.310075
+ 8.2111111 0.310381 8.2138889 0.310522 8.2166667 0.310511 8.2194444 0.310373
+ 8.2222222 0.310144 8.2250000 0.309867 8.2277778 0.309596 8.2305556 0.309333
+ 8.2333333 0.309078 8.2361111 0.309026 8.2388889 0.309348 8.2416667 0.310091
+ 8.2444444 0.311282 8.2472222 0.312922 8.2500000 0.314980 8.2527778 0.317394
+ 8.2555556 0.320066 8.2583333 0.322861 8.2611111 0.325581 8.2638889 0.328029
+ 8.2666667 0.330037 8.2694444 0.331561 8.2722222 0.332574 8.2750000 0.333078
+ 8.2777778 0.333106 8.2805556 0.333302 8.2833333 0.335067 8.2861111 0.338563
+ 8.2888889 0.343905 8.2916667 0.350883 8.2944444 0.359153 8.2972222 0.368241
+ 8.3000000 0.377558 8.3027778 0.386620 8.3055556 0.395434 8.3083333 0.403424
+ 8.3111111 0.409297 8.3138889 0.413033 8.3166667 0.414724 8.3194444 0.414587
+ 8.3222222 0.412970 8.3250000 0.410353 8.3277778 0.407952 8.3305556 0.406981
+ 8.3333333 0.406771 8.3361111 0.406566 8.3388889 0.406367 8.3416667 0.406174
+ 8.3444444 0.405986 8.3472222 0.405803 8.3500000 0.405625 8.3527778 0.405451
+ 8.3555556 0.404661 8.3583333 0.402527 8.3611111 0.399719 8.3638889 0.396987
+ 8.3666667 0.394330 8.3694444 0.391746 8.3722222 0.389232 8.3750000 0.386788
+ 8.3777778 0.384410 8.3805556 0.382098 8.3833333 0.379848 8.3861111 0.377661
+ 8.3888889 0.375533 8.3916667 0.373464 8.3944444 0.371452 8.3972222 0.369494
+ 8.4000000 0.367590 8.4027778 0.365739 8.4055556 0.363938 8.4083333 0.362186
+ 8.4111111 0.360482 8.4138889 0.358825 8.4166667 0.357214 8.4194444 0.355647
+ 8.4222222 0.354122 8.4250000 0.352639 8.4277778 0.351197 8.4305556 0.349795
+ 8.4333333 0.348431 8.4361111 0.347104 8.4388889 0.345813 8.4416667 0.344558
+ 8.4444444 0.343338 8.4472222 0.342150 8.4500000 0.340996 8.4527778 0.339872
+ 8.4555556 0.338780 8.4583333 0.337718 8.4611111 0.336684 8.4638889 0.335679
+ 8.4666667 0.334702 8.4694444 0.333751 8.4722222 0.332827 8.4750000 0.331927
+ 8.4777778 0.331053 8.4805556 0.330202 8.4833333 0.329375 8.4861111 0.328570
+ 8.4888889 0.327787 8.4916667 0.327026 8.4944444 0.326286 8.4972222 0.325565
+ 8.5000000 0.324865 8.5027778 0.324184 8.5055556 0.323521 8.5083333 0.322877
+ 8.5111111 0.322250 8.5138889 0.321641 8.5166667 0.321048 8.5194444 0.320471
+ 8.5222222 0.319910 8.5250000 0.319365 8.5277778 0.318834 8.5305556 0.318318
+ 8.5333333 0.317817 8.5361111 0.317329 8.5388889 0.316854 8.5416667 0.316392
+ 8.5444444 0.315943 8.5472222 0.315506 8.5500000 0.315081 8.5527778 0.314668
+ 8.5555556 0.314266 8.5583333 0.313876 8.5611111 0.313495 8.5638889 0.313126
+ 8.5666667 0.312766 8.5694444 0.312416 8.5722222 0.312076 8.5750000 0.311745
+ 8.5777778 0.311424 8.5805556 0.311111 8.5833333 0.310806 8.5861111 0.310510
+ 8.5888889 0.310222 8.5916667 0.309942 8.5944444 0.309670 8.5972222 0.309405
+ 8.6000000 0.309147 8.6027778 0.308897 8.6055556 0.308653 8.6083333 0.308416
+ 8.6111111 0.308185 8.6138889 0.307961 8.6166667 0.307743 8.6194444 0.307531
+ 8.6222222 0.307325 8.6250000 0.307124 8.6277778 0.306929 8.6305556 0.306739
+ 8.6333333 0.306554 8.6361111 0.306375 8.6388889 0.306200 8.6416667 0.306030
+ 8.6444444 0.305865 8.6472222 0.305704 8.6500000 0.305548 8.6527778 0.305396
+ 8.6555556 0.305248 8.6583333 0.305105 8.6611111 0.304965 8.6638889 0.304849
+ 8.6666667 0.304765 8.6694444 0.304684 8.6722222 0.304604 8.6750000 0.304527
+ 8.6777778 0.304452 8.6805556 0.304378 8.6833333 0.304307 8.6861111 0.304238
+ 8.6888889 0.304171 8.6916667 0.304085 8.6944444 0.303973 8.6972222 0.303864
+ 8.7000000 0.303758 8.7027778 0.303655 8.7055556 0.303555 8.7083333 0.303458
+ 8.7111111 0.303363 8.7138889 0.303271 8.7166667 0.303181 8.7194444 0.303094
+ 8.7222222 0.303009 8.7250000 0.302927 8.7277778 0.302847 8.7305556 0.302769
+ 8.7333333 0.302693 8.7361111 0.302619 8.7388889 0.302547 8.7416667 0.302478
+ 8.7444444 0.302410 8.7472222 0.302344 8.7500000 0.302280 8.7527778 0.302217
+ 8.7555556 0.302156 8.7583333 0.302097 8.7611111 0.302040 8.7638889 0.301984
+ 8.7666667 0.301930 8.7694444 0.301877 8.7722222 0.301825 8.7750000 0.301775
+ 8.7777778 0.301727 8.7805556 0.301679 8.7833333 0.301655 8.7861111 0.301647
+ 8.7888889 0.301648 8.7916667 0.301648 8.7944444 0.301649 8.7972222 0.301649
+ 8.8000000 0.301650 8.8027778 0.301651 8.8055556 0.301651 8.8083333 0.301652
+ 8.8111111 0.301630 8.8138889 0.301594 8.8166667 0.301551 8.8194444 0.301508
+ 8.8222222 0.301484 8.8250000 0.301482 8.8277778 0.301496 8.8305556 0.301524
+ 8.8333333 0.301561 8.8361111 0.301607 8.8388889 0.301663 8.8416667 0.301734
+ 8.8444444 0.301824 8.8472222 0.301940 8.8500000 0.302070 8.8527778 0.302221
+ 8.8555556 0.302404 8.8583333 0.302629 8.8611111 0.302903 8.8638889 0.303223
+ 8.8666667 0.303576 8.8694444 0.303943 8.8722222 0.304298 8.8750000 0.304615
+ 8.8777778 0.304888 8.8805556 0.305110 8.8833333 0.305272 8.8861111 0.305368
+ 8.8888889 0.305397 8.8916667 0.305363 8.8944444 0.305275 8.8972222 0.305150
+ 8.9000000 0.305179 8.9027778 0.305393 8.9055556 0.305773 8.9083333 0.306295
+ 8.9111111 0.306933 8.9138889 0.307658 8.9166667 0.308442 8.9194444 0.309255
+ 8.9222222 0.310047 8.9250000 0.310817 8.9277778 0.311395 8.9305556 0.311772
+ 8.9333333 0.311967 8.9361111 0.312004 8.9388889 0.311910 8.9416667 0.311714
+ 8.9444444 0.311445 8.9472222 0.311132 8.9500000 0.310827 8.9527778 0.310530
+ 8.9555556 0.310242 8.9583333 0.309961 8.9611111 0.309688 8.9638889 0.309423
+ 8.9666667 0.309165 8.9694444 0.308914 8.9722222 0.308830 8.9750000 0.308888
+ 8.9777778 0.309064 8.9805556 0.309321 8.9833333 0.309616 8.9861111 0.309902
+ 8.9888889 0.310180 8.9916667 0.310451 8.9944444 0.310714 8.9972222 0.310970
+ 9.0000000 0.311058 9.0027778 0.311005 9.0055556 0.310834 9.0083333 0.310581
+ 9.0111111 0.310291 9.0138889 0.310009 9.0166667 0.309735 9.0194444 0.309468
+ 9.0222222 0.309209 9.0250000 0.308957 9.0277778 0.308779 9.0305556 0.309046
+ 9.0333333 0.309796 9.0361111 0.311047 9.0388889 0.312787 9.0416667 0.314975
+ 9.0444444 0.317539 9.0472222 0.320367 9.0500000 0.323318 9.0527778 0.326188
+ 9.0555556 0.328912 9.0583333 0.331121 9.0611111 0.332778 9.0638889 0.333870
+ 9.0666667 0.334408 9.0694444 0.334435 9.0722222 0.334230 9.0750000 0.335522
+ 9.0777778 0.338473 9.0805556 0.343201 9.0833333 0.349503 9.0861111 0.357050
+ 9.0888889 0.365389 9.0916667 0.373963 9.0944444 0.382301 9.0972222 0.390411
+ 9.1000000 0.398095 9.1027778 0.403742 9.1055556 0.407340 9.1083333 0.408982
+ 9.1111111 0.408876 9.1138889 0.407355 9.1166667 0.404876 9.1194444 0.402611
+ 9.1222222 0.401719 9.1250000 0.401551 9.1277778 0.401386 9.1305556 0.401227
+ 9.1333333 0.401071 9.1361111 0.400920 9.1388889 0.400773 9.1416667 0.400631
+ 9.1444444 0.400492 9.1472222 0.399748 9.1500000 0.397714 9.1527778 0.395037
+ 9.1555556 0.392433 9.1583333 0.389901 9.1611111 0.387438 9.1638889 0.385043
+ 9.1666667 0.382713 9.1694444 0.380447 9.1722222 0.378243 9.1750000 0.376099
+ 9.1777778 0.374015 9.1805556 0.371987 9.1833333 0.370015 9.1861111 0.368097
+ 9.1888889 0.366231 9.1916667 0.364417 9.1944444 0.362652 9.1972222 0.360936
+ 9.2000000 0.359266 9.2027778 0.357643 9.2055556 0.356064 9.2083333 0.354528
+ 9.2111111 0.353034 9.2138889 0.351581 9.2166667 0.350168 9.2194444 0.348793
+ 9.2222222 0.347457 9.2250000 0.346157 9.2277778 0.344892 9.2305556 0.343662
+ 9.2333333 0.342466 9.2361111 0.341303 9.2388889 0.340171 9.2416667 0.339071
+ 9.2444444 0.338000 9.2472222 0.336959 9.2500000 0.335947 9.2527778 0.334962
+ 9.2555556 0.334004 9.2583333 0.333073 9.2611111 0.332167 9.2638889 0.331285
+ 9.2666667 0.330428 9.2694444 0.329595 9.2722222 0.328784 9.2750000 0.327995
+ 9.2777778 0.327228 9.2805556 0.326483 9.2833333 0.325757 9.2861111 0.325051
+ 9.2888889 0.324365 9.2916667 0.323698 9.2944444 0.323048 9.2972222 0.322417
+ 9.3000000 0.321803 9.3027778 0.321206 9.3055556 0.320625 9.3083333 0.320060
+ 9.3111111 0.319510 9.3138889 0.318976 9.3166667 0.318456 9.3194444 0.317950
+ 9.3222222 0.317458 9.3250000 0.316980 9.3277778 0.316515 9.3305556 0.316062
+ 9.3333333 0.315622 9.3361111 0.315194 9.3388889 0.314778 9.3416667 0.314373
+ 9.3444444 0.313980 9.3472222 0.313597 9.3500000 0.313224 9.3527778 0.312862
+ 9.3555556 0.312509 9.3583333 0.312167 9.3611111 0.311833 9.3638889 0.311509
+ 9.3666667 0.311194 9.3694444 0.310887 9.3722222 0.310589 9.3750000 0.310299
+ 9.3777778 0.310017 9.3805556 0.309742 9.3833333 0.309475 9.3861111 0.309216
+ 9.3888889 0.308963 9.3916667 0.308718 9.3944444 0.308479 9.3972222 0.308247
+ 9.4000000 0.308021 9.4027778 0.307850 9.4055556 0.307712 9.4083333 0.307579
+ 9.4111111 0.307449 9.4138889 0.307323 9.4166667 0.307200 9.4194444 0.307080
+ 9.4222222 0.306964 9.4250000 0.306851 9.4277778 0.306741 9.4305556 0.306586
+ 9.4333333 0.306405 9.4361111 0.306230 9.4388889 0.306059 9.4416667 0.305893
+ 9.4444444 0.305732 9.4472222 0.305575 9.4500000 0.305422 9.4527778 0.305273
+ 9.4555556 0.305149 9.4583333 0.305074 9.4611111 0.305034 9.4638889 0.305015
+ 9.4666667 0.304997 9.4694444 0.304979 9.4722222 0.304962 9.4750000 0.304945
+ 9.4777778 0.304928 9.4805556 0.304912 9.4833333 0.304877 9.4861111 0.304796
+ 9.4888889 0.304684 9.4916667 0.304555 9.4944444 0.304431 9.4972222 0.304309
+ 9.5000000 0.304191 9.5027778 0.304076 9.5055556 0.303965 9.5083333 0.303856
+ 9.5111111 0.303750 9.5138889 0.303648 9.5166667 0.303548 9.5194444 0.303451
+ 9.5222222 0.303356 9.5250000 0.303264 9.5277778 0.303175 9.5305556 0.303088
+ 9.5333333 0.303003 9.5361111 0.302921 9.5388889 0.302841 9.5416667 0.302763
+ 9.5444444 0.302687 9.5472222 0.302614 9.5500000 0.302542 9.5527778 0.302472
+ 9.5555556 0.302405 9.5583333 0.302339 9.5611111 0.302275 9.5638889 0.302212
+ 9.5666667 0.302152 9.5694444 0.302093 9.5722222 0.302036 9.5750000 0.301980
+ 9.5777778 0.301926 9.5805556 0.301873 9.5833333 0.301821 9.5861111 0.301772
+ 9.5888889 0.301723 9.5916667 0.301676 9.5944444 0.301630 9.5972222 0.301585
+ 9.6000000 0.301542 9.6027778 0.301500 9.6055556 0.301459 9.6083333 0.301419
+ 9.6111111 0.301394 9.6138889 0.301425 9.6166667 0.301515 9.6194444 0.301667
+ 9.6222222 0.301883 9.6250000 0.302158 9.6277778 0.302489 9.6305556 0.302867
+ 9.6333333 0.303283 9.6361111 0.303724 9.6388889 0.304162 9.6416667 0.304533
+ 9.6444444 0.304834 9.6472222 0.305061 9.6500000 0.305216 9.6527778 0.305300
+ 9.6555556 0.305319 9.6583333 0.305281 9.6611111 0.305196 9.6638889 0.305077
+ 9.6666667 0.304966 9.6694444 0.305044 9.6722222 0.305299 9.6750000 0.305713
+ 9.6777778 0.306262 9.6805556 0.306919 9.6833333 0.307654 9.6861111 0.308437
+ 9.6888889 0.309236 9.6916667 0.310015 9.6944444 0.310742 9.6972222 0.311265
+ 9.7000000 0.311595 9.7027778 0.311749 9.7055556 0.311752 9.7083333 0.311633
+ 9.7111111 0.311421 9.7138889 0.311147 9.7166667 0.310841 9.7194444 0.310544
+ 9.7222222 0.310255 9.7250000 0.309975 9.7277778 0.309701 9.7305556 0.309436
+ 9.7333333 0.309177 9.7361111 0.308926 9.7388889 0.308715 9.7416667 0.308607
+ 9.7444444 0.308588 9.7472222 0.308635 9.7500000 0.308719 9.7527778 0.308801
+ 9.7555556 0.308881 9.7583333 0.308958 9.7611111 0.309034 9.7638889 0.309107
+ 9.7666667 0.309144 9.7694444 0.309084 9.7722222 0.308940 9.7750000 0.308733
+ 9.7777778 0.308493 9.7805556 0.308261 9.7833333 0.308034 9.7861111 0.307814
+ 9.7888889 0.307600 9.7916667 0.307392 9.7944444 0.307255 9.7972222 0.307492
+ 9.8000000 0.308146 9.8027778 0.309242 9.8055556 0.310787 9.8083333 0.312765
+ 9.8111111 0.315132 9.8138889 0.317815 9.8166667 0.320708 9.8194444 0.323675
+ 9.8222222 0.326495 9.8250000 0.328866 9.8277778 0.330750 9.8305556 0.332123
+ 9.8333333 0.332979 9.8361111 0.333336 9.8388889 0.333239 9.8416667 0.333152
+ 9.8444444 0.334552 9.8472222 0.337594 9.8500000 0.342351 9.8527778 0.348627
+ 9.8555556 0.356106 9.8583333 0.364346 9.8611111 0.372805 9.8638889 0.381031
+ 9.8666667 0.389032 9.8694444 0.396428 9.8722222 0.401852 9.8750000 0.405294
+ 9.8777778 0.406844 9.8805556 0.406701 9.8833333 0.405189 9.8861111 0.402750
+ 9.8888889 0.400777 9.8916667 0.400181 9.8944444 0.400314 9.8972222 0.400443
+ 9.9000000 0.400569 9.9027778 0.400691 9.9055556 0.400810 9.9083333 0.400926
+ 9.9111111 0.401039 9.9138889 0.401148 9.9166667 0.400413 9.9194444 0.398375
+ 9.9222222 0.395680 9.9250000 0.393059 9.9277778 0.390509 9.9305556 0.388030
+ 9.9333333 0.385618 9.9361111 0.383273 9.9388889 0.380991 9.9416667 0.378773
+ 9.9444444 0.376614 9.9472222 0.374516 9.9500000 0.372474 9.9527778 0.370489
+ 9.9555556 0.368558 9.9583333 0.366679 9.9611111 0.364853 9.9638889 0.363076
+ 9.9666667 0.361348 9.9694444 0.359667 9.9722222 0.358033 9.9750000 0.356443
+ 9.9777778 0.354897 9.9805556 0.353393 9.9833333 0.351930 9.9861111 0.350507
+ 9.9888889 0.344802 9.9916667 0.339254 9.9944444 0.333857 9.9972222 0.328608
+ )

Vea env_avg 0 PWL(
+ 0.0000000 0.300000 0.0027778 0.300008 0.0055556 0.300017 0.0083333 0.300026
+ 0.0111111 0.300035 0.0138889 0.300045 0.0166667 0.300054 0.0194444 0.300063
+ 0.0222222 0.300072 0.0250000 0.300081 0.0277778 0.300090 0.0305556 0.300098
+ 0.0333333 0.300107 0.0361111 0.300117 0.0388889 0.300126 0.0416667 0.300136
+ 0.0444444 0.300146 0.0472222 0.300155 0.0500000 0.300164 0.0527778 0.300172
+ 0.0555556 0.300179 0.0583333 0.300183 0.0611111 0.300185 0.0638889 0.300185
+ 0.0666667 0.300189 0.0694444 0.300196 0.0722222 0.300207 0.0750000 0.300220
+ 0.0777778 0.300237 0.0805556 0.300255 0.0833333 0.300273 0.0861111 0.300292
+ 0.0888889 0.300310 0.0916667 0.300326 0.0944444 0.300339 0.0972222 0.300350
+ 0.1000000 0.300357 0.1027778 0.300360 0.1055556 0.300360 0.1083333 0.300362
+ 0.1111111 0.300366 0.1138889 0.300372 0.1166667 0.300379 0.1194444 0.300386
+ 0.1222222 0.300391 0.1250000 0.300394 0.1277778 0.300394 0.1305556 0.300400
+ 0.1333333 0.300413 0.1361111 0.300435 0.1388889 0.300465 0.1416667 0.300505
+ 0.1444444 0.300554 0.1472222 0.300612 0.1500000 0.300677 0.1527778 0.300747
+ 0.1555556 0.300819 0.1583333 0.300890 0.1611111 0.300957 0.1638889 0.301014
+ 0.1666667 0.301056 0.1694444 0.301080 0.1722222 0.301080 0.1750000 0.301104
+ 0.1777778 0.301157 0.1805556 0.301243 0.1833333 0.301362 0.1861111 0.301512
+ 0.1888889 0.301688 0.1916667 0.301887 0.1944444 0.302098 0.1972222 0.302312
+ 0.2000000 0.302518 0.2027778 0.302704 0.2055556 0.302857 0.2083333 0.302967
+ 0.2111111 0.303027 0.2138889 0.303032 0.2166667 0.303071 0.2194444 0.303161
+ 0.2222222 0.303295 0.2250000 0.303461 0.2277778 0.303649 0.2305556 0.303845
+ 0.2333333 0.304040 0.2361111 0.304224 0.2388889 0.304390 0.2416667 0.304533
+ 0.2444444 0.304650 0.2472222 0.304739 0.2500000 0.304799 0.2527778 0.304833
+ 0.2555556 0.304843 0.2583333 0.304837 0.2611111 0.304849 0.2638889 0.304876
+ 0.2666667 0.304914 0.2694444 0.304959 0.2722222 0.305008 0.2750000 0.305059
+ 0.2777778 0.305108 0.2805556 0.305153 0.2833333 0.305194 0.2861111 0.305229
+ 0.2888889 0.305258 0.2916667 0.305280 0.2944444 0.305295 0.2972222 0.305305
+ 0.3000000 0.305310 0.3027778 0.305310 0.3055556 0.305305 0.3083333 0.305298
+ 0.3111111 0.305289 0.3138889 0.305280 0.3166667 0.305272 0.3194444 0.305264
+ 0.3222222 0.305255 0.3250000 0.305245 0.3277778 0.305237 0.3305556 0.305231
+ 0.3333333 0.305225 0.3361111 0.305221 0.3388889 0.305218 0.3416667 0.305215
+ 0.3444444 0.305213 0.3472222 0.305210 0.3500000 0.305207 0.3527778 0.305203
+ 0.3555556 0.305199 0.3583333 0.305193 0.3611111 0.305185 0.3638889 0.305177
+ 0.3666667 0.305167 0.3694444 0.305159 0.3722222 0.305151 0.3750000 0.305144
+ 0.3777778 0.305137 0.3805556 0.305131 0.3833333 0.305125 0.3861111 0.305119
+ 0.3888889 0.305114 0.3916667 0.305108 0.3944444 0.305103 0.3972222 0.305097
+ 0.4000000 0.305091 0.4027778 0.305086 0.4055556 0.305079 0.4083333 0.305073
+ 0.4111111 0.305066 0.4138889 0.305058 0.4166667 0.305050 0.4194444 0.305042
+ 0.4222222 0.305033 0.4250000 0.305024 0.4277778 0.305015 0.4305556 0.305006
+ 0.4333333 0.304997 0.4361111 0.304989 0.4388889 0.304980 0.4416667 0.304972
+ 0.4444444 0.304965 0.4472222 0.304958 0.4500000 0.304952 0.4527778 0.304947
+ 0.4555556 0.304942 0.4583333 0.304938 0.4611111 0.304935 0.4638889 0.304932
+ 0.4666667 0.304930 0.4694444 0.304928 0.4722222 0.304927 0.4750000 0.304925
+ 0.4777778 0.304923 0.4805556 0.304921 0.4833333 0.304918 0.4861111 0.304915
+ 0.4888889 0.304911 0.4916667 0.304907 0.4944444 0.304901 0.4972222 0.304894
+ 0.5000000 0.304887 0.5027778 0.304878 0.5055556 0.304870 0.5083333 0.304864
+ 0.5111111 0.304859 0.5138889 0.304855 0.5166667 0.304853 0.5194444 0.304852
+ 0.5222222 0.304852 0.5250000 0.304853 0.5277778 0.304855 0.5305556 0.304857
+ 0.5333333 0.304860 0.5361111 0.304863 0.5388889 0.304867 0.5416667 0.304870
+ 0.5444444 0.304872 0.5472222 0.304874 0.5500000 0.304875 0.5527778 0.304876
+ 0.5555556 0.304874 0.5583333 0.304872 0.5611111 0.304867 0.5638889 0.304862
+ 0.5666667 0.304854 0.5694444 0.304845 0.5722222 0.304838 0.5750000 0.304833
+ 0.5777778 0.304829 0.5805556 0.304827 0.5833333 0.304825 0.5861111 0.304825
+ 0.5888889 0.304825 0.5916667 0.304825 0.5944444 0.304826 0.5972222 0.304827
+ 0.6000000 0.304827 0.6027778 0.304827 0.6055556 0.304827 0.6083333 0.304826
+ 0.6111111 0.304824 0.6138889 0.304822 0.6166667 0.304818 0.6194444 0.304813
+ 0.6222222 0.304807 0.6250000 0.304800 0.6277778 0.304792 0.6305556 0.304783
+ 0.6333333 0.304776 0.6361111 0.304769 0.6388889 0.304763 0.6416667 0.304757
+ 0.6444444 0.304752 0.6472222 0.304747 0.6500000 0.304741 0.6527778 0.304736
+ 0.6555556 0.304730 0.6583333 0.304724 0.6611111 0.304717 0.6638889 0.304710
+ 0.6666667 0.304703 0.6694444 0.304695 0.6722222 0.304688 0.6750000 0.304680
+ 0.6777778 0.304673 0.6805556 0.304666 0.6833333 0.304660 0.6861111 0.304654
+ 0.6888889 0.304649 0.6916667 0.304644 0.6944444 0.304640 0.6972222 0.304636
+ 0.7000000 0.304632 0.7027778 0.304628 0.7055556 0.304623 0.7083333 0.304618
+ 0.7111111 0.304612 0.7138889 0.304604 0.7166667 0.304596 0.7194444 0.304588
+ 0.7222222 0.304582 0.7250000 0.304576 0.7277778 0.304572 0.7305556 0.304568
+ 0.7333333 0.304564 0.7361111 0.304562 0.7388889 0.304559 0.7416667 0.304557
+ 0.7444444 0.304555 0.7472222 0.304552 0.7500000 0.304549 0.7527778 0.304546
+ 0.7555556 0.304543 0.7583333 0.304539 0.7611111 0.304535 0.7638889 0.304531
+ 0.7666667 0.304526 0.7694444 0.304520 0.7722222 0.304515 0.7750000 0.304509
+ 0.7777778 0.304504 0.7805556 0.304499 0.7833333 0.304495 0.7861111 0.304491
+ 0.7888889 0.304487 0.7916667 0.304484 0.7944444 0.304481 0.7972222 0.304478
+ 0.8000000 0.304475 0.8027778 0.304472 0.8055556 0.304467 0.8083333 0.304462
+ 0.8111111 0.304454 0.8138889 0.304447 0.8166667 0.304443 0.8194444 0.304441
+ 0.8222222 0.304442 0.8250000 0.304446 0.8277778 0.304453 0.8305556 0.304462
+ 0.8333333 0.304474 0.8361111 0.304488 0.8388889 0.304503 0.8416667 0.304520
+ 0.8444444 0.304537 0.8472222 0.304554 0.8500000 0.304570 0.8527778 0.304585
+ 0.8555556 0.304598 0.8583333 0.304608 0.8611111 0.304616 0.8638889 0.304621
+ 0.8666667 0.304622 0.8694444 0.304620 0.8722222 0.304615 0.8750000 0.304607
+ 0.8777778 0.304603 0.8805556 0.304603 0.8833333 0.304606 0.8861111 0.304613
+ 0.8888889 0.304624 0.8916667 0.304638 0.8944444 0.304654 0.8972222 0.304671
+ 0.9000000 0.304690 0.9027778 0.304708 0.9055556 0.304725 0.9083333 0.304739
+ 0.9111111 0.304751 0.9138889 0.304759 0.9166667 0.304762 0.9194444 0.304762
+ 0.9222222 0.304758 0.9250000 0.304751 0.9277778 0.304743 0.9305556 0.304736
+ 0.9333333 0.304730 0.9361111 0.304722 0.9388889 0.304715 0.9416667 0.304713
+ 0.9444444 0.304717 0.9472222 0.304728 0.9500000 0.304748 0.9527778 0.304779
+ 0.9555556 0.304820 0.9583333 0.304872 0.9611111 0.304933 0.9638889 0.305003
+ 0.9666667 0.305078 0.9694444 0.305155 0.9722222 0.305232 0.9750000 0.305301
+ 0.9777778 0.305360 0.9805556 0.305400 0.9833333 0.305418 0.9861111 0.305409
+ 0.9888889 0.305434 0.9916667 0.305496 0.9944444 0.305598 0.9972222 0.305741
+ 1.0000000 0.305923 1.0027778 0.306139 1.0055556 0.306381 1.0083333 0.306641
+ 1.0111111 0.306906 1.0138889 0.307163 1.0166667 0.307396 1.0194444 0.307592
+ 1.0222222 0.307738 1.0250000 0.307823 1.0277778 0.307842 1.0305556 0.307863
+ 1.0333333 0.307948 1.0361111 0.308093 1.0388889 0.308285 1.0416667 0.308510
+ 1.0444444 0.308756 1.0472222 0.309007 1.0500000 0.309251 1.0527778 0.309477
+ 1.0555556 0.309676 1.0583333 0.309842 1.0611111 0.309972 1.0638889 0.310064
+ 1.0666667 0.310121 1.0694444 0.310142 1.0722222 0.310133 1.0750000 0.310131
+ 1.0777778 0.310152 1.0805556 0.310189 1.0833333 0.310239 1.0861111 0.310296
+ 1.0888889 0.310356 1.0916667 0.310416 1.0944444 0.310473 1.0972222 0.310524
+ 1.1000000 0.310569 1.1027778 0.310605 1.1055556 0.310633 1.1083333 0.310653
+ 1.1111111 0.310664 1.1138889 0.310668 1.1166667 0.310665 1.1194444 0.310656
+ 1.1222222 0.310643 1.1250000 0.310627 1.1277778 0.310607 1.1305556 0.310589
+ 1.1333333 0.310571 1.1361111 0.310552 1.1388889 0.310533 1.1416667 0.310514
+ 1.1444444 0.310497 1.1472222 0.310481 1.1500000 0.310466 1.1527778 0.310453
+ 1.1555556 0.310441 1.1583333 0.310430 1.1611111 0.310420 1.1638889 0.310411
+ 1.1666667 0.310401 1.1694444 0.310392 1.1722222 0.310381 1.1750000 0.310370
+ 1.1777778 0.310358 1.1805556 0.310344 1.1833333 0.310329 1.1861111 0.310313
+ 1.1888889 0.310295 1.1916667 0.310276 1.1944444 0.310259 1.1972222 0.310242
+ 1.2000000 0.310227 1.2027778 0.310212 1.2055556 0.310199 1.2083333 0.310186
+ 1.2111111 0.310173 1.2138889 0.310161 1.2166667 0.310148 1.2194444 0.310136
+ 1.2222222 0.310124 1.2250000 0.310112 1.2277778 0.310099 1.2305556 0.310086
+ 1.2333333 0.310073 1.2361111 0.310059 1.2388889 0.310045 1.2416667 0.310030
+ 1.2444444 0.310016 1.2472222 0.310001 1.2500000 0.309987 1.2527778 0.309972
+ 1.2555556 0.309958 1.2583333 0.309944 1.2611111 0.309931 1.2638889 0.309918
+ 1.2666667 0.309906 1.2694444 0.309895 1.2722222 0.309885 1.2750000 0.309876
+ 1.2777778 0.309867 1.2805556 0.309859 1.2833333 0.309852 1.2861111 0.309845
+ 1.2888889 0.309839 1.2916667 0.309832 1.2944444 0.309824 1.2972222 0.309816
+ 1.3000000 0.309807 1.3027778 0.309796 1.3055556 0.309782 1.3083333 0.309767
+ 1.3111111 0.309749 1.3138889 0.309734 1.3166667 0.309723 1.3194444 0.309715
+ 1.3222222 0.309710 1.3250000 0.309708 1.3277778 0.309708 1.3305556 0.309711
+ 1.3333333 0.309715 1.3361111 0.309721 1.3388889 0.309726 1.3416667 0.309730
+ 1.3444444 0.309734 1.3472222 0.309735 1.3500000 0.309734 1.3527778 0.309731
+ 1.3555556 0.309724 1.3583333 0.309714 1.3611111 0.309701 1.3638889 0.309685
+ 1.3666667 0.309668 1.3694444 0.309654 1.3722222 0.309642 1.3750000 0.309632
+ 1.3777778 0.309624 1.3805556 0.309617 1.3833333 0.309611 1.3861111 0.309605
+ 1.3888889 0.309599 1.3916667 0.309593 1.3944444 0.309587 1.3972222 0.309579
+ 1.4000000 0.309571 1.4027778 0.309561 1.4055556 0.309550 1.4083333 0.309538
+ 1.4111111 0.309525 1.4138889 0.309511 1.4166667 0.309495 1.4194444 0.309479
+ 1.4222222 0.309462 1.4250000 0.309445 1.4277778 0.309428 1.4305556 0.309412
+ 1.4333333 0.309396 1.4361111 0.309380 1.4388889 0.309364 1.4416667 0.309347
+ 1.4444444 0.309330 1.4472222 0.309313 1.4500000 0.309297 1.4527778 0.309281
+ 1.4555556 0.309265 1.4583333 0.309250 1.4611111 0.309234 1.4638889 0.309219
+ 1.4666667 0.309204 1.4694444 0.309189 1.4722222 0.309173 1.4750000 0.309157
+ 1.4777778 0.309141 1.4805556 0.309124 1.4833333 0.309108 1.4861111 0.309093
+ 1.4888889 0.309079 1.4916667 0.309065 1.4944444 0.309053 1.4972222 0.309041
+ 1.5000000 0.309029 1.5027778 0.309018 1.5055556 0.309007 1.5083333 0.308996
+ 1.5111111 0.308984 1.5138889 0.308973 1.5166667 0.308961 1.5194444 0.308948
+ 1.5222222 0.308934 1.5250000 0.308920 1.5277778 0.308905 1.5305556 0.308889
+ 1.5333333 0.308873 1.5361111 0.308857 1.5388889 0.308842 1.5416667 0.308828
+ 1.5444444 0.308813 1.5472222 0.308799 1.5500000 0.308785 1.5527778 0.308771
+ 1.5555556 0.308757 1.5583333 0.308743 1.5611111 0.308729 1.5638889 0.308716
+ 1.5666667 0.308703 1.5694444 0.308690 1.5722222 0.308678 1.5750000 0.308667
+ 1.5777778 0.308657 1.5805556 0.308647 1.5833333 0.308638 1.5861111 0.308629
+ 1.5888889 0.308621 1.5916667 0.308614 1.5944444 0.308607 1.5972222 0.308601
+ 1.6000000 0.308594 1.6027778 0.308587 1.6055556 0.308580 1.6083333 0.308573
+ 1.6111111 0.308564 1.6138889 0.308555 1.6166667 0.308545 1.6194444 0.308532
+ 1.6222222 0.308518 1.6250000 0.308503 1.6277778 0.308490 1.6305556 0.308481
+ 1.6333333 0.308474 1.6361111 0.308469 1.6388889 0.308468 1.6416667 0.308469
+ 1.6444444 0.308471 1.6472222 0.308476 1.6500000 0.308481 1.6527778 0.308488
+ 1.6555556 0.308494 1.6583333 0.308501 1.6611111 0.308506 1.6638889 0.308511
+ 1.6666667 0.308514 1.6694444 0.308516 1.6722222 0.308515 1.6750000 0.308513
+ 1.6777778 0.308508 1.6805556 0.308500 1.6833333 0.308491 1.6861111 0.308479
+ 1.6888889 0.308464 1.6916667 0.308449 1.6944444 0.308437 1.6972222 0.308426
+ 1.7000000 0.308417 1.7027778 0.308410 1.7055556 0.308405 1.7083333 0.308402
+ 1.7111111 0.308401 1.7138889 0.308402 1.7166667 0.308404 1.7194444 0.308407
+ 1.7222222 0.308410 1.7250000 0.308413 1.7277778 0.308415 1.7305556 0.308415
+ 1.7333333 0.308414 1.7361111 0.308410 1.7388889 0.308404 1.7416667 0.308397
+ 1.7444444 0.308388 1.7472222 0.308379 1.7500000 0.308371 1.7527778 0.308365
+ 1.7555556 0.308362 1.7583333 0.308364 1.7611111 0.308371 1.7638889 0.308386
+ 1.7666667 0.308409 1.7694444 0.308439 1.7722222 0.308478 1.7750000 0.308524
+ 1.7777778 0.308576 1.7805556 0.308631 1.7833333 0.308688 1.7861111 0.308742
+ 1.7888889 0.308790 1.7916667 0.308827 1.7944444 0.308848 1.7972222 0.308849
+ 1.8000000 0.308841 1.8027778 0.308863 1.8055556 0.308917 1.8083333 0.309007
+ 1.8111111 0.309131 1.8138889 0.309288 1.8166667 0.309475 1.8194444 0.309684
+ 1.8222222 0.309905 1.8250000 0.310129 1.8277778 0.310342 1.8305556 0.310530
+ 1.8333333 0.310681 1.8361111 0.310784 1.8388889 0.310829 1.8416667 0.310813
+ 1.8444444 0.310850 1.8472222 0.310944 1.8500000 0.311085 1.8527778 0.311260
+ 1.8555556 0.311456 1.8583333 0.311660 1.8611111 0.311861 1.8638889 0.312049
+ 1.8666667 0.312216 1.8694444 0.312357 1.8722222 0.312469 1.8750000 0.312550
+ 1.8777778 0.312601 1.8805556 0.312623 1.8833333 0.312618 1.8861111 0.312599
+ 1.8888889 0.312600 1.8916667 0.312616 1.8944444 0.312644 1.8972222 0.312678
+ 1.9000000 0.312716 1.9027778 0.312754 1.9055556 0.312791 1.9083333 0.312823
+ 1.9111111 0.312849 1.9138889 0.312869 1.9166667 0.312882 1.9194444 0.312889
+ 1.9222222 0.312889 1.9250000 0.312883 1.9277778 0.312872 1.9305556 0.312858
+ 1.9333333 0.312840 1.9361111 0.312821 1.9388889 0.312801 1.9416667 0.312781
+ 1.9444444 0.312761 1.9472222 0.312742 1.9500000 0.312725 1.9527778 0.312709
+ 1.9555556 0.312695 1.9583333 0.312682 1.9611111 0.312669 1.9638889 0.312657
+ 1.9666667 0.312645 1.9694444 0.312633 1.9722222 0.312620 1.9750000 0.312605
+ 1.9777778 0.312589 1.9805556 0.312570 1.9833333 0.312550 1.9861111 0.312527
+ 1.9888889 0.312506 1.9916667 0.312486 1.9944444 0.312467 1.9972222 0.312450
+ 2.0000000 0.312433 2.0027778 0.312417 2.0055556 0.312401 2.0083333 0.312384
+ 2.0111111 0.312367 2.0138889 0.312350 2.0166667 0.312331 2.0194444 0.312311
+ 2.0222222 0.312290 2.0250000 0.312268 2.0277778 0.312246 2.0305556 0.312224
+ 2.0333333 0.312202 2.0361111 0.312181 2.0388889 0.312160 2.0416667 0.312138
+ 2.0444444 0.312116 2.0472222 0.312094 2.0500000 0.312073 2.0527778 0.312054
+ 2.0555556 0.312037 2.0583333 0.312020 2.0611111 0.312006 2.0638889 0.311993
+ 2.0666667 0.311981 2.0694444 0.311970 2.0722222 0.311960 2.0750000 0.311951
+ 2.0777778 0.311943 2.0805556 0.311934 2.0833333 0.311926 2.0861111 0.311916
+ 2.0888889 0.311906 2.0916667 0.311895 2.0944444 0.311883 2.0972222 0.311868
+ 2.1000000 0.311852 2.1027778 0.311833 2.1055556 0.311812 2.1083333 0.311792
+ 2.1111111 0.311775 2.1138889 0.311761 2.1166667 0.311750 2.1194444 0.311742
+ 2.1222222 0.311735 2.1250000 0.311730 2.1277778 0.311727 2.1305556 0.311724
+ 2.1333333 0.311721 2.1361111 0.311718 2.1388889 0.311714 2.1416667 0.311709
+ 2.1444444 0.311701 2.1472222 0.311692 2.1500000 0.311680 2.1527778 0.311666
+ 2.1555556 0.311650 2.1583333 0.311631 2.1611111 0.311609 2.1638889 0.311590
+ 2.1666667 0.311572 2.1694444 0.311556 2.1722222 0.311541 2.1750000 0.311527
+ 2.1777778 0.311514 2.1805556 0.311501 2.1833333 0.311488 2.1861111 0.311475
+ 2.1888889 0.311461 2.1916667 0.311446 2.1944444 0.311431 2.1972222 0.311415
+ 2.2000000 0.311398 2.2027778 0.311380 2.2055556 0.311361 2.2083333 0.311342
+ 2.2111111 0.311322 2.2138889 0.311302 2.2166667 0.311282 2.2194444 0.311263
+ 2.2222222 0.311243 2.2250000 0.311224 2.2277778 0.311206 2.2305556 0.311187
+ 2.2333333 0.311169 2.2361111 0.311152 2.2388889 0.311134 2.2416667 0.311117
+ 2.2444444 0.311099 2.2472222 0.311081 2.2500000 0.311062 2.2527778 0.311043
+ 2.2555556 0.311024 2.2583333 0.311004 2.2611111 0.310984 2.2638889 0.310964
+ 2.2666667 0.310946 2.2694444 0.310928 2.2722222 0.310911 2.2750000 0.310894
+ 2.2777778 0.310878 2.2805556 0.310862 2.2833333 0.310846 2.2861111 0.310830
+ 2.2888889 0.310814 2.2916667 0.310798 2.2944444 0.310781 2.2972222 0.310764
+ 2.3000000 0.310746 2.3027778 0.310728 2.3055556 0.310709 2.3083333 0.310690
+ 2.3111111 0.310672 2.3138889 0.310653 2.3166667 0.310634 2.3194444 0.310616
+ 2.3222222 0.310598 2.3250000 0.310580 2.3277778 0.310562 2.3305556 0.310544
+ 2.3333333 0.310527 2.3361111 0.310509 2.3388889 0.310490 2.3416667 0.310472
+ 2.3444444 0.310453 2.3472222 0.310435 2.3500000 0.310418 2.3527778 0.310403
+ 2.3555556 0.310389 2.3583333 0.310377 2.3611111 0.310366 2.3638889 0.310357
+ 2.3666667 0.310349 2.3694444 0.310341 2.3722222 0.310334 2.3750000 0.310328
+ 2.3777778 0.310321 2.3805556 0.310313 2.3833333 0.310305 2.3861111 0.310296
+ 2.3888889 0.310285 2.3916667 0.310273 2.3944444 0.310259 2.3972222 0.310243
+ 2.4000000 0.310225 2.4027778 0.310207 2.4055556 0.310192 2.4083333 0.310179
+ 2.4111111 0.310168 2.4138889 0.310159 2.4166667 0.310151 2.4194444 0.310146
+ 2.4222222 0.310141 2.4250000 0.310137 2.4277778 0.310134 2.4305556 0.310131
+ 2.4333333 0.310129 2.4361111 0.310127 2.4388889 0.310124 2.4416667 0.310121
+ 2.4444444 0.310118 2.4472222 0.310115 2.4500000 0.310111 2.4527778 0.310107
+ 2.4555556 0.310101 2.4583333 0.310095 2.4611111 0.310088 2.4638889 0.310080
+ 2.4666667 0.310071 2.4694444 0.310060 2.4722222 0.310048 2.4750000 0.310034
+ 2.4777778 0.310018 2.4805556 0.309999 2.4833333 0.309984 2.4861111 0.309972
+ 2.4888889 0.309964 2.4916667 0.309959 2.4944444 0.309958 2.4972222 0.309959
+ 2.5000000 0.309963 2.5027778 0.309969 2.5055556 0.309974 2.5083333 0.309979
+ 2.5111111 0.309981 2.5138889 0.309980 2.5166667 0.309976 2.5194444 0.309967
+ 2.5222222 0.309953 2.5250000 0.309936 2.5277778 0.309920 2.5305556 0.309908
+ 2.5333333 0.309898 2.5361111 0.309887 2.5388889 0.309876 2.5416667 0.309861
+ 2.5444444 0.309845 2.5472222 0.309835 2.5500000 0.309835 2.5527778 0.309844
+ 2.5555556 0.309865 2.5583333 0.309898 2.5611111 0.309942 2.5638889 0.309996
+ 2.5666667 0.310058 2.5694444 0.310127 2.5722222 0.310198 2.5750000 0.310267
+ 2.5777778 0.310329 2.5805556 0.310379 2.5833333 0.310411 2.5861111 0.310419
+ 2.5888889 0.310401 2.5916667 0.310416 2.5944444 0.310468 2.5972222 0.310557
+ 2.6000000 0.310684 2.6027778 0.310846 2.6055556 0.311039 2.6083333 0.311253
+ 2.6111111 0.311480 2.6138889 0.311709 2.6166667 0.311925 2.6194444 0.312115
+ 2.6222222 0.312267 2.6250000 0.312371 2.6277778 0.312417 2.6305556 0.312401
+ 2.6333333 0.312432 2.6361111 0.312518 2.6388889 0.312651 2.6416667 0.312819
+ 2.6444444 0.313009 2.6472222 0.313207 2.6500000 0.313403 2.6527778 0.313586
+ 2.6555556 0.313750 2.6583333 0.313889 2.6611111 0.313999 2.6638889 0.314080
+ 2.6666667 0.314130 2.6694444 0.314152 2.6722222 0.314148 2.6750000 0.314123
+ 2.6777778 0.314117 2.6805556 0.314127 2.6833333 0.314148 2.6861111 0.314177
+ 2.6888889 0.314211 2.6916667 0.314245 2.6944444 0.314278 2.6972222 0.314308
+ 2.7000000 0.314332 2.7027778 0.314351 2.7055556 0.314364 2.7083333 0.314370
+ 2.7111111 0.314369 2.7138889 0.314363 2.7166667 0.314352 2.7194444 0.314336
+ 2.7222222 0.314317 2.7250000 0.314295 2.7277778 0.314272 2.7305556 0.314247
+ 2.7333333 0.314223 2.7361111 0.314198 2.7388889 0.314175 2.7416667 0.314153
+ 2.7444444 0.314131 2.7472222 0.314112 2.7500000 0.314093 2.7527778 0.314075
+ 2.7555556 0.314058 2.7583333 0.314042 2.7611111 0.314025 2.7638889 0.314008
+ 2.7666667 0.313990 2.7694444 0.313971 2.7722222 0.313951 2.7750000 0.313930
+ 2.7777778 0.313907 2.7805556 0.313883 2.7833333 0.313858 2.7861111 0.313833
+ 2.7888889 0.313810 2.7916667 0.313787 2.7944444 0.313766 2.7972222 0.313746
+ 2.8000000 0.313726 2.8027778 0.313706 2.8055556 0.313687 2.8083333 0.313668
+ 2.8111111 0.313648 2.8138889 0.313629 2.8166667 0.313610 2.8194444 0.313590
+ 2.8222222 0.313570 2.8250000 0.313550 2.8277778 0.313529 2.8305556 0.313508
+ 2.8333333 0.313488 2.8361111 0.313467 2.8388889 0.313446 2.8416667 0.313425
+ 2.8444444 0.313405 2.8472222 0.313384 2.8500000 0.313364 2.8527778 0.313344
+ 2.8555556 0.313325 2.8583333 0.313306 2.8611111 0.313288 2.8638889 0.313270
+ 2.8666667 0.313252 2.8694444 0.313235 2.8722222 0.313217 2.8750000 0.313200
+ 2.8777778 0.313182 2.8805556 0.313164 2.8833333 0.313146 2.8861111 0.313126
+ 2.8888889 0.313106 2.8916667 0.313083 2.8944444 0.313059 2.8972222 0.313037
+ 2.9000000 0.313017 2.9027778 0.312999 2.9055556 0.312984 2.9083333 0.312970
+ 2.9111111 0.312958 2.9138889 0.312948 2.9166667 0.312939 2.9194444 0.312930
+ 2.9222222 0.312921 2.9250000 0.312912 2.9277778 0.312902 2.9305556 0.312890
+ 2.9333333 0.312877 2.9361111 0.312863 2.9388889 0.312846 2.9416667 0.312827
+ 2.9444444 0.312806 2.9472222 0.312783 2.9500000 0.312761 2.9527778 0.312740
+ 2.9555556 0.312722 2.9583333 0.312704 2.9611111 0.312688 2.9638889 0.312672
+ 2.9666667 0.312656 2.9694444 0.312640 2.9722222 0.312624 2.9750000 0.312607
+ 2.9777778 0.312590 2.9805556 0.312572 2.9833333 0.312553 2.9861111 0.312534
+ 2.9888889 0.312514 2.9916667 0.312494 2.9944444 0.312473 2.9972222 0.312452
+ 3.0000000 0.312430 3.0027778 0.312408 3.0055556 0.312386 3.0083333 0.312364
+ 3.0111111 0.312343 3.0138889 0.312321 3.0166667 0.312299 3.0194444 0.312277
+ 3.0222222 0.312255 3.0250000 0.312234 3.0277778 0.312212 3.0305556 0.312190
+ 3.0333333 0.312168 3.0361111 0.312146 3.0388889 0.312124 3.0416667 0.312102
+ 3.0444444 0.312080 3.0472222 0.312059 3.0500000 0.312038 3.0527778 0.312018
+ 3.0555556 0.311998 3.0583333 0.311979 3.0611111 0.311959 3.0638889 0.311940
+ 3.0666667 0.311921 3.0694444 0.311902 3.0722222 0.311883 3.0750000 0.311864
+ 3.0777778 0.311845 3.0805556 0.311826 3.0833333 0.311807 3.0861111 0.311788
+ 3.0888889 0.311770 3.0916667 0.311751 3.0944444 0.311733 3.0972222 0.311714
+ 3.1000000 0.311695 3.1027778 0.311676 3.1055556 0.311656 3.1083333 0.311636
+ 3.1111111 0.311615 3.1138889 0.311594 3.1166667 0.311574 3.1194444 0.311555
+ 3.1222222 0.311538 3.1250000 0.311521 3.1277778 0.311505 3.1305556 0.311490
+ 3.1333333 0.311476 3.1361111 0.311462 3.1388889 0.311448 3.1416667 0.311435
+ 3.1444444 0.311422 3.1472222 0.311410 3.1500000 0.311398 3.1527778 0.311386
+ 3.1555556 0.311373 3.1583333 0.311361 3.1611111 0.311348 3.1638889 0.311334
+ 3.1666667 0.311320 3.1694444 0.311304 3.1722222 0.311288 3.1750000 0.311270
+ 3.1777778 0.311251 3.1805556 0.311230 3.1833333 0.311210 3.1861111 0.311192
+ 3.1888889 0.311176 3.1916667 0.311160 3.1944444 0.311147 3.1972222 0.311134
+ 3.2000000 0.311123 3.2027778 0.311113 3.2055556 0.311104 3.2083333 0.311096
+ 3.2111111 0.311088 3.2138889 0.311081 3.2166667 0.311074 3.2194444 0.311068
+ 3.2222222 0.311062 3.2250000 0.311056 3.2277778 0.311049 3.2305556 0.311043
+ 3.2333333 0.311036 3.2361111 0.311028 3.2388889 0.311019 3.2416667 0.311009
+ 3.2444444 0.310998 3.2472222 0.310986 3.2500000 0.310973 3.2527778 0.310958
+ 3.2555556 0.310942 3.2583333 0.310923 3.2611111 0.310904 3.2638889 0.310885
+ 3.2666667 0.310868 3.2694444 0.310854 3.2722222 0.310842 3.2750000 0.310832
+ 3.2777778 0.310825 3.2805556 0.310819 3.2833333 0.310816 3.2861111 0.310814
+ 3.2888889 0.310813 3.2916667 0.310812 3.2944444 0.310811 3.2972222 0.310808
+ 3.3000000 0.310803 3.3027778 0.310796 3.3055556 0.310787 3.3083333 0.310774
+ 3.3111111 0.310759 3.3138889 0.310741 3.3166667 0.310722 3.3194444 0.310704
+ 3.3222222 0.310687 3.3250000 0.310670 3.3277778 0.310653 3.3305556 0.310633
+ 3.3333333 0.310616 3.3361111 0.310603 3.3388889 0.310596 3.3416667 0.310594
+ 3.3444444 0.310599 3.3472222 0.310612 3.3500000 0.310633 3.3527778 0.310660
+ 3.3555556 0.310694 3.3583333 0.310733 3.3611111 0.310775 3.3638889 0.310817
+ 3.3666667 0.310857 3.3694444 0.310889 3.3722222 0.310912 3.3750000 0.310919
+ 3.3777778 0.310906 3.3805556 0.310902 3.3833333 0.310924 3.3861111 0.310976
+ 3.3888889 0.311059 3.3916667 0.311172 3.3944444 0.311313 3.3972222 0.311477
+ 3.4000000 0.311658 3.4027778 0.311847 3.4055556 0.312032 3.4083333 0.312203
+ 3.4111111 0.312346 3.4138889 0.312451 3.4166667 0.312509 3.4194444 0.312514
+ 3.4222222 0.312518 3.4250000 0.312575 3.4277778 0.312677 3.4305556 0.312815
+ 3.4333333 0.312978 3.4361111 0.313153 3.4388889 0.313330 3.4416667 0.313498
+ 3.4444444 0.313652 3.4472222 0.313784 3.4500000 0.313891 3.4527778 0.313971
+ 3.4555556 0.314023 3.4583333 0.314048 3.4611111 0.314047 3.4638889 0.314024
+ 3.4666667 0.314015 3.4694444 0.314023 3.4722222 0.314044 3.4750000 0.314073
+ 3.4777778 0.314107 3.4805556 0.314143 3.4833333 0.314179 3.4861111 0.314211
+ 3.4888889 0.314238 3.4916667 0.314259 3.4944444 0.314273 3.4972222 0.314279
+ 3.5000000 0.314279 3.5027778 0.314271 3.5055556 0.314258 3.5083333 0.314239
+ 3.5111111 0.314216 3.5138889 0.314190 3.5166667 0.314166 3.5194444 0.314143
+ 3.5222222 0.314120 3.5250000 0.314097 3.5277778 0.314073 3.5305556 0.314048
+ 3.5333333 0.314023 3.5361111 0.313999 3.5388889 0.313977 3.5416667 0.313956
+ 3.5444444 0.313937 3.5472222 0.313918 3.5500000 0.313900 3.5527778 0.313883
+ 3.5555556 0.313866 3.5583333 0.313849 3.5611111 0.313831 3.5638889 0.313812
+ 3.5666667 0.313793 3.5694444 0.313772 3.5722222 0.313750 3.5750000 0.313726
+ 3.5777778 0.313702 3.5805556 0.313677 3.5833333 0.313653 3.5861111 0.313631
+ 3.5888889 0.313608 3.5916667 0.313586 3.5944444 0.313564 3.5972222 0.313541
+ 3.6000000 0.313518 3.6027778 0.313494 3.6055556 0.313471 3.6083333 0.313446
+ 3.6111111 0.313422 3.6138889 0.313398 3.6166667 0.313373 3.6194444 0.313350
+ 3.6222222 0.313326 3.6250000 0.313304 3.6277778 0.313282 3.6305556 0.313262
+ 3.6333333 0.313243 3.6361111 0.313225 3.6388889 0.313208 3.6416667 0.313193
+ 3.6444444 0.313179 3.6472222 0.313167 3.6500000 0.313155 3.6527778 0.313144
+ 3.6555556 0.313133 3.6583333 0.313122 3.6611111 0.313111 3.6638889 0.313099
+ 3.6666667 0.313087 3.6694444 0.313073 3.6722222 0.313059 3.6750000 0.313042
+ 3.6777778 0.313024 3.6805556 0.313004 3.6833333 0.312983 3.6861111 0.312960
+ 3.6888889 0.312937 3.6916667 0.312916 3.6944444 0.312897 3.6972222 0.312880
+ 3.7000000 0.312866 3.7027778 0.312853 3.7055556 0.312843 3.7083333 0.312834
+ 3.7111111 0.312826 3.7138889 0.312819 3.7166667 0.312814 3.7194444 0.312808
+ 3.7222222 0.312802 3.7250000 0.312795 3.7277778 0.312787 3.7305556 0.312777
+ 3.7333333 0.312765 3.7361111 0.312751 3.7388889 0.312735 3.7416667 0.312715
+ 3.7444444 0.312693 3.7472222 0.312671 3.7500000 0.312650 3.7527778 0.312632
+ 3.7555556 0.312615 3.7583333 0.312599 3.7611111 0.312583 3.7638889 0.312568
+ 3.7666667 0.312552 3.7694444 0.312536 3.7722222 0.312519 3.7750000 0.312501
+ 3.7777778 0.312483 3.7805556 0.312464 3.7833333 0.312443 3.7861111 0.312423
+ 3.7888889 0.312401 3.7916667 0.312380 3.7944444 0.312359 3.7972222 0.312338
+ 3.8000000 0.312317 3.8027778 0.312297 3.8055556 0.312278 3.8083333 0.312260
+ 3.8111111 0.312242 3.8138889 0.312225 3.8166667 0.312208 3.8194444 0.312191
+ 3.8222222 0.312173 3.8250000 0.312156 3.8277778 0.312138 3.8305556 0.312119
+ 3.8333333 0.312099 3.8361111 0.312078 3.8388889 0.312056 3.8416667 0.312035
+ 3.8444444 0.312014 3.8472222 0.311994 3.8500000 0.311976 3.8527778 0.311958
+ 3.8555556 0.311940 3.8583333 0.311923 3.8611111 0.311907 3.8638889 0.311890
+ 3.8666667 0.311874 3.8694444 0.311858 3.8722222 0.311841 3.8750000 0.311824
+ 3.8777778 0.311807 3.8805556 0.311789 3.8833333 0.311771 3.8861111 0.311752
+ 3.8888889 0.311733 3.8916667 0.311713 3.8944444 0.311693 3.8972222 0.311673
+ 3.9000000 0.311651 3.9027778 0.311630 3.9055556 0.311609 3.9083333 0.311588
+ 3.9111111 0.311568 3.9138889 0.311547 3.9166667 0.311527 3.9194444 0.311508
+ 3.9222222 0.311489 3.9250000 0.311471 3.9277778 0.311453 3.9305556 0.311437
+ 3.9333333 0.311422 3.9361111 0.311408 3.9388889 0.311395 3.9416667 0.311383
+ 3.9444444 0.311373 3.9472222 0.311363 3.9500000 0.311354 3.9527778 0.311345
+ 3.9555556 0.311337 3.9583333 0.311328 3.9611111 0.311318 3.9638889 0.311307
+ 3.9666667 0.311294 3.9694444 0.311280 3.9722222 0.311264 3.9750000 0.311245
+ 3.9777778 0.311225 3.9805556 0.311208 3.9833333 0.311194 3.9861111 0.311182
+ 3.9888889 0.311173 3.9916667 0.311166 3.9944444 0.311161 3.9972222 0.311157
+ 4.0000000 0.311154 4.0027778 0.311151 4.0055556 0.311148 4.0083333 0.311144
+ 4.0111111 0.311140 4.0138889 0.311135 4.0166667 0.311129 4.0194444 0.311121
+ 4.0222222 0.311113 4.0250000 0.311104 4.0277778 0.311093 4.0305556 0.311082
+ 4.0333333 0.311071 4.0361111 0.311059 4.0388889 0.311047 4.0416667 0.311034
+ 4.0444444 0.311021 4.0472222 0.311007 4.0500000 0.310993 4.0527778 0.310977
+ 4.0555556 0.310960 4.0583333 0.310941 4.0611111 0.310922 4.0638889 0.310907
+ 4.0666667 0.310895 4.0694444 0.310887 4.0722222 0.310883 4.0750000 0.310882
+ 4.0777778 0.310884 4.0805556 0.310887 4.0833333 0.310892 4.0861111 0.310896
+ 4.0888889 0.310899 4.0916667 0.310900 4.0944444 0.310898 4.0972222 0.310892
+ 4.1000000 0.310882 4.1027778 0.310868 4.1055556 0.310850 4.1083333 0.310831
+ 4.1111111 0.310814 4.1138889 0.310798 4.1166667 0.310781 4.1194444 0.310763
+ 4.1222222 0.310745 4.1250000 0.310732 4.1277778 0.310725 4.1305556 0.310725
+ 4.1333333 0.310734 4.1361111 0.310752 4.1388889 0.310778 4.1416667 0.310813
+ 4.1444444 0.310856 4.1472222 0.310903 4.1500000 0.310953 4.1527778 0.311003
+ 4.1555556 0.311048 4.1583333 0.311085 4.1611111 0.311108 4.1638889 0.311112
+ 4.1666667 0.311093 4.1694444 0.311099 4.1722222 0.311135 4.1750000 0.311204
+ 4.1777778 0.311307 4.1805556 0.311442 4.1833333 0.311607 4.1861111 0.311794
+ 4.1888889 0.311995 4.1916667 0.312201 4.1944444 0.312399 4.1972222 0.312577
+ 4.2000000 0.312723 4.2027778 0.312824 4.2055556 0.312873 4.2083333 0.312865
+ 4.2111111 0.312884 4.2138889 0.312958 4.2166667 0.313078 4.2194444 0.313234
+ 4.2222222 0.313412 4.2250000 0.313601 4.2277778 0.313789 4.2305556 0.313966
+ 4.2333333 0.314124 4.2361111 0.314259 4.2388889 0.314367 4.2416667 0.314445
+ 4.2444444 0.314494 4.2472222 0.314515 4.2500000 0.314510 4.2527778 0.314484
+ 4.2555556 0.314477 4.2583333 0.314485 4.2611111 0.314505 4.2638889 0.314533
+ 4.2666667 0.314566 4.2694444 0.314599 4.2722222 0.314632 4.2750000 0.314661
+ 4.2777778 0.314685 4.2805556 0.314704 4.2833333 0.314717 4.2861111 0.314723
+ 4.2888889 0.314723 4.2916667 0.314717 4.2944444 0.314707 4.2972222 0.314692
+ 4.3000000 0.314673 4.3027778 0.314652 4.3055556 0.314629 4.3083333 0.314605
+ 4.3111111 0.314580 4.3138889 0.314555 4.3166667 0.314530 4.3194444 0.314505
+ 4.3222222 0.314481 4.3250000 0.314458 4.3277778 0.314435 4.3305556 0.314413
+ 4.3333333 0.314391 4.3361111 0.314370 4.3388889 0.314348 4.3416667 0.314326
+ 4.3444444 0.314305 4.3472222 0.314283 4.3500000 0.314260 4.3527778 0.314237
+ 4.3555556 0.314214 4.3583333 0.314190 4.3611111 0.314165 4.3638889 0.314140
+ 4.3666667 0.314114 4.3694444 0.314089 4.3722222 0.314065 4.3750000 0.314041
+ 4.3777778 0.314019 4.3805556 0.313997 4.3833333 0.313976 4.3861111 0.313956
+ 4.3888889 0.313935 4.3916667 0.313914 4.3944444 0.313893 4.3972222 0.313871
+ 4.4000000 0.313848 4.4027778 0.313824 4.4055556 0.313799 4.4083333 0.313774
+ 4.4111111 0.313750 4.4138889 0.313726 4.4166667 0.313703 4.4194444 0.313680
+ 4.4222222 0.313657 4.4250000 0.313634 4.4277778 0.313609 4.4305556 0.313584
+ 4.4333333 0.313561 4.4361111 0.313540 4.4388889 0.313520 4.4416667 0.313502
+ 4.4444444 0.313486 4.4472222 0.313472 4.4500000 0.313459 4.4527778 0.313447
+ 4.4555556 0.313437 4.4583333 0.313427 4.4611111 0.313418 4.4638889 0.313408
+ 4.4666667 0.313399 4.4694444 0.313388 4.4722222 0.313377 4.4750000 0.313364
+ 4.4777778 0.313349 4.4805556 0.313331 4.4833333 0.313311 4.4861111 0.313288
+ 4.4888889 0.313265 4.4916667 0.313246 4.4944444 0.313230 4.4972222 0.313218
+ 4.5000000 0.313209 4.5027778 0.313202 4.5055556 0.313198 4.5083333 0.313195
+ 4.5111111 0.313193 4.5138889 0.313192 4.5166667 0.313190 4.5194444 0.313186
+ 4.5222222 0.313181 4.5250000 0.313174 4.5277778 0.313163 4.5305556 0.313150
+ 4.5333333 0.313134 4.5361111 0.313115 4.5388889 0.313093 4.5416667 0.313069
+ 4.5444444 0.313048 4.5472222 0.313028 4.5500000 0.313010 4.5527778 0.312993
+ 4.5555556 0.312977 4.5583333 0.312961 4.5611111 0.312945 4.5638889 0.312928
+ 4.5666667 0.312912 4.5694444 0.312894 4.5722222 0.312876 4.5750000 0.312858
+ 4.5777778 0.312839 4.5805556 0.312820 4.5833333 0.312800 4.5861111 0.312780
+ 4.5888889 0.312760 4.5916667 0.312741 4.5944444 0.312721 4.5972222 0.312702
+ 4.6000000 0.312682 4.6027778 0.312663 4.6055556 0.312644 4.6083333 0.312625
+ 4.6111111 0.312606 4.6138889 0.312587 4.6166667 0.312568 4.6194444 0.312548
+ 4.6222222 0.312528 4.6250000 0.312508 4.6277778 0.312487 4.6305556 0.312467
+ 4.6333333 0.312445 4.6361111 0.312423 4.6388889 0.312400 4.6416667 0.312378
+ 4.6444444 0.312356 4.6472222 0.312335 4.6500000 0.312315 4.6527778 0.312295
+ 4.6555556 0.312277 4.6583333 0.312258 4.6611111 0.312240 4.6638889 0.312223
+ 4.6666667 0.312205 4.6694444 0.312188 4.6722222 0.312171 4.6750000 0.312153
+ 4.6777778 0.312135 4.6805556 0.312117 4.6833333 0.312099 4.6861111 0.312080
+ 4.6888889 0.312060 4.6916667 0.312040 4.6944444 0.312020 4.6972222 0.312000
+ 4.7000000 0.311979 4.7027778 0.311959 4.7055556 0.311938 4.7083333 0.311917
+ 4.7111111 0.311897 4.7138889 0.311876 4.7166667 0.311855 4.7194444 0.311834
+ 4.7222222 0.311813 4.7250000 0.311791 4.7277778 0.311770 4.7305556 0.311749
+ 4.7333333 0.311729 4.7361111 0.311711 4.7388889 0.311693 4.7416667 0.311677
+ 4.7444444 0.311661 4.7472222 0.311646 4.7500000 0.311633 4.7527778 0.311620
+ 4.7555556 0.311607 4.7583333 0.311596 4.7611111 0.311584 4.7638889 0.311573
+ 4.7666667 0.311562 4.7694444 0.311551 4.7722222 0.311540 4.7750000 0.311528
+ 4.7777778 0.311516 4.7805556 0.311503 4.7833333 0.311490 4.7861111 0.311475
+ 4.7888889 0.311458 4.7916667 0.311440 4.7944444 0.311420 4.7972222 0.311400
+ 4.8000000 0.311382 4.8027778 0.311366 4.8055556 0.311353 4.8083333 0.311342
+ 4.8111111 0.311333 4.8138889 0.311327 4.8166667 0.311322 4.8194444 0.311319
+ 4.8222222 0.311317 4.8250000 0.311315 4.8277778 0.311315 4.8305556 0.311314
+ 4.8333333 0.311314 4.8361111 0.311313 4.8388889 0.311312 4.8416667 0.311309
+ 4.8444444 0.311305 4.8472222 0.311300 4.8500000 0.311293 4.8527778 0.311284
+ 4.8555556 0.311273 4.8583333 0.311260 4.8611111 0.311245 4.8638889 0.311227
+ 4.8666667 0.311208 4.8694444 0.311188 4.8722222 0.311171 4.8750000 0.311157
+ 4.8777778 0.311146 4.8805556 0.311138 4.8833333 0.311132 4.8861111 0.311130
+ 4.8888889 0.311130 4.8916667 0.311133 4.8944444 0.311136 4.8972222 0.311140
+ 4.9000000 0.311143 4.9027778 0.311144 4.9055556 0.311143 4.9083333 0.311139
+ 4.9111111 0.311131 4.9138889 0.311119 4.9166667 0.311102 4.9194444 0.311082
+ 4.9222222 0.311065 4.9250000 0.311050 4.9277778 0.311037 4.9305556 0.311024
+ 4.9333333 0.311010 4.9361111 0.310993 4.9388889 0.310973 4.9416667 0.310960
+ 4.9444444 0.310954 4.9472222 0.310956 4.9500000 0.310968 4.9527778 0.310990
+ 4.9555556 0.311023 4.9583333 0.311064 4.9611111 0.311115 4.9638889 0.311171
+ 4.9666667 0.311231 4.9694444 0.311291 4.9722222 0.311347 4.9750000 0.311395
+ 4.9777778 0.311429 4.9805556 0.311444 4.9833333 0.311434 4.9861111 0.311430
+ 4.9888889 0.311460 4.9916667 0.311526 4.9944444 0.311629 4.9972222 0.311769
+ 5.0000000 0.311942 5.0027778 0.312142 5.0055556 0.312362 5.0083333 0.312591
+ 5.0111111 0.312815 5.0138889 0.313023 5.0166667 0.313200 5.0194444 0.313334
+ 5.0222222 0.313413 5.0250000 0.313432 5.0277778 0.313427 5.0305556 0.313484
+ 5.0333333 0.313595 5.0361111 0.313750 5.0388889 0.313937 5.0416667 0.314141
+ 5.0444444 0.314350 5.0472222 0.314552 5.0500000 0.314738 5.0527778 0.314901
+ 5.0555556 0.315036 5.0583333 0.315139 5.0611111 0.315210 5.0638889 0.315250
+ 5.0666667 0.315260 5.0694444 0.315242 5.0722222 0.315226 5.0750000 0.315229
+ 5.0777778 0.315247 5.0805556 0.315275 5.0833333 0.315310 5.0861111 0.315347
+ 5.0888889 0.315384 5.0916667 0.315418 5.0944444 0.315448 5.0972222 0.315470
+ 5.1000000 0.315486 5.1027778 0.315495 5.1055556 0.315496 5.1083333 0.315491
+ 5.1111111 0.315480 5.1138889 0.315463 5.1166667 0.315444 5.1194444 0.315421
+ 5.1222222 0.315396 5.1250000 0.315371 5.1277778 0.315345 5.1305556 0.315320
+ 5.1333333 0.315296 5.1361111 0.315274 5.1388889 0.315253 5.1416667 0.315233
+ 5.1444444 0.315215 5.1472222 0.315199 5.1500000 0.315183 5.1527778 0.315167
+ 5.1555556 0.315151 5.1583333 0.315134 5.1611111 0.315117 5.1638889 0.315098
+ 5.1666667 0.315078 5.1694444 0.315055 5.1722222 0.315031 5.1750000 0.315004
+ 5.1777778 0.314977 5.1805556 0.314952 5.1833333 0.314929 5.1861111 0.314908
+ 5.1888889 0.314888 5.1916667 0.314869 5.1944444 0.314851 5.1972222 0.314832
+ 5.2000000 0.314814 5.2027778 0.314796 5.2055556 0.314777 5.2083333 0.314758
+ 5.2111111 0.314737 5.2138889 0.314716 5.2166667 0.314694 5.2194444 0.314671
+ 5.2222222 0.314646 5.2250000 0.314621 5.2277778 0.314596 5.2305556 0.314570
+ 5.2333333 0.314543 5.2361111 0.314517 5.2388889 0.314490 5.2416667 0.314464
+ 5.2444444 0.314438 5.2472222 0.314413 5.2500000 0.314389 5.2527778 0.314365
+ 5.2555556 0.314341 5.2583333 0.314319 5.2611111 0.314296 5.2638889 0.314274
+ 5.2666667 0.314252 5.2694444 0.314231 5.2722222 0.314209 5.2750000 0.314188
+ 5.2777778 0.314166 5.2805556 0.314145 5.2833333 0.314123 5.2861111 0.314102
+ 5.2888889 0.314080 5.2916667 0.314058 5.2944444 0.314036 5.2972222 0.314013
+ 5.3000000 0.313990 5.3027778 0.313967 5.3055556 0.313943 5.3083333 0.313918
+ 5.3111111 0.313893 5.3138889 0.313869 5.3166667 0.313846 5.3194444 0.313825
+ 5.3222222 0.313806 5.3250000 0.313789 5.3277778 0.313774 5.3305556 0.313760
+ 5.3333333 0.313748 5.3361111 0.313738 5.3388889 0.313728 5.3416667 0.313719
+ 5.3444444 0.313710 5.3472222 0.313700 5.3500000 0.313689 5.3527778 0.313676
+ 5.3555556 0.313662 5.3583333 0.313645 5.3611111 0.313626 5.3638889 0.313604
+ 5.3666667 0.313579 5.3694444 0.313556 5.3722222 0.313536 5.3750000 0.313517
+ 5.3777778 0.313500 5.3805556 0.313485 5.3833333 0.313471 5.3861111 0.313458
+ 5.3888889 0.313445 5.3916667 0.313433 5.3944444 0.313421 5.3972222 0.313408
+ 5.4000000 0.313396 5.4027778 0.313382 5.4055556 0.313368 5.4083333 0.313354
+ 5.4111111 0.313339 5.4138889 0.313323 5.4166667 0.313306 5.4194444 0.313289
+ 5.4222222 0.313271 5.4250000 0.313253 5.4277778 0.313235 5.4305556 0.313216
+ 5.4333333 0.313196 5.4361111 0.313177 5.4388889 0.313157 5.4416667 0.313136
+ 5.4444444 0.313114 5.4472222 0.313091 5.4500000 0.313068 5.4527778 0.313044
+ 5.4555556 0.313022 5.4583333 0.313002 5.4611111 0.312983 5.4638889 0.312966
+ 5.4666667 0.312951 5.4694444 0.312937 5.4722222 0.312926 5.4750000 0.312916
+ 5.4777778 0.312909 5.4805556 0.312903 5.4833333 0.312899 5.4861111 0.312896
+ 5.4888889 0.312895 5.4916667 0.312894 5.4944444 0.312893 5.4972222 0.312892
+ 5.5000000 0.312890 5.5027778 0.312887 5.5055556 0.312882 5.5083333 0.312875
+ 5.5111111 0.312864 5.5138889 0.312851 5.5166667 0.312833 5.5194444 0.312811
+ 5.5222222 0.312790 5.5250000 0.312774 5.5277778 0.312763 5.5305556 0.312756
+ 5.5333333 0.312753 5.5361111 0.312753 5.5388889 0.312756 5.5416667 0.312759
+ 5.5444444 0.312764 5.5472222 0.312768 5.5500000 0.312771 5.5527778 0.312772
+ 5.5555556 0.312770 5.5583333 0.312764 5.5611111 0.312755 5.5638889 0.312741
+ 5.5666667 0.312722 5.5694444 0.312699 5.5722222 0.312680 5.5750000 0.312664
+ 5.5777778 0.312651 5.5805556 0.312640 5.5833333 0.312629 5.5861111 0.312618
+ 5.5888889 0.312605 5.5916667 0.312588 5.5944444 0.312565 5.5972222 0.312549
+ 5.6000000 0.312541 5.6027778 0.312544 5.6055556 0.312558 5.6083333 0.312582
+ 5.6111111 0.312618 5.6138889 0.312662 5.6166667 0.312715 5.6194444 0.312772
+ 5.6222222 0.312831 5.6250000 0.312888 5.6277778 0.312937 5.6305556 0.312974
+ 5.6333333 0.312993 5.6361111 0.312988 5.6388889 0.312973 5.6416667 0.312991
+ 5.6444444 0.313044 5.6472222 0.313135 5.6500000 0.313262 5.6527778 0.313422
+ 5.6555556 0.313610 5.6583333 0.313818 5.6611111 0.314036 5.6638889 0.314251
+ 5.6666667 0.314450 5.6694444 0.314619 5.6722222 0.314748 5.6750000 0.314824
+ 5.6777778 0.314843 5.6805556 0.314831 5.6833333 0.314878 5.6861111 0.314978
+ 5.6888889 0.315121 5.6916667 0.315295 5.6944444 0.315487 5.6972222 0.315683
+ 5.7000000 0.315873 5.7027778 0.316048 5.7055556 0.316202 5.7083333 0.316329
+ 5.7111111 0.316427 5.7138889 0.316494 5.7166667 0.316531 5.7194444 0.316539
+ 5.7222222 0.316521 5.7250000 0.316500 5.7277778 0.316498 5.7305556 0.316511
+ 5.7333333 0.316535 5.7361111 0.316565 5.7388889 0.316598 5.7416667 0.316632
+ 5.7444444 0.316664 5.7472222 0.316691 5.7500000 0.316712 5.7527778 0.316728
+ 5.7555556 0.316736 5.7583333 0.316737 5.7611111 0.316732 5.7638889 0.316720
+ 5.7666667 0.316703 5.7694444 0.316682 5.7722222 0.316658 5.7750000 0.316632
+ 5.7777778 0.316604 5.7805556 0.316575 5.7833333 0.316547 5.7861111 0.316519
+ 5.7888889 0.316491 5.7916667 0.316465 5.7944444 0.316439 5.7972222 0.316414
+ 5.8000000 0.316390 5.8027778 0.316366 5.8055556 0.316342 5.8083333 0.316317
+ 5.8111111 0.316293 5.8138889 0.316268 5.8166667 0.316242 5.8194444 0.316216
+ 5.8222222 0.316189 5.8250000 0.316162 5.8277778 0.316134 5.8305556 0.316105
+ 5.8333333 0.316076 5.8361111 0.316046 5.8388889 0.316017 5.8416667 0.315989
+ 5.8444444 0.315962 5.8472222 0.315935 5.8500000 0.315908 5.8527778 0.315883
+ 5.8555556 0.315857 5.8583333 0.315833 5.8611111 0.315808 5.8638889 0.315784
+ 5.8666667 0.315760 5.8694444 0.315736 5.8722222 0.315712 5.8750000 0.315688
+ 5.8777778 0.315664 5.8805556 0.315640 5.8833333 0.315614 5.8861111 0.315589
+ 5.8888889 0.315563 5.8916667 0.315536 5.8944444 0.315509 5.8972222 0.315482
+ 5.9000000 0.315455 5.9027778 0.315427 5.9055556 0.315400 5.9083333 0.315373
+ 5.9111111 0.315346 5.9138889 0.315320 5.9166667 0.315294 5.9194444 0.315269
+ 5.9222222 0.315244 5.9250000 0.315221 5.9277778 0.315198 5.9305556 0.315175
+ 5.9333333 0.315153 5.9361111 0.315131 5.9388889 0.315110 5.9416667 0.315088
+ 5.9444444 0.315066 5.9472222 0.315043 5.9500000 0.315019 5.9527778 0.314994
+ 5.9555556 0.314969 5.9583333 0.314942 5.9611111 0.314914 5.9638889 0.314888
+ 5.9666667 0.314863 5.9694444 0.314838 5.9722222 0.314815 5.9750000 0.314793
+ 5.9777778 0.314771 5.9805556 0.314751 5.9833333 0.314731 5.9861111 0.314712
+ 5.9888889 0.314694 5.9916667 0.314676 5.9944444 0.314658 5.9972222 0.314640
+ 6.0000000 0.314622 6.0027778 0.314604 6.0055556 0.314586 6.0083333 0.314566
+ 6.0111111 0.314545 6.0138889 0.314524 6.0166667 0.314501 6.0194444 0.314477
+ 6.0222222 0.314451 6.0250000 0.314425 6.0277778 0.314400 6.0305556 0.314376
+ 6.0333333 0.314353 6.0361111 0.314331 6.0388889 0.314310 6.0416667 0.314288
+ 6.0444444 0.314266 6.0472222 0.314244 6.0500000 0.314221 6.0527778 0.314197
+ 6.0555556 0.314173 6.0583333 0.314148 6.0611111 0.314122 6.0638889 0.314097
+ 6.0666667 0.314071 6.0694444 0.314045 6.0722222 0.314019 6.0750000 0.313993
+ 6.0777778 0.313967 6.0805556 0.313942 6.0833333 0.313917 6.0861111 0.313892
+ 6.0888889 0.313868 6.0916667 0.313845 6.0944444 0.313822 6.0972222 0.313800
+ 6.1000000 0.313778 6.1027778 0.313757 6.1055556 0.313736 6.1083333 0.313716
+ 6.1111111 0.313696 6.1138889 0.313677 6.1166667 0.313657 6.1194444 0.313636
+ 6.1222222 0.313615 6.1250000 0.313594 6.1277778 0.313571 6.1305556 0.313547
+ 6.1333333 0.313523 6.1361111 0.313498 6.1388889 0.313475 6.1416667 0.313452
+ 6.1444444 0.313430 6.1472222 0.313409 6.1500000 0.313388 6.1527778 0.313369
+ 6.1555556 0.313349 6.1583333 0.313330 6.1611111 0.313312 6.1638889 0.313293
+ 6.1666667 0.313274 6.1694444 0.313255 6.1722222 0.313236 6.1750000 0.313216
+ 6.1777778 0.313196 6.1805556 0.313175 6.1833333 0.313153 6.1861111 0.313130
+ 6.1888889 0.313107 6.1916667 0.313083 6.1944444 0.313059 6.1972222 0.313037
+ 6.2000000 0.313016 6.2027778 0.312995 6.2055556 0.312975 6.2083333 0.312956
+ 6.2111111 0.312937 6.2138889 0.312918 6.2166667 0.312899 6.2194444 0.312880
+ 6.2222222 0.312861 6.2250000 0.312840 6.2277778 0.312820 6.2305556 0.312798
+ 6.2333333 0.312775 6.2361111 0.312752 6.2388889 0.312730 6.2416667 0.312709
+ 6.2444444 0.312689 6.2472222 0.312670 6.2500000 0.312651 6.2527778 0.312633
+ 6.2555556 0.312614 6.2583333 0.312594 6.2611111 0.312573 6.2638889 0.312551
+ 6.2666667 0.312528 6.2694444 0.312506 6.2722222 0.312486 6.2750000 0.312466
+ 6.2777778 0.312448 6.2805556 0.312430 6.2833333 0.312413 6.2861111 0.312395
+ 6.2888889 0.312377 6.2916667 0.312359 6.2944444 0.312339 6.2972222 0.312318
+ 6.3000000 0.312296 6.3027778 0.312274 6.3055556 0.312254 6.3083333 0.312236
+ 6.3111111 0.312219 6.3138889 0.312203 6.3166667 0.312188 6.3194444 0.312174
+ 6.3222222 0.312160 6.3250000 0.312146 6.3277778 0.312131 6.3305556 0.312116
+ 6.3333333 0.312101 6.3361111 0.312083 6.3388889 0.312065 6.3416667 0.312045
+ 6.3444444 0.312024 6.3472222 0.312002 6.3500000 0.311982 6.3527778 0.311964
+ 6.3555556 0.311946 6.3583333 0.311929 6.3611111 0.311913 6.3638889 0.311897
+ 6.3666667 0.311881 6.3694444 0.311865 6.3722222 0.311849 6.3750000 0.311833
+ 6.3777778 0.311816 6.3805556 0.311798 6.3833333 0.311780 6.3861111 0.311762
+ 6.3888889 0.311743 6.3916667 0.311724 6.3944444 0.311705 6.3972222 0.311686
+ 6.4000000 0.311667 6.4027778 0.311648 6.4055556 0.311630 6.4083333 0.311613
+ 6.4111111 0.311596 6.4138889 0.311581 6.4166667 0.311566 6.4194444 0.311552
+ 6.4222222 0.311539 6.4250000 0.311527 6.4277778 0.311514 6.4305556 0.311501
+ 6.4333333 0.311487 6.4361111 0.311473 6.4388889 0.311457 6.4416667 0.311439
+ 6.4444444 0.311419 6.4472222 0.311399 6.4500000 0.311382 6.4527778 0.311367
+ 6.4555556 0.311355 6.4583333 0.311345 6.4611111 0.311337 6.4638889 0.311331
+ 6.4666667 0.311327 6.4694444 0.311324 6.4722222 0.311321 6.4750000 0.311319
+ 6.4777778 0.311317 6.4805556 0.311315 6.4833333 0.311312 6.4861111 0.311308
+ 6.4888889 0.311303 6.4916667 0.311297 6.4944444 0.311288 6.4972222 0.311278
+ 6.5000000 0.311266 6.5027778 0.311253 6.5055556 0.311238 6.5083333 0.311222
+ 6.5111111 0.311204 6.5138889 0.311186 6.5166667 0.311166 6.5194444 0.311146
+ 6.5222222 0.311127 6.5250000 0.311109 6.5277778 0.311093 6.5305556 0.311079
+ 6.5333333 0.311066 6.5361111 0.311055 6.5388889 0.311046 6.5416667 0.311039
+ 6.5444444 0.311033 6.5472222 0.311028 6.5500000 0.311024 6.5527778 0.311019
+ 6.5555556 0.311014 6.5583333 0.311008 6.5611111 0.311000 6.5638889 0.310990
+ 6.5666667 0.310977 6.5694444 0.310962 6.5722222 0.310946 6.5750000 0.310929
+ 6.5777778 0.310912 6.5805556 0.310896 6.5833333 0.310882 6.5861111 0.310873
+ 6.5888889 0.310868 6.5916667 0.310870 6.5944444 0.310880 6.5972222 0.310898
+ 6.6000000 0.310925 6.6027778 0.310961 6.6055556 0.311006 6.6083333 0.311058
+ 6.6111111 0.311116 6.6138889 0.311177 6.6166667 0.311238 6.6194444 0.311294
+ 6.6222222 0.311342 6.6250000 0.311375 6.6277778 0.311389 6.6305556 0.311378
+ 6.6333333 0.311376 6.6361111 0.311409 6.6388889 0.311478 6.6416667 0.311585
+ 6.6444444 0.311729 6.6472222 0.311909 6.6500000 0.312117 6.6527778 0.312347
+ 6.6555556 0.312588 6.6583333 0.312827 6.6611111 0.313052 6.6638889 0.313247
+ 6.6666667 0.313401 6.6694444 0.313502 6.6722222 0.313541 6.6750000 0.313518
+ 6.6777778 0.313560 6.6805556 0.313664 6.6833333 0.313819 6.6861111 0.314013
+ 6.6888889 0.314233 6.6916667 0.314463 6.6944444 0.314692 6.6972222 0.314907
+ 6.7000000 0.315098 6.7027778 0.315259 6.7055556 0.315386 6.7083333 0.315476
+ 6.7111111 0.315530 6.7138889 0.315549 6.7166667 0.315537 6.7194444 0.315519
+ 6.7222222 0.315523 6.7250000 0.315545 6.7277778 0.315580 6.7305556 0.315622
+ 6.7333333 0.315668 6.7361111 0.315715 6.7388889 0.315759 6.7416667 0.315798
+ 6.7444444 0.315830 6.7472222 0.315855 6.7500000 0.315871 6.7527778 0.315880
+ 6.7555556 0.315880 6.7583333 0.315873 6.7611111 0.315860 6.7638889 0.315842
+ 6.7666667 0.315820 6.7694444 0.315794 6.7722222 0.315767 6.7750000 0.315739
+ 6.7777778 0.315710 6.7805556 0.315682 6.7833333 0.315654 6.7861111 0.315628
+ 6.7888889 0.315603 6.7916667 0.315579 6.7944444 0.315557 6.7972222 0.315535
+ 6.8000000 0.315514 6.8027778 0.315493 6.8055556 0.315472 6.8083333 0.315451
+ 6.8111111 0.315428 6.8138889 0.315404 6.8166667 0.315379 6.8194444 0.315352
+ 6.8222222 0.315324 6.8250000 0.315298 6.8277778 0.315273 6.8305556 0.315250
+ 6.8333333 0.315228 6.8361111 0.315207 6.8388889 0.315187 6.8416667 0.315167
+ 6.8444444 0.315147 6.8472222 0.315127 6.8500000 0.315105 6.8527778 0.315083
+ 6.8555556 0.315059 6.8583333 0.315034 6.8611111 0.315007 6.8638889 0.314980
+ 6.8666667 0.314954 6.8694444 0.314930 6.8722222 0.314907 6.8750000 0.314886
+ 6.8777778 0.314865 6.8805556 0.314844 6.8833333 0.314824 6.8861111 0.314804
+ 6.8888889 0.314784 6.8916667 0.314763 6.8944444 0.314741 6.8972222 0.314719
+ 6.9000000 0.314695 6.9027778 0.314670 6.9055556 0.314643 6.9083333 0.314618
+ 6.9111111 0.314594 6.9138889 0.314573 6.9166667 0.314553 6.9194444 0.314536
+ 6.9222222 0.314520 6.9250000 0.314506 6.9277778 0.314493 6.9305556 0.314481
+ 6.9333333 0.314469 6.9361111 0.314459 6.9388889 0.314448 6.9416667 0.314437
+ 6.9444444 0.314426 6.9472222 0.314414 6.9500000 0.314401 6.9527778 0.314387
+ 6.9555556 0.314371 6.9583333 0.314354 6.9611111 0.314335 6.9638889 0.314314
+ 6.9666667 0.314291 6.9694444 0.314266 6.9722222 0.314241 6.9750000 0.314217
+ 6.9777778 0.314195 6.9805556 0.314176 6.9833333 0.314158 6.9861111 0.314143
+ 6.9888889 0.314129 6.9916667 0.314117 6.9944444 0.314106 6.9972222 0.314097
+ 7.0000000 0.314088 7.0027778 0.314080 7.0055556 0.314073 7.0083333 0.314066
+ 7.0111111 0.314058 7.0138889 0.314050 7.0166667 0.314041 7.0194444 0.314031
+ 7.0222222 0.314019 7.0250000 0.314005 7.0277778 0.313990 7.0305556 0.313972
+ 7.0333333 0.313952 7.0361111 0.313930 7.0388889 0.313905 7.0416667 0.313881
+ 7.0444444 0.313859 7.0472222 0.313839 7.0500000 0.313822 7.0527778 0.313806
+ 7.0555556 0.313792 7.0583333 0.313779 7.0611111 0.313767 7.0638889 0.313754
+ 7.0666667 0.313742 7.0694444 0.313729 7.0722222 0.313716 7.0750000 0.313702
+ 7.0777778 0.313687 7.0805556 0.313670 7.0833333 0.313652 7.0861111 0.313634
+ 7.0888889 0.313614 7.0916667 0.313593 7.0944444 0.313571 7.0972222 0.313547
+ 7.1000000 0.313523 7.1027778 0.313499 7.1055556 0.313474 7.1083333 0.313450
+ 7.1111111 0.313427 7.1138889 0.313403 7.1166667 0.313380 7.1194444 0.313357
+ 7.1222222 0.313334 7.1250000 0.313310 7.1277778 0.313287 7.1305556 0.313263
+ 7.1333333 0.313239 7.1361111 0.313214 7.1388889 0.313190 7.1416667 0.313166
+ 7.1444444 0.313141 7.1472222 0.313118 7.1500000 0.313094 7.1527778 0.313072
+ 7.1555556 0.313050 7.1583333 0.313030 7.1611111 0.313010 7.1638889 0.312991
+ 7.1666667 0.312973 7.1694444 0.312956 7.1722222 0.312939 7.1750000 0.312922
+ 7.1777778 0.312905 7.1805556 0.312888 7.1833333 0.312870 7.1861111 0.312852
+ 7.1888889 0.312832 7.1916667 0.312812 7.1944444 0.312791 7.1972222 0.312769
+ 7.2000000 0.312745 7.2027778 0.312722 7.2055556 0.312701 7.2083333 0.312680
+ 7.2111111 0.312660 7.2138889 0.312641 7.2166667 0.312623 7.2194444 0.312604
+ 7.2222222 0.312587 7.2250000 0.312569 7.2277778 0.312551 7.2305556 0.312533
+ 7.2333333 0.312515 7.2361111 0.312497 7.2388889 0.312479 7.2416667 0.312462
+ 7.2444444 0.312444 7.2472222 0.312427 7.2500000 0.312410 7.2527778 0.312394
+ 7.2555556 0.312378 7.2583333 0.312363 7.2611111 0.312348 7.2638889 0.312333
+ 7.2666667 0.312319 7.2694444 0.312304 7.2722222 0.312289 7.2750000 0.312274
+ 7.2777778 0.312258 7.2805556 0.312240 7.2833333 0.312221 7.2861111 0.312200
+ 7.2888889 0.312178 7.2916667 0.312158 7.2944444 0.312141 7.2972222 0.312126
+ 7.3000000 0.312114 7.3027778 0.312104 7.3055556 0.312096 7.3083333 0.312090
+ 7.3111111 0.312084 7.3138889 0.312080 7.3166667 0.312076 7.3194444 0.312073
+ 7.3222222 0.312069 7.3250000 0.312065 7.3277778 0.312060 7.3305556 0.312054
+ 7.3333333 0.312047 7.3361111 0.312039 7.3388889 0.312029 7.3416667 0.312018
+ 7.3444444 0.312006 7.3472222 0.311993 7.3500000 0.311977 7.3527778 0.311961
+ 7.3555556 0.311943 7.3583333 0.311923 7.3611111 0.311901 7.3638889 0.311881
+ 7.3666667 0.311863 7.3694444 0.311848 7.3722222 0.311836 7.3750000 0.311827
+ 7.3777778 0.311821 7.3805556 0.311817 7.3833333 0.311816 7.3861111 0.311816
+ 7.3888889 0.311817 7.3916667 0.311818 7.3944444 0.311817 7.3972222 0.311815
+ 7.4000000 0.311809 7.4027778 0.311800 7.4055556 0.311786 7.4083333 0.311769
+ 7.4111111 0.311747 7.4138889 0.311729 7.4166667 0.311713 7.4194444 0.311698
+ 7.4222222 0.311684 7.4250000 0.311668 7.4277778 0.311649 7.4305556 0.311630
+ 7.4333333 0.311617 7.4361111 0.311612 7.4388889 0.311615 7.4416667 0.311629
+ 7.4444444 0.311653 7.4472222 0.311686 7.4500000 0.311729 7.4527778 0.311779
+ 7.4555556 0.311835 7.4583333 0.311892 7.4611111 0.311948 7.4638889 0.311999
+ 7.4666667 0.312038 7.4694444 0.312062 7.4722222 0.312065 7.4750000 0.312043
+ 7.4777778 0.312051 7.4805556 0.312094 7.4833333 0.312171 7.4861111 0.312285
+ 7.4888889 0.312434 7.4916667 0.312612 7.4944444 0.312815 7.4972222 0.313032
+ 7.5000000 0.313252 7.5027778 0.313463 7.5055556 0.313651 7.5083333 0.313803
+ 7.5111111 0.313908 7.5138889 0.313957 7.5166667 0.313944 7.5194444 0.313967
+ 7.5222222 0.314048 7.5250000 0.314178 7.5277778 0.314345 7.5305556 0.314537
+ 7.5333333 0.314740 7.5361111 0.314943 7.5388889 0.315133 7.5416667 0.315305
+ 7.5444444 0.315451 7.5472222 0.315567 7.5500000 0.315653 7.5527778 0.315707
+ 7.5555556 0.315730 7.5583333 0.315726 7.5611111 0.315697 7.5638889 0.315689
+ 7.5666667 0.315699 7.5694444 0.315722 7.5722222 0.315754 7.5750000 0.315791
+ 7.5777778 0.315831 7.5805556 0.315870 7.5833333 0.315906 7.5861111 0.315937
+ 7.5888889 0.315962 7.5916667 0.315980 7.5944444 0.315991 7.5972222 0.315995
+ 7.6000000 0.315992 7.6027778 0.315983 7.6055556 0.315968 7.6083333 0.315948
+ 7.6111111 0.315924 7.6138889 0.315898 7.6166667 0.315869 7.6194444 0.315840
+ 7.6222222 0.315812 7.6250000 0.315784 7.6277778 0.315755 7.6305556 0.315726
+ 7.6333333 0.315698 7.6361111 0.315671 7.6388889 0.315644 7.6416667 0.315618
+ 7.6444444 0.315593 7.6472222 0.315569 7.6500000 0.315545 7.6527778 0.315521
+ 7.6555556 0.315497 7.6583333 0.315472 7.6611111 0.315448 7.6638889 0.315423
+ 7.6666667 0.315397 7.6694444 0.315371 7.6722222 0.315345 7.6750000 0.315318
+ 7.6777778 0.315290 7.6805556 0.315262 7.6833333 0.315234 7.6861111 0.315208
+ 7.6888889 0.315182 7.6916667 0.315157 7.6944444 0.315132 7.6972222 0.315108
+ 7.7000000 0.315085 7.7027778 0.315062 7.7055556 0.315040 7.7083333 0.315018
+ 7.7111111 0.314997 7.7138889 0.314975 7.7166667 0.314953 7.7194444 0.314931
+ 7.7222222 0.314908 7.7250000 0.314885 7.7277778 0.314862 7.7305556 0.314839
+ 7.7333333 0.314815 7.7361111 0.314791 7.7388889 0.314767 7.7416667 0.314743
+ 7.7444444 0.314719 7.7472222 0.314695 7.7500000 0.314671 7.7527778 0.314647
+ 7.7555556 0.314624 7.7583333 0.314602 7.7611111 0.314580 7.7638889 0.314559
+ 7.7666667 0.314538 7.7694444 0.314518 7.7722222 0.314498 7.7750000 0.314479
+ 7.7777778 0.314459 7.7805556 0.314440 7.7833333 0.314420 7.7861111 0.314399
+ 7.7888889 0.314377 7.7916667 0.314354 7.7944444 0.314329 7.7972222 0.314303
+ 7.8000000 0.314279 7.8027778 0.314258 7.8055556 0.314239 7.8083333 0.314222
+ 7.8111111 0.314207 7.8138889 0.314193 7.8166667 0.314182 7.8194444 0.314171
+ 7.8222222 0.314160 7.8250000 0.314149 7.8277778 0.314138 7.8305556 0.314126
+ 7.8333333 0.314112 7.8361111 0.314098 7.8388889 0.314081 7.8416667 0.314063
+ 7.8444444 0.314044 7.8472222 0.314022 7.8500000 0.313999 7.8527778 0.313975
+ 7.8555556 0.313949 7.8583333 0.313925 7.8611111 0.313902 7.8638889 0.313880
+ 7.8666667 0.313859 7.8694444 0.313840 7.8722222 0.313821 7.8750000 0.313803
+ 7.8777778 0.313785 7.8805556 0.313767 7.8833333 0.313750 7.8861111 0.313732
+ 7.8888889 0.313715 7.8916667 0.313697 7.8944444 0.313678 7.8972222 0.313659
+ 7.9000000 0.313639 7.9027778 0.313618 7.9055556 0.313597 7.9083333 0.313574
+ 7.9111111 0.313552 7.9138889 0.313528 7.9166667 0.313504 7.9194444 0.313480
+ 7.9222222 0.313455 7.9250000 0.313431 7.9277778 0.313406 7.9305556 0.313381
+ 7.9333333 0.313357 7.9361111 0.313332 7.9388889 0.313308 7.9416667 0.313283
+ 7.9444444 0.313259 7.9472222 0.313235 7.9500000 0.313211 7.9527778 0.313187
+ 7.9555556 0.313164 7.9583333 0.313140 7.9611111 0.313118 7.9638889 0.313095
+ 7.9666667 0.313073 7.9694444 0.313051 7.9722222 0.313030 7.9750000 0.313008
+ 7.9777778 0.312987 7.9805556 0.312966 7.9833333 0.312946 7.9861111 0.312925
+ 7.9888889 0.312904 7.9916667 0.312883 7.9944444 0.312862 7.9972222 0.312840
+ 8.0000000 0.312818 8.0027778 0.312796 8.0055556 0.312773 8.0083333 0.312750
+ 8.0111111 0.312726 8.0138889 0.312703 8.0166667 0.312681 8.0194444 0.312658
+ 8.0222222 0.312636 8.0250000 0.312614 8.0277778 0.312591 8.0305556 0.312569
+ 8.0333333 0.312546 8.0361111 0.312523 8.0388889 0.312500 8.0416667 0.312477
+ 8.0444444 0.312454 8.0472222 0.312431 8.0500000 0.312408 8.0527778 0.312386
+ 8.0555556 0.312365 8.0583333 0.312344 8.0611111 0.312324 8.0638889 0.312305
+ 8.0666667 0.312287 8.0694444 0.312270 8.0722222 0.312254 8.0750000 0.312239
+ 8.0777778 0.312225 8.0805556 0.312212 8.0833333 0.312200 8.0861111 0.312188
+ 8.0888889 0.312176 8.0916667 0.312165 8.0944444 0.312152 8.0972222 0.312138
+ 8.1000000 0.312123 8.1027778 0.312107 8.1055556 0.312088 8.1083333 0.312067
+ 8.1111111 0.312046 8.1138889 0.312028 8.1166667 0.312013 8.1194444 0.312002
+ 8.1222222 0.311993 8.1250000 0.311986 8.1277778 0.311982 8.1305556 0.311979
+ 8.1333333 0.311977 8.1361111 0.311976 8.1388889 0.311975 8.1416667 0.311974
+ 8.1444444 0.311971 8.1472222 0.311968 8.1500000 0.311964 8.1527778 0.311958
+ 8.1555556 0.311950 8.1583333 0.311940 8.1611111 0.311929 8.1638889 0.311916
+ 8.1666667 0.311901 8.1694444 0.311884 8.1722222 0.311866 8.1750000 0.311846
+ 8.1777778 0.311825 8.1805556 0.311804 8.1833333 0.311786 8.1861111 0.311769
+ 8.1888889 0.311755 8.1916667 0.311744 8.1944444 0.311735 8.1972222 0.311728
+ 8.2000000 0.311724 8.2027778 0.311722 8.2055556 0.311721 8.2083333 0.311721
+ 8.2111111 0.311720 8.2138889 0.311718 8.2166667 0.311714 8.2194444 0.311708
+ 8.2222222 0.311700 8.2250000 0.311689 8.2277778 0.311675 8.2305556 0.311660
+ 8.2333333 0.311643 8.2361111 0.311627 8.2388889 0.311612 8.2416667 0.311599
+ 8.2444444 0.311590 8.2472222 0.311587 8.2500000 0.311590 8.2527778 0.311600
+ 8.2555556 0.311618 8.2583333 0.311644 8.2611111 0.311677 8.2638889 0.311716
+ 8.2666667 0.311759 8.2694444 0.311804 8.2722222 0.311848 8.2750000 0.311887
+ 8.2777778 0.311916 8.2805556 0.311931 8.2833333 0.311927 8.2861111 0.311910
+ 8.2888889 0.311921 8.2916667 0.311964 8.2944444 0.312039 8.2972222 0.312148
+ 8.3000000 0.312290 8.3027778 0.312459 8.3055556 0.312651 8.3083333 0.312855
+ 8.3111111 0.313062 8.3138889 0.313258 8.3166667 0.313432 8.3194444 0.313569
+ 8.3222222 0.313660 8.3250000 0.313697 8.3277778 0.313675 8.3305556 0.313705
+ 8.3333333 0.313788 8.3361111 0.313916 8.3388889 0.314076 8.3416667 0.314256
+ 8.3444444 0.314444 8.3472222 0.314629 8.3500000 0.314801 8.3527778 0.314954
+ 8.3555556 0.315083 8.3583333 0.315185 8.3611111 0.315257 8.3638889 0.315301
+ 8.3666667 0.315318 8.3694444 0.315309 8.3722222 0.315283 8.3750000 0.315276
+ 8.3777778 0.315283 8.3805556 0.315302 8.3833333 0.315327 8.3861111 0.315357
+ 8.3888889 0.315388 8.3916667 0.315417 8.3944444 0.315443 8.3972222 0.315464
+ 8.4000000 0.315480 8.4027778 0.315489 8.4055556 0.315492 8.4083333 0.315490
+ 8.4111111 0.315482 8.4138889 0.315469 8.4166667 0.315453 8.4194444 0.315433
+ 8.4222222 0.315411 8.4250000 0.315387 8.4277778 0.315362 8.4305556 0.315337
+ 8.4333333 0.315312 8.4361111 0.315287 8.4388889 0.315263 8.4416667 0.315239
+ 8.4444444 0.315216 8.4472222 0.315194 8.4500000 0.315172 8.4527778 0.315151
+ 8.4555556 0.315130 8.4583333 0.315110 8.4611111 0.315089 8.4638889 0.315068
+ 8.4666667 0.315046 8.4694444 0.315024 8.4722222 0.315001 8.4750000 0.314977
+ 8.4777778 0.314952 8.4805556 0.314927 8.4833333 0.314901 8.4861111 0.314873
+ 8.4888889 0.314846 8.4916667 0.314821 8.4944444 0.314796 8.4972222 0.314772
+ 8.5000000 0.314749 8.5027778 0.314727 8.5055556 0.314705 8.5083333 0.314684
+ 8.5111111 0.314664 8.5138889 0.314644 8.5166667 0.314624 8.5194444 0.314604
+ 8.5222222 0.314583 8.5250000 0.314563 8.5277778 0.314542 8.5305556 0.314521
+ 8.5333333 0.314500 8.5361111 0.314478 8.5388889 0.314456 8.5416667 0.314433
+ 8.5444444 0.314411 8.5472222 0.314389 8.5500000 0.314366 8.5527778 0.314344
+ 8.5555556 0.314322 8.5583333 0.314300 8.5611111 0.314279 8.5638889 0.314258
+ 8.5666667 0.314238 8.5694444 0.314217 8.5722222 0.314197 8.5750000 0.314177
+ 8.5777778 0.314156 8.5805556 0.314135 8.5833333 0.314113 8.5861111 0.314091
+ 8.5888889 0.314068 8.5916667 0.314044 8.5944444 0.314019 8.5972222 0.313993
+ 8.6000000 0.313970 8.6027778 0.313947 8.6055556 0.313927 8.6083333 0.313907
+ 8.6111111 0.313890 8.6138889 0.313873 8.6166667 0.313857 8.6194444 0.313843
+ 8.6222222 0.313828 8.6250000 0.313814 8.6277778 0.313801 8.6305556 0.313787
+ 8.6333333 0.313773 8.6361111 0.313758 8.6388889 0.313743 8.6416667 0.313727
+ 8.6444444 0.313710 8.6472222 0.313692 8.6500000 0.313672 8.6527778 0.313650
+ 8.6555556 0.313627 8.6583333 0.313602 8.6611111 0.313578 8.6638889 0.313557
+ 8.6666667 0.313537 8.6694444 0.313519 8.6722222 0.313501 8.6750000 0.313485
+ 8.6777778 0.313468 8.6805556 0.313452 8.6833333 0.313435 8.6861111 0.313418
+ 8.6888889 0.313400 8.6916667 0.313382 8.6944444 0.313363 8.6972222 0.313342
+ 8.7000000 0.313321 8.7027778 0.313299 8.7055556 0.313277 8.7083333 0.313254
+ 8.7111111 0.313230 8.7138889 0.313205 8.7166667 0.313181 8.7194444 0.313158
+ 8.7222222 0.313135 8.7250000 0.313112 8.7277778 0.313089 8.7305556 0.313066
+ 8.7333333 0.313043 8.7361111 0.313020 8.7388889 0.312996 8.7416667 0.312973
+ 8.7444444 0.312949 8.7472222 0.312925 8.7500000 0.312901 8.7527778 0.312877
+ 8.7555556 0.312854 8.7583333 0.312830 8.7611111 0.312806 8.7638889 0.312783
+ 8.7666667 0.312759 8.7694444 0.312736 8.7722222 0.312713 8.7750000 0.312690
+ 8.7777778 0.312668 8.7805556 0.312646 8.7833333 0.312624 8.7861111 0.312603
+ 8.7888889 0.312582 8.7916667 0.312561 8.7944444 0.312541 8.7972222 0.312521
+ 8.8000000 0.312502 8.8027778 0.312482 8.8055556 0.312462 8.8083333 0.312441
+ 8.8111111 0.312421 8.8138889 0.312399 8.8166667 0.312377 8.8194444 0.312355
+ 8.8222222 0.312332 8.8250000 0.312311 8.8277778 0.312290 8.8305556 0.312269
+ 8.8333333 0.312249 8.8361111 0.312230 8.8388889 0.312210 8.8416667 0.312191
+ 8.8444444 0.312172 8.8472222 0.312153 8.8500000 0.312135 8.8527778 0.312116
+ 8.8555556 0.312098 8.8583333 0.312080 8.8611111 0.312063 8.8638889 0.312046
+ 8.8666667 0.312031 8.8694444 0.312016 8.8722222 0.312002 8.8750000 0.311990
+ 8.8777778 0.311978 8.8805556 0.311966 8.8833333 0.311955 8.8861111 0.311943
+ 8.8888889 0.311931 8.8916667 0.311917 8.8944444 0.311901 8.8972222 0.311883
+ 8.9000000 0.311863 8.9027778 0.311842 8.9055556 0.311825 8.9083333 0.311811
+ 8.9111111 0.311801 8.9138889 0.311793 8.9166667 0.311789 8.9194444 0.311787
+ 8.9222222 0.311786 8.9250000 0.311787 8.9277778 0.311789 8.9305556 0.311791
+ 8.9333333 0.311793 8.9361111 0.311794 8.9388889 0.311794 8.9416667 0.311792
+ 8.9444444 0.311789 8.9472222 0.311783 8.9500000 0.311774 8.9527778 0.311763
+ 8.9555556 0.311749 8.9583333 0.311733 8.9611111 0.311714 8.9638889 0.311692
+ 8.9666667 0.311673 8.9694444 0.311656 8.9722222 0.311642 8.9750000 0.311630
+ 8.9777778 0.311621 8.9805556 0.311614 8.9833333 0.311610 8.9861111 0.311608
+ 8.9888889 0.311607 8.9916667 0.311608 8.9944444 0.311608 8.9972222 0.311608
+ 9.0000000 0.311607 9.0027778 0.311603 9.0055556 0.311596 9.0083333 0.311586
+ 9.0111111 0.311572 9.0138889 0.311554 9.0166667 0.311534 9.0194444 0.311514
+ 9.0222222 0.311496 9.0250000 0.311479 9.0277778 0.311460 9.0305556 0.311439
+ 9.0333333 0.311422 9.0361111 0.311409 9.0388889 0.311404 9.0416667 0.311406
+ 9.0444444 0.311416 9.0472222 0.311435 9.0500000 0.311463 9.0527778 0.311499
+ 9.0555556 0.311541 9.0583333 0.311587 9.0611111 0.311635 9.0638889 0.311682
+ 9.0666667 0.311723 9.0694444 0.311755 9.0722222 0.311772 9.0750000 0.311772
+ 9.0777778 0.311752 9.0805556 0.311759 9.0833333 0.311797 9.0861111 0.311867
+ 9.0888889 0.311969 9.0916667 0.312102 9.0944444 0.312262 9.0972222 0.312443
+ 9.1000000 0.312636 9.1027778 0.312832 9.1055556 0.313018 9.1083333 0.313182
+ 9.1111111 0.313313 9.1138889 0.313399 9.1166667 0.313434 9.1194444 0.313413
+ 9.1222222 0.313440 9.1250000 0.313518 9.1277778 0.313639 9.1305556 0.313791
+ 9.1333333 0.313962 9.1361111 0.314140 9.1388889 0.314315 9.1416667 0.314477
+ 9.1444444 0.314621 9.1472222 0.314741 9.1500000 0.314833 9.1527778 0.314898
+ 9.1555556 0.314934 9.1583333 0.314944 9.1611111 0.314930 9.1638889 0.314910
+ 9.1666667 0.314907 9.1694444 0.314918 9.1722222 0.314939 9.1750000 0.314965
+ 9.1777778 0.314995 9.1805556 0.315024 9.1833333 0.315050 9.1861111 0.315073
+ 9.1888889 0.315090 9.1916667 0.315102 9.1944444 0.315107 9.1972222 0.315106
+ 9.2000000 0.315099 9.2027778 0.315088 9.2055556 0.315073 9.2083333 0.315054
+ 9.2111111 0.315033 9.2138889 0.315011 9.2166667 0.314987 9.2194444 0.314963
+ 9.2222222 0.314939 9.2250000 0.314916 9.2277778 0.314893 9.2305556 0.314870
+ 9.2333333 0.314848 9.2361111 0.314825 9.2388889 0.314803 9.2416667 0.314781
+ 9.2444444 0.314758 9.2472222 0.314735 9.2500000 0.314711 9.2527778 0.314687
+ 9.2555556 0.314662 9.2583333 0.314637 9.2611111 0.314611 9.2638889 0.314585
+ 9.2666667 0.314559 9.2694444 0.314533 9.2722222 0.314506 9.2750000 0.314480
+ 9.2777778 0.314454 9.2805556 0.314427 9.2833333 0.314401 9.2861111 0.314375
+ 9.2888889 0.314348 9.2916667 0.314322 9.2944444 0.314297 9.2972222 0.314273
+ 9.3000000 0.314249 9.3027778 0.314226 9.3055556 0.314203 9.3083333 0.314181
+ 9.3111111 0.314159 9.3138889 0.314137 9.3166667 0.314115 9.3194444 0.314093
+ 9.3222222 0.314071 9.3250000 0.314048 9.3277778 0.314025 9.3305556 0.314002
+ 9.3333333 0.313980 9.3361111 0.313958 9.3388889 0.313936 9.3416667 0.313916
+ 9.3444444 0.313896 9.3472222 0.313877 9.3500000 0.313859 9.3527778 0.313842
+ 9.3555556 0.313826 9.3583333 0.313810 9.3611111 0.313794 9.3638889 0.313778
+ 9.3666667 0.313762 9.3694444 0.313745 9.3722222 0.313727 9.3750000 0.313708
+ 9.3777778 0.313687 9.3805556 0.313665 9.3833333 0.313642 9.3861111 0.313617
+ 9.3888889 0.313593 9.3916667 0.313572 9.3944444 0.313552 9.3972222 0.313534
+ 9.4000000 0.313518 9.4027778 0.313503 9.4055556 0.313490 9.4083333 0.313477
+ 9.4111111 0.313465 9.4138889 0.313454 9.4166667 0.313443 9.4194444 0.313432
+ 9.4222222 0.313420 9.4250000 0.313408 9.4277778 0.313395 9.4305556 0.313381
+ 9.4333333 0.313365 9.4361111 0.313348 9.4388889 0.313330 9.4416667 0.313310
+ 9.4444444 0.313288 9.4472222 0.313265 9.4500000 0.313241 9.4527778 0.313219
+ 9.4555556 0.313198 9.4583333 0.313179 9.4611111 0.313162 9.4638889 0.313145
+ 9.4666667 0.313130 9.4694444 0.313115 9.4722222 0.313100 9.4750000 0.313086
+ 9.4777778 0.313071 9.4805556 0.313056 9.4833333 0.313040 9.4861111 0.313023
+ 9.4888889 0.313005 9.4916667 0.312986 9.4944444 0.312965 9.4972222 0.312944
+ 9.5000000 0.312920 9.5027778 0.312897 9.5055556 0.312874 9.5083333 0.312853
+ 9.5111111 0.312832 9.5138889 0.312811 9.5166667 0.312791 9.5194444 0.312771
+ 9.5222222 0.312750 9.5250000 0.312730 9.5277778 0.312709 9.5305556 0.312688
+ 9.5333333 0.312666 9.5361111 0.312643 9.5388889 0.312620 9.5416667 0.312597
+ 9.5444444 0.312574 9.5472222 0.312552 9.5500000 0.312530 9.5527778 0.312509
+ 9.5555556 0.312487 9.5583333 0.312464 9.5611111 0.312442 9.5638889 0.312419
+ 9.5666667 0.312396 9.5694444 0.312374 9.5722222 0.312352 9.5750000 0.312330
+ 9.5777778 0.312308 9.5805556 0.312287 9.5833333 0.312265 9.5861111 0.312244
+ 9.5888889 0.312223 9.5916667 0.312202 9.5944444 0.312181 9.5972222 0.312159
+ 9.6000000 0.312138 9.6027778 0.312116 9.6055556 0.312094 9.6083333 0.312072
+ 9.6111111 0.312050 9.6138889 0.312028 9.6166667 0.312007 9.6194444 0.311987
+ 9.6222222 0.311967 9.6250000 0.311948 9.6277778 0.311931 9.6305556 0.311914
+ 9.6333333 0.311899 9.6361111 0.311885 9.6388889 0.311871 9.6416667 0.311859
+ 9.6444444 0.311847 9.6472222 0.311835 9.6500000 0.311824 9.6527778 0.311813
+ 9.6555556 0.311801 9.6583333 0.311788 9.6611111 0.311773 9.6638889 0.311757
+ 9.6666667 0.311739 9.6694444 0.311718 9.6722222 0.311698 9.6750000 0.311682
+ 9.6777778 0.311669 9.6805556 0.311659 9.6833333 0.311652 9.6861111 0.311648
+ 9.6888889 0.311646 9.6916667 0.311646 9.6944444 0.311647 9.6972222 0.311649
+ 9.7000000 0.311651 9.7027778 0.311652 9.7055556 0.311652 9.7083333 0.311651
+ 9.7111111 0.311647 9.7138889 0.311642 9.7166667 0.311634 9.7194444 0.311623
+ 9.7222222 0.311609 9.7250000 0.311592 9.7277778 0.311573 9.7305556 0.311552
+ 9.7333333 0.311534 9.7361111 0.311518 9.7388889 0.311504 9.7416667 0.311493
+ 9.7444444 0.311483 9.7472222 0.311475 9.7500000 0.311468 9.7527778 0.311463
+ 9.7555556 0.311459 9.7583333 0.311456 9.7611111 0.311453 9.7638889 0.311450
+ 9.7666667 0.311446 9.7694444 0.311439 9.7722222 0.311431 9.7750000 0.311420
+ 9.7777778 0.311406 9.7805556 0.311388 9.7833333 0.311369 9.7861111 0.311348
+ 9.7888889 0.311330 9.7916667 0.311312 9.7944444 0.311293 9.7972222 0.311272
+ 9.8000000 0.311254 9.8027778 0.311241 9.8055556 0.311233 9.8083333 0.311231
+ 9.8111111 0.311237 9.8138889 0.311251 9.8166667 0.311273 9.8194444 0.311302
+ 9.8222222 0.311338 9.8250000 0.311379 9.8277778 0.311424 9.8305556 0.311470
+ 9.8333333 0.311513 9.8361111 0.311551 9.8388889 0.311579 9.8416667 0.311594
+ 9.8444444 0.311589 9.8472222 0.311573 9.8500000 0.311583 9.8527778 0.311622
+ 9.8555556 0.311693 9.8583333 0.311794 9.8611111 0.311925 9.8638889 0.312083
+ 9.8666667 0.312260 9.8694444 0.312449 9.8722222 0.312641 9.8750000 0.312823
+ 9.8777778 0.312984 9.8805556 0.313111 9.8833333 0.313195 9.8861111 0.313227
+ 9.8888889 0.313205 9.8916667 0.313234 9.8944444 0.313313 9.8972222 0.313435
+ 9.9000000 0.313588 9.9027778 0.313761 9.9055556 0.313941 9.9083333 0.314118
+ 9.9111111 0.314282 9.9138889 0.314428 9.9166667 0.314549 9.9194444 0.314643
+ 9.9222222 0.314708 9.9250000 0.314745 9.9277778 0.314754 9.9305556 0.314737
+ 9.9333333 0.314722 9.9361111 0.314725 9.9388889 0.314743 9.9416667 0.314772
+ 9.9444444 0.314809 9.9472222 0.314850 9.9500000 0.314891 9.9527778 0.314930
+ 9.9555556 0.314966 9.9583333 0.314995 9.9611111 0.315018 9.9638889 0.315034
+ 9.9666667 0.315041 9.9694444 0.315041 9.9722222 0.315034 9.9750000 0.315021
+ 9.9777778 0.315001 9.9805556 0.314977 9.9833333 0.314950 9.9861111 0.314926
+ 9.9888889 0.314904 9.9916667 0.314884 9.9944444 0.314865 9.9972222 0.314847
+ )

* ---- Threshold ----
Vthresh threshold 0 0.315

* ---- DUT: noise gate + threshold comp + AND + hold ----
* (Bypass envelope circuits — test only the detection path)

Xngate env_fast env_avg noise_gate_out vdd vss vbias noise_gate
Xtcomp env_fast threshold thr_gate_out vdd vss vbias threshold_comp
Xand noise_gate_out thr_gate_out rpeak_raw vdd vss and2_gate
Xhold rpeak_raw rpeak_out vdd vss vbias rpeak_hold

* ---- Simulation ----
.tran 50u 10.0 0 50u

* ---- Measurements ----
.meas tran det1 when v(rpeak_out)=0.45 rise=1
.meas tran det2 when v(rpeak_out)=0.45 rise=2
.meas tran det3 when v(rpeak_out)=0.45 rise=3
.meas tran det4 when v(rpeak_out)=0.45 rise=4
.meas tran det5 when v(rpeak_out)=0.45 rise=5
.meas tran det6 when v(rpeak_out)=0.45 rise=6
.meas tran det7 when v(rpeak_out)=0.45 rise=7
.meas tran det8 when v(rpeak_out)=0.45 rise=8
.meas tran det9 when v(rpeak_out)=0.45 rise=9
.meas tran det10 when v(rpeak_out)=0.45 rise=10
.meas tran det11 when v(rpeak_out)=0.45 rise=11
.meas tran det12 when v(rpeak_out)=0.45 rise=12
.meas tran det13 when v(rpeak_out)=0.45 rise=13
.meas tran det14 when v(rpeak_out)=0.45 rise=14

.save v(env_fast) v(env_avg) v(noise_gate_out) v(thr_gate_out) v(rpeak_out)

.control
set filetype=ascii
run

echo ""
echo "=== PHASE 1A: DETECTION LOGIC TEST ==="
echo "--- Detection times (SPICE vs Python) ---"
print det1
print det2
print det3
print det4
print det5
print det6
print det7
print det8
print det9
print det10
print det11
print det12
print det13
print det14

wrdata phase1a_results.txt v(env_fast) v(env_avg) v(noise_gate_out) v(thr_gate_out) v(rpeak_out)

echo "=== Done ==="
quit
.endc

.end
