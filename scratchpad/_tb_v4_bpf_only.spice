* Minimal test: HPF + LPF + Differentiator only
* Synthetic ramp input: 3 beats at 0.5s, 1.0s, 1.5s

.lib C:/Users/kadhi/OneDrive/Desktop/amux/verilogLearning/Leaky-Integrate-Fire---SNN-model-on-FPGA/experiments/frontend_optimization/ngspice_frontend/sky130_minimal.lib.spice tt
.include C:/Users/kadhi/OneDrive/Desktop/amux/verilogLearning/Leaky-Integrate-Fire---SNN-model-on-FPGA/experiments/frontend_optimization/complete_frontend_v9b/rpeak_detector_v4.spice
.option scale=1.0u method=gear reltol=0.01 gmin=1e-15

Vdd vdd 0 0.9
Vss vss 0 0.0
Vbias vbias 0 0.40

* Synthetic ECG: flat 0.30V + 3 triangular QRS complexes (200mV amplitude)
* Beat 1: upslope 0.485-0.500s, downslope 0.500-0.520s
* Beat 2: upslope 0.985-1.000s, downslope 1.000-1.020s
* Beat 3: upslope 1.485-1.500s, downslope 1.500-1.520s
Vecg ecg_in 0 pwl(
+ 0.0000 0.300 0.4849 0.300
+ 0.4850 0.300 0.5000 0.500 0.5200 0.300
+ 0.5201 0.300 0.9849 0.300
+ 0.9850 0.300 1.0000 0.500 1.0200 0.300
+ 1.0201 0.300 1.4849 0.300
+ 1.4850 0.300 1.5000 0.500 1.5200 0.300
+ 1.5201 0.300 2.000 0.300
+ )

* Test only first 3 stages
Xhpf ecg_in v_hpf vdd vss vbias hpf_5hz
Xlpf v_hpf v_bpf vdd vss vbias lpf_15hz
Xdiff v_bpf rect_out vdd vss vbias diff_rect

.ic v(v_hpf)=0.3000
.ic v(v_bpf)=0.3000
.ic v(xdiff.diff_node)=0.4000
.ic v(rect_out)=0.4000

.save v(ecg_in) v(v_hpf) v(v_bpf) v(xdiff.diff_node) v(rect_out)

.tran 0.1m 2.0 uic

.control
run
wrdata scratchpad/_v4_bpf_data.txt v(ecg_in) v(v_hpf) v(v_bpf) v(xdiff.diff_node) v(rect_out)
quit
.endc

.end
