* ============================================================
* TESTBENCH: Envelope Detection Path (Phase 1)
* ============================================================
* Record 100, 10.0s, 13 Python detections
*
* Python detection times (for comparison):
* Detection 1: sample=8, t=0.0222s
* Detection 2: sample=370, t=1.0278s
* Detection 3: sample=663, t=1.8417s
* Detection 4: sample=947, t=2.6306s
* Detection 5: sample=1231, t=3.4194s
* Detection 6: sample=1515, t=4.2083s
* Detection 7: sample=1809, t=5.0250s
* Detection 8: sample=2045, t=5.6806s
* Detection 9: sample=2403, t=6.6750s
* Detection 10: sample=2706, t=7.5167s
* Detection 11: sample=2998, t=8.3278s
* Detection 12: sample=3283, t=9.1194s
* Detection 13: sample=3560, t=9.8889s
* ============================================================

.lib C:/Users/kadhi/OneDrive/Desktop/amux/verilogLearning/Leaky-Integrate-Fire---SNN-model-on-FPGA/experiments/frontend_optimization/ngspice_frontend/sky130_minimal.lib.spice tt

.include C:/Users/kadhi/OneDrive/Desktop/amux/verilogLearning/Leaky-Integrate-Fire---SNN-model-on-FPGA/experiments/frontend_optimization/complete_frontend_v9b/inverter.spice
.include C:/Users/kadhi/OneDrive/Desktop/amux/verilogLearning/Leaky-Integrate-Fire---SNN-model-on-FPGA/experiments/frontend_optimization/complete_frontend_v9b/rpeak_hold.spice
.include C:/Users/kadhi/OneDrive/Desktop/amux/verilogLearning/Leaky-Integrate-Fire---SNN-model-on-FPGA/experiments/frontend_optimization/complete_frontend_v9b/rpeak_detector_v2.spice

.option scale=1.0u method=gear reltol=0.01 gmin=1e-15

* ---- Power supplies ----
Vdd vdd 0 0.9
Vss vss 0 0.0
Vbias vbias 0 0.300

* ---- Input: rectified derivative from Python ----
Vrect rect_in 0 PWL(
+ 0.0000000 0.300000 0.0027778 0.304505 0.0055556 0.304754 0.0083333 0.304919
+ 0.0111111 0.305012 0.0138889 0.305044 0.0166667 0.305030 0.0194444 0.304983
+ 0.0222222 0.304920 0.0250000 0.304864 0.0277778 0.304844 0.0305556 0.304882
+ 0.0333333 0.304978 0.0361111 0.305116 0.0388889 0.305264 0.0416667 0.305383
+ 0.0444444 0.305424 0.0472222 0.305326 0.0500000 0.305027 0.0527778 0.304475
+ 0.0555556 0.303648 0.0583333 0.302547 0.0611111 0.301189 0.0638889 0.300401
+ 0.0666667 0.302179 0.0694444 0.304063 0.0722222 0.305926 0.0750000 0.307616
+ 0.0777778 0.308991 0.0805556 0.309948 0.0833333 0.310429 0.0861111 0.310413
+ 0.0888889 0.309909 0.0916667 0.308951 0.0944444 0.307603 0.0972222 0.305955
+ 0.1000000 0.304122 0.1027778 0.302228 0.1055556 0.300397 0.1083333 0.301259
+ 0.1111111 0.302639 0.1138889 0.303638 0.1166667 0.304150 0.1194444 0.304066
+ 0.1222222 0.303291 0.1250000 0.301760 0.1277778 0.300560 0.1305556 0.303661
+ 0.1333333 0.307492 0.1361111 0.311952 0.1388889 0.316873 0.1416667 0.322018
+ 0.1444444 0.327096 0.1472222 0.331777 0.1500000 0.335710 0.1527778 0.338536
+ 0.1555556 0.339888 0.1583333 0.339411 0.1611111 0.336782 0.1638889 0.331744
+ 0.1666667 0.324138 0.1694444 0.313938 0.1722222 0.301265 0.1750000 0.313586
+ 0.1777778 0.330127 0.1805556 0.347689 0.1833333 0.365426 0.1861111 0.382327
+ 0.1888889 0.397241 0.1916667 0.408935 0.1944444 0.416211 0.1972222 0.418039
+ 0.2000000 0.413677 0.2027778 0.402782 0.2055556 0.385505 0.2083333 0.362577
+ 0.2111111 0.335339 0.2138889 0.305673 0.2166667 0.324186 0.2194444 0.351930
+ 0.2222222 0.375502 0.2250000 0.393407 0.2277778 0.404899 0.2305556 0.409981
+ 0.2333333 0.409232 0.2361111 0.403575 0.2388889 0.394066 0.2416667 0.381761
+ 0.2444444 0.367655 0.2472222 0.352658 0.2500000 0.337592 0.2527778 0.323157
+ 0.2555556 0.309910 0.2583333 0.301748 0.2611111 0.311567 0.2638889 0.319429
+ 0.2666667 0.325320 0.2694444 0.329310 0.2722222 0.331538 0.2750000 0.332202
+ 0.2777778 0.331533 0.2805556 0.329788 0.2833333 0.327231 0.2861111 0.324121
+ 0.2888889 0.320703 0.2916667 0.317194 0.2944444 0.313777 0.2972222 0.310591
+ 0.3000000 0.307722 0.3027778 0.305223 0.3055556 0.303127 0.3083333 0.301464
+ 0.3111111 0.300253 0.3138889 0.300505 0.3166667 0.300838 0.3194444 0.300795
+ 0.3222222 0.300445 0.3250000 0.300133 0.3277778 0.300857 0.3305556 0.301635
+ 0.3333333 0.302380 0.3361111 0.303014 0.3388889 0.303487 0.3416667 0.303778
+ 0.3444444 0.303881 0.3472222 0.303800 0.3500000 0.303544 0.3527778 0.303127
+ 0.3555556 0.302582 0.3583333 0.301957 0.3611111 0.301297 0.3638889 0.300643
+ 0.3666667 0.300031 0.3694444 0.300515 0.3722222 0.300972 0.3750000 0.301329
+ 0.3777778 0.301587 0.3805556 0.301763 0.3833333 0.301884 0.3861111 0.301976
+ 0.3888889 0.302051 0.3916667 0.302104 0.3944444 0.302124 0.3972222 0.302100
+ 0.4000000 0.302028 0.4027778 0.301911 0.4055556 0.301747 0.4083333 0.301538
+ 0.4111111 0.301291 0.4138889 0.301024 0.4166667 0.300761 0.4194444 0.300528
+ 0.4222222 0.300341 0.4250000 0.300209 0.4277778 0.300131 0.4305556 0.300109
+ 0.4333333 0.300151 0.4361111 0.300265 0.4388889 0.300454 0.4416667 0.300705
+ 0.4444444 0.301001 0.4472222 0.301326 0.4500000 0.301675 0.4527778 0.302046
+ 0.4555556 0.302436 0.4583333 0.302829 0.4611111 0.303200 0.4638889 0.303519
+ 0.4666667 0.303766 0.4694444 0.303932 0.4722222 0.304013 0.4750000 0.304006
+ 0.4777778 0.303911 0.4805556 0.303731 0.4833333 0.303479 0.4861111 0.303171
+ 0.4888889 0.302814 0.4916667 0.302402 0.4944444 0.301921 0.4972222 0.301367
+ 0.5000000 0.300747 0.5027778 0.300073 0.5055556 0.300641 0.5083333 0.301385
+ 0.5111111 0.302146 0.5138889 0.302906 0.5166667 0.303635 0.5194444 0.304304
+ 0.5222222 0.304893 0.5250000 0.305401 0.5277778 0.305836 0.5305556 0.306193
+ 0.5333333 0.306457 0.5361111 0.306606 0.5388889 0.306629 0.5416667 0.306527
+ 0.5444444 0.306305 0.5472222 0.305967 0.5500000 0.305512 0.5527778 0.304935
+ 0.5555556 0.304240 0.5583333 0.303438 0.5611111 0.302560 0.5638889 0.301638
+ 0.5666667 0.300701 0.5694444 0.300233 0.5722222 0.301145 0.5750000 0.302008
+ 0.5777778 0.302791 0.5805556 0.303469 0.5833333 0.304033 0.5861111 0.304485
+ 0.5888889 0.304826 0.5916667 0.305056 0.5944444 0.305179 0.5972222 0.305197
+ 0.6000000 0.305114 0.6027778 0.304935 0.6055556 0.304660 0.6083333 0.304298
+ 0.6111111 0.303858 0.6138889 0.303355 0.6166667 0.302802 0.6194444 0.302214
+ 0.6222222 0.301609 0.6250000 0.300998 0.6277778 0.300394 0.6305556 0.300182
+ 0.6333333 0.300701 0.6361111 0.301134 0.6388889 0.301467 0.6416667 0.301700
+ 0.6444444 0.301842 0.6472222 0.301897 0.6500000 0.301866 0.6527778 0.301754
+ 0.6555556 0.301575 0.6583333 0.301356 0.6611111 0.301130 0.6638889 0.300926
+ 0.6666667 0.300760 0.6694444 0.300645 0.6722222 0.300595 0.6750000 0.300624
+ 0.6777778 0.300743 0.6805556 0.300949 0.6833333 0.301223 0.6861111 0.301536
+ 0.6888889 0.301853 0.6916667 0.302144 0.6944444 0.302376 0.6972222 0.302511
+ 0.7000000 0.302518 0.7027778 0.302380 0.7055556 0.302099 0.7083333 0.301698
+ 0.7111111 0.301209 0.7138889 0.300663 0.7166667 0.300083 0.7194444 0.300508
+ 0.7222222 0.301082 0.7250000 0.301611 0.7277778 0.302075 0.7305556 0.302463
+ 0.7333333 0.302777 0.7361111 0.303025 0.7388889 0.303207 0.7416667 0.303312
+ 0.7444444 0.303325 0.7472222 0.303251 0.7500000 0.303111 0.7527778 0.302933
+ 0.7555556 0.302734 0.7583333 0.302517 0.7611111 0.302283 0.7638889 0.302044
+ 0.7666667 0.301826 0.7694444 0.301659 0.7722222 0.301570 0.7750000 0.301573
+ 0.7777778 0.301664 0.7805556 0.301832 0.7833333 0.302056 0.7861111 0.302312
+ 0.7888889 0.302571 0.7916667 0.302792 0.7944444 0.302935 0.7972222 0.302961
+ 0.8000000 0.302838 0.8027778 0.302547 0.8055556 0.302068 0.8083333 0.301377
+ 0.8111111 0.300459 0.8138889 0.300681 0.8166667 0.302010 0.8194444 0.303473
+ 0.8222222 0.305010 0.8250000 0.306565 0.8277778 0.308083 0.8305556 0.309517
+ 0.8333333 0.310821 0.8361111 0.311946 0.8388889 0.312838 0.8416667 0.313452
+ 0.8444444 0.313754 0.8472222 0.313721 0.8500000 0.313338 0.8527778 0.312617
+ 0.8555556 0.311589 0.8583333 0.310304 0.8611111 0.308818 0.8638889 0.307179
+ 0.8666667 0.305417 0.8694444 0.303554 0.8722222 0.301607 0.8750000 0.300404
+ 0.8777778 0.302453 0.8805556 0.304510 0.8833333 0.306540 0.8861111 0.308500
+ 0.8888889 0.310337 0.8916667 0.311978 0.8944444 0.313324 0.8972222 0.314257
+ 0.9000000 0.314678 0.9027778 0.314530 0.9055556 0.313816 0.9083333 0.312584
+ 0.9111111 0.310915 0.9138889 0.308929 0.9166667 0.306771 0.9194444 0.304601
+ 0.9222222 0.302577 0.9250000 0.300842 0.9277778 0.300467 0.9305556 0.301227
+ 0.9333333 0.301318 0.9361111 0.300635 0.9388889 0.300907 0.9416667 0.303351
+ 0.9444444 0.306694 0.9472222 0.310884 0.9500000 0.315807 0.9527778 0.321280
+ 0.9555556 0.327047 0.9583333 0.332775 0.9611111 0.338075 0.9638889 0.342518
+ 0.9666667 0.345664 0.9694444 0.347074 0.9722222 0.346320 0.9750000 0.343003
+ 0.9777778 0.336794 0.9805556 0.327480 0.9833333 0.315003 0.9861111 0.300514
+ 0.9888889 0.318744 0.9916667 0.339128 0.9944444 0.360860 0.9972222 0.382895
+ 1.0000000 0.403973 1.0027778 0.422672 1.0055556 0.437497 1.0083333 0.447013
+ 1.0111111 0.450000 1.0138889 0.445579 1.0166667 0.433322 1.0194444 0.413357
+ 1.0222222 0.386459 1.0250000 0.354064 1.0277778 0.318180 1.0305556 0.318796
+ 1.0333333 0.354325 1.0361111 0.386005 1.0388889 0.411848 1.0416667 0.430514
+ 1.0444444 0.441410 1.0472222 0.444654 1.0500000 0.440921 1.0527778 0.431280
+ 1.0555556 0.417031 1.0583333 0.399556 1.0611111 0.380190 1.0638889 0.360136
+ 1.0666667 0.340419 1.0694444 0.321878 1.0722222 0.305161 1.0750000 0.309272
+ 1.0777778 0.321149 1.0805556 0.330362 1.0833333 0.336945 1.0861111 0.341044
+ 1.0888889 0.342901 1.0916667 0.342827 1.0944444 0.341176 1.0972222 0.338316
+ 1.1000000 0.334594 1.1027778 0.330323 1.1055556 0.325777 1.1083333 0.321199
+ 1.1111111 0.316796 1.1138889 0.312728 1.1166667 0.309110 1.1194444 0.306020
+ 1.1222222 0.303510 1.1250000 0.301602 1.1277778 0.300287 1.1305556 0.300483
+ 1.1333333 0.300782 1.1361111 0.300702 1.1388889 0.300335 1.1416667 0.300243
+ 1.1444444 0.300967 1.1472222 0.301772 1.1500000 0.302595 1.1527778 0.303375
+ 1.1555556 0.304063 1.1583333 0.304622 1.1611111 0.305026 1.1638889 0.305253
+ 1.1666667 0.305288 1.1694444 0.305132 1.1722222 0.304798 1.1750000 0.304313
+ 1.1777778 0.303713 1.1805556 0.303029 1.1833333 0.302287 1.1861111 0.301509
+ 1.1888889 0.300724 1.1916667 0.300035 1.1944444 0.300736 1.1972222 0.301360
+ 1.2000000 0.301908 1.2027778 0.302385 1.2055556 0.302794 1.2083333 0.303125
+ 1.2111111 0.303365 1.2138889 0.303509 1.2166667 0.303567 1.2194444 0.303560
+ 1.2222222 0.303504 1.2250000 0.303403 1.2277778 0.303257 1.2305556 0.303068
+ 1.2333333 0.302852 1.2361111 0.302638 1.2388889 0.302449 1.2416667 0.302296
+ 1.2444444 0.302180 1.2472222 0.302107 1.2500000 0.302089 1.2527778 0.302139
+ 1.2555556 0.302267 1.2583333 0.302470 1.2611111 0.302742 1.2638889 0.303076
+ 1.2666667 0.303466 1.2694444 0.303903 1.2722222 0.304371 1.2750000 0.304842
+ 1.2777778 0.305282 1.2805556 0.305658 1.2833333 0.305952 1.2861111 0.306148
+ 1.2888889 0.306223 1.2916667 0.306143 1.2944444 0.305874 1.2972222 0.305393
+ 1.3000000 0.304694 1.3027778 0.303779 1.3055556 0.302656 1.3083333 0.301335
+ 1.3111111 0.300170 1.3138889 0.301823 1.3166667 0.303567 1.3194444 0.305330
+ 1.3222222 0.307038 1.3250000 0.308622 1.3277778 0.310020 1.3305556 0.311167
+ 1.3333333 0.312000 1.3361111 0.312468 1.3388889 0.312541 1.3416667 0.312223
+ 1.3444444 0.311543 1.3472222 0.310543 1.3500000 0.309271 1.3527778 0.307776
+ 1.3555556 0.306124 1.3583333 0.304393 1.3611111 0.302661 1.3638889 0.300992
+ 1.3666667 0.300571 1.3694444 0.302000 1.3722222 0.303268 1.3750000 0.304345
+ 1.3777778 0.305205 1.3805556 0.305834 1.3833333 0.306238 1.3861111 0.306438
+ 1.3888889 0.306455 1.3916667 0.306304 1.3944444 0.305997 1.3972222 0.305554
+ 1.4000000 0.305007 1.4027778 0.304396 1.4055556 0.303750 1.4083333 0.303088
+ 1.4111111 0.302421 1.4138889 0.301764 1.4166667 0.301142 1.4194444 0.300583
+ 1.4222222 0.300108 1.4250000 0.300272 1.4277778 0.300551 1.4305556 0.300723
+ 1.4333333 0.300785 1.4361111 0.300737 1.4388889 0.300592 1.4416667 0.300379
+ 1.4444444 0.300134 1.4472222 0.300117 1.4500000 0.300359 1.4527778 0.300585
+ 1.4555556 0.300783 1.4583333 0.300937 1.4611111 0.301034 1.4638889 0.301066
+ 1.4666667 0.301032 1.4694444 0.300934 1.4722222 0.300772 1.4750000 0.300540
+ 1.4777778 0.300239 1.4805556 0.300126 1.4833333 0.300533 1.4861111 0.300960
+ 1.4888889 0.301382 1.4916667 0.301784 1.4944444 0.302157 1.4972222 0.302489
+ 1.5000000 0.302761 1.5027778 0.302947 1.5055556 0.303032 1.5083333 0.303013
+ 1.5111111 0.302899 1.5138889 0.302701 1.5166667 0.302423 1.5194444 0.302068
+ 1.5222222 0.301653 1.5250000 0.301205 1.5277778 0.300757 1.5305556 0.300330
+ 1.5333333 0.300065 1.5361111 0.300422 1.5388889 0.300729 1.5416667 0.300968
+ 1.5444444 0.301123 1.5472222 0.301196 1.5500000 0.301209 1.5527778 0.301195
+ 1.5555556 0.301189 1.5583333 0.301215 1.5611111 0.301288 1.5638889 0.301420
+ 1.5666667 0.301619 1.5694444 0.301887 1.5722222 0.302218 1.5750000 0.302591
+ 1.5777778 0.302980 1.5805556 0.303365 1.5833333 0.303733 1.5861111 0.304081
+ 1.5888889 0.304399 1.5916667 0.304671 1.5944444 0.304876 1.5972222 0.304995
+ 1.6000000 0.305024 1.6027778 0.304959 1.6055556 0.304795 1.6083333 0.304517
+ 1.6111111 0.304103 1.6138889 0.303539 1.6166667 0.302814 1.6194444 0.301923
+ 1.6222222 0.300865 1.6250000 0.300354 1.6277778 0.301716 1.6305556 0.303184
+ 1.6333333 0.304702 1.6361111 0.306203 1.6388889 0.307617 1.6416667 0.308886
+ 1.6444444 0.309971 1.6472222 0.310845 1.6500000 0.311489 1.6527778 0.311887
+ 1.6555556 0.312034 1.6583333 0.311936 1.6611111 0.311604 1.6638889 0.311053
+ 1.6666667 0.310298 1.6694444 0.309359 1.6722222 0.308265 1.6750000 0.307058
+ 1.6777778 0.305789 1.6805556 0.304507 1.6833333 0.303244 1.6861111 0.302011
+ 1.6888889 0.300814 1.6916667 0.300342 1.6944444 0.301456 1.6972222 0.302529
+ 1.7000000 0.303579 1.7027778 0.304632 1.7055556 0.305709 1.7083333 0.306805
+ 1.7111111 0.307875 1.7138889 0.308838 1.7166667 0.309596 1.7194444 0.310068
+ 1.7222222 0.310205 1.7250000 0.309992 1.7277778 0.309440 1.7305556 0.308595
+ 1.7333333 0.307535 1.7361111 0.306377 1.7388889 0.305258 1.7416667 0.304321
+ 1.7444444 0.303702 1.7472222 0.303532 1.7500000 0.303938 1.7527778 0.305021
+ 1.7555556 0.306838 1.7583333 0.309388 1.7611111 0.312610 1.7638889 0.316395
+ 1.7666667 0.320585 1.7694444 0.324978 1.7722222 0.329313 1.7750000 0.333277
+ 1.7777778 0.336512 1.7805556 0.338634 1.7833333 0.339265 1.7861111 0.338047
+ 1.7888889 0.334656 1.7916667 0.328819 1.7944444 0.320348 1.7972222 0.309187
+ 1.8000000 0.304555 1.8027778 0.320579 1.8055556 0.338385 1.8083333 0.357260
+ 1.8111111 0.376283 1.8138889 0.394338 1.8166667 0.410159 1.8194444 0.422390
+ 1.8222222 0.429694 1.8250000 0.430913 1.8277778 0.425224 1.8305556 0.412276
+ 1.8333333 0.392282 1.8361111 0.366105 1.8388889 0.335298 1.8416667 0.302030
+ 1.8444444 0.331134 1.8472222 0.361564 1.8500000 0.386971 1.8527778 0.405792
+ 1.8555556 0.417381 1.8583333 0.421941 1.8611111 0.420253 1.8638889 0.413381
+ 1.8666667 0.402470 1.8694444 0.388652 1.8722222 0.373000 1.8750000 0.356501
+ 1.8777778 0.340029 1.8805556 0.324322 1.8833333 0.309970 1.8861111 0.302587
+ 1.8888889 0.313063 1.8916667 0.321318 1.8944444 0.327348 1.8972222 0.331255
+ 1.9000000 0.333225 1.9027778 0.333504 1.9055556 0.332377 1.9083333 0.330156
+ 1.9111111 0.327155 1.9138889 0.323671 1.9166667 0.319973 1.9194444 0.316290
+ 1.9222222 0.312819 1.9250000 0.309717 1.9277778 0.307096 1.9305556 0.305018
+ 1.9333333 0.303493 1.9361111 0.302494 1.9388889 0.301973 1.9416667 0.301873
+ 1.9444444 0.302129 1.9472222 0.302657 1.9500000 0.303359 1.9527778 0.304130
+ 1.9555556 0.304874 1.9583333 0.305513 1.9611111 0.305987 1.9638889 0.306244
+ 1.9666667 0.306244 1.9694444 0.305969 1.9722222 0.305431 1.9750000 0.304666
+ 1.9777778 0.303724 1.9805556 0.302659 1.9833333 0.301530 1.9861111 0.300390
+ 1.9888889 0.300702 1.9916667 0.301684 1.9944444 0.302500 1.9972222 0.303112
+ 2.0000000 0.303505 2.0027778 0.303687 2.0055556 0.303676 2.0083333 0.303493
+ 2.0111111 0.303160 2.0138889 0.302706 2.0166667 0.302173 2.0194444 0.301608
+ 2.0222222 0.301054 2.0250000 0.300542 2.0277778 0.300092 2.0305556 0.300281
+ 2.0333333 0.300549 2.0361111 0.300684 2.0388889 0.300663 2.0416667 0.300480
+ 2.0444444 0.300141 2.0472222 0.300342 2.0500000 0.300955 2.0527778 0.301673
+ 2.0555556 0.302466 2.0583333 0.303294 2.0611111 0.304118 2.0638889 0.304897
+ 2.0666667 0.305602 2.0694444 0.306213 2.0722222 0.306709 2.0750000 0.307072
+ 2.0777778 0.307286 2.0805556 0.307341 2.0833333 0.307232 2.0861111 0.306960
+ 2.0888889 0.306520 2.0916667 0.305906 2.0944444 0.305108 2.0972222 0.304125
+ 2.1000000 0.302974 2.1027778 0.301683 2.1055556 0.300286 2.1083333 0.301187
+ 2.1111111 0.302701 2.1138889 0.304217 2.1166667 0.305684 2.1194444 0.307041
+ 2.1222222 0.308224 2.1250000 0.309178 2.1277778 0.309863 2.1305556 0.310247
+ 2.1333333 0.310313 2.1361111 0.310060 2.1388889 0.309512 2.1416667 0.308713
+ 2.1444444 0.307716 2.1472222 0.306576 2.1500000 0.305335 2.1527778 0.304033
+ 2.1555556 0.302708 2.1583333 0.301403 2.1611111 0.300163 2.1638889 0.300974
+ 2.1666667 0.301981 2.1694444 0.302841 2.1722222 0.303534 2.1750000 0.304049
+ 2.1777778 0.304374 2.1805556 0.304513 2.1833333 0.304479 2.1861111 0.304297
+ 2.1888889 0.303995 2.1916667 0.303602 2.1944444 0.303143 2.1972222 0.302643
+ 2.2000000 0.302136 2.2027778 0.301663 2.2055556 0.301258 2.2083333 0.300941
+ 2.2111111 0.300717 2.2138889 0.300587 2.2166667 0.300556 2.2194444 0.300622
+ 2.2222222 0.300768 2.2250000 0.300962 2.2277778 0.301166 2.2305556 0.301350
+ 2.2333333 0.301498 2.2361111 0.301602 2.2388889 0.301647 2.2416667 0.301619
+ 2.2444444 0.301507 2.2472222 0.301313 2.2500000 0.301058 2.2527778 0.300766
+ 2.2555556 0.300456 2.2583333 0.300131 2.2611111 0.300211 2.2638889 0.300570
+ 2.2666667 0.300937 2.2694444 0.301293 2.2722222 0.301620 2.2750000 0.301900
+ 2.2777778 0.302118 2.2805556 0.302258 2.2833333 0.302309 2.2861111 0.302262
+ 2.2888889 0.302125 2.2916667 0.301918 2.2944444 0.301671 2.2972222 0.301410
+ 2.3000000 0.301157 2.3027778 0.300925 2.3055556 0.300727 2.3083333 0.300580
+ 2.3111111 0.300502 2.3138889 0.300500 2.3166667 0.300562 2.3194444 0.300662
+ 2.3222222 0.300777 2.3250000 0.300886 2.3277778 0.300974 2.3305556 0.301021
+ 2.3333333 0.301002 2.3361111 0.300887 2.3388889 0.300650 2.3416667 0.300283
+ 2.3444444 0.300204 2.3472222 0.300791 2.3500000 0.301463 2.3527778 0.302205
+ 2.3555556 0.302999 2.3583333 0.303807 2.3611111 0.304582 2.3638889 0.305277
+ 2.3666667 0.305857 2.3694444 0.306300 2.3722222 0.306587 2.3750000 0.306697
+ 2.3777778 0.306616 2.3805556 0.306340 2.3833333 0.305888 2.3861111 0.305282
+ 2.3888889 0.304538 2.3916667 0.303666 2.3944444 0.302678 2.3972222 0.301593
+ 2.4000000 0.300438 2.4027778 0.300751 2.4055556 0.301941 2.4083333 0.303106
+ 2.4111111 0.304217 2.4138889 0.305248 2.4166667 0.306169 2.4194444 0.306954
+ 2.4222222 0.307590 2.4250000 0.308081 2.4277778 0.308444 2.4305556 0.308693
+ 2.4333333 0.308834 2.4361111 0.308874 2.4388889 0.308823 2.4416667 0.308698
+ 2.4444444 0.308513 2.4472222 0.308273 2.4500000 0.307978 2.4527778 0.307623
+ 2.4555556 0.307212 2.4583333 0.306755 2.4611111 0.306257 2.4638889 0.305713
+ 2.4666667 0.305097 2.4694444 0.304372 2.4722222 0.303502 2.4750000 0.302460
+ 2.4777778 0.301232 2.4805556 0.300191 2.4833333 0.301799 2.4861111 0.303568
+ 2.4888889 0.305447 2.4916667 0.307359 2.4944444 0.309192 2.4972222 0.310805
+ 2.5000000 0.312048 2.5027778 0.312785 2.5055556 0.312927 2.5083333 0.312431
+ 2.5111111 0.311310 2.5138889 0.309631 2.5166667 0.307518 2.5194444 0.305137
+ 2.5222222 0.302677 2.5250000 0.300327 2.5277778 0.301727 2.5305556 0.303307
+ 2.5333333 0.304241 2.5361111 0.304375 2.5388889 0.303585 2.5416667 0.301793
+ 2.5444444 0.301025 2.5472222 0.304840 2.5500000 0.309569 2.5527778 0.315070
+ 2.5555556 0.321120 2.5583333 0.327414 2.5611111 0.333581 2.5638889 0.339208
+ 2.5666667 0.343861 2.5694444 0.347097 2.5722222 0.348470 2.5750000 0.347547
+ 2.5777778 0.343948 2.5805556 0.337389 2.5833333 0.327728 2.5861111 0.315003
+ 2.5888889 0.300553 2.5916667 0.318502 2.5944444 0.338205 2.5972222 0.358824
+ 2.6000000 0.379314 2.6027778 0.398446 2.6055556 0.414861 2.6083333 0.427193
+ 2.6111111 0.434196 2.6138889 0.434868 2.6166667 0.428548 2.6194444 0.415010
+ 2.6222222 0.394558 2.6250000 0.368110 2.6277778 0.337232 2.6305556 0.304058
+ 2.6333333 0.328928 2.6361111 0.359205 2.6388889 0.384578 2.6416667 0.403520
+ 2.6444444 0.415368 2.6472222 0.420281 2.6500000 0.419004 2.6527778 0.412585
+ 2.6555556 0.402158 2.6583333 0.388829 2.6611111 0.373641 2.6638889 0.357553
+ 2.6666667 0.341428 2.6694444 0.326001 2.6722222 0.311855 2.6750000 0.300591
+ 2.6777778 0.311070 2.6805556 0.319446 2.6833333 0.325694 2.6861111 0.329889
+ 2.6888889 0.332192 2.6916667 0.332837 2.6944444 0.332103 2.6972222 0.330283
+ 2.7000000 0.327662 2.7027778 0.324507 2.7055556 0.321065 2.7083333 0.317558
+ 2.7111111 0.314169 2.7138889 0.311038 2.7166667 0.308262 2.7194444 0.305905
+ 2.7222222 0.303999 2.7250000 0.302560 2.7277778 0.301586 2.7305556 0.301051
+ 2.7333333 0.300905 2.7361111 0.301079 2.7388889 0.301496 2.7416667 0.302075
+ 2.7444444 0.302741 2.7472222 0.303420 2.7500000 0.304040 2.7527778 0.304537
+ 2.7555556 0.304864 2.7583333 0.304999 2.7611111 0.304943 2.7638889 0.304712
+ 2.7666667 0.304326 2.7694444 0.303807 2.7722222 0.303177 2.7750000 0.302473
+ 2.7777778 0.301730 2.7805556 0.300980 2.7833333 0.300241 2.7861111 0.300472
+ 2.7888889 0.301137 2.7916667 0.301729 2.7944444 0.302227 2.7972222 0.302624
+ 2.8000000 0.302927 2.8027778 0.303148 2.8055556 0.303290 2.8083333 0.303351
+ 2.8111111 0.303329 2.8138889 0.303239 2.8166667 0.303102 2.8194444 0.302940
+ 2.8222222 0.302766 2.8250000 0.302593 2.8277778 0.302436 2.8305556 0.302310
+ 2.8333333 0.302226 2.8361111 0.302185 2.8388889 0.302185 2.8416667 0.302221
+ 2.8444444 0.302289 2.8472222 0.302393 2.8500000 0.302539 2.8527778 0.302726
+ 2.8555556 0.302938 2.8583333 0.303152 2.8611111 0.303350 2.8638889 0.303525
+ 2.8666667 0.303674 2.8694444 0.303789 2.8722222 0.303847 2.8750000 0.303823
+ 2.8777778 0.303694 2.8805556 0.303449 2.8833333 0.303080 2.8861111 0.302573
+ 2.8888889 0.301914 2.8916667 0.301092 2.8944444 0.300111 2.8972222 0.300999
+ 2.9000000 0.302188 2.9027778 0.303398 2.9055556 0.304572 2.9083333 0.305660
+ 2.9111111 0.306611 2.9138889 0.307373 2.9166667 0.307897 2.9194444 0.308158
+ 2.9222222 0.308153 2.9250000 0.307902 2.9277778 0.307431 2.9305556 0.306760
+ 2.9333333 0.305911 2.9361111 0.304912 2.9388889 0.303808 2.9416667 0.302648
+ 2.9444444 0.301474 2.9472222 0.300325 2.9500000 0.300760 2.9527778 0.301742
+ 2.9555556 0.302583 2.9583333 0.303248 2.9611111 0.303720 2.9638889 0.304000
+ 2.9666667 0.304107 2.9694444 0.304066 2.9722222 0.303897 2.9750000 0.303622
+ 2.9777778 0.303269 2.9805556 0.302875 2.9833333 0.302480 2.9861111 0.302114
+ 2.9888889 0.301787 2.9916667 0.301493 2.9944444 0.301227 2.9972222 0.300992
+ 3.0000000 0.300800 3.0027778 0.300659 3.0055556 0.300571 3.0083333 0.300524
+ 3.0111111 0.300506 3.0138889 0.300508 3.0166667 0.300522 3.0194444 0.300540
+ 3.0222222 0.300548 3.0250000 0.300535 3.0277778 0.300498 3.0305556 0.300438
+ 3.0333333 0.300358 3.0361111 0.300253 3.0388889 0.300109 3.0416667 0.300088
+ 3.0444444 0.300334 3.0472222 0.300607 3.0500000 0.300872 3.0527778 0.301104
+ 3.0555556 0.301292 3.0583333 0.301436 3.0611111 0.301540 3.0638889 0.301604
+ 3.0666667 0.301627 3.0694444 0.301616 3.0722222 0.301587 3.0750000 0.301564
+ 3.0777778 0.301562 3.0805556 0.301585 3.0833333 0.301622 3.0861111 0.301661
+ 3.0888889 0.301693 3.0916667 0.301713 3.0944444 0.301710 3.0972222 0.301662
+ 3.1000000 0.301548 3.1027778 0.301347 3.1055556 0.301054 3.1083333 0.300672
+ 3.1111111 0.300215 3.1138889 0.300299 3.1166667 0.300851 3.1194444 0.301419
+ 3.1222222 0.301977 3.1250000 0.302493 3.1277778 0.302946 3.1305556 0.303327
+ 3.1333333 0.303644 3.1361111 0.303916 3.1388889 0.304158 3.1416667 0.304373
+ 3.1444444 0.304557 3.1472222 0.304703 3.1500000 0.304802 3.1527778 0.304840
+ 3.1555556 0.304795 3.1583333 0.304643 3.1611111 0.304369 3.1638889 0.303975
+ 3.1666667 0.303483 3.1694444 0.302916 3.1722222 0.302292 3.1750000 0.301617
+ 3.1777778 0.300899 3.1805556 0.300149 3.1833333 0.300617 3.1861111 0.301388
+ 3.1888889 0.302164 3.1916667 0.302939 3.1944444 0.303704 3.1972222 0.304435
+ 3.2000000 0.305104 3.2027778 0.305691 3.2055556 0.306188 3.2083333 0.306609
+ 3.2111111 0.306967 3.2138889 0.307263 3.2166667 0.307491 3.2194444 0.307647
+ 3.2222222 0.307731 3.2250000 0.307739 3.2277778 0.307662 3.2305556 0.307485
+ 3.2333333 0.307199 3.2361111 0.306800 3.2388889 0.306303 3.2416667 0.305730
+ 3.2444444 0.305102 3.2472222 0.304427 3.2500000 0.303701 3.2527778 0.302917
+ 3.2555556 0.302076 3.2583333 0.301181 3.2611111 0.300228 3.2638889 0.300796
+ 3.2666667 0.301893 3.2694444 0.303059 3.2722222 0.304282 3.2750000 0.305542
+ 3.2777778 0.306801 3.2805556 0.307994 3.2833333 0.309031 3.2861111 0.309816
+ 3.2888889 0.310270 3.2916667 0.310343 3.2944444 0.310023 3.2972222 0.309327
+ 3.3000000 0.308304 3.3027778 0.307024 3.3055556 0.305571 3.3083333 0.304029
+ 3.3111111 0.302491 3.3138889 0.301058 3.3166667 0.300160 3.3194444 0.301065
+ 3.3222222 0.301580 3.3250000 0.301644 3.3277778 0.301200 3.3305556 0.300199
+ 3.3333333 0.301400 3.3361111 0.303613 3.3388889 0.306419 3.3416667 0.309753
+ 3.3444444 0.313506 3.3472222 0.317530 3.3500000 0.321634 3.3527778 0.325575
+ 3.3555556 0.329069 3.3583333 0.331797 3.3611111 0.333425 3.3638889 0.333627
+ 3.3666667 0.332098 3.3694444 0.328568 3.3722222 0.322821 3.3750000 0.314722
+ 3.3777778 0.304260 3.3805556 0.308427 3.3833333 0.323021 3.3861111 0.339019
+ 3.3888889 0.355718 3.3916667 0.372229 3.3944444 0.387489 3.3972222 0.400307
+ 3.4000000 0.409433 3.4027778 0.413694 3.4055556 0.412142 3.4083333 0.404197
+ 3.4111111 0.389745 3.4138889 0.369236 3.4166667 0.343759 3.4194444 0.315034
+ 3.4222222 0.314738 3.4250000 0.343152 3.4277778 0.367975 3.4305556 0.387504
+ 3.4333333 0.400806 3.4361111 0.407729 3.4388889 0.408731 3.4416667 0.404638
+ 3.4444444 0.396440 3.4472222 0.385156 3.4500000 0.371763 3.4527778 0.357165
+ 3.4555556 0.342168 3.4583333 0.327474 3.4611111 0.313670 3.4638889 0.301227
+ 3.4666667 0.309501 3.4694444 0.318290 3.4722222 0.325046 3.4750000 0.329789
+ 3.4777778 0.332626 3.4805556 0.333723 3.4833333 0.333296 3.4861111 0.331603
+ 3.4888889 0.328929 3.4916667 0.325564 3.4944444 0.321780 3.4972222 0.317825
+ 3.5000000 0.313915 3.5027778 0.310233 3.5055556 0.306931 3.5083333 0.304117
+ 3.5111111 0.301857 3.5138889 0.300165 3.5166667 0.300987 3.5194444 0.301649
+ 3.5222222 0.301874 3.5250000 0.301722 3.5277778 0.301262 3.5305556 0.300577
+ 3.5333333 0.300240 3.5361111 0.301108 3.5388889 0.301961 3.5416667 0.302750
+ 3.5444444 0.303434 3.5472222 0.303984 3.5500000 0.304375 3.5527778 0.304593
+ 3.5555556 0.304634 3.5583333 0.304503 3.5611111 0.304212 3.5638889 0.303776
+ 3.5666667 0.303209 3.5694444 0.302534 3.5722222 0.301788 3.5750000 0.301018
+ 3.5777778 0.300278 3.5805556 0.300385 3.5833333 0.300930 3.5861111 0.301326
+ 3.5888889 0.301552 3.5916667 0.301607 3.5944444 0.301511 3.5972222 0.301307
+ 3.6000000 0.301053 3.6027778 0.300797 3.6055556 0.300571 3.6083333 0.300390
+ 3.6111111 0.300271 3.6138889 0.300234 3.6166667 0.300301 3.6194444 0.300481
+ 3.6222222 0.300774 3.6250000 0.301168 3.6277778 0.301652 3.6305556 0.302217
+ 3.6333333 0.302860 3.6361111 0.303569 3.6388889 0.304312 3.6416667 0.305045
+ 3.6444444 0.305721 3.6472222 0.306303 3.6500000 0.306769 3.6527778 0.307102
+ 3.6555556 0.307285 3.6583333 0.307301 3.6611111 0.307143 3.6638889 0.306822
+ 3.6666667 0.306353 3.6694444 0.305752 3.6722222 0.305029 3.6750000 0.304204
+ 3.6777778 0.303309 3.6805556 0.302373 3.6833333 0.301416 3.6861111 0.300440
+ 3.6888889 0.300567 3.6916667 0.301619 3.6944444 0.302721 3.6972222 0.303853
+ 3.7000000 0.304980 3.7027778 0.306063 3.7055556 0.307068 3.7083333 0.307965
+ 3.7111111 0.308722 3.7138889 0.309296 3.7166667 0.309642 3.7194444 0.309730
+ 3.7222222 0.309552 3.7250000 0.309116 3.7277778 0.308436 3.7305556 0.307524
+ 3.7333333 0.306401 3.7361111 0.305104 3.7388889 0.303690 3.7416667 0.302232
+ 3.7444444 0.300810 3.7472222 0.300508 3.7500000 0.301670 3.7527778 0.302638
+ 3.7555556 0.303385 3.7583333 0.303894 3.7611111 0.304168 3.7638889 0.304227
+ 3.7666667 0.304106 3.7694444 0.303841 3.7722222 0.303466 3.7750000 0.303012
+ 3.7777778 0.302512 3.7805556 0.302007 3.7833333 0.301547 3.7861111 0.301177
+ 3.7888889 0.300928 3.7916667 0.300815 3.7944444 0.300841 3.7972222 0.301002
+ 3.8000000 0.301276 3.8027778 0.301622 3.8055556 0.301991 3.8083333 0.302334
+ 3.8111111 0.302619 3.8138889 0.302826 3.8166667 0.302949 3.8194444 0.302975
+ 3.8222222 0.302888 3.8250000 0.302675 3.8277778 0.302339 3.8305556 0.301903
+ 3.8333333 0.301397 3.8361111 0.300845 3.8388889 0.300266 3.8416667 0.300323
+ 3.8444444 0.300895 3.8472222 0.301421 3.8500000 0.301878 3.8527778 0.302254
+ 3.8555556 0.302549 3.8583333 0.302775 3.8611111 0.302940 3.8638889 0.303045
+ 3.8666667 0.303082 3.8694444 0.303041 3.8722222 0.302920 3.8750000 0.302729
+ 3.8777778 0.302486 3.8805556 0.302212 3.8833333 0.301920 3.8861111 0.301621
+ 3.8888889 0.301326 3.8916667 0.301042 3.8944444 0.300772 3.8972222 0.300514
+ 3.9000000 0.300263 3.9027778 0.300024 3.9055556 0.300193 3.9083333 0.300373
+ 3.9111111 0.300515 3.9138889 0.300641 3.9166667 0.300784 3.9194444 0.300982
+ 3.9222222 0.301259 3.9250000 0.301623 3.9277778 0.302069 3.9305556 0.302591
+ 3.9333333 0.303184 3.9361111 0.303829 3.9388889 0.304488 3.9416667 0.305115
+ 3.9444444 0.305671 3.9472222 0.306127 3.9500000 0.306455 3.9527778 0.306631
+ 3.9555556 0.306631 3.9583333 0.306432 3.9611111 0.306022 3.9638889 0.305400
+ 3.9666667 0.304576 3.9694444 0.303562 3.9722222 0.302368 3.9750000 0.301013
+ 3.9777778 0.300469 3.9805556 0.302020 3.9833333 0.303563 3.9861111 0.305026
+ 3.9888889 0.306345 3.9916667 0.307470 3.9944444 0.308365 3.9972222 0.309007
+ 4.0000000 0.309387 4.0027778 0.309520 4.0055556 0.309441 4.0083333 0.309194
+ 4.0111111 0.308817 4.0138889 0.308342 4.0166667 0.307796 4.0194444 0.307211
+ 4.0222222 0.306623 4.0250000 0.306071 4.0277778 0.305583 4.0305556 0.305174
+ 4.0333333 0.304844 4.0361111 0.304587 4.0388889 0.304384 4.0416667 0.304203
+ 4.0444444 0.303993 4.0472222 0.303691 4.0500000 0.303230 4.0527778 0.302558
+ 4.0555556 0.301647 4.0583333 0.300483 4.0611111 0.300945 4.0638889 0.302629
+ 4.0666667 0.304528 4.0694444 0.306549 4.0722222 0.308551 4.0750000 0.310369
+ 4.0777778 0.311843 4.0805556 0.312855 4.0833333 0.313327 4.0861111 0.313227
+ 4.0888889 0.312550 4.0916667 0.311333 4.0944444 0.309657 4.0972222 0.307647
+ 4.1000000 0.305456 4.1027778 0.303257 4.1055556 0.301225 4.1083333 0.300465
+ 4.1111111 0.301654 4.1138889 0.302206 4.1166667 0.302013 4.1194444 0.301006
+ 4.1222222 0.300839 4.1250000 0.303496 4.1277778 0.306902 4.1305556 0.310952
+ 4.1333333 0.315496 4.1361111 0.320331 4.1388889 0.325194 4.1416667 0.329765
+ 4.1444444 0.333684 4.1472222 0.336583 4.1500000 0.338093 4.1527778 0.337852
+ 4.1555556 0.335513 4.1583333 0.330786 4.1611111 0.323471 4.1638889 0.313493
+ 4.1666667 0.300937 4.1694444 0.313938 4.1722222 0.330677 4.1750000 0.348626
+ 4.1777778 0.366921 4.1805556 0.384516 4.1833333 0.400214 4.1861111 0.412730
+ 4.1888889 0.420803 4.1916667 0.423319 4.1944444 0.419447 4.1972222 0.408745
+ 4.2000000 0.391275 4.2027778 0.367706 4.2055556 0.339375 4.2083333 0.308236
+ 4.2111111 0.323331 4.2138889 0.352830 4.2166667 0.378026 4.2194444 0.397293
+ 4.2222222 0.409816 4.2250000 0.415572 4.2277778 0.415153 4.2305556 0.409514
+ 4.2333333 0.399765 4.2361111 0.387027 4.2388889 0.372355 4.2416667 0.356715
+ 4.2444444 0.340965 4.2472222 0.325837 4.2500000 0.311919 4.2527778 0.300361
+ 4.2555556 0.310731 4.2583333 0.319055 4.2611111 0.325314 4.2638889 0.329578
+ 4.2666667 0.331990 4.2694444 0.332759 4.2722222 0.332148 4.2750000 0.330443
+ 4.2777778 0.327931 4.2805556 0.324876 4.2833333 0.321517 4.2861111 0.318070
+ 4.2888889 0.314725 4.2916667 0.311634 4.2944444 0.308904 4.2972222 0.306589
+ 4.3000000 0.304703 4.3027778 0.303238 4.3055556 0.302172 4.3083333 0.301478
+ 4.3111111 0.301112 4.3138889 0.301008 4.3166667 0.301091 4.3194444 0.301295
+ 4.3222222 0.301566 4.3250000 0.301866 4.3277778 0.302160 4.3305556 0.302414
+ 4.3333333 0.302600 4.3361111 0.302699 4.3388889 0.302714 4.3416667 0.302660
+ 4.3444444 0.302553 4.3472222 0.302396 4.3500000 0.302185 4.3527778 0.301917
+ 4.3555556 0.301600 4.3583333 0.301245 4.3611111 0.300862 4.3638889 0.300450
+ 4.3666667 0.300001 4.3694444 0.300487 4.3722222 0.301001 4.3750000 0.301506
+ 4.3777778 0.301962 4.3805556 0.302337 4.3833333 0.302610 4.3861111 0.302764
+ 4.3888889 0.302779 4.3916667 0.302642 4.3944444 0.302356 4.3972222 0.301947
+ 4.4000000 0.301449 4.4027778 0.300900 4.4055556 0.300336 4.4083333 0.300208
+ 4.4111111 0.300687 4.4138889 0.301059 4.4166667 0.301281 4.4194444 0.301329
+ 4.4222222 0.301192 4.4250000 0.300873 4.4277778 0.300383 4.4305556 0.300264
+ 4.4333333 0.301046 4.4361111 0.301931 4.4388889 0.302878 4.4416667 0.303839
+ 4.4444444 0.304777 4.4472222 0.305662 4.4500000 0.306473 4.4527778 0.307188
+ 4.4555556 0.307773 4.4583333 0.308190 4.4611111 0.308410 4.4638889 0.308420
+ 4.4666667 0.308217 4.4694444 0.307802 4.4722222 0.307168 4.4750000 0.306305
+ 4.4777778 0.305216 4.4805556 0.303913 4.4833333 0.302424 4.4861111 0.300779
+ 4.4888889 0.300990 4.4916667 0.302839 4.4944444 0.304710 4.4972222 0.306530
+ 4.5000000 0.308219 4.5027778 0.309698 4.5055556 0.310900 4.5083333 0.311769
+ 4.5111111 0.312264 4.5138889 0.312358 4.5166667 0.312048 4.5194444 0.311358
+ 4.5222222 0.310345 4.5250000 0.309078 4.5277778 0.307627 4.5305556 0.306051
+ 4.5333333 0.304409 4.5361111 0.302764 4.5388889 0.301190 4.5416667 0.300243
+ 4.5444444 0.301481 4.5472222 0.302494 4.5500000 0.303278 4.5527778 0.303834
+ 4.5555556 0.304171 4.5583333 0.304303 4.5611111 0.304264 4.5638889 0.304094
+ 4.5666667 0.303840 4.5694444 0.303539 4.5722222 0.303220 4.5750000 0.302903
+ 4.5777778 0.302608 4.5805556 0.302361 4.5833333 0.302184 4.5861111 0.302086
+ 4.5888889 0.302060 4.5916667 0.302085 4.5944444 0.302139 4.5972222 0.302206
+ 4.6000000 0.302277 4.6027778 0.302339 4.6055556 0.302375 4.6083333 0.302370
+ 4.6111111 0.302317 4.6138889 0.302226 4.6166667 0.302108 4.6194444 0.301972
+ 4.6222222 0.301816 4.6250000 0.301631 4.6277778 0.301408 4.6305556 0.301148
+ 4.6333333 0.300856 4.6361111 0.300537 4.6388889 0.300190 4.6416667 0.300188
+ 4.6444444 0.300594 4.6472222 0.301013 4.6500000 0.301420 4.6527778 0.301793
+ 4.6555556 0.302114 4.6583333 0.302379 4.6611111 0.302585 4.6638889 0.302728
+ 4.6666667 0.302801 4.6694444 0.302807 4.6722222 0.302754 4.6750000 0.302651
+ 4.6777778 0.302504 4.6805556 0.302314 4.6833333 0.302083 4.6861111 0.301825
+ 4.6888889 0.301564 4.6916667 0.301330 4.6944444 0.301142 4.6972222 0.301001
+ 4.7000000 0.300898 4.7027778 0.300824 4.7055556 0.300774 4.7083333 0.300740
+ 4.7111111 0.300712 4.7138889 0.300671 4.7166667 0.300596 4.7194444 0.300470
+ 4.7222222 0.300283 4.7250000 0.300030 4.7277778 0.300290 4.7305556 0.300675
+ 4.7333333 0.301127 4.7361111 0.301635 4.7388889 0.302177 4.7416667 0.302725
+ 4.7444444 0.303258 4.7472222 0.303760 4.7500000 0.304225 4.7527778 0.304644
+ 4.7555556 0.304999 4.7583333 0.305276 4.7611111 0.305470 4.7638889 0.305583
+ 4.7666667 0.305621 4.7694444 0.305585 4.7722222 0.305471 4.7750000 0.305267
+ 4.7777778 0.304961 4.7805556 0.304549 4.7833333 0.304027 4.7861111 0.303388
+ 4.7888889 0.302623 4.7916667 0.301723 4.7944444 0.300694 4.7972222 0.300443
+ 4.8000000 0.301655 4.8027778 0.302908 4.8055556 0.304172 4.8083333 0.305419
+ 4.8111111 0.306619 4.8138889 0.307735 4.8166667 0.308723 4.8194444 0.309547
+ 4.8222222 0.310194 4.8250000 0.310669 4.8277778 0.310979 4.8305556 0.311121
+ 4.8333333 0.311084 4.8361111 0.310862 4.8388889 0.310463 4.8416667 0.309902
+ 4.8444444 0.309198 4.8472222 0.308369 4.8500000 0.307435 4.8527778 0.306418
+ 4.8555556 0.305346 4.8583333 0.304241 4.8611111 0.303113 4.8638889 0.301949
+ 4.8666667 0.300723 4.8694444 0.300589 4.8722222 0.301998 4.8750000 0.303494
+ 4.8777778 0.305066 4.8805556 0.306690 4.8833333 0.308328 4.8861111 0.309901
+ 4.8888889 0.311293 4.8916667 0.312371 4.8944444 0.313019 4.8972222 0.313167
+ 4.9000000 0.312788 4.9027778 0.311895 4.9055556 0.310531 4.9083333 0.308777
+ 4.9111111 0.306737 4.9138889 0.304541 4.9166667 0.302326 4.9194444 0.300232
+ 4.9222222 0.301597 4.9250000 0.303015 4.9277778 0.303881 4.9305556 0.304064
+ 4.9333333 0.303455 4.9361111 0.301979 4.9388889 0.300387 4.9416667 0.303614
+ 4.9444444 0.307626 4.9472222 0.312305 4.9500000 0.317488 4.9527778 0.322961
+ 4.9555556 0.328454 4.9583333 0.333641 4.9611111 0.338160 4.9638889 0.341622
+ 4.9666667 0.343630 4.9694444 0.343786 4.9722222 0.341718 4.9750000 0.337104
+ 4.9777778 0.329711 4.9805556 0.319425 4.9833333 0.306284 4.9861111 0.309497
+ 4.9888889 0.327498 4.9916667 0.347068 4.9944444 0.367320 4.9972222 0.387156
+ 5.0000000 0.405309 5.0027778 0.420408 5.0055556 0.431066 5.0083333 0.436015
+ 5.0111111 0.434256 5.0138889 0.425193 5.0166667 0.408742 5.0194444 0.385430
+ 5.0222222 0.356443 5.0250000 0.323616 5.0277778 0.310714 5.0305556 0.343961
+ 5.0333333 0.373631 5.0361111 0.397672 5.0388889 0.414777 5.0416667 0.424508
+ 5.0444444 0.427202 5.0472222 0.423719 5.0500000 0.415183 5.0527778 0.402788
+ 5.0555556 0.387696 5.0583333 0.370991 5.0611111 0.353664 5.0638889 0.336587
+ 5.0666667 0.320498 5.0694444 0.305979 5.0722222 0.306560 5.0750000 0.316870
+ 5.0777778 0.324853 5.0805556 0.330532 5.0833333 0.334027 5.0861111 0.335543
+ 5.0888889 0.335354 5.0916667 0.333778 5.0944444 0.331153 5.0972222 0.327799
+ 5.1000000 0.324015 5.1027778 0.320074 5.1055556 0.316212 5.1083333 0.312624
+ 5.1111111 0.309454 5.1138889 0.306793 5.1166667 0.304681 5.1194444 0.303125
+ 5.1222222 0.302108 5.1250000 0.301594 5.1277778 0.301526 5.1305556 0.301823
+ 5.1333333 0.302389 5.1361111 0.303128 5.1388889 0.303949 5.1416667 0.304769
+ 5.1444444 0.305514 5.1472222 0.306114 5.1500000 0.306511 5.1527778 0.306668
+ 5.1555556 0.306571 5.1583333 0.306232 5.1611111 0.305674 5.1638889 0.304920
+ 5.1666667 0.303997 5.1694444 0.302941 5.1722222 0.301803 5.1750000 0.300637
+ 5.1777778 0.300503 5.1805556 0.301573 5.1833333 0.302538 5.1861111 0.303373
+ 5.1888889 0.304057 5.1916667 0.304573 5.1944444 0.304909 5.1972222 0.305064
+ 5.2000000 0.305053 5.2027778 0.304900 5.2055556 0.304624 5.2083333 0.304239
+ 5.2111111 0.303763 5.2138889 0.303224 5.2166667 0.302660 5.2194444 0.302105
+ 5.2222222 0.301588 5.2250000 0.301126 5.2277778 0.300735 5.2305556 0.300435
+ 5.2333333 0.300244 5.2361111 0.300170 5.2388889 0.300209 5.2416667 0.300347
+ 5.2444444 0.300562 5.2472222 0.300834 5.2500000 0.301144 5.2527778 0.301467
+ 5.2555556 0.301772 5.2583333 0.302028 5.2611111 0.302222 5.2638889 0.302358
+ 5.2666667 0.302456 5.2694444 0.302529 5.2722222 0.302580 5.2750000 0.302603
+ 5.2777778 0.302590 5.2805556 0.302544 5.2833333 0.302473 5.2861111 0.302386
+ 5.2888889 0.302290 5.2916667 0.302182 5.2944444 0.302050 5.2972222 0.301883
+ 5.3000000 0.301670 5.3027778 0.301392 5.3055556 0.301021 5.3083333 0.300532
+ 5.3111111 0.300085 5.3138889 0.300818 5.3166667 0.301644 5.3194444 0.302545
+ 5.3222222 0.303509 5.3250000 0.304520 5.3277778 0.305539 5.3305556 0.306510
+ 5.3333333 0.307369 5.3361111 0.308057 5.3388889 0.308529 5.3416667 0.308752
+ 5.3444444 0.308705 5.3472222 0.308380 5.3500000 0.307780 5.3527778 0.306922
+ 5.3555556 0.305841 5.3583333 0.304585 5.3611111 0.303214 5.3638889 0.301785
+ 5.3666667 0.300348 5.3694444 0.301042 5.3722222 0.302333 5.3750000 0.303485
+ 5.3777778 0.304470 5.3805556 0.305276 5.3833333 0.305904 5.3861111 0.306364
+ 5.3888889 0.306663 5.3916667 0.306808 5.3944444 0.306810 5.3972222 0.306691
+ 5.4000000 0.306479 5.4027778 0.306197 5.4055556 0.305863 5.4083333 0.305491
+ 5.4111111 0.305097 5.4138889 0.304704 5.4166667 0.304336 5.4194444 0.304009
+ 5.4222222 0.303724 5.4250000 0.303473 5.4277778 0.303242 5.4305556 0.303021
+ 5.4333333 0.302797 5.4361111 0.302552 5.4388889 0.302260 5.4416667 0.301892
+ 5.4444444 0.301431 5.4472222 0.300878 5.4500000 0.300255 5.4527778 0.300422
+ 5.4555556 0.301147 5.4583333 0.301932 5.4611111 0.302790 5.4638889 0.303721
+ 5.4666667 0.304710 5.4694444 0.305738 5.4722222 0.306785 5.4750000 0.307836
+ 5.4777778 0.308864 5.4805556 0.309832 5.4833333 0.310694 5.4861111 0.311406
+ 5.4888889 0.311944 5.4916667 0.312291 5.4944444 0.312427 5.4972222 0.312317
+ 5.5000000 0.311927 5.5027778 0.311235 5.5055556 0.310238 5.5083333 0.308939
+ 5.5111111 0.307331 5.5138889 0.305413 5.5166667 0.303217 5.5194444 0.300816
+ 5.5222222 0.301702 5.5250000 0.304241 5.5277778 0.306709 5.5305556 0.309017
+ 5.5333333 0.311072 5.5361111 0.312785 5.5388889 0.314075 5.5416667 0.314886
+ 5.5444444 0.315193 5.5472222 0.315002 5.5500000 0.314336 5.5527778 0.313223
+ 5.5555556 0.311695 5.5583333 0.309801 5.5611111 0.307614 5.5638889 0.305225
+ 5.5666667 0.302747 5.5694444 0.300302 5.5722222 0.301987 5.5750000 0.304002
+ 5.5777778 0.305616 5.5805556 0.306694 5.5833333 0.307099 5.5861111 0.306714
+ 5.5888889 0.305457 5.5916667 0.303283 5.5944444 0.300185 5.5972222 0.303801
+ 5.6000000 0.308587 5.6027778 0.314017 5.6055556 0.319865 5.6083333 0.325846
+ 5.6111111 0.331622 5.6138889 0.336817 5.6166667 0.341022 5.6194444 0.343811
+ 5.6222222 0.344753 5.6250000 0.343445 5.6277778 0.339545 5.6305556 0.332808
+ 5.6333333 0.323110 5.6361111 0.310476 5.6388889 0.304889 5.6416667 0.322571
+ 5.6444444 0.341916 5.6472222 0.362033 5.6500000 0.381820 5.6527778 0.400016
+ 5.6555556 0.415257 5.6583333 0.426166 5.6611111 0.431487 5.6638889 0.430240
+ 5.6666667 0.421858 5.6694444 0.406280 5.6722222 0.384031 5.6750000 0.356261
+ 5.6777778 0.324730 5.6805556 0.308325 5.6833333 0.340423 5.6861111 0.369142
+ 5.6888889 0.392478 5.6916667 0.409156 5.6944444 0.418762 5.6972222 0.421640
+ 5.7000000 0.418626 5.7027778 0.410780 5.7055556 0.399214 5.7083333 0.385006
+ 5.7111111 0.369179 5.7138889 0.352681 5.7166667 0.336355 5.7194444 0.320906
+ 5.7222222 0.306879 5.7250000 0.305332 5.7277778 0.315480 5.7305556 0.323442
+ 5.7333333 0.329210 5.7361111 0.332890 5.7388889 0.334679 5.7416667 0.334832
+ 5.7444444 0.333639 5.7472222 0.331395 5.7500000 0.328388 5.7527778 0.324888
+ 5.7555556 0.321147 5.7583333 0.317390 5.7611111 0.313807 5.7638889 0.310544
+ 5.7666667 0.307707 5.7694444 0.305365 5.7722222 0.303556 5.7750000 0.302285
+ 5.7777778 0.301519 5.7805556 0.301183 5.7833333 0.301179 5.7861111 0.301402
+ 5.7888889 0.301758 5.7916667 0.302171 5.7944444 0.302580 5.7972222 0.302933
+ 5.8000000 0.303187 5.8027778 0.303314 5.8055556 0.303312 5.8083333 0.303198
+ 5.8111111 0.302998 5.8138889 0.302732 5.8166667 0.302418 5.8194444 0.302074
+ 5.8222222 0.301719 5.8250000 0.301369 5.8277778 0.301030 5.8305556 0.300695
+ 5.8333333 0.300347 5.8361111 0.300017 5.8388889 0.300389 5.8416667 0.300750
+ 5.8444444 0.301087 5.8472222 0.301398 5.8500000 0.301691 5.8527778 0.301970
+ 5.8555556 0.302228 5.8583333 0.302452 5.8611111 0.302629 5.8638889 0.302758
+ 5.8666667 0.302839 5.8694444 0.302870 5.8722222 0.302839 5.8750000 0.302736
+ 5.8777778 0.302561 5.8805556 0.302327 5.8833333 0.302058 5.8861111 0.301776
+ 5.8888889 0.301496 5.8916667 0.301228 5.8944444 0.300987 5.8972222 0.300790
+ 5.9000000 0.300658 5.9027778 0.300603 5.9055556 0.300624 5.9083333 0.300712
+ 5.9111111 0.300859 5.9138889 0.301067 5.9166667 0.301340 5.9194444 0.301675
+ 5.9222222 0.302053 5.9250000 0.302437 5.9277778 0.302791 5.9305556 0.303082
+ 5.9333333 0.303291 5.9361111 0.303403 5.9388889 0.303403 5.9416667 0.303276
+ 5.9444444 0.303021 5.9472222 0.302651 5.9500000 0.302195 5.9527778 0.301684
+ 5.9555556 0.301136 5.9583333 0.300564 5.9611111 0.300021 5.9638889 0.300602
+ 5.9666667 0.301162 5.9694444 0.301695 5.9722222 0.302205 5.9750000 0.302705
+ 5.9777778 0.303198 5.9805556 0.303670 5.9833333 0.304097 5.9861111 0.304461
+ 5.9888889 0.304756 5.9916667 0.304977 5.9944444 0.305110 5.9972222 0.305132
+ 6.0000000 0.305027 6.0027778 0.304793 6.0055556 0.304440 6.0083333 0.303987
+ 6.0111111 0.303448 6.0138889 0.302831 6.0166667 0.302138 6.0194444 0.301379
+ 6.0222222 0.300582 6.0250000 0.300208 6.0277778 0.300941 6.0305556 0.301575
+ 6.0333333 0.302083 6.0361111 0.302442 6.0388889 0.302636 6.0416667 0.302654
+ 6.0444444 0.302501 6.0472222 0.302206 6.0500000 0.301820 6.0527778 0.301400
+ 6.0555556 0.300996 6.0583333 0.300641 6.0611111 0.300353 6.0638889 0.300144
+ 6.0666667 0.300014 6.0694444 0.300041 6.0722222 0.300032 6.0750000 0.300025
+ 6.0777778 0.300121 6.0805556 0.300253 6.0833333 0.300425 6.0861111 0.300643
+ 6.0888889 0.300899 6.0916667 0.301181 6.0944444 0.301475 6.0972222 0.301776
+ 6.1000000 0.302081 6.1027778 0.302379 6.1055556 0.302647 6.1083333 0.302854
+ 6.1111111 0.302968 6.1138889 0.302973 6.1166667 0.302865 6.1194444 0.302641
+ 6.1222222 0.302302 6.1250000 0.301864 6.1277778 0.301358 6.1305556 0.300825
+ 6.1333333 0.300300 6.1361111 0.300201 6.1388889 0.300680 6.1416667 0.301143
+ 6.1444444 0.301591 6.1472222 0.302012 6.1500000 0.302386 6.1527778 0.302698
+ 6.1555556 0.302940 6.1583333 0.303109 6.1611111 0.303203 6.1638889 0.303216
+ 6.1666667 0.303145 6.1694444 0.302992 6.1722222 0.302767 6.1750000 0.302487
+ 6.1777778 0.302166 6.1805556 0.301805 6.1833333 0.301400 6.1861111 0.300952
+ 6.1888889 0.300472 6.1916667 0.300025 6.1944444 0.300520 6.1972222 0.300998
+ 6.2000000 0.301446 6.2027778 0.301852 6.2055556 0.302199 6.2083333 0.302469
+ 6.2111111 0.302648 6.2138889 0.302732 6.2166667 0.302718 6.2194444 0.302601
+ 6.2222222 0.302372 6.2250000 0.302021 6.2277778 0.301547 6.2305556 0.300974
+ 6.2333333 0.300343 6.2361111 0.300298 6.2388889 0.300917 6.2416667 0.301486
+ 6.2444444 0.301974 6.2472222 0.302339 6.2500000 0.302538 6.2527778 0.302538
+ 6.2555556 0.302332 6.2583333 0.301939 6.2611111 0.301402 6.2638889 0.300764
+ 6.2666667 0.300062 6.2694444 0.300665 6.2722222 0.301369 6.2750000 0.301998
+ 6.2777778 0.302499 6.2805556 0.302839 6.2833333 0.302998 6.2861111 0.302967
+ 6.2888889 0.302742 6.2916667 0.302325 6.2944444 0.301735 6.2972222 0.301007
+ 6.3000000 0.300192 6.3027778 0.300661 6.3055556 0.301510 6.3083333 0.302316
+ 6.3111111 0.303043 6.3138889 0.303653 6.3166667 0.304119 6.3194444 0.304424
+ 6.3222222 0.304565 6.3250000 0.304546 6.3277778 0.304367 6.3305556 0.304027
+ 6.3333333 0.303527 6.3361111 0.302879 6.3388889 0.302115 6.3416667 0.301278
+ 6.3444444 0.300416 6.3472222 0.300424 6.3500000 0.301202 6.3527778 0.301883
+ 6.3555556 0.302444 6.3583333 0.302871 6.3611111 0.303159 6.3638889 0.303313
+ 6.3666667 0.303349 6.3694444 0.303282 6.3722222 0.303127 6.3750000 0.302897
+ 6.3777778 0.302617 6.3805556 0.302319 6.3833333 0.302038 6.3861111 0.301798
+ 6.3888889 0.301608 6.3916667 0.301469 6.3944444 0.301387 6.3972222 0.301376
+ 6.4000000 0.301452 6.4027778 0.301628 6.4055556 0.301904 6.4083333 0.302269
+ 6.4111111 0.302701 6.4138889 0.303175 6.4166667 0.303658 6.4194444 0.304105
+ 6.4222222 0.304462 6.4250000 0.304678 6.4277778 0.304711 6.4305556 0.304537
+ 6.4333333 0.304147 6.4361111 0.303547 6.4388889 0.302747 6.4416667 0.301762
+ 6.4444444 0.300613 6.4472222 0.300667 6.4500000 0.302029 6.4527778 0.303417
+ 6.4555556 0.304772 6.4583333 0.306043 6.4611111 0.307189 6.4638889 0.308177
+ 6.4666667 0.308983 6.4694444 0.309597 6.4722222 0.310017 6.4750000 0.310244
+ 6.4777778 0.310278 6.4805556 0.310114 6.4833333 0.309752 6.4861111 0.309204
+ 6.4888889 0.308496 6.4916667 0.307669 6.4944444 0.306771 6.4972222 0.305844
+ 6.5000000 0.304925 6.5027778 0.304037 6.5055556 0.303202 6.5083333 0.302436
+ 6.5111111 0.301733 6.5138889 0.301069 6.5166667 0.300408 6.5194444 0.300277
+ 6.5222222 0.300993 6.5250000 0.301735 6.5277778 0.302503 6.5305556 0.303312
+ 6.5333333 0.304184 6.5361111 0.305122 6.5388889 0.306093 6.5416667 0.307028
+ 6.5444444 0.307834 6.5472222 0.308421 6.5500000 0.308719 6.5527778 0.308684
+ 6.5555556 0.308303 6.5583333 0.307590 6.5611111 0.306597 6.5638889 0.305419
+ 6.5666667 0.304190 6.5694444 0.303056 6.5722222 0.302163 6.5750000 0.301654
+ 6.5777778 0.301657 6.5805556 0.302282 6.5833333 0.303607 6.5861111 0.305676
+ 6.5888889 0.308483 6.5916667 0.311976 6.5944444 0.316067 6.5972222 0.320632
+ 6.6000000 0.325504 6.6027778 0.330451 6.6055556 0.335169 6.6083333 0.339291
+ 6.6111111 0.342412 6.6138889 0.344122 6.6166667 0.344023 6.6194444 0.341741
+ 6.6222222 0.336943 6.6250000 0.329375 6.6277778 0.318901 6.6305556 0.305541
+ 6.6333333 0.310495 6.6361111 0.328792 6.6388889 0.348715 6.6416667 0.369415
+ 6.6444444 0.389836 6.6472222 0.408740 6.6500000 0.424752 6.6527778 0.436465
+ 6.6555556 0.442590 6.6583333 0.442089 6.6611111 0.434286 6.6638889 0.418965
+ 6.6666667 0.396467 6.6694444 0.367783 6.6722222 0.334547 6.6750000 0.301070
+ 6.6777778 0.336582 6.6805556 0.369467 6.6833333 0.397478 6.6861111 0.418934
+ 6.6888889 0.432888 6.6916667 0.439147 6.6944444 0.438157 6.6972222 0.430837
+ 6.7000000 0.418414 6.7027778 0.402262 6.7055556 0.383755 6.7083333 0.364169
+ 6.7111111 0.344611 6.7138889 0.326009 6.7166667 0.309090 6.7194444 0.305621
+ 6.7222222 0.317805 6.7250000 0.327328 6.7277778 0.334211 6.7305556 0.338598
+ 6.7333333 0.340729 6.7361111 0.340907 6.7388889 0.339481 6.7416667 0.336813
+ 6.7444444 0.333259 6.7472222 0.329142 6.7500000 0.324749 6.7527778 0.320329
+ 6.7555556 0.316099 6.7583333 0.312234 6.7611111 0.308856 6.7638889 0.306033
+ 6.7666667 0.303788 6.7694444 0.302116 6.7722222 0.300991 6.7750000 0.300369
+ 6.7777778 0.300188 6.7805556 0.300368 6.7833333 0.300813 6.7861111 0.301427
+ 6.7888889 0.302121 6.7916667 0.302815 6.7944444 0.303436 6.7972222 0.303918
+ 6.8000000 0.304209 6.8027778 0.304281 6.8055556 0.304128 6.8083333 0.303764
+ 6.8111111 0.303210 6.8138889 0.302496 6.8166667 0.301657 6.8194444 0.300739
+ 6.8222222 0.300208 6.8250000 0.301136 6.8277778 0.302004 6.8305556 0.302782
+ 6.8333333 0.303444 6.8361111 0.303963 6.8388889 0.304307 6.8416667 0.304444
+ 6.8444444 0.304357 6.8472222 0.304053 6.8500000 0.303561 6.8527778 0.302922
+ 6.8555556 0.302175 6.8583333 0.301353 6.8611111 0.300489 6.8638889 0.300376
+ 6.8666667 0.301200 6.8694444 0.301946 6.8722222 0.302591 6.8750000 0.303122
+ 6.8777778 0.303532 6.8805556 0.303810 6.8833333 0.303943 6.8861111 0.303930
+ 6.8888889 0.303779 6.8916667 0.303500 6.8944444 0.303099 6.8972222 0.302572
+ 6.9000000 0.301911 6.9027778 0.301111 6.9055556 0.300190 6.9083333 0.300821
+ 6.9111111 0.301887 6.9138889 0.302973 6.9166667 0.304050 6.9194444 0.305081
+ 6.9222222 0.306024 6.9250000 0.306838 6.9277778 0.307499 6.9305556 0.308005
+ 6.9333333 0.308365 6.9361111 0.308587 6.9388889 0.308667 6.9416667 0.308595
+ 6.9444444 0.308363 6.9472222 0.307971 6.9500000 0.307432 6.9527778 0.306760
+ 6.9555556 0.305968 6.9583333 0.305069 6.9611111 0.304081 6.9638889 0.303032
+ 6.9666667 0.301947 6.9694444 0.300845 6.9722222 0.300271 6.9750000 0.301400
+ 6.9777778 0.302535 6.9805556 0.303657 6.9833333 0.304738 6.9861111 0.305757
+ 6.9888889 0.306699 6.9916667 0.307560 6.9944444 0.308329 6.9972222 0.308984
+ 7.0000000 0.309499 7.0027778 0.309860 7.0055556 0.310058 7.0083333 0.310090
+ 7.0111111 0.309952 7.0138889 0.309640 7.0166667 0.309150 7.0194444 0.308482
+ 7.0222222 0.307650 7.0250000 0.306676 7.0277778 0.305589 7.0305556 0.304408
+ 7.0333333 0.303150 7.0361111 0.301835 7.0388889 0.300493 7.0416667 0.300840
+ 7.0444444 0.302127 7.0472222 0.303331 7.0500000 0.304421 7.0527778 0.305364
+ 7.0555556 0.306127 7.0583333 0.306686 7.0611111 0.307030 7.0638889 0.307166
+ 7.0666667 0.307110 7.0694444 0.306886 7.0722222 0.306514 7.0750000 0.306020
+ 7.0777778 0.305436 7.0805556 0.304797 7.0833333 0.304138 7.0861111 0.303482
+ 7.0888889 0.302841 7.0916667 0.302218 7.0944444 0.301621 7.0972222 0.301064
+ 7.1000000 0.300564 7.1027778 0.300134 7.1055556 0.300220 7.1083333 0.300502
+ 7.1111111 0.300712 7.1138889 0.300845 7.1166667 0.300896 7.1194444 0.300869
+ 7.1222222 0.300781 7.1250000 0.300653 7.1277778 0.300504 7.1305556 0.300346
+ 7.1333333 0.300190 7.1361111 0.300054 7.1388889 0.300035 7.1416667 0.300048
+ 7.1444444 0.300043 7.1472222 0.300245 7.1500000 0.300549 7.1527778 0.300936
+ 7.1555556 0.301384 7.1583333 0.301873 7.1611111 0.302373 7.1638889 0.302848
+ 7.1666667 0.303256 7.1694444 0.303565 7.1722222 0.303756 7.1750000 0.303826
+ 7.1777778 0.303777 7.1805556 0.303608 7.1833333 0.303317 7.1861111 0.302916
+ 7.1888889 0.302427 7.1916667 0.301882 7.1944444 0.301307 7.1972222 0.300719
+ 7.2000000 0.300128 7.2027778 0.300455 7.2055556 0.301010 7.2083333 0.301513
+ 7.2111111 0.301945 7.2138889 0.302303 7.2166667 0.302590 7.2194444 0.302802
+ 7.2222222 0.302931 7.2250000 0.302976 7.2277778 0.302950 7.2305556 0.302885
+ 7.2333333 0.302823 7.2361111 0.302799 7.2388889 0.302822 7.2416667 0.302891
+ 7.2444444 0.303002 7.2472222 0.303155 7.2500000 0.303354 7.2527778 0.303589
+ 7.2555556 0.303840 7.2583333 0.304076 7.2611111 0.304273 7.2638889 0.304412
+ 7.2666667 0.304475 7.2694444 0.304441 7.2722222 0.304283 7.2750000 0.303973
+ 7.2777778 0.303491 7.2805556 0.302830 7.2833333 0.301996 7.2861111 0.300999
+ 7.2888889 0.300149 7.2916667 0.301427 7.2944444 0.302793 7.2972222 0.304180
+ 7.3000000 0.305508 7.3027778 0.306714 7.3055556 0.307756 7.3083333 0.308609
+ 7.3111111 0.309267 7.3138889 0.309733 7.3166667 0.310010 7.3194444 0.310103
+ 7.3222222 0.310018 7.3250000 0.309770 7.3277778 0.309382 7.3305556 0.308882
+ 7.3333333 0.308293 7.3361111 0.307631 7.3388889 0.306919 7.3416667 0.306176
+ 7.3444444 0.305421 7.3472222 0.304654 7.3500000 0.303863 7.3527778 0.303031
+ 7.3555556 0.302143 7.3583333 0.301187 7.3611111 0.300145 7.3638889 0.301006
+ 7.3666667 0.302287 7.3694444 0.303704 7.3722222 0.305244 7.3750000 0.306861
+ 7.3777778 0.308467 7.3805556 0.309941 7.3833333 0.311152 7.3861111 0.311988
+ 7.3888889 0.312363 7.3916667 0.312221 7.3944444 0.311545 7.3972222 0.310356
+ 7.4000000 0.308724 7.4027778 0.306753 7.4055556 0.304574 7.4083333 0.302331
+ 7.4111111 0.300189 7.4138889 0.301673 7.4166667 0.303071 7.4194444 0.303842
+ 7.4222222 0.303865 7.4250000 0.303057 7.4277778 0.301371 7.4305556 0.301205
+ 7.4333333 0.304643 7.4361111 0.308862 7.4388889 0.313719 7.4416667 0.319012
+ 7.4444444 0.324486 7.4472222 0.329846 7.4500000 0.334760 7.4527778 0.338858
+ 7.4555556 0.341737 7.4583333 0.342986 7.4611111 0.342221 7.4638889 0.339118
+ 7.4666667 0.333425 7.4694444 0.324983 7.4722222 0.313746 7.4750000 0.300187
+ 7.4777778 0.316533 7.4805556 0.334789 7.4833333 0.354214 7.4861111 0.373854
+ 7.4888889 0.392571 7.4916667 0.409092 7.4944444 0.422060 7.4972222 0.430138
+ 7.5000000 0.432164 7.5027778 0.427311 7.5055556 0.415208 7.5083333 0.396033
+ 7.5111111 0.370580 7.5138889 0.340291 7.5166667 0.307193 7.5194444 0.326278
+ 7.5222222 0.357561 7.5250000 0.384332 7.5277778 0.404864 7.5305556 0.418256
+ 7.5333333 0.424462 7.5361111 0.424095 7.5388889 0.418159 7.5416667 0.407813
+ 7.5444444 0.394238 7.5472222 0.378556 7.5500000 0.361800 7.5527778 0.344879
+ 7.5555556 0.328559 7.5583333 0.313446 7.5611111 0.300014 7.5638889 0.311516
+ 7.5666667 0.320877 7.5694444 0.328033 7.5722222 0.333038 7.5750000 0.336039
+ 7.5777778 0.337250 7.5805556 0.336924 7.5833333 0.335335 7.5861111 0.332767
+ 7.5888889 0.329504 7.5916667 0.325814 7.5944444 0.321927 7.5972222 0.318039
+ 7.6000000 0.314309 7.6027778 0.310868 7.6055556 0.307821 7.6083333 0.305240
+ 7.6111111 0.303157 7.6138889 0.301569 7.6166667 0.300449 7.6194444 0.300249
+ 7.6222222 0.300582 7.6250000 0.300615 7.6277778 0.300418 7.6305556 0.300062
+ 7.6333333 0.300384 7.6361111 0.300864 7.6388889 0.301328 7.6416667 0.301744
+ 7.6444444 0.302089 7.6472222 0.302348 7.6500000 0.302504 7.6527778 0.302552
+ 7.6555556 0.302496 7.6583333 0.302357 7.6611111 0.302157 7.6638889 0.301916
+ 7.6666667 0.301644 7.6694444 0.301346 7.6722222 0.301026 7.6750000 0.300687
+ 7.6777778 0.300333 7.6805556 0.300033 7.6833333 0.300410 7.6861111 0.300795
+ 7.6888889 0.301179 7.6916667 0.301553 7.6944444 0.301913 7.6972222 0.302255
+ 7.7000000 0.302571 7.7027778 0.302846 7.7055556 0.303061 7.7083333 0.303198
+ 7.7111111 0.303245 7.7138889 0.303204 7.7166667 0.303094 7.7194444 0.302939
+ 7.7222222 0.302754 7.7250000 0.302549 7.7277778 0.302337 7.7305556 0.302138
+ 7.7333333 0.301973 7.7361111 0.301853 7.7388889 0.301773 7.7416667 0.301726
+ 7.7444444 0.301710 7.7472222 0.301738 7.7500000 0.301828 7.7527778 0.301988
+ 7.7555556 0.302210 7.7583333 0.302472 7.7611111 0.302753 7.7638889 0.303040
+ 7.7666667 0.303326 7.7694444 0.303600 7.7722222 0.303832 7.7750000 0.303984
+ 7.7777778 0.304020 7.7805556 0.303912 7.7833333 0.303646 7.7861111 0.303216
+ 7.7888889 0.302616 7.7916667 0.301841 7.7944444 0.300895 7.7972222 0.300198
+ 7.8000000 0.301394 7.8027778 0.302640 7.8055556 0.303885 7.8083333 0.305076
+ 7.8111111 0.306155 7.8138889 0.307064 7.8166667 0.307753 7.8194444 0.308193
+ 7.8222222 0.308380 7.8250000 0.308326 7.8277778 0.308051 7.8305556 0.307578
+ 7.8333333 0.306932 7.8361111 0.306146 7.8388889 0.305267 7.8416667 0.304345
+ 7.8444444 0.303416 7.8472222 0.302504 7.8500000 0.301618 7.8527778 0.300767
+ 7.8555556 0.300040 7.8583333 0.300794 7.8611111 0.301488 7.8638889 0.302120
+ 7.8666667 0.302690 7.8694444 0.303195 7.8722222 0.303623 7.8750000 0.303961
+ 7.8777778 0.304197 7.8805556 0.304331 7.8833333 0.304368 7.8861111 0.304312
+ 7.8888889 0.304165 7.8916667 0.303927 7.8944444 0.303610 7.8972222 0.303235
+ 7.9000000 0.302832 7.9027778 0.302422 7.9055556 0.302014 7.9083333 0.301614
+ 7.9111111 0.301230 7.9138889 0.300880 7.9166667 0.300582 7.9194444 0.300346
+ 7.9222222 0.300173 7.9250000 0.300051 7.9277778 0.300033 7.9305556 0.300086
+ 7.9333333 0.300110 7.9361111 0.300113 7.9388889 0.300111 7.9416667 0.300118
+ 7.9444444 0.300146 7.9472222 0.300198 7.9500000 0.300270 7.9527778 0.300356
+ 7.9555556 0.300460 7.9583333 0.300591 7.9611111 0.300755 7.9638889 0.300937
+ 7.9666667 0.301116 7.9694444 0.301275 7.9722222 0.301413 7.9750000 0.301533
+ 7.9777778 0.301633 7.9805556 0.301703 7.9833333 0.301727 7.9861111 0.301699
+ 7.9888889 0.301628 7.9916667 0.301523 7.9944444 0.301385 7.9972222 0.301207
+ 8.0000000 0.300979 8.0027778 0.300704 8.0055556 0.300408 8.0083333 0.300125
+ 8.0111111 0.300121 8.0138889 0.300318 8.0166667 0.300464 8.0194444 0.300559
+ 8.0222222 0.300596 8.0250000 0.300571 8.0277778 0.300490 8.0305556 0.300374
+ 8.0333333 0.300251 8.0361111 0.300142 8.0388889 0.300059 8.0416667 0.300011
+ 8.0444444 0.300011 8.0472222 0.300072 8.0500000 0.300209 8.0527778 0.300429
+ 8.0555556 0.300730 8.0583333 0.301100 8.0611111 0.301527 8.0638889 0.302008
+ 8.0666667 0.302540 8.0694444 0.303112 8.0722222 0.303699 8.0750000 0.304265
+ 8.0777778 0.304779 8.0805556 0.305217 8.0833333 0.305558 8.0861111 0.305776
+ 8.0888889 0.305839 8.0916667 0.305714 8.0944444 0.305376 8.0972222 0.304819
+ 8.1000000 0.304052 8.1027778 0.303091 8.1055556 0.301946 8.1083333 0.300628
+ 8.1111111 0.300841 8.1138889 0.302416 8.1166667 0.304032 8.1194444 0.305620
+ 8.1222222 0.307114 8.1250000 0.308457 8.1277778 0.309591 8.1305556 0.310471
+ 8.1333333 0.311065 8.1361111 0.311371 8.1388889 0.311410 8.1416667 0.311217
+ 8.1444444 0.310824 8.1472222 0.310254 8.1500000 0.309528 8.1527778 0.308678
+ 8.1555556 0.307744 8.1583333 0.306764 8.1611111 0.305770 8.1638889 0.304789
+ 8.1666667 0.303841 8.1694444 0.302931 8.1722222 0.302049 8.1750000 0.301177
+ 8.1777778 0.300285 8.1805556 0.300667 8.1833333 0.301713 8.1861111 0.302871
+ 8.1888889 0.304142 8.1916667 0.305503 8.1944444 0.306911 8.1972222 0.308293
+ 8.2000000 0.309546 8.2027778 0.310552 8.2055556 0.311210 8.2083333 0.311459
+ 8.2111111 0.311275 8.2138889 0.310678 8.2166667 0.309723 8.2194444 0.308498
+ 8.2222222 0.307113 8.2250000 0.305695 8.2277778 0.304388 8.2305556 0.303353
+ 8.2333333 0.302752 8.2361111 0.302727 8.2388889 0.303381 8.2416667 0.304768
+ 8.2444444 0.306897 8.2472222 0.309734 8.2500000 0.313193 8.2527778 0.317132
+ 8.2555556 0.321346 8.2583333 0.325572 8.2611111 0.329505 8.2638889 0.332817
+ 8.2666667 0.335160 8.2694444 0.336169 8.2722222 0.335475 8.2750000 0.332730
+ 8.2777778 0.327648 8.2805556 0.320034 8.2833333 0.309823 8.2861111 0.302909
+ 8.2888889 0.317923 8.2916667 0.334780 8.2944444 0.352814 8.2972222 0.371122
+ 8.3000000 0.388600 8.3027778 0.403996 8.3055556 0.415980 8.3083333 0.423244
+ 8.3111111 0.424650 8.3138889 0.419380 8.3166667 0.407079 8.3194444 0.387961
+ 8.3222222 0.362892 8.3250000 0.333408 8.3277778 0.301627 8.3305556 0.329965
+ 8.3333333 0.358856 8.3361111 0.382892 8.3388889 0.400635 8.3416667 0.411529
+ 8.3444444 0.415810 8.3472222 0.414240 8.3500000 0.407831 8.3527778 0.397651
+ 8.3555556 0.384734 8.3583333 0.370065 8.3611111 0.354561 8.3638889 0.339045
+ 8.3666667 0.324222 8.3694444 0.310649 8.3722222 0.301275 8.3750000 0.311295
+ 8.3777778 0.319285 8.3805556 0.325225 8.3833333 0.329194 8.3861111 0.331352
+ 8.3888889 0.331927 8.3916667 0.331189 8.3944444 0.329425 8.3972222 0.326915
+ 8.4000000 0.323910 8.4027778 0.320641 8.4055556 0.317317 8.4083333 0.314121
+ 8.4111111 0.311196 8.4138889 0.308635 8.4166667 0.306484 8.4194444 0.304758
+ 8.4222222 0.303450 8.4250000 0.302540 8.4277778 0.301988 8.4305556 0.301737
+ 8.4333333 0.301719 8.4361111 0.301872 8.4388889 0.302139 8.4416667 0.302479
+ 8.4444444 0.302849 8.4472222 0.303206 8.4500000 0.303508 8.4527778 0.303727
+ 8.4555556 0.303853 8.4583333 0.303885 8.4611111 0.303824 8.4638889 0.303662
+ 8.4666667 0.303396 8.4694444 0.303034 8.4722222 0.302599 8.4750000 0.302125
+ 8.4777778 0.301637 8.4805556 0.301147 8.4833333 0.300652 8.4861111 0.300145
+ 8.4888889 0.300371 8.4916667 0.300889 8.4944444 0.301396 8.4972222 0.301882
+ 8.5000000 0.302338 8.5027778 0.302756 8.5055556 0.303119 8.5083333 0.303410
+ 8.5111111 0.303615 8.5138889 0.303736 8.5166667 0.303780 8.5194444 0.303755
+ 8.5222222 0.303669 8.5250000 0.303527 8.5277778 0.303337 8.5305556 0.303118
+ 8.5333333 0.302894 8.5361111 0.302690 8.5388889 0.302519 8.5416667 0.302391
+ 8.5444444 0.302309 8.5472222 0.302273 8.5500000 0.302288 8.5527778 0.302357
+ 8.5555556 0.302478 8.5583333 0.302634 8.5611111 0.302805 8.5638889 0.302970
+ 8.5666667 0.303108 8.5694444 0.303202 8.5722222 0.303232 8.5750000 0.303181
+ 8.5777778 0.303037 8.5805556 0.302798 8.5833333 0.302471 8.5861111 0.302060
+ 8.5888889 0.301567 8.5916667 0.300989 8.5944444 0.300330 8.5972222 0.300397
+ 8.6000000 0.301167 8.6027778 0.301954 8.6055556 0.302739 8.6083333 0.303508
+ 8.6111111 0.304238 8.6138889 0.304893 8.6166667 0.305437 8.6194444 0.305851
+ 8.6222222 0.306134 8.6250000 0.306301 8.6277778 0.306363 8.6305556 0.306326
+ 8.6333333 0.306189 8.6361111 0.305947 8.6388889 0.305590 8.6416667 0.305110
+ 8.6444444 0.304499 8.6472222 0.303755 8.6500000 0.302887 8.6527778 0.301922
+ 8.6555556 0.300900 8.6583333 0.300127 8.6611111 0.301115 8.6638889 0.302032
+ 8.6666667 0.302855 8.6694444 0.303556 8.6722222 0.304098 8.6750000 0.304454
+ 8.6777778 0.304614 8.6805556 0.304597 8.6833333 0.304434 8.6861111 0.304159
+ 8.6888889 0.303804 8.6916667 0.303388 8.6944444 0.302928 8.6972222 0.302444
+ 8.7000000 0.301959 8.7027778 0.301495 8.7055556 0.301062 8.7083333 0.300662
+ 8.7111111 0.300294 8.7138889 0.300038 8.7166667 0.300318 8.7194444 0.300531
+ 8.7222222 0.300670 8.7250000 0.300740 8.7277778 0.300750 8.7305556 0.300704
+ 8.7333333 0.300606 8.7361111 0.300466 8.7388889 0.300309 8.7416667 0.300164
+ 8.7444444 0.300053 8.7472222 0.300018 8.7500000 0.300054 8.7527778 0.300064
+ 8.7555556 0.300053 8.7583333 0.300026 8.7611111 0.300010 8.7638889 0.300053
+ 8.7666667 0.300101 8.7694444 0.300161 8.7722222 0.300243 8.7750000 0.300362
+ 8.7777778 0.300526 8.7805556 0.300725 8.7833333 0.300940 8.7861111 0.301150
+ 8.7888889 0.301342 8.7916667 0.301513 8.7944444 0.301658 8.7972222 0.301761
+ 8.8000000 0.301801 8.8027778 0.301764 8.8055556 0.301648 8.8083333 0.301459
+ 8.8111111 0.301206 8.8138889 0.300894 8.8166667 0.300527 8.8194444 0.300125
+ 8.8222222 0.300281 8.8250000 0.300658 8.8277778 0.300985 8.8305556 0.301252
+ 8.8333333 0.301465 8.8361111 0.301632 8.8388889 0.301756 8.8416667 0.301841
+ 8.8444444 0.301896 8.8472222 0.301942 8.8500000 0.302007 8.8527778 0.302111
+ 8.8555556 0.302267 8.8583333 0.302483 8.8611111 0.302770 8.8638889 0.303137
+ 8.8666667 0.303585 8.8694444 0.304097 8.8722222 0.304633 8.8750000 0.305137
+ 8.8777778 0.305539 8.8805556 0.305780 8.8833333 0.305817 8.8861111 0.305616
+ 8.8888889 0.305155 8.8916667 0.304421 8.8944444 0.303422 8.8972222 0.302182
+ 8.9000000 0.300742 8.9027778 0.300856 8.9055556 0.302569 8.9083333 0.304345
+ 8.9111111 0.306115 8.9138889 0.307795 8.9166667 0.309303 8.9194444 0.310575
+ 8.9222222 0.311580 8.9250000 0.312310 8.9277778 0.312761 8.9305556 0.312928
+ 8.9333333 0.312812 8.9361111 0.312421 8.9388889 0.311773 8.9416667 0.310894
+ 8.9444444 0.309814 8.9472222 0.308569 8.9500000 0.307200 8.9527778 0.305752
+ 8.9555556 0.304271 8.9583333 0.302807 8.9611111 0.301387 8.9638889 0.300012
+ 8.9666667 0.301332 8.9694444 0.302665 8.9722222 0.303998 8.9750000 0.305335
+ 8.9777778 0.306667 8.9805556 0.307979 8.9833333 0.309237 8.9861111 0.310373
+ 8.9888889 0.311280 8.9916667 0.311837 8.9944444 0.311952 8.9972222 0.311588
+ 9.0000000 0.310756 9.0027778 0.309503 9.0055556 0.307902 9.0083333 0.306056
+ 9.0111111 0.304096 9.0138889 0.302172 9.0166667 0.300449 9.0194444 0.300910
+ 9.0222222 0.301757 9.0250000 0.301975 9.0277778 0.301475 9.0305556 0.300198
+ 9.0333333 0.301882 9.0361111 0.304751 9.0388889 0.308337 9.0416667 0.312508
+ 9.0444444 0.317078 9.0472222 0.321816 9.0500000 0.326453 9.0527778 0.330689
+ 9.0555556 0.334195 9.0583333 0.336618 9.0611111 0.337607 9.0638889 0.336832
+ 9.0666667 0.334006 9.0694444 0.328900 9.0722222 0.321352 9.0750000 0.311303
+ 9.0777778 0.301168 9.0805556 0.315804 9.0833333 0.332148 9.0861111 0.349537
+ 9.0888889 0.367116 9.0916667 0.383856 9.0944444 0.398591 9.0972222 0.410069
+ 9.1000000 0.417051 9.1027778 0.418462 9.1055556 0.413542 9.1083333 0.401960
+ 9.1111111 0.383904 9.1138889 0.360165 9.1166667 0.332181 9.1194444 0.301958
+ 9.1222222 0.328142 9.1250000 0.355732 9.1277778 0.378759 9.1305556 0.395815
+ 9.1333333 0.406302 9.1361111 0.410372 9.1388889 0.408711 9.1416667 0.402283
+ 9.1444444 0.392146 9.1472222 0.379357 9.1500000 0.364918 9.1527778 0.349748
+ 9.1555556 0.334655 9.1583333 0.320317 9.1611111 0.307276 9.1638889 0.304068
+ 9.1666667 0.313454 9.1694444 0.320762 9.1722222 0.325998 9.1750000 0.329274
+ 9.1777778 0.330782 9.1805556 0.330769 9.1833333 0.329509 9.1861111 0.327296
+ 9.1888889 0.324429 9.1916667 0.321199 9.1944444 0.317860 9.1972222 0.314618
+ 9.2000000 0.311626 9.2027778 0.308986 9.2055556 0.306766 9.2083333 0.305001
+ 9.2111111 0.303692 9.2138889 0.302807 9.2166667 0.302288 9.2194444 0.302067
+ 9.2222222 0.302069 9.2250000 0.302214 9.2277778 0.302425 9.2305556 0.302631
+ 9.2333333 0.302779 9.2361111 0.302838 9.2388889 0.302804 9.2416667 0.302684
+ 9.2444444 0.302489 9.2472222 0.302230 9.2500000 0.301920 9.2527778 0.301587
+ 9.2555556 0.301262 9.2583333 0.300973 9.2611111 0.300734 9.2638889 0.300546
+ 9.2666667 0.300405 9.2694444 0.300306 9.2722222 0.300252 9.2750000 0.300237
+ 9.2777778 0.300245 9.2805556 0.300244 9.2833333 0.300202 9.2861111 0.300092
+ 9.2888889 0.300095 9.2916667 0.300357 9.2944444 0.300678 9.2972222 0.301040
+ 9.3000000 0.301412 9.3027778 0.301760 9.3055556 0.302043 9.3083333 0.302234
+ 9.3111111 0.302324 9.3138889 0.302318 9.3166667 0.302233 9.3194444 0.302097
+ 9.3222222 0.301942 9.3250000 0.301803 9.3277778 0.301715 9.3305556 0.301711
+ 9.3333333 0.301817 9.3361111 0.302040 9.3388889 0.302365 9.3416667 0.302768
+ 9.3444444 0.303222 9.3472222 0.303702 9.3500000 0.304179 9.3527778 0.304618
+ 9.3555556 0.304973 9.3583333 0.305200 9.3611111 0.305267 9.3638889 0.305172
+ 9.3666667 0.304929 9.3694444 0.304557 9.3722222 0.304060 9.3750000 0.303438
+ 9.3777778 0.302693 9.3805556 0.301846 9.3833333 0.300930 9.3861111 0.300024
+ 9.3888889 0.300993 9.3916667 0.301968 9.3944444 0.302937 9.3972222 0.303875
+ 9.4000000 0.304746 9.4027778 0.305519 9.4055556 0.306174 9.4083333 0.306704
+ 9.4111111 0.307099 9.4138889 0.307349 9.4166667 0.307439 9.4194444 0.307365
+ 9.4222222 0.307135 9.4250000 0.306772 9.4277778 0.306294 9.4305556 0.305710
+ 9.4333333 0.305024 9.4361111 0.304243 9.4388889 0.303385 9.4416667 0.302476
+ 9.4444444 0.301538 9.4472222 0.300585 9.4500000 0.300367 9.4527778 0.301298
+ 9.4555556 0.302178 9.4583333 0.302979 9.4611111 0.303674 9.4638889 0.304251
+ 9.4666667 0.304709 9.4694444 0.305043 9.4722222 0.305243 9.4750000 0.305291
+ 9.4777778 0.305172 9.4805556 0.304891 9.4833333 0.304467 9.4861111 0.303925
+ 9.4888889 0.303292 9.4916667 0.302592 9.4944444 0.301859 9.4972222 0.301130
+ 9.5000000 0.300445 9.5027778 0.300168 9.5055556 0.300693 9.5083333 0.301127
+ 9.5111111 0.301468 9.5138889 0.301712 9.5166667 0.301852 9.5194444 0.301885
+ 9.5222222 0.301817 9.5250000 0.301658 9.5277778 0.301420 9.5305556 0.301118
+ 9.5333333 0.300772 9.5361111 0.300405 9.5388889 0.300050 9.5416667 0.300260
+ 9.5444444 0.300498 9.5472222 0.300650 9.5500000 0.300718 9.5527778 0.300706
+ 9.5555556 0.300623 9.5583333 0.300483 9.5611111 0.300310 9.5638889 0.300128
+ 9.5666667 0.300047 9.5694444 0.300208 9.5722222 0.300356 9.5750000 0.300494
+ 9.5777778 0.300618 9.5805556 0.300718 9.5833333 0.300786 9.5861111 0.300818
+ 9.5888889 0.300815 9.5916667 0.300783 9.5944444 0.300729 9.5972222 0.300652
+ 9.6000000 0.300551 9.6027778 0.300425 9.6055556 0.300278 9.6083333 0.300113
+ 9.6111111 0.300074 9.6138889 0.300296 9.6166667 0.300574 9.6194444 0.300926
+ 9.6222222 0.301358 9.6250000 0.301862 9.6277778 0.302418 9.6305556 0.303001
+ 9.6333333 0.303587 9.6361111 0.304150 9.6388889 0.304663 9.6416667 0.305102
+ 9.6444444 0.305442 9.6472222 0.305659 9.6500000 0.305734 9.6527778 0.305641
+ 9.6555556 0.305345 9.6583333 0.304815 9.6611111 0.304032 9.6638889 0.303003
+ 9.6666667 0.301757 9.6694444 0.300333 9.6722222 0.301233 9.6750000 0.302903
+ 9.6777778 0.304633 9.6805556 0.306352 9.6833333 0.307975 9.6861111 0.309419
+ 9.6888889 0.310624 9.6916667 0.311556 9.6944444 0.312201 9.6972222 0.312549
+ 9.7000000 0.312591 9.7027778 0.312322 9.7055556 0.311754 9.7083333 0.310918
+ 9.7111111 0.309857 9.7138889 0.308612 9.7166667 0.307219 9.7194444 0.305721
+ 9.7222222 0.304170 9.7250000 0.302618 9.7277778 0.301110 9.7305556 0.300323
+ 9.7333333 0.301674 9.7361111 0.302942 9.7388889 0.304127 9.7416667 0.305221
+ 9.7444444 0.306222 9.7472222 0.307137 9.7500000 0.307975 9.7527778 0.308725
+ 9.7555556 0.309344 9.7583333 0.309751 9.7611111 0.309864 9.7638889 0.309632
+ 9.7666667 0.309042 9.7694444 0.308107 9.7722222 0.306861 9.7750000 0.305374
+ 9.7777778 0.303749 9.7805556 0.302123 9.7833333 0.300650 9.7861111 0.300519
+ 9.7888889 0.301258 9.7916667 0.301469 9.7944444 0.301086 9.7972222 0.300061
+ 9.8000000 0.301634 9.8027778 0.303995 9.8055556 0.306977 9.8083333 0.310497
+ 9.8111111 0.314436 9.8138889 0.318641 9.8166667 0.322922 9.8194444 0.327045
+ 9.8222222 0.330740 9.8250000 0.333702 9.8277778 0.335616 9.8305556 0.336169
+ 9.8333333 0.335060 9.8361111 0.332013 9.8388889 0.326803 9.8416667 0.319275
+ 9.8444444 0.309381 9.8472222 0.302797 9.8500000 0.317010 9.8527778 0.332826
+ 9.8555556 0.349621 9.8583333 0.366587 9.8611111 0.382747 9.8638889 0.396978
+ 9.8666667 0.408058 9.8694444 0.414774 9.8722222 0.416062 9.8750000 0.411157
+ 9.8777778 0.399708 9.8805556 0.381881 9.8833333 0.358439 9.8861111 0.330788
+ 9.8888889 0.300892 9.8916667 0.328934 9.8944444 0.356331 9.8972222 0.379263
+ 9.9000000 0.396331 9.9027778 0.406917 9.9055556 0.411119 9.9083333 0.409556
+ 9.9111111 0.403153 9.9138889 0.392965 9.9166667 0.380054 9.9194444 0.365419
+ 9.9222222 0.349957 9.9250000 0.334457 9.9277778 0.319588 9.9305556 0.305895
+ 9.9333333 0.306201 9.9361111 0.316409 9.9388889 0.324569 9.9416667 0.330638
+ 9.9444444 0.334670 9.9472222 0.336802 9.9500000 0.337235 9.9527778 0.336221
+ 9.9555556 0.334045 9.9583333 0.330995 9.9611111 0.327343 9.9638889 0.323331
+ 9.9666667 0.319178 9.9694444 0.315075 9.9722222 0.311188 9.9750000 0.307645
+ 9.9777778 0.304531 9.9805556 0.301887 9.9833333 0.300279 9.9861111 0.301984
+ 9.9888889 0.303253 9.9916667 0.304126 9.9944444 0.304647 9.9972222 0.304868
+ )

* ---- Threshold: set low to pass all QRS peaks initially ----
* (In Phase 2, this will be generated by the EWMA circuit)
Vthresh threshold 0 0.310

* ---- DUT ----
Xdut rect_in threshold rpeak_out vdd vss vbias
+ env_fast_raw env_fast env_avg noise_gate_out thr_gate_out
+ rpeak_detector_v2

* ---- Initial conditions ----
.ic v(env_fast_raw)=0.300 v(env_fast)=0.300 v(env_avg)=0.300

* ---- Simulation ----
.tran 50u 10.0 0 50u

* ---- Measurements ----
.meas tran ef_pk1 max v(env_fast) from=0.2 to=0.5
.meas tran ef_pk2 max v(env_fast) from=0.9 to=1.3
.meas tran ef_pk3 max v(env_fast) from=1.7 to=2.1
.meas tran ea_1s find v(env_avg) at=1.0
.meas tran ea_5s find v(env_avg) at=5.0
.meas tran ea_9s find v(env_avg) at=9.0

.meas tran det1 when v(rpeak_out)=0.45 rise=1
.meas tran det2 when v(rpeak_out)=0.45 rise=2
.meas tran det3 when v(rpeak_out)=0.45 rise=3
.meas tran det4 when v(rpeak_out)=0.45 rise=4
.meas tran det5 when v(rpeak_out)=0.45 rise=5
.meas tran det6 when v(rpeak_out)=0.45 rise=6
.meas tran det7 when v(rpeak_out)=0.45 rise=7
.meas tran det8 when v(rpeak_out)=0.45 rise=8
.meas tran det9 when v(rpeak_out)=0.45 rise=9
.meas tran det10 when v(rpeak_out)=0.45 rise=10
.meas tran det11 when v(rpeak_out)=0.45 rise=11
.meas tran det12 when v(rpeak_out)=0.45 rise=12

.save v(rect_in) v(env_fast_raw) v(env_fast) v(env_avg)
.save v(noise_gate_out) v(thr_gate_out) v(rpeak_out)

.control
set filetype=ascii
run

echo ""
echo "=== ENVELOPE TEST RESULTS ==="
echo "--- Envelope peaks ---"
print ef_pk1 ef_pk2 ef_pk3
echo "--- Average tracker ---"
print ea_1s ea_5s ea_9s
echo "--- Detection times ---"
print det1 det2 det3 det4 det5 det6
print det7 det8 det9 det10 det11 det12
echo ""

wrdata envelope_test_out.txt v(rect_in) v(env_fast_raw) v(env_fast) v(env_avg) v(noise_gate_out) v(thr_gate_out) v(rpeak_out)

echo "=== Testbench Complete ==="
quit
.endc

.end
