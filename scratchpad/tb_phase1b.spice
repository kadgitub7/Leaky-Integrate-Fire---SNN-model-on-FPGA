* ============================================================
* Phase 1B: Fast Envelope Follower Test
* ============================================================
* Synthetic pulsed input: 5 pulses at 0.5, 1.3, 2.1, 2.9, 3.7s
* Each pulse: 100mV peak above 0.300V baseline, 40ms wide
*
* Expected: env should peak near 0.400V, decay toward ~0.300V
*           with tau ~ 100ms between beats
* ============================================================

.lib C:/Users/kadhi/OneDrive/Desktop/amux/verilogLearning/Leaky-Integrate-Fire---SNN-model-on-FPGA/experiments/frontend_optimization/ngspice_frontend/sky130_minimal.lib.spice tt

.include C:/Users/kadhi/OneDrive/Desktop/amux/verilogLearning/Leaky-Integrate-Fire---SNN-model-on-FPGA/experiments/frontend_optimization/complete_frontend_v9b/rpeak_detector_v2.spice

.option scale=1.0u method=gear reltol=0.01 gmin=1e-15

Vdd vdd 0 0.9
Vss vss 0 0.0
Vbias vbias 0 0.300

* Synthetic pulsed input
Vin vin 0 PWL(
+ 0.0000000 0.300000 0.0010000 0.300000 0.0020000 0.300000 0.0030000 0.300000
+ 0.0040000 0.300000 0.0050000 0.300000 0.0060000 0.300000 0.0070000 0.300000
+ 0.0080000 0.300000 0.0090000 0.300000 0.0100000 0.300000 0.0110000 0.300000
+ 0.0120000 0.300000 0.0130000 0.300000 0.0140000 0.300000 0.0150000 0.300000
+ 0.0160000 0.300000 0.0170000 0.300000 0.0180000 0.300000 0.0190000 0.300000
+ 0.0200000 0.300000 0.0210000 0.300000 0.0220000 0.300000 0.0230000 0.300000
+ 0.0240000 0.300000 0.0250000 0.300000 0.0260000 0.300000 0.0270000 0.300000
+ 0.0280000 0.300000 0.0290000 0.300000 0.0300000 0.300000 0.0310000 0.300000
+ 0.0320000 0.300000 0.0330000 0.300000 0.0340000 0.300000 0.0350000 0.300000
+ 0.0360000 0.300000 0.0370000 0.300000 0.0380000 0.300000 0.0390000 0.300000
+ 0.0400000 0.300000 0.0410000 0.300000 0.0420000 0.300000 0.0430000 0.300000
+ 0.0440000 0.300000 0.0450000 0.300000 0.0460000 0.300000 0.0470000 0.300000
+ 0.0480000 0.300000 0.0490000 0.300000 0.0500000 0.300000 0.0510000 0.300000
+ 0.0520000 0.300000 0.0530000 0.300000 0.0540000 0.300000 0.0550000 0.300000
+ 0.0560000 0.300000 0.0570000 0.300000 0.0580000 0.300000 0.0590000 0.300000
+ 0.0600000 0.300000 0.0610000 0.300000 0.0620000 0.300000 0.0630000 0.300000
+ 0.0640000 0.300000 0.0650000 0.300000 0.0660000 0.300000 0.0670000 0.300000
+ 0.0680000 0.300000 0.0690000 0.300000 0.0700000 0.300000 0.0710000 0.300000
+ 0.0720000 0.300000 0.0730000 0.300000 0.0740000 0.300000 0.0750000 0.300000
+ 0.0760000 0.300000 0.0770000 0.300000 0.0780000 0.300000 0.0790000 0.300000
+ 0.0800000 0.300000 0.0810000 0.300000 0.0820000 0.300000 0.0830000 0.300000
+ 0.0840000 0.300000 0.0850000 0.300000 0.0860000 0.300000 0.0870000 0.300000
+ 0.0880000 0.300000 0.0890000 0.300000 0.0900000 0.300000 0.0910000 0.300000
+ 0.0920000 0.300000 0.0930000 0.300000 0.0940000 0.300000 0.0950000 0.300000
+ 0.0960000 0.300000 0.0970000 0.300000 0.0980000 0.300000 0.0990000 0.300000
+ 0.1000000 0.300000 0.1010000 0.300000 0.1020000 0.300000 0.1030000 0.300000
+ 0.1040000 0.300000 0.1050000 0.300000 0.1060000 0.300000 0.1070000 0.300000
+ 0.1080000 0.300000 0.1090000 0.300000 0.1100000 0.300000 0.1110000 0.300000
+ 0.1120000 0.300000 0.1130000 0.300000 0.1140000 0.300000 0.1150000 0.300000
+ 0.1160000 0.300000 0.1170000 0.300000 0.1180000 0.300000 0.1190000 0.300000
+ 0.1200000 0.300000 0.1210000 0.300000 0.1220000 0.300000 0.1230000 0.300000
+ 0.1240000 0.300000 0.1250000 0.300000 0.1260000 0.300000 0.1270000 0.300000
+ 0.1280000 0.300000 0.1290000 0.300000 0.1300000 0.300000 0.1310000 0.300000
+ 0.1320000 0.300000 0.1330000 0.300000 0.1340000 0.300000 0.1350000 0.300000
+ 0.1360000 0.300000 0.1370000 0.300000 0.1380000 0.300000 0.1390000 0.300000
+ 0.1400000 0.300000 0.1410000 0.300000 0.1420000 0.300000 0.1430000 0.300000
+ 0.1440000 0.300000 0.1450000 0.300000 0.1460000 0.300000 0.1470000 0.300000
+ 0.1480000 0.300000 0.1490000 0.300000 0.1500000 0.300000 0.1510000 0.300000
+ 0.1520000 0.300000 0.1530000 0.300000 0.1540000 0.300000 0.1550000 0.300000
+ 0.1560000 0.300000 0.1570000 0.300000 0.1580000 0.300000 0.1590000 0.300000
+ 0.1600000 0.300000 0.1610000 0.300000 0.1620000 0.300000 0.1630000 0.300000
+ 0.1640000 0.300000 0.1650000 0.300000 0.1660000 0.300000 0.1670000 0.300000
+ 0.1680000 0.300000 0.1690000 0.300000 0.1700000 0.300000 0.1710000 0.300000
+ 0.1720000 0.300000 0.1730000 0.300000 0.1740000 0.300000 0.1750000 0.300000
+ 0.1760000 0.300000 0.1770000 0.300000 0.1780000 0.300000 0.1790000 0.300000
+ 0.1800000 0.300000 0.1810000 0.300000 0.1820000 0.300000 0.1830000 0.300000
+ 0.1840000 0.300000 0.1850000 0.300000 0.1860000 0.300000 0.1870000 0.300000
+ 0.1880000 0.300000 0.1890000 0.300000 0.1900000 0.300000 0.1910000 0.300000
+ 0.1920000 0.300000 0.1930000 0.300000 0.1940000 0.300000 0.1950000 0.300000
+ 0.1960000 0.300000 0.1970000 0.300000 0.1980000 0.300000 0.1990000 0.300000
+ 0.2000000 0.300000 0.2010000 0.300000 0.2020000 0.300000 0.2030000 0.300000
+ 0.2040000 0.300000 0.2050000 0.300000 0.2060000 0.300000 0.2070000 0.300000
+ 0.2080000 0.300000 0.2090000 0.300000 0.2100000 0.300000 0.2110000 0.300000
+ 0.2120000 0.300000 0.2130000 0.300000 0.2140000 0.300000 0.2150000 0.300000
+ 0.2160000 0.300000 0.2170000 0.300000 0.2180000 0.300000 0.2190000 0.300000
+ 0.2200000 0.300000 0.2210000 0.300000 0.2220000 0.300000 0.2230000 0.300000
+ 0.2240000 0.300000 0.2250000 0.300000 0.2260000 0.300000 0.2270000 0.300000
+ 0.2280000 0.300000 0.2290000 0.300000 0.2300000 0.300000 0.2310000 0.300000
+ 0.2320000 0.300000 0.2330000 0.300000 0.2340000 0.300000 0.2350000 0.300000
+ 0.2360000 0.300000 0.2370000 0.300000 0.2380000 0.300000 0.2390000 0.300000
+ 0.2400000 0.300000 0.2410000 0.300000 0.2420000 0.300000 0.2430000 0.300000
+ 0.2440000 0.300000 0.2450000 0.300000 0.2460000 0.300000 0.2470000 0.300000
+ 0.2480000 0.300000 0.2490000 0.300000 0.2500000 0.300000 0.2510000 0.300000
+ 0.2520000 0.300000 0.2530000 0.300000 0.2540000 0.300000 0.2550000 0.300000
+ 0.2560000 0.300000 0.2570000 0.300000 0.2580000 0.300000 0.2590000 0.300000
+ 0.2600000 0.300000 0.2610000 0.300000 0.2620000 0.300000 0.2630000 0.300000
+ 0.2640000 0.300000 0.2650000 0.300000 0.2660000 0.300000 0.2670000 0.300000
+ 0.2680000 0.300000 0.2690000 0.300000 0.2700000 0.300000 0.2710000 0.300000
+ 0.2720000 0.300000 0.2730000 0.300000 0.2740000 0.300000 0.2750000 0.300000
+ 0.2760000 0.300000 0.2770000 0.300000 0.2780000 0.300000 0.2790000 0.300000
+ 0.2800000 0.300000 0.2810000 0.300000 0.2820000 0.300000 0.2830000 0.300000
+ 0.2840000 0.300000 0.2850000 0.300000 0.2860000 0.300000 0.2870000 0.300000
+ 0.2880000 0.300000 0.2890000 0.300000 0.2900000 0.300000 0.2910000 0.300000
+ 0.2920000 0.300000 0.2930000 0.300000 0.2940000 0.300000 0.2950000 0.300000
+ 0.2960000 0.300000 0.2970000 0.300000 0.2980000 0.300000 0.2990000 0.300000
+ 0.3000000 0.300000 0.3010000 0.300000 0.3020000 0.300000 0.3030000 0.300000
+ 0.3040000 0.300000 0.3050000 0.300000 0.3060000 0.300000 0.3070000 0.300000
+ 0.3080000 0.300000 0.3090000 0.300000 0.3100000 0.300000 0.3110000 0.300000
+ 0.3120000 0.300000 0.3130000 0.300000 0.3140000 0.300000 0.3150000 0.300000
+ 0.3160000 0.300000 0.3170000 0.300000 0.3180000 0.300000 0.3190000 0.300000
+ 0.3200000 0.300000 0.3210000 0.300000 0.3220000 0.300000 0.3230000 0.300000
+ 0.3240000 0.300000 0.3250000 0.300000 0.3260000 0.300000 0.3270000 0.300000
+ 0.3280000 0.300000 0.3290000 0.300000 0.3300000 0.300000 0.3310000 0.300000
+ 0.3320000 0.300000 0.3330000 0.300000 0.3340000 0.300000 0.3350000 0.300000
+ 0.3360000 0.300000 0.3370000 0.300000 0.3380000 0.300000 0.3390000 0.300000
+ 0.3400000 0.300000 0.3410000 0.300000 0.3420000 0.300000 0.3430000 0.300000
+ 0.3440000 0.300000 0.3450000 0.300000 0.3460000 0.300000 0.3470000 0.300000
+ 0.3480000 0.300000 0.3490000 0.300000 0.3500000 0.300000 0.3510000 0.300000
+ 0.3520000 0.300000 0.3530000 0.300000 0.3540000 0.300000 0.3550000 0.300000
+ 0.3560000 0.300000 0.3570000 0.300000 0.3580000 0.300000 0.3590000 0.300000
+ 0.3600000 0.300000 0.3610000 0.300000 0.3620000 0.300000 0.3630000 0.300000
+ 0.3640000 0.300000 0.3650000 0.300000 0.3660000 0.300000 0.3670000 0.300000
+ 0.3680000 0.300000 0.3690000 0.300000 0.3700000 0.300000 0.3710000 0.300000
+ 0.3720000 0.300000 0.3730000 0.300000 0.3740000 0.300000 0.3750000 0.300000
+ 0.3760000 0.300000 0.3770000 0.300000 0.3780000 0.300000 0.3790000 0.300000
+ 0.3800000 0.300000 0.3810000 0.300000 0.3820000 0.300000 0.3830000 0.300000
+ 0.3840000 0.300000 0.3850000 0.300000 0.3860000 0.300000 0.3870000 0.300000
+ 0.3880000 0.300000 0.3890000 0.300000 0.3900000 0.300000 0.3910000 0.300000
+ 0.3920000 0.300000 0.3930000 0.300000 0.3940000 0.300000 0.3950000 0.300000
+ 0.3960000 0.300000 0.3970000 0.300000 0.3980000 0.300000 0.3990000 0.300000
+ 0.4000000 0.300000 0.4010000 0.300000 0.4020000 0.300000 0.4030000 0.300000
+ 0.4040000 0.300000 0.4050000 0.300000 0.4060000 0.300000 0.4070000 0.300000
+ 0.4080000 0.300000 0.4090000 0.300000 0.4100000 0.300000 0.4110000 0.300000
+ 0.4120000 0.300000 0.4130000 0.300000 0.4140000 0.300000 0.4150000 0.300000
+ 0.4160000 0.300000 0.4170000 0.300000 0.4180000 0.300000 0.4190000 0.300000
+ 0.4200000 0.300000 0.4210000 0.300000 0.4220000 0.300000 0.4230000 0.300000
+ 0.4240000 0.300000 0.4250000 0.300000 0.4260000 0.300000 0.4270000 0.300000
+ 0.4280000 0.300000 0.4290000 0.300000 0.4300000 0.300000 0.4310000 0.300000
+ 0.4320000 0.300000 0.4330000 0.300000 0.4340000 0.300000 0.4350000 0.300000
+ 0.4360000 0.300000 0.4370000 0.300000 0.4380000 0.300000 0.4390000 0.300000
+ 0.4400000 0.300000 0.4410000 0.300000 0.4420000 0.300000 0.4430000 0.300000
+ 0.4440000 0.300000 0.4450000 0.300000 0.4460000 0.300000 0.4470000 0.300000
+ 0.4480000 0.300000 0.4490000 0.300000 0.4500000 0.300000 0.4510000 0.300000
+ 0.4520000 0.300000 0.4530000 0.300000 0.4540000 0.300000 0.4550000 0.300000
+ 0.4560000 0.300000 0.4570000 0.300000 0.4580000 0.300000 0.4590000 0.300000
+ 0.4600000 0.300000 0.4610000 0.300000 0.4620000 0.300000 0.4630000 0.300000
+ 0.4640000 0.300000 0.4650000 0.300000 0.4660000 0.300000 0.4670000 0.300000
+ 0.4680000 0.300000 0.4690000 0.300000 0.4700000 0.300000 0.4710000 0.300000
+ 0.4720000 0.300000 0.4730000 0.300000 0.4740000 0.300000 0.4750000 0.300000
+ 0.4760000 0.300000 0.4770000 0.300000 0.4780000 0.300000 0.4790000 0.300000
+ 0.4800000 0.300000 0.4810000 0.305000 0.4820000 0.310000 0.4830000 0.315000
+ 0.4840000 0.320000 0.4850000 0.325000 0.4860000 0.330000 0.4870000 0.335000
+ 0.4880000 0.340000 0.4890000 0.345000 0.4900000 0.350000 0.4910000 0.355000
+ 0.4920000 0.360000 0.4930000 0.365000 0.4940000 0.370000 0.4950000 0.375000
+ 0.4960000 0.380000 0.4970000 0.385000 0.4980000 0.390000 0.4990000 0.395000
+ 0.5000000 0.400000 0.5010000 0.395000 0.5020000 0.390000 0.5030000 0.385000
+ 0.5040000 0.380000 0.5050000 0.375000 0.5060000 0.370000 0.5070000 0.365000
+ 0.5080000 0.360000 0.5090000 0.355000 0.5100000 0.350000 0.5110000 0.345000
+ 0.5120000 0.340000 0.5130000 0.335000 0.5140000 0.330000 0.5150000 0.325000
+ 0.5160000 0.320000 0.5170000 0.315000 0.5180000 0.310000 0.5190000 0.305000
+ 0.5200000 0.300000 0.5210000 0.300000 0.5220000 0.300000 0.5230000 0.300000
+ 0.5240000 0.300000 0.5250000 0.300000 0.5260000 0.300000 0.5270000 0.300000
+ 0.5280000 0.300000 0.5290000 0.300000 0.5300000 0.300000 0.5310000 0.300000
+ 0.5320000 0.300000 0.5330000 0.300000 0.5340000 0.300000 0.5350000 0.300000
+ 0.5360000 0.300000 0.5370000 0.300000 0.5380000 0.300000 0.5390000 0.300000
+ 0.5400000 0.300000 0.5410000 0.300000 0.5420000 0.300000 0.5430000 0.300000
+ 0.5440000 0.300000 0.5450000 0.300000 0.5460000 0.300000 0.5470000 0.300000
+ 0.5480000 0.300000 0.5490000 0.300000 0.5500000 0.300000 0.5510000 0.300000
+ 0.5520000 0.300000 0.5530000 0.300000 0.5540000 0.300000 0.5550000 0.300000
+ 0.5560000 0.300000 0.5570000 0.300000 0.5580000 0.300000 0.5590000 0.300000
+ 0.5600000 0.300000 0.5610000 0.300000 0.5620000 0.300000 0.5630000 0.300000
+ 0.5640000 0.300000 0.5650000 0.300000 0.5660000 0.300000 0.5670000 0.300000
+ 0.5680000 0.300000 0.5690000 0.300000 0.5700000 0.300000 0.5710000 0.300000
+ 0.5720000 0.300000 0.5730000 0.300000 0.5740000 0.300000 0.5750000 0.300000
+ 0.5760000 0.300000 0.5770000 0.300000 0.5780000 0.300000 0.5790000 0.300000
+ 0.5800000 0.300000 0.5810000 0.300000 0.5820000 0.300000 0.5830000 0.300000
+ 0.5840000 0.300000 0.5850000 0.300000 0.5860000 0.300000 0.5870000 0.300000
+ 0.5880000 0.300000 0.5890000 0.300000 0.5900000 0.300000 0.5910000 0.300000
+ 0.5920000 0.300000 0.5930000 0.300000 0.5940000 0.300000 0.5950000 0.300000
+ 0.5960000 0.300000 0.5970000 0.300000 0.5980000 0.300000 0.5990000 0.300000
+ 0.6000000 0.300000 0.6010000 0.300000 0.6020000 0.300000 0.6030000 0.300000
+ 0.6040000 0.300000 0.6050000 0.300000 0.6060000 0.300000 0.6070000 0.300000
+ 0.6080000 0.300000 0.6090000 0.300000 0.6100000 0.300000 0.6110000 0.300000
+ 0.6120000 0.300000 0.6130000 0.300000 0.6140000 0.300000 0.6150000 0.300000
+ 0.6160000 0.300000 0.6170000 0.300000 0.6180000 0.300000 0.6190000 0.300000
+ 0.6200000 0.300000 0.6210000 0.300000 0.6220000 0.300000 0.6230000 0.300000
+ 0.6240000 0.300000 0.6250000 0.300000 0.6260000 0.300000 0.6270000 0.300000
+ 0.6280000 0.300000 0.6290000 0.300000 0.6300000 0.300000 0.6310000 0.300000
+ 0.6320000 0.300000 0.6330000 0.300000 0.6340000 0.300000 0.6350000 0.300000
+ 0.6360000 0.300000 0.6370000 0.300000 0.6380000 0.300000 0.6390000 0.300000
+ 0.6400000 0.300000 0.6410000 0.300000 0.6420000 0.300000 0.6430000 0.300000
+ 0.6440000 0.300000 0.6450000 0.300000 0.6460000 0.300000 0.6470000 0.300000
+ 0.6480000 0.300000 0.6490000 0.300000 0.6500000 0.300000 0.6510000 0.300000
+ 0.6520000 0.300000 0.6530000 0.300000 0.6540000 0.300000 0.6550000 0.300000
+ 0.6560000 0.300000 0.6570000 0.300000 0.6580000 0.300000 0.6590000 0.300000
+ 0.6600000 0.300000 0.6610000 0.300000 0.6620000 0.300000 0.6630000 0.300000
+ 0.6640000 0.300000 0.6650000 0.300000 0.6660000 0.300000 0.6670000 0.300000
+ 0.6680000 0.300000 0.6690000 0.300000 0.6700000 0.300000 0.6710000 0.300000
+ 0.6720000 0.300000 0.6730000 0.300000 0.6740000 0.300000 0.6750000 0.300000
+ 0.6760000 0.300000 0.6770000 0.300000 0.6780000 0.300000 0.6790000 0.300000
+ 0.6800000 0.300000 0.6810000 0.300000 0.6820000 0.300000 0.6830000 0.300000
+ 0.6840000 0.300000 0.6850000 0.300000 0.6860000 0.300000 0.6870000 0.300000
+ 0.6880000 0.300000 0.6890000 0.300000 0.6900000 0.300000 0.6910000 0.300000
+ 0.6920000 0.300000 0.6930000 0.300000 0.6940000 0.300000 0.6950000 0.300000
+ 0.6960000 0.300000 0.6970000 0.300000 0.6980000 0.300000 0.6990000 0.300000
+ 0.7000000 0.300000 0.7010000 0.300000 0.7020000 0.300000 0.7030000 0.300000
+ 0.7040000 0.300000 0.7050000 0.300000 0.7060000 0.300000 0.7070000 0.300000
+ 0.7080000 0.300000 0.7090000 0.300000 0.7100000 0.300000 0.7110000 0.300000
+ 0.7120000 0.300000 0.7130000 0.300000 0.7140000 0.300000 0.7150000 0.300000
+ 0.7160000 0.300000 0.7170000 0.300000 0.7180000 0.300000 0.7190000 0.300000
+ 0.7200000 0.300000 0.7210000 0.300000 0.7220000 0.300000 0.7230000 0.300000
+ 0.7240000 0.300000 0.7250000 0.300000 0.7260000 0.300000 0.7270000 0.300000
+ 0.7280000 0.300000 0.7290000 0.300000 0.7300000 0.300000 0.7310000 0.300000
+ 0.7320000 0.300000 0.7330000 0.300000 0.7340000 0.300000 0.7350000 0.300000
+ 0.7360000 0.300000 0.7370000 0.300000 0.7380000 0.300000 0.7390000 0.300000
+ 0.7400000 0.300000 0.7410000 0.300000 0.7420000 0.300000 0.7430000 0.300000
+ 0.7440000 0.300000 0.7450000 0.300000 0.7460000 0.300000 0.7470000 0.300000
+ 0.7480000 0.300000 0.7490000 0.300000 0.7500000 0.300000 0.7510000 0.300000
+ 0.7520000 0.300000 0.7530000 0.300000 0.7540000 0.300000 0.7550000 0.300000
+ 0.7560000 0.300000 0.7570000 0.300000 0.7580000 0.300000 0.7590000 0.300000
+ 0.7600000 0.300000 0.7610000 0.300000 0.7620000 0.300000 0.7630000 0.300000
+ 0.7640000 0.300000 0.7650000 0.300000 0.7660000 0.300000 0.7670000 0.300000
+ 0.7680000 0.300000 0.7690000 0.300000 0.7700000 0.300000 0.7710000 0.300000
+ 0.7720000 0.300000 0.7730000 0.300000 0.7740000 0.300000 0.7750000 0.300000
+ 0.7760000 0.300000 0.7770000 0.300000 0.7780000 0.300000 0.7790000 0.300000
+ 0.7800000 0.300000 0.7810000 0.300000 0.7820000 0.300000 0.7830000 0.300000
+ 0.7840000 0.300000 0.7850000 0.300000 0.7860000 0.300000 0.7870000 0.300000
+ 0.7880000 0.300000 0.7890000 0.300000 0.7900000 0.300000 0.7910000 0.300000
+ 0.7920000 0.300000 0.7930000 0.300000 0.7940000 0.300000 0.7950000 0.300000
+ 0.7960000 0.300000 0.7970000 0.300000 0.7980000 0.300000 0.7990000 0.300000
+ 0.8000000 0.300000 0.8010000 0.300000 0.8020000 0.300000 0.8030000 0.300000
+ 0.8040000 0.300000 0.8050000 0.300000 0.8060000 0.300000 0.8070000 0.300000
+ 0.8080000 0.300000 0.8090000 0.300000 0.8100000 0.300000 0.8110000 0.300000
+ 0.8120000 0.300000 0.8130000 0.300000 0.8140000 0.300000 0.8150000 0.300000
+ 0.8160000 0.300000 0.8170000 0.300000 0.8180000 0.300000 0.8190000 0.300000
+ 0.8200000 0.300000 0.8210000 0.300000 0.8220000 0.300000 0.8230000 0.300000
+ 0.8240000 0.300000 0.8250000 0.300000 0.8260000 0.300000 0.8270000 0.300000
+ 0.8280000 0.300000 0.8290000 0.300000 0.8300000 0.300000 0.8310000 0.300000
+ 0.8320000 0.300000 0.8330000 0.300000 0.8340000 0.300000 0.8350000 0.300000
+ 0.8360000 0.300000 0.8370000 0.300000 0.8380000 0.300000 0.8390000 0.300000
+ 0.8400000 0.300000 0.8410000 0.300000 0.8420000 0.300000 0.8430000 0.300000
+ 0.8440000 0.300000 0.8450000 0.300000 0.8460000 0.300000 0.8470000 0.300000
+ 0.8480000 0.300000 0.8490000 0.300000 0.8500000 0.300000 0.8510000 0.300000
+ 0.8520000 0.300000 0.8530000 0.300000 0.8540000 0.300000 0.8550000 0.300000
+ 0.8560000 0.300000 0.8570000 0.300000 0.8580000 0.300000 0.8590000 0.300000
+ 0.8600000 0.300000 0.8610000 0.300000 0.8620000 0.300000 0.8630000 0.300000
+ 0.8640000 0.300000 0.8650000 0.300000 0.8660000 0.300000 0.8670000 0.300000
+ 0.8680000 0.300000 0.8690000 0.300000 0.8700000 0.300000 0.8710000 0.300000
+ 0.8720000 0.300000 0.8730000 0.300000 0.8740000 0.300000 0.8750000 0.300000
+ 0.8760000 0.300000 0.8770000 0.300000 0.8780000 0.300000 0.8790000 0.300000
+ 0.8800000 0.300000 0.8810000 0.300000 0.8820000 0.300000 0.8830000 0.300000
+ 0.8840000 0.300000 0.8850000 0.300000 0.8860000 0.300000 0.8870000 0.300000
+ 0.8880000 0.300000 0.8890000 0.300000 0.8900000 0.300000 0.8910000 0.300000
+ 0.8920000 0.300000 0.8930000 0.300000 0.8940000 0.300000 0.8950000 0.300000
+ 0.8960000 0.300000 0.8970000 0.300000 0.8980000 0.300000 0.8990000 0.300000
+ 0.9000000 0.300000 0.9010000 0.300000 0.9020000 0.300000 0.9030000 0.300000
+ 0.9040000 0.300000 0.9050000 0.300000 0.9060000 0.300000 0.9070000 0.300000
+ 0.9080000 0.300000 0.9090000 0.300000 0.9100000 0.300000 0.9110000 0.300000
+ 0.9120000 0.300000 0.9130000 0.300000 0.9140000 0.300000 0.9150000 0.300000
+ 0.9160000 0.300000 0.9170000 0.300000 0.9180000 0.300000 0.9190000 0.300000
+ 0.9200000 0.300000 0.9210000 0.300000 0.9220000 0.300000 0.9230000 0.300000
+ 0.9240000 0.300000 0.9250000 0.300000 0.9260000 0.300000 0.9270000 0.300000
+ 0.9280000 0.300000 0.9290000 0.300000 0.9300000 0.300000 0.9310000 0.300000
+ 0.9320000 0.300000 0.9330000 0.300000 0.9340000 0.300000 0.9350000 0.300000
+ 0.9360000 0.300000 0.9370000 0.300000 0.9380000 0.300000 0.9390000 0.300000
+ 0.9400000 0.300000 0.9410000 0.300000 0.9420000 0.300000 0.9430000 0.300000
+ 0.9440000 0.300000 0.9450000 0.300000 0.9460000 0.300000 0.9470000 0.300000
+ 0.9480000 0.300000 0.9490000 0.300000 0.9500000 0.300000 0.9510000 0.300000
+ 0.9520000 0.300000 0.9530000 0.300000 0.9540000 0.300000 0.9550000 0.300000
+ 0.9560000 0.300000 0.9570000 0.300000 0.9580000 0.300000 0.9590000 0.300000
+ 0.9600000 0.300000 0.9610000 0.300000 0.9620000 0.300000 0.9630000 0.300000
+ 0.9640000 0.300000 0.9650000 0.300000 0.9660000 0.300000 0.9670000 0.300000
+ 0.9680000 0.300000 0.9690000 0.300000 0.9700000 0.300000 0.9710000 0.300000
+ 0.9720000 0.300000 0.9730000 0.300000 0.9740000 0.300000 0.9750000 0.300000
+ 0.9760000 0.300000 0.9770000 0.300000 0.9780000 0.300000 0.9790000 0.300000
+ 0.9800000 0.300000 0.9810000 0.300000 0.9820000 0.300000 0.9830000 0.300000
+ 0.9840000 0.300000 0.9850000 0.300000 0.9860000 0.300000 0.9870000 0.300000
+ 0.9880000 0.300000 0.9890000 0.300000 0.9900000 0.300000 0.9910000 0.300000
+ 0.9920000 0.300000 0.9930000 0.300000 0.9940000 0.300000 0.9950000 0.300000
+ 0.9960000 0.300000 0.9970000 0.300000 0.9980000 0.300000 0.9990000 0.300000
+ 1.0000000 0.300000 1.0010000 0.300000 1.0020000 0.300000 1.0030000 0.300000
+ 1.0040000 0.300000 1.0050000 0.300000 1.0060000 0.300000 1.0070000 0.300000
+ 1.0080000 0.300000 1.0090000 0.300000 1.0100000 0.300000 1.0110000 0.300000
+ 1.0120000 0.300000 1.0130000 0.300000 1.0140000 0.300000 1.0150000 0.300000
+ 1.0160000 0.300000 1.0170000 0.300000 1.0180000 0.300000 1.0190000 0.300000
+ 1.0200000 0.300000 1.0210000 0.300000 1.0220000 0.300000 1.0230000 0.300000
+ 1.0240000 0.300000 1.0250000 0.300000 1.0260000 0.300000 1.0270000 0.300000
+ 1.0280000 0.300000 1.0290000 0.300000 1.0300000 0.300000 1.0310000 0.300000
+ 1.0320000 0.300000 1.0330000 0.300000 1.0340000 0.300000 1.0350000 0.300000
+ 1.0360000 0.300000 1.0370000 0.300000 1.0380000 0.300000 1.0390000 0.300000
+ 1.0400000 0.300000 1.0410000 0.300000 1.0420000 0.300000 1.0430000 0.300000
+ 1.0440000 0.300000 1.0450000 0.300000 1.0460000 0.300000 1.0470000 0.300000
+ 1.0480000 0.300000 1.0490000 0.300000 1.0500000 0.300000 1.0510000 0.300000
+ 1.0520000 0.300000 1.0530000 0.300000 1.0540000 0.300000 1.0550000 0.300000
+ 1.0560000 0.300000 1.0570000 0.300000 1.0580000 0.300000 1.0590000 0.300000
+ 1.0600000 0.300000 1.0610000 0.300000 1.0620000 0.300000 1.0630000 0.300000
+ 1.0640000 0.300000 1.0650000 0.300000 1.0660000 0.300000 1.0670000 0.300000
+ 1.0680000 0.300000 1.0690000 0.300000 1.0700000 0.300000 1.0710000 0.300000
+ 1.0720000 0.300000 1.0730000 0.300000 1.0740000 0.300000 1.0750000 0.300000
+ 1.0760000 0.300000 1.0770000 0.300000 1.0780000 0.300000 1.0790000 0.300000
+ 1.0800000 0.300000 1.0810000 0.300000 1.0820000 0.300000 1.0830000 0.300000
+ 1.0840000 0.300000 1.0850000 0.300000 1.0860000 0.300000 1.0870000 0.300000
+ 1.0880000 0.300000 1.0890000 0.300000 1.0900000 0.300000 1.0910000 0.300000
+ 1.0920000 0.300000 1.0930000 0.300000 1.0940000 0.300000 1.0950000 0.300000
+ 1.0960000 0.300000 1.0970000 0.300000 1.0980000 0.300000 1.0990000 0.300000
+ 1.1000000 0.300000 1.1010000 0.300000 1.1020000 0.300000 1.1030000 0.300000
+ 1.1040000 0.300000 1.1050000 0.300000 1.1060000 0.300000 1.1070000 0.300000
+ 1.1080000 0.300000 1.1090000 0.300000 1.1100000 0.300000 1.1110000 0.300000
+ 1.1120000 0.300000 1.1130000 0.300000 1.1140000 0.300000 1.1150000 0.300000
+ 1.1160000 0.300000 1.1170000 0.300000 1.1180000 0.300000 1.1190000 0.300000
+ 1.1200000 0.300000 1.1210000 0.300000 1.1220000 0.300000 1.1230000 0.300000
+ 1.1240000 0.300000 1.1250000 0.300000 1.1260000 0.300000 1.1270000 0.300000
+ 1.1280000 0.300000 1.1290000 0.300000 1.1300000 0.300000 1.1310000 0.300000
+ 1.1320000 0.300000 1.1330000 0.300000 1.1340000 0.300000 1.1350000 0.300000
+ 1.1360000 0.300000 1.1370000 0.300000 1.1380000 0.300000 1.1390000 0.300000
+ 1.1400000 0.300000 1.1410000 0.300000 1.1420000 0.300000 1.1430000 0.300000
+ 1.1440000 0.300000 1.1450000 0.300000 1.1460000 0.300000 1.1470000 0.300000
+ 1.1480000 0.300000 1.1490000 0.300000 1.1500000 0.300000 1.1510000 0.300000
+ 1.1520000 0.300000 1.1530000 0.300000 1.1540000 0.300000 1.1550000 0.300000
+ 1.1560000 0.300000 1.1570000 0.300000 1.1580000 0.300000 1.1590000 0.300000
+ 1.1600000 0.300000 1.1610000 0.300000 1.1620000 0.300000 1.1630000 0.300000
+ 1.1640000 0.300000 1.1650000 0.300000 1.1660000 0.300000 1.1670000 0.300000
+ 1.1680000 0.300000 1.1690000 0.300000 1.1700000 0.300000 1.1710000 0.300000
+ 1.1720000 0.300000 1.1730000 0.300000 1.1740000 0.300000 1.1750000 0.300000
+ 1.1760000 0.300000 1.1770000 0.300000 1.1780000 0.300000 1.1790000 0.300000
+ 1.1800000 0.300000 1.1810000 0.300000 1.1820000 0.300000 1.1830000 0.300000
+ 1.1840000 0.300000 1.1850000 0.300000 1.1860000 0.300000 1.1870000 0.300000
+ 1.1880000 0.300000 1.1890000 0.300000 1.1900000 0.300000 1.1910000 0.300000
+ 1.1920000 0.300000 1.1930000 0.300000 1.1940000 0.300000 1.1950000 0.300000
+ 1.1960000 0.300000 1.1970000 0.300000 1.1980000 0.300000 1.1990000 0.300000
+ 1.2000000 0.300000 1.2010000 0.300000 1.2020000 0.300000 1.2030000 0.300000
+ 1.2040000 0.300000 1.2050000 0.300000 1.2060000 0.300000 1.2070000 0.300000
+ 1.2080000 0.300000 1.2090000 0.300000 1.2100000 0.300000 1.2110000 0.300000
+ 1.2120000 0.300000 1.2130000 0.300000 1.2140000 0.300000 1.2150000 0.300000
+ 1.2160000 0.300000 1.2170000 0.300000 1.2180000 0.300000 1.2190000 0.300000
+ 1.2200000 0.300000 1.2210000 0.300000 1.2220000 0.300000 1.2230000 0.300000
+ 1.2240000 0.300000 1.2250000 0.300000 1.2260000 0.300000 1.2270000 0.300000
+ 1.2280000 0.300000 1.2290000 0.300000 1.2300000 0.300000 1.2310000 0.300000
+ 1.2320000 0.300000 1.2330000 0.300000 1.2340000 0.300000 1.2350000 0.300000
+ 1.2360000 0.300000 1.2370000 0.300000 1.2380000 0.300000 1.2390000 0.300000
+ 1.2400000 0.300000 1.2410000 0.300000 1.2420000 0.300000 1.2430000 0.300000
+ 1.2440000 0.300000 1.2450000 0.300000 1.2460000 0.300000 1.2470000 0.300000
+ 1.2480000 0.300000 1.2490000 0.300000 1.2500000 0.300000 1.2510000 0.300000
+ 1.2520000 0.300000 1.2530000 0.300000 1.2540000 0.300000 1.2550000 0.300000
+ 1.2560000 0.300000 1.2570000 0.300000 1.2580000 0.300000 1.2590000 0.300000
+ 1.2600000 0.300000 1.2610000 0.300000 1.2620000 0.300000 1.2630000 0.300000
+ 1.2640000 0.300000 1.2650000 0.300000 1.2660000 0.300000 1.2670000 0.300000
+ 1.2680000 0.300000 1.2690000 0.300000 1.2700000 0.300000 1.2710000 0.300000
+ 1.2720000 0.300000 1.2730000 0.300000 1.2740000 0.300000 1.2750000 0.300000
+ 1.2760000 0.300000 1.2770000 0.300000 1.2780000 0.300000 1.2790000 0.300000
+ 1.2800000 0.300000 1.2810000 0.305000 1.2820000 0.310000 1.2830000 0.315000
+ 1.2840000 0.320000 1.2850000 0.325000 1.2860000 0.330000 1.2870000 0.335000
+ 1.2880000 0.340000 1.2890000 0.345000 1.2900000 0.350000 1.2910000 0.355000
+ 1.2920000 0.360000 1.2930000 0.365000 1.2940000 0.370000 1.2950000 0.375000
+ 1.2960000 0.380000 1.2970000 0.385000 1.2980000 0.390000 1.2990000 0.395000
+ 1.3000000 0.400000 1.3010000 0.395000 1.3020000 0.390000 1.3030000 0.385000
+ 1.3040000 0.380000 1.3050000 0.375000 1.3060000 0.370000 1.3070000 0.365000
+ 1.3080000 0.360000 1.3090000 0.355000 1.3100000 0.350000 1.3110000 0.345000
+ 1.3120000 0.340000 1.3130000 0.335000 1.3140000 0.330000 1.3150000 0.325000
+ 1.3160000 0.320000 1.3170000 0.315000 1.3180000 0.310000 1.3190000 0.305000
+ 1.3200000 0.300000 1.3210000 0.300000 1.3220000 0.300000 1.3230000 0.300000
+ 1.3240000 0.300000 1.3250000 0.300000 1.3260000 0.300000 1.3270000 0.300000
+ 1.3280000 0.300000 1.3290000 0.300000 1.3300000 0.300000 1.3310000 0.300000
+ 1.3320000 0.300000 1.3330000 0.300000 1.3340000 0.300000 1.3350000 0.300000
+ 1.3360000 0.300000 1.3370000 0.300000 1.3380000 0.300000 1.3390000 0.300000
+ 1.3400000 0.300000 1.3410000 0.300000 1.3420000 0.300000 1.3430000 0.300000
+ 1.3440000 0.300000 1.3450000 0.300000 1.3460000 0.300000 1.3470000 0.300000
+ 1.3480000 0.300000 1.3490000 0.300000 1.3500000 0.300000 1.3510000 0.300000
+ 1.3520000 0.300000 1.3530000 0.300000 1.3540000 0.300000 1.3550000 0.300000
+ 1.3560000 0.300000 1.3570000 0.300000 1.3580000 0.300000 1.3590000 0.300000
+ 1.3600000 0.300000 1.3610000 0.300000 1.3620000 0.300000 1.3630000 0.300000
+ 1.3640000 0.300000 1.3650000 0.300000 1.3660000 0.300000 1.3670000 0.300000
+ 1.3680000 0.300000 1.3690000 0.300000 1.3700000 0.300000 1.3710000 0.300000
+ 1.3720000 0.300000 1.3730000 0.300000 1.3740000 0.300000 1.3750000 0.300000
+ 1.3760000 0.300000 1.3770000 0.300000 1.3780000 0.300000 1.3790000 0.300000
+ 1.3800000 0.300000 1.3810000 0.300000 1.3820000 0.300000 1.3830000 0.300000
+ 1.3840000 0.300000 1.3850000 0.300000 1.3860000 0.300000 1.3870000 0.300000
+ 1.3880000 0.300000 1.3890000 0.300000 1.3900000 0.300000 1.3910000 0.300000
+ 1.3920000 0.300000 1.3930000 0.300000 1.3940000 0.300000 1.3950000 0.300000
+ 1.3960000 0.300000 1.3970000 0.300000 1.3980000 0.300000 1.3990000 0.300000
+ 1.4000000 0.300000 1.4010000 0.300000 1.4020000 0.300000 1.4030000 0.300000
+ 1.4040000 0.300000 1.4050000 0.300000 1.4060000 0.300000 1.4070000 0.300000
+ 1.4080000 0.300000 1.4090000 0.300000 1.4100000 0.300000 1.4110000 0.300000
+ 1.4120000 0.300000 1.4130000 0.300000 1.4140000 0.300000 1.4150000 0.300000
+ 1.4160000 0.300000 1.4170000 0.300000 1.4180000 0.300000 1.4190000 0.300000
+ 1.4200000 0.300000 1.4210000 0.300000 1.4220000 0.300000 1.4230000 0.300000
+ 1.4240000 0.300000 1.4250000 0.300000 1.4260000 0.300000 1.4270000 0.300000
+ 1.4280000 0.300000 1.4290000 0.300000 1.4300000 0.300000 1.4310000 0.300000
+ 1.4320000 0.300000 1.4330000 0.300000 1.4340000 0.300000 1.4350000 0.300000
+ 1.4360000 0.300000 1.4370000 0.300000 1.4380000 0.300000 1.4390000 0.300000
+ 1.4400000 0.300000 1.4410000 0.300000 1.4420000 0.300000 1.4430000 0.300000
+ 1.4440000 0.300000 1.4450000 0.300000 1.4460000 0.300000 1.4470000 0.300000
+ 1.4480000 0.300000 1.4490000 0.300000 1.4500000 0.300000 1.4510000 0.300000
+ 1.4520000 0.300000 1.4530000 0.300000 1.4540000 0.300000 1.4550000 0.300000
+ 1.4560000 0.300000 1.4570000 0.300000 1.4580000 0.300000 1.4590000 0.300000
+ 1.4600000 0.300000 1.4610000 0.300000 1.4620000 0.300000 1.4630000 0.300000
+ 1.4640000 0.300000 1.4650000 0.300000 1.4660000 0.300000 1.4670000 0.300000
+ 1.4680000 0.300000 1.4690000 0.300000 1.4700000 0.300000 1.4710000 0.300000
+ 1.4720000 0.300000 1.4730000 0.300000 1.4740000 0.300000 1.4750000 0.300000
+ 1.4760000 0.300000 1.4770000 0.300000 1.4780000 0.300000 1.4790000 0.300000
+ 1.4800000 0.300000 1.4810000 0.300000 1.4820000 0.300000 1.4830000 0.300000
+ 1.4840000 0.300000 1.4850000 0.300000 1.4860000 0.300000 1.4870000 0.300000
+ 1.4880000 0.300000 1.4890000 0.300000 1.4900000 0.300000 1.4910000 0.300000
+ 1.4920000 0.300000 1.4930000 0.300000 1.4940000 0.300000 1.4950000 0.300000
+ 1.4960000 0.300000 1.4970000 0.300000 1.4980000 0.300000 1.4990000 0.300000
+ 1.5000000 0.300000 1.5010000 0.300000 1.5020000 0.300000 1.5030000 0.300000
+ 1.5040000 0.300000 1.5050000 0.300000 1.5060000 0.300000 1.5070000 0.300000
+ 1.5080000 0.300000 1.5090000 0.300000 1.5100000 0.300000 1.5110000 0.300000
+ 1.5120000 0.300000 1.5130000 0.300000 1.5140000 0.300000 1.5150000 0.300000
+ 1.5160000 0.300000 1.5170000 0.300000 1.5180000 0.300000 1.5190000 0.300000
+ 1.5200000 0.300000 1.5210000 0.300000 1.5220000 0.300000 1.5230000 0.300000
+ 1.5240000 0.300000 1.5250000 0.300000 1.5260000 0.300000 1.5270000 0.300000
+ 1.5280000 0.300000 1.5290000 0.300000 1.5300000 0.300000 1.5310000 0.300000
+ 1.5320000 0.300000 1.5330000 0.300000 1.5340000 0.300000 1.5350000 0.300000
+ 1.5360000 0.300000 1.5370000 0.300000 1.5380000 0.300000 1.5390000 0.300000
+ 1.5400000 0.300000 1.5410000 0.300000 1.5420000 0.300000 1.5430000 0.300000
+ 1.5440000 0.300000 1.5450000 0.300000 1.5460000 0.300000 1.5470000 0.300000
+ 1.5480000 0.300000 1.5490000 0.300000 1.5500000 0.300000 1.5510000 0.300000
+ 1.5520000 0.300000 1.5530000 0.300000 1.5540000 0.300000 1.5550000 0.300000
+ 1.5560000 0.300000 1.5570000 0.300000 1.5580000 0.300000 1.5590000 0.300000
+ 1.5600000 0.300000 1.5610000 0.300000 1.5620000 0.300000 1.5630000 0.300000
+ 1.5640000 0.300000 1.5650000 0.300000 1.5660000 0.300000 1.5670000 0.300000
+ 1.5680000 0.300000 1.5690000 0.300000 1.5700000 0.300000 1.5710000 0.300000
+ 1.5720000 0.300000 1.5730000 0.300000 1.5740000 0.300000 1.5750000 0.300000
+ 1.5760000 0.300000 1.5770000 0.300000 1.5780000 0.300000 1.5790000 0.300000
+ 1.5800000 0.300000 1.5810000 0.300000 1.5820000 0.300000 1.5830000 0.300000
+ 1.5840000 0.300000 1.5850000 0.300000 1.5860000 0.300000 1.5870000 0.300000
+ 1.5880000 0.300000 1.5890000 0.300000 1.5900000 0.300000 1.5910000 0.300000
+ 1.5920000 0.300000 1.5930000 0.300000 1.5940000 0.300000 1.5950000 0.300000
+ 1.5960000 0.300000 1.5970000 0.300000 1.5980000 0.300000 1.5990000 0.300000
+ 1.6000000 0.300000 1.6010000 0.300000 1.6020000 0.300000 1.6030000 0.300000
+ 1.6040000 0.300000 1.6050000 0.300000 1.6060000 0.300000 1.6070000 0.300000
+ 1.6080000 0.300000 1.6090000 0.300000 1.6100000 0.300000 1.6110000 0.300000
+ 1.6120000 0.300000 1.6130000 0.300000 1.6140000 0.300000 1.6150000 0.300000
+ 1.6160000 0.300000 1.6170000 0.300000 1.6180000 0.300000 1.6190000 0.300000
+ 1.6200000 0.300000 1.6210000 0.300000 1.6220000 0.300000 1.6230000 0.300000
+ 1.6240000 0.300000 1.6250000 0.300000 1.6260000 0.300000 1.6270000 0.300000
+ 1.6280000 0.300000 1.6290000 0.300000 1.6300000 0.300000 1.6310000 0.300000
+ 1.6320000 0.300000 1.6330000 0.300000 1.6340000 0.300000 1.6350000 0.300000
+ 1.6360000 0.300000 1.6370000 0.300000 1.6380000 0.300000 1.6390000 0.300000
+ 1.6400000 0.300000 1.6410000 0.300000 1.6420000 0.300000 1.6430000 0.300000
+ 1.6440000 0.300000 1.6450000 0.300000 1.6460000 0.300000 1.6470000 0.300000
+ 1.6480000 0.300000 1.6490000 0.300000 1.6500000 0.300000 1.6510000 0.300000
+ 1.6520000 0.300000 1.6530000 0.300000 1.6540000 0.300000 1.6550000 0.300000
+ 1.6560000 0.300000 1.6570000 0.300000 1.6580000 0.300000 1.6590000 0.300000
+ 1.6600000 0.300000 1.6610000 0.300000 1.6620000 0.300000 1.6630000 0.300000
+ 1.6640000 0.300000 1.6650000 0.300000 1.6660000 0.300000 1.6670000 0.300000
+ 1.6680000 0.300000 1.6690000 0.300000 1.6700000 0.300000 1.6710000 0.300000
+ 1.6720000 0.300000 1.6730000 0.300000 1.6740000 0.300000 1.6750000 0.300000
+ 1.6760000 0.300000 1.6770000 0.300000 1.6780000 0.300000 1.6790000 0.300000
+ 1.6800000 0.300000 1.6810000 0.300000 1.6820000 0.300000 1.6830000 0.300000
+ 1.6840000 0.300000 1.6850000 0.300000 1.6860000 0.300000 1.6870000 0.300000
+ 1.6880000 0.300000 1.6890000 0.300000 1.6900000 0.300000 1.6910000 0.300000
+ 1.6920000 0.300000 1.6930000 0.300000 1.6940000 0.300000 1.6950000 0.300000
+ 1.6960000 0.300000 1.6970000 0.300000 1.6980000 0.300000 1.6990000 0.300000
+ 1.7000000 0.300000 1.7010000 0.300000 1.7020000 0.300000 1.7030000 0.300000
+ 1.7040000 0.300000 1.7050000 0.300000 1.7060000 0.300000 1.7070000 0.300000
+ 1.7080000 0.300000 1.7090000 0.300000 1.7100000 0.300000 1.7110000 0.300000
+ 1.7120000 0.300000 1.7130000 0.300000 1.7140000 0.300000 1.7150000 0.300000
+ 1.7160000 0.300000 1.7170000 0.300000 1.7180000 0.300000 1.7190000 0.300000
+ 1.7200000 0.300000 1.7210000 0.300000 1.7220000 0.300000 1.7230000 0.300000
+ 1.7240000 0.300000 1.7250000 0.300000 1.7260000 0.300000 1.7270000 0.300000
+ 1.7280000 0.300000 1.7290000 0.300000 1.7300000 0.300000 1.7310000 0.300000
+ 1.7320000 0.300000 1.7330000 0.300000 1.7340000 0.300000 1.7350000 0.300000
+ 1.7360000 0.300000 1.7370000 0.300000 1.7380000 0.300000 1.7390000 0.300000
+ 1.7400000 0.300000 1.7410000 0.300000 1.7420000 0.300000 1.7430000 0.300000
+ 1.7440000 0.300000 1.7450000 0.300000 1.7460000 0.300000 1.7470000 0.300000
+ 1.7480000 0.300000 1.7490000 0.300000 1.7500000 0.300000 1.7510000 0.300000
+ 1.7520000 0.300000 1.7530000 0.300000 1.7540000 0.300000 1.7550000 0.300000
+ 1.7560000 0.300000 1.7570000 0.300000 1.7580000 0.300000 1.7590000 0.300000
+ 1.7600000 0.300000 1.7610000 0.300000 1.7620000 0.300000 1.7630000 0.300000
+ 1.7640000 0.300000 1.7650000 0.300000 1.7660000 0.300000 1.7670000 0.300000
+ 1.7680000 0.300000 1.7690000 0.300000 1.7700000 0.300000 1.7710000 0.300000
+ 1.7720000 0.300000 1.7730000 0.300000 1.7740000 0.300000 1.7750000 0.300000
+ 1.7760000 0.300000 1.7770000 0.300000 1.7780000 0.300000 1.7790000 0.300000
+ 1.7800000 0.300000 1.7810000 0.300000 1.7820000 0.300000 1.7830000 0.300000
+ 1.7840000 0.300000 1.7850000 0.300000 1.7860000 0.300000 1.7870000 0.300000
+ 1.7880000 0.300000 1.7890000 0.300000 1.7900000 0.300000 1.7910000 0.300000
+ 1.7920000 0.300000 1.7930000 0.300000 1.7940000 0.300000 1.7950000 0.300000
+ 1.7960000 0.300000 1.7970000 0.300000 1.7980000 0.300000 1.7990000 0.300000
+ 1.8000000 0.300000 1.8010000 0.300000 1.8020000 0.300000 1.8030000 0.300000
+ 1.8040000 0.300000 1.8050000 0.300000 1.8060000 0.300000 1.8070000 0.300000
+ 1.8080000 0.300000 1.8090000 0.300000 1.8100000 0.300000 1.8110000 0.300000
+ 1.8120000 0.300000 1.8130000 0.300000 1.8140000 0.300000 1.8150000 0.300000
+ 1.8160000 0.300000 1.8170000 0.300000 1.8180000 0.300000 1.8190000 0.300000
+ 1.8200000 0.300000 1.8210000 0.300000 1.8220000 0.300000 1.8230000 0.300000
+ 1.8240000 0.300000 1.8250000 0.300000 1.8260000 0.300000 1.8270000 0.300000
+ 1.8280000 0.300000 1.8290000 0.300000 1.8300000 0.300000 1.8310000 0.300000
+ 1.8320000 0.300000 1.8330000 0.300000 1.8340000 0.300000 1.8350000 0.300000
+ 1.8360000 0.300000 1.8370000 0.300000 1.8380000 0.300000 1.8390000 0.300000
+ 1.8400000 0.300000 1.8410000 0.300000 1.8420000 0.300000 1.8430000 0.300000
+ 1.8440000 0.300000 1.8450000 0.300000 1.8460000 0.300000 1.8470000 0.300000
+ 1.8480000 0.300000 1.8490000 0.300000 1.8500000 0.300000 1.8510000 0.300000
+ 1.8520000 0.300000 1.8530000 0.300000 1.8540000 0.300000 1.8550000 0.300000
+ 1.8560000 0.300000 1.8570000 0.300000 1.8580000 0.300000 1.8590000 0.300000
+ 1.8600000 0.300000 1.8610000 0.300000 1.8620000 0.300000 1.8630000 0.300000
+ 1.8640000 0.300000 1.8650000 0.300000 1.8660000 0.300000 1.8670000 0.300000
+ 1.8680000 0.300000 1.8690000 0.300000 1.8700000 0.300000 1.8710000 0.300000
+ 1.8720000 0.300000 1.8730000 0.300000 1.8740000 0.300000 1.8750000 0.300000
+ 1.8760000 0.300000 1.8770000 0.300000 1.8780000 0.300000 1.8790000 0.300000
+ 1.8800000 0.300000 1.8810000 0.300000 1.8820000 0.300000 1.8830000 0.300000
+ 1.8840000 0.300000 1.8850000 0.300000 1.8860000 0.300000 1.8870000 0.300000
+ 1.8880000 0.300000 1.8890000 0.300000 1.8900000 0.300000 1.8910000 0.300000
+ 1.8920000 0.300000 1.8930000 0.300000 1.8940000 0.300000 1.8950000 0.300000
+ 1.8960000 0.300000 1.8970000 0.300000 1.8980000 0.300000 1.8990000 0.300000
+ 1.9000000 0.300000 1.9010000 0.300000 1.9020000 0.300000 1.9030000 0.300000
+ 1.9040000 0.300000 1.9050000 0.300000 1.9060000 0.300000 1.9070000 0.300000
+ 1.9080000 0.300000 1.9090000 0.300000 1.9100000 0.300000 1.9110000 0.300000
+ 1.9120000 0.300000 1.9130000 0.300000 1.9140000 0.300000 1.9150000 0.300000
+ 1.9160000 0.300000 1.9170000 0.300000 1.9180000 0.300000 1.9190000 0.300000
+ 1.9200000 0.300000 1.9210000 0.300000 1.9220000 0.300000 1.9230000 0.300000
+ 1.9240000 0.300000 1.9250000 0.300000 1.9260000 0.300000 1.9270000 0.300000
+ 1.9280000 0.300000 1.9290000 0.300000 1.9300000 0.300000 1.9310000 0.300000
+ 1.9320000 0.300000 1.9330000 0.300000 1.9340000 0.300000 1.9350000 0.300000
+ 1.9360000 0.300000 1.9370000 0.300000 1.9380000 0.300000 1.9390000 0.300000
+ 1.9400000 0.300000 1.9410000 0.300000 1.9420000 0.300000 1.9430000 0.300000
+ 1.9440000 0.300000 1.9450000 0.300000 1.9460000 0.300000 1.9470000 0.300000
+ 1.9480000 0.300000 1.9490000 0.300000 1.9500000 0.300000 1.9510000 0.300000
+ 1.9520000 0.300000 1.9530000 0.300000 1.9540000 0.300000 1.9550000 0.300000
+ 1.9560000 0.300000 1.9570000 0.300000 1.9580000 0.300000 1.9590000 0.300000
+ 1.9600000 0.300000 1.9610000 0.300000 1.9620000 0.300000 1.9630000 0.300000
+ 1.9640000 0.300000 1.9650000 0.300000 1.9660000 0.300000 1.9670000 0.300000
+ 1.9680000 0.300000 1.9690000 0.300000 1.9700000 0.300000 1.9710000 0.300000
+ 1.9720000 0.300000 1.9730000 0.300000 1.9740000 0.300000 1.9750000 0.300000
+ 1.9760000 0.300000 1.9770000 0.300000 1.9780000 0.300000 1.9790000 0.300000
+ 1.9800000 0.300000 1.9810000 0.300000 1.9820000 0.300000 1.9830000 0.300000
+ 1.9840000 0.300000 1.9850000 0.300000 1.9860000 0.300000 1.9870000 0.300000
+ 1.9880000 0.300000 1.9890000 0.300000 1.9900000 0.300000 1.9910000 0.300000
+ 1.9920000 0.300000 1.9930000 0.300000 1.9940000 0.300000 1.9950000 0.300000
+ 1.9960000 0.300000 1.9970000 0.300000 1.9980000 0.300000 1.9990000 0.300000
+ 2.0000000 0.300000 2.0010000 0.300000 2.0020000 0.300000 2.0030000 0.300000
+ 2.0040000 0.300000 2.0050000 0.300000 2.0060000 0.300000 2.0070000 0.300000
+ 2.0080000 0.300000 2.0090000 0.300000 2.0100000 0.300000 2.0110000 0.300000
+ 2.0120000 0.300000 2.0130000 0.300000 2.0140000 0.300000 2.0150000 0.300000
+ 2.0160000 0.300000 2.0170000 0.300000 2.0180000 0.300000 2.0190000 0.300000
+ 2.0200000 0.300000 2.0210000 0.300000 2.0220000 0.300000 2.0230000 0.300000
+ 2.0240000 0.300000 2.0250000 0.300000 2.0260000 0.300000 2.0270000 0.300000
+ 2.0280000 0.300000 2.0290000 0.300000 2.0300000 0.300000 2.0310000 0.300000
+ 2.0320000 0.300000 2.0330000 0.300000 2.0340000 0.300000 2.0350000 0.300000
+ 2.0360000 0.300000 2.0370000 0.300000 2.0380000 0.300000 2.0390000 0.300000
+ 2.0400000 0.300000 2.0410000 0.300000 2.0420000 0.300000 2.0430000 0.300000
+ 2.0440000 0.300000 2.0450000 0.300000 2.0460000 0.300000 2.0470000 0.300000
+ 2.0480000 0.300000 2.0490000 0.300000 2.0500000 0.300000 2.0510000 0.300000
+ 2.0520000 0.300000 2.0530000 0.300000 2.0540000 0.300000 2.0550000 0.300000
+ 2.0560000 0.300000 2.0570000 0.300000 2.0580000 0.300000 2.0590000 0.300000
+ 2.0600000 0.300000 2.0610000 0.300000 2.0620000 0.300000 2.0630000 0.300000
+ 2.0640000 0.300000 2.0650000 0.300000 2.0660000 0.300000 2.0670000 0.300000
+ 2.0680000 0.300000 2.0690000 0.300000 2.0700000 0.300000 2.0710000 0.300000
+ 2.0720000 0.300000 2.0730000 0.300000 2.0740000 0.300000 2.0750000 0.300000
+ 2.0760000 0.300000 2.0770000 0.300000 2.0780000 0.300000 2.0790000 0.300000
+ 2.0800000 0.300000 2.0810000 0.305000 2.0820000 0.310000 2.0830000 0.315000
+ 2.0840000 0.320000 2.0850000 0.325000 2.0860000 0.330000 2.0870000 0.335000
+ 2.0880000 0.340000 2.0890000 0.345000 2.0900000 0.350000 2.0910000 0.355000
+ 2.0920000 0.360000 2.0930000 0.365000 2.0940000 0.370000 2.0950000 0.375000
+ 2.0960000 0.380000 2.0970000 0.385000 2.0980000 0.390000 2.0990000 0.395000
+ 2.1000000 0.400000 2.1010000 0.395000 2.1020000 0.390000 2.1030000 0.385000
+ 2.1040000 0.380000 2.1050000 0.375000 2.1060000 0.370000 2.1070000 0.365000
+ 2.1080000 0.360000 2.1090000 0.355000 2.1100000 0.350000 2.1110000 0.345000
+ 2.1120000 0.340000 2.1130000 0.335000 2.1140000 0.330000 2.1150000 0.325000
+ 2.1160000 0.320000 2.1170000 0.315000 2.1180000 0.310000 2.1190000 0.305000
+ 2.1200000 0.300000 2.1210000 0.300000 2.1220000 0.300000 2.1230000 0.300000
+ 2.1240000 0.300000 2.1250000 0.300000 2.1260000 0.300000 2.1270000 0.300000
+ 2.1280000 0.300000 2.1290000 0.300000 2.1300000 0.300000 2.1310000 0.300000
+ 2.1320000 0.300000 2.1330000 0.300000 2.1340000 0.300000 2.1350000 0.300000
+ 2.1360000 0.300000 2.1370000 0.300000 2.1380000 0.300000 2.1390000 0.300000
+ 2.1400000 0.300000 2.1410000 0.300000 2.1420000 0.300000 2.1430000 0.300000
+ 2.1440000 0.300000 2.1450000 0.300000 2.1460000 0.300000 2.1470000 0.300000
+ 2.1480000 0.300000 2.1490000 0.300000 2.1500000 0.300000 2.1510000 0.300000
+ 2.1520000 0.300000 2.1530000 0.300000 2.1540000 0.300000 2.1550000 0.300000
+ 2.1560000 0.300000 2.1570000 0.300000 2.1580000 0.300000 2.1590000 0.300000
+ 2.1600000 0.300000 2.1610000 0.300000 2.1620000 0.300000 2.1630000 0.300000
+ 2.1640000 0.300000 2.1650000 0.300000 2.1660000 0.300000 2.1670000 0.300000
+ 2.1680000 0.300000 2.1690000 0.300000 2.1700000 0.300000 2.1710000 0.300000
+ 2.1720000 0.300000 2.1730000 0.300000 2.1740000 0.300000 2.1750000 0.300000
+ 2.1760000 0.300000 2.1770000 0.300000 2.1780000 0.300000 2.1790000 0.300000
+ 2.1800000 0.300000 2.1810000 0.300000 2.1820000 0.300000 2.1830000 0.300000
+ 2.1840000 0.300000 2.1850000 0.300000 2.1860000 0.300000 2.1870000 0.300000
+ 2.1880000 0.300000 2.1890000 0.300000 2.1900000 0.300000 2.1910000 0.300000
+ 2.1920000 0.300000 2.1930000 0.300000 2.1940000 0.300000 2.1950000 0.300000
+ 2.1960000 0.300000 2.1970000 0.300000 2.1980000 0.300000 2.1990000 0.300000
+ 2.2000000 0.300000 2.2010000 0.300000 2.2020000 0.300000 2.2030000 0.300000
+ 2.2040000 0.300000 2.2050000 0.300000 2.2060000 0.300000 2.2070000 0.300000
+ 2.2080000 0.300000 2.2090000 0.300000 2.2100000 0.300000 2.2110000 0.300000
+ 2.2120000 0.300000 2.2130000 0.300000 2.2140000 0.300000 2.2150000 0.300000
+ 2.2160000 0.300000 2.2170000 0.300000 2.2180000 0.300000 2.2190000 0.300000
+ 2.2200000 0.300000 2.2210000 0.300000 2.2220000 0.300000 2.2230000 0.300000
+ 2.2240000 0.300000 2.2250000 0.300000 2.2260000 0.300000 2.2270000 0.300000
+ 2.2280000 0.300000 2.2290000 0.300000 2.2300000 0.300000 2.2310000 0.300000
+ 2.2320000 0.300000 2.2330000 0.300000 2.2340000 0.300000 2.2350000 0.300000
+ 2.2360000 0.300000 2.2370000 0.300000 2.2380000 0.300000 2.2390000 0.300000
+ 2.2400000 0.300000 2.2410000 0.300000 2.2420000 0.300000 2.2430000 0.300000
+ 2.2440000 0.300000 2.2450000 0.300000 2.2460000 0.300000 2.2470000 0.300000
+ 2.2480000 0.300000 2.2490000 0.300000 2.2500000 0.300000 2.2510000 0.300000
+ 2.2520000 0.300000 2.2530000 0.300000 2.2540000 0.300000 2.2550000 0.300000
+ 2.2560000 0.300000 2.2570000 0.300000 2.2580000 0.300000 2.2590000 0.300000
+ 2.2600000 0.300000 2.2610000 0.300000 2.2620000 0.300000 2.2630000 0.300000
+ 2.2640000 0.300000 2.2650000 0.300000 2.2660000 0.300000 2.2670000 0.300000
+ 2.2680000 0.300000 2.2690000 0.300000 2.2700000 0.300000 2.2710000 0.300000
+ 2.2720000 0.300000 2.2730000 0.300000 2.2740000 0.300000 2.2750000 0.300000
+ 2.2760000 0.300000 2.2770000 0.300000 2.2780000 0.300000 2.2790000 0.300000
+ 2.2800000 0.300000 2.2810000 0.300000 2.2820000 0.300000 2.2830000 0.300000
+ 2.2840000 0.300000 2.2850000 0.300000 2.2860000 0.300000 2.2870000 0.300000
+ 2.2880000 0.300000 2.2890000 0.300000 2.2900000 0.300000 2.2910000 0.300000
+ 2.2920000 0.300000 2.2930000 0.300000 2.2940000 0.300000 2.2950000 0.300000
+ 2.2960000 0.300000 2.2970000 0.300000 2.2980000 0.300000 2.2990000 0.300000
+ 2.3000000 0.300000 2.3010000 0.300000 2.3020000 0.300000 2.3030000 0.300000
+ 2.3040000 0.300000 2.3050000 0.300000 2.3060000 0.300000 2.3070000 0.300000
+ 2.3080000 0.300000 2.3090000 0.300000 2.3100000 0.300000 2.3110000 0.300000
+ 2.3120000 0.300000 2.3130000 0.300000 2.3140000 0.300000 2.3150000 0.300000
+ 2.3160000 0.300000 2.3170000 0.300000 2.3180000 0.300000 2.3190000 0.300000
+ 2.3200000 0.300000 2.3210000 0.300000 2.3220000 0.300000 2.3230000 0.300000
+ 2.3240000 0.300000 2.3250000 0.300000 2.3260000 0.300000 2.3270000 0.300000
+ 2.3280000 0.300000 2.3290000 0.300000 2.3300000 0.300000 2.3310000 0.300000
+ 2.3320000 0.300000 2.3330000 0.300000 2.3340000 0.300000 2.3350000 0.300000
+ 2.3360000 0.300000 2.3370000 0.300000 2.3380000 0.300000 2.3390000 0.300000
+ 2.3400000 0.300000 2.3410000 0.300000 2.3420000 0.300000 2.3430000 0.300000
+ 2.3440000 0.300000 2.3450000 0.300000 2.3460000 0.300000 2.3470000 0.300000
+ 2.3480000 0.300000 2.3490000 0.300000 2.3500000 0.300000 2.3510000 0.300000
+ 2.3520000 0.300000 2.3530000 0.300000 2.3540000 0.300000 2.3550000 0.300000
+ 2.3560000 0.300000 2.3570000 0.300000 2.3580000 0.300000 2.3590000 0.300000
+ 2.3600000 0.300000 2.3610000 0.300000 2.3620000 0.300000 2.3630000 0.300000
+ 2.3640000 0.300000 2.3650000 0.300000 2.3660000 0.300000 2.3670000 0.300000
+ 2.3680000 0.300000 2.3690000 0.300000 2.3700000 0.300000 2.3710000 0.300000
+ 2.3720000 0.300000 2.3730000 0.300000 2.3740000 0.300000 2.3750000 0.300000
+ 2.3760000 0.300000 2.3770000 0.300000 2.3780000 0.300000 2.3790000 0.300000
+ 2.3800000 0.300000 2.3810000 0.300000 2.3820000 0.300000 2.3830000 0.300000
+ 2.3840000 0.300000 2.3850000 0.300000 2.3860000 0.300000 2.3870000 0.300000
+ 2.3880000 0.300000 2.3890000 0.300000 2.3900000 0.300000 2.3910000 0.300000
+ 2.3920000 0.300000 2.3930000 0.300000 2.3940000 0.300000 2.3950000 0.300000
+ 2.3960000 0.300000 2.3970000 0.300000 2.3980000 0.300000 2.3990000 0.300000
+ 2.4000000 0.300000 2.4010000 0.300000 2.4020000 0.300000 2.4030000 0.300000
+ 2.4040000 0.300000 2.4050000 0.300000 2.4060000 0.300000 2.4070000 0.300000
+ 2.4080000 0.300000 2.4090000 0.300000 2.4100000 0.300000 2.4110000 0.300000
+ 2.4120000 0.300000 2.4130000 0.300000 2.4140000 0.300000 2.4150000 0.300000
+ 2.4160000 0.300000 2.4170000 0.300000 2.4180000 0.300000 2.4190000 0.300000
+ 2.4200000 0.300000 2.4210000 0.300000 2.4220000 0.300000 2.4230000 0.300000
+ 2.4240000 0.300000 2.4250000 0.300000 2.4260000 0.300000 2.4270000 0.300000
+ 2.4280000 0.300000 2.4290000 0.300000 2.4300000 0.300000 2.4310000 0.300000
+ 2.4320000 0.300000 2.4330000 0.300000 2.4340000 0.300000 2.4350000 0.300000
+ 2.4360000 0.300000 2.4370000 0.300000 2.4380000 0.300000 2.4390000 0.300000
+ 2.4400000 0.300000 2.4410000 0.300000 2.4420000 0.300000 2.4430000 0.300000
+ 2.4440000 0.300000 2.4450000 0.300000 2.4460000 0.300000 2.4470000 0.300000
+ 2.4480000 0.300000 2.4490000 0.300000 2.4500000 0.300000 2.4510000 0.300000
+ 2.4520000 0.300000 2.4530000 0.300000 2.4540000 0.300000 2.4550000 0.300000
+ 2.4560000 0.300000 2.4570000 0.300000 2.4580000 0.300000 2.4590000 0.300000
+ 2.4600000 0.300000 2.4610000 0.300000 2.4620000 0.300000 2.4630000 0.300000
+ 2.4640000 0.300000 2.4650000 0.300000 2.4660000 0.300000 2.4670000 0.300000
+ 2.4680000 0.300000 2.4690000 0.300000 2.4700000 0.300000 2.4710000 0.300000
+ 2.4720000 0.300000 2.4730000 0.300000 2.4740000 0.300000 2.4750000 0.300000
+ 2.4760000 0.300000 2.4770000 0.300000 2.4780000 0.300000 2.4790000 0.300000
+ 2.4800000 0.300000 2.4810000 0.300000 2.4820000 0.300000 2.4830000 0.300000
+ 2.4840000 0.300000 2.4850000 0.300000 2.4860000 0.300000 2.4870000 0.300000
+ 2.4880000 0.300000 2.4890000 0.300000 2.4900000 0.300000 2.4910000 0.300000
+ 2.4920000 0.300000 2.4930000 0.300000 2.4940000 0.300000 2.4950000 0.300000
+ 2.4960000 0.300000 2.4970000 0.300000 2.4980000 0.300000 2.4990000 0.300000
+ 2.5000000 0.300000 2.5010000 0.300000 2.5020000 0.300000 2.5030000 0.300000
+ 2.5040000 0.300000 2.5050000 0.300000 2.5060000 0.300000 2.5070000 0.300000
+ 2.5080000 0.300000 2.5090000 0.300000 2.5100000 0.300000 2.5110000 0.300000
+ 2.5120000 0.300000 2.5130000 0.300000 2.5140000 0.300000 2.5150000 0.300000
+ 2.5160000 0.300000 2.5170000 0.300000 2.5180000 0.300000 2.5190000 0.300000
+ 2.5200000 0.300000 2.5210000 0.300000 2.5220000 0.300000 2.5230000 0.300000
+ 2.5240000 0.300000 2.5250000 0.300000 2.5260000 0.300000 2.5270000 0.300000
+ 2.5280000 0.300000 2.5290000 0.300000 2.5300000 0.300000 2.5310000 0.300000
+ 2.5320000 0.300000 2.5330000 0.300000 2.5340000 0.300000 2.5350000 0.300000
+ 2.5360000 0.300000 2.5370000 0.300000 2.5380000 0.300000 2.5390000 0.300000
+ 2.5400000 0.300000 2.5410000 0.300000 2.5420000 0.300000 2.5430000 0.300000
+ 2.5440000 0.300000 2.5450000 0.300000 2.5460000 0.300000 2.5470000 0.300000
+ 2.5480000 0.300000 2.5490000 0.300000 2.5500000 0.300000 2.5510000 0.300000
+ 2.5520000 0.300000 2.5530000 0.300000 2.5540000 0.300000 2.5550000 0.300000
+ 2.5560000 0.300000 2.5570000 0.300000 2.5580000 0.300000 2.5590000 0.300000
+ 2.5600000 0.300000 2.5610000 0.300000 2.5620000 0.300000 2.5630000 0.300000
+ 2.5640000 0.300000 2.5650000 0.300000 2.5660000 0.300000 2.5670000 0.300000
+ 2.5680000 0.300000 2.5690000 0.300000 2.5700000 0.300000 2.5710000 0.300000
+ 2.5720000 0.300000 2.5730000 0.300000 2.5740000 0.300000 2.5750000 0.300000
+ 2.5760000 0.300000 2.5770000 0.300000 2.5780000 0.300000 2.5790000 0.300000
+ 2.5800000 0.300000 2.5810000 0.300000 2.5820000 0.300000 2.5830000 0.300000
+ 2.5840000 0.300000 2.5850000 0.300000 2.5860000 0.300000 2.5870000 0.300000
+ 2.5880000 0.300000 2.5890000 0.300000 2.5900000 0.300000 2.5910000 0.300000
+ 2.5920000 0.300000 2.5930000 0.300000 2.5940000 0.300000 2.5950000 0.300000
+ 2.5960000 0.300000 2.5970000 0.300000 2.5980000 0.300000 2.5990000 0.300000
+ 2.6000000 0.300000 2.6010000 0.300000 2.6020000 0.300000 2.6030000 0.300000
+ 2.6040000 0.300000 2.6050000 0.300000 2.6060000 0.300000 2.6070000 0.300000
+ 2.6080000 0.300000 2.6090000 0.300000 2.6100000 0.300000 2.6110000 0.300000
+ 2.6120000 0.300000 2.6130000 0.300000 2.6140000 0.300000 2.6150000 0.300000
+ 2.6160000 0.300000 2.6170000 0.300000 2.6180000 0.300000 2.6190000 0.300000
+ 2.6200000 0.300000 2.6210000 0.300000 2.6220000 0.300000 2.6230000 0.300000
+ 2.6240000 0.300000 2.6250000 0.300000 2.6260000 0.300000 2.6270000 0.300000
+ 2.6280000 0.300000 2.6290000 0.300000 2.6300000 0.300000 2.6310000 0.300000
+ 2.6320000 0.300000 2.6330000 0.300000 2.6340000 0.300000 2.6350000 0.300000
+ 2.6360000 0.300000 2.6370000 0.300000 2.6380000 0.300000 2.6390000 0.300000
+ 2.6400000 0.300000 2.6410000 0.300000 2.6420000 0.300000 2.6430000 0.300000
+ 2.6440000 0.300000 2.6450000 0.300000 2.6460000 0.300000 2.6470000 0.300000
+ 2.6480000 0.300000 2.6490000 0.300000 2.6500000 0.300000 2.6510000 0.300000
+ 2.6520000 0.300000 2.6530000 0.300000 2.6540000 0.300000 2.6550000 0.300000
+ 2.6560000 0.300000 2.6570000 0.300000 2.6580000 0.300000 2.6590000 0.300000
+ 2.6600000 0.300000 2.6610000 0.300000 2.6620000 0.300000 2.6630000 0.300000
+ 2.6640000 0.300000 2.6650000 0.300000 2.6660000 0.300000 2.6670000 0.300000
+ 2.6680000 0.300000 2.6690000 0.300000 2.6700000 0.300000 2.6710000 0.300000
+ 2.6720000 0.300000 2.6730000 0.300000 2.6740000 0.300000 2.6750000 0.300000
+ 2.6760000 0.300000 2.6770000 0.300000 2.6780000 0.300000 2.6790000 0.300000
+ 2.6800000 0.300000 2.6810000 0.300000 2.6820000 0.300000 2.6830000 0.300000
+ 2.6840000 0.300000 2.6850000 0.300000 2.6860000 0.300000 2.6870000 0.300000
+ 2.6880000 0.300000 2.6890000 0.300000 2.6900000 0.300000 2.6910000 0.300000
+ 2.6920000 0.300000 2.6930000 0.300000 2.6940000 0.300000 2.6950000 0.300000
+ 2.6960000 0.300000 2.6970000 0.300000 2.6980000 0.300000 2.6990000 0.300000
+ 2.7000000 0.300000 2.7010000 0.300000 2.7020000 0.300000 2.7030000 0.300000
+ 2.7040000 0.300000 2.7050000 0.300000 2.7060000 0.300000 2.7070000 0.300000
+ 2.7080000 0.300000 2.7090000 0.300000 2.7100000 0.300000 2.7110000 0.300000
+ 2.7120000 0.300000 2.7130000 0.300000 2.7140000 0.300000 2.7150000 0.300000
+ 2.7160000 0.300000 2.7170000 0.300000 2.7180000 0.300000 2.7190000 0.300000
+ 2.7200000 0.300000 2.7210000 0.300000 2.7220000 0.300000 2.7230000 0.300000
+ 2.7240000 0.300000 2.7250000 0.300000 2.7260000 0.300000 2.7270000 0.300000
+ 2.7280000 0.300000 2.7290000 0.300000 2.7300000 0.300000 2.7310000 0.300000
+ 2.7320000 0.300000 2.7330000 0.300000 2.7340000 0.300000 2.7350000 0.300000
+ 2.7360000 0.300000 2.7370000 0.300000 2.7380000 0.300000 2.7390000 0.300000
+ 2.7400000 0.300000 2.7410000 0.300000 2.7420000 0.300000 2.7430000 0.300000
+ 2.7440000 0.300000 2.7450000 0.300000 2.7460000 0.300000 2.7470000 0.300000
+ 2.7480000 0.300000 2.7490000 0.300000 2.7500000 0.300000 2.7510000 0.300000
+ 2.7520000 0.300000 2.7530000 0.300000 2.7540000 0.300000 2.7550000 0.300000
+ 2.7560000 0.300000 2.7570000 0.300000 2.7580000 0.300000 2.7590000 0.300000
+ 2.7600000 0.300000 2.7610000 0.300000 2.7620000 0.300000 2.7630000 0.300000
+ 2.7640000 0.300000 2.7650000 0.300000 2.7660000 0.300000 2.7670000 0.300000
+ 2.7680000 0.300000 2.7690000 0.300000 2.7700000 0.300000 2.7710000 0.300000
+ 2.7720000 0.300000 2.7730000 0.300000 2.7740000 0.300000 2.7750000 0.300000
+ 2.7760000 0.300000 2.7770000 0.300000 2.7780000 0.300000 2.7790000 0.300000
+ 2.7800000 0.300000 2.7810000 0.300000 2.7820000 0.300000 2.7830000 0.300000
+ 2.7840000 0.300000 2.7850000 0.300000 2.7860000 0.300000 2.7870000 0.300000
+ 2.7880000 0.300000 2.7890000 0.300000 2.7900000 0.300000 2.7910000 0.300000
+ 2.7920000 0.300000 2.7930000 0.300000 2.7940000 0.300000 2.7950000 0.300000
+ 2.7960000 0.300000 2.7970000 0.300000 2.7980000 0.300000 2.7990000 0.300000
+ 2.8000000 0.300000 2.8010000 0.300000 2.8020000 0.300000 2.8030000 0.300000
+ 2.8040000 0.300000 2.8050000 0.300000 2.8060000 0.300000 2.8070000 0.300000
+ 2.8080000 0.300000 2.8090000 0.300000 2.8100000 0.300000 2.8110000 0.300000
+ 2.8120000 0.300000 2.8130000 0.300000 2.8140000 0.300000 2.8150000 0.300000
+ 2.8160000 0.300000 2.8170000 0.300000 2.8180000 0.300000 2.8190000 0.300000
+ 2.8200000 0.300000 2.8210000 0.300000 2.8220000 0.300000 2.8230000 0.300000
+ 2.8240000 0.300000 2.8250000 0.300000 2.8260000 0.300000 2.8270000 0.300000
+ 2.8280000 0.300000 2.8290000 0.300000 2.8300000 0.300000 2.8310000 0.300000
+ 2.8320000 0.300000 2.8330000 0.300000 2.8340000 0.300000 2.8350000 0.300000
+ 2.8360000 0.300000 2.8370000 0.300000 2.8380000 0.300000 2.8390000 0.300000
+ 2.8400000 0.300000 2.8410000 0.300000 2.8420000 0.300000 2.8430000 0.300000
+ 2.8440000 0.300000 2.8450000 0.300000 2.8460000 0.300000 2.8470000 0.300000
+ 2.8480000 0.300000 2.8490000 0.300000 2.8500000 0.300000 2.8510000 0.300000
+ 2.8520000 0.300000 2.8530000 0.300000 2.8540000 0.300000 2.8550000 0.300000
+ 2.8560000 0.300000 2.8570000 0.300000 2.8580000 0.300000 2.8590000 0.300000
+ 2.8600000 0.300000 2.8610000 0.300000 2.8620000 0.300000 2.8630000 0.300000
+ 2.8640000 0.300000 2.8650000 0.300000 2.8660000 0.300000 2.8670000 0.300000
+ 2.8680000 0.300000 2.8690000 0.300000 2.8700000 0.300000 2.8710000 0.300000
+ 2.8720000 0.300000 2.8730000 0.300000 2.8740000 0.300000 2.8750000 0.300000
+ 2.8760000 0.300000 2.8770000 0.300000 2.8780000 0.300000 2.8790000 0.300000
+ 2.8800000 0.300000 2.8810000 0.305000 2.8820000 0.310000 2.8830000 0.315000
+ 2.8840000 0.320000 2.8850000 0.325000 2.8860000 0.330000 2.8870000 0.335000
+ 2.8880000 0.340000 2.8890000 0.345000 2.8900000 0.350000 2.8910000 0.355000
+ 2.8920000 0.360000 2.8930000 0.365000 2.8940000 0.370000 2.8950000 0.375000
+ 2.8960000 0.380000 2.8970000 0.385000 2.8980000 0.390000 2.8990000 0.395000
+ 2.9000000 0.400000 2.9010000 0.395000 2.9020000 0.390000 2.9030000 0.385000
+ 2.9040000 0.380000 2.9050000 0.375000 2.9060000 0.370000 2.9070000 0.365000
+ 2.9080000 0.360000 2.9090000 0.355000 2.9100000 0.350000 2.9110000 0.345000
+ 2.9120000 0.340000 2.9130000 0.335000 2.9140000 0.330000 2.9150000 0.325000
+ 2.9160000 0.320000 2.9170000 0.315000 2.9180000 0.310000 2.9190000 0.305000
+ 2.9200000 0.300000 2.9210000 0.300000 2.9220000 0.300000 2.9230000 0.300000
+ 2.9240000 0.300000 2.9250000 0.300000 2.9260000 0.300000 2.9270000 0.300000
+ 2.9280000 0.300000 2.9290000 0.300000 2.9300000 0.300000 2.9310000 0.300000
+ 2.9320000 0.300000 2.9330000 0.300000 2.9340000 0.300000 2.9350000 0.300000
+ 2.9360000 0.300000 2.9370000 0.300000 2.9380000 0.300000 2.9390000 0.300000
+ 2.9400000 0.300000 2.9410000 0.300000 2.9420000 0.300000 2.9430000 0.300000
+ 2.9440000 0.300000 2.9450000 0.300000 2.9460000 0.300000 2.9470000 0.300000
+ 2.9480000 0.300000 2.9490000 0.300000 2.9500000 0.300000 2.9510000 0.300000
+ 2.9520000 0.300000 2.9530000 0.300000 2.9540000 0.300000 2.9550000 0.300000
+ 2.9560000 0.300000 2.9570000 0.300000 2.9580000 0.300000 2.9590000 0.300000
+ 2.9600000 0.300000 2.9610000 0.300000 2.9620000 0.300000 2.9630000 0.300000
+ 2.9640000 0.300000 2.9650000 0.300000 2.9660000 0.300000 2.9670000 0.300000
+ 2.9680000 0.300000 2.9690000 0.300000 2.9700000 0.300000 2.9710000 0.300000
+ 2.9720000 0.300000 2.9730000 0.300000 2.9740000 0.300000 2.9750000 0.300000
+ 2.9760000 0.300000 2.9770000 0.300000 2.9780000 0.300000 2.9790000 0.300000
+ 2.9800000 0.300000 2.9810000 0.300000 2.9820000 0.300000 2.9830000 0.300000
+ 2.9840000 0.300000 2.9850000 0.300000 2.9860000 0.300000 2.9870000 0.300000
+ 2.9880000 0.300000 2.9890000 0.300000 2.9900000 0.300000 2.9910000 0.300000
+ 2.9920000 0.300000 2.9930000 0.300000 2.9940000 0.300000 2.9950000 0.300000
+ 2.9960000 0.300000 2.9970000 0.300000 2.9980000 0.300000 2.9990000 0.300000
+ 3.0000000 0.300000 3.0010000 0.300000 3.0020000 0.300000 3.0030000 0.300000
+ 3.0040000 0.300000 3.0050000 0.300000 3.0060000 0.300000 3.0070000 0.300000
+ 3.0080000 0.300000 3.0090000 0.300000 3.0100000 0.300000 3.0110000 0.300000
+ 3.0120000 0.300000 3.0130000 0.300000 3.0140000 0.300000 3.0150000 0.300000
+ 3.0160000 0.300000 3.0170000 0.300000 3.0180000 0.300000 3.0190000 0.300000
+ 3.0200000 0.300000 3.0210000 0.300000 3.0220000 0.300000 3.0230000 0.300000
+ 3.0240000 0.300000 3.0250000 0.300000 3.0260000 0.300000 3.0270000 0.300000
+ 3.0280000 0.300000 3.0290000 0.300000 3.0300000 0.300000 3.0310000 0.300000
+ 3.0320000 0.300000 3.0330000 0.300000 3.0340000 0.300000 3.0350000 0.300000
+ 3.0360000 0.300000 3.0370000 0.300000 3.0380000 0.300000 3.0390000 0.300000
+ 3.0400000 0.300000 3.0410000 0.300000 3.0420000 0.300000 3.0430000 0.300000
+ 3.0440000 0.300000 3.0450000 0.300000 3.0460000 0.300000 3.0470000 0.300000
+ 3.0480000 0.300000 3.0490000 0.300000 3.0500000 0.300000 3.0510000 0.300000
+ 3.0520000 0.300000 3.0530000 0.300000 3.0540000 0.300000 3.0550000 0.300000
+ 3.0560000 0.300000 3.0570000 0.300000 3.0580000 0.300000 3.0590000 0.300000
+ 3.0600000 0.300000 3.0610000 0.300000 3.0620000 0.300000 3.0630000 0.300000
+ 3.0640000 0.300000 3.0650000 0.300000 3.0660000 0.300000 3.0670000 0.300000
+ 3.0680000 0.300000 3.0690000 0.300000 3.0700000 0.300000 3.0710000 0.300000
+ 3.0720000 0.300000 3.0730000 0.300000 3.0740000 0.300000 3.0750000 0.300000
+ 3.0760000 0.300000 3.0770000 0.300000 3.0780000 0.300000 3.0790000 0.300000
+ 3.0800000 0.300000 3.0810000 0.300000 3.0820000 0.300000 3.0830000 0.300000
+ 3.0840000 0.300000 3.0850000 0.300000 3.0860000 0.300000 3.0870000 0.300000
+ 3.0880000 0.300000 3.0890000 0.300000 3.0900000 0.300000 3.0910000 0.300000
+ 3.0920000 0.300000 3.0930000 0.300000 3.0940000 0.300000 3.0950000 0.300000
+ 3.0960000 0.300000 3.0970000 0.300000 3.0980000 0.300000 3.0990000 0.300000
+ 3.1000000 0.300000 3.1010000 0.300000 3.1020000 0.300000 3.1030000 0.300000
+ 3.1040000 0.300000 3.1050000 0.300000 3.1060000 0.300000 3.1070000 0.300000
+ 3.1080000 0.300000 3.1090000 0.300000 3.1100000 0.300000 3.1110000 0.300000
+ 3.1120000 0.300000 3.1130000 0.300000 3.1140000 0.300000 3.1150000 0.300000
+ 3.1160000 0.300000 3.1170000 0.300000 3.1180000 0.300000 3.1190000 0.300000
+ 3.1200000 0.300000 3.1210000 0.300000 3.1220000 0.300000 3.1230000 0.300000
+ 3.1240000 0.300000 3.1250000 0.300000 3.1260000 0.300000 3.1270000 0.300000
+ 3.1280000 0.300000 3.1290000 0.300000 3.1300000 0.300000 3.1310000 0.300000
+ 3.1320000 0.300000 3.1330000 0.300000 3.1340000 0.300000 3.1350000 0.300000
+ 3.1360000 0.300000 3.1370000 0.300000 3.1380000 0.300000 3.1390000 0.300000
+ 3.1400000 0.300000 3.1410000 0.300000 3.1420000 0.300000 3.1430000 0.300000
+ 3.1440000 0.300000 3.1450000 0.300000 3.1460000 0.300000 3.1470000 0.300000
+ 3.1480000 0.300000 3.1490000 0.300000 3.1500000 0.300000 3.1510000 0.300000
+ 3.1520000 0.300000 3.1530000 0.300000 3.1540000 0.300000 3.1550000 0.300000
+ 3.1560000 0.300000 3.1570000 0.300000 3.1580000 0.300000 3.1590000 0.300000
+ 3.1600000 0.300000 3.1610000 0.300000 3.1620000 0.300000 3.1630000 0.300000
+ 3.1640000 0.300000 3.1650000 0.300000 3.1660000 0.300000 3.1670000 0.300000
+ 3.1680000 0.300000 3.1690000 0.300000 3.1700000 0.300000 3.1710000 0.300000
+ 3.1720000 0.300000 3.1730000 0.300000 3.1740000 0.300000 3.1750000 0.300000
+ 3.1760000 0.300000 3.1770000 0.300000 3.1780000 0.300000 3.1790000 0.300000
+ 3.1800000 0.300000 3.1810000 0.300000 3.1820000 0.300000 3.1830000 0.300000
+ 3.1840000 0.300000 3.1850000 0.300000 3.1860000 0.300000 3.1870000 0.300000
+ 3.1880000 0.300000 3.1890000 0.300000 3.1900000 0.300000 3.1910000 0.300000
+ 3.1920000 0.300000 3.1930000 0.300000 3.1940000 0.300000 3.1950000 0.300000
+ 3.1960000 0.300000 3.1970000 0.300000 3.1980000 0.300000 3.1990000 0.300000
+ 3.2000000 0.300000 3.2010000 0.300000 3.2020000 0.300000 3.2030000 0.300000
+ 3.2040000 0.300000 3.2050000 0.300000 3.2060000 0.300000 3.2070000 0.300000
+ 3.2080000 0.300000 3.2090000 0.300000 3.2100000 0.300000 3.2110000 0.300000
+ 3.2120000 0.300000 3.2130000 0.300000 3.2140000 0.300000 3.2150000 0.300000
+ 3.2160000 0.300000 3.2170000 0.300000 3.2180000 0.300000 3.2190000 0.300000
+ 3.2200000 0.300000 3.2210000 0.300000 3.2220000 0.300000 3.2230000 0.300000
+ 3.2240000 0.300000 3.2250000 0.300000 3.2260000 0.300000 3.2270000 0.300000
+ 3.2280000 0.300000 3.2290000 0.300000 3.2300000 0.300000 3.2310000 0.300000
+ 3.2320000 0.300000 3.2330000 0.300000 3.2340000 0.300000 3.2350000 0.300000
+ 3.2360000 0.300000 3.2370000 0.300000 3.2380000 0.300000 3.2390000 0.300000
+ 3.2400000 0.300000 3.2410000 0.300000 3.2420000 0.300000 3.2430000 0.300000
+ 3.2440000 0.300000 3.2450000 0.300000 3.2460000 0.300000 3.2470000 0.300000
+ 3.2480000 0.300000 3.2490000 0.300000 3.2500000 0.300000 3.2510000 0.300000
+ 3.2520000 0.300000 3.2530000 0.300000 3.2540000 0.300000 3.2550000 0.300000
+ 3.2560000 0.300000 3.2570000 0.300000 3.2580000 0.300000 3.2590000 0.300000
+ 3.2600000 0.300000 3.2610000 0.300000 3.2620000 0.300000 3.2630000 0.300000
+ 3.2640000 0.300000 3.2650000 0.300000 3.2660000 0.300000 3.2670000 0.300000
+ 3.2680000 0.300000 3.2690000 0.300000 3.2700000 0.300000 3.2710000 0.300000
+ 3.2720000 0.300000 3.2730000 0.300000 3.2740000 0.300000 3.2750000 0.300000
+ 3.2760000 0.300000 3.2770000 0.300000 3.2780000 0.300000 3.2790000 0.300000
+ 3.2800000 0.300000 3.2810000 0.300000 3.2820000 0.300000 3.2830000 0.300000
+ 3.2840000 0.300000 3.2850000 0.300000 3.2860000 0.300000 3.2870000 0.300000
+ 3.2880000 0.300000 3.2890000 0.300000 3.2900000 0.300000 3.2910000 0.300000
+ 3.2920000 0.300000 3.2930000 0.300000 3.2940000 0.300000 3.2950000 0.300000
+ 3.2960000 0.300000 3.2970000 0.300000 3.2980000 0.300000 3.2990000 0.300000
+ 3.3000000 0.300000 3.3010000 0.300000 3.3020000 0.300000 3.3030000 0.300000
+ 3.3040000 0.300000 3.3050000 0.300000 3.3060000 0.300000 3.3070000 0.300000
+ 3.3080000 0.300000 3.3090000 0.300000 3.3100000 0.300000 3.3110000 0.300000
+ 3.3120000 0.300000 3.3130000 0.300000 3.3140000 0.300000 3.3150000 0.300000
+ 3.3160000 0.300000 3.3170000 0.300000 3.3180000 0.300000 3.3190000 0.300000
+ 3.3200000 0.300000 3.3210000 0.300000 3.3220000 0.300000 3.3230000 0.300000
+ 3.3240000 0.300000 3.3250000 0.300000 3.3260000 0.300000 3.3270000 0.300000
+ 3.3280000 0.300000 3.3290000 0.300000 3.3300000 0.300000 3.3310000 0.300000
+ 3.3320000 0.300000 3.3330000 0.300000 3.3340000 0.300000 3.3350000 0.300000
+ 3.3360000 0.300000 3.3370000 0.300000 3.3380000 0.300000 3.3390000 0.300000
+ 3.3400000 0.300000 3.3410000 0.300000 3.3420000 0.300000 3.3430000 0.300000
+ 3.3440000 0.300000 3.3450000 0.300000 3.3460000 0.300000 3.3470000 0.300000
+ 3.3480000 0.300000 3.3490000 0.300000 3.3500000 0.300000 3.3510000 0.300000
+ 3.3520000 0.300000 3.3530000 0.300000 3.3540000 0.300000 3.3550000 0.300000
+ 3.3560000 0.300000 3.3570000 0.300000 3.3580000 0.300000 3.3590000 0.300000
+ 3.3600000 0.300000 3.3610000 0.300000 3.3620000 0.300000 3.3630000 0.300000
+ 3.3640000 0.300000 3.3650000 0.300000 3.3660000 0.300000 3.3670000 0.300000
+ 3.3680000 0.300000 3.3690000 0.300000 3.3700000 0.300000 3.3710000 0.300000
+ 3.3720000 0.300000 3.3730000 0.300000 3.3740000 0.300000 3.3750000 0.300000
+ 3.3760000 0.300000 3.3770000 0.300000 3.3780000 0.300000 3.3790000 0.300000
+ 3.3800000 0.300000 3.3810000 0.300000 3.3820000 0.300000 3.3830000 0.300000
+ 3.3840000 0.300000 3.3850000 0.300000 3.3860000 0.300000 3.3870000 0.300000
+ 3.3880000 0.300000 3.3890000 0.300000 3.3900000 0.300000 3.3910000 0.300000
+ 3.3920000 0.300000 3.3930000 0.300000 3.3940000 0.300000 3.3950000 0.300000
+ 3.3960000 0.300000 3.3970000 0.300000 3.3980000 0.300000 3.3990000 0.300000
+ 3.4000000 0.300000 3.4010000 0.300000 3.4020000 0.300000 3.4030000 0.300000
+ 3.4040000 0.300000 3.4050000 0.300000 3.4060000 0.300000 3.4070000 0.300000
+ 3.4080000 0.300000 3.4090000 0.300000 3.4100000 0.300000 3.4110000 0.300000
+ 3.4120000 0.300000 3.4130000 0.300000 3.4140000 0.300000 3.4150000 0.300000
+ 3.4160000 0.300000 3.4170000 0.300000 3.4180000 0.300000 3.4190000 0.300000
+ 3.4200000 0.300000 3.4210000 0.300000 3.4220000 0.300000 3.4230000 0.300000
+ 3.4240000 0.300000 3.4250000 0.300000 3.4260000 0.300000 3.4270000 0.300000
+ 3.4280000 0.300000 3.4290000 0.300000 3.4300000 0.300000 3.4310000 0.300000
+ 3.4320000 0.300000 3.4330000 0.300000 3.4340000 0.300000 3.4350000 0.300000
+ 3.4360000 0.300000 3.4370000 0.300000 3.4380000 0.300000 3.4390000 0.300000
+ 3.4400000 0.300000 3.4410000 0.300000 3.4420000 0.300000 3.4430000 0.300000
+ 3.4440000 0.300000 3.4450000 0.300000 3.4460000 0.300000 3.4470000 0.300000
+ 3.4480000 0.300000 3.4490000 0.300000 3.4500000 0.300000 3.4510000 0.300000
+ 3.4520000 0.300000 3.4530000 0.300000 3.4540000 0.300000 3.4550000 0.300000
+ 3.4560000 0.300000 3.4570000 0.300000 3.4580000 0.300000 3.4590000 0.300000
+ 3.4600000 0.300000 3.4610000 0.300000 3.4620000 0.300000 3.4630000 0.300000
+ 3.4640000 0.300000 3.4650000 0.300000 3.4660000 0.300000 3.4670000 0.300000
+ 3.4680000 0.300000 3.4690000 0.300000 3.4700000 0.300000 3.4710000 0.300000
+ 3.4720000 0.300000 3.4730000 0.300000 3.4740000 0.300000 3.4750000 0.300000
+ 3.4760000 0.300000 3.4770000 0.300000 3.4780000 0.300000 3.4790000 0.300000
+ 3.4800000 0.300000 3.4810000 0.300000 3.4820000 0.300000 3.4830000 0.300000
+ 3.4840000 0.300000 3.4850000 0.300000 3.4860000 0.300000 3.4870000 0.300000
+ 3.4880000 0.300000 3.4890000 0.300000 3.4900000 0.300000 3.4910000 0.300000
+ 3.4920000 0.300000 3.4930000 0.300000 3.4940000 0.300000 3.4950000 0.300000
+ 3.4960000 0.300000 3.4970000 0.300000 3.4980000 0.300000 3.4990000 0.300000
+ 3.5000000 0.300000 3.5010000 0.300000 3.5020000 0.300000 3.5030000 0.300000
+ 3.5040000 0.300000 3.5050000 0.300000 3.5060000 0.300000 3.5070000 0.300000
+ 3.5080000 0.300000 3.5090000 0.300000 3.5100000 0.300000 3.5110000 0.300000
+ 3.5120000 0.300000 3.5130000 0.300000 3.5140000 0.300000 3.5150000 0.300000
+ 3.5160000 0.300000 3.5170000 0.300000 3.5180000 0.300000 3.5190000 0.300000
+ 3.5200000 0.300000 3.5210000 0.300000 3.5220000 0.300000 3.5230000 0.300000
+ 3.5240000 0.300000 3.5250000 0.300000 3.5260000 0.300000 3.5270000 0.300000
+ 3.5280000 0.300000 3.5290000 0.300000 3.5300000 0.300000 3.5310000 0.300000
+ 3.5320000 0.300000 3.5330000 0.300000 3.5340000 0.300000 3.5350000 0.300000
+ 3.5360000 0.300000 3.5370000 0.300000 3.5380000 0.300000 3.5390000 0.300000
+ 3.5400000 0.300000 3.5410000 0.300000 3.5420000 0.300000 3.5430000 0.300000
+ 3.5440000 0.300000 3.5450000 0.300000 3.5460000 0.300000 3.5470000 0.300000
+ 3.5480000 0.300000 3.5490000 0.300000 3.5500000 0.300000 3.5510000 0.300000
+ 3.5520000 0.300000 3.5530000 0.300000 3.5540000 0.300000 3.5550000 0.300000
+ 3.5560000 0.300000 3.5570000 0.300000 3.5580000 0.300000 3.5590000 0.300000
+ 3.5600000 0.300000 3.5610000 0.300000 3.5620000 0.300000 3.5630000 0.300000
+ 3.5640000 0.300000 3.5650000 0.300000 3.5660000 0.300000 3.5670000 0.300000
+ 3.5680000 0.300000 3.5690000 0.300000 3.5700000 0.300000 3.5710000 0.300000
+ 3.5720000 0.300000 3.5730000 0.300000 3.5740000 0.300000 3.5750000 0.300000
+ 3.5760000 0.300000 3.5770000 0.300000 3.5780000 0.300000 3.5790000 0.300000
+ 3.5800000 0.300000 3.5810000 0.300000 3.5820000 0.300000 3.5830000 0.300000
+ 3.5840000 0.300000 3.5850000 0.300000 3.5860000 0.300000 3.5870000 0.300000
+ 3.5880000 0.300000 3.5890000 0.300000 3.5900000 0.300000 3.5910000 0.300000
+ 3.5920000 0.300000 3.5930000 0.300000 3.5940000 0.300000 3.5950000 0.300000
+ 3.5960000 0.300000 3.5970000 0.300000 3.5980000 0.300000 3.5990000 0.300000
+ 3.6000000 0.300000 3.6010000 0.300000 3.6020000 0.300000 3.6030000 0.300000
+ 3.6040000 0.300000 3.6050000 0.300000 3.6060000 0.300000 3.6070000 0.300000
+ 3.6080000 0.300000 3.6090000 0.300000 3.6100000 0.300000 3.6110000 0.300000
+ 3.6120000 0.300000 3.6130000 0.300000 3.6140000 0.300000 3.6150000 0.300000
+ 3.6160000 0.300000 3.6170000 0.300000 3.6180000 0.300000 3.6190000 0.300000
+ 3.6200000 0.300000 3.6210000 0.300000 3.6220000 0.300000 3.6230000 0.300000
+ 3.6240000 0.300000 3.6250000 0.300000 3.6260000 0.300000 3.6270000 0.300000
+ 3.6280000 0.300000 3.6290000 0.300000 3.6300000 0.300000 3.6310000 0.300000
+ 3.6320000 0.300000 3.6330000 0.300000 3.6340000 0.300000 3.6350000 0.300000
+ 3.6360000 0.300000 3.6370000 0.300000 3.6380000 0.300000 3.6390000 0.300000
+ 3.6400000 0.300000 3.6410000 0.300000 3.6420000 0.300000 3.6430000 0.300000
+ 3.6440000 0.300000 3.6450000 0.300000 3.6460000 0.300000 3.6470000 0.300000
+ 3.6480000 0.300000 3.6490000 0.300000 3.6500000 0.300000 3.6510000 0.300000
+ 3.6520000 0.300000 3.6530000 0.300000 3.6540000 0.300000 3.6550000 0.300000
+ 3.6560000 0.300000 3.6570000 0.300000 3.6580000 0.300000 3.6590000 0.300000
+ 3.6600000 0.300000 3.6610000 0.300000 3.6620000 0.300000 3.6630000 0.300000
+ 3.6640000 0.300000 3.6650000 0.300000 3.6660000 0.300000 3.6670000 0.300000
+ 3.6680000 0.300000 3.6690000 0.300000 3.6700000 0.300000 3.6710000 0.300000
+ 3.6720000 0.300000 3.6730000 0.300000 3.6740000 0.300000 3.6750000 0.300000
+ 3.6760000 0.300000 3.6770000 0.300000 3.6780000 0.300000 3.6790000 0.300000
+ 3.6800000 0.300000 3.6810000 0.305000 3.6820000 0.310000 3.6830000 0.315000
+ 3.6840000 0.320000 3.6850000 0.325000 3.6860000 0.330000 3.6870000 0.335000
+ 3.6880000 0.340000 3.6890000 0.345000 3.6900000 0.350000 3.6910000 0.355000
+ 3.6920000 0.360000 3.6930000 0.365000 3.6940000 0.370000 3.6950000 0.375000
+ 3.6960000 0.380000 3.6970000 0.385000 3.6980000 0.390000 3.6990000 0.395000
+ 3.7000000 0.400000 3.7010000 0.395000 3.7020000 0.390000 3.7030000 0.385000
+ 3.7040000 0.380000 3.7050000 0.375000 3.7060000 0.370000 3.7070000 0.365000
+ 3.7080000 0.360000 3.7090000 0.355000 3.7100000 0.350000 3.7110000 0.345000
+ 3.7120000 0.340000 3.7130000 0.335000 3.7140000 0.330000 3.7150000 0.325000
+ 3.7160000 0.320000 3.7170000 0.315000 3.7180000 0.310000 3.7190000 0.305000
+ 3.7200000 0.300000 3.7210000 0.300000 3.7220000 0.300000 3.7230000 0.300000
+ 3.7240000 0.300000 3.7250000 0.300000 3.7260000 0.300000 3.7270000 0.300000
+ 3.7280000 0.300000 3.7290000 0.300000 3.7300000 0.300000 3.7310000 0.300000
+ 3.7320000 0.300000 3.7330000 0.300000 3.7340000 0.300000 3.7350000 0.300000
+ 3.7360000 0.300000 3.7370000 0.300000 3.7380000 0.300000 3.7390000 0.300000
+ 3.7400000 0.300000 3.7410000 0.300000 3.7420000 0.300000 3.7430000 0.300000
+ 3.7440000 0.300000 3.7450000 0.300000 3.7460000 0.300000 3.7470000 0.300000
+ 3.7480000 0.300000 3.7490000 0.300000 3.7500000 0.300000 3.7510000 0.300000
+ 3.7520000 0.300000 3.7530000 0.300000 3.7540000 0.300000 3.7550000 0.300000
+ 3.7560000 0.300000 3.7570000 0.300000 3.7580000 0.300000 3.7590000 0.300000
+ 3.7600000 0.300000 3.7610000 0.300000 3.7620000 0.300000 3.7630000 0.300000
+ 3.7640000 0.300000 3.7650000 0.300000 3.7660000 0.300000 3.7670000 0.300000
+ 3.7680000 0.300000 3.7690000 0.300000 3.7700000 0.300000 3.7710000 0.300000
+ 3.7720000 0.300000 3.7730000 0.300000 3.7740000 0.300000 3.7750000 0.300000
+ 3.7760000 0.300000 3.7770000 0.300000 3.7780000 0.300000 3.7790000 0.300000
+ 3.7800000 0.300000 3.7810000 0.300000 3.7820000 0.300000 3.7830000 0.300000
+ 3.7840000 0.300000 3.7850000 0.300000 3.7860000 0.300000 3.7870000 0.300000
+ 3.7880000 0.300000 3.7890000 0.300000 3.7900000 0.300000 3.7910000 0.300000
+ 3.7920000 0.300000 3.7930000 0.300000 3.7940000 0.300000 3.7950000 0.300000
+ 3.7960000 0.300000 3.7970000 0.300000 3.7980000 0.300000 3.7990000 0.300000
+ 3.8000000 0.300000 3.8010000 0.300000 3.8020000 0.300000 3.8030000 0.300000
+ 3.8040000 0.300000 3.8050000 0.300000 3.8060000 0.300000 3.8070000 0.300000
+ 3.8080000 0.300000 3.8090000 0.300000 3.8100000 0.300000 3.8110000 0.300000
+ 3.8120000 0.300000 3.8130000 0.300000 3.8140000 0.300000 3.8150000 0.300000
+ 3.8160000 0.300000 3.8170000 0.300000 3.8180000 0.300000 3.8190000 0.300000
+ 3.8200000 0.300000 3.8210000 0.300000 3.8220000 0.300000 3.8230000 0.300000
+ 3.8240000 0.300000 3.8250000 0.300000 3.8260000 0.300000 3.8270000 0.300000
+ 3.8280000 0.300000 3.8290000 0.300000 3.8300000 0.300000 3.8310000 0.300000
+ 3.8320000 0.300000 3.8330000 0.300000 3.8340000 0.300000 3.8350000 0.300000
+ 3.8360000 0.300000 3.8370000 0.300000 3.8380000 0.300000 3.8390000 0.300000
+ 3.8400000 0.300000 3.8410000 0.300000 3.8420000 0.300000 3.8430000 0.300000
+ 3.8440000 0.300000 3.8450000 0.300000 3.8460000 0.300000 3.8470000 0.300000
+ 3.8480000 0.300000 3.8490000 0.300000 3.8500000 0.300000 3.8510000 0.300000
+ 3.8520000 0.300000 3.8530000 0.300000 3.8540000 0.300000 3.8550000 0.300000
+ 3.8560000 0.300000 3.8570000 0.300000 3.8580000 0.300000 3.8590000 0.300000
+ 3.8600000 0.300000 3.8610000 0.300000 3.8620000 0.300000 3.8630000 0.300000
+ 3.8640000 0.300000 3.8650000 0.300000 3.8660000 0.300000 3.8670000 0.300000
+ 3.8680000 0.300000 3.8690000 0.300000 3.8700000 0.300000 3.8710000 0.300000
+ 3.8720000 0.300000 3.8730000 0.300000 3.8740000 0.300000 3.8750000 0.300000
+ 3.8760000 0.300000 3.8770000 0.300000 3.8780000 0.300000 3.8790000 0.300000
+ 3.8800000 0.300000 3.8810000 0.300000 3.8820000 0.300000 3.8830000 0.300000
+ 3.8840000 0.300000 3.8850000 0.300000 3.8860000 0.300000 3.8870000 0.300000
+ 3.8880000 0.300000 3.8890000 0.300000 3.8900000 0.300000 3.8910000 0.300000
+ 3.8920000 0.300000 3.8930000 0.300000 3.8940000 0.300000 3.8950000 0.300000
+ 3.8960000 0.300000 3.8970000 0.300000 3.8980000 0.300000 3.8990000 0.300000
+ 3.9000000 0.300000 3.9010000 0.300000 3.9020000 0.300000 3.9030000 0.300000
+ 3.9040000 0.300000 3.9050000 0.300000 3.9060000 0.300000 3.9070000 0.300000
+ 3.9080000 0.300000 3.9090000 0.300000 3.9100000 0.300000 3.9110000 0.300000
+ 3.9120000 0.300000 3.9130000 0.300000 3.9140000 0.300000 3.9150000 0.300000
+ 3.9160000 0.300000 3.9170000 0.300000 3.9180000 0.300000 3.9190000 0.300000
+ 3.9200000 0.300000 3.9210000 0.300000 3.9220000 0.300000 3.9230000 0.300000
+ 3.9240000 0.300000 3.9250000 0.300000 3.9260000 0.300000 3.9270000 0.300000
+ 3.9280000 0.300000 3.9290000 0.300000 3.9300000 0.300000 3.9310000 0.300000
+ 3.9320000 0.300000 3.9330000 0.300000 3.9340000 0.300000 3.9350000 0.300000
+ 3.9360000 0.300000 3.9370000 0.300000 3.9380000 0.300000 3.9390000 0.300000
+ 3.9400000 0.300000 3.9410000 0.300000 3.9420000 0.300000 3.9430000 0.300000
+ 3.9440000 0.300000 3.9450000 0.300000 3.9460000 0.300000 3.9470000 0.300000
+ 3.9480000 0.300000 3.9490000 0.300000 3.9500000 0.300000 3.9510000 0.300000
+ 3.9520000 0.300000 3.9530000 0.300000 3.9540000 0.300000 3.9550000 0.300000
+ 3.9560000 0.300000 3.9570000 0.300000 3.9580000 0.300000 3.9590000 0.300000
+ 3.9600000 0.300000 3.9610000 0.300000 3.9620000 0.300000 3.9630000 0.300000
+ 3.9640000 0.300000 3.9650000 0.300000 3.9660000 0.300000 3.9670000 0.300000
+ 3.9680000 0.300000 3.9690000 0.300000 3.9700000 0.300000 3.9710000 0.300000
+ 3.9720000 0.300000 3.9730000 0.300000 3.9740000 0.300000 3.9750000 0.300000
+ 3.9760000 0.300000 3.9770000 0.300000 3.9780000 0.300000 3.9790000 0.300000
+ 3.9800000 0.300000 3.9810000 0.300000 3.9820000 0.300000 3.9830000 0.300000
+ 3.9840000 0.300000 3.9850000 0.300000 3.9860000 0.300000 3.9870000 0.300000
+ 3.9880000 0.300000 3.9890000 0.300000 3.9900000 0.300000 3.9910000 0.300000
+ 3.9920000 0.300000 3.9930000 0.300000 3.9940000 0.300000 3.9950000 0.300000
+ 3.9960000 0.300000 3.9970000 0.300000 3.9980000 0.300000 3.9990000 0.300000
+ 4.0000000 0.300000 4.0010000 0.300000 4.0020000 0.300000 4.0030000 0.300000
+ 4.0040000 0.300000 4.0050000 0.300000 4.0060000 0.300000 4.0070000 0.300000
+ 4.0080000 0.300000 4.0090000 0.300000 4.0100000 0.300000 4.0110000 0.300000
+ 4.0120000 0.300000 4.0130000 0.300000 4.0140000 0.300000 4.0150000 0.300000
+ 4.0160000 0.300000 4.0170000 0.300000 4.0180000 0.300000 4.0190000 0.300000
+ 4.0200000 0.300000 4.0210000 0.300000 4.0220000 0.300000 4.0230000 0.300000
+ 4.0240000 0.300000 4.0250000 0.300000 4.0260000 0.300000 4.0270000 0.300000
+ 4.0280000 0.300000 4.0290000 0.300000 4.0300000 0.300000 4.0310000 0.300000
+ 4.0320000 0.300000 4.0330000 0.300000 4.0340000 0.300000 4.0350000 0.300000
+ 4.0360000 0.300000 4.0370000 0.300000 4.0380000 0.300000 4.0390000 0.300000
+ 4.0400000 0.300000 4.0410000 0.300000 4.0420000 0.300000 4.0430000 0.300000
+ 4.0440000 0.300000 4.0450000 0.300000 4.0460000 0.300000 4.0470000 0.300000
+ 4.0480000 0.300000 4.0490000 0.300000 4.0500000 0.300000 4.0510000 0.300000
+ 4.0520000 0.300000 4.0530000 0.300000 4.0540000 0.300000 4.0550000 0.300000
+ 4.0560000 0.300000 4.0570000 0.300000 4.0580000 0.300000 4.0590000 0.300000
+ 4.0600000 0.300000 4.0610000 0.300000 4.0620000 0.300000 4.0630000 0.300000
+ 4.0640000 0.300000 4.0650000 0.300000 4.0660000 0.300000 4.0670000 0.300000
+ 4.0680000 0.300000 4.0690000 0.300000 4.0700000 0.300000 4.0710000 0.300000
+ 4.0720000 0.300000 4.0730000 0.300000 4.0740000 0.300000 4.0750000 0.300000
+ 4.0760000 0.300000 4.0770000 0.300000 4.0780000 0.300000 4.0790000 0.300000
+ 4.0800000 0.300000 4.0810000 0.300000 4.0820000 0.300000 4.0830000 0.300000
+ 4.0840000 0.300000 4.0850000 0.300000 4.0860000 0.300000 4.0870000 0.300000
+ 4.0880000 0.300000 4.0890000 0.300000 4.0900000 0.300000 4.0910000 0.300000
+ 4.0920000 0.300000 4.0930000 0.300000 4.0940000 0.300000 4.0950000 0.300000
+ 4.0960000 0.300000 4.0970000 0.300000 4.0980000 0.300000 4.0990000 0.300000
+ 4.1000000 0.300000 4.1010000 0.300000 4.1020000 0.300000 4.1030000 0.300000
+ 4.1040000 0.300000 4.1050000 0.300000 4.1060000 0.300000 4.1070000 0.300000
+ 4.1080000 0.300000 4.1090000 0.300000 4.1100000 0.300000 4.1110000 0.300000
+ 4.1120000 0.300000 4.1130000 0.300000 4.1140000 0.300000 4.1150000 0.300000
+ 4.1160000 0.300000 4.1170000 0.300000 4.1180000 0.300000 4.1190000 0.300000
+ 4.1200000 0.300000 4.1210000 0.300000 4.1220000 0.300000 4.1230000 0.300000
+ 4.1240000 0.300000 4.1250000 0.300000 4.1260000 0.300000 4.1270000 0.300000
+ 4.1280000 0.300000 4.1290000 0.300000 4.1300000 0.300000 4.1310000 0.300000
+ 4.1320000 0.300000 4.1330000 0.300000 4.1340000 0.300000 4.1350000 0.300000
+ 4.1360000 0.300000 4.1370000 0.300000 4.1380000 0.300000 4.1390000 0.300000
+ 4.1400000 0.300000 4.1410000 0.300000 4.1420000 0.300000 4.1430000 0.300000
+ 4.1440000 0.300000 4.1450000 0.300000 4.1460000 0.300000 4.1470000 0.300000
+ 4.1480000 0.300000 4.1490000 0.300000 4.1500000 0.300000 4.1510000 0.300000
+ 4.1520000 0.300000 4.1530000 0.300000 4.1540000 0.300000 4.1550000 0.300000
+ 4.1560000 0.300000 4.1570000 0.300000 4.1580000 0.300000 4.1590000 0.300000
+ 4.1600000 0.300000 4.1610000 0.300000 4.1620000 0.300000 4.1630000 0.300000
+ 4.1640000 0.300000 4.1650000 0.300000 4.1660000 0.300000 4.1670000 0.300000
+ 4.1680000 0.300000 4.1690000 0.300000 4.1700000 0.300000 4.1710000 0.300000
+ 4.1720000 0.300000 4.1730000 0.300000 4.1740000 0.300000 4.1750000 0.300000
+ 4.1760000 0.300000 4.1770000 0.300000 4.1780000 0.300000 4.1790000 0.300000
+ 4.1800000 0.300000 4.1810000 0.300000 4.1820000 0.300000 4.1830000 0.300000
+ 4.1840000 0.300000 4.1850000 0.300000 4.1860000 0.300000 4.1870000 0.300000
+ 4.1880000 0.300000 4.1890000 0.300000 4.1900000 0.300000 4.1910000 0.300000
+ 4.1920000 0.300000 4.1930000 0.300000 4.1940000 0.300000 4.1950000 0.300000
+ 4.1960000 0.300000 4.1970000 0.300000 4.1980000 0.300000 4.1990000 0.300000
+ 4.2000000 0.300000 4.2010000 0.300000 4.2020000 0.300000 4.2030000 0.300000
+ 4.2040000 0.300000 4.2050000 0.300000 4.2060000 0.300000 4.2070000 0.300000
+ 4.2080000 0.300000 4.2090000 0.300000 4.2100000 0.300000 4.2110000 0.300000
+ 4.2120000 0.300000 4.2130000 0.300000 4.2140000 0.300000 4.2150000 0.300000
+ 4.2160000 0.300000 4.2170000 0.300000 4.2180000 0.300000 4.2190000 0.300000
+ 4.2200000 0.300000 4.2210000 0.300000 4.2220000 0.300000 4.2230000 0.300000
+ 4.2240000 0.300000 4.2250000 0.300000 4.2260000 0.300000 4.2270000 0.300000
+ 4.2280000 0.300000 4.2290000 0.300000 4.2300000 0.300000 4.2310000 0.300000
+ 4.2320000 0.300000 4.2330000 0.300000 4.2340000 0.300000 4.2350000 0.300000
+ 4.2360000 0.300000 4.2370000 0.300000 4.2380000 0.300000 4.2390000 0.300000
+ 4.2400000 0.300000 4.2410000 0.300000 4.2420000 0.300000 4.2430000 0.300000
+ 4.2440000 0.300000 4.2450000 0.300000 4.2460000 0.300000 4.2470000 0.300000
+ 4.2480000 0.300000 4.2490000 0.300000 4.2500000 0.300000 4.2510000 0.300000
+ 4.2520000 0.300000 4.2530000 0.300000 4.2540000 0.300000 4.2550000 0.300000
+ 4.2560000 0.300000 4.2570000 0.300000 4.2580000 0.300000 4.2590000 0.300000
+ 4.2600000 0.300000 4.2610000 0.300000 4.2620000 0.300000 4.2630000 0.300000
+ 4.2640000 0.300000 4.2650000 0.300000 4.2660000 0.300000 4.2670000 0.300000
+ 4.2680000 0.300000 4.2690000 0.300000 4.2700000 0.300000 4.2710000 0.300000
+ 4.2720000 0.300000 4.2730000 0.300000 4.2740000 0.300000 4.2750000 0.300000
+ 4.2760000 0.300000 4.2770000 0.300000 4.2780000 0.300000 4.2790000 0.300000
+ 4.2800000 0.300000 4.2810000 0.300000 4.2820000 0.300000 4.2830000 0.300000
+ 4.2840000 0.300000 4.2850000 0.300000 4.2860000 0.300000 4.2870000 0.300000
+ 4.2880000 0.300000 4.2890000 0.300000 4.2900000 0.300000 4.2910000 0.300000
+ 4.2920000 0.300000 4.2930000 0.300000 4.2940000 0.300000 4.2950000 0.300000
+ 4.2960000 0.300000 4.2970000 0.300000 4.2980000 0.300000 4.2990000 0.300000
+ 4.3000000 0.300000 4.3010000 0.300000 4.3020000 0.300000 4.3030000 0.300000
+ 4.3040000 0.300000 4.3050000 0.300000 4.3060000 0.300000 4.3070000 0.300000
+ 4.3080000 0.300000 4.3090000 0.300000 4.3100000 0.300000 4.3110000 0.300000
+ 4.3120000 0.300000 4.3130000 0.300000 4.3140000 0.300000 4.3150000 0.300000
+ 4.3160000 0.300000 4.3170000 0.300000 4.3180000 0.300000 4.3190000 0.300000
+ 4.3200000 0.300000 4.3210000 0.300000 4.3220000 0.300000 4.3230000 0.300000
+ 4.3240000 0.300000 4.3250000 0.300000 4.3260000 0.300000 4.3270000 0.300000
+ 4.3280000 0.300000 4.3290000 0.300000 4.3300000 0.300000 4.3310000 0.300000
+ 4.3320000 0.300000 4.3330000 0.300000 4.3340000 0.300000 4.3350000 0.300000
+ 4.3360000 0.300000 4.3370000 0.300000 4.3380000 0.300000 4.3390000 0.300000
+ 4.3400000 0.300000 4.3410000 0.300000 4.3420000 0.300000 4.3430000 0.300000
+ 4.3440000 0.300000 4.3450000 0.300000 4.3460000 0.300000 4.3470000 0.300000
+ 4.3480000 0.300000 4.3490000 0.300000 4.3500000 0.300000 4.3510000 0.300000
+ 4.3520000 0.300000 4.3530000 0.300000 4.3540000 0.300000 4.3550000 0.300000
+ 4.3560000 0.300000 4.3570000 0.300000 4.3580000 0.300000 4.3590000 0.300000
+ 4.3600000 0.300000 4.3610000 0.300000 4.3620000 0.300000 4.3630000 0.300000
+ 4.3640000 0.300000 4.3650000 0.300000 4.3660000 0.300000 4.3670000 0.300000
+ 4.3680000 0.300000 4.3690000 0.300000 4.3700000 0.300000 4.3710000 0.300000
+ 4.3720000 0.300000 4.3730000 0.300000 4.3740000 0.300000 4.3750000 0.300000
+ 4.3760000 0.300000 4.3770000 0.300000 4.3780000 0.300000 4.3790000 0.300000
+ 4.3800000 0.300000 4.3810000 0.300000 4.3820000 0.300000 4.3830000 0.300000
+ 4.3840000 0.300000 4.3850000 0.300000 4.3860000 0.300000 4.3870000 0.300000
+ 4.3880000 0.300000 4.3890000 0.300000 4.3900000 0.300000 4.3910000 0.300000
+ 4.3920000 0.300000 4.3930000 0.300000 4.3940000 0.300000 4.3950000 0.300000
+ 4.3960000 0.300000 4.3970000 0.300000 4.3980000 0.300000 4.3990000 0.300000
+ 4.4000000 0.300000 4.4010000 0.300000 4.4020000 0.300000 4.4030000 0.300000
+ 4.4040000 0.300000 4.4050000 0.300000 4.4060000 0.300000 4.4070000 0.300000
+ 4.4080000 0.300000 4.4090000 0.300000 4.4100000 0.300000 4.4110000 0.300000
+ 4.4120000 0.300000 4.4130000 0.300000 4.4140000 0.300000 4.4150000 0.300000
+ 4.4160000 0.300000 4.4170000 0.300000 4.4180000 0.300000 4.4190000 0.300000
+ 4.4200000 0.300000 4.4210000 0.300000 4.4220000 0.300000 4.4230000 0.300000
+ 4.4240000 0.300000 4.4250000 0.300000 4.4260000 0.300000 4.4270000 0.300000
+ 4.4280000 0.300000 4.4290000 0.300000 4.4300000 0.300000 4.4310000 0.300000
+ 4.4320000 0.300000 4.4330000 0.300000 4.4340000 0.300000 4.4350000 0.300000
+ 4.4360000 0.300000 4.4370000 0.300000 4.4380000 0.300000 4.4390000 0.300000
+ 4.4400000 0.300000 4.4410000 0.300000 4.4420000 0.300000 4.4430000 0.300000
+ 4.4440000 0.300000 4.4450000 0.300000 4.4460000 0.300000 4.4470000 0.300000
+ 4.4480000 0.300000 4.4490000 0.300000 4.4500000 0.300000 4.4510000 0.300000
+ 4.4520000 0.300000 4.4530000 0.300000 4.4540000 0.300000 4.4550000 0.300000
+ 4.4560000 0.300000 4.4570000 0.300000 4.4580000 0.300000 4.4590000 0.300000
+ 4.4600000 0.300000 4.4610000 0.300000 4.4620000 0.300000 4.4630000 0.300000
+ 4.4640000 0.300000 4.4650000 0.300000 4.4660000 0.300000 4.4670000 0.300000
+ 4.4680000 0.300000 4.4690000 0.300000 4.4700000 0.300000 4.4710000 0.300000
+ 4.4720000 0.300000 4.4730000 0.300000 4.4740000 0.300000 4.4750000 0.300000
+ 4.4760000 0.300000 4.4770000 0.300000 4.4780000 0.300000 4.4790000 0.300000
+ 4.4800000 0.300000 4.4810000 0.300000 4.4820000 0.300000 4.4830000 0.300000
+ 4.4840000 0.300000 4.4850000 0.300000 4.4860000 0.300000 4.4870000 0.300000
+ 4.4880000 0.300000 4.4890000 0.300000 4.4900000 0.300000 4.4910000 0.300000
+ 4.4920000 0.300000 4.4930000 0.300000 4.4940000 0.300000 4.4950000 0.300000
+ 4.4960000 0.300000 4.4970000 0.300000 4.4980000 0.300000 4.4990000 0.300000
+ 4.5000000 0.300000 4.5010000 0.300000 4.5020000 0.300000 4.5030000 0.300000
+ 4.5040000 0.300000 4.5050000 0.300000 4.5060000 0.300000 4.5070000 0.300000
+ 4.5080000 0.300000 4.5090000 0.300000 4.5100000 0.300000 4.5110000 0.300000
+ 4.5120000 0.300000 4.5130000 0.300000 4.5140000 0.300000 4.5150000 0.300000
+ 4.5160000 0.300000 4.5170000 0.300000 4.5180000 0.300000 4.5190000 0.300000
+ 4.5200000 0.300000 4.5210000 0.300000 4.5220000 0.300000 4.5230000 0.300000
+ 4.5240000 0.300000 4.5250000 0.300000 4.5260000 0.300000 4.5270000 0.300000
+ 4.5280000 0.300000 4.5290000 0.300000 4.5300000 0.300000 4.5310000 0.300000
+ 4.5320000 0.300000 4.5330000 0.300000 4.5340000 0.300000 4.5350000 0.300000
+ 4.5360000 0.300000 4.5370000 0.300000 4.5380000 0.300000 4.5390000 0.300000
+ 4.5400000 0.300000 4.5410000 0.300000 4.5420000 0.300000 4.5430000 0.300000
+ 4.5440000 0.300000 4.5450000 0.300000 4.5460000 0.300000 4.5470000 0.300000
+ 4.5480000 0.300000 4.5490000 0.300000 4.5500000 0.300000 4.5510000 0.300000
+ 4.5520000 0.300000 4.5530000 0.300000 4.5540000 0.300000 4.5550000 0.300000
+ 4.5560000 0.300000 4.5570000 0.300000 4.5580000 0.300000 4.5590000 0.300000
+ 4.5600000 0.300000 4.5610000 0.300000 4.5620000 0.300000 4.5630000 0.300000
+ 4.5640000 0.300000 4.5650000 0.300000 4.5660000 0.300000 4.5670000 0.300000
+ 4.5680000 0.300000 4.5690000 0.300000 4.5700000 0.300000 4.5710000 0.300000
+ 4.5720000 0.300000 4.5730000 0.300000 4.5740000 0.300000 4.5750000 0.300000
+ 4.5760000 0.300000 4.5770000 0.300000 4.5780000 0.300000 4.5790000 0.300000
+ 4.5800000 0.300000 4.5810000 0.300000 4.5820000 0.300000 4.5830000 0.300000
+ 4.5840000 0.300000 4.5850000 0.300000 4.5860000 0.300000 4.5870000 0.300000
+ 4.5880000 0.300000 4.5890000 0.300000 4.5900000 0.300000 4.5910000 0.300000
+ 4.5920000 0.300000 4.5930000 0.300000 4.5940000 0.300000 4.5950000 0.300000
+ 4.5960000 0.300000 4.5970000 0.300000 4.5980000 0.300000 4.5990000 0.300000
+ 4.6000000 0.300000 4.6010000 0.300000 4.6020000 0.300000 4.6030000 0.300000
+ 4.6040000 0.300000 4.6050000 0.300000 4.6060000 0.300000 4.6070000 0.300000
+ 4.6080000 0.300000 4.6090000 0.300000 4.6100000 0.300000 4.6110000 0.300000
+ 4.6120000 0.300000 4.6130000 0.300000 4.6140000 0.300000 4.6150000 0.300000
+ 4.6160000 0.300000 4.6170000 0.300000 4.6180000 0.300000 4.6190000 0.300000
+ 4.6200000 0.300000 4.6210000 0.300000 4.6220000 0.300000 4.6230000 0.300000
+ 4.6240000 0.300000 4.6250000 0.300000 4.6260000 0.300000 4.6270000 0.300000
+ 4.6280000 0.300000 4.6290000 0.300000 4.6300000 0.300000 4.6310000 0.300000
+ 4.6320000 0.300000 4.6330000 0.300000 4.6340000 0.300000 4.6350000 0.300000
+ 4.6360000 0.300000 4.6370000 0.300000 4.6380000 0.300000 4.6390000 0.300000
+ 4.6400000 0.300000 4.6410000 0.300000 4.6420000 0.300000 4.6430000 0.300000
+ 4.6440000 0.300000 4.6450000 0.300000 4.6460000 0.300000 4.6470000 0.300000
+ 4.6480000 0.300000 4.6490000 0.300000 4.6500000 0.300000 4.6510000 0.300000
+ 4.6520000 0.300000 4.6530000 0.300000 4.6540000 0.300000 4.6550000 0.300000
+ 4.6560000 0.300000 4.6570000 0.300000 4.6580000 0.300000 4.6590000 0.300000
+ 4.6600000 0.300000 4.6610000 0.300000 4.6620000 0.300000 4.6630000 0.300000
+ 4.6640000 0.300000 4.6650000 0.300000 4.6660000 0.300000 4.6670000 0.300000
+ 4.6680000 0.300000 4.6690000 0.300000 4.6700000 0.300000 4.6710000 0.300000
+ 4.6720000 0.300000 4.6730000 0.300000 4.6740000 0.300000 4.6750000 0.300000
+ 4.6760000 0.300000 4.6770000 0.300000 4.6780000 0.300000 4.6790000 0.300000
+ 4.6800000 0.300000 4.6810000 0.300000 4.6820000 0.300000 4.6830000 0.300000
+ 4.6840000 0.300000 4.6850000 0.300000 4.6860000 0.300000 4.6870000 0.300000
+ 4.6880000 0.300000 4.6890000 0.300000 4.6900000 0.300000 4.6910000 0.300000
+ 4.6920000 0.300000 4.6930000 0.300000 4.6940000 0.300000 4.6950000 0.300000
+ 4.6960000 0.300000 4.6970000 0.300000 4.6980000 0.300000 4.6990000 0.300000
+ 4.7000000 0.300000 4.7010000 0.300000 4.7020000 0.300000 4.7030000 0.300000
+ 4.7040000 0.300000 4.7050000 0.300000 4.7060000 0.300000 4.7070000 0.300000
+ 4.7080000 0.300000 4.7090000 0.300000 4.7100000 0.300000 4.7110000 0.300000
+ 4.7120000 0.300000 4.7130000 0.300000 4.7140000 0.300000 4.7150000 0.300000
+ 4.7160000 0.300000 4.7170000 0.300000 4.7180000 0.300000 4.7190000 0.300000
+ 4.7200000 0.300000 4.7210000 0.300000 4.7220000 0.300000 4.7230000 0.300000
+ 4.7240000 0.300000 4.7250000 0.300000 4.7260000 0.300000 4.7270000 0.300000
+ 4.7280000 0.300000 4.7290000 0.300000 4.7300000 0.300000 4.7310000 0.300000
+ 4.7320000 0.300000 4.7330000 0.300000 4.7340000 0.300000 4.7350000 0.300000
+ 4.7360000 0.300000 4.7370000 0.300000 4.7380000 0.300000 4.7390000 0.300000
+ 4.7400000 0.300000 4.7410000 0.300000 4.7420000 0.300000 4.7430000 0.300000
+ 4.7440000 0.300000 4.7450000 0.300000 4.7460000 0.300000 4.7470000 0.300000
+ 4.7480000 0.300000 4.7490000 0.300000 4.7500000 0.300000 4.7510000 0.300000
+ 4.7520000 0.300000 4.7530000 0.300000 4.7540000 0.300000 4.7550000 0.300000
+ 4.7560000 0.300000 4.7570000 0.300000 4.7580000 0.300000 4.7590000 0.300000
+ 4.7600000 0.300000 4.7610000 0.300000 4.7620000 0.300000 4.7630000 0.300000
+ 4.7640000 0.300000 4.7650000 0.300000 4.7660000 0.300000 4.7670000 0.300000
+ 4.7680000 0.300000 4.7690000 0.300000 4.7700000 0.300000 4.7710000 0.300000
+ 4.7720000 0.300000 4.7730000 0.300000 4.7740000 0.300000 4.7750000 0.300000
+ 4.7760000 0.300000 4.7770000 0.300000 4.7780000 0.300000 4.7790000 0.300000
+ 4.7800000 0.300000 4.7810000 0.300000 4.7820000 0.300000 4.7830000 0.300000
+ 4.7840000 0.300000 4.7850000 0.300000 4.7860000 0.300000 4.7870000 0.300000
+ 4.7880000 0.300000 4.7890000 0.300000 4.7900000 0.300000 4.7910000 0.300000
+ 4.7920000 0.300000 4.7930000 0.300000 4.7940000 0.300000 4.7950000 0.300000
+ 4.7960000 0.300000 4.7970000 0.300000 4.7980000 0.300000 4.7990000 0.300000
+ 4.8000000 0.300000 4.8010000 0.300000 4.8020000 0.300000 4.8030000 0.300000
+ 4.8040000 0.300000 4.8050000 0.300000 4.8060000 0.300000 4.8070000 0.300000
+ 4.8080000 0.300000 4.8090000 0.300000 4.8100000 0.300000 4.8110000 0.300000
+ 4.8120000 0.300000 4.8130000 0.300000 4.8140000 0.300000 4.8150000 0.300000
+ 4.8160000 0.300000 4.8170000 0.300000 4.8180000 0.300000 4.8190000 0.300000
+ 4.8200000 0.300000 4.8210000 0.300000 4.8220000 0.300000 4.8230000 0.300000
+ 4.8240000 0.300000 4.8250000 0.300000 4.8260000 0.300000 4.8270000 0.300000
+ 4.8280000 0.300000 4.8290000 0.300000 4.8300000 0.300000 4.8310000 0.300000
+ 4.8320000 0.300000 4.8330000 0.300000 4.8340000 0.300000 4.8350000 0.300000
+ 4.8360000 0.300000 4.8370000 0.300000 4.8380000 0.300000 4.8390000 0.300000
+ 4.8400000 0.300000 4.8410000 0.300000 4.8420000 0.300000 4.8430000 0.300000
+ 4.8440000 0.300000 4.8450000 0.300000 4.8460000 0.300000 4.8470000 0.300000
+ 4.8480000 0.300000 4.8490000 0.300000 4.8500000 0.300000 4.8510000 0.300000
+ 4.8520000 0.300000 4.8530000 0.300000 4.8540000 0.300000 4.8550000 0.300000
+ 4.8560000 0.300000 4.8570000 0.300000 4.8580000 0.300000 4.8590000 0.300000
+ 4.8600000 0.300000 4.8610000 0.300000 4.8620000 0.300000 4.8630000 0.300000
+ 4.8640000 0.300000 4.8650000 0.300000 4.8660000 0.300000 4.8670000 0.300000
+ 4.8680000 0.300000 4.8690000 0.300000 4.8700000 0.300000 4.8710000 0.300000
+ 4.8720000 0.300000 4.8730000 0.300000 4.8740000 0.300000 4.8750000 0.300000
+ 4.8760000 0.300000 4.8770000 0.300000 4.8780000 0.300000 4.8790000 0.300000
+ 4.8800000 0.300000 4.8810000 0.300000 4.8820000 0.300000 4.8830000 0.300000
+ 4.8840000 0.300000 4.8850000 0.300000 4.8860000 0.300000 4.8870000 0.300000
+ 4.8880000 0.300000 4.8890000 0.300000 4.8900000 0.300000 4.8910000 0.300000
+ 4.8920000 0.300000 4.8930000 0.300000 4.8940000 0.300000 4.8950000 0.300000
+ 4.8960000 0.300000 4.8970000 0.300000 4.8980000 0.300000 4.8990000 0.300000
+ 4.9000000 0.300000 4.9010000 0.300000 4.9020000 0.300000 4.9030000 0.300000
+ 4.9040000 0.300000 4.9050000 0.300000 4.9060000 0.300000 4.9070000 0.300000
+ 4.9080000 0.300000 4.9090000 0.300000 4.9100000 0.300000 4.9110000 0.300000
+ 4.9120000 0.300000 4.9130000 0.300000 4.9140000 0.300000 4.9150000 0.300000
+ 4.9160000 0.300000 4.9170000 0.300000 4.9180000 0.300000 4.9190000 0.300000
+ 4.9200000 0.300000 4.9210000 0.300000 4.9220000 0.300000 4.9230000 0.300000
+ 4.9240000 0.300000 4.9250000 0.300000 4.9260000 0.300000 4.9270000 0.300000
+ 4.9280000 0.300000 4.9290000 0.300000 4.9300000 0.300000 4.9310000 0.300000
+ 4.9320000 0.300000 4.9330000 0.300000 4.9340000 0.300000 4.9350000 0.300000
+ 4.9360000 0.300000 4.9370000 0.300000 4.9380000 0.300000 4.9390000 0.300000
+ 4.9400000 0.300000 4.9410000 0.300000 4.9420000 0.300000 4.9430000 0.300000
+ 4.9440000 0.300000 4.9450000 0.300000 4.9460000 0.300000 4.9470000 0.300000
+ 4.9480000 0.300000 4.9490000 0.300000 4.9500000 0.300000 4.9510000 0.300000
+ 4.9520000 0.300000 4.9530000 0.300000 4.9540000 0.300000 4.9550000 0.300000
+ 4.9560000 0.300000 4.9570000 0.300000 4.9580000 0.300000 4.9590000 0.300000
+ 4.9600000 0.300000 4.9610000 0.300000 4.9620000 0.300000 4.9630000 0.300000
+ 4.9640000 0.300000 4.9650000 0.300000 4.9660000 0.300000 4.9670000 0.300000
+ 4.9680000 0.300000 4.9690000 0.300000 4.9700000 0.300000 4.9710000 0.300000
+ 4.9720000 0.300000 4.9730000 0.300000 4.9740000 0.300000 4.9750000 0.300000
+ 4.9760000 0.300000 4.9770000 0.300000 4.9780000 0.300000 4.9790000 0.300000
+ 4.9800000 0.300000 4.9810000 0.300000 4.9820000 0.300000 4.9830000 0.300000
+ 4.9840000 0.300000 4.9850000 0.300000 4.9860000 0.300000 4.9870000 0.300000
+ 4.9880000 0.300000 4.9890000 0.300000 4.9900000 0.300000 4.9910000 0.300000
+ 4.9920000 0.300000 4.9930000 0.300000 4.9940000 0.300000 4.9950000 0.300000
+ 4.9960000 0.300000 4.9970000 0.300000 4.9980000 0.300000 4.9990000 0.300000
+ )

* DUT: fast envelope follower only
Xenv vin env_out vdd vss vbias fast_envelope

* Initial condition: start at baseline
.ic v(env_out)=0.300

.tran 100u 5 0 100u

* Measurements
.meas tran env_pk1 max v(env_out) from=0.45 to=0.6
.meas tran env_pk2 max v(env_out) from=1.25 to=1.4
.meas tran env_at_0_7 find v(env_out) at=0.7
.meas tran env_at_0_9 find v(env_out) at=0.9
.meas tran env_at_1_1 find v(env_out) at=1.1

.save v(vin) v(env_out)

.control
set filetype=ascii
run

echo ""
echo "=== PHASE 1B: ENVELOPE FOLLOWER TEST ==="
print env_pk1 env_pk2
echo "--- Decay profile after first pulse ---"
print env_at_0_7 env_at_0_9 env_at_1_1
echo ""

wrdata phase1b_results.txt v(vin) v(env_out)

echo "=== Done ==="
quit
.endc

.end
