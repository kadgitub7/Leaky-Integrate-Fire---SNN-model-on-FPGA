* V5 Detector Test — MIT-BIH Record 200
.lib C:/Users/kadhi/OneDrive/Desktop/amux/verilogLearning/Leaky-Integrate-Fire---SNN-model-on-FPGA/experiments/frontend_optimization/ngspice_frontend/sky130_minimal.lib.spice tt
.include C:/Users/kadhi/OneDrive/Desktop/amux/verilogLearning/Leaky-Integrate-Fire---SNN-model-on-FPGA/experiments/frontend_optimization/complete_frontend_v9b/rpeak_detector_v5.spice
.option scale=1.0u method=gear reltol=0.01 gmin=1e-15

Vdd vdd 0 0.9
Vss vss 0 0.0
Vbias vbias 0 0.4

Vecg ecg_in 0 pwl(
+ 0.0000000 0.452855 0.0027778 0.452855 0.0055556 0.452855 0.0083333 0.452855
+ 0.0111111 0.452855 0.0138889 0.452855 0.0166667 0.452855 0.0194444 0.452855
+ 0.0222222 0.452855 0.0250000 0.433529 0.0277778 0.420059 0.0305556 0.413031
+ 0.0333333 0.410688 0.0361111 0.412738 0.0388889 0.415666 0.0416667 0.418887
+ 0.0444444 0.419766 0.0472222 0.420644 0.0500000 0.421230 0.0527778 0.420644
+ 0.0555556 0.420644 0.0583333 0.420059 0.0611111 0.418887 0.0638889 0.417716
+ 0.0666667 0.417423 0.0694444 0.418009 0.0722222 0.418302 0.0750000 0.419766
+ 0.0777778 0.418594 0.0805556 0.418887 0.0833333 0.418887 0.0861111 0.420351
+ 0.0888889 0.421816 0.0916667 0.422694 0.0944444 0.420937 0.0972222 0.420059
+ 0.1000000 0.419766 0.1027778 0.420937 0.1055556 0.422401 0.1083333 0.423280
+ 0.1111111 0.422108 0.1138889 0.420937 0.1166667 0.420059 0.1194444 0.420644
+ 0.1222222 0.420644 0.1250000 0.420937 0.1277778 0.421523 0.1305556 0.421523
+ 0.1333333 0.421816 0.1361111 0.422108 0.1388889 0.422108 0.1416667 0.422694
+ 0.1444444 0.424158 0.1472222 0.425329 0.1500000 0.425622 0.1527778 0.424744
+ 0.1555556 0.423280 0.1583333 0.421230 0.1611111 0.421230 0.1638889 0.421523
+ 0.1666667 0.421816 0.1694444 0.422987 0.1722222 0.424158 0.1750000 0.424744
+ 0.1777778 0.425915 0.1805556 0.425329 0.1833333 0.424744 0.1861111 0.424744
+ 0.1888889 0.425037 0.1916667 0.426794 0.1944444 0.426794 0.1972222 0.427086
+ 0.2000000 0.427672 0.2027778 0.427965 0.2055556 0.428258 0.2083333 0.427965
+ 0.2111111 0.428551 0.2138889 0.429136 0.2166667 0.428843 0.2194444 0.429136
+ 0.2222222 0.430015 0.2250000 0.430600 0.2277778 0.431186 0.2305556 0.431479
+ 0.2333333 0.431479 0.2361111 0.431772 0.2388889 0.433236 0.2416667 0.434407
+ 0.2444444 0.433821 0.2472222 0.433236 0.2500000 0.433236 0.2527778 0.433821
+ 0.2555556 0.433821 0.2583333 0.434700 0.2611111 0.434700 0.2638889 0.434114
+ 0.2666667 0.433236 0.2694444 0.433529 0.2722222 0.434407 0.2750000 0.434993
+ 0.2777778 0.435286 0.2805556 0.433821 0.2833333 0.433529 0.2861111 0.433529
+ 0.2888889 0.432943 0.2916667 0.432943 0.2944444 0.432357 0.2972222 0.432064
+ 0.3000000 0.430893 0.3027778 0.431186 0.3055556 0.430600 0.3083333 0.430600
+ 0.3111111 0.430307 0.3138889 0.429722 0.3166667 0.429136 0.3194444 0.428843
+ 0.3222222 0.428551 0.3250000 0.427965 0.3277778 0.427672 0.3305556 0.427965
+ 0.3333333 0.427965 0.3361111 0.427965 0.3388889 0.428258 0.3416667 0.427965
+ 0.3444444 0.427672 0.3472222 0.427086 0.3500000 0.426501 0.3527778 0.426794
+ 0.3555556 0.426794 0.3583333 0.427379 0.3611111 0.426794 0.3638889 0.426501
+ 0.3666667 0.426501 0.3694444 0.425622 0.3722222 0.425622 0.3750000 0.424744
+ 0.3777778 0.424158 0.3805556 0.423572 0.3833333 0.422987 0.3861111 0.423865
+ 0.3888889 0.423280 0.3916667 0.422987 0.3944444 0.422401 0.3972222 0.421523
+ 0.4000000 0.422108 0.4027778 0.422401 0.4055556 0.422694 0.4083333 0.422401
+ 0.4111111 0.422401 0.4138889 0.422694 0.4166667 0.421816 0.4194444 0.421816
+ 0.4222222 0.420644 0.4250000 0.420644 0.4277778 0.419766 0.4305556 0.420351
+ 0.4333333 0.420059 0.4361111 0.420351 0.4388889 0.420059 0.4416667 0.419473
+ 0.4444444 0.419180 0.4472222 0.419180 0.4500000 0.418302 0.4527778 0.419180
+ 0.4555556 0.420059 0.4583333 0.420351 0.4611111 0.420937 0.4638889 0.421230
+ 0.4666667 0.420644 0.4694444 0.421230 0.4722222 0.421230 0.4750000 0.421523
+ 0.4777778 0.422401 0.4805556 0.422401 0.4833333 0.422108 0.4861111 0.422694
+ 0.4888889 0.422694 0.4916667 0.421523 0.4944444 0.421523 0.4972222 0.420351
+ 0.5000000 0.420351 0.5027778 0.420059 0.5055556 0.420937 0.5083333 0.420937
+ 0.5111111 0.421230 0.5138889 0.420937 0.5166667 0.420937 0.5194444 0.420937
+ 0.5222222 0.421523 0.5250000 0.422108 0.5277778 0.422108 0.5305556 0.420644
+ 0.5333333 0.419180 0.5361111 0.417716 0.5388889 0.418302 0.5416667 0.418302
+ 0.5444444 0.418302 0.5472222 0.417716 0.5500000 0.417130 0.5527778 0.416545
+ 0.5555556 0.415959 0.5583333 0.414495 0.5611111 0.412738 0.5638889 0.411859
+ 0.5666667 0.412445 0.5694444 0.415666 0.5722222 0.420351 0.5750000 0.424451
+ 0.5777778 0.426794 0.5805556 0.429722 0.5833333 0.432943 0.5861111 0.436750
+ 0.5888889 0.440556 0.5916667 0.442606 0.5944444 0.440264 0.5972222 0.434993
+ 0.6000000 0.423280 0.6027778 0.407467 0.6055556 0.390776 0.6083333 0.378770
+ 0.6111111 0.368521 0.6138889 0.358858 0.6166667 0.350659 0.6194444 0.346559
+ 0.6222222 0.344217 0.6250000 0.345095 0.6277778 0.347438 0.6305556 0.350952
+ 0.6333333 0.353880 0.6361111 0.357980 0.6388889 0.364714 0.6416667 0.372328
+ 0.6444444 0.376720 0.6472222 0.377892 0.6500000 0.377892 0.6527778 0.379063
+ 0.6555556 0.380527 0.6583333 0.381698 0.6611111 0.383163 0.6638889 0.385505
+ 0.6666667 0.388141 0.6694444 0.390483 0.6722222 0.393704 0.6750000 0.395461
+ 0.6777778 0.398389 0.6805556 0.400732 0.6833333 0.402489 0.6861111 0.405124
+ 0.6888889 0.406881 0.6916667 0.409224 0.6944444 0.410981 0.6972222 0.413909
+ 0.7000000 0.416837 0.7027778 0.420644 0.7055556 0.423280 0.7083333 0.427086
+ 0.7111111 0.430015 0.7138889 0.431479 0.7166667 0.431772 0.7194444 0.432650
+ 0.7222222 0.434114 0.7250000 0.435578 0.7277778 0.437042 0.7305556 0.437335
+ 0.7333333 0.437628 0.7361111 0.438799 0.7388889 0.438799 0.7416667 0.439971
+ 0.7444444 0.441142 0.7472222 0.441435 0.7500000 0.441142 0.7527778 0.442899
+ 0.7555556 0.443192 0.7583333 0.444363 0.7611111 0.445242 0.7638889 0.446120
+ 0.7666667 0.446120 0.7694444 0.447291 0.7722222 0.448170 0.7750000 0.449341
+ 0.7777778 0.449341 0.7805556 0.449927 0.7833333 0.449927 0.7861111 0.450220
+ 0.7888889 0.451391 0.7916667 0.450805 0.7944444 0.450512 0.7972222 0.450805
+ 0.8000000 0.450805 0.8027778 0.452562 0.8055556 0.453441 0.8083333 0.454026
+ 0.8111111 0.454319 0.8138889 0.454319 0.8166667 0.453734 0.8194444 0.454319
+ 0.8222222 0.454905 0.8250000 0.456369 0.8277778 0.456076 0.8305556 0.455783
+ 0.8333333 0.455783 0.8361111 0.456076 0.8388889 0.455783 0.8416667 0.456369
+ 0.8444444 0.455490 0.8472222 0.455783 0.8500000 0.454905 0.8527778 0.455198
+ 0.8555556 0.455490 0.8583333 0.454905 0.8611111 0.454612 0.8638889 0.453148
+ 0.8666667 0.453148 0.8694444 0.453148 0.8722222 0.452855 0.8750000 0.451391
+ 0.8777778 0.449927 0.8805556 0.448755 0.8833333 0.446999 0.8861111 0.446999
+ 0.8888889 0.446999 0.8916667 0.446999 0.8944444 0.446120 0.8972222 0.444656
+ 0.9000000 0.442606 0.9027778 0.442020 0.9055556 0.441728 0.9083333 0.440849
+ 0.9111111 0.440556 0.9138889 0.440849 0.9166667 0.439971 0.9194444 0.438214
+ 0.9222222 0.437042 0.9250000 0.434700 0.9277778 0.433236 0.9305556 0.431772
+ 0.9333333 0.430893 0.9361111 0.430893 0.9388889 0.430600 0.9416667 0.430015
+ 0.9444444 0.429722 0.9472222 0.428258 0.9500000 0.426208 0.9527778 0.427672
+ 0.9555556 0.427965 0.9583333 0.427379 0.9611111 0.427086 0.9638889 0.425915
+ 0.9666667 0.424744 0.9694444 0.425329 0.9722222 0.425622 0.9750000 0.425037
+ 0.9777778 0.423572 0.9805556 0.422401 0.9833333 0.422987 0.9861111 0.422987
+ 0.9888889 0.423572 0.9916667 0.423280 0.9944444 0.422987 0.9972222 0.422401
+ 1.0000000 0.421523 1.0027778 0.421816 1.0055556 0.421816 1.0083333 0.421230
+ 1.0111111 0.421816 1.0138889 0.422401 1.0166667 0.422987 1.0194444 0.424158
+ 1.0222222 0.424158 1.0250000 0.423865 1.0277778 0.422401 1.0305556 0.421816
+ 1.0333333 0.422108 1.0361111 0.422987 1.0388889 0.423280 1.0416667 0.423280
+ 1.0444444 0.422694 1.0472222 0.423572 1.0500000 0.423280 1.0527778 0.423572
+ 1.0555556 0.423865 1.0583333 0.423865 1.0611111 0.422694 1.0638889 0.420937
+ 1.0666667 0.420351 1.0694444 0.421230 1.0722222 0.421816 1.0750000 0.422694
+ 1.0777778 0.422401 1.0805556 0.422987 1.0833333 0.422401 1.0861111 0.422694
+ 1.0888889 0.422401 1.0916667 0.422401 1.0944444 0.422401 1.0972222 0.422401
+ 1.1000000 0.421523 1.1027778 0.421230 1.1055556 0.421816 1.1083333 0.421816
+ 1.1111111 0.421816 1.1138889 0.422108 1.1166667 0.420644 1.1194444 0.420059
+ 1.1222222 0.420644 1.1250000 0.420644 1.1277778 0.420059 1.1305556 0.419766
+ 1.1333333 0.420059 1.1361111 0.420644 1.1388889 0.422108 1.1416667 0.422987
+ 1.1444444 0.423865 1.1472222 0.423865 1.1500000 0.424451 1.1527778 0.424158
+ 1.1555556 0.424451 1.1583333 0.424744 1.1611111 0.425329 1.1638889 0.425622
+ 1.1666667 0.425915 1.1694444 0.426208 1.1722222 0.426501 1.1750000 0.426794
+ 1.1777778 0.425915 1.1805556 0.424158 1.1833333 0.422108 1.1861111 0.421816
+ 1.1888889 0.421816 1.1916667 0.421816 1.1944444 0.422694 1.1972222 0.422108
+ 1.2000000 0.422108 1.2027778 0.422108 1.2055556 0.422694 1.2083333 0.422694
+ 1.2111111 0.422694 1.2138889 0.422108 1.2166667 0.422694 1.2194444 0.422987
+ 1.2222222 0.423280 1.2250000 0.423572 1.2277778 0.423280 1.2305556 0.422987
+ 1.2333333 0.422987 1.2361111 0.423280 1.2388889 0.423865 1.2416667 0.423572
+ 1.2444444 0.423572 1.2472222 0.421523 1.2500000 0.420644 1.2527778 0.420644
+ 1.2555556 0.420937 1.2583333 0.421230 1.2611111 0.421230 1.2638889 0.420937
+ 1.2666667 0.420644 1.2694444 0.420937 1.2722222 0.421523 1.2750000 0.422108
+ 1.2777778 0.422108 1.2805556 0.423280 1.2833333 0.422401 1.2861111 0.422401
+ 1.2888889 0.422694 1.2916667 0.423572 1.2944444 0.422987 1.2972222 0.422694
+ 1.3000000 0.422108 1.3027778 0.422401 1.3055556 0.422401 1.3083333 0.421523
+ 1.3111111 0.419766 1.3138889 0.419180 1.3166667 0.421230 1.3194444 0.425037
+ 1.3222222 0.430015 1.3250000 0.435286 1.3277778 0.439678 1.3305556 0.444949
+ 1.3333333 0.451098 1.3361111 0.456662 1.3388889 0.461640 1.3416667 0.467789
+ 1.3444444 0.474817 1.3472222 0.481845 1.3500000 0.487408 1.3527778 0.494436
+ 1.3555556 0.497365 1.3583333 0.496779 1.3611111 0.491215 1.3638889 0.482723
+ 1.3666667 0.468375 1.3694444 0.446413 1.3722222 0.425915 1.3750000 0.412738
+ 1.3777778 0.405417 1.3805556 0.402196 1.3833333 0.400732 1.3861111 0.402489
+ 1.3888889 0.406589 1.3916667 0.409810 1.3944444 0.411274 1.3972222 0.411859
+ 1.4000000 0.412738 1.4027778 0.413616 1.4055556 0.415081 1.4083333 0.414788
+ 1.4111111 0.414788 1.4138889 0.413324 1.4166667 0.412738 1.4194444 0.412738
+ 1.4222222 0.412738 1.4250000 0.413324 1.4277778 0.414202 1.4305556 0.414788
+ 1.4333333 0.415959 1.4361111 0.417130 1.4388889 0.418302 1.4416667 0.418009
+ 1.4444444 0.417130 1.4472222 0.416545 1.4500000 0.415959 1.4527778 0.415959
+ 1.4555556 0.416252 1.4583333 0.416545 1.4611111 0.416252 1.4638889 0.415959
+ 1.4666667 0.417423 1.4694444 0.417716 1.4722222 0.418302 1.4750000 0.418594
+ 1.4777778 0.418594 1.4805556 0.418594 1.4833333 0.418302 1.4861111 0.418594
+ 1.4888889 0.418594 1.4916667 0.418887 1.4944444 0.418302 1.4972222 0.419180
+ 1.5000000 0.418887 1.5027778 0.419180 1.5055556 0.420059 1.5083333 0.420937
+ 1.5111111 0.419766 1.5138889 0.419473 1.5166667 0.418302 1.5194444 0.418887
+ 1.5222222 0.418887 1.5250000 0.419766 1.5277778 0.420059 1.5305556 0.420059
+ 1.5333333 0.419473 1.5361111 0.420351 1.5388889 0.421816 1.5416667 0.421523
+ 1.5444444 0.421230 1.5472222 0.421230 1.5500000 0.420937 1.5527778 0.422987
+ 1.5555556 0.424158 1.5583333 0.424744 1.5611111 0.425037 1.5638889 0.424744
+ 1.5666667 0.424158 1.5694444 0.424744 1.5722222 0.425329 1.5750000 0.425037
+ 1.5777778 0.425037 1.5805556 0.423865 1.5833333 0.425037 1.5861111 0.425329
+ 1.5888889 0.425037 1.5916667 0.425622 1.5944444 0.425329 1.5972222 0.424158
+ 1.6000000 0.423572 1.6027778 0.423865 1.6055556 0.424451 1.6083333 0.425915
+ 1.6111111 0.426208 1.6138889 0.426501 1.6166667 0.427379 1.6194444 0.426794
+ 1.6222222 0.427672 1.6250000 0.428551 1.6277778 0.428258 1.6305556 0.428258
+ 1.6333333 0.427965 1.6361111 0.428258 1.6388889 0.428843 1.6416667 0.429136
+ 1.6444444 0.429429 1.6472222 0.427965 1.6500000 0.428551 1.6527778 0.428551
+ 1.6555556 0.428258 1.6583333 0.427672 1.6611111 0.427672 1.6638889 0.427672
+ 1.6666667 0.427672 1.6694444 0.427672 1.6722222 0.427672 1.6750000 0.427965
+ 1.6777778 0.427086 1.6805556 0.427086 1.6833333 0.427379 1.6861111 0.427086
+ 1.6888889 0.427965 1.6916667 0.427965 1.6944444 0.428258 1.6972222 0.427965
+ 1.7000000 0.427086 1.7027778 0.427965 1.7055556 0.428551 1.7083333 0.428258
+ 1.7111111 0.428258 1.7138889 0.427379 1.7166667 0.427086 1.7194444 0.427086
+ 1.7222222 0.427672 1.7250000 0.426501 1.7277778 0.426208 1.7305556 0.425622
+ 1.7333333 0.425329 1.7361111 0.425622 1.7388889 0.426501 1.7416667 0.426208
+ 1.7444444 0.425329 1.7472222 0.424158 1.7500000 0.424158 1.7527778 0.425622
+ 1.7555556 0.428258 1.7583333 0.427965 1.7611111 0.427086 1.7638889 0.426208
+ 1.7666667 0.425622 1.7694444 0.425915 1.7722222 0.425915 1.7750000 0.424744
+ 1.7777778 0.424451 1.7805556 0.423572 1.7833333 0.424744 1.7861111 0.425037
+ 1.7888889 0.425037 1.7916667 0.424158 1.7944444 0.423280 1.7972222 0.423280
+ 1.8000000 0.423280 1.8027778 0.423280 1.8055556 0.423865 1.8083333 0.424744
+ 1.8111111 0.424744 1.8138889 0.424744 1.8166667 0.425329 1.8194444 0.425915
+ 1.8222222 0.427086 1.8250000 0.428258 1.8277778 0.428843 1.8305556 0.427672
+ 1.8333333 0.427965 1.8361111 0.429429 1.8388889 0.431479 1.8416667 0.432650
+ 1.8444444 0.433529 1.8472222 0.433529 1.8500000 0.434700 1.8527778 0.435871
+ 1.8555556 0.437042 1.8583333 0.438507 1.8611111 0.438799 1.8638889 0.437921
+ 1.8666667 0.439385 1.8694444 0.444070 1.8722222 0.447877 1.8750000 0.447877
+ 1.8777778 0.445242 1.8805556 0.444070 1.8833333 0.443485 1.8861111 0.441142
+ 1.8888889 0.434407 1.8916667 0.419180 1.8944444 0.395754 1.8972222 0.368521
+ 1.9000000 0.345974 1.9027778 0.330161 1.9055556 0.321376 1.9083333 0.317862
+ 1.9111111 0.315520 1.9138889 0.314641 1.9166667 0.315227 1.9194444 0.317277
+ 1.9222222 0.320791 1.9250000 0.324305 1.9277778 0.329868 1.9305556 0.338360
+ 1.9333333 0.345974 1.9361111 0.353294 1.9388889 0.357687 1.9416667 0.360029
+ 1.9444444 0.363250 1.9472222 0.367643 1.9500000 0.371742 1.9527778 0.377306
+ 1.9555556 0.383748 1.9583333 0.387262 1.9611111 0.390483 1.9638889 0.393411
+ 1.9666667 0.396925 1.9694444 0.401903 1.9722222 0.405124 1.9750000 0.407760
+ 1.9777778 0.408931 1.9805556 0.409517 1.9833333 0.410395 1.9861111 0.412445
+ 1.9888889 0.414495 1.9916667 0.416545 1.9944444 0.421230 1.9972222 0.425037
+ 2.0000000 0.428843 2.0027778 0.432064 2.0055556 0.435286 2.0083333 0.438799
+ 2.0111111 0.441142 2.0138889 0.443192 2.0166667 0.444656 2.0194444 0.445827
+ 2.0222222 0.447584 2.0250000 0.449048 2.0277778 0.451391 2.0305556 0.451684
+ 2.0333333 0.451391 2.0361111 0.452855 2.0388889 0.455198 2.0416667 0.457540
+ 2.0444444 0.459883 2.0472222 0.459590 2.0500000 0.460761 2.0527778 0.461933
+ 2.0555556 0.462811 2.0583333 0.463982 2.0611111 0.465154 2.0638889 0.466618
+ 2.0666667 0.467496 2.0694444 0.468668 2.0722222 0.470132 2.0750000 0.470717
+ 2.0777778 0.471889 2.0805556 0.472182 2.0833333 0.473060 2.0861111 0.474231
+ 2.0888889 0.476574 2.0916667 0.478331 2.0944444 0.479502 2.0972222 0.478917
+ 2.1000000 0.479502 2.1027778 0.480381 2.1055556 0.481552 2.1083333 0.483016
+ 2.1111111 0.482430 2.1138889 0.482138 2.1166667 0.481259 2.1194444 0.480966
+ 2.1222222 0.481259 2.1250000 0.480673 2.1277778 0.479209 2.1305556 0.478624
+ 2.1333333 0.477452 2.1361111 0.478038 2.1388889 0.477452 2.1416667 0.476574
+ 2.1444444 0.474231 2.1472222 0.472182 2.1500000 0.471303 2.1527778 0.469839
+ 2.1555556 0.468375 2.1583333 0.467789 2.1611111 0.466618 2.1638889 0.465154
+ 2.1666667 0.463397 2.1694444 0.461347 2.1722222 0.459297 2.1750000 0.457833
+ 2.1777778 0.455783 2.1805556 0.453441 2.1833333 0.451391 2.1861111 0.449341
+ 2.1888889 0.448463 2.1916667 0.446706 2.1944444 0.444363 2.1972222 0.443192
+ 2.2000000 0.443192 2.2027778 0.442606 2.2055556 0.442020 2.2083333 0.441435
+ 2.2111111 0.440556 2.2138889 0.439971 2.2166667 0.438799 2.2194444 0.437921
+ 2.2222222 0.436750 2.2250000 0.435578 2.2277778 0.434407 2.2305556 0.433236
+ 2.2333333 0.432064 2.2361111 0.432943 2.2388889 0.433236 2.2416667 0.432357
+ 2.2444444 0.431186 2.2472222 0.430015 2.2500000 0.429136 2.2527778 0.430307
+ 2.2555556 0.432064 2.2583333 0.432650 2.2611111 0.432064 2.2638889 0.430893
+ 2.2666667 0.431186 2.2694444 0.431772 2.2722222 0.431479 2.2750000 0.431186
+ 2.2777778 0.430600 2.2805556 0.429722 2.2833333 0.428843 2.2861111 0.428551
+ 2.2888889 0.428843 2.2916667 0.429429 2.2944444 0.428843 2.2972222 0.427379
+ 2.3000000 0.427086 2.3027778 0.425915 2.3055556 0.426208 2.3083333 0.426794
+ 2.3111111 0.427379 2.3138889 0.427965 2.3166667 0.427672 2.3194444 0.426794
+ 2.3222222 0.426794 2.3250000 0.427086 2.3277778 0.426794 2.3305556 0.425622
+ 2.3333333 0.425622 2.3361111 0.425329 2.3388889 0.425915 2.3416667 0.426794
+ 2.3444444 0.426208 2.3472222 0.425915 2.3500000 0.425037 2.3527778 0.425622
+ 2.3555556 0.427086 2.3583333 0.426794 2.3611111 0.425915 2.3638889 0.425037
+ 2.3666667 0.424451 2.3694444 0.424744 2.3722222 0.425037 2.3750000 0.425037
+ 2.3777778 0.424451 2.3805556 0.423865 2.3833333 0.423280 2.3861111 0.423865
+ 2.3888889 0.424744 2.3916667 0.424451 2.3944444 0.424158 2.3972222 0.423280
+ 2.4000000 0.423280 2.4027778 0.424451 2.4055556 0.425037 2.4083333 0.424744
+ 2.4111111 0.424451 2.4138889 0.423865 2.4166667 0.422694 2.4194444 0.421230
+ 2.4222222 0.422108 2.4250000 0.423572 2.4277778 0.424451 2.4305556 0.425037
+ 2.4333333 0.423865 2.4361111 0.425915 2.4388889 0.427086 2.4416667 0.428258
+ 2.4444444 0.427965 2.4472222 0.427086 2.4500000 0.424451 2.4527778 0.423572
+ 2.4555556 0.423280 2.4583333 0.423280 2.4611111 0.425329 2.4638889 0.426501
+ 2.4666667 0.427672 2.4694444 0.428551 2.4722222 0.427965 2.4750000 0.426794
+ 2.4777778 0.426501 2.4805556 0.426794 2.4833333 0.427379 2.4861111 0.427672
+ 2.4888889 0.427672 2.4916667 0.427672 2.4944444 0.426794 2.4972222 0.425329
+ 2.5000000 0.425037 2.5027778 0.425037 2.5055556 0.425037 2.5083333 0.424744
+ 2.5111111 0.424451 2.5138889 0.424744 2.5166667 0.424744 2.5194444 0.425329
+ 2.5222222 0.425622 2.5250000 0.426208 2.5277778 0.425329 2.5305556 0.423865
+ 2.5333333 0.424451 2.5361111 0.425915 2.5388889 0.425915 2.5416667 0.425915
+ 2.5444444 0.425037 2.5472222 0.426208 2.5500000 0.426501 2.5527778 0.427672
+ 2.5555556 0.429429 2.5583333 0.430600 2.5611111 0.428258 2.5638889 0.425329
+ 2.5666667 0.421523 2.5694444 0.419766 2.5722222 0.419473 2.5750000 0.421523
+ 2.5777778 0.422987 2.5805556 0.422987 2.5833333 0.423865 2.5861111 0.423572
+ 2.5888889 0.424744 2.5916667 0.424158 2.5944444 0.423572 2.5972222 0.422401
+ 2.6000000 0.421230 2.6027778 0.421523 2.6055556 0.422401 2.6083333 0.422108
+ 2.6111111 0.422694 2.6138889 0.422987 2.6166667 0.421816 2.6194444 0.422108
+ 2.6222222 0.421523 2.6250000 0.421523 2.6277778 0.421230 2.6305556 0.420351
+ 2.6333333 0.420059 2.6361111 0.419766 2.6388889 0.419766 2.6416667 0.421816
+ 2.6444444 0.425037 2.6472222 0.427965 2.6500000 0.432357 2.6527778 0.437335
+ 2.6555556 0.443485 2.6583333 0.449341 2.6611111 0.453441 2.6638889 0.458126
+ 2.6666667 0.463690 2.6694444 0.472182 2.6722222 0.479209 2.6750000 0.485359
+ 2.6777778 0.490630 2.6805556 0.492387 2.6833333 0.491215 2.6861111 0.486237
+ 2.6888889 0.478624 2.6916667 0.465739 2.6944444 0.445534 2.6972222 0.425329
+ 2.7000000 0.412738 2.7027778 0.407174 2.7055556 0.402782 2.7083333 0.401903
+ 2.7111111 0.403367 2.7138889 0.406589 2.7166667 0.408931 2.7194444 0.410981
+ 2.7222222 0.410688 2.7250000 0.409810 2.7277778 0.411274 2.7305556 0.410688
+ 2.7333333 0.410102 2.7361111 0.409517 2.7388889 0.408053 2.7416667 0.408638
+ 2.7444444 0.408638 2.7472222 0.408638 2.7500000 0.408053 2.7527778 0.408346
+ 2.7555556 0.409224 2.7583333 0.409810 2.7611111 0.409810 2.7638889 0.409810
+ 2.7666667 0.410981 2.7694444 0.411567 2.7722222 0.412152 2.7750000 0.412738
+ 2.7777778 0.411567 2.7805556 0.409517 2.7833333 0.408931 2.7861111 0.409517
+ 2.7888889 0.411274 2.7916667 0.413031 2.7944444 0.412445 2.7972222 0.410102
+ 2.8000000 0.409224 2.8027778 0.408638 2.8055556 0.409517 2.8083333 0.409224
+ 2.8111111 0.409517 2.8138889 0.408931 2.8166667 0.408931 2.8194444 0.409224
+ 2.8222222 0.409517 2.8250000 0.409810 2.8277778 0.409517 2.8305556 0.409810
+ 2.8333333 0.409810 2.8361111 0.410102 2.8388889 0.410688 2.8416667 0.412445
+ 2.8444444 0.412738 2.8472222 0.412738 2.8500000 0.413031 2.8527778 0.413324
+ 2.8555556 0.411859 2.8583333 0.410981 2.8611111 0.411567 2.8638889 0.412152
+ 2.8666667 0.412445 2.8694444 0.412445 2.8722222 0.411274 2.8750000 0.411859
+ 2.8777778 0.412152 2.8805556 0.411859 2.8833333 0.411567 2.8861111 0.412152
+ 2.8888889 0.412445 2.8916667 0.412738 2.8944444 0.412152 2.8972222 0.410981
+ 2.9000000 0.411859 2.9027778 0.411859 2.9055556 0.412738 2.9083333 0.413031
+ 2.9111111 0.414202 2.9138889 0.415373 2.9166667 0.415666 2.9194444 0.416837
+ 2.9222222 0.416252 2.9250000 0.415959 2.9277778 0.414788 2.9305556 0.414495
+ 2.9333333 0.414495 2.9361111 0.415081 2.9388889 0.415666 2.9416667 0.414495
+ 2.9444444 0.413616 2.9472222 0.413616 2.9500000 0.414495 2.9527778 0.416252
+ 2.9555556 0.416837 2.9583333 0.416252 2.9611111 0.415666 2.9638889 0.415959
+ 2.9666667 0.416545 2.9694444 0.417130 2.9722222 0.417716 2.9750000 0.417423
+ 2.9777778 0.417423 2.9805556 0.416837 2.9833333 0.416837 2.9861111 0.417716
+ 2.9888889 0.417130 2.9916667 0.418009 2.9944444 0.417130 2.9972222 0.415666
+ 3.0000000 0.415373 3.0027778 0.415373 3.0055556 0.415959 3.0083333 0.415666
+ 3.0111111 0.415666 3.0138889 0.415959 3.0166667 0.414202 3.0194444 0.414202
+ 3.0222222 0.414788 3.0250000 0.415666 3.0277778 0.416252 3.0305556 0.415081
+ 3.0333333 0.414495 3.0361111 0.414788 3.0388889 0.414788 3.0416667 0.413616
+ 3.0444444 0.414788 3.0472222 0.414495 3.0500000 0.413909 3.0527778 0.414495
+ 3.0555556 0.415081 3.0583333 0.415081 3.0611111 0.414495 3.0638889 0.412738
+ 3.0666667 0.412738 3.0694444 0.412445 3.0722222 0.412738 3.0750000 0.412738
+ 3.0777778 0.412152 3.0805556 0.411274 3.0833333 0.410981 3.0861111 0.411567
+ 3.0888889 0.412738 3.0916667 0.413031 3.0944444 0.413616 3.0972222 0.414202
+ 3.1000000 0.415081 3.1027778 0.416252 3.1055556 0.417716 3.1083333 0.418887
+ 3.1111111 0.420059 3.1138889 0.420644 3.1166667 0.422108 3.1194444 0.423572
+ 3.1222222 0.424158 3.1250000 0.423865 3.1277778 0.423280 3.1305556 0.423280
+ 3.1333333 0.424744 3.1361111 0.424744 3.1388889 0.425622 3.1416667 0.426208
+ 3.1444444 0.428843 3.1472222 0.430015 3.1500000 0.429722 3.1527778 0.427379
+ 3.1555556 0.422987 3.1583333 0.417130 3.1611111 0.407174 3.1638889 0.391947
+ 3.1666667 0.370278 3.1694444 0.348902 3.1722222 0.331040 3.1750000 0.319327
+ 3.1777778 0.313177 3.1805556 0.311420 3.1833333 0.311713 3.1861111 0.310542
+ 3.1888889 0.312006 3.1916667 0.315520 3.1944444 0.321083 3.1972222 0.326647
+ 3.2000000 0.332504 3.2027778 0.336603 3.2055556 0.342167 3.2083333 0.348023
+ 3.2111111 0.354758 3.2138889 0.360029 3.2166667 0.365300 3.2194444 0.369985
+ 3.2222222 0.374085 3.2250000 0.377306 3.2277778 0.378770 3.2305556 0.381406
+ 3.2333333 0.383748 3.2361111 0.387848 3.2388889 0.391947 3.2416667 0.393997
+ 3.2444444 0.395754 3.2472222 0.396633 3.2500000 0.398097 3.2527778 0.399268
+ 3.2555556 0.401318 3.2583333 0.403660 3.2611111 0.404832 3.2638889 0.407760
+ 3.2666667 0.411859 3.2694444 0.416252 3.2722222 0.420351 3.2750000 0.423280
+ 3.2777778 0.425329 3.2805556 0.427086 3.2833333 0.430600 3.2861111 0.433529
+ 3.2888889 0.435871 3.2916667 0.437042 3.2944444 0.437921 3.2972222 0.439971
+ 3.3000000 0.441142 3.3027778 0.442313 3.3055556 0.442899 3.3083333 0.443192
+ 3.3111111 0.444656 3.3138889 0.445534 3.3166667 0.446706 3.3194444 0.448170
+ 3.3222222 0.449927 3.3250000 0.450805 3.3277778 0.450512 3.3305556 0.450805
+ 3.3333333 0.452855 3.3361111 0.454026 3.3388889 0.453734 3.3416667 0.454026
+ 3.3444444 0.454905 3.3472222 0.455783 3.3500000 0.457247 3.3527778 0.459883
+ 3.3555556 0.461054 3.3583333 0.461933 3.3611111 0.461933 3.3638889 0.463397
+ 3.3666667 0.463397 3.3694444 0.463690 3.3722222 0.463982 3.3750000 0.464275
+ 3.3777778 0.464275 3.3805556 0.465739 3.3833333 0.466325 3.3861111 0.465739
+ 3.3888889 0.466032 3.3916667 0.465154 3.3944444 0.464568 3.3972222 0.464275
+ 3.4000000 0.464861 3.4027778 0.464568 3.4055556 0.465154 3.4083333 0.464568
+ 3.4111111 0.463397 3.4138889 0.461640 3.4166667 0.460469 3.4194444 0.459590
+ 3.4222222 0.459590 3.4250000 0.458126 3.4277778 0.456076 3.4305556 0.455490
+ 3.4333333 0.454319 3.4361111 0.453441 3.4388889 0.453148 3.4416667 0.452562
+ 3.4444444 0.449341 3.4472222 0.446999 3.4500000 0.445242 3.4527778 0.443777
+ 3.4555556 0.442606 3.4583333 0.441142 3.4611111 0.439385 3.4638889 0.437921
+ 3.4666667 0.436164 3.4694444 0.435578 3.4722222 0.434407 3.4750000 0.433529
+ 3.4777778 0.432064 3.4805556 0.430893 3.4833333 0.430015 3.4861111 0.428551
+ 3.4888889 0.428258 3.4916667 0.427672 3.4944444 0.426501 3.4972222 0.425622
+ 3.5000000 0.424451 3.5027778 0.424744 3.5055556 0.424158 3.5083333 0.423280
+ 3.5111111 0.422987 3.5138889 0.422401 3.5166667 0.422401 3.5194444 0.422108
+ 3.5222222 0.421816 3.5250000 0.420351 3.5277778 0.420059 3.5305556 0.419180
+ 3.5333333 0.419766 3.5361111 0.420644 3.5388889 0.421523 3.5416667 0.420644
+ 3.5444444 0.419473 3.5472222 0.418887 3.5500000 0.418887 3.5527778 0.420059
+ 3.5555556 0.420937 3.5583333 0.420351 3.5611111 0.419766 3.5638889 0.419180
+ 3.5666667 0.420059 3.5694444 0.420644 3.5722222 0.420937 3.5750000 0.420644
+ 3.5777778 0.419473 3.5805556 0.418887 3.5833333 0.418594 3.5861111 0.418887
+ 3.5888889 0.418887 3.5916667 0.419180 3.5944444 0.418302 3.5972222 0.417423
+ 3.6000000 0.417716 3.6027778 0.418887 3.6055556 0.419180 3.6083333 0.418302
+ 3.6111111 0.418302 3.6138889 0.417130 3.6166667 0.417716 3.6194444 0.418009
+ 3.6222222 0.418887 3.6250000 0.419766 3.6277778 0.419473 3.6305556 0.419180
+ 3.6333333 0.419180 3.6361111 0.418887 3.6388889 0.419766 3.6416667 0.419766
+ 3.6444444 0.418009 3.6472222 0.417716 3.6500000 0.418009 3.6527778 0.418302
+ 3.6555556 0.418302 3.6583333 0.418887 3.6611111 0.418887 3.6638889 0.418009
+ 3.6666667 0.418302 3.6694444 0.418009 3.6722222 0.418302 3.6750000 0.418009
+ 3.6777778 0.418009 3.6805556 0.417716 3.6833333 0.417716 3.6861111 0.419180
+ 3.6888889 0.418302 3.6916667 0.418302 3.6944444 0.418594 3.6972222 0.418302
+ 3.7000000 0.418302 3.7027778 0.418302 3.7055556 0.418302 3.7083333 0.417423
+ 3.7111111 0.417423 3.7138889 0.417130 3.7166667 0.419180 3.7194444 0.419180
+ 3.7222222 0.419473 3.7250000 0.419766 3.7277778 0.419180 3.7305556 0.418594
+ 3.7333333 0.417716 3.7361111 0.418009 3.7388889 0.418009 3.7416667 0.417716
+ 3.7444444 0.417423 3.7472222 0.418302 3.7500000 0.419766 3.7527778 0.420059
+ 3.7555556 0.419766 3.7583333 0.419180 3.7611111 0.418887 3.7638889 0.418887
+ 3.7666667 0.419180 3.7694444 0.419180 3.7722222 0.418887 3.7750000 0.419180
+ 3.7777778 0.419473 3.7805556 0.419473 3.7833333 0.420059 3.7861111 0.421230
+ 3.7888889 0.422108 3.7916667 0.422694 3.7944444 0.422401 3.7972222 0.422108
+ 3.8000000 0.422401 3.8027778 0.423280 3.8055556 0.423865 3.8083333 0.424158
+ 3.8111111 0.424451 3.8138889 0.424451 3.8166667 0.424451 3.8194444 0.424158
+ 3.8222222 0.423865 3.8250000 0.423280 3.8277778 0.422987 3.8305556 0.421816
+ 3.8333333 0.421523 3.8361111 0.421523 3.8388889 0.421816 3.8416667 0.420937
+ 3.8444444 0.420351 3.8472222 0.419766 3.8500000 0.419473 3.8527778 0.419473
+ 3.8555556 0.419180 3.8583333 0.419473 3.8611111 0.419766 3.8638889 0.420059
+ 3.8666667 0.420059 3.8694444 0.420351 3.8722222 0.420937 3.8750000 0.420644
+ 3.8777778 0.420644 3.8805556 0.420644 3.8833333 0.421523 3.8861111 0.421523
+ 3.8888889 0.421230 3.8916667 0.421523 3.8944444 0.421230 3.8972222 0.420644
+ 3.9000000 0.420059 3.9027778 0.419766 3.9055556 0.419180 3.9083333 0.417716
+ 3.9111111 0.418009 3.9138889 0.418887 3.9166667 0.418594 3.9194444 0.418594
+ 3.9222222 0.419473 3.9250000 0.419766 3.9277778 0.420059 3.9305556 0.420351
+ 3.9333333 0.420937 3.9361111 0.420644 3.9388889 0.419766 3.9416667 0.418594
+ 3.9444444 0.418594 3.9472222 0.419180 3.9500000 0.422401 3.9527778 0.427379
+ 3.9555556 0.433236 3.9583333 0.439092 3.9611111 0.444363 3.9638889 0.449634
+ 3.9666667 0.456076 3.9694444 0.463690 3.9722222 0.472474 3.9750000 0.480673
+ 3.9777778 0.487994 3.9805556 0.493851 3.9833333 0.497657 3.9861111 0.497365
+ 3.9888889 0.490630 3.9916667 0.476574 3.9944444 0.451391 3.9972222 0.424451
+ 4.0000000 0.407760 4.0027778 0.400732 4.0055556 0.400439 4.0083333 0.401903
+ 4.0111111 0.405417 4.0138889 0.408346 4.0166667 0.410688 4.0194444 0.410981
+ 4.0222222 0.412445 4.0250000 0.411859 4.0277778 0.411859 4.0305556 0.410395
+ 4.0333333 0.410102 4.0361111 0.410102 4.0388889 0.411567 4.0416667 0.413031
+ 4.0444444 0.412445 4.0472222 0.412152 4.0500000 0.413324 4.0527778 0.414788
+ 4.0555556 0.416252 4.0583333 0.415959 4.0611111 0.415373 4.0638889 0.414202
+ 4.0666667 0.414202 4.0694444 0.414788 4.0722222 0.415081 4.0750000 0.414788
+ 4.0777778 0.413909 4.0805556 0.412445 4.0833333 0.412738 4.0861111 0.414495
+ 4.0888889 0.415666 4.0916667 0.415959 4.0944444 0.415081 4.0972222 0.414788
+ 4.1000000 0.415081 4.1027778 0.415666 4.1055556 0.416252 4.1083333 0.415666
+ 4.1111111 0.415959 4.1138889 0.415666 4.1166667 0.416545 4.1194444 0.416837
+ 4.1222222 0.416545 4.1250000 0.416545 4.1277778 0.416545 4.1305556 0.417130
+ 4.1333333 0.418302 4.1361111 0.417423 4.1388889 0.417423 4.1416667 0.417423
+ 4.1444444 0.417423 4.1472222 0.416837 4.1500000 0.417130 4.1527778 0.417716
+ 4.1555556 0.417423 4.1583333 0.417423 4.1611111 0.417130 4.1638889 0.416545
+ 4.1666667 0.417423 4.1694444 0.417130 4.1722222 0.416252 4.1750000 0.417130
+ 4.1777778 0.417716 4.1805556 0.418594 4.1833333 0.419180 4.1861111 0.419180
+ 4.1888889 0.418887 4.1916667 0.419473 4.1944444 0.419766 4.1972222 0.420351
+ 4.2000000 0.420937 4.2027778 0.420644 4.2055556 0.420351 4.2083333 0.419473
+ 4.2111111 0.420059 4.2138889 0.419473 4.2166667 0.420059 4.2194444 0.420351
+ 4.2222222 0.421523 4.2250000 0.420937 4.2277778 0.420937 4.2305556 0.420937
+ 4.2333333 0.422108 4.2361111 0.423572 4.2388889 0.424158 4.2416667 0.423865
+ 4.2444444 0.422987 4.2472222 0.422987 4.2500000 0.423865 4.2527778 0.424451
+ 4.2555556 0.425037 4.2583333 0.425037 4.2611111 0.424158 4.2638889 0.424744
+ 4.2666667 0.425915 4.2694444 0.426208 4.2722222 0.425915 4.2750000 0.424744
+ 4.2777778 0.424451 4.2805556 0.424158 4.2833333 0.424158 4.2861111 0.424158
+ 4.2888889 0.425037 4.2916667 0.425037 4.2944444 0.425915 4.2972222 0.426208
+ 4.3000000 0.425037 4.3027778 0.425329 4.3055556 0.425915 4.3083333 0.425915
+ 4.3111111 0.424744 4.3138889 0.423865 4.3166667 0.423865 4.3194444 0.424158
+ 4.3222222 0.424158 4.3250000 0.424451 4.3277778 0.422987 4.3305556 0.422694
+ 4.3333333 0.422694 4.3361111 0.423280 4.3388889 0.423865 4.3416667 0.423280
+ 4.3444444 0.422401 4.3472222 0.422108 4.3500000 0.422987 4.3527778 0.423280
+ 4.3555556 0.423572 4.3583333 0.422694 4.3611111 0.421523 4.3638889 0.421230
+ 4.3666667 0.421816 4.3694444 0.422987 4.3722222 0.422987 4.3750000 0.422987
+ 4.3777778 0.422401 4.3805556 0.421230 4.3833333 0.422108 4.3861111 0.421816
+ 4.3888889 0.421816 4.3916667 0.422694 4.3944444 0.423280 4.3972222 0.423865
+ 4.4000000 0.425915 4.4027778 0.428258 4.4055556 0.429429 4.4083333 0.430893
+ 4.4111111 0.432064 4.4138889 0.432357 4.4166667 0.434114 4.4194444 0.435871
+ 4.4222222 0.436750 4.4250000 0.437335 4.4277778 0.436750 4.4305556 0.437628
+ 4.4333333 0.440264 4.4361111 0.441435 4.4388889 0.440849 4.4416667 0.437628
+ 4.4444444 0.430893 4.4472222 0.418302 4.4500000 0.398389 4.4527778 0.375842
+ 4.4555556 0.353880 4.4583333 0.333089 4.4611111 0.316398 4.4638889 0.307906
+ 4.4666667 0.307321 4.4694444 0.307906 4.4722222 0.309956 4.4750000 0.310835
+ 4.4777778 0.314348 4.4805556 0.318155 4.4833333 0.324012 4.4861111 0.330747
+ 4.4888889 0.336018 4.4916667 0.341581 4.4944444 0.348902 4.4972222 0.356808
+ 4.5000000 0.362958 4.5027778 0.367643 4.5055556 0.371742 4.5083333 0.375842
+ 4.5111111 0.379649 4.5138889 0.383748 4.5166667 0.387555 4.5194444 0.391069
+ 4.5222222 0.393704 4.5250000 0.395168 4.5277778 0.398682 4.5305556 0.401903
+ 4.5333333 0.405417 4.5361111 0.408638 4.5388889 0.411859 4.5416667 0.415373
+ 4.5444444 0.419766 4.5472222 0.422987 4.5500000 0.426794 4.5527778 0.430893
+ 4.5555556 0.433529 4.5583333 0.436750 4.5611111 0.439385 4.5638889 0.440264
+ 4.5666667 0.442899 4.5694444 0.444070 4.5722222 0.445242 4.5750000 0.446999
+ 4.5777778 0.448170 4.5805556 0.448755 4.5833333 0.449634 4.5861111 0.450805
+ 4.5888889 0.452562 4.5916667 0.453441 4.5944444 0.454319 4.5972222 0.454026
+ 4.6000000 0.455198 4.6027778 0.456076 4.6055556 0.457833 4.6083333 0.459004
+ 4.6111111 0.459883 4.6138889 0.461054 4.6166667 0.462811 4.6194444 0.464275
+ 4.6222222 0.464861 4.6250000 0.466618 4.6277778 0.467496 4.6305556 0.468668
+ 4.6333333 0.469546 4.6361111 0.471596 4.6388889 0.472182 4.6416667 0.472767
+ 4.6444444 0.472474 4.6472222 0.473060 4.6500000 0.474817 4.6527778 0.475695
+ 4.6555556 0.476574 4.6583333 0.477160 4.6611111 0.477160 4.6638889 0.477160
+ 4.6666667 0.478038 4.6694444 0.479209 4.6722222 0.480088 4.6750000 0.478624
+ 4.6777778 0.478624 4.6805556 0.477160 4.6833333 0.477160 4.6861111 0.478038
+ 4.6888889 0.478038 4.6916667 0.478038 4.6944444 0.475988 4.6972222 0.474231
+ 4.7000000 0.473939 4.7027778 0.473939 4.7055556 0.473353 4.7083333 0.471596
+ 4.7111111 0.469253 4.7138889 0.466325 4.7166667 0.463690 4.7194444 0.461347
+ 4.7222222 0.459590 4.7250000 0.458419 4.7277778 0.456369 4.7305556 0.455490
+ 4.7333333 0.454319 4.7361111 0.453734 4.7388889 0.452562 4.7416667 0.451098
+ 4.7444444 0.448755 4.7472222 0.446706 4.7500000 0.444949 4.7527778 0.443777
+ 4.7555556 0.442899 4.7583333 0.441142 4.7611111 0.439385 4.7638889 0.437921
+ 4.7666667 0.437921 4.7694444 0.437921 4.7722222 0.437042 4.7750000 0.436164
+ 4.7777778 0.434700 4.7805556 0.433529 4.7833333 0.432357 4.7861111 0.432357
+ 4.7888889 0.432357 4.7916667 0.431186 4.7944444 0.431186 4.7972222 0.430600
+ 4.8000000 0.430307 4.8027778 0.430600 4.8055556 0.430600 4.8083333 0.430015
+ 4.8111111 0.428258 4.8138889 0.427672 4.8166667 0.428551 4.8194444 0.428258
+ 4.8222222 0.429136 4.8250000 0.428258 4.8277778 0.427379 4.8305556 0.427086
+ 4.8333333 0.427086 4.8361111 0.428843 4.8388889 0.429136 4.8416667 0.428551
+ 4.8444444 0.426794 4.8472222 0.426208 4.8500000 0.426208 4.8527778 0.427086
+ 4.8555556 0.427672 4.8583333 0.427965 4.8611111 0.427379 4.8638889 0.426501
+ 4.8666667 0.427965 4.8694444 0.427672 4.8722222 0.427672 4.8750000 0.427379
+ 4.8777778 0.425915 4.8805556 0.425329 4.8833333 0.425915 4.8861111 0.426794
+ 4.8888889 0.427672 4.8916667 0.427086 4.8944444 0.427086 4.8972222 0.426208
+ 4.9000000 0.425622 4.9027778 0.426501 4.9055556 0.426794 4.9083333 0.425915
+ 4.9111111 0.425037 4.9138889 0.423865 4.9166667 0.422987 4.9194444 0.423280
+ 4.9222222 0.423572 4.9250000 0.424451 4.9277778 0.425037 4.9305556 0.424744
+ 4.9333333 0.425915 4.9361111 0.425037 4.9388889 0.425329 4.9416667 0.424744
+ 4.9444444 0.423865 4.9472222 0.423572 4.9500000 0.423865 4.9527778 0.424158
+ 4.9555556 0.423865 4.9583333 0.423572 4.9611111 0.422987 4.9638889 0.422401
+ 4.9666667 0.422987 4.9694444 0.423280 4.9722222 0.423280 4.9750000 0.423280
+ 4.9777778 0.423572 4.9805556 0.422987 4.9833333 0.422987 4.9861111 0.422987
+ 4.9888889 0.423865 4.9916667 0.423572 4.9944444 0.423280 4.9972222 0.421816
+ 5.0000000 0.422108 5.0027778 0.422694 5.0055556 0.423280 5.0083333 0.423865
+ 5.0111111 0.422694 5.0138889 0.421816 5.0166667 0.422401 5.0194444 0.422987
+ 5.0222222 0.422694 5.0250000 0.422694 5.0277778 0.422987 5.0305556 0.423280
+ 5.0333333 0.423865 5.0361111 0.424451 5.0388889 0.425622 5.0416667 0.426208
+ 5.0444444 0.426794 5.0472222 0.427086 5.0500000 0.427379 5.0527778 0.427086
+ 5.0555556 0.426794 5.0583333 0.425329 5.0611111 0.423572 5.0638889 0.422401
+ 5.0666667 0.422694 5.0694444 0.422401 5.0722222 0.422401 5.0750000 0.422401
+ 5.0777778 0.421816 5.0805556 0.421816 5.0833333 0.422401 5.0861111 0.422108
+ 5.0888889 0.421816 5.0916667 0.421523 5.0944444 0.421230 5.0972222 0.420644
+ 5.1000000 0.422108 5.1027778 0.422108 5.1055556 0.422694 5.1083333 0.424158
+ 5.1111111 0.424158 5.1138889 0.423280 5.1166667 0.423280 5.1194444 0.423280
+ 5.1222222 0.422987 5.1250000 0.422108 5.1277778 0.421230 5.1305556 0.420351
+ 5.1333333 0.420351 5.1361111 0.420644 5.1388889 0.421230 5.1416667 0.420644
+ 5.1444444 0.420059 5.1472222 0.419473 5.1500000 0.420059 5.1527778 0.420059
+ 5.1555556 0.420351 5.1583333 0.420351 5.1611111 0.420644 5.1638889 0.420644
+ 5.1666667 0.421523 5.1694444 0.421523 5.1722222 0.421523 5.1750000 0.421230
+ 5.1777778 0.420351 5.1805556 0.420059 5.1833333 0.419766 5.1861111 0.419473
+ 5.1888889 0.417716 5.1916667 0.417130 5.1944444 0.418594 5.1972222 0.420937
+ 5.2000000 0.424451 5.2027778 0.430600 5.2055556 0.437921 5.2083333 0.443777
+ 5.2111111 0.449048 5.2138889 0.453441 5.2166667 0.459297 5.2194444 0.466325
+ 5.2222222 0.473060 5.2250000 0.479795 5.2277778 0.484773 5.2305556 0.487701
+ 5.2333333 0.487408 5.2361111 0.481845 5.2388889 0.474817 5.2416667 0.464275
+ 5.2444444 0.449048 5.2472222 0.430893 5.2500000 0.416545 5.2527778 0.408638
+ 5.2555556 0.404832 5.2583333 0.403660 5.2611111 0.405124 5.2638889 0.407467
+ 5.2666667 0.409810 5.2694444 0.411859 5.2722222 0.412445 5.2750000 0.413909
+ 5.2777778 0.413909 5.2805556 0.413031 5.2833333 0.411859 5.2861111 0.411274
+ 5.2888889 0.410395 5.2916667 0.410102 5.2944444 0.410102 5.2972222 0.410102
+ 5.3000000 0.411274 5.3027778 0.412152 5.3055556 0.413616 5.3083333 0.414202
+ 5.3111111 0.413616 5.3138889 0.412738 5.3166667 0.412738 5.3194444 0.413031
+ 5.3222222 0.413031 5.3250000 0.413324 5.3277778 0.412152 5.3305556 0.412738
+ 5.3333333 0.412738 5.3361111 0.412445 5.3388889 0.413616 5.3416667 0.413324
+ 5.3444444 0.413324 5.3472222 0.413324 5.3500000 0.414202 5.3527778 0.414495
+ 5.3555556 0.414202 5.3583333 0.413909 5.3611111 0.413909 5.3638889 0.414495
+ 5.3666667 0.414788 5.3694444 0.415081 5.3722222 0.415666 5.3750000 0.415081
+ 5.3777778 0.414788 5.3805556 0.414202 5.3833333 0.414788 5.3861111 0.416252
+ 5.3888889 0.416252 5.3916667 0.415959 5.3944444 0.415959 5.3972222 0.415373
+ 5.4000000 0.415081 5.4027778 0.415959 5.4055556 0.415373 5.4083333 0.415666
+ 5.4111111 0.415081 5.4138889 0.414788 5.4166667 0.415666 5.4194444 0.417130
+ 5.4222222 0.418009 5.4250000 0.419180 5.4277778 0.418302 5.4305556 0.416837
+ 5.4333333 0.416545 5.4361111 0.417130 5.4388889 0.416837 5.4416667 0.418594
+ 5.4444444 0.418009 5.4472222 0.417716 5.4500000 0.418302 5.4527778 0.418302
+ 5.4555556 0.419180 5.4583333 0.419473 5.4611111 0.418594 5.4638889 0.418594
+ 5.4666667 0.419180 5.4694444 0.419473 5.4722222 0.418594 5.4750000 0.417716
+ 5.4777778 0.418302 5.4805556 0.418887 5.4833333 0.421523 5.4861111 0.422108
+ 5.4888889 0.422987 5.4916667 0.422401 5.4944444 0.421230 5.4972222 0.420351
+ 5.5000000 0.420644 5.5027778 0.419766 5.5055556 0.420059 5.5083333 0.421230
+ 5.5111111 0.420644 5.5138889 0.420351 5.5166667 0.421816 5.5194444 0.422108
+ 5.5222222 0.422108 5.5250000 0.421816 5.5277778 0.421230 5.5305556 0.420351
+ 5.5333333 0.421230 5.5361111 0.421523 5.5388889 0.422987 5.5416667 0.422108
+ 5.5444444 0.420644 5.5472222 0.419473 5.5500000 0.419473 5.5527778 0.420644
+ 5.5555556 0.421230 5.5583333 0.422401 5.5611111 0.422108 5.5638889 0.421523
+ 5.5666667 0.421816 5.5694444 0.421816 5.5722222 0.422401 5.5750000 0.422401
+ 5.5777778 0.422401 5.5805556 0.419180 5.5833333 0.420351 5.5861111 0.419766
+ 5.5888889 0.419180 5.5916667 0.419180 5.5944444 0.419473 5.5972222 0.419766
+ 5.6000000 0.420937 5.6027778 0.420937 5.6055556 0.420937 5.6083333 0.419766
+ 5.6111111 0.418594 5.6138889 0.419473 5.6166667 0.420059 5.6194444 0.421816
+ 5.6222222 0.421230 5.6250000 0.421816 5.6277778 0.420937 5.6305556 0.419766
+ 5.6333333 0.420059 5.6361111 0.420059 5.6388889 0.420059 5.6416667 0.419180
+ 5.6444444 0.418302 5.6472222 0.417130 5.6500000 0.417716 5.6527778 0.418302
+ 5.6555556 0.418887 5.6583333 0.419473 5.6611111 0.417716 5.6638889 0.416545
+ 5.6666667 0.416837 5.6694444 0.416252 5.6722222 0.417130 5.6750000 0.417423
+ 5.6777778 0.417716 5.6805556 0.417716 5.6833333 0.418594 5.6861111 0.419473
+ 5.6888889 0.420059 5.6916667 0.420059 5.6944444 0.420351 5.6972222 0.420059
+ 5.7000000 0.421230 5.7027778 0.422108 5.7055556 0.423280 5.7083333 0.427672
+ 5.7111111 0.433236 5.7138889 0.437335 5.7166667 0.439385 5.7194444 0.439092
+ 5.7222222 0.438214 5.7250000 0.437628 5.7277778 0.433529 5.7305556 0.425915
+ 5.7333333 0.409224 5.7361111 0.386091 5.7388889 0.363543 5.7416667 0.347438
+ 5.7444444 0.336018 5.7472222 0.328697 5.7500000 0.324305 5.7527778 0.320791
+ 5.7555556 0.320205 5.7583333 0.321669 5.7611111 0.322548 5.7638889 0.323426
+ 5.7666667 0.328404 5.7694444 0.338067 5.7722222 0.347731 5.7750000 0.355930
+ 5.7777778 0.361493 5.7805556 0.365007 5.7833333 0.370864 5.7861111 0.376135
+ 5.7888889 0.379063 5.7916667 0.380527 5.7944444 0.381991 5.7972222 0.384041
+ 5.8000000 0.386091 5.8027778 0.389898 5.8055556 0.393119 5.8083333 0.397804
+ 5.8111111 0.398682 5.8138889 0.400732 5.8166667 0.403367 5.8194444 0.406881
+ 5.8222222 0.411274 5.8250000 0.415959 5.8277778 0.419473 5.8305556 0.422987
+ 5.8333333 0.426501 5.8361111 0.429722 5.8388889 0.432357 5.8416667 0.434407
+ 5.8444444 0.435578 5.8472222 0.435871 5.8500000 0.437042 5.8527778 0.437921
+ 5.8555556 0.438507 5.8583333 0.438507 5.8611111 0.439092 5.8638889 0.442020
+ 5.8666667 0.443777 5.8694444 0.444949 5.8722222 0.445827 5.8750000 0.445827
+ 5.8777778 0.445534 5.8805556 0.445534 5.8833333 0.446999 5.8861111 0.448755
+ 5.8888889 0.450512 5.8916667 0.451684 5.8944444 0.452855 5.8972222 0.452562
+ 5.9000000 0.454026 5.9027778 0.455783 5.9055556 0.456662 5.9083333 0.457833
+ 5.9111111 0.457247 5.9138889 0.457247 5.9166667 0.457833 5.9194444 0.458712
+ 5.9222222 0.459590 5.9250000 0.461347 5.9277778 0.462811 5.9305556 0.463104
+ 5.9333333 0.463104 5.9361111 0.464275 5.9388889 0.465154 5.9416667 0.465447
+ 5.9444444 0.464861 5.9472222 0.463104 5.9500000 0.463397 5.9527778 0.463397
+ 5.9555556 0.462811 5.9583333 0.462225 5.9611111 0.460469 5.9638889 0.459004
+ 5.9666667 0.459297 5.9694444 0.459004 5.9722222 0.458126 5.9750000 0.457833
+ 5.9777778 0.455490 5.9805556 0.453148 5.9833333 0.452562 5.9861111 0.452269
+ 5.9888889 0.451977 5.9916667 0.450220 5.9944444 0.447584 5.9972222 0.444363
+ 6.0000000 0.441435 6.0027778 0.439971 6.0055556 0.437921 6.0083333 0.437921
+ 6.0111111 0.435871 6.0138889 0.434700 6.0166667 0.432943 6.0194444 0.432943
+ 6.0222222 0.431479 6.0250000 0.430015 6.0277778 0.428843 6.0305556 0.427965
+ 6.0333333 0.428551 6.0361111 0.428843 6.0388889 0.428843 6.0416667 0.427965
+ 6.0444444 0.426501 6.0472222 0.426794 6.0500000 0.426501 6.0527778 0.425915
+ 6.0555556 0.425329 6.0583333 0.423865 6.0611111 0.423280 6.0638889 0.422108
+ 6.0666667 0.422401 6.0694444 0.423572 6.0722222 0.423280 6.0750000 0.422987
+ 6.0777778 0.421523 6.0805556 0.419766 6.0833333 0.419473 6.0861111 0.421523
+ 6.0888889 0.421816 6.0916667 0.422694 6.0944444 0.421816 6.0972222 0.421816
+ 6.1000000 0.422108 6.1027778 0.422987 6.1055556 0.424451 6.1083333 0.423865
+ 6.1111111 0.423865 6.1138889 0.423572 6.1166667 0.424744 6.1194444 0.425329
+ 6.1222222 0.424451 6.1250000 0.424158 6.1277778 0.423865 6.1305556 0.423865
+ 6.1333333 0.423865 6.1361111 0.424158 6.1388889 0.422987 6.1416667 0.423572
+ 6.1444444 0.423280 6.1472222 0.422987 6.1500000 0.423280 6.1527778 0.421816
+ 6.1555556 0.421816 6.1583333 0.422694 6.1611111 0.422401 6.1638889 0.421816
+ 6.1666667 0.420644 6.1694444 0.420937 6.1722222 0.421523 6.1750000 0.421523
+ 6.1777778 0.420937 6.1805556 0.419180 6.1833333 0.419766 6.1861111 0.420937
+ 6.1888889 0.422987 6.1916667 0.423572 6.1944444 0.422108 6.1972222 0.421230
+ 6.2000000 0.420351 6.2027778 0.420937 6.2055556 0.421816 6.2083333 0.422108
+ 6.2111111 0.422401 6.2138889 0.421230 6.2166667 0.422987 6.2194444 0.423865
+ 6.2222222 0.424451 6.2250000 0.424158 6.2277778 0.423865 6.2305556 0.422401
+ 6.2333333 0.422987 6.2361111 0.424451 6.2388889 0.425037 6.2416667 0.422694
+ 6.2444444 0.420644 6.2472222 0.419180 6.2500000 0.419766 6.2527778 0.421230
+ 6.2555556 0.422401 6.2583333 0.422108 6.2611111 0.421523 6.2638889 0.421523
+ 6.2666667 0.423280 6.2694444 0.423572 6.2722222 0.424451 6.2750000 0.424744
+ 6.2777778 0.425037 6.2805556 0.424451 6.2833333 0.425329 6.2861111 0.426501
+ 6.2888889 0.427086 6.2916667 0.427672 6.2944444 0.427672 6.2972222 0.426794
+ 6.3000000 0.427086 6.3027778 0.427379 6.3055556 0.425915 6.3083333 0.425329
+ 6.3111111 0.424744 6.3138889 0.423280 6.3166667 0.424451 6.3194444 0.424451
+ 6.3222222 0.425037 6.3250000 0.424158 6.3277778 0.423280 6.3305556 0.422108
+ 6.3333333 0.423572 6.3361111 0.422694 6.3388889 0.422694 6.3416667 0.422987
+ 6.3444444 0.421523 6.3472222 0.419766 6.3500000 0.420059 6.3527778 0.422108
+ 6.3555556 0.423865 6.3583333 0.423572 6.3611111 0.422401 6.3638889 0.421816
+ 6.3666667 0.423572 6.3694444 0.423572 6.3722222 0.424451 6.3750000 0.423280
+ 6.3777778 0.422401 6.3805556 0.420937 6.3833333 0.421523 6.3861111 0.421523
+ 6.3888889 0.422401 6.3916667 0.422401 6.3944444 0.421816 6.3972222 0.421523
+ 6.4000000 0.421523 6.4027778 0.420937 6.4055556 0.420059 6.4083333 0.420059
+ 6.4111111 0.420644 6.4138889 0.422108 6.4166667 0.422694 6.4194444 0.422694
+ 6.4222222 0.421523 6.4250000 0.420059 6.4277778 0.418302 6.4305556 0.418009
+ 6.4333333 0.418009 6.4361111 0.418302 6.4388889 0.419766 6.4416667 0.421523
+ 6.4444444 0.425037 6.4472222 0.429429 6.4500000 0.434407 6.4527778 0.440849
+ 6.4555556 0.446120 6.4583333 0.451391 6.4611111 0.458126 6.4638889 0.464861
+ 6.4666667 0.473060 6.4694444 0.480966 6.4722222 0.488873 6.4750000 0.496486
+ 6.4777778 0.500000 6.4805556 0.499414 6.4833333 0.494729 6.4861111 0.486237
+ 6.4888889 0.471010 6.4916667 0.444949 6.4944444 0.421523 6.4972222 0.408638
+ 6.5000000 0.404246 6.5027778 0.403660 6.5055556 0.405417 6.5083333 0.407760
+ 6.5111111 0.410688 6.5138889 0.411859 6.5166667 0.412445 6.5194444 0.412445
+ 6.5222222 0.412445 6.5250000 0.411567 6.5277778 0.409810 6.5305556 0.409517
+ 6.5333333 0.410395 6.5361111 0.410981 6.5388889 0.410688 6.5416667 0.411274
+ 6.5444444 0.411567 6.5472222 0.410688 6.5500000 0.412738 6.5527778 0.413909
+ 6.5555556 0.414495 6.5583333 0.415081 6.5611111 0.414202 6.5638889 0.413616
+ 6.5666667 0.414495 6.5694444 0.415373 6.5722222 0.416252 6.5750000 0.416252
+ 6.5777778 0.416837 6.5805556 0.416252 6.5833333 0.415666 6.5861111 0.415959
+ 6.5888889 0.416252 6.5916667 0.416837 6.5944444 0.416545 6.5972222 0.416837
+ 6.6000000 0.417716 6.6027778 0.417423 6.6055556 0.416837 6.6083333 0.416252
+ 6.6111111 0.414788 6.6138889 0.414202 6.6166667 0.414788 6.6194444 0.416545
+ 6.6222222 0.417423 6.6250000 0.417130 6.6277778 0.416837 6.6305556 0.416252
+ 6.6333333 0.418009 6.6361111 0.418594 6.6388889 0.417130 6.6416667 0.415373
+ 6.6444444 0.414495 6.6472222 0.413909 6.6500000 0.414495 6.6527778 0.415666
+ 6.6555556 0.416837 6.6583333 0.418009 6.6611111 0.418302 6.6638889 0.418594
+ 6.6666667 0.418594 6.6694444 0.419473 6.6722222 0.420644 6.6750000 0.420059
+ 6.6777778 0.419180 6.6805556 0.417423 6.6833333 0.418594 6.6861111 0.419473
+ 6.6888889 0.420351 6.6916667 0.420644 6.6944444 0.420644 6.6972222 0.420059
+ 6.7000000 0.418594 6.7027778 0.417716 6.7055556 0.417716 6.7083333 0.418594
+ 6.7111111 0.419766 6.7138889 0.420059 6.7166667 0.420644 6.7194444 0.420937
+ 6.7222222 0.421816 6.7250000 0.421523 6.7277778 0.421816 6.7305556 0.421523
+ 6.7333333 0.423280 6.7361111 0.424158 6.7388889 0.425329 6.7416667 0.423865
+ 6.7444444 0.421523 6.7472222 0.418594 6.7500000 0.419180 6.7527778 0.420937
+ 6.7555556 0.423280 6.7583333 0.423865 6.7611111 0.425037 6.7638889 0.425037
+ 6.7666667 0.425329 6.7694444 0.425329 6.7722222 0.425037 6.7750000 0.424451
+ 6.7777778 0.424451 6.7805556 0.423572 6.7833333 0.424451 6.7861111 0.425037
+ 6.7888889 0.425329 6.7916667 0.426208 6.7944444 0.426501 6.7972222 0.426208
+ 6.8000000 0.425329 6.8027778 0.424158 6.8055556 0.424451 6.8083333 0.423572
+ 6.8111111 0.423572 6.8138889 0.422694 6.8166667 0.422987 6.8194444 0.423572
+ 6.8222222 0.422694 6.8250000 0.421523 6.8277778 0.421523 6.8305556 0.420937
+ 6.8333333 0.421230 6.8361111 0.421230 6.8388889 0.420644 6.8416667 0.420059
+ 6.8444444 0.418887 6.8472222 0.418887 6.8500000 0.420351 6.8527778 0.421816
+ 6.8555556 0.421523 6.8583333 0.422108 6.8611111 0.422108 6.8638889 0.421230
+ 6.8666667 0.421230 6.8694444 0.418887 6.8722222 0.416252 6.8750000 0.415081
+ 6.8777778 0.415373 6.8805556 0.416252 6.8833333 0.417716 6.8861111 0.419766
+ 6.8888889 0.421816 6.8916667 0.421523 6.8944444 0.422401 6.8972222 0.422401
+ 6.9000000 0.424744 6.9027778 0.426501 6.9055556 0.428551 6.9083333 0.429722
+ 6.9111111 0.429136 6.9138889 0.429722 6.9166667 0.430600 6.9194444 0.430893
+ 6.9222222 0.432357 6.9250000 0.433529 6.9277778 0.432943 6.9305556 0.430600
+ 6.9333333 0.427379 6.9361111 0.420937 6.9388889 0.406296 6.9416667 0.383455
+ 6.9444444 0.358565 6.9472222 0.336603 6.9500000 0.318448 6.9527778 0.307613
+ 6.9555556 0.304978 6.9583333 0.304978 6.9611111 0.306149 6.9638889 0.307613
+ 6.9666667 0.311127 6.9694444 0.316105 6.9722222 0.322255 6.9750000 0.328697
+ 6.9777778 0.335139 6.9805556 0.341874 6.9833333 0.350659 6.9861111 0.361493
+ 6.9888889 0.368814 6.9916667 0.373499 6.9944444 0.376720 6.9972222 0.379649
+ 7.0000000 0.382870 7.0027778 0.386969 7.0055556 0.390776 7.0083333 0.393119
+ 7.0111111 0.395168 7.0138889 0.397804 7.0166667 0.401903 7.0194444 0.405710
+ 7.0222222 0.408931 7.0250000 0.412152 7.0277778 0.417716 7.0305556 0.422694
+ 7.0333333 0.427086 7.0361111 0.430600 7.0388889 0.434700 7.0416667 0.437921
+ 7.0444444 0.440556 7.0472222 0.441728 7.0500000 0.442606 7.0527778 0.444949
+ 7.0555556 0.446413 7.0583333 0.448463 7.0611111 0.448463 7.0638889 0.449048
+ 7.0666667 0.450805 7.0694444 0.451098 7.0722222 0.452269 7.0750000 0.453148
+ 7.0777778 0.454612 7.0805556 0.454905 7.0833333 0.455783 7.0861111 0.457247
+ 7.0888889 0.459590 7.0916667 0.461347 7.0944444 0.461933 7.0972222 0.462518
+ 7.1000000 0.464861 7.1027778 0.467496 7.1055556 0.468960 7.1083333 0.469253
+ 7.1111111 0.469253 7.1138889 0.470132 7.1166667 0.470717 7.1194444 0.472767
+ 7.1222222 0.473939 7.1250000 0.474524 7.1277778 0.474524 7.1305556 0.474231
+ 7.1333333 0.474524 7.1361111 0.475403 7.1388889 0.475403 7.1416667 0.476574
+ 7.1444444 0.475695 7.1472222 0.475110 7.1500000 0.475695 7.1527778 0.476867
+ 7.1555556 0.477452 7.1583333 0.476281 7.1611111 0.475110 7.1638889 0.473939
+ 7.1666667 0.473353 7.1694444 0.472767 7.1722222 0.472182 7.1750000 0.471010
+ 7.1777778 0.469546 7.1805556 0.467496 7.1833333 0.466032 7.1861111 0.464275
+ 7.1888889 0.461347 7.1916667 0.459004 7.1944444 0.458126 7.1972222 0.456955
+ 7.2000000 0.455490 7.2027778 0.454612 7.2055556 0.453734 7.2083333 0.453148
+ 7.2111111 0.450805 7.2138889 0.448755 7.2166667 0.446999 7.2194444 0.446413
+ 7.2222222 0.445827 7.2250000 0.444949 7.2277778 0.443777 7.2305556 0.442899
+ 7.2333333 0.441728 7.2361111 0.441142 7.2388889 0.439678 7.2416667 0.439092
+ 7.2444444 0.437628 7.2472222 0.435578 7.2500000 0.434700 7.2527778 0.432943
+ 7.2555556 0.431479 7.2583333 0.430307 7.2611111 0.430015 7.2638889 0.429722
+ 7.2666667 0.429722 7.2694444 0.430600 7.2722222 0.430015 7.2750000 0.430600
+ 7.2777778 0.430015 7.2805556 0.429429 7.2833333 0.429429 7.2861111 0.429136
+ 7.2888889 0.428551 7.2916667 0.428551 7.2944444 0.428551 7.2972222 0.428258
+ 7.3000000 0.427672 7.3027778 0.426208 7.3055556 0.426208 7.3083333 0.426208
+ 7.3111111 0.425622 7.3138889 0.426208 7.3166667 0.427379 7.3194444 0.427379
+ 7.3222222 0.426794 7.3250000 0.427086 7.3277778 0.425915 7.3305556 0.425329
+ 7.3333333 0.425329 7.3361111 0.425329 7.3388889 0.426208 7.3416667 0.425915
+ 7.3444444 0.425622 7.3472222 0.424451 7.3500000 0.424158 7.3527778 0.425037
+ 7.3555556 0.425329 7.3583333 0.425915 7.3611111 0.424744 7.3638889 0.424158
+ 7.3666667 0.423280 7.3694444 0.423280 7.3722222 0.423280 7.3750000 0.422987
+ 7.3777778 0.422108 7.3805556 0.420937 7.3833333 0.421816 7.3861111 0.422401
+ 7.3888889 0.423280 7.3916667 0.424158 7.3944444 0.424744 7.3972222 0.424158
+ 7.4000000 0.422987 7.4027778 0.422108 7.4055556 0.421230 7.4083333 0.420059
+ 7.4111111 0.420644 7.4138889 0.421816 7.4166667 0.422401 7.4194444 0.421816
+ 7.4222222 0.422401 7.4250000 0.421523 7.4277778 0.421816 7.4305556 0.420937
+ 7.4333333 0.421523 7.4361111 0.421816 7.4388889 0.422108 7.4416667 0.421523
+ 7.4444444 0.420644 7.4472222 0.419180 7.4500000 0.419180 7.4527778 0.420351
+ 7.4555556 0.421523 7.4583333 0.421230 7.4611111 0.420937 7.4638889 0.421523
+ 7.4666667 0.422401 7.4694444 0.422401 7.4722222 0.421230 7.4750000 0.420059
+ 7.4777778 0.419473 7.4805556 0.419180 7.4833333 0.420644 7.4861111 0.421523
+ 7.4888889 0.421816 7.4916667 0.420059 7.4944444 0.419766 7.4972222 0.420059
+ 7.5000000 0.420937 7.5027778 0.420351 7.5055556 0.419766 7.5083333 0.420351
+ 7.5111111 0.420937 7.5138889 0.420644 7.5166667 0.420059 7.5194444 0.419766
+ 7.5222222 0.419766 7.5250000 0.420351 7.5277778 0.420937 7.5305556 0.420351
+ 7.5333333 0.421816 7.5361111 0.422694 7.5388889 0.422987 7.5416667 0.424744
+ 7.5444444 0.424744 7.5472222 0.424451 7.5500000 0.425037 7.5527778 0.423865
+ 7.5555556 0.423280 7.5583333 0.421523 7.5611111 0.420644 7.5638889 0.420059
+ 7.5666667 0.420351 7.5694444 0.420937 7.5722222 0.421230 7.5750000 0.421230
+ 7.5777778 0.421523 7.5805556 0.421523 7.5833333 0.422401 7.5861111 0.421816
+ 7.5888889 0.421816 7.5916667 0.421523 7.5944444 0.421816 7.5972222 0.421230
+ 7.6000000 0.419473 7.6027778 0.417423 7.6055556 0.417130 7.6083333 0.416545
+ 7.6111111 0.416837 7.6138889 0.418302 7.6166667 0.418887 7.6194444 0.420351
+ 7.6222222 0.420059 7.6250000 0.418302 7.6277778 0.417130 7.6305556 0.416837
+ 7.6333333 0.416545 7.6361111 0.417423 7.6388889 0.417130 7.6416667 0.416837
+ 7.6444444 0.416252 7.6472222 0.416837 7.6500000 0.417423 7.6527778 0.418594
+ 7.6555556 0.418009 7.6583333 0.417130 7.6611111 0.417130 7.6638889 0.416545
+ 7.6666667 0.417423 7.6694444 0.418887 7.6722222 0.418887 7.6750000 0.418009
+ 7.6777778 0.418302 7.6805556 0.417130 7.6833333 0.416545 7.6861111 0.415959
+ 7.6888889 0.415666 7.6916667 0.415373 7.6944444 0.415081 7.6972222 0.415373
+ 7.7000000 0.417423 7.7027778 0.420644 7.7055556 0.425329 7.7083333 0.429429
+ 7.7111111 0.433236 7.7138889 0.437628 7.7166667 0.442899 7.7194444 0.447877
+ 7.7222222 0.454026 7.7250000 0.460469 7.7277778 0.467204 7.7305556 0.473646
+ 7.7333333 0.478624 7.7361111 0.482138 7.7388889 0.482430 7.7416667 0.478917
+ 7.7444444 0.472474 7.7472222 0.462518 7.7500000 0.448755 7.7527778 0.433236
+ 7.7555556 0.419766 7.7583333 0.409517 7.7611111 0.403367 7.7638889 0.399854
+ 7.7666667 0.400732 7.7694444 0.403953 7.7722222 0.406003 7.7750000 0.406589
+ 7.7777778 0.407174 7.7805556 0.406296 7.7833333 0.407174 7.7861111 0.408053
+ 7.7888889 0.408931 7.7916667 0.408931 7.7944444 0.408638 7.7972222 0.407760
+ 7.8000000 0.408638 7.8027778 0.409224 7.8055556 0.409810 7.8083333 0.410395
+ 7.8111111 0.409224 7.8138889 0.408346 7.8166667 0.408638 7.8194444 0.410981
+ 7.8222222 0.412738 7.8250000 0.413616 7.8277778 0.412738 7.8305556 0.412445
+ 7.8333333 0.412445 7.8361111 0.412738 7.8388889 0.412445 7.8416667 0.412738
+ 7.8444444 0.412152 7.8472222 0.411859 7.8500000 0.412152 7.8527778 0.412738
+ 7.8555556 0.413031 7.8583333 0.413616 7.8611111 0.413031 7.8638889 0.412738
+ 7.8666667 0.413031 7.8694444 0.413031 7.8722222 0.413616 7.8750000 0.414202
+ 7.8777778 0.414495 7.8805556 0.414495 7.8833333 0.414202 7.8861111 0.414202
+ 7.8888889 0.415081 7.8916667 0.414788 7.8944444 0.413909 7.8972222 0.413616
+ 7.9000000 0.413031 7.9027778 0.413909 7.9055556 0.413616 7.9083333 0.413616
+ 7.9111111 0.413324 7.9138889 0.414202 7.9166667 0.415081 7.9194444 0.415666
+ 7.9222222 0.415959 7.9250000 0.414788 7.9277778 0.414788 7.9305556 0.415666
+ 7.9333333 0.416545 7.9361111 0.418009 7.9388889 0.418302 7.9416667 0.417130
+ 7.9444444 0.416837 7.9472222 0.415959 7.9500000 0.416545 7.9527778 0.415959
+ 7.9555556 0.415373 7.9583333 0.415373 7.9611111 0.415081 7.9638889 0.416545
+ 7.9666667 0.417716 7.9694444 0.418594 7.9722222 0.419180 7.9750000 0.418009
+ 7.9777778 0.415959 7.9805556 0.415666 7.9833333 0.415959 7.9861111 0.417130
+ 7.9888889 0.418009 7.9916667 0.418302 7.9944444 0.417716 7.9972222 0.417423
+ 8.0000000 0.418302 8.0027778 0.419180 8.0055556 0.419180 8.0083333 0.418887
+ 8.0111111 0.418302 8.0138889 0.418594 8.0166667 0.418887 8.0194444 0.420351
+ 8.0222222 0.420937 8.0250000 0.420937 8.0277778 0.421230 8.0305556 0.420937
+ 8.0333333 0.420644 8.0361111 0.420351 8.0388889 0.421230 8.0416667 0.420059
+ 8.0444444 0.419766 8.0472222 0.419473 8.0500000 0.419180 8.0527778 0.420351
+ 8.0555556 0.421230 8.0583333 0.420937 8.0611111 0.420937 8.0638889 0.420351
+ 8.0666667 0.419766 8.0694444 0.421816 8.0722222 0.421816 8.0750000 0.421230
+ 8.0777778 0.421230 8.0805556 0.421230 8.0833333 0.421523 8.0861111 0.422694
+ 8.0888889 0.422694 8.0916667 0.421230 8.0944444 0.419473 8.0972222 0.418887
+ 8.1000000 0.420644 8.1027778 0.420351 8.1055556 0.421523 8.1083333 0.420644
+ 8.1111111 0.419766 8.1138889 0.418302 8.1166667 0.419473 8.1194444 0.420059
+ 8.1222222 0.420937 8.1250000 0.419473 8.1277778 0.416545 8.1305556 0.416545
+ 8.1333333 0.416837 8.1361111 0.418009 8.1388889 0.418009 8.1416667 0.418302
+ 8.1444444 0.417423 8.1472222 0.416837 8.1500000 0.416837 8.1527778 0.417130
+ 8.1555556 0.417423 8.1583333 0.418887 8.1611111 0.417716 8.1638889 0.417130
+ 8.1666667 0.416837 8.1694444 0.417130 8.1722222 0.417423 8.1750000 0.416837
+ 8.1777778 0.416837 8.1805556 0.416252 8.1833333 0.416252 8.1861111 0.416545
+ 8.1888889 0.415666 8.1916667 0.415081 8.1944444 0.415081 8.1972222 0.415081
+ 8.2000000 0.415373 8.2027778 0.417716 8.2055556 0.419766 8.2083333 0.420059
+ 8.2111111 0.420059 8.2138889 0.419180 8.2166667 0.420351 8.2194444 0.421523
+ 8.2222222 0.422987 8.2250000 0.424744 8.2277778 0.424744 8.2305556 0.424451
+ 8.2333333 0.424744 8.2361111 0.425915 8.2388889 0.428258 8.2416667 0.428843
+ 8.2444444 0.429136 8.2472222 0.430307 8.2500000 0.434114 8.2527778 0.439092
+ 8.2555556 0.441728 8.2583333 0.441728 8.2611111 0.439385 8.2638889 0.438799
+ 8.2666667 0.438214 8.2694444 0.436750 8.2722222 0.432064 8.2750000 0.422987
+ 8.2777778 0.407174 8.2805556 0.384334 8.2833333 0.362079 8.2861111 0.343045
+ 8.2888889 0.330161 8.2916667 0.323133 8.2944444 0.320498 8.2972222 0.317862
+ 8.3000000 0.317277 8.3027778 0.318741 8.3055556 0.320498 8.3083333 0.321083
+ 8.3111111 0.321669 8.3138889 0.322840 8.3166667 0.327818 8.3194444 0.334553
+ 8.3222222 0.343045 8.3250000 0.347145 8.3277778 0.349195 8.3305556 0.352123
+ 8.3333333 0.356223 8.3361111 0.362665 8.3388889 0.369400 8.3416667 0.374378
+ 8.3444444 0.377013 8.3472222 0.380234 8.3500000 0.384041 8.3527778 0.386676
+ 8.3555556 0.389312 8.3583333 0.391362 8.3611111 0.394290 8.3638889 0.396925
+ 8.3666667 0.400146 8.3694444 0.401611 8.3722222 0.402489 8.3750000 0.402489
+ 8.3777778 0.403075 8.3805556 0.403660 8.3833333 0.406003 8.3861111 0.408053
+ 8.3888889 0.409517 8.3916667 0.412738 8.3944444 0.415373 8.3972222 0.418887
+ 8.4000000 0.422987 8.4027778 0.426794 8.4055556 0.430600 8.4083333 0.432943
+ 8.4111111 0.434114 8.4138889 0.435578 8.4166667 0.437628 8.4194444 0.439385
+ 8.4222222 0.440849 8.4250000 0.441728 8.4277778 0.442606 8.4305556 0.442020
+ 8.4333333 0.442606 8.4361111 0.443777 8.4388889 0.446120 8.4416667 0.446999
+ 8.4444444 0.447291 8.4472222 0.446413 8.4500000 0.448170 8.4527778 0.448755
+ 8.4555556 0.449927 8.4583333 0.451684 8.4611111 0.453148 8.4638889 0.454026
+ 8.4666667 0.455198 8.4694444 0.455490 8.4722222 0.456369 8.4750000 0.457247
+ 8.4777778 0.457540 8.4805556 0.459883 8.4833333 0.460761 8.4861111 0.462811
+ 8.4888889 0.463982 8.4916667 0.463690 8.4944444 0.463690 8.4972222 0.464275
+ 8.5000000 0.465739 8.5027778 0.466911 8.5055556 0.468375 8.5083333 0.468082
+ 8.5111111 0.468668 8.5138889 0.468082 8.5166667 0.468375 8.5194444 0.469253
+ 8.5222222 0.469546 8.5250000 0.469546 8.5277778 0.470717 8.5305556 0.471010
+ 8.5333333 0.471010 8.5361111 0.471010 8.5388889 0.470717 8.5416667 0.470132
+ 8.5444444 0.468082 8.5472222 0.466911 8.5500000 0.467789 8.5527778 0.468375
+ 8.5555556 0.468960 8.5583333 0.468668 8.5611111 0.466911 8.5638889 0.465154
+ 8.5666667 0.465447 8.5694444 0.465154 8.5722222 0.465154 8.5750000 0.463397
+ 8.5777778 0.461347 8.5805556 0.460176 8.5833333 0.459590 8.5861111 0.460176
+ 8.5888889 0.459883 8.5916667 0.458126 8.5944444 0.456955 8.5972222 0.455198
+ 8.6000000 0.454905 8.6027778 0.453441 8.6055556 0.452855 8.6083333 0.450805
+ 8.6111111 0.448755 8.6138889 0.446706 8.6166667 0.445534 8.6194444 0.444949
+ 8.6222222 0.443485 8.6250000 0.442020 8.6277778 0.441142 8.6305556 0.439385
+ 8.6333333 0.438799 8.6361111 0.437335 8.6388889 0.437042 8.6416667 0.435286
+ 8.6444444 0.434114 8.6472222 0.432943 8.6500000 0.432650 8.6527778 0.432650
+ 8.6555556 0.432357 8.6583333 0.432650 8.6611111 0.431479 8.6638889 0.429429
+ 8.6666667 0.427965 8.6694444 0.426501 8.6722222 0.426208 8.6750000 0.427379
+ 8.6777778 0.428843 8.6805556 0.428843 8.6833333 0.429722 8.6861111 0.429429
+ 8.6888889 0.429429 8.6916667 0.429429 8.6944444 0.428258 8.6972222 0.427965
+ 8.7000000 0.427672 8.7027778 0.426794 8.7055556 0.426208 8.7083333 0.427379
+ 8.7111111 0.427086 8.7138889 0.426208 8.7166667 0.426501 8.7194444 0.426501
+ 8.7222222 0.427379 8.7250000 0.427086 8.7277778 0.425915 8.7305556 0.425329
+ 8.7333333 0.425915 8.7361111 0.427379 8.7388889 0.427965 8.7416667 0.427379
+ 8.7444444 0.426501 8.7472222 0.424744 8.7500000 0.424744 8.7527778 0.424158
+ 8.7555556 0.423865 8.7583333 0.423865 8.7611111 0.423865 8.7638889 0.423572
+ 8.7666667 0.423572 8.7694444 0.423572 8.7722222 0.424451 8.7750000 0.424744
+ 8.7777778 0.424451 8.7805556 0.424158 8.7833333 0.424744 8.7861111 0.425329
+ 8.7888889 0.425329 8.7916667 0.425329 8.7944444 0.425329 8.7972222 0.424451
+ 8.8000000 0.424158 8.8027778 0.423572 8.8055556 0.424744 8.8083333 0.425329
+ 8.8111111 0.425329 8.8138889 0.425037 8.8166667 0.424158 8.8194444 0.422987
+ 8.8222222 0.421816 8.8250000 0.420351 8.8277778 0.418887 8.8305556 0.420351
+ 8.8333333 0.420644 8.8361111 0.421230 8.8388889 0.420937 8.8416667 0.421230
+ 8.8444444 0.420059 8.8472222 0.418302 8.8500000 0.418302 8.8527778 0.418594
+ 8.8555556 0.420059 8.8583333 0.421230 8.8611111 0.421523 8.8638889 0.420644
+ 8.8666667 0.420644 8.8694444 0.420644 8.8722222 0.422108 8.8750000 0.422401
+ 8.8777778 0.421523 8.8805556 0.420059 8.8833333 0.419473 8.8861111 0.419766
+ 8.8888889 0.419473 8.8916667 0.418887 8.8944444 0.418302 8.8972222 0.418594
+ 8.9000000 0.419180 8.9027778 0.420644 8.9055556 0.422108 8.9083333 0.422108
+ 8.9111111 0.422108 8.9138889 0.421523 8.9166667 0.421523 8.9194444 0.422108
+ 8.9222222 0.422108 8.9250000 0.420937 8.9277778 0.419180 8.9305556 0.418009
+ 8.9333333 0.418887 8.9361111 0.420059 8.9388889 0.420644 8.9416667 0.421230
+ 8.9444444 0.420644 8.9472222 0.420351 8.9500000 0.420059 8.9527778 0.419766
+ 8.9555556 0.419766 8.9583333 0.419473 8.9611111 0.420059 8.9638889 0.422108
+ 8.9666667 0.423865 8.9694444 0.425037 8.9722222 0.424451 8.9750000 0.424158
+ 8.9777778 0.423865 8.9805556 0.423280 8.9833333 0.423572 8.9861111 0.423572
+ 8.9888889 0.423865 8.9916667 0.424158 8.9944444 0.422694 8.9972222 0.421816
+ 9.0000000 0.422694 9.0027778 0.422987 9.0055556 0.423280 9.0083333 0.422108
+ 9.0111111 0.420351 9.0138889 0.419180 9.0166667 0.420059 9.0194444 0.421523
+ 9.0222222 0.422108 9.0250000 0.422108 9.0277778 0.420644 9.0305556 0.419180
+ 9.0333333 0.418887 9.0361111 0.419766 9.0388889 0.420059 9.0416667 0.420059
+ 9.0444444 0.420351 9.0472222 0.420644 9.0500000 0.422401 9.0527778 0.423572
+ 9.0555556 0.423572 9.0583333 0.422401 9.0611111 0.421230 9.0638889 0.419473
+ 9.0666667 0.420351 9.0694444 0.420059 9.0722222 0.420351 9.0750000 0.420644
+ 9.0777778 0.420059 9.0805556 0.419473 9.0833333 0.418594 9.0861111 0.417716
+ 9.0888889 0.418009 9.0916667 0.417130 9.0944444 0.415666 9.0972222 0.415666
+ 9.1000000 0.416545 9.1027778 0.417423 9.1055556 0.418887 9.1083333 0.420937
+ 9.1111111 0.421816 9.1138889 0.421523 9.1166667 0.421816 9.1194444 0.420644
+ 9.1222222 0.420937 9.1250000 0.421230 9.1277778 0.420059 9.1305556 0.418887
+ 9.1333333 0.420351 9.1361111 0.423280 9.1388889 0.427965 9.1416667 0.432943
+ 9.1444444 0.437921 9.1472222 0.442899 9.1500000 0.448170 9.1527778 0.453148
+ 9.1555556 0.459004 9.1583333 0.465154 9.1611111 0.471889 9.1638889 0.478331
+ 9.1666667 0.485359 9.1694444 0.491215 9.1722222 0.492679 9.1750000 0.490630
+ 9.1777778 0.483602 9.1805556 0.468960 9.1833333 0.445242 9.1861111 0.422401
+ 9.1888889 0.409517 9.1916667 0.406296 9.1944444 0.404539 9.1972222 0.404539
+ 9.2000000 0.407760 9.2027778 0.410688 9.2055556 0.412152 9.2083333 0.412738
+ 9.2111111 0.412445 9.2138889 0.410981 9.2166667 0.410102 9.2194444 0.409517
+ 9.2222222 0.408931 9.2250000 0.409224 9.2277778 0.410102 9.2305556 0.409810
+ 9.2333333 0.409810 9.2361111 0.409224 9.2388889 0.410395 9.2416667 0.413031
+ 9.2444444 0.414788 9.2472222 0.415081 9.2500000 0.413324 9.2527778 0.412152
+ 9.2555556 0.411859 9.2583333 0.412445 9.2611111 0.413616 9.2638889 0.415666
+ 9.2666667 0.416545 9.2694444 0.416837 9.2722222 0.416545 9.2750000 0.417130
+ 9.2777778 0.415081 9.2805556 0.413909 9.2833333 0.413616 9.2861111 0.413909
+ 9.2888889 0.415081 9.2916667 0.415666 9.2944444 0.416252 9.2972222 0.415666
+ 9.3000000 0.416252 9.3027778 0.416545 9.3055556 0.416837 9.3083333 0.416837
+ 9.3111111 0.416545 9.3138889 0.416252 9.3166667 0.415959 9.3194444 0.417130
+ 9.3222222 0.417130 9.3250000 0.417423 9.3277778 0.417130 9.3305556 0.416252
+ 9.3333333 0.417130 9.3361111 0.417423 9.3388889 0.417716 9.3416667 0.417130
+ 9.3444444 0.416837 9.3472222 0.416837 9.3500000 0.415959 9.3527778 0.416252
+ 9.3555556 0.416837 9.3583333 0.417716 9.3611111 0.418302 9.3638889 0.419473
+ 9.3666667 0.421230 9.3694444 0.421816 9.3722222 0.420059 9.3750000 0.415959
+ 9.3777778 0.411567 9.3805556 0.411567 9.3833333 0.414788 9.3861111 0.416837
+ 9.3888889 0.417716 9.3916667 0.415373 9.3944444 0.413031 9.3972222 0.413324
+ 9.4000000 0.415959 9.4027778 0.416837 9.4055556 0.417716 9.4083333 0.417716
+ 9.4111111 0.418009 9.4138889 0.417716 9.4166667 0.417716 9.4194444 0.417716
+ 9.4222222 0.418302 9.4250000 0.418594 9.4277778 0.418594 9.4305556 0.418887
+ 9.4333333 0.420937 9.4361111 0.421523 9.4388889 0.422694 9.4416667 0.422987
+ 9.4444444 0.422108 9.4472222 0.421523 9.4500000 0.422694 9.4527778 0.424451
+ 9.4555556 0.424451 9.4583333 0.425329 9.4611111 0.424158 9.4638889 0.423572
+ 9.4666667 0.424158 9.4694444 0.424451 9.4722222 0.423572 9.4750000 0.422401
+ 9.4777778 0.422694 9.4805556 0.421816 9.4833333 0.422108 9.4861111 0.422987
+ 9.4888889 0.423572 9.4916667 0.422694 9.4944444 0.423280 9.4972222 0.423280
+ 9.5000000 0.423572 9.5027778 0.423865 9.5055556 0.423865 9.5083333 0.423865
+ 9.5111111 0.423865 9.5138889 0.423572 9.5166667 0.422694 9.5194444 0.422108
+ 9.5222222 0.422987 9.5250000 0.422694 9.5277778 0.421230 9.5305556 0.421523
+ 9.5333333 0.421230 9.5361111 0.421230 9.5388889 0.421523 9.5416667 0.421816
+ 9.5444444 0.420351 9.5472222 0.420351 9.5500000 0.420059 9.5527778 0.420059
+ 9.5555556 0.420351 9.5583333 0.419473 9.5611111 0.419766 9.5638889 0.419473
+ 9.5666667 0.420644 9.5694444 0.420644 9.5722222 0.420937 9.5750000 0.420351
+ 9.5777778 0.418887 9.5805556 0.418594 9.5833333 0.418887 9.5861111 0.420059
+ 9.5888889 0.419473 9.5916667 0.419180 9.5944444 0.418594 9.5972222 0.418302
+ 9.6000000 0.420059 9.6027778 0.421230 9.6055556 0.424744 9.6083333 0.426208
+ 9.6111111 0.427672 9.6138889 0.428258 9.6166667 0.429136 9.6194444 0.430893
+ 9.6222222 0.432064 9.6250000 0.432943 9.6277778 0.432357 9.6305556 0.431186
+ 9.6333333 0.431772 9.6361111 0.434114 9.6388889 0.435871 9.6416667 0.435578
+ 9.6444444 0.431479 9.6472222 0.425037 9.6500000 0.416837 9.6527778 0.401318
+ 9.6555556 0.379356 9.6583333 0.355637 9.6611111 0.333675 9.6638889 0.315813
+ 9.6666667 0.304392 9.6694444 0.300000 9.6722222 0.300000 9.6750000 0.300586
+ 9.6777778 0.300878 9.6805556 0.303221 9.6833333 0.307028 9.6861111 0.310542
+ 9.6888889 0.314934 9.6916667 0.320791 9.6944444 0.326061 9.6972222 0.331625
+ 9.7000000 0.336310 9.7027778 0.344510 9.7055556 0.354466 9.7083333 0.362079
+ 9.7111111 0.369400 9.7138889 0.372914 9.7166667 0.377013 9.7194444 0.379356
+ 9.7222222 0.383163 9.7250000 0.387262 9.7277778 0.389898 9.7305556 0.391947
+ 9.7333333 0.394290 9.7361111 0.396633 9.7388889 0.400732 9.7416667 0.404246
+ 9.7444444 0.406296 9.7472222 0.409224 9.7500000 0.412445 9.7527778 0.417423
+ 9.7555556 0.422987 9.7583333 0.426794 9.7611111 0.429722 9.7638889 0.432064
+ 9.7666667 0.435286 9.7694444 0.438214 9.7722222 0.440849 9.7750000 0.442020
+ 9.7777778 0.442313 9.7805556 0.443777 9.7833333 0.445242 9.7861111 0.446120
+ 9.7888889 0.447584 9.7916667 0.449048 9.7944444 0.450512 9.7972222 0.450805
+ 9.8000000 0.451977 9.8027778 0.452562 9.8055556 0.453441 9.8083333 0.454026
+ 9.8111111 0.454905 9.8138889 0.455490 9.8166667 0.456076 9.8194444 0.458126
+ 9.8222222 0.459883 9.8250000 0.461054 9.8277778 0.461640 9.8305556 0.462811
+ 9.8333333 0.463104 9.8361111 0.463982 9.8388889 0.466325 9.8416667 0.467789
+ 9.8444444 0.468082 9.8472222 0.468375 9.8500000 0.469839 9.8527778 0.471010
+ 9.8555556 0.471889 9.8583333 0.472474 9.8611111 0.472474 9.8638889 0.471596
+ 9.8666667 0.472474 9.8694444 0.473353 9.8722222 0.473646 9.8750000 0.473646
+ 9.8777778 0.473353 9.8805556 0.473353 9.8833333 0.473646 9.8861111 0.473060
+ 9.8888889 0.473353 9.8916667 0.473353 9.8944444 0.472474 9.8972222 0.470717
+ 9.9000000 0.470717 9.9027778 0.469546 9.9055556 0.469253 9.9083333 0.468668
+ 9.9111111 0.466325 9.9138889 0.464275 9.9166667 0.463104 9.9194444 0.461054
+ 9.9222222 0.459883 9.9250000 0.457540 9.9277778 0.454905 9.9305556 0.452562
+ 9.9333333 0.450220 9.9361111 0.449341 9.9388889 0.448170 9.9416667 0.446999
+ 9.9444444 0.444363 9.9472222 0.442020 9.9500000 0.440556 9.9527778 0.439678
+ 9.9555556 0.439971 9.9583333 0.439092 9.9611111 0.438214 9.9638889 0.435871
+ 9.9666667 0.434700 9.9694444 0.434700 9.9722222 0.434407 9.9750000 0.433821
+ 9.9777778 0.432064 9.9805556 0.428843 9.9833333 0.427672 9.9861111 0.427379
+ 9.9888889 0.427965 9.9916667 0.427086 9.9944444 0.425915 9.9972222 0.424744
+ )

Xdet ecg_in rpeak_out vdd vss vbias
+ v_hpf v_bpf diff_out mwi_out slow_avg noise_gate_out
+ rpeak_detector_v5

.ic v(v_hpf)=0.40
.ic v(v_bpf)=0.40
.ic v(diff_out)=0.40
.ic v(mwi_out)=0.40
.ic v(slow_avg)=0.40

.save v(ecg_in) v(rpeak_out) v(mwi_out) v(slow_avg)
+ v(noise_gate_out) v(diff_out)

.tran 0.1m 10.0000 uic

.control
run
wrdata scratchpad/_v5_data_200.txt v(ecg_in) v(rpeak_out) v(mwi_out) v(slow_avg) v(noise_gate_out) v(diff_out)
quit
.endc

.end
