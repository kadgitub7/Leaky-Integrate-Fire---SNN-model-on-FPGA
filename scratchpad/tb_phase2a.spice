* ============================================================
* Phase 2A: Direct ECG -> Envelope Detection Path
* ============================================================
* Tests: ECG -> rpeak_detector_v2 (no AC coupling stage)
* The ECG signal feeds directly into the dual-envelope detector.
* QRS peaks are the dominant feature without differentiation.
*
* Record 100, 10.0s, 13 Python detections
* Python det 1: t=0.0222s
* Python det 2: t=1.0278s
* Python det 3: t=1.8417s
* Python det 4: t=2.6306s
* Python det 5: t=3.4194s
* Python det 6: t=4.2083s
* Python det 7: t=5.0250s
* Python det 8: t=5.6806s
* Python det 9: t=6.6750s
* Python det 10: t=7.5167s
* Python det 11: t=8.3278s
* Python det 12: t=9.1194s
* Python det 13: t=9.8889s
* ============================================================

.lib C:/Users/kadhi/OneDrive/Desktop/amux/verilogLearning/Leaky-Integrate-Fire---SNN-model-on-FPGA/experiments/frontend_optimization/ngspice_frontend/sky130_minimal.lib.spice tt

.include C:/Users/kadhi/OneDrive/Desktop/amux/verilogLearning/Leaky-Integrate-Fire---SNN-model-on-FPGA/experiments/frontend_optimization/complete_frontend_v9b/inverter.spice
.include C:/Users/kadhi/OneDrive/Desktop/amux/verilogLearning/Leaky-Integrate-Fire---SNN-model-on-FPGA/experiments/frontend_optimization/complete_frontend_v9b/rpeak_hold.spice
.include C:/Users/kadhi/OneDrive/Desktop/amux/verilogLearning/Leaky-Integrate-Fire---SNN-model-on-FPGA/experiments/frontend_optimization/complete_frontend_v9b/rpeak_detector_v2.spice

.option scale=1.0u method=gear reltol=0.01 gmin=1e-15

Vdd vdd 0 0.9
Vss vss 0 0.0
Vbias vbias 0 0.300

* ---- Raw ECG signal as PWL ----
Vecg ecg_in 0 PWL(
+ 0.0000000 0.312305 0.0027778 0.312305 0.0055556 0.312305 0.0083333 0.312305
+ 0.0111111 0.312305 0.0138889 0.312305 0.0166667 0.312305 0.0194444 0.312305
+ 0.0222222 0.315421 0.0250000 0.313551 0.0277778 0.312305 0.0305556 0.311682
+ 0.0333333 0.310436 0.0361111 0.311059 0.0388889 0.310436 0.0416667 0.308567
+ 0.0444444 0.307944 0.0472222 0.307321 0.0500000 0.309190 0.0527778 0.311059
+ 0.0555556 0.308567 0.0583333 0.307944 0.0611111 0.306698 0.0638889 0.307944
+ 0.0666667 0.311059 0.0694444 0.313551 0.0722222 0.311059 0.0750000 0.306698
+ 0.0777778 0.304829 0.0805556 0.301090 0.0833333 0.302336 0.0861111 0.299844
+ 0.0888889 0.299221 0.0916667 0.297975 0.0944444 0.296106 0.0972222 0.296106
+ 0.1000000 0.296106 0.1027778 0.297352 0.1055556 0.298598 0.1083333 0.297352
+ 0.1111111 0.296106 0.1138889 0.294237 0.1166667 0.294237 0.1194444 0.294237
+ 0.1222222 0.294237 0.1250000 0.294860 0.1277778 0.293614 0.1305556 0.292368
+ 0.1333333 0.294860 0.1361111 0.296106 0.1388889 0.296106 0.1416667 0.295483
+ 0.1444444 0.294860 0.1472222 0.292368 0.1500000 0.294237 0.1527778 0.292991
+ 0.1555556 0.295483 0.1583333 0.294237 0.1611111 0.292991 0.1638889 0.291121
+ 0.1666667 0.290498 0.1694444 0.288629 0.1722222 0.285514 0.1750000 0.282399
+ 0.1777778 0.282399 0.1805556 0.279907 0.1833333 0.273676 0.1861111 0.269938
+ 0.1888889 0.269938 0.1916667 0.277414 0.1944444 0.289252 0.1972222 0.302960
+ 0.2000000 0.321651 0.2027778 0.345327 0.2055556 0.377103 0.2083333 0.407632
+ 0.2111111 0.427570 0.2138889 0.435047 0.2166667 0.425701 0.2194444 0.395171
+ 0.2222222 0.351558 0.2250000 0.309813 0.2277778 0.284891 0.2305556 0.276168
+ 0.2333333 0.277414 0.2361111 0.284268 0.2388889 0.289252 0.2416667 0.289875
+ 0.2444444 0.288629 0.2472222 0.287383 0.2500000 0.289252 0.2527778 0.289875
+ 0.2555556 0.291121 0.2583333 0.291745 0.2611111 0.290498 0.2638889 0.288629
+ 0.2666667 0.288006 0.2694444 0.289875 0.2722222 0.287383 0.2750000 0.288629
+ 0.2777778 0.289252 0.2805556 0.288629 0.2833333 0.289252 0.2861111 0.289875
+ 0.2888889 0.289252 0.2916667 0.289252 0.2944444 0.287383 0.2972222 0.286137
+ 0.3000000 0.288629 0.3027778 0.289875 0.3055556 0.292368 0.3083333 0.290498
+ 0.3111111 0.290498 0.3138889 0.289252 0.3166667 0.288006 0.3194444 0.288629
+ 0.3222222 0.288006 0.3250000 0.287383 0.3277778 0.286137 0.3305556 0.286137
+ 0.3333333 0.288006 0.3361111 0.289252 0.3388889 0.289252 0.3416667 0.289252
+ 0.3444444 0.288006 0.3472222 0.286760 0.3500000 0.289875 0.3527778 0.289875
+ 0.3555556 0.289252 0.3583333 0.289252 0.3611111 0.288629 0.3638889 0.288629
+ 0.3666667 0.288006 0.3694444 0.289252 0.3722222 0.288006 0.3750000 0.286760
+ 0.3777778 0.286137 0.3805556 0.286760 0.3833333 0.287383 0.3861111 0.289252
+ 0.3888889 0.290498 0.3916667 0.288629 0.3944444 0.289252 0.3972222 0.287383
+ 0.4000000 0.289252 0.4027778 0.288629 0.4055556 0.288629 0.4083333 0.287383
+ 0.4111111 0.287383 0.4138889 0.286137 0.4166667 0.288006 0.4194444 0.288006
+ 0.4222222 0.288629 0.4250000 0.289252 0.4277778 0.286760 0.4305556 0.286760
+ 0.4333333 0.287383 0.4361111 0.288629 0.4388889 0.288629 0.4416667 0.288629
+ 0.4444444 0.286760 0.4472222 0.286137 0.4500000 0.286137 0.4527778 0.287383
+ 0.4555556 0.287383 0.4583333 0.288629 0.4611111 0.286760 0.4638889 0.285514
+ 0.4666667 0.285514 0.4694444 0.285514 0.4722222 0.284891 0.4750000 0.285514
+ 0.4777778 0.284268 0.4805556 0.282399 0.4833333 0.284268 0.4861111 0.285514
+ 0.4888889 0.286137 0.4916667 0.285514 0.4944444 0.283645 0.4972222 0.283645
+ 0.5000000 0.284891 0.5027778 0.284891 0.5055556 0.285514 0.5083333 0.285514
+ 0.5111111 0.284891 0.5138889 0.284268 0.5166667 0.286137 0.5194444 0.289252
+ 0.5222222 0.289875 0.5250000 0.289875 0.5277778 0.288629 0.5305556 0.288006
+ 0.5333333 0.291121 0.5361111 0.292991 0.5388889 0.292991 0.5416667 0.294237
+ 0.5444444 0.293614 0.5472222 0.294237 0.5500000 0.294860 0.5527778 0.296106
+ 0.5555556 0.298598 0.5583333 0.299221 0.5611111 0.299221 0.5638889 0.297352
+ 0.5666667 0.298598 0.5694444 0.299844 0.5722222 0.301713 0.5750000 0.299844
+ 0.5777778 0.299844 0.5805556 0.298598 0.5833333 0.298598 0.5861111 0.300467
+ 0.5888889 0.299221 0.5916667 0.298598 0.5944444 0.299844 0.5972222 0.298598
+ 0.6000000 0.299221 0.6027778 0.299221 0.6055556 0.297352 0.6083333 0.297975
+ 0.6111111 0.297975 0.6138889 0.297352 0.6166667 0.296729 0.6194444 0.297352
+ 0.6222222 0.297975 0.6250000 0.296106 0.6277778 0.295483 0.6305556 0.294237
+ 0.6333333 0.296106 0.6361111 0.296729 0.6388889 0.297975 0.6416667 0.295483
+ 0.6444444 0.295483 0.6472222 0.294860 0.6500000 0.296106 0.6527778 0.296106
+ 0.6555556 0.297352 0.6583333 0.296729 0.6611111 0.294860 0.6638889 0.294237
+ 0.6666667 0.295483 0.6694444 0.296106 0.6722222 0.294860 0.6750000 0.295483
+ 0.6777778 0.292991 0.6805556 0.292991 0.6833333 0.292368 0.6861111 0.293614
+ 0.6888889 0.292991 0.6916667 0.291745 0.6944444 0.291745 0.6972222 0.292368
+ 0.7000000 0.293614 0.7027778 0.294860 0.7055556 0.294860 0.7083333 0.294237
+ 0.7111111 0.293614 0.7138889 0.291745 0.7166667 0.294237 0.7194444 0.293614
+ 0.7222222 0.292991 0.7250000 0.292368 0.7277778 0.291745 0.7305556 0.289875
+ 0.7333333 0.291745 0.7361111 0.292991 0.7388889 0.294237 0.7416667 0.291745
+ 0.7444444 0.289875 0.7472222 0.289252 0.7500000 0.291121 0.7527778 0.292991
+ 0.7555556 0.292368 0.7583333 0.291745 0.7611111 0.290498 0.7638889 0.289252
+ 0.7666667 0.289875 0.7694444 0.291121 0.7722222 0.291745 0.7750000 0.292368
+ 0.7777778 0.292368 0.7805556 0.291745 0.7833333 0.292991 0.7861111 0.292368
+ 0.7888889 0.294237 0.7916667 0.292991 0.7944444 0.292991 0.7972222 0.292368
+ 0.8000000 0.292368 0.8027778 0.294237 0.8055556 0.295483 0.8083333 0.293614
+ 0.8111111 0.292368 0.8138889 0.291121 0.8166667 0.292368 0.8194444 0.293614
+ 0.8222222 0.294237 0.8250000 0.295483 0.8277778 0.296729 0.8305556 0.296106
+ 0.8333333 0.296106 0.8361111 0.296729 0.8388889 0.299221 0.8416667 0.299221
+ 0.8444444 0.298598 0.8472222 0.302336 0.8500000 0.302960 0.8527778 0.304829
+ 0.8555556 0.305452 0.8583333 0.304829 0.8611111 0.303583 0.8638889 0.301713
+ 0.8666667 0.302960 0.8694444 0.302336 0.8722222 0.302336 0.8750000 0.302336
+ 0.8777778 0.301713 0.8805556 0.301090 0.8833333 0.300467 0.8861111 0.301090
+ 0.8888889 0.302960 0.8916667 0.304206 0.8944444 0.304829 0.8972222 0.299844
+ 0.9000000 0.294860 0.9027778 0.294860 0.9055556 0.292991 0.9083333 0.291745
+ 0.9111111 0.289252 0.9138889 0.289252 0.9166667 0.289875 0.9194444 0.291121
+ 0.9222222 0.290498 0.9250000 0.291121 0.9277778 0.289875 0.9305556 0.288006
+ 0.9333333 0.287383 0.9361111 0.288006 0.9388889 0.288006 0.9416667 0.286760
+ 0.9444444 0.287383 0.9472222 0.286137 0.9500000 0.289252 0.9527778 0.288629
+ 0.9555556 0.289252 0.9583333 0.290498 0.9611111 0.287383 0.9638889 0.286137
+ 0.9666667 0.288006 0.9694444 0.289252 0.9722222 0.289875 0.9750000 0.289252
+ 0.9777778 0.286760 0.9805556 0.284891 0.9833333 0.285514 0.9861111 0.283022
+ 0.9888889 0.277414 0.9916667 0.274922 0.9944444 0.271184 0.9972222 0.266822
+ 1.0000000 0.263707 1.0027778 0.267445 1.0055556 0.278660 1.0083333 0.292991
+ 1.0111111 0.310436 1.0138889 0.328505 1.0166667 0.359657 1.0194444 0.391433
+ 1.0222222 0.420093 1.0250000 0.439408 1.0277778 0.447508 1.0305556 0.443146
+ 1.0333333 0.424455 1.0361111 0.391433 1.0388889 0.350935 1.0416667 0.316667
+ 1.0444444 0.296729 1.0472222 0.281776 1.0500000 0.274299 1.0527778 0.271184
+ 1.0555556 0.273676 1.0583333 0.277414 1.0611111 0.281776 1.0638889 0.281776
+ 1.0666667 0.282399 1.0694444 0.281776 1.0722222 0.283022 1.0750000 0.283022
+ 1.0777778 0.283022 1.0805556 0.281153 1.0833333 0.282399 1.0861111 0.282399
+ 1.0888889 0.282399 1.0916667 0.283645 1.0944444 0.281153 1.0972222 0.279283
+ 1.1000000 0.279283 1.1027778 0.280530 1.1055556 0.281153 1.1083333 0.281776
+ 1.1111111 0.279907 1.1138889 0.281153 1.1166667 0.282399 1.1194444 0.283645
+ 1.1222222 0.281776 1.1250000 0.281776 1.1277778 0.279907 1.1305556 0.279283
+ 1.1333333 0.279283 1.1361111 0.281776 1.1388889 0.281776 1.1416667 0.281153
+ 1.1444444 0.279907 1.1472222 0.278660 1.1500000 0.280530 1.1527778 0.279283
+ 1.1555556 0.279907 1.1583333 0.279283 1.1611111 0.278660 1.1638889 0.279283
+ 1.1666667 0.280530 1.1694444 0.280530 1.1722222 0.281153 1.1750000 0.281776
+ 1.1777778 0.279907 1.1805556 0.279283 1.1833333 0.281776 1.1861111 0.281776
+ 1.1888889 0.282399 1.1916667 0.282399 1.1944444 0.279283 1.1972222 0.279907
+ 1.2000000 0.281153 1.2027778 0.281776 1.2055556 0.283645 1.2083333 0.281776
+ 1.2111111 0.281153 1.2138889 0.279283 1.2166667 0.280530 1.2194444 0.281776
+ 1.2222222 0.281776 1.2250000 0.282399 1.2277778 0.279907 1.2305556 0.278660
+ 1.2333333 0.278660 1.2361111 0.280530 1.2388889 0.281153 1.2416667 0.279907
+ 1.2444444 0.278660 1.2472222 0.278037 1.2500000 0.278037 1.2527778 0.279283
+ 1.2555556 0.278660 1.2583333 0.277414 1.2611111 0.278037 1.2638889 0.276168
+ 1.2666667 0.276791 1.2694444 0.276791 1.2722222 0.278037 1.2750000 0.276791
+ 1.2777778 0.274299 1.2805556 0.273676 1.2833333 0.274299 1.2861111 0.276168
+ 1.2888889 0.274922 1.2916667 0.274299 1.2944444 0.273676 1.2972222 0.271807
+ 1.3000000 0.273053 1.3027778 0.273676 1.3055556 0.274299 1.3083333 0.273676
+ 1.3111111 0.271807 1.3138889 0.271184 1.3166667 0.273053 1.3194444 0.274299
+ 1.3222222 0.274922 1.3250000 0.275545 1.3277778 0.276168 1.3305556 0.275545
+ 1.3333333 0.279283 1.3361111 0.281153 1.3388889 0.284268 1.3416667 0.284891
+ 1.3444444 0.285514 1.3472222 0.284891 1.3500000 0.288006 1.3527778 0.289875
+ 1.3555556 0.291121 1.3583333 0.290498 1.3611111 0.289252 1.3638889 0.289252
+ 1.3666667 0.290498 1.3694444 0.291745 1.3722222 0.292991 1.3750000 0.292991
+ 1.3777778 0.290498 1.3805556 0.290498 1.3833333 0.291121 1.3861111 0.292368
+ 1.3888889 0.292368 1.3916667 0.293614 1.3944444 0.290498 1.3972222 0.289252
+ 1.4000000 0.292368 1.4027778 0.291745 1.4055556 0.292991 1.4083333 0.292991
+ 1.4111111 0.290498 1.4138889 0.289875 1.4166667 0.291745 1.4194444 0.292368
+ 1.4222222 0.291121 1.4250000 0.292368 1.4277778 0.291121 1.4305556 0.291121
+ 1.4333333 0.291745 1.4361111 0.293614 1.4388889 0.294237 1.4416667 0.292368
+ 1.4444444 0.291745 1.4472222 0.290498 1.4500000 0.291121 1.4527778 0.292991
+ 1.4555556 0.291121 1.4583333 0.291121 1.4611111 0.291121 1.4638889 0.289252
+ 1.4666667 0.291121 1.4694444 0.290498 1.4722222 0.291121 1.4750000 0.289875
+ 1.4777778 0.288629 1.4805556 0.288006 1.4833333 0.288629 1.4861111 0.288629
+ 1.4888889 0.289252 1.4916667 0.289875 1.4944444 0.287383 1.4972222 0.286760
+ 1.5000000 0.287383 1.5027778 0.288629 1.5055556 0.289252 1.5083333 0.289252
+ 1.5111111 0.287383 1.5138889 0.287383 1.5166667 0.287383 1.5194444 0.290498
+ 1.5222222 0.289252 1.5250000 0.288629 1.5277778 0.288006 1.5305556 0.286137
+ 1.5333333 0.288629 1.5361111 0.289252 1.5388889 0.289252 1.5416667 0.288629
+ 1.5444444 0.286137 1.5472222 0.285514 1.5500000 0.286137 1.5527778 0.286760
+ 1.5555556 0.288006 1.5583333 0.287383 1.5611111 0.287383 1.5638889 0.287383
+ 1.5666667 0.287383 1.5694444 0.289252 1.5722222 0.289252 1.5750000 0.288629
+ 1.5777778 0.287383 1.5805556 0.286760 1.5833333 0.286760 1.5861111 0.288006
+ 1.5888889 0.289252 1.5916667 0.287383 1.5944444 0.287383 1.5972222 0.286137
+ 1.6000000 0.286760 1.6027778 0.288006 1.6055556 0.289252 1.6083333 0.288006
+ 1.6111111 0.288006 1.6138889 0.288006 1.6166667 0.289252 1.6194444 0.288629
+ 1.6222222 0.289252 1.6250000 0.288629 1.6277778 0.287383 1.6305556 0.287383
+ 1.6333333 0.288006 1.6361111 0.289252 1.6388889 0.291121 1.6416667 0.293614
+ 1.6444444 0.292991 1.6472222 0.293614 1.6500000 0.294860 1.6527778 0.296106
+ 1.6555556 0.297352 1.6583333 0.297352 1.6611111 0.297352 1.6638889 0.298598
+ 1.6666667 0.299221 1.6694444 0.300467 1.6722222 0.302336 1.6750000 0.303583
+ 1.6777778 0.300467 1.6805556 0.299844 1.6833333 0.300467 1.6861111 0.299844
+ 1.6888889 0.301090 1.6916667 0.299844 1.6944444 0.299221 1.6972222 0.296106
+ 1.7000000 0.296106 1.7027778 0.297352 1.7055556 0.299221 1.7083333 0.302336
+ 1.7111111 0.302960 1.7138889 0.301713 1.7166667 0.297352 1.7194444 0.296729
+ 1.7222222 0.295483 1.7250000 0.294860 1.7277778 0.292368 1.7305556 0.290498
+ 1.7333333 0.288006 1.7361111 0.289252 1.7388889 0.288629 1.7416667 0.288629
+ 1.7444444 0.286137 1.7472222 0.284268 1.7500000 0.285514 1.7527778 0.287383
+ 1.7555556 0.286760 1.7583333 0.286137 1.7611111 0.284891 1.7638889 0.283645
+ 1.7666667 0.283022 1.7694444 0.284268 1.7722222 0.284891 1.7750000 0.284891
+ 1.7777778 0.283022 1.7805556 0.282399 1.7833333 0.283022 1.7861111 0.283645
+ 1.7888889 0.286137 1.7916667 0.284268 1.7944444 0.281776 1.7972222 0.279907
+ 1.8000000 0.279283 1.8027778 0.276168 1.8055556 0.272430 1.8083333 0.269315
+ 1.8111111 0.265576 1.8138889 0.261215 1.8166667 0.259346 1.8194444 0.264953
+ 1.8222222 0.279907 1.8250000 0.299221 1.8277778 0.319159 1.8305556 0.345327
+ 1.8333333 0.381464 1.8361111 0.416355 1.8388889 0.440654 1.8416667 0.450000
+ 1.8444444 0.436293 1.8472222 0.395171 1.8500000 0.336604 1.8527778 0.290498
+ 1.8555556 0.268069 1.8583333 0.267445 1.8611111 0.274922 1.8638889 0.278660
+ 1.8666667 0.281153 1.8694444 0.281776 1.8722222 0.281153 1.8750000 0.281776
+ 1.8777778 0.281153 1.8805556 0.279907 1.8833333 0.281153 1.8861111 0.279907
+ 1.8888889 0.281776 1.8916667 0.281153 1.8944444 0.281153 1.8972222 0.279283
+ 1.9000000 0.279907 1.9027778 0.280530 1.9055556 0.280530 1.9083333 0.278660
+ 1.9111111 0.279907 1.9138889 0.278037 1.9166667 0.278660 1.9194444 0.279907
+ 1.9222222 0.279907 1.9250000 0.278037 1.9277778 0.278037 1.9305556 0.276168
+ 1.9333333 0.278037 1.9361111 0.279283 1.9388889 0.279283 1.9416667 0.279907
+ 1.9444444 0.277414 1.9472222 0.276791 1.9500000 0.278037 1.9527778 0.278660
+ 1.9555556 0.279283 1.9583333 0.279283 1.9611111 0.277414 1.9638889 0.278037
+ 1.9666667 0.280530 1.9694444 0.281153 1.9722222 0.280530 1.9750000 0.280530
+ 1.9777778 0.281153 1.9805556 0.278660 1.9833333 0.279907 1.9861111 0.281776
+ 1.9888889 0.280530 1.9916667 0.280530 1.9944444 0.278660 1.9972222 0.277414
+ 2.0000000 0.277414 2.0027778 0.278660 2.0055556 0.278660 2.0083333 0.279283
+ 2.0111111 0.277414 2.0138889 0.277414 2.0166667 0.278037 2.0194444 0.278660
+ 2.0222222 0.280530 2.0250000 0.280530 2.0277778 0.279283 2.0305556 0.277414
+ 2.0333333 0.279283 2.0361111 0.279907 2.0388889 0.281153 2.0416667 0.280530
+ 2.0444444 0.280530 2.0472222 0.279907 2.0500000 0.282399 2.0527778 0.280530
+ 2.0555556 0.281776 2.0583333 0.281776 2.0611111 0.280530 2.0638889 0.278660
+ 2.0666667 0.279907 2.0694444 0.279907 2.0722222 0.279283 2.0750000 0.278660
+ 2.0777778 0.278037 2.0805556 0.278037 2.0833333 0.277414 2.0861111 0.278660
+ 2.0888889 0.278660 2.0916667 0.279283 2.0944444 0.276168 2.0972222 0.276791
+ 2.1000000 0.276168 2.1027778 0.278037 2.1055556 0.278037 2.1083333 0.278037
+ 2.1111111 0.278037 2.1138889 0.277414 2.1166667 0.277414 2.1194444 0.278660
+ 2.1222222 0.281153 2.1250000 0.281153 2.1277778 0.281776 2.1305556 0.283645
+ 2.1333333 0.285514 2.1361111 0.288006 2.1388889 0.288629 2.1416667 0.289252
+ 2.1444444 0.288629 2.1472222 0.288629 2.1500000 0.289875 2.1527778 0.290498
+ 2.1555556 0.292368 2.1583333 0.292368 2.1611111 0.291121 2.1638889 0.291745
+ 2.1666667 0.292368 2.1694444 0.292991 2.1722222 0.292991 2.1750000 0.292991
+ 2.1777778 0.291745 2.1805556 0.291745 2.1833333 0.291745 2.1861111 0.291121
+ 2.1888889 0.292991 2.1916667 0.292368 2.1944444 0.291121 2.1972222 0.290498
+ 2.2000000 0.289875 2.2027778 0.291745 2.2055556 0.292368 2.2083333 0.292368
+ 2.2111111 0.290498 2.2138889 0.289875 2.2166667 0.292368 2.2194444 0.291745
+ 2.2222222 0.293614 2.2250000 0.291745 2.2277778 0.289875 2.2305556 0.289252
+ 2.2333333 0.290498 2.2361111 0.290498 2.2388889 0.290498 2.2416667 0.289875
+ 2.2444444 0.286760 2.2472222 0.286760 2.2500000 0.288006 2.2527778 0.288629
+ 2.2555556 0.289252 2.2583333 0.288629 2.2611111 0.288006 2.2638889 0.285514
+ 2.2666667 0.286760 2.2694444 0.286760 2.2722222 0.286137 2.2750000 0.285514
+ 2.2777778 0.286137 2.2805556 0.284891 2.2833333 0.286137 2.2861111 0.286760
+ 2.2888889 0.288006 2.2916667 0.286137 2.2944444 0.286760 2.2972222 0.284891
+ 2.3000000 0.284891 2.3027778 0.286760 2.3055556 0.286137 2.3083333 0.286760
+ 2.3111111 0.284268 2.3138889 0.283022 2.3166667 0.284268 2.3194444 0.285514
+ 2.3222222 0.284891 2.3250000 0.285514 2.3277778 0.284891 2.3305556 0.283022
+ 2.3333333 0.284268 2.3361111 0.284891 2.3388889 0.286760 2.3416667 0.286760
+ 2.3444444 0.286760 2.3472222 0.284268 2.3500000 0.284891 2.3527778 0.287383
+ 2.3555556 0.287383 2.3583333 0.288006 2.3611111 0.286137 2.3638889 0.284891
+ 2.3666667 0.285514 2.3694444 0.286137 2.3722222 0.286137 2.3750000 0.286137
+ 2.3777778 0.283645 2.3805556 0.282399 2.3833333 0.286137 2.3861111 0.285514
+ 2.3888889 0.286137 2.3916667 0.285514 2.3944444 0.285514 2.3972222 0.284268
+ 2.4000000 0.285514 2.4027778 0.287383 2.4055556 0.286137 2.4083333 0.287383
+ 2.4111111 0.287383 2.4138889 0.287383 2.4166667 0.288006 2.4194444 0.291745
+ 2.4222222 0.292368 2.4250000 0.292368 2.4277778 0.291745 2.4305556 0.292368
+ 2.4333333 0.294237 2.4361111 0.294860 2.4388889 0.296106 2.4416667 0.295483
+ 2.4444444 0.295483 2.4472222 0.296106 2.4500000 0.297352 2.4527778 0.298598
+ 2.4555556 0.299844 2.4583333 0.297975 2.4611111 0.297352 2.4638889 0.296106
+ 2.4666667 0.295483 2.4694444 0.297352 2.4722222 0.296729 2.4750000 0.296106
+ 2.4777778 0.295483 2.4805556 0.296106 2.4833333 0.295483 2.4861111 0.296106
+ 2.4888889 0.297352 2.4916667 0.298598 2.4944444 0.300467 2.4972222 0.297975
+ 2.5000000 0.295483 2.5027778 0.291745 2.5055556 0.291745 2.5083333 0.287383
+ 2.5111111 0.285514 2.5138889 0.283022 2.5166667 0.282399 2.5194444 0.283022
+ 2.5222222 0.284268 2.5250000 0.283645 2.5277778 0.282399 2.5305556 0.281776
+ 2.5333333 0.281153 2.5361111 0.282399 2.5388889 0.282399 2.5416667 0.282399
+ 2.5444444 0.281153 2.5472222 0.279907 2.5500000 0.280530 2.5527778 0.283645
+ 2.5555556 0.283645 2.5583333 0.281776 2.5611111 0.281153 2.5638889 0.278660
+ 2.5666667 0.279907 2.5694444 0.280530 2.5722222 0.281776 2.5750000 0.279907
+ 2.5777778 0.277414 2.5805556 0.273053 2.5833333 0.271184 2.5861111 0.267445
+ 2.5888889 0.266822 2.5916667 0.264953 2.5944444 0.263084 2.5972222 0.255607
+ 2.6000000 0.250000 2.6027778 0.251869 2.6055556 0.258723 2.6083333 0.268692
+ 2.6111111 0.282399 2.6138889 0.296729 2.6166667 0.316044 2.6194444 0.341589
+ 2.6222222 0.376480 2.6250000 0.409502 2.6277778 0.431308 2.6305556 0.437539
+ 2.6333333 0.426324 2.6361111 0.389564 2.6388889 0.338474 2.6416667 0.292368
+ 2.6444444 0.268069 2.6472222 0.265576 2.6500000 0.271184 2.6527778 0.279283
+ 2.6555556 0.281776 2.6583333 0.281776 2.6611111 0.280530 2.6638889 0.279283
+ 2.6666667 0.279907 2.6694444 0.282399 2.6722222 0.281776 2.6750000 0.281153
+ 2.6777778 0.279907 2.6805556 0.279283 2.6833333 0.279907 2.6861111 0.280530
+ 2.6888889 0.281776 2.6916667 0.281153 2.6944444 0.279283 2.6972222 0.278660
+ 2.7000000 0.279283 2.7027778 0.281153 2.7055556 0.279907 2.7083333 0.279283
+ 2.7111111 0.279907 2.7138889 0.279907 2.7166667 0.279283 2.7194444 0.281776
+ 2.7222222 0.282399 2.7250000 0.281776 2.7277778 0.281153 2.7305556 0.280530
+ 2.7333333 0.280530 2.7361111 0.280530 2.7388889 0.281153 2.7416667 0.281153
+ 2.7444444 0.279907 2.7472222 0.279907 2.7500000 0.280530 2.7527778 0.281153
+ 2.7555556 0.282399 2.7583333 0.283645 2.7611111 0.282399 2.7638889 0.281153
+ 2.7666667 0.281776 2.7694444 0.282399 2.7722222 0.283645 2.7750000 0.282399
+ 2.7777778 0.281153 2.7805556 0.281153 2.7833333 0.282399 2.7861111 0.283645
+ 2.7888889 0.283645 2.7916667 0.282399 2.7944444 0.281153 2.7972222 0.281776
+ 2.8000000 0.281776 2.8027778 0.284891 2.8055556 0.283645 2.8083333 0.282399
+ 2.8111111 0.281153 2.8138889 0.283022 2.8166667 0.282399 2.8194444 0.283645
+ 2.8222222 0.283022 2.8250000 0.281776 2.8277778 0.283022 2.8305556 0.283645
+ 2.8333333 0.283645 2.8361111 0.283645 2.8388889 0.283645 2.8416667 0.283022
+ 2.8444444 0.281776 2.8472222 0.281776 2.8500000 0.284891 2.8527778 0.284268
+ 2.8555556 0.283645 2.8583333 0.282399 2.8611111 0.281776 2.8638889 0.281776
+ 2.8666667 0.283645 2.8694444 0.284891 2.8722222 0.282399 2.8750000 0.283022
+ 2.8777778 0.281776 2.8805556 0.283645 2.8833333 0.283645 2.8861111 0.284891
+ 2.8888889 0.284268 2.8916667 0.282399 2.8944444 0.281153 2.8972222 0.282399
+ 2.9000000 0.282399 2.9027778 0.284268 2.9055556 0.284891 2.9083333 0.284268
+ 2.9111111 0.283645 2.9138889 0.286760 2.9166667 0.288629 2.9194444 0.290498
+ 2.9222222 0.291121 2.9250000 0.290498 2.9277778 0.289875 2.9305556 0.291121
+ 2.9333333 0.293614 2.9361111 0.294860 2.9388889 0.292991 2.9416667 0.293614
+ 2.9444444 0.294860 2.9472222 0.294860 2.9500000 0.295483 2.9527778 0.296729
+ 2.9555556 0.295483 2.9583333 0.294237 2.9611111 0.293614 2.9638889 0.293614
+ 2.9666667 0.294237 2.9694444 0.295483 2.9722222 0.294237 2.9750000 0.293614
+ 2.9777778 0.291745 2.9805556 0.293614 2.9833333 0.294860 2.9861111 0.295483
+ 2.9888889 0.296106 2.9916667 0.293614 2.9944444 0.292368 2.9972222 0.292991
+ 3.0000000 0.293614 3.0027778 0.293614 3.0055556 0.294860 3.0083333 0.292991
+ 3.0111111 0.292368 3.0138889 0.292991 3.0166667 0.293614 3.0194444 0.292991
+ 3.0222222 0.292368 3.0250000 0.291121 3.0277778 0.291745 3.0305556 0.291121
+ 3.0333333 0.293614 3.0361111 0.292991 3.0388889 0.291745 3.0416667 0.289252
+ 3.0444444 0.288006 3.0472222 0.289252 3.0500000 0.290498 3.0527778 0.290498
+ 3.0555556 0.291121 3.0583333 0.289875 3.0611111 0.288629 3.0638889 0.289252
+ 3.0666667 0.291121 3.0694444 0.290498 3.0722222 0.290498 3.0750000 0.289252
+ 3.0777778 0.287383 3.0805556 0.288006 3.0833333 0.288629 3.0861111 0.289252
+ 3.0888889 0.288629 3.0916667 0.287383 3.0944444 0.286760 3.0972222 0.287383
+ 3.1000000 0.288006 3.1027778 0.288629 3.1055556 0.288629 3.1083333 0.289252
+ 3.1111111 0.288629 3.1138889 0.288006 3.1166667 0.288629 3.1194444 0.290498
+ 3.1222222 0.288006 3.1250000 0.288006 3.1277778 0.286760 3.1305556 0.284891
+ 3.1333333 0.285514 3.1361111 0.287383 3.1388889 0.287383 3.1416667 0.286760
+ 3.1444444 0.286760 3.1472222 0.286760 3.1500000 0.288006 3.1527778 0.288006
+ 3.1555556 0.287383 3.1583333 0.287383 3.1611111 0.283022 3.1638889 0.285514
+ 3.1666667 0.285514 3.1694444 0.287383 3.1722222 0.287383 3.1750000 0.286760
+ 3.1777778 0.286137 3.1805556 0.287383 3.1833333 0.289252 3.1861111 0.289252
+ 3.1888889 0.288629 3.1916667 0.288629 3.1944444 0.288006 3.1972222 0.289252
+ 3.2000000 0.290498 3.2027778 0.294237 3.2055556 0.294237 3.2083333 0.292991
+ 3.2111111 0.292368 3.2138889 0.294860 3.2166667 0.295483 3.2194444 0.296106
+ 3.2222222 0.295483 3.2250000 0.296106 3.2277778 0.296729 3.2305556 0.297352
+ 3.2333333 0.299221 3.2361111 0.301713 3.2388889 0.299844 3.2416667 0.300467
+ 3.2444444 0.298598 3.2472222 0.298598 3.2500000 0.299844 3.2527778 0.301090
+ 3.2555556 0.298598 3.2583333 0.297352 3.2611111 0.297975 3.2638889 0.298598
+ 3.2666667 0.296729 3.2694444 0.297352 3.2722222 0.295483 3.2750000 0.298598
+ 3.2777778 0.299221 3.2805556 0.299844 3.2833333 0.297352 3.2861111 0.295483
+ 3.2888889 0.292991 3.2916667 0.291121 3.2944444 0.289875 3.2972222 0.288629
+ 3.3000000 0.287383 3.3027778 0.289252 3.3055556 0.288629 3.3083333 0.287383
+ 3.3111111 0.285514 3.3138889 0.286760 3.3166667 0.288006 3.3194444 0.288629
+ 3.3222222 0.287383 3.3250000 0.285514 3.3277778 0.284891 3.3305556 0.283645
+ 3.3333333 0.284268 3.3361111 0.284891 3.3388889 0.284891 3.3416667 0.283022
+ 3.3444444 0.283645 3.3472222 0.283645 3.3500000 0.284891 3.3527778 0.284268
+ 3.3555556 0.285514 3.3583333 0.284268 3.3611111 0.283022 3.3638889 0.284891
+ 3.3666667 0.285514 3.3694444 0.286760 3.3722222 0.286137 3.3750000 0.284268
+ 3.3777778 0.282399 3.3805556 0.281153 3.3833333 0.276791 3.3861111 0.274922
+ 3.3888889 0.269938 3.3916667 0.266199 3.3944444 0.259969 3.3972222 0.261215
+ 3.4000000 0.271184 3.4027778 0.286137 3.4055556 0.302960 3.4083333 0.323520
+ 3.4111111 0.353427 3.4138889 0.389564 3.4166667 0.418224 3.4194444 0.432555
+ 3.4222222 0.427570 3.4250000 0.397040 3.4277778 0.348442 3.4305556 0.305452
+ 3.4333333 0.278037 3.4361111 0.268069 3.4388889 0.270561 3.4416667 0.274299
+ 3.4444444 0.279283 3.4472222 0.280530 3.4500000 0.281776 3.4527778 0.281776
+ 3.4555556 0.280530 3.4583333 0.279907 3.4611111 0.277414 3.4638889 0.277414
+ 3.4666667 0.279907 3.4694444 0.281153 3.4722222 0.279907 3.4750000 0.279907
+ 3.4777778 0.278660 3.4805556 0.279907 3.4833333 0.282399 3.4861111 0.281776
+ 3.4888889 0.281153 3.4916667 0.281153 3.4944444 0.281153 3.4972222 0.281153
+ 3.5000000 0.282399 3.5027778 0.281776 3.5055556 0.281776 3.5083333 0.280530
+ 3.5111111 0.277414 3.5138889 0.279283 3.5166667 0.280530 3.5194444 0.281153
+ 3.5222222 0.280530 3.5250000 0.279907 3.5277778 0.277414 3.5305556 0.278660
+ 3.5333333 0.279907 3.5361111 0.279907 3.5388889 0.279907 3.5416667 0.279283
+ 3.5444444 0.278660 3.5472222 0.279907 3.5500000 0.278037 3.5527778 0.279907
+ 3.5555556 0.279283 3.5583333 0.279283 3.5611111 0.278037 3.5638889 0.278660
+ 3.5666667 0.279907 3.5694444 0.281153 3.5722222 0.281153 3.5750000 0.281153
+ 3.5777778 0.280530 3.5805556 0.281153 3.5833333 0.281153 3.5861111 0.279907
+ 3.5888889 0.279907 3.5916667 0.278037 3.5944444 0.276168 3.5972222 0.278660
+ 3.6000000 0.279907 3.6027778 0.281153 3.6055556 0.281776 3.6083333 0.278660
+ 3.6111111 0.279907 3.6138889 0.279907 3.6166667 0.280530 3.6194444 0.281153
+ 3.6222222 0.281153 3.6250000 0.279907 3.6277778 0.278037 3.6305556 0.278660
+ 3.6333333 0.280530 3.6361111 0.281153 3.6388889 0.280530 3.6416667 0.279907
+ 3.6444444 0.277414 3.6472222 0.277414 3.6500000 0.277414 3.6527778 0.278037
+ 3.6555556 0.277414 3.6583333 0.274299 3.6611111 0.274922 3.6638889 0.274299
+ 3.6666667 0.276168 3.6694444 0.274922 3.6722222 0.271807 3.6750000 0.273676
+ 3.6777778 0.273053 3.6805556 0.275545 3.6833333 0.276168 3.6861111 0.277414
+ 3.6888889 0.276791 3.6916667 0.274922 3.6944444 0.274299 3.6972222 0.274922
+ 3.7000000 0.276791 3.7027778 0.278037 3.7055556 0.279283 3.7083333 0.277414
+ 3.7111111 0.278037 3.7138889 0.279907 3.7166667 0.283022 3.7194444 0.284268
+ 3.7222222 0.284891 3.7250000 0.284891 3.7277778 0.284891 3.7305556 0.287383
+ 3.7333333 0.289252 3.7361111 0.291121 3.7388889 0.292368 3.7416667 0.292368
+ 3.7444444 0.290498 3.7472222 0.291745 3.7500000 0.291745 3.7527778 0.292368
+ 3.7555556 0.291745 3.7583333 0.291121 3.7611111 0.290498 3.7638889 0.291121
+ 3.7666667 0.292368 3.7694444 0.292368 3.7722222 0.293614 3.7750000 0.291745
+ 3.7777778 0.290498 3.7805556 0.291745 3.7833333 0.291121 3.7861111 0.293614
+ 3.7888889 0.292991 3.7916667 0.292368 3.7944444 0.292991 3.7972222 0.294860
+ 3.8000000 0.295483 3.8027778 0.294237 3.8055556 0.293614 3.8083333 0.292368
+ 3.8111111 0.289875 3.8138889 0.292368 3.8166667 0.292991 3.8194444 0.292991
+ 3.8222222 0.291121 3.8250000 0.289875 3.8277778 0.288629 3.8305556 0.289875
+ 3.8333333 0.291121 3.8361111 0.290498 3.8388889 0.288629 3.8416667 0.289252
+ 3.8444444 0.288006 3.8472222 0.289875 3.8500000 0.289875 3.8527778 0.290498
+ 3.8555556 0.291121 3.8583333 0.288629 3.8611111 0.288629 3.8638889 0.287383
+ 3.8666667 0.288629 3.8694444 0.289875 3.8722222 0.289252 3.8750000 0.291121
+ 3.8777778 0.288629 3.8805556 0.289252 3.8833333 0.289252 3.8861111 0.289252
+ 3.8888889 0.289252 3.8916667 0.288629 3.8944444 0.288006 3.8972222 0.289252
+ 3.9000000 0.290498 3.9027778 0.291121 3.9055556 0.289875 3.9083333 0.288629
+ 3.9111111 0.286137 3.9138889 0.287383 3.9166667 0.288006 3.9194444 0.288629
+ 3.9222222 0.290498 3.9250000 0.289875 3.9277778 0.286760 3.9305556 0.289252
+ 3.9333333 0.291121 3.9361111 0.291121 3.9388889 0.289252 3.9416667 0.289252
+ 3.9444444 0.288629 3.9472222 0.288629 3.9500000 0.289252 3.9527778 0.289252
+ 3.9555556 0.289252 3.9583333 0.288006 3.9611111 0.288006 3.9638889 0.288006
+ 3.9666667 0.289875 3.9694444 0.289875 3.9722222 0.289875 3.9750000 0.287383
+ 3.9777778 0.286760 3.9805556 0.288006 3.9833333 0.289252 3.9861111 0.290498
+ 3.9888889 0.291745 3.9916667 0.292368 3.9944444 0.292368 3.9972222 0.296106
+ 4.0000000 0.296729 4.0027778 0.298598 4.0055556 0.297975 4.0083333 0.297352
+ 4.0111111 0.297975 4.0138889 0.299221 4.0166667 0.301090 4.0194444 0.301090
+ 4.0222222 0.302960 4.0250000 0.301090 4.0277778 0.301090 4.0305556 0.302960
+ 4.0333333 0.301713 4.0361111 0.302336 4.0388889 0.301090 4.0416667 0.299844
+ 4.0444444 0.298598 4.0472222 0.300467 4.0500000 0.301713 4.0527778 0.301713
+ 4.0555556 0.299221 4.0583333 0.298598 4.0611111 0.299221 4.0638889 0.301713
+ 4.0666667 0.304829 4.0694444 0.306075 4.0722222 0.304206 4.0750000 0.301713
+ 4.0777778 0.296729 4.0805556 0.296729 4.0833333 0.294860 4.0861111 0.294860
+ 4.0888889 0.291745 4.0916667 0.289252 4.0944444 0.288006 4.0972222 0.288006
+ 4.1000000 0.287383 4.1027778 0.286760 4.1055556 0.286760 4.1083333 0.288006
+ 4.1111111 0.286137 4.1138889 0.287383 4.1166667 0.288006 4.1194444 0.288006
+ 4.1222222 0.287383 4.1250000 0.286137 4.1277778 0.284268 4.1305556 0.286137
+ 4.1333333 0.284268 4.1361111 0.287383 4.1388889 0.288006 4.1416667 0.285514
+ 4.1444444 0.283022 4.1472222 0.285514 4.1500000 0.287383 4.1527778 0.286760
+ 4.1555556 0.286760 4.1583333 0.286137 4.1611111 0.283022 4.1638889 0.281776
+ 4.1666667 0.281153 4.1694444 0.277414 4.1722222 0.273676 4.1750000 0.271184
+ 4.1777778 0.266822 4.1805556 0.262461 4.1833333 0.263084 4.1861111 0.268692
+ 4.1888889 0.279907 4.1916667 0.293614 4.1944444 0.310436 4.1972222 0.335358
+ 4.2000000 0.369626 4.2027778 0.404517 4.2055556 0.430062 4.2083333 0.440654
+ 4.2111111 0.429439 4.2138889 0.395171 4.2166667 0.346573 4.2194444 0.303583
+ 4.2222222 0.277414 4.2250000 0.268069 4.2277778 0.269315 4.2305556 0.274299
+ 4.2333333 0.280530 4.2361111 0.281776 4.2388889 0.281153 4.2416667 0.281153
+ 4.2444444 0.280530 4.2472222 0.281776 4.2500000 0.283022 4.2527778 0.282399
+ 4.2555556 0.282399 4.2583333 0.280530 4.2611111 0.279283 4.2638889 0.279283
+ 4.2666667 0.281776 4.2694444 0.281776 4.2722222 0.279907 4.2750000 0.279907
+ 4.2777778 0.278660 4.2805556 0.279283 4.2833333 0.281153 4.2861111 0.281153
+ 4.2888889 0.280530 4.2916667 0.278660 4.2944444 0.278660 4.2972222 0.278660
+ 4.3000000 0.280530 4.3027778 0.281776 4.3055556 0.281776 4.3083333 0.279283
+ 4.3111111 0.278660 4.3138889 0.279907 4.3166667 0.281153 4.3194444 0.281153
+ 4.3222222 0.281153 4.3250000 0.279907 4.3277778 0.279283 4.3305556 0.279283
+ 4.3333333 0.280530 4.3361111 0.281776 4.3388889 0.281153 4.3416667 0.279283
+ 4.3444444 0.277414 4.3472222 0.278660 4.3500000 0.279907 4.3527778 0.279283
+ 4.3555556 0.279907 4.3583333 0.278660 4.3611111 0.277414 4.3638889 0.277414
+ 4.3666667 0.279283 4.3694444 0.281153 4.3722222 0.281776 4.3750000 0.280530
+ 4.3777778 0.279283 4.3805556 0.279283 4.3833333 0.280530 4.3861111 0.281776
+ 4.3888889 0.279283 4.3916667 0.278037 4.3944444 0.278037 4.3972222 0.278660
+ 4.4000000 0.278660 4.4027778 0.279907 4.4055556 0.278037 4.4083333 0.278660
+ 4.4111111 0.277414 4.4138889 0.279283 4.4166667 0.280530 4.4194444 0.279907
+ 4.4222222 0.280530 4.4250000 0.280530 4.4277778 0.279283 4.4305556 0.280530
+ 4.4333333 0.281153 4.4361111 0.281153 4.4388889 0.279907 4.4416667 0.279283
+ 4.4444444 0.277414 4.4472222 0.277414 4.4500000 0.279283 4.4527778 0.279283
+ 4.4555556 0.278037 4.4583333 0.276791 4.4611111 0.274922 4.4638889 0.275545
+ 4.4666667 0.276168 4.4694444 0.276791 4.4722222 0.276791 4.4750000 0.274299
+ 4.4777778 0.274922 4.4805556 0.274922 4.4833333 0.276168 4.4861111 0.276168
+ 4.4888889 0.274922 4.4916667 0.275545 4.4944444 0.274299 4.4972222 0.276791
+ 4.5000000 0.276791 4.5027778 0.278660 4.5055556 0.280530 4.5083333 0.280530
+ 4.5111111 0.282399 4.5138889 0.284891 4.5166667 0.288629 4.5194444 0.289252
+ 4.5222222 0.289875 4.5250000 0.289252 4.5277778 0.289252 4.5305556 0.291745
+ 4.5333333 0.293614 4.5361111 0.294860 4.5388889 0.294237 4.5416667 0.294237
+ 4.5444444 0.291745 4.5472222 0.293614 4.5500000 0.294860 4.5527778 0.295483
+ 4.5555556 0.292991 4.5583333 0.294237 4.5611111 0.293614 4.5638889 0.294237
+ 4.5666667 0.295483 4.5694444 0.296106 4.5722222 0.296106 4.5750000 0.294237
+ 4.5777778 0.294237 4.5805556 0.294860 4.5833333 0.296729 4.5861111 0.296729
+ 4.5888889 0.296729 4.5916667 0.296106 4.5944444 0.294237 4.5972222 0.294860
+ 4.6000000 0.296106 4.6027778 0.296106 4.6055556 0.294237 4.6083333 0.293614
+ 4.6111111 0.292368 4.6138889 0.293614 4.6166667 0.293614 4.6194444 0.294860
+ 4.6222222 0.294237 4.6250000 0.292991 4.6277778 0.292368 4.6305556 0.291745
+ 4.6333333 0.293614 4.6361111 0.292991 4.6388889 0.292368 4.6416667 0.291745
+ 4.6444444 0.289875 4.6472222 0.289875 4.6500000 0.291121 4.6527778 0.291745
+ 4.6555556 0.291121 4.6583333 0.291121 4.6611111 0.289875 4.6638889 0.290498
+ 4.6666667 0.291745 4.6694444 0.290498 4.6722222 0.291121 4.6750000 0.289252
+ 4.6777778 0.289252 4.6805556 0.290498 4.6833333 0.291745 4.6861111 0.291745
+ 4.6888889 0.291745 4.6916667 0.289252 4.6944444 0.288629 4.6972222 0.289252
+ 4.7000000 0.290498 4.7027778 0.289875 4.7055556 0.289875 4.7083333 0.289252
+ 4.7111111 0.288629 4.7138889 0.289252 4.7166667 0.289875 4.7194444 0.289875
+ 4.7222222 0.290498 4.7250000 0.289875 4.7277778 0.289252 4.7305556 0.289875
+ 4.7333333 0.291121 4.7361111 0.292368 4.7388889 0.289875 4.7416667 0.291121
+ 4.7444444 0.288629 4.7472222 0.289252 4.7500000 0.291745 4.7527778 0.290498
+ 4.7555556 0.289252 4.7583333 0.289252 4.7611111 0.288629 4.7638889 0.289252
+ 4.7666667 0.289252 4.7694444 0.290498 4.7722222 0.290498 4.7750000 0.289252
+ 4.7777778 0.289252 4.7805556 0.289875 4.7833333 0.291121 4.7861111 0.291121
+ 4.7888889 0.291121 4.7916667 0.289252 4.7944444 0.289252 4.7972222 0.290498
+ 4.8000000 0.291121 4.8027778 0.292368 4.8055556 0.292368 4.8083333 0.293614
+ 4.8111111 0.291121 4.8138889 0.292991 4.8166667 0.296106 4.8194444 0.298598
+ 4.8222222 0.298598 4.8250000 0.297975 4.8277778 0.297352 4.8305556 0.298598
+ 4.8333333 0.301090 4.8361111 0.301713 4.8388889 0.302336 4.8416667 0.302960
+ 4.8444444 0.302960 4.8472222 0.303583 4.8500000 0.305452 4.8527778 0.304829
+ 4.8555556 0.304829 4.8583333 0.302336 4.8611111 0.301090 4.8638889 0.300467
+ 4.8666667 0.301713 4.8694444 0.303583 4.8722222 0.300467 4.8750000 0.300467
+ 4.8777778 0.299221 4.8805556 0.301090 4.8833333 0.304206 4.8861111 0.305452
+ 4.8888889 0.302960 4.8916667 0.298598 4.8944444 0.296106 4.8972222 0.294860
+ 4.9000000 0.292991 4.9027778 0.292368 4.9055556 0.290498 4.9083333 0.289252
+ 4.9111111 0.289875 4.9138889 0.290498 4.9166667 0.289252 4.9194444 0.289252
+ 4.9222222 0.288629 4.9250000 0.288006 4.9277778 0.287383 4.9305556 0.288006
+ 4.9333333 0.288629 4.9361111 0.290498 4.9388889 0.289875 4.9416667 0.288629
+ 4.9444444 0.287383 4.9472222 0.287383 4.9500000 0.287383 4.9527778 0.288629
+ 4.9555556 0.288006 4.9583333 0.287383 4.9611111 0.286137 4.9638889 0.288006
+ 4.9666667 0.288006 4.9694444 0.288006 4.9722222 0.288006 4.9750000 0.287383
+ 4.9777778 0.286137 4.9805556 0.284891 4.9833333 0.284268 4.9861111 0.279907
+ 4.9888889 0.274922 4.9916667 0.270561 4.9944444 0.268692 4.9972222 0.265576
+ 5.0000000 0.263707 5.0027778 0.267445 5.0055556 0.278660 5.0083333 0.295483
+ 5.0111111 0.313551 5.0138889 0.338474 5.0166667 0.367757 5.0194444 0.402648
+ 5.0222222 0.431308 5.0250000 0.448131 5.0277778 0.445016 5.0305556 0.426947
+ 5.0333333 0.385826 5.0361111 0.332866 5.0388889 0.293614 5.0416667 0.274922
+ 5.0444444 0.271807 5.0472222 0.277414 5.0500000 0.283022 5.0527778 0.285514
+ 5.0555556 0.285514 5.0583333 0.284268 5.0611111 0.283022 5.0638889 0.283022
+ 5.0666667 0.283645 5.0694444 0.284268 5.0722222 0.284891 5.0750000 0.284268
+ 5.0777778 0.282399 5.0805556 0.282399 5.0833333 0.283645 5.0861111 0.284268
+ 5.0888889 0.284268 5.0916667 0.282399 5.0944444 0.281153 5.0972222 0.282399
+ 5.1000000 0.282399 5.1027778 0.281776 5.1055556 0.282399 5.1083333 0.281153
+ 5.1111111 0.279283 5.1138889 0.280530 5.1166667 0.281153 5.1194444 0.283022
+ 5.1222222 0.281153 5.1250000 0.281153 5.1277778 0.280530 5.1305556 0.280530
+ 5.1333333 0.281153 5.1361111 0.281776 5.1388889 0.281776 5.1416667 0.281153
+ 5.1444444 0.279907 5.1472222 0.281776 5.1500000 0.282399 5.1527778 0.283645
+ 5.1555556 0.283645 5.1583333 0.283022 5.1611111 0.281776 5.1638889 0.282399
+ 5.1666667 0.284268 5.1694444 0.284268 5.1722222 0.284268 5.1750000 0.283645
+ 5.1777778 0.282399 5.1805556 0.284268 5.1833333 0.281776 5.1861111 0.283645
+ 5.1888889 0.284268 5.1916667 0.283022 5.1944444 0.281776 5.1972222 0.281776
+ 5.2000000 0.282399 5.2027778 0.283645 5.2055556 0.283645 5.2083333 0.282399
+ 5.2111111 0.281153 5.2138889 0.281776 5.2166667 0.282399 5.2194444 0.283645
+ 5.2222222 0.283022 5.2250000 0.282399 5.2277778 0.281776 5.2305556 0.283022
+ 5.2333333 0.283022 5.2361111 0.284268 5.2388889 0.284268 5.2416667 0.284891
+ 5.2444444 0.281776 5.2472222 0.284891 5.2500000 0.284891 5.2527778 0.285514
+ 5.2555556 0.283645 5.2583333 0.283022 5.2611111 0.280530 5.2638889 0.281776
+ 5.2666667 0.283645 5.2694444 0.283645 5.2722222 0.284268 5.2750000 0.282399
+ 5.2777778 0.281776 5.2805556 0.281776 5.2833333 0.281776 5.2861111 0.281776
+ 5.2888889 0.283645 5.2916667 0.282399 5.2944444 0.281153 5.2972222 0.283022
+ 5.3000000 0.284268 5.3027778 0.283645 5.3055556 0.283645 5.3083333 0.281776
+ 5.3111111 0.279907 5.3138889 0.283645 5.3166667 0.284268 5.3194444 0.285514
+ 5.3222222 0.283645 5.3250000 0.282399 5.3277778 0.283022 5.3305556 0.284268
+ 5.3333333 0.285514 5.3361111 0.287383 5.3388889 0.287383 5.3416667 0.289252
+ 5.3444444 0.289252 5.3472222 0.291121 5.3500000 0.291745 5.3527778 0.293614
+ 5.3555556 0.294860 5.3583333 0.294860 5.3611111 0.293614 5.3638889 0.295483
+ 5.3666667 0.296729 5.3694444 0.295483 5.3722222 0.295483 5.3750000 0.295483
+ 5.3777778 0.294237 5.3805556 0.294237 5.3833333 0.295483 5.3861111 0.296106
+ 5.3888889 0.295483 5.3916667 0.294860 5.3944444 0.294237 5.3972222 0.294237
+ 5.4000000 0.295483 5.4027778 0.295483 5.4055556 0.294860 5.4083333 0.294237
+ 5.4111111 0.292991 5.4138889 0.293614 5.4166667 0.294860 5.4194444 0.295483
+ 5.4222222 0.294860 5.4250000 0.294860 5.4277778 0.293614 5.4305556 0.294860
+ 5.4333333 0.295483 5.4361111 0.296106 5.4388889 0.295483 5.4416667 0.294237
+ 5.4444444 0.291745 5.4472222 0.292368 5.4500000 0.294860 5.4527778 0.296729
+ 5.4555556 0.296729 5.4583333 0.296106 5.4611111 0.294860 5.4638889 0.294860
+ 5.4666667 0.296729 5.4694444 0.297352 5.4722222 0.297352 5.4750000 0.297352
+ 5.4777778 0.295483 5.4805556 0.297352 5.4833333 0.299844 5.4861111 0.301090
+ 5.4888889 0.301090 5.4916667 0.299221 5.4944444 0.299221 5.4972222 0.299844
+ 5.5000000 0.303583 5.5027778 0.302960 5.5055556 0.299844 5.5083333 0.298598
+ 5.5111111 0.301713 5.5138889 0.304829 5.5166667 0.304206 5.5194444 0.302960
+ 5.5222222 0.301713 5.5250000 0.300467 5.5277778 0.300467 5.5305556 0.299844
+ 5.5333333 0.299221 5.5361111 0.296729 5.5388889 0.294860 5.5416667 0.291121
+ 5.5444444 0.290498 5.5472222 0.290498 5.5500000 0.291745 5.5527778 0.289252
+ 5.5555556 0.288006 5.5583333 0.287383 5.5611111 0.285514 5.5638889 0.284891
+ 5.5666667 0.285514 5.5694444 0.286760 5.5722222 0.286137 5.5750000 0.283645
+ 5.5777778 0.282399 5.5805556 0.283645 5.5833333 0.284268 5.5861111 0.284891
+ 5.5888889 0.284891 5.5916667 0.284268 5.5944444 0.283022 5.5972222 0.285514
+ 5.6000000 0.286760 5.6027778 0.286137 5.6055556 0.286137 5.6083333 0.286760
+ 5.6111111 0.284891 5.6138889 0.286760 5.6166667 0.286760 5.6194444 0.288006
+ 5.6222222 0.286137 5.6250000 0.286760 5.6277778 0.283645 5.6305556 0.284891
+ 5.6333333 0.283645 5.6361111 0.280530 5.6388889 0.276791 5.6416667 0.271184
+ 5.6444444 0.265576 5.6472222 0.265576 5.6500000 0.261838 5.6527778 0.259346
+ 5.6555556 0.263084 5.6583333 0.274922 5.6611111 0.292368 5.6638889 0.312928
+ 5.6666667 0.333489 5.6694444 0.362773 5.6722222 0.393925 5.6750000 0.421963
+ 5.6777778 0.435670 5.6805556 0.439408 5.6833333 0.421963 5.6861111 0.380218
+ 5.6888889 0.327259 5.6916667 0.288629 5.6944444 0.270561 5.6972222 0.271807
+ 5.7000000 0.278660 5.7027778 0.283645 5.7055556 0.284891 5.7083333 0.282399
+ 5.7111111 0.280530 5.7138889 0.283022 5.7166667 0.281776 5.7194444 0.283645
+ 5.7222222 0.282399 5.7250000 0.281153 5.7277778 0.279907 5.7305556 0.281776
+ 5.7333333 0.283022 5.7361111 0.282399 5.7388889 0.282399 5.7416667 0.281153
+ 5.7444444 0.280530 5.7472222 0.279907 5.7500000 0.280530 5.7527778 0.281776
+ 5.7555556 0.281776 5.7583333 0.281153 5.7611111 0.280530 5.7638889 0.281776
+ 5.7666667 0.282399 5.7694444 0.281776 5.7722222 0.282399 5.7750000 0.279283
+ 5.7777778 0.278037 5.7805556 0.279907 5.7833333 0.279283 5.7861111 0.281776
+ 5.7888889 0.281776 5.7916667 0.281776 5.7944444 0.280530 5.7972222 0.280530
+ 5.8000000 0.281776 5.8027778 0.283645 5.8055556 0.283022 5.8083333 0.281153
+ 5.8111111 0.280530 5.8138889 0.281776 5.8166667 0.280530 5.8194444 0.281776
+ 5.8222222 0.281153 5.8250000 0.279283 5.8277778 0.278660 5.8305556 0.279907
+ 5.8333333 0.282399 5.8361111 0.282399 5.8388889 0.283022 5.8416667 0.280530
+ 5.8444444 0.280530 5.8472222 0.281153 5.8500000 0.281776 5.8527778 0.283022
+ 5.8555556 0.283645 5.8583333 0.281153 5.8611111 0.281153 5.8638889 0.282399
+ 5.8666667 0.283022 5.8694444 0.283645 5.8722222 0.282399 5.8750000 0.281776
+ 5.8777778 0.280530 5.8805556 0.280530 5.8833333 0.282399 5.8861111 0.283022
+ 5.8888889 0.281153 5.8916667 0.281776 5.8944444 0.280530 5.8972222 0.281153
+ 5.9000000 0.282399 5.9027778 0.283022 5.9055556 0.282399 5.9083333 0.281153
+ 5.9111111 0.279907 5.9138889 0.280530 5.9166667 0.281776 5.9194444 0.283022
+ 5.9222222 0.283022 5.9250000 0.282399 5.9277778 0.279907 5.9305556 0.281153
+ 5.9333333 0.280530 5.9361111 0.281776 5.9388889 0.280530 5.9416667 0.279907
+ 5.9444444 0.277414 5.9472222 0.278037 5.9500000 0.279907 5.9527778 0.280530
+ 5.9555556 0.279907 5.9583333 0.279907 5.9611111 0.278660 5.9638889 0.280530
+ 5.9666667 0.281776 5.9694444 0.283022 5.9722222 0.282399 5.9750000 0.281153
+ 5.9777778 0.279907 5.9805556 0.281776 5.9833333 0.284268 5.9861111 0.284268
+ 5.9888889 0.284268 5.9916667 0.282399 5.9944444 0.284268 5.9972222 0.286137
+ 6.0000000 0.287383 6.0027778 0.288006 6.0055556 0.288629 6.0083333 0.288006
+ 6.0111111 0.286137 6.0138889 0.288629 6.0166667 0.289875 6.0194444 0.291745
+ 6.0222222 0.292368 6.0250000 0.292368 6.0277778 0.290498 6.0305556 0.291121
+ 6.0333333 0.291745 6.0361111 0.292368 6.0388889 0.292368 6.0416667 0.289252
+ 6.0444444 0.289875 6.0472222 0.287383 6.0500000 0.289875 6.0527778 0.291121
+ 6.0555556 0.291121 6.0583333 0.292368 6.0611111 0.291745 6.0638889 0.291745
+ 6.0666667 0.292991 6.0694444 0.292368 6.0722222 0.292368 6.0750000 0.291121
+ 6.0777778 0.290498 6.0805556 0.289875 6.0833333 0.291121 6.0861111 0.292368
+ 6.0888889 0.291121 6.0916667 0.289875 6.0944444 0.289875 6.0972222 0.289252
+ 6.1000000 0.291121 6.1027778 0.291121 6.1055556 0.291745 6.1083333 0.289252
+ 6.1111111 0.288006 6.1138889 0.288629 6.1166667 0.289252 6.1194444 0.287383
+ 6.1222222 0.286137 6.1250000 0.284891 6.1277778 0.284268 6.1305556 0.287383
+ 6.1333333 0.288006 6.1361111 0.288006 6.1388889 0.287383 6.1416667 0.285514
+ 6.1444444 0.284891 6.1472222 0.285514 6.1500000 0.285514 6.1527778 0.287383
+ 6.1555556 0.286137 6.1583333 0.284891 6.1611111 0.286760 6.1638889 0.285514
+ 6.1666667 0.286760 6.1694444 0.288006 6.1722222 0.287383 6.1750000 0.286137
+ 6.1777778 0.284268 6.1805556 0.286760 6.1833333 0.286760 6.1861111 0.286760
+ 6.1888889 0.287383 6.1916667 0.286760 6.1944444 0.286137 6.1972222 0.285514
+ 6.2000000 0.287383 6.2027778 0.286137 6.2055556 0.286760 6.2083333 0.285514
+ 6.2111111 0.284268 6.2138889 0.286137 6.2166667 0.286137 6.2194444 0.286760
+ 6.2222222 0.286137 6.2250000 0.285514 6.2277778 0.281776 6.2305556 0.282399
+ 6.2333333 0.285514 6.2361111 0.285514 6.2388889 0.284268 6.2416667 0.284268
+ 6.2444444 0.281776 6.2472222 0.283645 6.2500000 0.284268 6.2527778 0.286760
+ 6.2555556 0.288006 6.2583333 0.287383 6.2611111 0.285514 6.2638889 0.285514
+ 6.2666667 0.286760 6.2694444 0.286760 6.2722222 0.288629 6.2750000 0.285514
+ 6.2777778 0.284891 6.2805556 0.284891 6.2833333 0.285514 6.2861111 0.285514
+ 6.2888889 0.284891 6.2916667 0.283645 6.2944444 0.282399 6.2972222 0.282399
+ 6.3000000 0.284891 6.3027778 0.284268 6.3055556 0.283645 6.3083333 0.284268
+ 6.3111111 0.283645 6.3138889 0.284891 6.3166667 0.286137 6.3194444 0.286137
+ 6.3222222 0.285514 6.3250000 0.284891 6.3277778 0.284268 6.3305556 0.285514
+ 6.3333333 0.286760 6.3361111 0.288006 6.3388889 0.287383 6.3416667 0.288006
+ 6.3444444 0.286760 6.3472222 0.287383 6.3500000 0.286760 6.3527778 0.285514
+ 6.3555556 0.286760 6.3583333 0.285514 6.3611111 0.284268 6.3638889 0.285514
+ 6.3666667 0.285514 6.3694444 0.286137 6.3722222 0.285514 6.3750000 0.283645
+ 6.3777778 0.283645 6.3805556 0.284268 6.3833333 0.286760 6.3861111 0.286137
+ 6.3888889 0.285514 6.3916667 0.284891 6.3944444 0.283645 6.3972222 0.284268
+ 6.4000000 0.284891 6.4027778 0.285514 6.4055556 0.286137 6.4083333 0.285514
+ 6.4111111 0.285514 6.4138889 0.286760 6.4166667 0.288006 6.4194444 0.287383
+ 6.4222222 0.287383 6.4250000 0.286137 6.4277778 0.285514 6.4305556 0.285514
+ 6.4333333 0.284891 6.4361111 0.287383 6.4388889 0.286137 6.4416667 0.286760
+ 6.4444444 0.285514 6.4472222 0.286137 6.4500000 0.285514 6.4527778 0.287383
+ 6.4555556 0.288629 6.4583333 0.289252 6.4611111 0.289252 6.4638889 0.291745
+ 6.4666667 0.292368 6.4694444 0.292991 6.4722222 0.292368 6.4750000 0.293614
+ 6.4777778 0.292368 6.4805556 0.294860 6.4833333 0.296106 6.4861111 0.297352
+ 6.4888889 0.298598 6.4916667 0.298598 6.4944444 0.297975 6.4972222 0.297352
+ 6.5000000 0.298598 6.5027778 0.298598 6.5055556 0.297975 6.5083333 0.295483
+ 6.5111111 0.294237 6.5138889 0.295483 6.5166667 0.296729 6.5194444 0.298598
+ 6.5222222 0.296106 6.5250000 0.294237 6.5277778 0.290498 6.5305556 0.292991
+ 6.5333333 0.293614 6.5361111 0.296729 6.5388889 0.297352 6.5416667 0.296729
+ 6.5444444 0.294860 6.5472222 0.292991 6.5500000 0.291745 6.5527778 0.291121
+ 6.5555556 0.290498 6.5583333 0.286760 6.5611111 0.284268 6.5638889 0.284891
+ 6.5666667 0.284891 6.5694444 0.284891 6.5722222 0.284268 6.5750000 0.284268
+ 6.5777778 0.284268 6.5805556 0.283022 6.5833333 0.285514 6.5861111 0.283645
+ 6.5888889 0.283645 6.5916667 0.280530 6.5944444 0.278037 6.5972222 0.279907
+ 6.6000000 0.280530 6.6027778 0.282399 6.6055556 0.283022 6.6083333 0.280530
+ 6.6111111 0.278660 6.6138889 0.279907 6.6166667 0.281153 6.6194444 0.281153
+ 6.6222222 0.281153 6.6250000 0.279283 6.6277778 0.276791 6.6305556 0.275545
+ 6.6333333 0.273676 6.6361111 0.269315 6.6388889 0.269938 6.6416667 0.265576
+ 6.6444444 0.259346 6.6472222 0.258723 6.6500000 0.264953 6.6527778 0.278037
+ 6.6555556 0.292368 6.6583333 0.306698 6.6611111 0.327882 6.6638889 0.357788
+ 6.6666667 0.390810 6.6694444 0.419470 6.6722222 0.435670 6.6750000 0.440654
+ 6.6777778 0.428816 6.6805556 0.400156 6.6833333 0.358411 6.6861111 0.321651
+ 6.6888889 0.294860 6.6916667 0.277414 6.6944444 0.268069 6.6972222 0.261838
+ 6.7000000 0.263707 6.7027778 0.268069 6.7055556 0.272430 6.7083333 0.274299
+ 6.7111111 0.274299 6.7138889 0.276168 6.7166667 0.278037 6.7194444 0.279283
+ 6.7222222 0.279283 6.7250000 0.278660 6.7277778 0.278037 6.7305556 0.277414
+ 6.7333333 0.278037 6.7361111 0.276791 6.7388889 0.276791 6.7416667 0.275545
+ 6.7444444 0.274299 6.7472222 0.274299 6.7500000 0.276791 6.7527778 0.276791
+ 6.7555556 0.276791 6.7583333 0.274922 6.7611111 0.274922 6.7638889 0.275545
+ 6.7666667 0.277414 6.7694444 0.276791 6.7722222 0.276791 6.7750000 0.277414
+ 6.7777778 0.274922 6.7805556 0.274922 6.7833333 0.276791 6.7861111 0.276168
+ 6.7888889 0.276168 6.7916667 0.274922 6.7944444 0.274922 6.7972222 0.276168
+ 6.8000000 0.276791 6.8027778 0.277414 6.8055556 0.276791 6.8083333 0.276791
+ 6.8111111 0.275545 6.8138889 0.278037 6.8166667 0.276791 6.8194444 0.277414
+ 6.8222222 0.276791 6.8250000 0.275545 6.8277778 0.275545 6.8305556 0.276791
+ 6.8333333 0.276791 6.8361111 0.278660 6.8388889 0.277414 6.8416667 0.276791
+ 6.8444444 0.273676 6.8472222 0.274922 6.8500000 0.274922 6.8527778 0.276791
+ 6.8555556 0.276791 6.8583333 0.275545 6.8611111 0.275545 6.8638889 0.276168
+ 6.8666667 0.276791 6.8694444 0.278660 6.8722222 0.278660 6.8750000 0.277414
+ 6.8777778 0.277414 6.8805556 0.278037 6.8833333 0.279907 6.8861111 0.279907
+ 6.8888889 0.278660 6.8916667 0.278660 6.8944444 0.277414 6.8972222 0.276791
+ 6.9000000 0.279907 6.9027778 0.279907 6.9055556 0.279907 6.9083333 0.279907
+ 6.9111111 0.276791 6.9138889 0.278660 6.9166667 0.279283 6.9194444 0.278660
+ 6.9222222 0.276791 6.9250000 0.274922 6.9277778 0.272430 6.9305556 0.273053
+ 6.9333333 0.274299 6.9361111 0.273676 6.9388889 0.273053 6.9416667 0.272430
+ 6.9444444 0.269938 6.9472222 0.268692 6.9500000 0.271184 6.9527778 0.269315
+ 6.9555556 0.268069 6.9583333 0.268692 6.9611111 0.266199 6.9638889 0.268069
+ 6.9666667 0.269938 6.9694444 0.269315 6.9722222 0.269938 6.9750000 0.268069
+ 6.9777778 0.268069 6.9805556 0.269315 6.9833333 0.270561 6.9861111 0.273053
+ 6.9888889 0.273053 6.9916667 0.271807 6.9944444 0.272430 6.9972222 0.275545
+ 7.0000000 0.276791 7.0027778 0.277414 7.0055556 0.279283 7.0083333 0.279283
+ 7.0111111 0.280530 7.0138889 0.281776 7.0166667 0.283022 7.0194444 0.286137
+ 7.0222222 0.286760 7.0250000 0.286137 7.0277778 0.286760 7.0305556 0.288006
+ 7.0333333 0.289252 7.0361111 0.289875 7.0388889 0.292368 7.0416667 0.290498
+ 7.0444444 0.291121 7.0472222 0.292368 7.0500000 0.292991 7.0527778 0.292368
+ 7.0555556 0.292368 7.0583333 0.291745 7.0611111 0.289252 7.0638889 0.291745
+ 7.0666667 0.291121 7.0694444 0.291121 7.0722222 0.290498 7.0750000 0.289875
+ 7.0777778 0.289875 7.0805556 0.289875 7.0833333 0.291745 7.0861111 0.291745
+ 7.0888889 0.291121 7.0916667 0.289875 7.0944444 0.289252 7.0972222 0.289875
+ 7.1000000 0.289875 7.1027778 0.291121 7.1055556 0.290498 7.1083333 0.289252
+ 7.1111111 0.288629 7.1138889 0.289252 7.1166667 0.291121 7.1194444 0.290498
+ 7.1222222 0.290498 7.1250000 0.288629 7.1277778 0.288629 7.1305556 0.289875
+ 7.1333333 0.289875 7.1361111 0.290498 7.1388889 0.290498 7.1416667 0.289875
+ 7.1444444 0.286760 7.1472222 0.287383 7.1500000 0.287383 7.1527778 0.288629
+ 7.1555556 0.287383 7.1583333 0.286137 7.1611111 0.286137 7.1638889 0.286137
+ 7.1666667 0.287383 7.1694444 0.288629 7.1722222 0.288629 7.1750000 0.287383
+ 7.1777778 0.286137 7.1805556 0.288006 7.1833333 0.288629 7.1861111 0.289252
+ 7.1888889 0.288629 7.1916667 0.287383 7.1944444 0.286760 7.1972222 0.286760
+ 7.2000000 0.288006 7.2027778 0.288629 7.2055556 0.289252 7.2083333 0.285514
+ 7.2111111 0.286137 7.2138889 0.287383 7.2166667 0.288629 7.2194444 0.287383
+ 7.2222222 0.286760 7.2250000 0.285514 7.2277778 0.283022 7.2305556 0.284268
+ 7.2333333 0.287383 7.2361111 0.287383 7.2388889 0.286760 7.2416667 0.286137
+ 7.2444444 0.284891 7.2472222 0.285514 7.2500000 0.287383 7.2527778 0.287383
+ 7.2555556 0.286760 7.2583333 0.285514 7.2611111 0.285514 7.2638889 0.286760
+ 7.2666667 0.286137 7.2694444 0.288006 7.2722222 0.287383 7.2750000 0.286137
+ 7.2777778 0.286137 7.2805556 0.286137 7.2833333 0.288006 7.2861111 0.288006
+ 7.2888889 0.287383 7.2916667 0.284891 7.2944444 0.284268 7.2972222 0.286760
+ 7.3000000 0.289252 7.3027778 0.290498 7.3055556 0.291121 7.3083333 0.293614
+ 7.3111111 0.292368 7.3138889 0.293614 7.3166667 0.292991 7.3194444 0.294860
+ 7.3222222 0.296106 7.3250000 0.297975 7.3277778 0.296106 7.3305556 0.297352
+ 7.3333333 0.297975 7.3361111 0.299221 7.3388889 0.299844 7.3416667 0.298598
+ 7.3444444 0.297352 7.3472222 0.297975 7.3500000 0.297975 7.3527778 0.299221
+ 7.3555556 0.297975 7.3583333 0.295483 7.3611111 0.295483 7.3638889 0.296106
+ 7.3666667 0.294860 7.3694444 0.295483 7.3722222 0.298598 7.3750000 0.299844
+ 7.3777778 0.299844 7.3805556 0.297975 7.3833333 0.294860 7.3861111 0.294237
+ 7.3888889 0.292991 7.3916667 0.290498 7.3944444 0.288629 7.3972222 0.286137
+ 7.4000000 0.286760 7.4027778 0.286137 7.4055556 0.286137 7.4083333 0.283645
+ 7.4111111 0.282399 7.4138889 0.283022 7.4166667 0.285514 7.4194444 0.286760
+ 7.4222222 0.285514 7.4250000 0.284891 7.4277778 0.284268 7.4305556 0.284268
+ 7.4333333 0.284891 7.4361111 0.285514 7.4388889 0.284891 7.4416667 0.284268
+ 7.4444444 0.282399 7.4472222 0.282399 7.4500000 0.284891 7.4527778 0.285514
+ 7.4555556 0.283022 7.4583333 0.282399 7.4611111 0.281153 7.4638889 0.281153
+ 7.4666667 0.282399 7.4694444 0.283022 7.4722222 0.281153 7.4750000 0.277414
+ 7.4777778 0.272430 7.4805556 0.268069 7.4833333 0.266199 7.4861111 0.264330
+ 7.4888889 0.260592 7.4916667 0.257477 7.4944444 0.264330 7.4972222 0.279283
+ 7.5000000 0.298598 7.5027778 0.317290 7.5055556 0.343458 7.5083333 0.374611
+ 7.5111111 0.405140 7.5138889 0.431308 7.5166667 0.441277 7.5194444 0.433801
+ 7.5222222 0.402648 7.5250000 0.353427 7.5277778 0.304829 7.5305556 0.274299
+ 7.5333333 0.264953 7.5361111 0.268692 7.5388889 0.272430 7.5416667 0.276168
+ 7.5444444 0.278660 7.5472222 0.278660 7.5500000 0.278660 7.5527778 0.280530
+ 7.5555556 0.281153 7.5583333 0.279907 7.5611111 0.277414 7.5638889 0.276168
+ 7.5666667 0.278660 7.5694444 0.278660 7.5722222 0.278660 7.5750000 0.278660
+ 7.5777778 0.276791 7.5805556 0.278037 7.5833333 0.279283 7.5861111 0.279907
+ 7.5888889 0.278037 7.5916667 0.279283 7.5944444 0.278037 7.5972222 0.280530
+ 7.6000000 0.281153 7.6027778 0.282399 7.6055556 0.280530 7.6083333 0.280530
+ 7.6111111 0.280530 7.6138889 0.280530 7.6166667 0.281153 7.6194444 0.280530
+ 7.6222222 0.280530 7.6250000 0.280530 7.6277778 0.279283 7.6305556 0.281153
+ 7.6333333 0.279283 7.6361111 0.280530 7.6388889 0.281153 7.6416667 0.279907
+ 7.6444444 0.279283 7.6472222 0.278660 7.6500000 0.279907 7.6527778 0.280530
+ 7.6555556 0.281153 7.6583333 0.279907 7.6611111 0.278660 7.6638889 0.279907
+ 7.6666667 0.278660 7.6694444 0.279283 7.6722222 0.279907 7.6750000 0.279907
+ 7.6777778 0.279283 7.6805556 0.279907 7.6833333 0.280530 7.6861111 0.281153
+ 7.6888889 0.279907 7.6916667 0.279907 7.6944444 0.280530 7.6972222 0.281153
+ 7.7000000 0.281776 7.7027778 0.281153 7.7055556 0.281776 7.7083333 0.281153
+ 7.7111111 0.278037 7.7138889 0.278660 7.7166667 0.279907 7.7194444 0.280530
+ 7.7222222 0.280530 7.7250000 0.278660 7.7277778 0.278037 7.7305556 0.279283
+ 7.7333333 0.281153 7.7361111 0.280530 7.7388889 0.279907 7.7416667 0.278660
+ 7.7444444 0.276168 7.7472222 0.278660 7.7500000 0.278660 7.7527778 0.280530
+ 7.7555556 0.279907 7.7583333 0.278037 7.7611111 0.276791 7.7638889 0.277414
+ 7.7666667 0.279283 7.7694444 0.279283 7.7722222 0.279907 7.7750000 0.278660
+ 7.7777778 0.277414 7.7805556 0.277414 7.7833333 0.278037 7.7861111 0.279283
+ 7.7888889 0.279283 7.7916667 0.278037 7.7944444 0.276791 7.7972222 0.277414
+ 7.8000000 0.278037 7.8027778 0.279907 7.8055556 0.278660 7.8083333 0.279283
+ 7.8111111 0.279283 7.8138889 0.282399 7.8166667 0.284268 7.8194444 0.285514
+ 7.8222222 0.286760 7.8250000 0.286760 7.8277778 0.286760 7.8305556 0.288629
+ 7.8333333 0.290498 7.8361111 0.292368 7.8388889 0.291121 7.8416667 0.291121
+ 7.8444444 0.290498 7.8472222 0.292368 7.8500000 0.292368 7.8527778 0.293614
+ 7.8555556 0.294237 7.8583333 0.293614 7.8611111 0.293614 7.8638889 0.294860
+ 7.8666667 0.294860 7.8694444 0.296729 7.8722222 0.295483 7.8750000 0.295483
+ 7.8777778 0.293614 7.8805556 0.295483 7.8833333 0.294860 7.8861111 0.296106
+ 7.8888889 0.294860 7.8916667 0.293614 7.8944444 0.292368 7.8972222 0.293614
+ 7.9000000 0.294860 7.9027778 0.294860 7.9055556 0.294237 7.9083333 0.292991
+ 7.9111111 0.291745 7.9138889 0.293614 7.9166667 0.292991 7.9194444 0.294237
+ 7.9222222 0.294860 7.9250000 0.292368 7.9277778 0.291745 7.9305556 0.292991
+ 7.9333333 0.293614 7.9361111 0.292368 7.9388889 0.292991 7.9416667 0.292368
+ 7.9444444 0.290498 7.9472222 0.290498 7.9500000 0.291745 7.9527778 0.292991
+ 7.9555556 0.291745 7.9583333 0.290498 7.9611111 0.288006 7.9638889 0.289252
+ 7.9666667 0.291745 7.9694444 0.291121 7.9722222 0.289875 7.9750000 0.289875
+ 7.9777778 0.287383 7.9805556 0.289252 7.9833333 0.290498 7.9861111 0.290498
+ 7.9888889 0.288629 7.9916667 0.288629 7.9944444 0.286137 7.9972222 0.288006
+ 8.0000000 0.290498 8.0027778 0.291121 8.0055556 0.289252 8.0083333 0.288006
+ 8.0111111 0.288006 8.0138889 0.286760 8.0166667 0.289252 8.0194444 0.289252
+ 8.0222222 0.288006 8.0250000 0.286760 8.0277778 0.286137 8.0305556 0.287383
+ 8.0333333 0.288629 8.0361111 0.288629 8.0388889 0.288006 8.0416667 0.288006
+ 8.0444444 0.287383 8.0472222 0.288629 8.0500000 0.288629 8.0527778 0.289875
+ 8.0555556 0.289875 8.0583333 0.288629 8.0611111 0.288006 8.0638889 0.288006
+ 8.0666667 0.290498 8.0694444 0.291121 8.0722222 0.290498 8.0750000 0.288629
+ 8.0777778 0.288629 8.0805556 0.290498 8.0833333 0.289875 8.0861111 0.291121
+ 8.0888889 0.290498 8.0916667 0.290498 8.0944444 0.287383 8.0972222 0.288629
+ 8.1000000 0.290498 8.1027778 0.291745 8.1055556 0.290498 8.1083333 0.290498
+ 8.1111111 0.288006 8.1138889 0.289252 8.1166667 0.290498 8.1194444 0.291745
+ 8.1222222 0.291745 8.1250000 0.291745 8.1277778 0.293614 8.1305556 0.295483
+ 8.1333333 0.298598 8.1361111 0.299221 8.1388889 0.299221 8.1416667 0.298598
+ 8.1444444 0.297975 8.1472222 0.300467 8.1500000 0.302960 8.1527778 0.301713
+ 8.1555556 0.301713 8.1583333 0.303583 8.1611111 0.302960 8.1638889 0.302336
+ 8.1666667 0.301713 8.1694444 0.301713 8.1722222 0.301090 8.1750000 0.299844
+ 8.1777778 0.298598 8.1805556 0.300467 8.1833333 0.301090 8.1861111 0.299844
+ 8.1888889 0.301090 8.1916667 0.301713 8.1944444 0.302960 8.1972222 0.306075
+ 8.2000000 0.302960 8.2027778 0.299844 8.2055556 0.297975 8.2083333 0.296729
+ 8.2111111 0.294237 8.2138889 0.292991 8.2166667 0.292368 8.2194444 0.292368
+ 8.2222222 0.290498 8.2250000 0.289252 8.2277778 0.286760 8.2305556 0.286760
+ 8.2333333 0.288629 8.2361111 0.288629 8.2388889 0.288629 8.2416667 0.288006
+ 8.2444444 0.286760 8.2472222 0.286760 8.2500000 0.287383 8.2527778 0.288629
+ 8.2555556 0.287383 8.2583333 0.286137 8.2611111 0.284268 8.2638889 0.286760
+ 8.2666667 0.287383 8.2694444 0.288629 8.2722222 0.288629 8.2750000 0.288629
+ 8.2777778 0.286137 8.2805556 0.286137 8.2833333 0.287383 8.2861111 0.286137
+ 8.2888889 0.281153 8.2916667 0.274299 8.2944444 0.270561 8.2972222 0.267445
+ 8.3000000 0.264953 8.3027778 0.262461 8.3055556 0.268069 8.3083333 0.281153
+ 8.3111111 0.298598 8.3138889 0.321651 8.3166667 0.348442 8.3194444 0.383333
+ 8.3222222 0.415732 8.3250000 0.439408 8.3277778 0.445639 8.3305556 0.429439
+ 8.3333333 0.388941 8.3361111 0.332866 8.3388889 0.289875 8.3416667 0.271807
+ 8.3444444 0.269938 8.3472222 0.279283 8.3500000 0.284891 8.3527778 0.286137
+ 8.3555556 0.284891 8.3583333 0.283022 8.3611111 0.282399 8.3638889 0.283022
+ 8.3666667 0.284268 8.3694444 0.284268 8.3722222 0.283645 8.3750000 0.282399
+ 8.3777778 0.281153 8.3805556 0.282399 8.3833333 0.283022 8.3861111 0.282399
+ 8.3888889 0.283645 8.3916667 0.281776 8.3944444 0.279907 8.3972222 0.279907
+ 8.4000000 0.281776 8.4027778 0.282399 8.4055556 0.282399 8.4083333 0.281776
+ 8.4111111 0.279283 8.4138889 0.280530 8.4166667 0.281776 8.4194444 0.282399
+ 8.4222222 0.282399 8.4250000 0.281153 8.4277778 0.281776 8.4305556 0.281153
+ 8.4333333 0.283022 8.4361111 0.283645 8.4388889 0.283022 8.4416667 0.282399
+ 8.4444444 0.280530 8.4472222 0.282399 8.4500000 0.283022 8.4527778 0.283645
+ 8.4555556 0.283022 8.4583333 0.281153 8.4611111 0.281153 8.4638889 0.282399
+ 8.4666667 0.283645 8.4694444 0.284268 8.4722222 0.284891 8.4750000 0.282399
+ 8.4777778 0.281153 8.4805556 0.282399 8.4833333 0.282399 8.4861111 0.284268
+ 8.4888889 0.283645 8.4916667 0.284268 8.4944444 0.283645 8.4972222 0.283645
+ 8.5000000 0.284268 8.5027778 0.286137 8.5055556 0.284891 8.5083333 0.283022
+ 8.5111111 0.283645 8.5138889 0.284268 8.5166667 0.283022 8.5194444 0.284891
+ 8.5222222 0.284268 8.5250000 0.283645 8.5277778 0.281776 8.5305556 0.283022
+ 8.5333333 0.283645 8.5361111 0.283022 8.5388889 0.284268 8.5416667 0.283645
+ 8.5444444 0.283022 8.5472222 0.282399 8.5500000 0.282399 8.5527778 0.284268
+ 8.5555556 0.283645 8.5583333 0.283645 8.5611111 0.283022 8.5638889 0.283022
+ 8.5666667 0.283022 8.5694444 0.283022 8.5722222 0.283645 8.5750000 0.281776
+ 8.5777778 0.281153 8.5805556 0.282399 8.5833333 0.282399 8.5861111 0.283645
+ 8.5888889 0.283645 8.5916667 0.282399 8.5944444 0.282399 8.5972222 0.281776
+ 8.6000000 0.284268 8.6027778 0.284891 8.6055556 0.284891 8.6083333 0.283645
+ 8.6111111 0.282399 8.6138889 0.286760 8.6166667 0.287383 8.6194444 0.289875
+ 8.6222222 0.289875 8.6250000 0.289252 8.6277778 0.289875 8.6305556 0.289875
+ 8.6333333 0.291121 8.6361111 0.291121 8.6388889 0.291121 8.6416667 0.292991
+ 8.6444444 0.292991 8.6472222 0.294860 8.6500000 0.296729 8.6527778 0.297352
+ 8.6555556 0.297975 8.6583333 0.296106 8.6611111 0.294860 8.6638889 0.297352
+ 8.6666667 0.298598 8.6694444 0.299221 8.6722222 0.296729 8.6750000 0.295483
+ 8.6777778 0.294860 8.6805556 0.294860 8.6833333 0.295483 8.6861111 0.296729
+ 8.6888889 0.296729 8.6916667 0.296729 8.6944444 0.294860 8.6972222 0.295483
+ 8.7000000 0.296106 8.7027778 0.296729 8.7055556 0.297352 8.7083333 0.296106
+ 8.7111111 0.294237 8.7138889 0.294860 8.7166667 0.294860 8.7194444 0.296106
+ 8.7222222 0.296729 8.7250000 0.295483 8.7277778 0.293614 8.7305556 0.295483
+ 8.7333333 0.296729 8.7361111 0.296729 8.7388889 0.296106 8.7416667 0.294860
+ 8.7444444 0.292991 8.7472222 0.293614 8.7500000 0.294237 8.7527778 0.293614
+ 8.7555556 0.292991 8.7583333 0.294237 8.7611111 0.292368 8.7638889 0.293614
+ 8.7666667 0.294237 8.7694444 0.293614 8.7722222 0.294237 8.7750000 0.291745
+ 8.7777778 0.290498 8.7805556 0.291121 8.7833333 0.291121 8.7861111 0.292991
+ 8.7888889 0.292368 8.7916667 0.291121 8.7944444 0.289252 8.7972222 0.290498
+ 8.8000000 0.292368 8.8027778 0.291121 8.8055556 0.292368 8.8083333 0.291121
+ 8.8111111 0.289875 8.8138889 0.291745 8.8166667 0.293614 8.8194444 0.292991
+ 8.8222222 0.292368 8.8250000 0.291745 8.8277778 0.289875 8.8305556 0.291121
+ 8.8333333 0.291121 8.8361111 0.292368 8.8388889 0.292368 8.8416667 0.289875
+ 8.8444444 0.290498 8.8472222 0.290498 8.8500000 0.291745 8.8527778 0.292368
+ 8.8555556 0.290498 8.8583333 0.290498 8.8611111 0.290498 8.8638889 0.291745
+ 8.8666667 0.292368 8.8694444 0.294237 8.8722222 0.294860 8.8750000 0.294237
+ 8.8777778 0.292368 8.8805556 0.291745 8.8833333 0.292991 8.8861111 0.292991
+ 8.8888889 0.291745 8.8916667 0.291121 8.8944444 0.291121 8.8972222 0.291745
+ 8.9000000 0.293614 8.9027778 0.292991 8.9055556 0.293614 8.9083333 0.291121
+ 8.9111111 0.291745 8.9138889 0.294237 8.9166667 0.297352 8.9194444 0.300467
+ 8.9222222 0.298598 8.9250000 0.300467 8.9277778 0.299221 8.9305556 0.302336
+ 8.9333333 0.302336 8.9361111 0.303583 8.9388889 0.304206 8.9416667 0.305452
+ 8.9444444 0.306075 8.9472222 0.306075 8.9500000 0.307944 8.9527778 0.308567
+ 8.9555556 0.307944 8.9583333 0.304829 8.9611111 0.303583 8.9638889 0.304206
+ 8.9666667 0.304206 8.9694444 0.304206 8.9722222 0.304206 8.9750000 0.303583
+ 8.9777778 0.302336 8.9805556 0.304206 8.9833333 0.307944 8.9861111 0.309190
+ 8.9888889 0.307321 8.9916667 0.300467 8.9944444 0.298598 8.9972222 0.298598
+ 9.0000000 0.296729 9.0027778 0.296106 9.0055556 0.294860 9.0083333 0.292991
+ 9.0111111 0.292991 9.0138889 0.291121 9.0166667 0.292368 9.0194444 0.292991
+ 9.0222222 0.293614 9.0250000 0.292991 9.0277778 0.291121 9.0305556 0.291745
+ 9.0333333 0.291745 9.0361111 0.292991 9.0388889 0.292991 9.0416667 0.292368
+ 9.0444444 0.291121 9.0472222 0.289875 9.0500000 0.290498 9.0527778 0.290498
+ 9.0555556 0.290498 9.0583333 0.289875 9.0611111 0.288006 9.0638889 0.288629
+ 9.0666667 0.289875 9.0694444 0.291121 9.0722222 0.290498 9.0750000 0.287383
+ 9.0777778 0.284268 9.0805556 0.281153 9.0833333 0.277414 9.0861111 0.274922
+ 9.0888889 0.272430 9.0916667 0.266822 9.0944444 0.264330 9.0972222 0.269938
+ 9.1000000 0.284268 9.1027778 0.301090 9.1055556 0.319159 9.1083333 0.343458
+ 9.1111111 0.377103 9.1138889 0.411994 9.1166667 0.432555 9.1194444 0.438162
+ 9.1222222 0.421963 9.1250000 0.386449 9.1277778 0.337850 9.1305556 0.296729
+ 9.1333333 0.276791 9.1361111 0.273053 9.1388889 0.278660 9.1416667 0.282399
+ 9.1444444 0.284891 9.1472222 0.286137 9.1500000 0.286137 9.1527778 0.287383
+ 9.1555556 0.286760 9.1583333 0.286760 9.1611111 0.285514 9.1638889 0.287383
+ 9.1666667 0.288006 9.1694444 0.288006 9.1722222 0.288629 9.1750000 0.288629
+ 9.1777778 0.286137 9.1805556 0.287383 9.1833333 0.288006 9.1861111 0.288629
+ 9.1888889 0.288006 9.1916667 0.286760 9.1944444 0.284891 9.1972222 0.285514
+ 9.2000000 0.284891 9.2027778 0.286760 9.2055556 0.287383 9.2083333 0.284891
+ 9.2111111 0.285514 9.2138889 0.286760 9.2166667 0.286137 9.2194444 0.286760
+ 9.2222222 0.286137 9.2250000 0.286760 9.2277778 0.285514 9.2305556 0.288629
+ 9.2333333 0.288629 9.2361111 0.289252 9.2388889 0.288006 9.2416667 0.286760
+ 9.2444444 0.286760 9.2472222 0.287383 9.2500000 0.288629 9.2527778 0.287383
+ 9.2555556 0.286137 9.2583333 0.286137 9.2611111 0.284268 9.2638889 0.286137
+ 9.2666667 0.286760 9.2694444 0.287383 9.2722222 0.284891 9.2750000 0.284891
+ 9.2777778 0.284268 9.2805556 0.284891 9.2833333 0.286137 9.2861111 0.287383
+ 9.2888889 0.287383 9.2916667 0.287383 9.2944444 0.288006 9.2972222 0.288629
+ 9.3000000 0.289875 9.3027778 0.288629 9.3055556 0.287383 9.3083333 0.286760
+ 9.3111111 0.286760 9.3138889 0.286137 9.3166667 0.286137 9.3194444 0.285514
+ 9.3222222 0.286760 9.3250000 0.285514 9.3277778 0.284891 9.3305556 0.287383
+ 9.3333333 0.287383 9.3361111 0.289252 9.3388889 0.286760 9.3416667 0.287383
+ 9.3444444 0.286137 9.3472222 0.286760 9.3500000 0.288006 9.3527778 0.288629
+ 9.3555556 0.286760 9.3583333 0.284891 9.3611111 0.283022 9.3638889 0.282399
+ 9.3666667 0.286137 9.3694444 0.285514 9.3722222 0.286137 9.3750000 0.284268
+ 9.3777778 0.282399 9.3805556 0.284268 9.3833333 0.284268 9.3861111 0.286760
+ 9.3888889 0.287383 9.3916667 0.284891 9.3944444 0.284891 9.3972222 0.285514
+ 9.4000000 0.287383 9.4027778 0.289252 9.4055556 0.289252 9.4083333 0.289252
+ 9.4111111 0.288629 9.4138889 0.291121 9.4166667 0.291745 9.4194444 0.294860
+ 9.4222222 0.294237 9.4250000 0.294237 9.4277778 0.292991 9.4305556 0.295483
+ 9.4333333 0.296106 9.4361111 0.297975 9.4388889 0.297975 9.4416667 0.296729
+ 9.4444444 0.297352 9.4472222 0.298598 9.4500000 0.299221 9.4527778 0.299844
+ 9.4555556 0.299844 9.4583333 0.298598 9.4611111 0.297352 9.4638889 0.297975
+ 9.4666667 0.298598 9.4694444 0.300467 9.4722222 0.299221 9.4750000 0.298598
+ 9.4777778 0.296106 9.4805556 0.296106 9.4833333 0.297352 9.4861111 0.296729
+ 9.4888889 0.296106 9.4916667 0.295483 9.4944444 0.294237 9.4972222 0.295483
+ 9.5000000 0.296106 9.5027778 0.296729 9.5055556 0.296729 9.5083333 0.295483
+ 9.5111111 0.294237 9.5138889 0.295483 9.5166667 0.294860 9.5194444 0.296106
+ 9.5222222 0.294237 9.5250000 0.295483 9.5277778 0.294237 9.5305556 0.295483
+ 9.5333333 0.294860 9.5361111 0.296106 9.5388889 0.295483 9.5416667 0.293614
+ 9.5444444 0.292368 9.5472222 0.292991 9.5500000 0.292991 9.5527778 0.292368
+ 9.5555556 0.291121 9.5583333 0.290498 9.5611111 0.291745 9.5638889 0.291745
+ 9.5666667 0.292991 9.5694444 0.291745 9.5722222 0.291745 9.5750000 0.290498
+ 9.5777778 0.289875 9.5805556 0.291745 9.5833333 0.290498 9.5861111 0.291745
+ 9.5888889 0.291745 9.5916667 0.291121 9.5944444 0.289875 9.5972222 0.291121
+ 9.6000000 0.292368 9.6027778 0.291121 9.6055556 0.291745 9.6083333 0.290498
+ 9.6111111 0.289875 9.6138889 0.289875 9.6166667 0.290498 9.6194444 0.292368
+ 9.6222222 0.292368 9.6250000 0.292991 9.6277778 0.291121 9.6305556 0.292991
+ 9.6333333 0.291745 9.6361111 0.291121 9.6388889 0.292368 9.6416667 0.291745
+ 9.6444444 0.290498 9.6472222 0.291745 9.6500000 0.292991 9.6527778 0.293614
+ 9.6555556 0.292991 9.6583333 0.291121 9.6611111 0.289875 9.6638889 0.289875
+ 9.6666667 0.292368 9.6694444 0.291745 9.6722222 0.294237 9.6750000 0.291121
+ 9.6777778 0.289875 9.6805556 0.290498 9.6833333 0.294237 9.6861111 0.295483
+ 9.6888889 0.297975 9.6916667 0.297975 9.6944444 0.297352 9.6972222 0.297975
+ 9.7000000 0.299221 9.7027778 0.301713 9.7055556 0.302960 9.7083333 0.302960
+ 9.7111111 0.301090 9.7138889 0.302960 9.7166667 0.304829 9.7194444 0.304829
+ 9.7222222 0.304206 9.7250000 0.304206 9.7277778 0.301713 9.7305556 0.300467
+ 9.7333333 0.301713 9.7361111 0.302336 9.7388889 0.301090 9.7416667 0.299221
+ 9.7444444 0.297352 9.7472222 0.297975 9.7500000 0.299844 9.7527778 0.303583
+ 9.7555556 0.303583 9.7583333 0.299844 9.7611111 0.295483 9.7638889 0.296106
+ 9.7666667 0.296106 9.7694444 0.293614 9.7722222 0.291745 9.7750000 0.289875
+ 9.7777778 0.288006 9.7805556 0.288006 9.7833333 0.289875 9.7861111 0.291121
+ 9.7888889 0.291745 9.7916667 0.291121 9.7944444 0.289252 9.7972222 0.289252
+ 9.8000000 0.289875 9.8027778 0.289875 9.8055556 0.288629 9.8083333 0.287383
+ 9.8111111 0.286760 9.8138889 0.286760 9.8166667 0.286760 9.8194444 0.287383
+ 9.8222222 0.286760 9.8250000 0.284891 9.8277778 0.285514 9.8305556 0.286760
+ 9.8333333 0.286137 9.8361111 0.287383 9.8388889 0.287383 9.8416667 0.286760
+ 9.8444444 0.284891 9.8472222 0.283022 9.8500000 0.279907 9.8527778 0.277414
+ 9.8555556 0.275545 9.8583333 0.271807 9.8611111 0.265576 9.8638889 0.263084
+ 9.8666667 0.269315 9.8694444 0.281776 9.8722222 0.297975 9.8750000 0.316044
+ 9.8777778 0.340966 9.8805556 0.375234 9.8833333 0.407009 9.8861111 0.427570
+ 9.8888889 0.434424 9.8916667 0.420093 9.8944444 0.381464 9.8972222 0.334112
+ 9.9000000 0.298598 9.9027778 0.278660 9.9055556 0.271807 9.9083333 0.272430
+ 9.9111111 0.276168 9.9138889 0.281153 9.9166667 0.283645 9.9194444 0.284268
+ 9.9222222 0.283645 9.9250000 0.283645 9.9277778 0.281776 9.9305556 0.280530
+ 9.9333333 0.283022 9.9361111 0.282399 9.9388889 0.282399 9.9416667 0.282399
+ 9.9444444 0.282399 9.9472222 0.284268 9.9500000 0.284268 9.9527778 0.285514
+ 9.9555556 0.283022 9.9583333 0.283022 9.9611111 0.282399 9.9638889 0.284268
+ 9.9666667 0.284268 9.9694444 0.284891 9.9722222 0.283645 9.9750000 0.282399
+ 9.9777778 0.281776 9.9805556 0.281776 9.9833333 0.282399 9.9861111 0.282399
+ 9.9888889 0.281153 9.9916667 0.281776 9.9944444 0.280530 9.9972222 0.279907
+ )

* ---- Threshold ----
Vthresh threshold 0 0.32

* ---- DUT: rpeak_detector_v2 (direct ECG input) ----
Xdet ecg_in threshold rpeak_out vdd vss vbias
+ env_fast_raw env_fast env_avg noise_gate_out thr_gate_out
+ rpeak_detector_v2

* Initial conditions: set near ECG baseline
.ic v(env_fast_raw)=0.2874 v(env_fast)=0.2874 v(env_avg)=0.2874

* ---- Simulation ----
.tran 50u 10.0 0 50u

* ---- Measurements ----
.meas tran det1 when v(rpeak_out)=0.45 rise=1
.meas tran det2 when v(rpeak_out)=0.45 rise=2
.meas tran det3 when v(rpeak_out)=0.45 rise=3
.meas tran det4 when v(rpeak_out)=0.45 rise=4
.meas tran det5 when v(rpeak_out)=0.45 rise=5
.meas tran det6 when v(rpeak_out)=0.45 rise=6
.meas tran det7 when v(rpeak_out)=0.45 rise=7
.meas tran det8 when v(rpeak_out)=0.45 rise=8
.meas tran det9 when v(rpeak_out)=0.45 rise=9
.meas tran det10 when v(rpeak_out)=0.45 rise=10
.meas tran det11 when v(rpeak_out)=0.45 rise=11
.meas tran det12 when v(rpeak_out)=0.45 rise=12
.meas tran det13 when v(rpeak_out)=0.45 rise=13
.meas tran det14 when v(rpeak_out)=0.45 rise=14
.meas tran det15 when v(rpeak_out)=0.45 rise=15

* Signal ranges
.meas tran efr_max max v(env_fast_raw)
.meas tran ef_max max v(env_fast)
.meas tran ea_max max v(env_avg)
.meas tran efr_min min v(env_fast_raw)
.meas tran ea_min min v(env_avg)

.save v(ecg_in) v(env_fast_raw) v(env_fast) v(env_avg)
+ v(noise_gate_out) v(thr_gate_out) v(rpeak_out)

.control
set filetype=ascii
run

echo ""
echo "=== PHASE 2A: FULL CHAIN TEST ==="
echo "--- Signal ranges ---"
echo "--- Detection times ---"

wrdata phase2a_results.txt v(ecg_in) v(env_fast_raw) v(env_fast) v(env_avg) v(noise_gate_out) v(thr_gate_out) v(rpeak_out)

echo "=== Done ==="
quit
.endc

.end
