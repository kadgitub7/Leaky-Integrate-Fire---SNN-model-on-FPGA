* Diagnostic: Record 108 with v3 detector
.lib C:/Users/kadhi/OneDrive/Desktop/amux/verilogLearning/Leaky-Integrate-Fire---SNN-model-on-FPGA/experiments/frontend_optimization/ngspice_frontend/sky130_minimal.lib.spice tt
.include C:/Users/kadhi/OneDrive/Desktop/amux/verilogLearning/Leaky-Integrate-Fire---SNN-model-on-FPGA/experiments/frontend_optimization/complete_frontend_v9b/inverter.spice
.include C:/Users/kadhi/OneDrive/Desktop/amux/verilogLearning/Leaky-Integrate-Fire---SNN-model-on-FPGA/experiments/frontend_optimization/complete_frontend_v9b/rpeak_hold.spice
.include C:/Users/kadhi/OneDrive/Desktop/amux/verilogLearning/Leaky-Integrate-Fire---SNN-model-on-FPGA/experiments/frontend_optimization/complete_frontend_v9b/rpeak_detector_v2.spice
.option scale=1.0u method=gear reltol=0.01 gmin=1e-15

Vdd vdd 0 0.9
Vss vss 0 0.0
Vbias vbias 0 0.300
Vecg ecg_in 0 PWL(
+ 0.0000000 0.425000 0.0027778 0.425000 0.0055556 0.425000 0.0083333 0.425000
+ 0.0111111 0.425000 0.0138889 0.425000 0.0166667 0.425000 0.0194444 0.425000
+ 0.0222222 0.423148 0.0250000 0.425000 0.0277778 0.425000 0.0305556 0.425926
+ 0.0333333 0.430556 0.0361111 0.432407 0.0388889 0.428704 0.0416667 0.416667
+ 0.0444444 0.406481 0.0472222 0.400926 0.0500000 0.396296 0.0527778 0.393519
+ 0.0555556 0.385185 0.0583333 0.375000 0.0611111 0.372222 0.0638889 0.373148
+ 0.0666667 0.377778 0.0694444 0.379630 0.0722222 0.375926 0.0750000 0.372222
+ 0.0777778 0.369444 0.0805556 0.370370 0.0833333 0.373148 0.0861111 0.379630
+ 0.0888889 0.378704 0.0916667 0.375926 0.0944444 0.372222 0.0972222 0.373148
+ 0.1000000 0.375000 0.1027778 0.378704 0.1055556 0.375926 0.1083333 0.375000
+ 0.1111111 0.375000 0.1138889 0.375000 0.1166667 0.376852 0.1194444 0.377778
+ 0.1222222 0.376852 0.1250000 0.374074 0.1277778 0.373148 0.1305556 0.373148
+ 0.1333333 0.373148 0.1361111 0.371296 0.1388889 0.367593 0.1416667 0.369444
+ 0.1444444 0.369444 0.1472222 0.375926 0.1500000 0.378704 0.1527778 0.380556
+ 0.1555556 0.379630 0.1583333 0.380556 0.1611111 0.377778 0.1638889 0.373148
+ 0.1666667 0.373148 0.1694444 0.375926 0.1722222 0.380556 0.1750000 0.387037
+ 0.1777778 0.388889 0.1805556 0.393519 0.1833333 0.398148 0.1861111 0.396296
+ 0.1888889 0.385185 0.1916667 0.366667 0.1944444 0.353704 0.1972222 0.351852
+ 0.2000000 0.353704 0.2027778 0.353704 0.2055556 0.349074 0.2083333 0.348148
+ 0.2111111 0.339815 0.2138889 0.332407 0.2166667 0.329630 0.2194444 0.327778
+ 0.2222222 0.321296 0.2250000 0.312963 0.2277778 0.303704 0.2305556 0.293519
+ 0.2333333 0.284259 0.2361111 0.278704 0.2388889 0.274074 0.2416667 0.267593
+ 0.2444444 0.266667 0.2472222 0.274074 0.2500000 0.278704 0.2527778 0.282407
+ 0.2555556 0.283333 0.2583333 0.294444 0.2611111 0.307407 0.2638889 0.318519
+ 0.2666667 0.332407 0.2694444 0.340741 0.2722222 0.347222 0.2750000 0.354630
+ 0.2777778 0.358333 0.2805556 0.365741 0.2833333 0.375000 0.2861111 0.379630
+ 0.2888889 0.379630 0.2916667 0.381481 0.2944444 0.381481 0.2972222 0.382407
+ 0.3000000 0.387963 0.3027778 0.389815 0.3055556 0.388889 0.3083333 0.384259
+ 0.3111111 0.384259 0.3138889 0.387037 0.3166667 0.392593 0.3194444 0.395370
+ 0.3222222 0.392593 0.3250000 0.394444 0.3277778 0.393519 0.3305556 0.392593
+ 0.3333333 0.394444 0.3361111 0.396296 0.3388889 0.395370 0.3416667 0.388889
+ 0.3444444 0.388889 0.3472222 0.390741 0.3500000 0.393519 0.3527778 0.395370
+ 0.3555556 0.397222 0.3583333 0.395370 0.3611111 0.394444 0.3638889 0.393519
+ 0.3666667 0.395370 0.3694444 0.395370 0.3722222 0.394444 0.3750000 0.395370
+ 0.3777778 0.397222 0.3805556 0.396296 0.3833333 0.398148 0.3861111 0.400000
+ 0.3888889 0.398148 0.3916667 0.398148 0.3944444 0.397222 0.3972222 0.400000
+ 0.4000000 0.403704 0.4027778 0.406481 0.4055556 0.403704 0.4083333 0.399074
+ 0.4111111 0.396296 0.4138889 0.397222 0.4166667 0.403704 0.4194444 0.407407
+ 0.4222222 0.407407 0.4250000 0.406481 0.4277778 0.403704 0.4305556 0.407407
+ 0.4333333 0.411111 0.4361111 0.412963 0.4388889 0.413889 0.4416667 0.407407
+ 0.4444444 0.402778 0.4472222 0.406481 0.4500000 0.412037 0.4527778 0.413889
+ 0.4555556 0.417593 0.4583333 0.414815 0.4611111 0.412963 0.4638889 0.413889
+ 0.4666667 0.414815 0.4694444 0.417593 0.4722222 0.416667 0.4750000 0.419444
+ 0.4777778 0.418519 0.4805556 0.415741 0.4833333 0.415741 0.4861111 0.421296
+ 0.4888889 0.416667 0.4916667 0.418519 0.4944444 0.417593 0.4972222 0.417593
+ 0.5000000 0.418519 0.5027778 0.419444 0.5055556 0.417593 0.5083333 0.416667
+ 0.5111111 0.412963 0.5138889 0.412037 0.5166667 0.412037 0.5194444 0.414815
+ 0.5222222 0.414815 0.5250000 0.411111 0.5277778 0.411111 0.5305556 0.410185
+ 0.5333333 0.411111 0.5361111 0.412963 0.5388889 0.412963 0.5416667 0.411111
+ 0.5444444 0.405556 0.5472222 0.406481 0.5500000 0.409259 0.5527778 0.408333
+ 0.5555556 0.410185 0.5583333 0.408333 0.5611111 0.405556 0.5638889 0.400000
+ 0.5666667 0.400926 0.5694444 0.401852 0.5722222 0.403704 0.5750000 0.402778
+ 0.5777778 0.401852 0.5805556 0.399074 0.5833333 0.398148 0.5861111 0.400926
+ 0.5888889 0.399074 0.5916667 0.399074 0.5944444 0.398148 0.5972222 0.396296
+ 0.6000000 0.400000 0.6027778 0.400926 0.6055556 0.400000 0.6083333 0.398148
+ 0.6111111 0.397222 0.6138889 0.398148 0.6166667 0.400926 0.6194444 0.400926
+ 0.6222222 0.400000 0.6250000 0.398148 0.6277778 0.397222 0.6305556 0.398148
+ 0.6333333 0.399074 0.6361111 0.400926 0.6388889 0.399074 0.6416667 0.396296
+ 0.6444444 0.395370 0.6472222 0.395370 0.6500000 0.396296 0.6527778 0.400000
+ 0.6555556 0.399074 0.6583333 0.398148 0.6611111 0.396296 0.6638889 0.395370
+ 0.6666667 0.395370 0.6694444 0.400000 0.6722222 0.400926 0.6750000 0.398148
+ 0.6777778 0.397222 0.6805556 0.395370 0.6833333 0.398148 0.6861111 0.397222
+ 0.6888889 0.394444 0.6916667 0.391667 0.6944444 0.388889 0.6972222 0.391667
+ 0.7000000 0.394444 0.7027778 0.397222 0.7055556 0.395370 0.7083333 0.390741
+ 0.7111111 0.387963 0.7138889 0.389815 0.7166667 0.389815 0.7194444 0.392593
+ 0.7222222 0.390741 0.7250000 0.386111 0.7277778 0.385185 0.7305556 0.380556
+ 0.7333333 0.382407 0.7361111 0.386111 0.7388889 0.385185 0.7416667 0.385185
+ 0.7444444 0.378704 0.7472222 0.380556 0.7500000 0.383333 0.7527778 0.385185
+ 0.7555556 0.381481 0.7583333 0.381481 0.7611111 0.378704 0.7638889 0.379630
+ 0.7666667 0.382407 0.7694444 0.383333 0.7722222 0.383333 0.7750000 0.381481
+ 0.7777778 0.379630 0.7805556 0.378704 0.7833333 0.378704 0.7861111 0.383333
+ 0.7888889 0.381481 0.7916667 0.381481 0.7944444 0.377778 0.7972222 0.378704
+ 0.8000000 0.382407 0.8027778 0.384259 0.8055556 0.385185 0.8083333 0.384259
+ 0.8111111 0.382407 0.8138889 0.381481 0.8166667 0.384259 0.8194444 0.386111
+ 0.8222222 0.384259 0.8250000 0.385185 0.8277778 0.385185 0.8305556 0.385185
+ 0.8333333 0.387037 0.8361111 0.387037 0.8388889 0.387963 0.8416667 0.387037
+ 0.8444444 0.386111 0.8472222 0.387037 0.8500000 0.390741 0.8527778 0.393519
+ 0.8555556 0.392593 0.8583333 0.388889 0.8611111 0.387037 0.8638889 0.384259
+ 0.8666667 0.387963 0.8694444 0.389815 0.8722222 0.390741 0.8750000 0.389815
+ 0.8777778 0.384259 0.8805556 0.387037 0.8833333 0.390741 0.8861111 0.394444
+ 0.8888889 0.389815 0.8916667 0.386111 0.8944444 0.386111 0.8972222 0.384259
+ 0.9000000 0.387963 0.9027778 0.391667 0.9055556 0.392593 0.9083333 0.391667
+ 0.9111111 0.391667 0.9138889 0.389815 0.9166667 0.392593 0.9194444 0.394444
+ 0.9222222 0.392593 0.9250000 0.388889 0.9277778 0.387963 0.9305556 0.388889
+ 0.9333333 0.391667 0.9361111 0.391667 0.9388889 0.390741 0.9416667 0.390741
+ 0.9444444 0.390741 0.9472222 0.391667 0.9500000 0.392593 0.9527778 0.396296
+ 0.9555556 0.399074 0.9583333 0.397222 0.9611111 0.396296 0.9638889 0.399074
+ 0.9666667 0.401852 0.9694444 0.404630 0.9722222 0.406481 0.9750000 0.406481
+ 0.9777778 0.405556 0.9805556 0.411111 0.9833333 0.414815 0.9861111 0.419444
+ 0.9888889 0.421296 0.9916667 0.420370 0.9944444 0.420370 0.9972222 0.425926
+ 1.0000000 0.428704 1.0027778 0.430556 1.0055556 0.432407 1.0083333 0.431481
+ 1.0111111 0.430556 1.0138889 0.430556 1.0166667 0.434259 1.0194444 0.437963
+ 1.0222222 0.438889 1.0250000 0.436111 1.0277778 0.427778 1.0305556 0.423148
+ 1.0333333 0.417593 1.0361111 0.413889 1.0388889 0.407407 1.0416667 0.397222
+ 1.0444444 0.388889 1.0472222 0.383333 1.0500000 0.379630 1.0527778 0.383333
+ 1.0555556 0.383333 1.0583333 0.382407 1.0611111 0.381481 1.0638889 0.380556
+ 1.0666667 0.381481 1.0694444 0.384259 1.0722222 0.385185 1.0750000 0.382407
+ 1.0777778 0.379630 1.0805556 0.377778 1.0833333 0.375926 1.0861111 0.381481
+ 1.0888889 0.385185 1.0916667 0.388889 1.0944444 0.385185 1.0972222 0.381481
+ 1.1000000 0.382407 1.1027778 0.384259 1.1055556 0.385185 1.1083333 0.382407
+ 1.1111111 0.383333 1.1138889 0.383333 1.1166667 0.384259 1.1194444 0.383333
+ 1.1222222 0.382407 1.1250000 0.379630 1.1277778 0.379630 1.1305556 0.381481
+ 1.1333333 0.384259 1.1361111 0.387037 1.1388889 0.387037 1.1416667 0.383333
+ 1.1444444 0.381481 1.1472222 0.379630 1.1500000 0.378704 1.1527778 0.376852
+ 1.1555556 0.375926 1.1583333 0.378704 1.1611111 0.384259 1.1638889 0.389815
+ 1.1666667 0.397222 1.1694444 0.401852 1.1722222 0.399074 1.1750000 0.385185
+ 1.1777778 0.369444 1.1805556 0.356481 1.1833333 0.353704 1.1861111 0.356481
+ 1.1888889 0.358333 1.1916667 0.356481 1.1944444 0.350000 1.1972222 0.341667
+ 1.2000000 0.337037 1.2027778 0.331481 1.2055556 0.326852 1.2083333 0.322222
+ 1.2111111 0.313889 1.2138889 0.303704 1.2166667 0.291667 1.2194444 0.281481
+ 1.2222222 0.278704 1.2250000 0.275000 1.2277778 0.275000 1.2305556 0.278704
+ 1.2333333 0.285185 1.2361111 0.289815 1.2388889 0.296296 1.2416667 0.308333
+ 1.2444444 0.321296 1.2472222 0.335185 1.2500000 0.346296 1.2527778 0.353704
+ 1.2555556 0.359259 1.2583333 0.366667 1.2611111 0.375926 1.2638889 0.382407
+ 1.2666667 0.389815 1.2694444 0.392593 1.2722222 0.392593 1.2750000 0.392593
+ 1.2777778 0.392593 1.2805556 0.394444 1.2833333 0.397222 1.2861111 0.399074
+ 1.2888889 0.397222 1.2916667 0.394444 1.2944444 0.392593 1.2972222 0.397222
+ 1.3000000 0.400926 1.3027778 0.402778 1.3055556 0.400000 1.3083333 0.396296
+ 1.3111111 0.397222 1.3138889 0.400000 1.3166667 0.402778 1.3194444 0.403704
+ 1.3222222 0.401852 1.3250000 0.402778 1.3277778 0.400000 1.3305556 0.399074
+ 1.3333333 0.398148 1.3361111 0.403704 1.3388889 0.405556 1.3416667 0.407407
+ 1.3444444 0.406481 1.3472222 0.407407 1.3500000 0.406481 1.3527778 0.406481
+ 1.3555556 0.406481 1.3583333 0.403704 1.3611111 0.403704 1.3638889 0.403704
+ 1.3666667 0.405556 1.3694444 0.411111 1.3722222 0.412037 1.3750000 0.411111
+ 1.3777778 0.408333 1.3805556 0.405556 1.3833333 0.408333 1.3861111 0.414815
+ 1.3888889 0.414815 1.3916667 0.413889 1.3944444 0.412037 1.3972222 0.411111
+ 1.4000000 0.412037 1.4027778 0.415741 1.4055556 0.419444 1.4083333 0.419444
+ 1.4111111 0.415741 1.4138889 0.416667 1.4166667 0.421296 1.4194444 0.422222
+ 1.4222222 0.420370 1.4250000 0.418519 1.4277778 0.419444 1.4305556 0.422222
+ 1.4333333 0.423148 1.4361111 0.426852 1.4388889 0.425926 1.4416667 0.427778
+ 1.4444444 0.426852 1.4472222 0.427778 1.4500000 0.427778 1.4527778 0.430556
+ 1.4555556 0.427778 1.4583333 0.426852 1.4611111 0.424074 1.4638889 0.425926
+ 1.4666667 0.428704 1.4694444 0.429630 1.4722222 0.427778 1.4750000 0.426852
+ 1.4777778 0.425926 1.4805556 0.428704 1.4833333 0.432407 1.4861111 0.431481
+ 1.4888889 0.429630 1.4916667 0.426852 1.4944444 0.424074 1.4972222 0.425000
+ 1.5000000 0.429630 1.5027778 0.429630 1.5055556 0.426852 1.5083333 0.424074
+ 1.5111111 0.421296 1.5138889 0.419444 1.5166667 0.418519 1.5194444 0.422222
+ 1.5222222 0.422222 1.5250000 0.421296 1.5277778 0.417593 1.5305556 0.412963
+ 1.5333333 0.412037 1.5361111 0.416667 1.5388889 0.417593 1.5416667 0.414815
+ 1.5444444 0.412963 1.5472222 0.410185 1.5500000 0.411111 1.5527778 0.416667
+ 1.5555556 0.412963 1.5583333 0.410185 1.5611111 0.409259 1.5638889 0.408333
+ 1.5666667 0.408333 1.5694444 0.410185 1.5722222 0.410185 1.5750000 0.408333
+ 1.5777778 0.406481 1.5805556 0.409259 1.5833333 0.411111 1.5861111 0.412037
+ 1.5888889 0.409259 1.5916667 0.406481 1.5944444 0.403704 1.5972222 0.403704
+ 1.6000000 0.403704 1.6027778 0.402778 1.6055556 0.402778 1.6083333 0.405556
+ 1.6111111 0.406481 1.6138889 0.407407 1.6166667 0.406481 1.6194444 0.404630
+ 1.6222222 0.404630 1.6250000 0.400000 1.6277778 0.399074 1.6305556 0.401852
+ 1.6333333 0.404630 1.6361111 0.406481 1.6388889 0.404630 1.6416667 0.401852
+ 1.6444444 0.395370 1.6472222 0.396296 1.6500000 0.400000 1.6527778 0.401852
+ 1.6555556 0.400000 1.6583333 0.398148 1.6611111 0.397222 1.6638889 0.395370
+ 1.6666667 0.399074 1.6694444 0.400000 1.6722222 0.398148 1.6750000 0.392593
+ 1.6777778 0.391667 1.6805556 0.392593 1.6833333 0.390741 1.6861111 0.394444
+ 1.6888889 0.398148 1.6916667 0.392593 1.6944444 0.388889 1.6972222 0.390741
+ 1.7000000 0.391667 1.7027778 0.395370 1.7055556 0.395370 1.7083333 0.393519
+ 1.7111111 0.389815 1.7138889 0.388889 1.7166667 0.388889 1.7194444 0.389815
+ 1.7222222 0.388889 1.7250000 0.389815 1.7277778 0.385185 1.7305556 0.386111
+ 1.7333333 0.389815 1.7361111 0.390741 1.7388889 0.388889 1.7416667 0.386111
+ 1.7444444 0.385185 1.7472222 0.384259 1.7500000 0.387037 1.7527778 0.389815
+ 1.7555556 0.388889 1.7583333 0.387963 1.7611111 0.385185 1.7638889 0.384259
+ 1.7666667 0.385185 1.7694444 0.387037 1.7722222 0.387037 1.7750000 0.390741
+ 1.7777778 0.389815 1.7805556 0.391667 1.7833333 0.390741 1.7861111 0.390741
+ 1.7888889 0.391667 1.7916667 0.389815 1.7944444 0.388889 1.7972222 0.391667
+ 1.8000000 0.392593 1.8027778 0.392593 1.8055556 0.391667 1.8083333 0.391667
+ 1.8111111 0.388889 1.8138889 0.388889 1.8166667 0.390741 1.8194444 0.390741
+ 1.8222222 0.391667 1.8250000 0.393519 1.8277778 0.393519 1.8305556 0.392593
+ 1.8333333 0.393519 1.8361111 0.392593 1.8388889 0.393519 1.8416667 0.391667
+ 1.8444444 0.391667 1.8472222 0.395370 1.8500000 0.397222 1.8527778 0.394444
+ 1.8555556 0.395370 1.8583333 0.395370 1.8611111 0.389815 1.8638889 0.392593
+ 1.8666667 0.394444 1.8694444 0.395370 1.8722222 0.393519 1.8750000 0.392593
+ 1.8777778 0.394444 1.8805556 0.395370 1.8833333 0.399074 1.8861111 0.398148
+ 1.8888889 0.396296 1.8916667 0.394444 1.8944444 0.393519 1.8972222 0.392593
+ 1.9000000 0.395370 1.9027778 0.397222 1.9055556 0.398148 1.9083333 0.398148
+ 1.9111111 0.395370 1.9138889 0.394444 1.9166667 0.396296 1.9194444 0.397222
+ 1.9222222 0.397222 1.9250000 0.397222 1.9277778 0.397222 1.9305556 0.400000
+ 1.9333333 0.406481 1.9361111 0.410185 1.9388889 0.411111 1.9416667 0.410185
+ 1.9444444 0.408333 1.9472222 0.410185 1.9500000 0.411111 1.9527778 0.415741
+ 1.9555556 0.420370 1.9583333 0.425926 1.9611111 0.426852 1.9638889 0.431481
+ 1.9666667 0.432407 1.9694444 0.436111 1.9722222 0.436111 1.9750000 0.432407
+ 1.9777778 0.433333 1.9805556 0.440741 1.9833333 0.449074 1.9861111 0.450000
+ 1.9888889 0.449074 1.9916667 0.446296 1.9944444 0.440741 1.9972222 0.433333
+ 2.0000000 0.425926 2.0027778 0.423148 2.0055556 0.415741 2.0083333 0.408333
+ 2.0111111 0.399074 2.0138889 0.391667 2.0166667 0.389815 2.0194444 0.389815
+ 2.0222222 0.389815 2.0250000 0.391667 2.0277778 0.388889 2.0305556 0.389815
+ 2.0333333 0.391667 2.0361111 0.394444 2.0388889 0.391667 2.0416667 0.389815
+ 2.0444444 0.387963 2.0472222 0.389815 2.0500000 0.389815 2.0527778 0.391667
+ 2.0555556 0.390741 2.0583333 0.390741 2.0611111 0.389815 2.0638889 0.388889
+ 2.0666667 0.389815 2.0694444 0.391667 2.0722222 0.395370 2.0750000 0.395370
+ 2.0777778 0.390741 2.0805556 0.388889 2.0833333 0.388889 2.0861111 0.390741
+ 2.0888889 0.384259 2.0916667 0.385185 2.0944444 0.383333 2.0972222 0.384259
+ 2.1000000 0.384259 2.1027778 0.388889 2.1055556 0.389815 2.1083333 0.389815
+ 2.1111111 0.384259 2.1138889 0.385185 2.1166667 0.388889 2.1194444 0.389815
+ 2.1222222 0.387963 2.1250000 0.383333 2.1277778 0.385185 2.1305556 0.388889
+ 2.1333333 0.395370 2.1361111 0.398148 2.1388889 0.399074 2.1416667 0.396296
+ 2.1444444 0.383333 2.1472222 0.369444 2.1500000 0.362037 2.1527778 0.361111
+ 2.1555556 0.357407 2.1583333 0.353704 2.1611111 0.350000 2.1638889 0.343519
+ 2.1666667 0.336111 2.1694444 0.332407 2.1722222 0.326852 2.1750000 0.322222
+ 2.1777778 0.317593 2.1805556 0.307407 2.1833333 0.296296 2.1861111 0.288889
+ 2.1888889 0.281481 2.1916667 0.278704 2.1944444 0.276852 2.1972222 0.282407
+ 2.2000000 0.292593 2.2027778 0.297222 2.2055556 0.301852 2.2083333 0.310185
+ 2.2111111 0.324074 2.2138889 0.340741 2.2166667 0.352778 2.2194444 0.360185
+ 2.2222222 0.362963 2.2250000 0.369444 2.2277778 0.375000 2.2305556 0.384259
+ 2.2333333 0.389815 2.2361111 0.393519 2.2388889 0.394444 2.2416667 0.396296
+ 2.2444444 0.396296 2.2472222 0.395370 2.2500000 0.398148 2.2527778 0.400000
+ 2.2555556 0.400926 2.2583333 0.399074 2.2611111 0.399074 2.2638889 0.399074
+ 2.2666667 0.399074 2.2694444 0.399074 2.2722222 0.400000 2.2750000 0.398148
+ 2.2777778 0.395370 2.2805556 0.400000 2.2833333 0.408333 2.2861111 0.412963
+ 2.2888889 0.409259 2.2916667 0.405556 2.2944444 0.400926 2.2972222 0.400926
+ 2.3000000 0.405556 2.3027778 0.404630 2.3055556 0.404630 2.3083333 0.402778
+ 2.3111111 0.405556 2.3138889 0.408333 2.3166667 0.407407 2.3194444 0.407407
+ 2.3222222 0.407407 2.3250000 0.406481 2.3277778 0.405556 2.3305556 0.406481
+ 2.3333333 0.410185 2.3361111 0.412963 2.3388889 0.411111 2.3416667 0.408333
+ 2.3444444 0.405556 2.3472222 0.407407 2.3500000 0.413889 2.3527778 0.416667
+ 2.3555556 0.418519 2.3583333 0.414815 2.3611111 0.411111 2.3638889 0.410185
+ 2.3666667 0.415741 2.3694444 0.423148 2.3722222 0.427778 2.3750000 0.421296
+ 2.3777778 0.415741 2.3805556 0.414815 2.3833333 0.419444 2.3861111 0.423148
+ 2.3888889 0.425000 2.3916667 0.421296 2.3944444 0.420370 2.3972222 0.422222
+ 2.4000000 0.421296 2.4027778 0.425926 2.4055556 0.430556 2.4083333 0.429630
+ 2.4111111 0.425926 2.4138889 0.428704 2.4166667 0.427778 2.4194444 0.427778
+ 2.4222222 0.426852 2.4250000 0.426852 2.4277778 0.425000 2.4305556 0.428704
+ 2.4333333 0.430556 2.4361111 0.431481 2.4388889 0.432407 2.4416667 0.429630
+ 2.4444444 0.424074 2.4472222 0.420370 2.4500000 0.422222 2.4527778 0.427778
+ 2.4555556 0.435185 2.4583333 0.436111 2.4611111 0.428704 2.4638889 0.423148
+ 2.4666667 0.422222 2.4694444 0.427778 2.4722222 0.431481 2.4750000 0.428704
+ 2.4777778 0.425000 2.4805556 0.424074 2.4833333 0.421296 2.4861111 0.424074
+ 2.4888889 0.420370 2.4916667 0.414815 2.4944444 0.413889 2.4972222 0.412963
+ 2.5000000 0.413889 2.5027778 0.416667 2.5055556 0.415741 2.5083333 0.411111
+ 2.5111111 0.409259 2.5138889 0.408333 2.5166667 0.409259 2.5194444 0.409259
+ 2.5222222 0.406481 2.5250000 0.404630 2.5277778 0.402778 2.5305556 0.401852
+ 2.5333333 0.405556 2.5361111 0.407407 2.5388889 0.406481 2.5416667 0.404630
+ 2.5444444 0.399074 2.5472222 0.400926 2.5500000 0.401852 2.5527778 0.403704
+ 2.5555556 0.403704 2.5583333 0.400926 2.5611111 0.398148 2.5638889 0.397222
+ 2.5666667 0.399074 2.5694444 0.401852 2.5722222 0.399074 2.5750000 0.398148
+ 2.5777778 0.392593 2.5805556 0.397222 2.5833333 0.399074 2.5861111 0.399074
+ 2.5888889 0.400000 2.5916667 0.398148 2.5944444 0.393519 2.5972222 0.393519
+ 2.6000000 0.395370 2.6027778 0.397222 2.6055556 0.397222 2.6083333 0.393519
+ 2.6111111 0.390741 2.6138889 0.387963 2.6166667 0.390741 2.6194444 0.394444
+ 2.6222222 0.394444 2.6250000 0.393519 2.6277778 0.391667 2.6305556 0.389815
+ 2.6333333 0.390741 2.6361111 0.391667 2.6388889 0.394444 2.6416667 0.390741
+ 2.6444444 0.386111 2.6472222 0.384259 2.6500000 0.384259 2.6527778 0.386111
+ 2.6555556 0.387037 2.6583333 0.387037 2.6611111 0.385185 2.6638889 0.383333
+ 2.6666667 0.384259 2.6694444 0.387037 2.6722222 0.387037 2.6750000 0.384259
+ 2.6777778 0.378704 2.6805556 0.381481 2.6833333 0.383333 2.6861111 0.385185
+ 2.6888889 0.384259 2.6916667 0.379630 2.6944444 0.379630 2.6972222 0.381481
+ 2.7000000 0.380556 2.7027778 0.384259 2.7055556 0.382407 2.7083333 0.379630
+ 2.7111111 0.379630 2.7138889 0.378704 2.7166667 0.382407 2.7194444 0.384259
+ 2.7222222 0.385185 2.7250000 0.383333 2.7277778 0.380556 2.7305556 0.379630
+ 2.7333333 0.380556 2.7361111 0.382407 2.7388889 0.380556 2.7416667 0.378704
+ 2.7444444 0.379630 2.7472222 0.380556 2.7500000 0.385185 2.7527778 0.389815
+ 2.7555556 0.386111 2.7583333 0.383333 2.7611111 0.380556 2.7638889 0.383333
+ 2.7666667 0.383333 2.7694444 0.386111 2.7722222 0.385185 2.7750000 0.382407
+ 2.7777778 0.383333 2.7805556 0.386111 2.7833333 0.385185 2.7861111 0.387037
+ 2.7888889 0.383333 2.7916667 0.382407 2.7944444 0.383333 2.7972222 0.387963
+ 2.8000000 0.389815 2.8027778 0.387963 2.8055556 0.385185 2.8083333 0.380556
+ 2.8111111 0.381481 2.8138889 0.385185 2.8166667 0.387963 2.8194444 0.388889
+ 2.8222222 0.387037 2.8250000 0.385185 2.8277778 0.382407 2.8305556 0.387037
+ 2.8333333 0.388889 2.8361111 0.387963 2.8388889 0.386111 2.8416667 0.387963
+ 2.8444444 0.387037 2.8472222 0.387963 2.8500000 0.388889 2.8527778 0.387037
+ 2.8555556 0.385185 2.8583333 0.384259 2.8611111 0.387963 2.8638889 0.390741
+ 2.8666667 0.390741 2.8694444 0.390741 2.8722222 0.390741 2.8750000 0.387963
+ 2.8777778 0.388889 2.8805556 0.391667 2.8833333 0.392593 2.8861111 0.391667
+ 2.8888889 0.386111 2.8916667 0.386111 2.8944444 0.386111 2.8972222 0.391667
+ 2.9000000 0.394444 2.9027778 0.392593 2.9055556 0.389815 2.9083333 0.386111
+ 2.9111111 0.388889 2.9138889 0.391667 2.9166667 0.394444 2.9194444 0.393519
+ 2.9222222 0.392593 2.9250000 0.388889 2.9277778 0.391667 2.9305556 0.395370
+ 2.9333333 0.396296 2.9361111 0.397222 2.9388889 0.399074 2.9416667 0.401852
+ 2.9444444 0.405556 2.9472222 0.407407 2.9500000 0.409259 2.9527778 0.412037
+ 2.9555556 0.412963 2.9583333 0.414815 2.9611111 0.417593 2.9638889 0.423148
+ 2.9666667 0.427778 2.9694444 0.431481 2.9722222 0.430556 2.9750000 0.429630
+ 2.9777778 0.427778 2.9805556 0.426852 2.9833333 0.431481 2.9861111 0.434259
+ 2.9888889 0.434259 2.9916667 0.435185 2.9944444 0.437963 2.9972222 0.440741
+ 3.0000000 0.436111 3.0027778 0.426852 3.0055556 0.417593 3.0083333 0.406481
+ 3.0111111 0.402778 3.0138889 0.395370 3.0166667 0.391667 3.0194444 0.383333
+ 3.0222222 0.380556 3.0250000 0.379630 3.0277778 0.382407 3.0305556 0.383333
+ 3.0333333 0.384259 3.0361111 0.384259 3.0388889 0.381481 3.0416667 0.381481
+ 3.0444444 0.383333 3.0472222 0.385185 3.0500000 0.386111 3.0527778 0.382407
+ 3.0555556 0.380556 3.0583333 0.377778 3.0611111 0.379630 3.0638889 0.382407
+ 3.0666667 0.387037 3.0694444 0.385185 3.0722222 0.383333 3.0750000 0.382407
+ 3.0777778 0.382407 3.0805556 0.383333 3.0833333 0.385185 3.0861111 0.384259
+ 3.0888889 0.382407 3.0916667 0.381481 3.0944444 0.383333 3.0972222 0.383333
+ 3.1000000 0.387037 3.1027778 0.386111 3.1055556 0.382407 3.1083333 0.380556
+ 3.1111111 0.382407 3.1138889 0.382407 3.1166667 0.383333 3.1194444 0.384259
+ 3.1222222 0.385185 3.1250000 0.385185 3.1277778 0.383333 3.1305556 0.381481
+ 3.1333333 0.379630 3.1361111 0.377778 3.1388889 0.384259 3.1416667 0.387963
+ 3.1444444 0.396296 3.1472222 0.403704 3.1500000 0.407407 3.1527778 0.402778
+ 3.1555556 0.388889 3.1583333 0.366667 3.1611111 0.352778 3.1638889 0.352778
+ 3.1666667 0.353704 3.1694444 0.355556 3.1722222 0.354630 3.1750000 0.345370
+ 3.1777778 0.337037 3.1805556 0.330556 3.1833333 0.327778 3.1861111 0.323148
+ 3.1888889 0.317593 3.1916667 0.310185 3.1944444 0.302778 3.1972222 0.291667
+ 3.2000000 0.287037 3.2027778 0.281481 3.2055556 0.275000 3.2083333 0.273148
+ 3.2111111 0.279630 3.2138889 0.287037 3.2166667 0.291667 3.2194444 0.296296
+ 3.2222222 0.306481 3.2250000 0.320370 3.2277778 0.335185 3.2305556 0.346296
+ 3.2333333 0.352778 3.2361111 0.360185 3.2388889 0.366667 3.2416667 0.376852
+ 3.2444444 0.379630 3.2472222 0.387037 3.2500000 0.391667 3.2527778 0.396296
+ 3.2555556 0.396296 3.2583333 0.393519 3.2611111 0.391667 3.2638889 0.394444
+ 3.2666667 0.396296 3.2694444 0.394444 3.2722222 0.394444 3.2750000 0.394444
+ 3.2777778 0.395370 3.2805556 0.397222 3.2833333 0.398148 3.2861111 0.395370
+ 3.2888889 0.396296 3.2916667 0.392593 3.2944444 0.392593 3.2972222 0.398148
+ 3.3000000 0.400926 3.3027778 0.400000 3.3055556 0.400000 3.3083333 0.396296
+ 3.3111111 0.398148 3.3138889 0.398148 3.3166667 0.400926 3.3194444 0.398148
+ 3.3222222 0.400000 3.3250000 0.396296 3.3277778 0.397222 3.3305556 0.398148
+ 3.3333333 0.401852 3.3361111 0.403704 3.3388889 0.404630 3.3416667 0.399074
+ 3.3444444 0.399074 3.3472222 0.402778 3.3500000 0.402778 3.3527778 0.403704
+ 3.3555556 0.403704 3.3583333 0.402778 3.3611111 0.404630 3.3638889 0.410185
+ 3.3666667 0.413889 3.3694444 0.411111 3.3722222 0.410185 3.3750000 0.407407
+ 3.3777778 0.408333 3.3805556 0.410185 3.3833333 0.411111 3.3861111 0.411111
+ 3.3888889 0.412037 3.3916667 0.412037 3.3944444 0.413889 3.3972222 0.414815
+ 3.4000000 0.414815 3.4027778 0.416667 3.4055556 0.416667 3.4083333 0.412963
+ 3.4111111 0.412037 3.4138889 0.418519 3.4166667 0.420370 3.4194444 0.423148
+ 3.4222222 0.418519 3.4250000 0.416667 3.4277778 0.418519 3.4305556 0.420370
+ 3.4333333 0.424074 3.4361111 0.424074 3.4388889 0.420370 3.4416667 0.419444
+ 3.4444444 0.418519 3.4472222 0.420370 3.4500000 0.418519 3.4527778 0.418519
+ 3.4555556 0.420370 3.4583333 0.421296 3.4611111 0.420370 3.4638889 0.420370
+ 3.4666667 0.422222 3.4694444 0.419444 3.4722222 0.420370 3.4750000 0.415741
+ 3.4777778 0.414815 3.4805556 0.416667 3.4833333 0.415741 3.4861111 0.414815
+ 3.4888889 0.411111 3.4916667 0.408333 3.4944444 0.408333 3.4972222 0.409259
+ 3.5000000 0.411111 3.5027778 0.409259 3.5055556 0.408333 3.5083333 0.404630
+ 3.5111111 0.402778 3.5138889 0.403704 3.5166667 0.401852 3.5194444 0.400926
+ 3.5222222 0.401852 3.5250000 0.399074 3.5277778 0.400000 3.5305556 0.401852
+ 3.5333333 0.400926 3.5361111 0.403704 3.5388889 0.403704 3.5416667 0.400926
+ 3.5444444 0.399074 3.5472222 0.398148 3.5500000 0.400926 3.5527778 0.400926
+ 3.5555556 0.401852 3.5583333 0.401852 3.5611111 0.400926 3.5638889 0.400000
+ 3.5666667 0.402778 3.5694444 0.401852 3.5722222 0.401852 3.5750000 0.397222
+ 3.5777778 0.399074 3.5805556 0.399074 3.5833333 0.401852 3.5861111 0.400926
+ 3.5888889 0.398148 3.5916667 0.397222 3.5944444 0.398148 3.5972222 0.396296
+ 3.6000000 0.399074 3.6027778 0.399074 3.6055556 0.396296 3.6083333 0.395370
+ 3.6111111 0.394444 3.6138889 0.398148 3.6166667 0.400000 3.6194444 0.397222
+ 3.6222222 0.392593 3.6250000 0.393519 3.6277778 0.397222 3.6305556 0.397222
+ 3.6333333 0.397222 3.6361111 0.397222 3.6388889 0.394444 3.6416667 0.389815
+ 3.6444444 0.391667 3.6472222 0.389815 3.6500000 0.394444 3.6527778 0.395370
+ 3.6555556 0.391667 3.6583333 0.390741 3.6611111 0.388889 3.6638889 0.391667
+ 3.6666667 0.389815 3.6694444 0.390741 3.6722222 0.384259 3.6750000 0.382407
+ 3.6777778 0.383333 3.6805556 0.386111 3.6833333 0.389815 3.6861111 0.389815
+ 3.6888889 0.383333 3.6916667 0.383333 3.6944444 0.386111 3.6972222 0.386111
+ 3.7000000 0.387963 3.7027778 0.387963 3.7055556 0.385185 3.7083333 0.383333
+ 3.7111111 0.382407 3.7138889 0.383333 3.7166667 0.386111 3.7194444 0.386111
+ 3.7222222 0.385185 3.7250000 0.378704 3.7277778 0.379630 3.7305556 0.384259
+ 3.7333333 0.390741 3.7361111 0.391667 3.7388889 0.388889 3.7416667 0.386111
+ 3.7444444 0.387037 3.7472222 0.389815 3.7500000 0.392593 3.7527778 0.394444
+ 3.7555556 0.391667 3.7583333 0.388889 3.7611111 0.390741 3.7638889 0.388889
+ 3.7666667 0.390741 3.7694444 0.389815 3.7722222 0.387037 3.7750000 0.388889
+ 3.7777778 0.388889 3.7805556 0.390741 3.7833333 0.394444 3.7861111 0.391667
+ 3.7888889 0.392593 3.7916667 0.389815 3.7944444 0.389815 3.7972222 0.388889
+ 3.8000000 0.390741 3.8027778 0.391667 3.8055556 0.391667 3.8083333 0.390741
+ 3.8111111 0.393519 3.8138889 0.396296 3.8166667 0.396296 3.8194444 0.394444
+ 3.8222222 0.389815 3.8250000 0.385185 3.8277778 0.385185 3.8305556 0.389815
+ 3.8333333 0.398148 3.8361111 0.400000 3.8388889 0.398148 3.8416667 0.394444
+ 3.8444444 0.395370 3.8472222 0.394444 3.8500000 0.396296 3.8527778 0.396296
+ 3.8555556 0.392593 3.8583333 0.392593 3.8611111 0.390741 3.8638889 0.394444
+ 3.8666667 0.396296 3.8694444 0.395370 3.8722222 0.394444 3.8750000 0.391667
+ 3.8777778 0.390741 3.8805556 0.396296 3.8833333 0.400000 3.8861111 0.400926
+ 3.8888889 0.403704 3.8916667 0.402778 3.8944444 0.404630 3.8972222 0.407407
+ 3.9000000 0.408333 3.9027778 0.409259 3.9055556 0.411111 3.9083333 0.413889
+ 3.9111111 0.416667 3.9138889 0.422222 3.9166667 0.425000 3.9194444 0.426852
+ 3.9222222 0.428704 3.9250000 0.429630 3.9277778 0.433333 3.9305556 0.436111
+ 3.9333333 0.437963 3.9361111 0.437037 3.9388889 0.437037 3.9416667 0.437037
+ 3.9444444 0.436111 3.9472222 0.437037 3.9500000 0.437963 3.9527778 0.435185
+ 3.9555556 0.431481 3.9583333 0.421296 3.9611111 0.412963 3.9638889 0.406481
+ 3.9666667 0.398148 3.9694444 0.390741 3.9722222 0.384259 3.9750000 0.381481
+ 3.9777778 0.381481 3.9805556 0.384259 3.9833333 0.388889 3.9861111 0.389815
+ 3.9888889 0.387963 3.9916667 0.385185 3.9944444 0.384259 3.9972222 0.384259
+ 4.0000000 0.385185 4.0027778 0.384259 4.0055556 0.379630 4.0083333 0.380556
+ 4.0111111 0.384259 4.0138889 0.386111 4.0166667 0.389815 4.0194444 0.387963
+ 4.0222222 0.384259 4.0250000 0.379630 4.0277778 0.381481 4.0305556 0.386111
+ 4.0333333 0.385185 4.0361111 0.385185 4.0388889 0.386111 4.0416667 0.381481
+ 4.0444444 0.381481 4.0472222 0.383333 4.0500000 0.387037 4.0527778 0.386111
+ 4.0555556 0.387963 4.0583333 0.386111 4.0611111 0.385185 4.0638889 0.384259
+ 4.0666667 0.387963 4.0694444 0.387963 4.0722222 0.385185 4.0750000 0.378704
+ 4.0777778 0.375926 4.0805556 0.379630 4.0833333 0.387037 4.0861111 0.390741
+ 4.0888889 0.392593 4.0916667 0.394444 4.0944444 0.393519 4.0972222 0.384259
+ 4.1000000 0.365741 4.1027778 0.356481 4.1055556 0.350926 4.1083333 0.350000
+ 4.1111111 0.352778 4.1138889 0.350926 4.1166667 0.348148 4.1194444 0.337963
+ 4.1222222 0.329630 4.1250000 0.320370 4.1277778 0.316667 4.1305556 0.312963
+ 4.1333333 0.307407 4.1361111 0.295370 4.1388889 0.286111 4.1416667 0.278704
+ 4.1444444 0.277778 4.1472222 0.278704 4.1500000 0.285185 4.1527778 0.287963
+ 4.1555556 0.290741 4.1583333 0.293519 4.1611111 0.305556 4.1638889 0.325000
+ 4.1666667 0.339815 4.1694444 0.350000 4.1722222 0.358333 4.1750000 0.363889
+ 4.1777778 0.373148 4.1805556 0.382407 4.1833333 0.387963 4.1861111 0.392593
+ 4.1888889 0.393519 4.1916667 0.392593 4.1944444 0.392593 4.1972222 0.394444
+ 4.2000000 0.397222 4.2027778 0.396296 4.2055556 0.395370 4.2083333 0.395370
+ 4.2111111 0.399074 4.2138889 0.402778 4.2166667 0.402778 4.2194444 0.401852
+ 4.2222222 0.396296 4.2250000 0.392593 4.2277778 0.397222 4.2305556 0.405556
+ 4.2333333 0.408333 4.2361111 0.409259 4.2388889 0.407407 4.2416667 0.403704
+ 4.2444444 0.401852 4.2472222 0.400926 4.2500000 0.402778 4.2527778 0.403704
+ 4.2555556 0.401852 4.2583333 0.402778 4.2611111 0.402778 4.2638889 0.404630
+ 4.2666667 0.405556 4.2694444 0.407407 4.2722222 0.406481 4.2750000 0.405556
+ 4.2777778 0.410185 4.2805556 0.411111 4.2833333 0.412963 4.2861111 0.413889
+ 4.2888889 0.414815 4.2916667 0.412037 4.2944444 0.409259 4.2972222 0.408333
+ 4.3000000 0.412963 4.3027778 0.414815 4.3055556 0.415741 4.3083333 0.413889
+ 4.3111111 0.412037 4.3138889 0.414815 4.3166667 0.418519 4.3194444 0.421296
+ 4.3222222 0.418519 4.3250000 0.417593 4.3277778 0.421296 4.3305556 0.421296
+ 4.3333333 0.424074 4.3361111 0.418519 4.3388889 0.416667 4.3416667 0.413889
+ 4.3444444 0.418519 4.3472222 0.426852 4.3500000 0.429630 4.3527778 0.428704
+ 4.3555556 0.425000 4.3583333 0.423148 4.3611111 0.428704 4.3638889 0.435185
+ 4.3666667 0.439815 4.3694444 0.439815 4.3722222 0.429630 4.3750000 0.426852
+ 4.3777778 0.428704 4.3805556 0.430556 4.3833333 0.435185 4.3861111 0.434259
+ 4.3888889 0.431481 4.3916667 0.426852 4.3944444 0.424074 4.3972222 0.425000
+ 4.4000000 0.430556 4.4027778 0.428704 4.4055556 0.421296 4.4083333 0.425000
+ 4.4111111 0.429630 4.4138889 0.429630 4.4166667 0.425926 4.4194444 0.419444
+ 4.4222222 0.417593 4.4250000 0.415741 4.4277778 0.413889 4.4305556 0.416667
+ 4.4333333 0.416667 4.4361111 0.412037 4.4388889 0.404630 4.4416667 0.403704
+ 4.4444444 0.411111 4.4472222 0.417593 4.4500000 0.420370 4.4527778 0.414815
+ 4.4555556 0.410185 4.4583333 0.407407 4.4611111 0.413889 4.4638889 0.416667
+ 4.4666667 0.418519 4.4694444 0.418519 4.4722222 0.412963 4.4750000 0.406481
+ 4.4777778 0.407407 4.4805556 0.411111 4.4833333 0.412037 4.4861111 0.408333
+ 4.4888889 0.412963 4.4916667 0.411111 4.4944444 0.409259 4.4972222 0.408333
+ 4.5000000 0.409259 4.5027778 0.408333 4.5055556 0.407407 4.5083333 0.410185
+ 4.5111111 0.412037 4.5138889 0.415741 4.5166667 0.420370 4.5194444 0.416667
+ 4.5222222 0.411111 4.5250000 0.405556 4.5277778 0.404630 4.5305556 0.406481
+ 4.5333333 0.409259 4.5361111 0.409259 4.5388889 0.408333 4.5416667 0.405556
+ 4.5444444 0.406481 4.5472222 0.407407 4.5500000 0.406481 4.5527778 0.404630
+ 4.5555556 0.403704 4.5583333 0.402778 4.5611111 0.403704 4.5638889 0.402778
+ 4.5666667 0.401852 4.5694444 0.400000 4.5722222 0.397222 4.5750000 0.394444
+ 4.5777778 0.398148 4.5805556 0.405556 4.5833333 0.401852 4.5861111 0.396296
+ 4.5888889 0.391667 4.5916667 0.393519 4.5944444 0.390741 4.5972222 0.387037
+ 4.6000000 0.383333 4.6027778 0.385185 4.6055556 0.384259 4.6083333 0.378704
+ 4.6111111 0.372222 4.6138889 0.384259 4.6166667 0.400000 4.6194444 0.401852
+ 4.6222222 0.392593 4.6250000 0.392593 4.6277778 0.397222 4.6305556 0.402778
+ 4.6333333 0.405556 4.6361111 0.402778 4.6388889 0.396296 4.6416667 0.395370
+ 4.6444444 0.404630 4.6472222 0.412037 4.6500000 0.411111 4.6527778 0.406481
+ 4.6555556 0.403704 4.6583333 0.403704 4.6611111 0.405556 4.6638889 0.406481
+ 4.6666667 0.405556 4.6694444 0.404630 4.6722222 0.402778 4.6750000 0.399074
+ 4.6777778 0.401852 4.6805556 0.407407 4.6833333 0.406481 4.6861111 0.407407
+ 4.6888889 0.403704 4.6916667 0.400926 4.6944444 0.400000 4.6972222 0.404630
+ 4.7000000 0.406481 4.7027778 0.405556 4.7055556 0.402778 4.7083333 0.402778
+ 4.7111111 0.402778 4.7138889 0.405556 4.7166667 0.405556 4.7194444 0.406481
+ 4.7222222 0.402778 4.7250000 0.400926 4.7277778 0.401852 4.7305556 0.404630
+ 4.7333333 0.409259 4.7361111 0.407407 4.7388889 0.400926 4.7416667 0.399074
+ 4.7444444 0.399074 4.7472222 0.400000 4.7500000 0.405556 4.7527778 0.406481
+ 4.7555556 0.406481 4.7583333 0.398148 4.7611111 0.400926 4.7638889 0.399074
+ 4.7666667 0.400000 4.7694444 0.398148 4.7722222 0.401852 4.7750000 0.404630
+ 4.7777778 0.406481 4.7805556 0.401852 4.7833333 0.395370 4.7861111 0.392593
+ 4.7888889 0.398148 4.7916667 0.410185 4.7944444 0.425926 4.7972222 0.428704
+ 4.8000000 0.421296 4.8027778 0.421296 4.8055556 0.422222 4.8083333 0.421296
+ 4.8111111 0.420370 4.8138889 0.418519 4.8166667 0.421296 4.8194444 0.427778
+ 4.8222222 0.431481 4.8250000 0.430556 4.8277778 0.433333 4.8305556 0.436111
+ 4.8333333 0.439815 4.8361111 0.441667 4.8388889 0.439815 4.8416667 0.441667
+ 4.8444444 0.445370 4.8472222 0.447222 4.8500000 0.448148 4.8527778 0.445370
+ 4.8555556 0.448148 4.8583333 0.449074 4.8611111 0.450000 4.8638889 0.450000
+ 4.8666667 0.449074 4.8694444 0.442593 4.8722222 0.433333 4.8750000 0.424074
+ 4.8777778 0.417593 4.8805556 0.410185 4.8833333 0.401852 4.8861111 0.396296
+ 4.8888889 0.395370 4.8916667 0.397222 4.8944444 0.403704 4.8972222 0.407407
+ 4.9000000 0.402778 4.9027778 0.396296 4.9055556 0.389815 4.9083333 0.387037
+ 4.9111111 0.392593 4.9138889 0.399074 4.9166667 0.401852 4.9194444 0.399074
+ 4.9222222 0.390741 4.9250000 0.380556 4.9277778 0.375926 4.9305556 0.375926
+ 4.9333333 0.381481 4.9361111 0.392593 4.9388889 0.400926 4.9416667 0.398148
+ 4.9444444 0.393519 4.9472222 0.395370 4.9500000 0.391667 4.9527778 0.387963
+ 4.9555556 0.396296 4.9583333 0.405556 4.9611111 0.410185 4.9638889 0.405556
+ 4.9666667 0.400926 4.9694444 0.400926 4.9722222 0.398148 4.9750000 0.392593
+ 4.9777778 0.390741 4.9805556 0.396296 4.9833333 0.399074 4.9861111 0.400000
+ 4.9888889 0.392593 4.9916667 0.376852 4.9944444 0.368519 4.9972222 0.374074
+ 5.0000000 0.381481 5.0027778 0.377778 5.0055556 0.374074 5.0083333 0.369444
+ 5.0111111 0.362037 5.0138889 0.353704 5.0166667 0.344444 5.0194444 0.338889
+ 5.0222222 0.341667 5.0250000 0.338889 5.0277778 0.335185 5.0305556 0.331481
+ 5.0333333 0.323148 5.0361111 0.317593 5.0388889 0.312963 5.0416667 0.312037
+ 5.0444444 0.309259 5.0472222 0.303704 5.0500000 0.292593 5.0527778 0.280556
+ 5.0555556 0.273148 5.0583333 0.271296 5.0611111 0.281481 5.0638889 0.295370
+ 5.0666667 0.307407 5.0694444 0.312963 5.0722222 0.318519 5.0750000 0.330556
+ 5.0777778 0.343519 5.0805556 0.355556 5.0833333 0.364815 5.0861111 0.373148
+ 5.0888889 0.389815 5.0916667 0.404630 5.0944444 0.408333 5.0972222 0.409259
+ 5.1000000 0.412037 5.1027778 0.412037 5.1055556 0.412037 5.1083333 0.406481
+ 5.1111111 0.408333 5.1138889 0.410185 5.1166667 0.415741 5.1194444 0.412963
+ 5.1222222 0.408333 5.1250000 0.404630 5.1277778 0.405556 5.1305556 0.410185
+ 5.1333333 0.412963 5.1361111 0.414815 5.1388889 0.417593 5.1416667 0.420370
+ 5.1444444 0.420370 5.1472222 0.415741 5.1500000 0.408333 5.1527778 0.400000
+ 5.1555556 0.404630 5.1583333 0.413889 5.1611111 0.426852 5.1638889 0.434259
+ 5.1666667 0.436111 5.1694444 0.429630 5.1722222 0.425000 5.1750000 0.422222
+ 5.1777778 0.417593 5.1805556 0.422222 5.1833333 0.421296 5.1861111 0.423148
+ 5.1888889 0.424074 5.1916667 0.424074 5.1944444 0.425000 5.1972222 0.425926
+ 5.2000000 0.427778 5.2027778 0.427778 5.2055556 0.427778 5.2083333 0.424074
+ 5.2111111 0.425926 5.2138889 0.430556 5.2166667 0.435185 5.2194444 0.437037
+ 5.2222222 0.437037 5.2250000 0.437037 5.2277778 0.434259 5.2305556 0.433333
+ 5.2333333 0.434259 5.2361111 0.435185 5.2388889 0.436111 5.2416667 0.436111
+ 5.2444444 0.436111 5.2472222 0.435185 5.2500000 0.435185 5.2527778 0.434259
+ 5.2555556 0.441667 5.2583333 0.445370 5.2611111 0.442593 5.2638889 0.437963
+ 5.2666667 0.439815 5.2694444 0.443519 5.2722222 0.445370 5.2750000 0.444444
+ 5.2777778 0.447222 5.2805556 0.449074 5.2833333 0.446296 5.2861111 0.446296
+ 5.2888889 0.446296 5.2916667 0.446296 5.2944444 0.445370 5.2972222 0.446296
+ 5.3000000 0.446296 5.3027778 0.440741 5.3055556 0.436111 5.3083333 0.433333
+ 5.3111111 0.431481 5.3138889 0.431481 5.3166667 0.437963 5.3194444 0.441667
+ 5.3222222 0.440741 5.3250000 0.434259 5.3277778 0.429630 5.3305556 0.431481
+ 5.3333333 0.434259 5.3361111 0.435185 5.3388889 0.432407 5.3416667 0.426852
+ 5.3444444 0.424074 5.3472222 0.425000 5.3500000 0.425000 5.3527778 0.423148
+ 5.3555556 0.418519 5.3583333 0.416667 5.3611111 0.418519 5.3638889 0.418519
+ 5.3666667 0.417593 5.3694444 0.419444 5.3722222 0.416667 5.3750000 0.414815
+ 5.3777778 0.414815 5.3805556 0.415741 5.3833333 0.414815 5.3861111 0.413889
+ 5.3888889 0.412037 5.3916667 0.410185 5.3944444 0.409259 5.3972222 0.408333
+ 5.4000000 0.410185 5.4027778 0.411111 5.4055556 0.409259 5.4083333 0.409259
+ 5.4111111 0.408333 5.4138889 0.406481 5.4166667 0.406481 5.4194444 0.400926
+ 5.4222222 0.401852 5.4250000 0.400926 5.4277778 0.402778 5.4305556 0.401852
+ 5.4333333 0.401852 5.4361111 0.403704 5.4388889 0.408333 5.4416667 0.409259
+ 5.4444444 0.407407 5.4472222 0.405556 5.4500000 0.406481 5.4527778 0.406481
+ 5.4555556 0.402778 5.4583333 0.398148 5.4611111 0.400000 5.4638889 0.400926
+ 5.4666667 0.402778 5.4694444 0.402778 5.4722222 0.399074 5.4750000 0.395370
+ 5.4777778 0.395370 5.4805556 0.394444 5.4833333 0.395370 5.4861111 0.392593
+ 5.4888889 0.390741 5.4916667 0.389815 5.4944444 0.389815 5.4972222 0.391667
+ 5.5000000 0.391667 5.5027778 0.389815 5.5055556 0.385185 5.5083333 0.383333
+ 5.5111111 0.383333 5.5138889 0.387037 5.5166667 0.387963 5.5194444 0.387963
+ 5.5222222 0.386111 5.5250000 0.379630 5.5277778 0.379630 5.5305556 0.379630
+ 5.5333333 0.384259 5.5361111 0.384259 5.5388889 0.383333 5.5416667 0.380556
+ 5.5444444 0.378704 5.5472222 0.380556 5.5500000 0.382407 5.5527778 0.381481
+ 5.5555556 0.381481 5.5583333 0.382407 5.5611111 0.384259 5.5638889 0.380556
+ 5.5666667 0.373148 5.5694444 0.372222 5.5722222 0.380556 5.5750000 0.387037
+ 5.5777778 0.388889 5.5805556 0.387037 5.5833333 0.381481 5.5861111 0.379630
+ 5.5888889 0.379630 5.5916667 0.379630 5.5944444 0.379630 5.5972222 0.379630
+ 5.6000000 0.380556 5.6027778 0.378704 5.6055556 0.379630 5.6083333 0.377778
+ 5.6111111 0.381481 5.6138889 0.384259 5.6166667 0.385185 5.6194444 0.387037
+ 5.6222222 0.386111 5.6250000 0.381481 5.6277778 0.379630 5.6305556 0.383333
+ 5.6333333 0.385185 5.6361111 0.383333 5.6388889 0.379630 5.6416667 0.375926
+ 5.6444444 0.376852 5.6472222 0.381481 5.6500000 0.383333 5.6527778 0.383333
+ 5.6555556 0.383333 5.6583333 0.381481 5.6611111 0.382407 5.6638889 0.385185
+ 5.6666667 0.382407 5.6694444 0.381481 5.6722222 0.378704 5.6750000 0.381481
+ 5.6777778 0.382407 5.6805556 0.380556 5.6833333 0.378704 5.6861111 0.377778
+ 5.6888889 0.379630 5.6916667 0.382407 5.6944444 0.383333 5.6972222 0.383333
+ 5.7000000 0.381481 5.7027778 0.380556 5.7055556 0.378704 5.7083333 0.378704
+ 5.7111111 0.382407 5.7138889 0.383333 5.7166667 0.384259 5.7194444 0.384259
+ 5.7222222 0.380556 5.7250000 0.379630 5.7277778 0.385185 5.7305556 0.391667
+ 5.7333333 0.392593 5.7361111 0.388889 5.7388889 0.385185 5.7416667 0.387037
+ 5.7444444 0.394444 5.7472222 0.400000 5.7500000 0.400000 5.7527778 0.397222
+ 5.7555556 0.395370 5.7583333 0.394444 5.7611111 0.393519 5.7638889 0.398148
+ 5.7666667 0.403704 5.7694444 0.415741 5.7722222 0.420370 5.7750000 0.419444
+ 5.7777778 0.419444 5.7805556 0.422222 5.7833333 0.425926 5.7861111 0.425000
+ 5.7888889 0.423148 5.7916667 0.425000 5.7944444 0.425000 5.7972222 0.426852
+ 5.8000000 0.429630 5.8027778 0.428704 5.8055556 0.423148 5.8083333 0.415741
+ 5.8111111 0.411111 5.8138889 0.409259 5.8166667 0.404630 5.8194444 0.396296
+ 5.8222222 0.385185 5.8250000 0.375926 5.8277778 0.372222 5.8305556 0.373148
+ 5.8333333 0.376852 5.8361111 0.377778 5.8388889 0.376852 5.8416667 0.375000
+ 5.8444444 0.377778 5.8472222 0.379630 5.8500000 0.380556 5.8527778 0.376852
+ 5.8555556 0.375000 5.8583333 0.374074 5.8611111 0.379630 5.8638889 0.379630
+ 5.8666667 0.379630 5.8694444 0.379630 5.8722222 0.378704 5.8750000 0.376852
+ 5.8777778 0.374074 5.8805556 0.375926 5.8833333 0.381481 5.8861111 0.380556
+ 5.8888889 0.377778 5.8916667 0.375000 5.8944444 0.373148 5.8972222 0.375926
+ 5.9000000 0.380556 5.9027778 0.382407 5.9055556 0.381481 5.9083333 0.377778
+ 5.9111111 0.375926 5.9138889 0.380556 5.9166667 0.384259 5.9194444 0.382407
+ 5.9222222 0.375926 5.9250000 0.365741 5.9277778 0.365741 5.9305556 0.371296
+ 5.9333333 0.376852 5.9361111 0.375926 5.9388889 0.375000 5.9416667 0.369444
+ 5.9444444 0.362037 5.9472222 0.347222 5.9500000 0.335185 5.9527778 0.329630
+ 5.9555556 0.329630 5.9583333 0.327778 5.9611111 0.326852 5.9638889 0.322222
+ 5.9666667 0.314815 5.9694444 0.307407 5.9722222 0.296296 5.9750000 0.288889
+ 5.9777778 0.292593 5.9805556 0.290741 5.9833333 0.281481 5.9861111 0.273148
+ 5.9888889 0.265741 5.9916667 0.262963 5.9944444 0.270370 5.9972222 0.282407
+ 6.0000000 0.289815 6.0027778 0.292593 6.0055556 0.299074 6.0083333 0.310185
+ 6.0111111 0.325000 6.0138889 0.333333 6.0166667 0.343519 6.0194444 0.351852
+ 6.0222222 0.365741 6.0250000 0.374074 6.0277778 0.382407 6.0305556 0.384259
+ 6.0333333 0.386111 6.0361111 0.387037 6.0388889 0.386111 6.0416667 0.385185
+ 6.0444444 0.389815 6.0472222 0.393519 6.0500000 0.395370 6.0527778 0.395370
+ 6.0555556 0.390741 6.0583333 0.387963 6.0611111 0.389815 6.0638889 0.395370
+ 6.0666667 0.397222 6.0694444 0.396296 6.0722222 0.392593 6.0750000 0.389815
+ 6.0777778 0.392593 6.0805556 0.391667 6.0833333 0.395370 6.0861111 0.399074
+ 6.0888889 0.397222 6.0916667 0.396296 6.0944444 0.396296 6.0972222 0.397222
+ 6.1000000 0.396296 6.1027778 0.394444 6.1055556 0.392593 6.1083333 0.390741
+ 6.1111111 0.395370 6.1138889 0.401852 6.1166667 0.407407 6.1194444 0.406481
+ 6.1222222 0.402778 6.1250000 0.399074 6.1277778 0.401852 6.1305556 0.403704
+ 6.1333333 0.406481 6.1361111 0.406481 6.1388889 0.408333 6.1416667 0.406481
+ 6.1444444 0.407407 6.1472222 0.408333 6.1500000 0.411111 6.1527778 0.411111
+ 6.1555556 0.411111 6.1583333 0.410185 6.1611111 0.410185 6.1638889 0.410185
+ 6.1666667 0.412963 6.1694444 0.412037 6.1722222 0.412963 6.1750000 0.410185
+ 6.1777778 0.412963 6.1805556 0.418519 6.1833333 0.423148 6.1861111 0.425000
+ 6.1888889 0.421296 6.1916667 0.419444 6.1944444 0.422222 6.1972222 0.422222
+ 6.2000000 0.424074 6.2027778 0.423148 6.2055556 0.420370 6.2083333 0.419444
+ 6.2111111 0.420370 6.2138889 0.425000 6.2166667 0.429630 6.2194444 0.427778
+ 6.2222222 0.427778 6.2250000 0.422222 6.2277778 0.424074 6.2305556 0.424074
+ 6.2333333 0.427778 6.2361111 0.424074 6.2388889 0.425926 6.2416667 0.420370
+ 6.2444444 0.421296 6.2472222 0.423148 6.2500000 0.423148 6.2527778 0.419444
+ 6.2555556 0.415741 6.2583333 0.417593 6.2611111 0.422222 6.2638889 0.423148
+ 6.2666667 0.420370 6.2694444 0.415741 6.2722222 0.411111 6.2750000 0.410185
+ 6.2777778 0.411111 6.2805556 0.412963 6.2833333 0.412963 6.2861111 0.408333
+ 6.2888889 0.408333 6.2916667 0.402778 6.2944444 0.404630 6.2972222 0.402778
+ 6.3000000 0.402778 6.3027778 0.401852 6.3055556 0.400926 6.3083333 0.399074
+ 6.3111111 0.401852 6.3138889 0.405556 6.3166667 0.405556 6.3194444 0.401852
+ 6.3222222 0.400000 6.3250000 0.396296 6.3277778 0.400000 6.3305556 0.399074
+ 6.3333333 0.399074 6.3361111 0.393519 6.3388889 0.389815 6.3416667 0.392593
+ 6.3444444 0.400926 6.3472222 0.406481 6.3500000 0.405556 6.3527778 0.400000
+ 6.3555556 0.395370 6.3583333 0.390741 6.3611111 0.391667 6.3638889 0.396296
+ 6.3666667 0.400000 6.3694444 0.402778 6.3722222 0.401852 6.3750000 0.396296
+ 6.3777778 0.396296 6.3805556 0.395370 6.3833333 0.397222 6.3861111 0.396296
+ 6.3888889 0.396296 6.3916667 0.393519 6.3944444 0.391667 6.3972222 0.395370
+ 6.4000000 0.397222 6.4027778 0.397222 6.4055556 0.393519 6.4083333 0.389815
+ 6.4111111 0.390741 6.4138889 0.394444 6.4166667 0.397222 6.4194444 0.393519
+ 6.4222222 0.390741 6.4250000 0.387963 6.4277778 0.391667 6.4305556 0.392593
+ 6.4333333 0.396296 6.4361111 0.390741 6.4388889 0.388889 6.4416667 0.387037
+ 6.4444444 0.391667 6.4472222 0.390741 6.4500000 0.391667 6.4527778 0.389815
+ 6.4555556 0.384259 6.4583333 0.384259 6.4611111 0.385185 6.4638889 0.387037
+ 6.4666667 0.388889 6.4694444 0.387037 6.4722222 0.384259 6.4750000 0.383333
+ 6.4777778 0.383333 6.4805556 0.384259 6.4833333 0.384259 6.4861111 0.384259
+ 6.4888889 0.379630 6.4916667 0.376852 6.4944444 0.378704 6.4972222 0.383333
+ 6.5000000 0.386111 6.5027778 0.387963 6.5055556 0.384259 6.5083333 0.380556
+ 6.5111111 0.377778 6.5138889 0.376852 6.5166667 0.378704 6.5194444 0.379630
+ 6.5222222 0.380556 6.5250000 0.382407 6.5277778 0.383333 6.5305556 0.384259
+ 6.5333333 0.387037 6.5361111 0.384259 6.5388889 0.381481 6.5416667 0.380556
+ 6.5444444 0.383333 6.5472222 0.383333 6.5500000 0.383333 6.5527778 0.380556
+ 6.5555556 0.378704 6.5583333 0.376852 6.5611111 0.378704 6.5638889 0.383333
+ 6.5666667 0.387963 6.5694444 0.388889 6.5722222 0.387963 6.5750000 0.385185
+ 6.5777778 0.385185 6.5805556 0.386111 6.5833333 0.387037 6.5861111 0.387037
+ 6.5888889 0.389815 6.5916667 0.387037 6.5944444 0.387037 6.5972222 0.387963
+ 6.6000000 0.388889 6.6027778 0.388889 6.6055556 0.387037 6.6083333 0.386111
+ 6.6111111 0.388889 6.6138889 0.387963 6.6166667 0.392593 6.6194444 0.390741
+ 6.6222222 0.389815 6.6250000 0.387963 6.6277778 0.388889 6.6305556 0.390741
+ 6.6333333 0.391667 6.6361111 0.392593 6.6388889 0.390741 6.6416667 0.389815
+ 6.6444444 0.391667 6.6472222 0.392593 6.6500000 0.394444 6.6527778 0.396296
+ 6.6555556 0.392593 6.6583333 0.389815 6.6611111 0.389815 6.6638889 0.391667
+ 6.6666667 0.394444 6.6694444 0.391667 6.6722222 0.391667 6.6750000 0.389815
+ 6.6777778 0.389815 6.6805556 0.390741 6.6833333 0.394444 6.6861111 0.393519
+ 6.6888889 0.390741 6.6916667 0.389815 6.6944444 0.391667 6.6972222 0.393519
+ 6.7000000 0.392593 6.7027778 0.391667 6.7055556 0.394444 6.7083333 0.389815
+ 6.7111111 0.388889 6.7138889 0.392593 6.7166667 0.402778 6.7194444 0.407407
+ 6.7222222 0.409259 6.7250000 0.407407 6.7277778 0.407407 6.7305556 0.409259
+ 6.7333333 0.412963 6.7361111 0.411111 6.7388889 0.416667 6.7416667 0.417593
+ 6.7444444 0.424074 6.7472222 0.425926 6.7500000 0.427778 6.7527778 0.432407
+ 6.7555556 0.430556 6.7583333 0.430556 6.7611111 0.429630 6.7638889 0.430556
+ 6.7666667 0.432407 6.7694444 0.434259 6.7722222 0.435185 6.7750000 0.437037
+ 6.7777778 0.437037 6.7805556 0.439815 6.7833333 0.435185 6.7861111 0.428704
+ 6.7888889 0.418519 6.7916667 0.411111 6.7944444 0.408333 6.7972222 0.401852
+ 6.8000000 0.396296 6.8027778 0.388889 6.8055556 0.386111 6.8083333 0.383333
+ 6.8111111 0.384259 6.8138889 0.387037 6.8166667 0.385185 6.8194444 0.385185
+ 6.8222222 0.381481 6.8250000 0.381481 6.8277778 0.377778 6.8305556 0.381481
+ 6.8333333 0.388889 6.8361111 0.392593 6.8388889 0.389815 6.8416667 0.387037
+ 6.8444444 0.384259 6.8472222 0.383333 6.8500000 0.387037 6.8527778 0.385185
+ 6.8555556 0.381481 6.8583333 0.383333 6.8611111 0.383333 6.8638889 0.384259
+ 6.8666667 0.384259 6.8694444 0.383333 6.8722222 0.381481 6.8750000 0.380556
+ 6.8777778 0.382407 6.8805556 0.385185 6.8833333 0.386111 6.8861111 0.385185
+ 6.8888889 0.385185 6.8916667 0.386111 6.8944444 0.383333 6.8972222 0.383333
+ 6.9000000 0.382407 6.9027778 0.383333 6.9055556 0.383333 6.9083333 0.378704
+ 6.9111111 0.375926 6.9138889 0.378704 6.9166667 0.377778 6.9194444 0.374074
+ 6.9222222 0.370370 6.9250000 0.369444 6.9277778 0.371296 6.9305556 0.371296
+ 6.9333333 0.375926 6.9361111 0.376852 6.9388889 0.367593 6.9416667 0.350000
+ 6.9444444 0.339815 6.9472222 0.335185 6.9500000 0.339815 6.9527778 0.341667
+ 6.9555556 0.336111 6.9583333 0.330556 6.9611111 0.325000 6.9638889 0.318519
+ 6.9666667 0.313889 6.9694444 0.307407 6.9722222 0.301852 6.9750000 0.300926
+ 6.9777778 0.300000 6.9805556 0.290741 6.9833333 0.279630 6.9861111 0.271296
+ 6.9888889 0.269444 6.9916667 0.267593 6.9944444 0.272222 6.9972222 0.279630
+ 7.0000000 0.287037 7.0027778 0.292593 7.0055556 0.298148 7.0083333 0.304630
+ 7.0111111 0.319444 7.0138889 0.334259 7.0166667 0.345370 7.0194444 0.353704
+ 7.0222222 0.358333 7.0250000 0.366667 7.0277778 0.381481 7.0305556 0.386111
+ 7.0333333 0.389815 7.0361111 0.393519 7.0388889 0.395370 7.0416667 0.395370
+ 7.0444444 0.395370 7.0472222 0.397222 7.0500000 0.399074 7.0527778 0.402778
+ 7.0555556 0.400926 7.0583333 0.400000 7.0611111 0.400000 7.0638889 0.403704
+ 7.0666667 0.406481 7.0694444 0.402778 7.0722222 0.401852 7.0750000 0.398148
+ 7.0777778 0.398148 7.0805556 0.401852 7.0833333 0.403704 7.0861111 0.407407
+ 7.0888889 0.402778 7.0916667 0.401852 7.0944444 0.403704 7.0972222 0.405556
+ 7.1000000 0.407407 7.1027778 0.407407 7.1055556 0.407407 7.1083333 0.404630
+ 7.1111111 0.408333 7.1138889 0.408333 7.1166667 0.408333 7.1194444 0.411111
+ 7.1222222 0.408333 7.1250000 0.407407 7.1277778 0.408333 7.1305556 0.406481
+ 7.1333333 0.408333 7.1361111 0.408333 7.1388889 0.407407 7.1416667 0.405556
+ 7.1444444 0.409259 7.1472222 0.412037 7.1500000 0.411111 7.1527778 0.411111
+ 7.1555556 0.413889 7.1583333 0.414815 7.1611111 0.416667 7.1638889 0.414815
+ 7.1666667 0.412963 7.1694444 0.413889 7.1722222 0.415741 7.1750000 0.412037
+ 7.1777778 0.416667 7.1805556 0.417593 7.1833333 0.422222 7.1861111 0.424074
+ 7.1888889 0.424074 7.1916667 0.424074 7.1944444 0.423148 7.1972222 0.424074
+ 7.2000000 0.423148 7.2027778 0.425000 7.2055556 0.425926 7.2083333 0.426852
+ 7.2111111 0.426852 7.2138889 0.424074 7.2166667 0.426852 7.2194444 0.426852
+ 7.2222222 0.427778 7.2250000 0.426852 7.2277778 0.432407 7.2305556 0.435185
+ 7.2333333 0.433333 7.2361111 0.433333 7.2388889 0.428704 7.2416667 0.426852
+ 7.2444444 0.426852 7.2472222 0.426852 7.2500000 0.425926 7.2527778 0.425926
+ 7.2555556 0.425926 7.2583333 0.425000 7.2611111 0.424074 7.2638889 0.424074
+ 7.2666667 0.423148 7.2694444 0.422222 7.2722222 0.419444 7.2750000 0.419444
+ 7.2777778 0.421296 7.2805556 0.421296 7.2833333 0.419444 7.2861111 0.412963
+ 7.2888889 0.410185 7.2916667 0.407407 7.2944444 0.409259 7.2972222 0.408333
+ 7.3000000 0.405556 7.3027778 0.403704 7.3055556 0.402778 7.3083333 0.403704
+ 7.3111111 0.401852 7.3138889 0.400926 7.3166667 0.405556 7.3194444 0.404630
+ 7.3222222 0.401852 7.3250000 0.396296 7.3277778 0.398148 7.3305556 0.399074
+ 7.3333333 0.399074 7.3361111 0.395370 7.3388889 0.397222 7.3416667 0.396296
+ 7.3444444 0.400926 7.3472222 0.400000 7.3500000 0.398148 7.3527778 0.397222
+ 7.3555556 0.394444 7.3583333 0.394444 7.3611111 0.391667 7.3638889 0.389815
+ 7.3666667 0.391667 7.3694444 0.392593 7.3722222 0.392593 7.3750000 0.392593
+ 7.3777778 0.392593 7.3805556 0.396296 7.3833333 0.396296 7.3861111 0.396296
+ 7.3888889 0.392593 7.3916667 0.390741 7.3944444 0.391667 7.3972222 0.392593
+ 7.4000000 0.394444 7.4027778 0.390741 7.4055556 0.384259 7.4083333 0.382407
+ 7.4111111 0.386111 7.4138889 0.389815 7.4166667 0.388889 7.4194444 0.387963
+ 7.4222222 0.385185 7.4250000 0.384259 7.4277778 0.380556 7.4305556 0.382407
+ 7.4333333 0.388889 7.4361111 0.388889 7.4388889 0.385185 7.4416667 0.382407
+ 7.4444444 0.383333 7.4472222 0.387037 7.4500000 0.390741 7.4527778 0.389815
+ 7.4555556 0.386111 7.4583333 0.380556 7.4611111 0.379630 7.4638889 0.382407
+ 7.4666667 0.384259 7.4694444 0.384259 7.4722222 0.377778 7.4750000 0.373148
+ 7.4777778 0.375000 7.4805556 0.375926 7.4833333 0.377778 7.4861111 0.376852
+ 7.4888889 0.375926 7.4916667 0.372222 7.4944444 0.374074 7.4972222 0.374074
+ 7.5000000 0.372222 7.5027778 0.373148 7.5055556 0.375000 7.5083333 0.374074
+ 7.5111111 0.376852 7.5138889 0.375926 7.5166667 0.375926 7.5194444 0.375000
+ 7.5222222 0.372222 7.5250000 0.372222 7.5277778 0.373148 7.5305556 0.377778
+ 7.5333333 0.376852 7.5361111 0.373148 7.5388889 0.372222 7.5416667 0.371296
+ 7.5444444 0.374074 7.5472222 0.375000 7.5500000 0.374074 7.5527778 0.375000
+ 7.5555556 0.375000 7.5583333 0.372222 7.5611111 0.372222 7.5638889 0.374074
+ 7.5666667 0.376852 7.5694444 0.378704 7.5722222 0.378704 7.5750000 0.375926
+ 7.5777778 0.374074 7.5805556 0.376852 7.5833333 0.377778 7.5861111 0.378704
+ 7.5888889 0.375926 7.5916667 0.374074 7.5944444 0.378704 7.5972222 0.379630
+ 7.6000000 0.377778 7.6027778 0.374074 7.6055556 0.374074 7.6083333 0.378704
+ 7.6111111 0.384259 7.6138889 0.387037 7.6166667 0.387037 7.6194444 0.381481
+ 7.6222222 0.375926 7.6250000 0.373148 7.6277778 0.378704 7.6305556 0.383333
+ 7.6333333 0.384259 7.6361111 0.381481 7.6388889 0.382407 7.6416667 0.380556
+ 7.6444444 0.383333 7.6472222 0.386111 7.6500000 0.383333 7.6527778 0.381481
+ 7.6555556 0.381481 7.6583333 0.379630 7.6611111 0.382407 7.6638889 0.385185
+ 7.6666667 0.384259 7.6694444 0.385185 7.6722222 0.383333 7.6750000 0.380556
+ 7.6777778 0.377778 7.6805556 0.379630 7.6833333 0.383333 7.6861111 0.387963
+ 7.6888889 0.387037 7.6916667 0.383333 7.6944444 0.381481 7.6972222 0.383333
+ 7.7000000 0.383333 7.7027778 0.387963 7.7055556 0.390741 7.7083333 0.386111
+ 7.7111111 0.384259 7.7138889 0.383333 7.7166667 0.384259 7.7194444 0.382407
+ 7.7222222 0.383333 7.7250000 0.381481 7.7277778 0.382407 7.7305556 0.384259
+ 7.7333333 0.385185 7.7361111 0.386111 7.7388889 0.384259 7.7416667 0.380556
+ 7.7444444 0.375926 7.7472222 0.377778 7.7500000 0.385185 7.7527778 0.396296
+ 7.7555556 0.400000 7.7583333 0.396296 7.7611111 0.396296 7.7638889 0.397222
+ 7.7666667 0.400000 7.7694444 0.400000 7.7722222 0.398148 7.7750000 0.395370
+ 7.7777778 0.402778 7.7805556 0.405556 7.7833333 0.410185 7.7861111 0.412037
+ 7.7888889 0.413889 7.7916667 0.414815 7.7944444 0.422222 7.7972222 0.424074
+ 7.8000000 0.428704 7.8027778 0.424074 7.8055556 0.420370 7.8083333 0.421296
+ 7.8111111 0.425926 7.8138889 0.428704 7.8166667 0.435185 7.8194444 0.433333
+ 7.8222222 0.432407 7.8250000 0.423148 7.8277778 0.409259 7.8305556 0.401852
+ 7.8333333 0.400000 7.8361111 0.395370 7.8388889 0.389815 7.8416667 0.381481
+ 7.8444444 0.378704 7.8472222 0.376852 7.8500000 0.380556 7.8527778 0.379630
+ 7.8555556 0.379630 7.8583333 0.375000 7.8611111 0.376852 7.8638889 0.379630
+ 7.8666667 0.378704 7.8694444 0.375926 7.8722222 0.375000 7.8750000 0.374074
+ 7.8777778 0.375926 7.8805556 0.376852 7.8833333 0.376852 7.8861111 0.377778
+ 7.8888889 0.374074 7.8916667 0.374074 7.8944444 0.376852 7.8972222 0.378704
+ 7.9000000 0.381481 7.9027778 0.378704 7.9055556 0.375926 7.9083333 0.375926
+ 7.9111111 0.373148 7.9138889 0.374074 7.9166667 0.375926 7.9194444 0.380556
+ 7.9222222 0.376852 7.9250000 0.375000 7.9277778 0.374074 7.9305556 0.375000
+ 7.9333333 0.375926 7.9361111 0.376852 7.9388889 0.376852 7.9416667 0.374074
+ 7.9444444 0.376852 7.9472222 0.378704 7.9500000 0.376852 7.9527778 0.373148
+ 7.9555556 0.364815 7.9583333 0.366667 7.9611111 0.371296 7.9638889 0.375000
+ 7.9666667 0.378704 7.9694444 0.377778 7.9722222 0.375000 7.9750000 0.362037
+ 7.9777778 0.348148 7.9805556 0.337037 7.9833333 0.333333 7.9861111 0.329630
+ 7.9888889 0.326852 7.9916667 0.327778 7.9944444 0.327778 7.9972222 0.322222
+ 8.0000000 0.312037 8.0027778 0.303704 8.0055556 0.296296 8.0083333 0.289815
+ 8.0111111 0.289815 8.0138889 0.283333 8.0166667 0.275000 8.0194444 0.265741
+ 8.0222222 0.260185 8.0250000 0.259259 8.0277778 0.260185 8.0305556 0.265741
+ 8.0333333 0.275926 8.0361111 0.284259 8.0388889 0.285185 8.0416667 0.293519
+ 8.0444444 0.311111 8.0472222 0.326852 8.0500000 0.339815 8.0527778 0.347222
+ 8.0555556 0.350926 8.0583333 0.354630 8.0611111 0.364815 8.0638889 0.375926
+ 8.0666667 0.386111 8.0694444 0.389815 8.0722222 0.390741 8.0750000 0.388889
+ 8.0777778 0.390741 8.0805556 0.392593 8.0833333 0.395370 8.0861111 0.395370
+ 8.0888889 0.395370 8.0916667 0.391667 8.0944444 0.394444 8.0972222 0.396296
+ 8.1000000 0.396296 8.1027778 0.397222 8.1055556 0.396296 8.1083333 0.392593
+ 8.1111111 0.394444 8.1138889 0.397222 8.1166667 0.400000 8.1194444 0.399074
+ 8.1222222 0.398148 8.1250000 0.396296 8.1277778 0.395370 8.1305556 0.395370
+ 8.1333333 0.397222 8.1361111 0.401852 8.1388889 0.401852 8.1416667 0.400000
+ 8.1444444 0.396296 8.1472222 0.399074 8.1500000 0.401852 8.1527778 0.400000
+ 8.1555556 0.400926 8.1583333 0.400926 8.1611111 0.400000 8.1638889 0.402778
+ 8.1666667 0.402778 8.1694444 0.403704 8.1722222 0.405556 8.1750000 0.404630
+ 8.1777778 0.406481 8.1805556 0.406481 8.1833333 0.411111 8.1861111 0.409259
+ 8.1888889 0.406481 8.1916667 0.404630 8.1944444 0.405556 8.1972222 0.406481
+ 8.2000000 0.411111 8.2027778 0.414815 8.2055556 0.413889 8.2083333 0.413889
+ 8.2111111 0.412963 8.2138889 0.411111 8.2166667 0.413889 8.2194444 0.416667
+ 8.2222222 0.418519 8.2250000 0.416667 8.2277778 0.416667 8.2305556 0.419444
+ 8.2333333 0.419444 8.2361111 0.420370 8.2388889 0.420370 8.2416667 0.417593
+ 8.2444444 0.418519 8.2472222 0.420370 8.2500000 0.420370 8.2527778 0.420370
+ 8.2555556 0.420370 8.2583333 0.421296 8.2611111 0.423148 8.2638889 0.421296
+ 8.2666667 0.420370 8.2694444 0.421296 8.2722222 0.420370 8.2750000 0.417593
+ 8.2777778 0.420370 8.2805556 0.424074 8.2833333 0.425926 8.2861111 0.424074
+ 8.2888889 0.423148 8.2916667 0.421296 8.2944444 0.421296 8.2972222 0.420370
+ 8.3000000 0.419444 8.3027778 0.417593 8.3055556 0.415741 8.3083333 0.411111
+ 8.3111111 0.408333 8.3138889 0.407407 8.3166667 0.410185 8.3194444 0.409259
+ 8.3222222 0.407407 8.3250000 0.405556 8.3277778 0.404630 8.3305556 0.402778
+ 8.3333333 0.404630 8.3361111 0.401852 8.3388889 0.398148 8.3416667 0.398148
+ 8.3444444 0.396296 8.3472222 0.399074 8.3500000 0.400926 8.3527778 0.400926
+ 8.3555556 0.395370 8.3583333 0.394444 8.3611111 0.396296 8.3638889 0.397222
+ 8.3666667 0.398148 8.3694444 0.397222 8.3722222 0.399074 8.3750000 0.397222
+ 8.3777778 0.395370 8.3805556 0.397222 8.3833333 0.399074 8.3861111 0.396296
+ 8.3888889 0.394444 8.3916667 0.393519 8.3944444 0.395370 8.3972222 0.399074
+ 8.4000000 0.398148 8.4027778 0.396296 8.4055556 0.393519 8.4083333 0.391667
+ 8.4111111 0.392593 8.4138889 0.396296 8.4166667 0.395370 8.4194444 0.395370
+ 8.4222222 0.391667 8.4250000 0.389815 8.4277778 0.389815 8.4305556 0.393519
+ 8.4333333 0.393519 8.4361111 0.393519 8.4388889 0.392593 8.4416667 0.390741
+ 8.4444444 0.388889 8.4472222 0.391667 8.4500000 0.392593 8.4527778 0.391667
+ 8.4555556 0.391667 8.4583333 0.387037 8.4611111 0.386111 8.4638889 0.386111
+ 8.4666667 0.389815 8.4694444 0.389815 8.4722222 0.387037 8.4750000 0.382407
+ 8.4777778 0.386111 8.4805556 0.387963 8.4833333 0.387963 8.4861111 0.387963
+ 8.4888889 0.387037 8.4916667 0.382407 8.4944444 0.381481 8.4972222 0.383333
+ 8.5000000 0.383333 8.5027778 0.384259 8.5055556 0.382407 8.5083333 0.377778
+ 8.5111111 0.378704 8.5138889 0.379630 8.5166667 0.380556 8.5194444 0.379630
+ 8.5222222 0.376852 8.5250000 0.373148 8.5277778 0.374074 8.5305556 0.375000
+ 8.5333333 0.379630 8.5361111 0.379630 8.5388889 0.375926 8.5416667 0.372222
+ 8.5444444 0.374074 8.5472222 0.373148 8.5500000 0.376852 8.5527778 0.380556
+ 8.5555556 0.378704 8.5583333 0.375000 8.5611111 0.373148 8.5638889 0.374074
+ 8.5666667 0.377778 8.5694444 0.380556 8.5722222 0.380556 8.5750000 0.376852
+ 8.5777778 0.375000 8.5805556 0.374074 8.5833333 0.376852 8.5861111 0.378704
+ 8.5888889 0.375926 8.5916667 0.377778 8.5944444 0.382407 8.5972222 0.385185
+ 8.6000000 0.381481 8.6027778 0.377778 8.6055556 0.375926 8.6083333 0.377778
+ 8.6111111 0.380556 8.6138889 0.380556 8.6166667 0.382407 8.6194444 0.382407
+ 8.6222222 0.379630 8.6250000 0.378704 8.6277778 0.376852 8.6305556 0.378704
+ 8.6333333 0.378704 8.6361111 0.378704 8.6388889 0.384259 8.6416667 0.384259
+ 8.6444444 0.383333 8.6472222 0.383333 8.6500000 0.383333 8.6527778 0.382407
+ 8.6555556 0.384259 8.6583333 0.382407 8.6611111 0.383333 8.6638889 0.382407
+ 8.6666667 0.382407 8.6694444 0.379630 8.6722222 0.381481 8.6750000 0.380556
+ 8.6777778 0.381481 8.6805556 0.383333 8.6833333 0.384259 8.6861111 0.381481
+ 8.6888889 0.382407 8.6916667 0.378704 8.6944444 0.381481 8.6972222 0.382407
+ 8.7000000 0.381481 8.7027778 0.380556 8.7055556 0.381481 8.7083333 0.380556
+ 8.7111111 0.381481 8.7138889 0.383333 8.7166667 0.385185 8.7194444 0.386111
+ 8.7222222 0.386111 8.7250000 0.383333 8.7277778 0.387037 8.7305556 0.390741
+ 8.7333333 0.388889 8.7361111 0.390741 8.7388889 0.391667 8.7416667 0.388889
+ 8.7444444 0.390741 8.7472222 0.395370 8.7500000 0.397222 8.7527778 0.399074
+ 8.7555556 0.407407 8.7583333 0.412963 8.7611111 0.416667 8.7638889 0.413889
+ 8.7666667 0.415741 8.7694444 0.419444 8.7722222 0.420370 8.7750000 0.419444
+ 8.7777778 0.419444 8.7805556 0.421296 8.7833333 0.425926 8.7861111 0.429630
+ 8.7888889 0.427778 8.7916667 0.422222 8.7944444 0.420370 8.7972222 0.413889
+ 8.8000000 0.409259 8.8027778 0.402778 8.8055556 0.395370 8.8083333 0.387963
+ 8.8111111 0.379630 8.8138889 0.375000 8.8166667 0.374074 8.8194444 0.370370
+ 8.8222222 0.372222 8.8250000 0.371296 8.8277778 0.369444 8.8305556 0.373148
+ 8.8333333 0.373148 8.8361111 0.373148 8.8388889 0.371296 8.8416667 0.369444
+ 8.8444444 0.366667 8.8472222 0.366667 8.8500000 0.372222 8.8527778 0.375000
+ 8.8555556 0.373148 8.8583333 0.368519 8.8611111 0.368519 8.8638889 0.369444
+ 8.8666667 0.373148 8.8694444 0.370370 8.8722222 0.372222 8.8750000 0.373148
+ 8.8777778 0.374074 8.8805556 0.374074 8.8833333 0.374074 8.8861111 0.370370
+ 8.8888889 0.368519 8.8916667 0.366667 8.8944444 0.368519 8.8972222 0.370370
+ 8.9000000 0.369444 8.9027778 0.372222 8.9055556 0.374074 8.9083333 0.370370
+ 8.9111111 0.371296 8.9138889 0.371296 8.9166667 0.372222 8.9194444 0.369444
+ 8.9222222 0.365741 8.9250000 0.360185 8.9277778 0.362963 8.9305556 0.370370
+ 8.9333333 0.377778 8.9361111 0.375926 8.9388889 0.372222 8.9416667 0.373148
+ 8.9444444 0.367593 8.9472222 0.354630 8.9500000 0.336111 8.9527778 0.327778
+ 8.9555556 0.325000 8.9583333 0.325000 8.9611111 0.322222 8.9638889 0.320370
+ 8.9666667 0.319444 8.9694444 0.311111 8.9722222 0.300926 8.9750000 0.291667
+ 8.9777778 0.284259 8.9805556 0.281481 8.9833333 0.278704 8.9861111 0.269444
+ 8.9888889 0.259259 8.9916667 0.250000 8.9944444 0.250926 8.9972222 0.254630
+ 9.0000000 0.262037 9.0027778 0.271296 9.0055556 0.276852 9.0083333 0.278704
+ 9.0111111 0.286111 9.0138889 0.301852 9.0166667 0.319444 9.0194444 0.331481
+ 9.0222222 0.337037 9.0250000 0.341667 9.0277778 0.352778 9.0305556 0.366667
+ 9.0333333 0.375000 9.0361111 0.377778 9.0388889 0.376852 9.0416667 0.376852
+ 9.0444444 0.378704 9.0472222 0.381481 9.0500000 0.385185 9.0527778 0.387037
+ 9.0555556 0.385185 9.0583333 0.383333 9.0611111 0.383333 9.0638889 0.387037
+ 9.0666667 0.387963 9.0694444 0.387037 9.0722222 0.386111 9.0750000 0.386111
+ 9.0777778 0.387963 9.0805556 0.391667 9.0833333 0.393519 9.0861111 0.393519
+ 9.0888889 0.391667 9.0916667 0.388889 9.0944444 0.388889 9.0972222 0.387037
+ 9.1000000 0.390741 9.1027778 0.391667 9.1055556 0.393519 9.1083333 0.390741
+ 9.1111111 0.392593 9.1138889 0.392593 9.1166667 0.394444 9.1194444 0.396296
+ 9.1222222 0.395370 9.1250000 0.394444 9.1277778 0.396296 9.1305556 0.399074
+ 9.1333333 0.401852 9.1361111 0.400000 9.1388889 0.398148 9.1416667 0.396296
+ 9.1444444 0.400000 9.1472222 0.400926 9.1500000 0.398148 9.1527778 0.399074
+ 9.1555556 0.400926 9.1583333 0.402778 9.1611111 0.404630 9.1638889 0.403704
+ 9.1666667 0.405556 9.1694444 0.409259 9.1722222 0.409259 9.1750000 0.407407
+ 9.1777778 0.406481 9.1805556 0.408333 9.1833333 0.410185 9.1861111 0.410185
+ 9.1888889 0.410185 9.1916667 0.409259 9.1944444 0.411111 9.1972222 0.409259
+ 9.2000000 0.412963 9.2027778 0.412963 9.2055556 0.412963 9.2083333 0.411111
+ 9.2111111 0.409259 9.2138889 0.408333 9.2166667 0.415741 9.2194444 0.419444
+ 9.2222222 0.417593 9.2250000 0.413889 9.2277778 0.414815 9.2305556 0.417593
+ 9.2333333 0.420370 9.2361111 0.420370 9.2388889 0.417593 9.2416667 0.414815
+ 9.2444444 0.412963 9.2472222 0.414815 9.2500000 0.413889 9.2527778 0.409259
+ 9.2555556 0.407407 9.2583333 0.404630 9.2611111 0.404630 9.2638889 0.405556
+ 9.2666667 0.406481 9.2694444 0.403704 9.2722222 0.400926 9.2750000 0.399074
+ 9.2777778 0.397222 9.2805556 0.399074 9.2833333 0.398148 9.2861111 0.395370
+ 9.2888889 0.393519 9.2916667 0.390741 9.2944444 0.391667 9.2972222 0.392593
+ 9.3000000 0.391667 9.3027778 0.391667 9.3055556 0.387963 9.3083333 0.380556
+ 9.3111111 0.384259 9.3138889 0.387037 9.3166667 0.389815 9.3194444 0.386111
+ 9.3222222 0.388889 9.3250000 0.383333 9.3277778 0.386111 9.3305556 0.385185
+ 9.3333333 0.387037 9.3361111 0.385185 9.3388889 0.383333 9.3416667 0.382407
+ 9.3444444 0.378704 9.3472222 0.381481 9.3500000 0.386111 9.3527778 0.386111
+ 9.3555556 0.385185 9.3583333 0.381481 9.3611111 0.382407 9.3638889 0.381481
+ 9.3666667 0.384259 9.3694444 0.383333 9.3722222 0.383333 9.3750000 0.380556
+ 9.3777778 0.382407 9.3805556 0.381481 9.3833333 0.384259 9.3861111 0.382407
+ 9.3888889 0.382407 9.3916667 0.380556 9.3944444 0.378704 9.3972222 0.380556
+ 9.4000000 0.383333 9.4027778 0.381481 9.4055556 0.384259 9.4083333 0.379630
+ 9.4111111 0.380556 9.4138889 0.383333 9.4166667 0.385185 9.4194444 0.383333
+ 9.4222222 0.379630 9.4250000 0.376852 9.4277778 0.375926 9.4305556 0.378704
+ 9.4333333 0.380556 9.4361111 0.378704 9.4388889 0.375000 9.4416667 0.373148
+ 9.4444444 0.372222 9.4472222 0.373148 9.4500000 0.374074 9.4527778 0.374074
+ 9.4555556 0.373148 9.4583333 0.369444 9.4611111 0.372222 9.4638889 0.373148
+ 9.4666667 0.376852 9.4694444 0.375000 9.4722222 0.373148 9.4750000 0.372222
+ 9.4777778 0.370370 9.4805556 0.372222 9.4833333 0.372222 9.4861111 0.373148
+ 9.4888889 0.374074 9.4916667 0.372222 9.4944444 0.370370 9.4972222 0.371296
+ 9.5000000 0.371296 9.5027778 0.368519 9.5055556 0.369444 9.5083333 0.368519
+ 9.5111111 0.367593 9.5138889 0.369444 9.5166667 0.371296 9.5194444 0.372222
+ 9.5222222 0.375000 9.5250000 0.372222 9.5277778 0.368519 9.5305556 0.364815
+ 9.5333333 0.370370 9.5361111 0.369444 9.5388889 0.370370 9.5416667 0.367593
+ 9.5444444 0.370370 9.5472222 0.369444 9.5500000 0.370370 9.5527778 0.368519
+ 9.5555556 0.369444 9.5583333 0.369444 9.5611111 0.374074 9.5638889 0.375000
+ 9.5666667 0.373148 9.5694444 0.372222 9.5722222 0.374074 9.5750000 0.375000
+ 9.5777778 0.377778 9.5805556 0.379630 9.5833333 0.378704 9.5861111 0.376852
+ 9.5888889 0.373148 9.5916667 0.372222 9.5944444 0.372222 9.5972222 0.373148
+ 9.6000000 0.375926 9.6027778 0.375000 9.6055556 0.372222 9.6083333 0.370370
+ 9.6111111 0.375926 9.6138889 0.376852 9.6166667 0.377778 9.6194444 0.378704
+ 9.6222222 0.377778 9.6250000 0.375000 9.6277778 0.375926 9.6305556 0.376852
+ 9.6333333 0.375926 9.6361111 0.374074 9.6388889 0.371296 9.6416667 0.374074
+ 9.6444444 0.372222 9.6472222 0.375000 9.6500000 0.374074 9.6527778 0.375000
+ 9.6555556 0.373148 9.6583333 0.375000 9.6611111 0.379630 9.6638889 0.380556
+ 9.6666667 0.381481 9.6694444 0.379630 9.6722222 0.376852 9.6750000 0.375000
+ 9.6777778 0.375926 9.6805556 0.378704 9.6833333 0.380556 9.6861111 0.378704
+ 9.6888889 0.375000 9.6916667 0.375926 9.6944444 0.376852 9.6972222 0.378704
+ 9.7000000 0.380556 9.7027778 0.381481 9.7055556 0.379630 9.7083333 0.377778
+ 9.7111111 0.381481 9.7138889 0.388889 9.7166667 0.394444 9.7194444 0.395370
+ 9.7222222 0.390741 9.7250000 0.390741 9.7277778 0.395370 9.7305556 0.400000
+ 9.7333333 0.403704 9.7361111 0.407407 9.7388889 0.409259 9.7416667 0.410185
+ 9.7444444 0.409259 9.7472222 0.413889 9.7500000 0.420370 9.7527778 0.423148
+ 9.7555556 0.422222 9.7583333 0.418519 9.7611111 0.416667 9.7638889 0.421296
+ 9.7666667 0.424074 9.7694444 0.425000 9.7722222 0.425926 9.7750000 0.424074
+ 9.7777778 0.422222 9.7805556 0.414815 9.7833333 0.405556 9.7861111 0.398148
+ 9.7888889 0.390741 9.7916667 0.382407 9.7944444 0.372222 9.7972222 0.369444
+ 9.8000000 0.370370 9.8027778 0.372222 9.8055556 0.372222 9.8083333 0.372222
+ 9.8111111 0.373148 9.8138889 0.375000 9.8166667 0.374074 9.8194444 0.374074
+ 9.8222222 0.370370 9.8250000 0.371296 9.8277778 0.371296 9.8305556 0.370370
+ 9.8333333 0.368519 9.8361111 0.366667 9.8388889 0.368519 9.8416667 0.370370
+ 9.8444444 0.371296 9.8472222 0.374074 9.8500000 0.373148 9.8527778 0.372222
+ 9.8555556 0.371296 9.8583333 0.371296 9.8611111 0.372222 9.8638889 0.374074
+ 9.8666667 0.375000 9.8694444 0.373148 9.8722222 0.372222 9.8750000 0.370370
+ 9.8777778 0.371296 9.8805556 0.372222 9.8833333 0.372222 9.8861111 0.374074
+ 9.8888889 0.373148 9.8916667 0.369444 9.8944444 0.373148 9.8972222 0.375926
+ 9.9000000 0.376852 9.9027778 0.375926 9.9055556 0.371296 9.9083333 0.367593
+ 9.9111111 0.368519 9.9138889 0.376852 9.9166667 0.381481 9.9194444 0.380556
+ 9.9222222 0.378704 9.9250000 0.376852 9.9277778 0.370370 9.9305556 0.354630
+ 9.9333333 0.342593 9.9361111 0.333333 9.9388889 0.333333 9.9416667 0.330556
+ 9.9444444 0.330556 9.9472222 0.328704 9.9500000 0.322222 9.9527778 0.313889
+ 9.9555556 0.306481 9.9583333 0.302778 9.9611111 0.296296 9.9638889 0.295370
+ 9.9666667 0.288889 9.9694444 0.282407 9.9722222 0.275926 9.9750000 0.270370
+ 9.9777778 0.266667 9.9805556 0.265741 9.9833333 0.265741 9.9861111 0.274074
+ 9.9888889 0.282407 9.9916667 0.285185 9.9944444 0.290741 9.9972222 0.303704
+ )

Xdet ecg_in rpeak_out vdd vss vbias
+ env_fast_raw env_fast env_avg peak_level adapt_thr
+ slope_gate_out thr_gate_out
+ rpeak_detector_v3

.ic v(env_fast_raw)=0.3926 v(env_fast)=0.3926
+ v(env_avg)=0.3926 v(peak_level)=0.3926
+ v(adapt_thr)=0.3926
+ v(xdet.xslope.delayed)=0.3926

.tran 50u 10.0 0 50u

.meas tran det1 when v(rpeak_out)=0.45 rise=1
.meas tran det2 when v(rpeak_out)=0.45 rise=2
.meas tran det3 when v(rpeak_out)=0.45 rise=3
.meas tran det4 when v(rpeak_out)=0.45 rise=4
.meas tran det5 when v(rpeak_out)=0.45 rise=5
.meas tran det6 when v(rpeak_out)=0.45 rise=6
.meas tran det7 when v(rpeak_out)=0.45 rise=7
.meas tran det8 when v(rpeak_out)=0.45 rise=8
.meas tran det9 when v(rpeak_out)=0.45 rise=9
.meas tran det10 when v(rpeak_out)=0.45 rise=10
.meas tran det11 when v(rpeak_out)=0.45 rise=11
.meas tran det12 when v(rpeak_out)=0.45 rise=12
.meas tran det13 when v(rpeak_out)=0.45 rise=13
.meas tran det14 when v(rpeak_out)=0.45 rise=14
.meas tran det15 when v(rpeak_out)=0.45 rise=15
.meas tran det16 when v(rpeak_out)=0.45 rise=16
.meas tran det17 when v(rpeak_out)=0.45 rise=17
.meas tran det18 when v(rpeak_out)=0.45 rise=18
.meas tran det19 when v(rpeak_out)=0.45 rise=19
.meas tran det20 when v(rpeak_out)=0.45 rise=20
.meas tran det21 when v(rpeak_out)=0.45 rise=21
.meas tran det22 when v(rpeak_out)=0.45 rise=22
.meas tran det23 when v(rpeak_out)=0.45 rise=23
.meas tran det24 when v(rpeak_out)=0.45 rise=24

.save v(ecg_in) v(env_fast) v(env_avg) v(peak_level) v(adapt_thr)
+ v(slope_gate_out) v(thr_gate_out) v(rpeak_out)

.control
set filetype=ascii
run
echo "=== DIAG RECORD 108 ==="
wrdata scratchpad/diag_108.txt v(ecg_in) v(env_fast) v(env_avg) v(peak_level) v(adapt_thr) v(slope_gate_out) v(thr_gate_out) v(rpeak_out)
quit
.endc
.end
