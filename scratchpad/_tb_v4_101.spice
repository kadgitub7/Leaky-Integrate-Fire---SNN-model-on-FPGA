* V4 Detector Test — MIT-BIH Record 101
.lib C:/Users/kadhi/OneDrive/Desktop/amux/verilogLearning/Leaky-Integrate-Fire---SNN-model-on-FPGA/experiments/frontend_optimization/ngspice_frontend/sky130_minimal.lib.spice tt
.include C:/Users/kadhi/OneDrive/Desktop/amux/verilogLearning/Leaky-Integrate-Fire---SNN-model-on-FPGA/experiments/frontend_optimization/complete_frontend_v9b/rpeak_detector_v4.spice
.option scale=1.0u method=gear reltol=0.01 gmin=1e-15

Vdd vdd 0 0.9
Vss vss 0 0.0
Vbias vbias 0 0.4

Vecg ecg_in 0 pwl(
+ 0.0000000 0.324936 0.0027778 0.324936 0.0055556 0.324936 0.0083333 0.324936
+ 0.0111111 0.324936 0.0138889 0.324936 0.0166667 0.324936 0.0194444 0.324936
+ 0.0222222 0.326463 0.0250000 0.327481 0.0277778 0.327481 0.0305556 0.326972
+ 0.0333333 0.326463 0.0361111 0.326972 0.0388889 0.327990 0.0416667 0.329008
+ 0.0444444 0.329517 0.0472222 0.327990 0.0500000 0.327481 0.0527778 0.327990
+ 0.0555556 0.329517 0.0583333 0.330534 0.0611111 0.330534 0.0638889 0.330025
+ 0.0666667 0.330534 0.0694444 0.330025 0.0722222 0.331043 0.0750000 0.334097
+ 0.0777778 0.336641 0.0805556 0.339695 0.0833333 0.340204 0.0861111 0.343766
+ 0.0888889 0.343766 0.0916667 0.343257 0.0944444 0.339695 0.0972222 0.339695
+ 0.1000000 0.338677 0.1027778 0.338677 0.1055556 0.339186 0.1083333 0.338677
+ 0.1111111 0.338677 0.1138889 0.337659 0.1166667 0.334606 0.1194444 0.334606
+ 0.1222222 0.334606 0.1250000 0.333588 0.1277778 0.333079 0.1305556 0.332061
+ 0.1333333 0.329008 0.1361111 0.327481 0.1388889 0.326463 0.1416667 0.327481
+ 0.1444444 0.327481 0.1472222 0.327990 0.1500000 0.325445 0.1527778 0.324427
+ 0.1555556 0.325954 0.1583333 0.327481 0.1611111 0.328499 0.1638889 0.325954
+ 0.1666667 0.324936 0.1694444 0.324427 0.1722222 0.324427 0.1750000 0.323919
+ 0.1777778 0.324427 0.1805556 0.324427 0.1833333 0.322392 0.1861111 0.323410
+ 0.1888889 0.324936 0.1916667 0.326972 0.1944444 0.326972 0.1972222 0.325954
+ 0.2000000 0.322392 0.2027778 0.319338 0.2055556 0.319338 0.2083333 0.319847
+ 0.2111111 0.324427 0.2138889 0.338677 0.2166667 0.359033 0.2194444 0.384987
+ 0.2222222 0.413995 0.2250000 0.446565 0.2277778 0.470483 0.2305556 0.468448
+ 0.2333333 0.443003 0.2361111 0.408906 0.2388889 0.381425 0.2416667 0.359033
+ 0.2444444 0.345293 0.2472222 0.341221 0.2500000 0.335623 0.2527778 0.331043
+ 0.2555556 0.331043 0.2583333 0.331043 0.2611111 0.330534 0.2638889 0.329517
+ 0.2666667 0.325954 0.2694444 0.323410 0.2722222 0.323410 0.2750000 0.320865
+ 0.2777778 0.319847 0.2805556 0.317812 0.2833333 0.316285 0.2861111 0.315776
+ 0.2888889 0.318830 0.2916667 0.318321 0.2944444 0.318830 0.2972222 0.317812
+ 0.3000000 0.315267 0.3027778 0.316285 0.3055556 0.317812 0.3083333 0.317303
+ 0.3111111 0.317812 0.3138889 0.317303 0.3166667 0.316285 0.3194444 0.315267
+ 0.3222222 0.316794 0.3250000 0.317812 0.3277778 0.316794 0.3305556 0.316285
+ 0.3333333 0.316794 0.3361111 0.317812 0.3388889 0.317303 0.3416667 0.317812
+ 0.3444444 0.317303 0.3472222 0.317303 0.3500000 0.315776 0.3527778 0.317812
+ 0.3555556 0.317812 0.3583333 0.319338 0.3611111 0.319847 0.3638889 0.318321
+ 0.3666667 0.316794 0.3694444 0.317812 0.3722222 0.318830 0.3750000 0.319847
+ 0.3777778 0.319338 0.3805556 0.318321 0.3833333 0.317303 0.3861111 0.318321
+ 0.3888889 0.319847 0.3916667 0.321374 0.3944444 0.320356 0.3972222 0.319338
+ 0.4000000 0.317812 0.4027778 0.317303 0.4055556 0.320865 0.4083333 0.321883
+ 0.4111111 0.321374 0.4138889 0.321883 0.4166667 0.322901 0.4194444 0.324427
+ 0.4222222 0.324427 0.4250000 0.324427 0.4277778 0.325445 0.4305556 0.324427
+ 0.4333333 0.324427 0.4361111 0.326972 0.4388889 0.327481 0.4416667 0.328499
+ 0.4444444 0.328499 0.4472222 0.328499 0.4500000 0.329008 0.4527778 0.331043
+ 0.4555556 0.332570 0.4583333 0.333079 0.4611111 0.333079 0.4638889 0.334097
+ 0.4666667 0.335623 0.4694444 0.337659 0.4722222 0.338677 0.4750000 0.339186
+ 0.4777778 0.340712 0.4805556 0.342239 0.4833333 0.342239 0.4861111 0.343257
+ 0.4888889 0.344275 0.4916667 0.345293 0.4944444 0.346819 0.4972222 0.347328
+ 0.5000000 0.346310 0.5027778 0.347328 0.5055556 0.348855 0.5083333 0.350891
+ 0.5111111 0.349364 0.5138889 0.347837 0.5166667 0.347837 0.5194444 0.347837
+ 0.5222222 0.348855 0.5250000 0.348855 0.5277778 0.346819 0.5305556 0.343766
+ 0.5333333 0.343257 0.5361111 0.342748 0.5388889 0.342748 0.5416667 0.341730
+ 0.5444444 0.339186 0.5472222 0.337150 0.5500000 0.336132 0.5527778 0.335115
+ 0.5555556 0.334606 0.5583333 0.334097 0.5611111 0.333079 0.5638889 0.332061
+ 0.5666667 0.331043 0.5694444 0.330025 0.5722222 0.330534 0.5750000 0.329008
+ 0.5777778 0.327990 0.5805556 0.326463 0.5833333 0.325445 0.5861111 0.326972
+ 0.5888889 0.326972 0.5916667 0.327990 0.5944444 0.328499 0.5972222 0.325954
+ 0.6000000 0.323919 0.6027778 0.323919 0.6055556 0.322901 0.6083333 0.324936
+ 0.6111111 0.324936 0.6138889 0.326463 0.6166667 0.324427 0.6194444 0.323919
+ 0.6222222 0.325445 0.6250000 0.324936 0.6277778 0.324936 0.6305556 0.324427
+ 0.6333333 0.324427 0.6361111 0.324427 0.6388889 0.324936 0.6416667 0.326463
+ 0.6444444 0.325445 0.6472222 0.324427 0.6500000 0.323410 0.6527778 0.324427
+ 0.6555556 0.325445 0.6583333 0.326463 0.6611111 0.327481 0.6638889 0.326972
+ 0.6666667 0.327481 0.6694444 0.326972 0.6722222 0.327481 0.6750000 0.327990
+ 0.6777778 0.326972 0.6805556 0.324936 0.6833333 0.324427 0.6861111 0.326463
+ 0.6888889 0.327481 0.6916667 0.329008 0.6944444 0.329008 0.6972222 0.329517
+ 0.7000000 0.327481 0.7027778 0.326972 0.7055556 0.326972 0.7083333 0.329008
+ 0.7111111 0.330534 0.7138889 0.329008 0.7166667 0.327481 0.7194444 0.326972
+ 0.7222222 0.326972 0.7250000 0.328499 0.7277778 0.328499 0.7305556 0.328499
+ 0.7333333 0.326972 0.7361111 0.328499 0.7388889 0.328499 0.7416667 0.327990
+ 0.7444444 0.328499 0.7472222 0.327481 0.7500000 0.326463 0.7527778 0.327481
+ 0.7555556 0.327990 0.7583333 0.327990 0.7611111 0.327990 0.7638889 0.325445
+ 0.7666667 0.325445 0.7694444 0.326972 0.7722222 0.328499 0.7750000 0.329008
+ 0.7777778 0.327481 0.7805556 0.327481 0.7833333 0.326463 0.7861111 0.326463
+ 0.7888889 0.325954 0.7916667 0.327481 0.7944444 0.327481 0.7972222 0.326463
+ 0.8000000 0.325445 0.8027778 0.324936 0.8055556 0.325954 0.8083333 0.327481
+ 0.8111111 0.326463 0.8138889 0.326972 0.8166667 0.327481 0.8194444 0.326972
+ 0.8222222 0.326972 0.8250000 0.327990 0.8277778 0.327990 0.8305556 0.327481
+ 0.8333333 0.325954 0.8361111 0.325954 0.8388889 0.326972 0.8416667 0.327481
+ 0.8444444 0.326463 0.8472222 0.325445 0.8500000 0.324427 0.8527778 0.326463
+ 0.8555556 0.325954 0.8583333 0.326972 0.8611111 0.328499 0.8638889 0.325445
+ 0.8666667 0.323919 0.8694444 0.325954 0.8722222 0.327481 0.8750000 0.329008
+ 0.8777778 0.328499 0.8805556 0.327990 0.8833333 0.327481 0.8861111 0.324427
+ 0.8888889 0.327990 0.8916667 0.327481 0.8944444 0.327481 0.8972222 0.327481
+ 0.9000000 0.327481 0.9027778 0.327481 0.9055556 0.328499 0.9083333 0.328499
+ 0.9111111 0.327990 0.9138889 0.327990 0.9166667 0.328499 0.9194444 0.330025
+ 0.9222222 0.331552 0.9250000 0.331552 0.9277778 0.330534 0.9305556 0.330025
+ 0.9333333 0.330025 0.9361111 0.331043 0.9388889 0.332061 0.9416667 0.335623
+ 0.9444444 0.337659 0.9472222 0.338168 0.9500000 0.338168 0.9527778 0.342239
+ 0.9555556 0.345293 0.9583333 0.345802 0.9611111 0.344784 0.9638889 0.341221
+ 0.9666667 0.338677 0.9694444 0.338168 0.9722222 0.338168 0.9750000 0.339186
+ 0.9777778 0.338677 0.9805556 0.338168 0.9833333 0.336132 0.9861111 0.334097
+ 0.9888889 0.334606 0.9916667 0.334606 0.9944444 0.335623 0.9972222 0.334097
+ 1.0000000 0.332570 1.0027778 0.332061 1.0055556 0.329517 1.0083333 0.329517
+ 1.0111111 0.326972 1.0138889 0.327481 1.0166667 0.326972 1.0194444 0.327990
+ 1.0222222 0.329008 1.0250000 0.329008 1.0277778 0.327990 1.0305556 0.327481
+ 1.0333333 0.323919 1.0361111 0.324427 1.0388889 0.324427 1.0416667 0.325954
+ 1.0444444 0.327481 1.0472222 0.326972 1.0500000 0.325445 1.0527778 0.324427
+ 1.0555556 0.326972 1.0583333 0.329008 1.0611111 0.328499 1.0638889 0.326972
+ 1.0666667 0.323410 1.0694444 0.323919 1.0722222 0.323410 1.0750000 0.323919
+ 1.0777778 0.323410 1.0805556 0.322392 1.0833333 0.332570 1.0861111 0.351399
+ 1.0888889 0.373791 1.0916667 0.399237 1.0944444 0.430280 1.0972222 0.456234
+ 1.1000000 0.463868 1.1027778 0.450636 1.1055556 0.421628 1.1083333 0.395165
+ 1.1111111 0.371756 1.1138889 0.354453 1.1166667 0.345802 1.1194444 0.341221
+ 1.1222222 0.336132 1.1250000 0.335623 1.1277778 0.334606 1.1305556 0.332570
+ 1.1333333 0.329517 1.1361111 0.327990 1.1388889 0.325445 1.1416667 0.322392
+ 1.1444444 0.321374 1.1472222 0.318830 1.1500000 0.319847 1.1527778 0.320865
+ 1.1555556 0.321883 1.1583333 0.322901 1.1611111 0.321883 1.1638889 0.319847
+ 1.1666667 0.317812 1.1694444 0.317303 1.1722222 0.318830 1.1750000 0.320356
+ 1.1777778 0.318321 1.1805556 0.319338 1.1833333 0.318321 1.1861111 0.320356
+ 1.1888889 0.319847 1.1916667 0.320356 1.1944444 0.319847 1.1972222 0.317812
+ 1.2000000 0.316794 1.2027778 0.317303 1.2055556 0.319847 1.2083333 0.320356
+ 1.2111111 0.319338 1.2138889 0.318830 1.2166667 0.318830 1.2194444 0.319847
+ 1.2222222 0.320865 1.2250000 0.320865 1.2277778 0.320865 1.2305556 0.319338
+ 1.2333333 0.318830 1.2361111 0.318830 1.2388889 0.319338 1.2416667 0.320356
+ 1.2444444 0.320865 1.2472222 0.319338 1.2500000 0.317812 1.2527778 0.318830
+ 1.2555556 0.320356 1.2583333 0.321883 1.2611111 0.322392 1.2638889 0.320865
+ 1.2666667 0.319338 1.2694444 0.320865 1.2722222 0.322392 1.2750000 0.323410
+ 1.2777778 0.322901 1.2805556 0.322901 1.2833333 0.321883 1.2861111 0.321374
+ 1.2888889 0.323919 1.2916667 0.325445 1.2944444 0.325445 1.2972222 0.325954
+ 1.3000000 0.324936 1.3027778 0.325954 1.3055556 0.327481 1.3083333 0.327990
+ 1.3111111 0.326463 1.3138889 0.327990 1.3166667 0.326463 1.3194444 0.327990
+ 1.3222222 0.329517 1.3250000 0.332061 1.3277778 0.334097 1.3305556 0.335623
+ 1.3333333 0.334097 1.3361111 0.335115 1.3388889 0.336132 1.3416667 0.337659
+ 1.3444444 0.338677 1.3472222 0.338677 1.3500000 0.338168 1.3527778 0.339186
+ 1.3555556 0.341221 1.3583333 0.342748 1.3611111 0.344784 1.3638889 0.345802
+ 1.3666667 0.345293 1.3694444 0.345802 1.3722222 0.348346 1.3750000 0.347837
+ 1.3777778 0.347328 1.3805556 0.348346 1.3833333 0.346819 1.3861111 0.347837
+ 1.3888889 0.347837 1.3916667 0.347328 1.3944444 0.348346 1.3972222 0.346819
+ 1.4000000 0.347328 1.4027778 0.347328 1.4055556 0.346819 1.4083333 0.345802
+ 1.4111111 0.343766 1.4138889 0.342748 1.4166667 0.340712 1.4194444 0.340204
+ 1.4222222 0.340712 1.4250000 0.341730 1.4277778 0.340204 1.4305556 0.337150
+ 1.4333333 0.336132 1.4361111 0.335623 1.4388889 0.336132 1.4416667 0.336132
+ 1.4444444 0.335623 1.4472222 0.332570 1.4500000 0.332061 1.4527778 0.331552
+ 1.4555556 0.332061 1.4583333 0.332061 1.4611111 0.331552 1.4638889 0.329517
+ 1.4666667 0.328499 1.4694444 0.328499 1.4722222 0.329008 1.4750000 0.330025
+ 1.4777778 0.330025 1.4805556 0.328499 1.4833333 0.327481 1.4861111 0.329008
+ 1.4888889 0.329517 1.4916667 0.330025 1.4944444 0.327990 1.4972222 0.327990
+ 1.5000000 0.327481 1.5027778 0.329008 1.5055556 0.329008 1.5083333 0.330025
+ 1.5111111 0.328499 1.5138889 0.329008 1.5166667 0.329517 1.5194444 0.329008
+ 1.5222222 0.329517 1.5250000 0.328499 1.5277778 0.330025 1.5305556 0.330025
+ 1.5333333 0.330025 1.5361111 0.330534 1.5388889 0.331043 1.5416667 0.331552
+ 1.5444444 0.332061 1.5472222 0.332061 1.5500000 0.331043 1.5527778 0.330534
+ 1.5555556 0.332061 1.5583333 0.331552 1.5611111 0.332570 1.5638889 0.331043
+ 1.5666667 0.330025 1.5694444 0.330025 1.5722222 0.332061 1.5750000 0.332570
+ 1.5777778 0.333079 1.5805556 0.333079 1.5833333 0.332570 1.5861111 0.333079
+ 1.5888889 0.332570 1.5916667 0.333588 1.5944444 0.333588 1.5972222 0.333079
+ 1.6000000 0.331043 1.6027778 0.331043 1.6055556 0.332061 1.6083333 0.333588
+ 1.6111111 0.333079 1.6138889 0.331552 1.6166667 0.331043 1.6194444 0.331552
+ 1.6222222 0.333079 1.6250000 0.333079 1.6277778 0.333079 1.6305556 0.333079
+ 1.6333333 0.333079 1.6361111 0.332570 1.6388889 0.332570 1.6416667 0.334097
+ 1.6444444 0.333079 1.6472222 0.331552 1.6500000 0.330534 1.6527778 0.331552
+ 1.6555556 0.332570 1.6583333 0.332570 1.6611111 0.333079 1.6638889 0.333079
+ 1.6666667 0.330025 1.6694444 0.331552 1.6722222 0.331043 1.6750000 0.333079
+ 1.6777778 0.333079 1.6805556 0.331552 1.6833333 0.331043 1.6861111 0.331043
+ 1.6888889 0.332061 1.6916667 0.332061 1.6944444 0.332061 1.6972222 0.332061
+ 1.7000000 0.331043 1.7027778 0.331043 1.7055556 0.332570 1.7083333 0.333079
+ 1.7111111 0.332570 1.7138889 0.332061 1.7166667 0.331043 1.7194444 0.331552
+ 1.7222222 0.333079 1.7250000 0.333079 1.7277778 0.332061 1.7305556 0.332570
+ 1.7333333 0.332061 1.7361111 0.332061 1.7388889 0.332061 1.7416667 0.333588
+ 1.7444444 0.333079 1.7472222 0.332061 1.7500000 0.331043 1.7527778 0.331552
+ 1.7555556 0.331552 1.7583333 0.333588 1.7611111 0.332570 1.7638889 0.332061
+ 1.7666667 0.331552 1.7694444 0.331552 1.7722222 0.332570 1.7750000 0.334097
+ 1.7777778 0.337150 1.7805556 0.336132 1.7833333 0.335115 1.7861111 0.335623
+ 1.7888889 0.337659 1.7916667 0.338677 1.7944444 0.338168 1.7972222 0.337659
+ 1.8000000 0.337150 1.8027778 0.336132 1.8055556 0.336641 1.8083333 0.337659
+ 1.8111111 0.340712 1.8138889 0.341730 1.8166667 0.341221 1.8194444 0.344784
+ 1.8222222 0.348346 1.8250000 0.349364 1.8277778 0.349873 1.8305556 0.347328
+ 1.8333333 0.344784 1.8361111 0.344275 1.8388889 0.344784 1.8416667 0.343766
+ 1.8444444 0.342239 1.8472222 0.341221 1.8500000 0.339695 1.8527778 0.340712
+ 1.8555556 0.340712 1.8583333 0.341730 1.8611111 0.340204 1.8638889 0.338677
+ 1.8666667 0.337150 1.8694444 0.337659 1.8722222 0.337150 1.8750000 0.335623
+ 1.8777778 0.335623 1.8805556 0.333588 1.8833333 0.330534 1.8861111 0.331043
+ 1.8888889 0.331552 1.8916667 0.333079 1.8944444 0.332061 1.8972222 0.330025
+ 1.9000000 0.329008 1.9027778 0.330025 1.9055556 0.330534 1.9083333 0.332061
+ 1.9111111 0.331043 1.9138889 0.330025 1.9166667 0.329008 1.9194444 0.327481
+ 1.9222222 0.329008 1.9250000 0.330025 1.9277778 0.329517 1.9305556 0.329008
+ 1.9333333 0.329008 1.9361111 0.330025 1.9388889 0.331043 1.9416667 0.330534
+ 1.9444444 0.328499 1.9472222 0.325445 1.9500000 0.322392 1.9527778 0.322901
+ 1.9555556 0.330534 1.9583333 0.344784 1.9611111 0.366667 1.9638889 0.390076
+ 1.9666667 0.415013 1.9694444 0.445547 1.9722222 0.470483 1.9750000 0.478626
+ 1.9777778 0.465903 1.9805556 0.437913 1.9833333 0.408906 1.9861111 0.382443
+ 1.9888889 0.361578 1.9916667 0.351908 1.9944444 0.348346 1.9972222 0.341221
+ 2.0000000 0.336132 2.0027778 0.335115 2.0055556 0.336132 2.0083333 0.335623
+ 2.0111111 0.333588 2.0138889 0.329517 2.0166667 0.324936 2.0194444 0.324427
+ 2.0222222 0.322901 2.0250000 0.324427 2.0277778 0.322901 2.0305556 0.321883
+ 2.0333333 0.320356 2.0361111 0.321883 2.0388889 0.322392 2.0416667 0.322392
+ 2.0444444 0.321883 2.0472222 0.320865 2.0500000 0.320356 2.0527778 0.319847
+ 2.0555556 0.319338 2.0583333 0.320356 2.0611111 0.320356 2.0638889 0.319338
+ 2.0666667 0.319338 2.0694444 0.320356 2.0722222 0.320865 2.0750000 0.320865
+ 2.0777778 0.320865 2.0805556 0.319847 2.0833333 0.318321 2.0861111 0.319338
+ 2.0888889 0.320356 2.0916667 0.320865 2.0944444 0.319847 2.0972222 0.319847
+ 2.1000000 0.318830 2.1027778 0.318830 2.1055556 0.320356 2.1083333 0.321374
+ 2.1111111 0.321374 2.1138889 0.319847 2.1166667 0.319338 2.1194444 0.318321
+ 2.1222222 0.320356 2.1250000 0.320865 2.1277778 0.321883 2.1305556 0.320865
+ 2.1333333 0.319847 2.1361111 0.319847 2.1388889 0.320356 2.1416667 0.321374
+ 2.1444444 0.320865 2.1472222 0.320356 2.1500000 0.319847 2.1527778 0.320865
+ 2.1555556 0.321883 2.1583333 0.322901 2.1611111 0.322901 2.1638889 0.322392
+ 2.1666667 0.322392 2.1694444 0.322901 2.1722222 0.324427 2.1750000 0.325445
+ 2.1777778 0.324936 2.1805556 0.324936 2.1833333 0.323410 2.1861111 0.324427
+ 2.1888889 0.327481 2.1916667 0.329008 2.1944444 0.330534 2.1972222 0.329517
+ 2.2000000 0.330534 2.2027778 0.330025 2.2055556 0.331552 2.2083333 0.334097
+ 2.2111111 0.336132 2.2138889 0.335115 2.2166667 0.335115 2.2194444 0.336132
+ 2.2222222 0.337150 2.2250000 0.339186 2.2277778 0.341730 2.2305556 0.341730
+ 2.2333333 0.340712 2.2361111 0.342748 2.2388889 0.344275 2.2416667 0.345293
+ 2.2444444 0.345802 2.2472222 0.344784 2.2500000 0.345802 2.2527778 0.345293
+ 2.2555556 0.346310 2.2583333 0.348855 2.2611111 0.346819 2.2638889 0.347328
+ 2.2666667 0.346819 2.2694444 0.346310 2.2722222 0.347837 2.2750000 0.347837
+ 2.2777778 0.347837 2.2805556 0.345293 2.2833333 0.343257 2.2861111 0.342748
+ 2.2888889 0.342239 2.2916667 0.342239 2.2944444 0.340712 2.2972222 0.338168
+ 2.3000000 0.337150 2.3027778 0.336132 2.3055556 0.334606 2.3083333 0.335115
+ 2.3111111 0.333079 2.3138889 0.332570 2.3166667 0.330025 2.3194444 0.327990
+ 2.3222222 0.329008 2.3250000 0.330025 2.3277778 0.329517 2.3305556 0.327990
+ 2.3333333 0.326972 2.3361111 0.326972 2.3388889 0.326972 2.3416667 0.326972
+ 2.3444444 0.326463 2.3472222 0.325445 2.3500000 0.323919 2.3527778 0.323410
+ 2.3555556 0.324427 2.3583333 0.325954 2.3611111 0.323919 2.3638889 0.323410
+ 2.3666667 0.322901 2.3694444 0.322901 2.3722222 0.324936 2.3750000 0.324427
+ 2.3777778 0.323410 2.3805556 0.323410 2.3833333 0.323919 2.3861111 0.324427
+ 2.3888889 0.324936 2.3916667 0.325954 2.3944444 0.324936 2.3972222 0.322901
+ 2.4000000 0.321883 2.4027778 0.322901 2.4055556 0.324427 2.4083333 0.323919
+ 2.4111111 0.324936 2.4138889 0.324427 2.4166667 0.324427 2.4194444 0.323919
+ 2.4222222 0.324936 2.4250000 0.326463 2.4277778 0.326972 2.4305556 0.326463
+ 2.4333333 0.324427 2.4361111 0.324427 2.4388889 0.324427 2.4416667 0.325445
+ 2.4444444 0.325445 2.4472222 0.324427 2.4500000 0.323919 2.4527778 0.324936
+ 2.4555556 0.325954 2.4583333 0.326463 2.4611111 0.325445 2.4638889 0.325445
+ 2.4666667 0.324427 2.4694444 0.325445 2.4722222 0.326972 2.4750000 0.326972
+ 2.4777778 0.327481 2.4805556 0.325445 2.4833333 0.323919 2.4861111 0.323410
+ 2.4888889 0.323919 2.4916667 0.324936 2.4944444 0.326463 2.4972222 0.325954
+ 2.5000000 0.324936 2.5027778 0.324936 2.5055556 0.324427 2.5083333 0.326463
+ 2.5111111 0.326463 2.5138889 0.324936 2.5166667 0.324936 2.5194444 0.324427
+ 2.5222222 0.325445 2.5250000 0.324936 2.5277778 0.324936 2.5305556 0.324936
+ 2.5333333 0.324427 2.5361111 0.324936 2.5388889 0.324936 2.5416667 0.325954
+ 2.5444444 0.323919 2.5472222 0.323410 2.5500000 0.322901 2.5527778 0.322901
+ 2.5555556 0.323410 2.5583333 0.324427 2.5611111 0.323919 2.5638889 0.323919
+ 2.5666667 0.323919 2.5694444 0.324427 2.5722222 0.324936 2.5750000 0.325445
+ 2.5777778 0.323919 2.5805556 0.322392 2.5833333 0.321374 2.5861111 0.321374
+ 2.5888889 0.321883 2.5916667 0.322901 2.5944444 0.323410 2.5972222 0.323919
+ 2.6000000 0.323919 2.6027778 0.322901 2.6055556 0.322901 2.6083333 0.324936
+ 2.6111111 0.325445 2.6138889 0.323410 2.6166667 0.320865 2.6194444 0.321374
+ 2.6222222 0.323410 2.6250000 0.324936 2.6277778 0.324936 2.6305556 0.322901
+ 2.6333333 0.321883 2.6361111 0.320865 2.6388889 0.323919 2.6416667 0.324427
+ 2.6444444 0.324427 2.6472222 0.323410 2.6500000 0.322392 2.6527778 0.322392
+ 2.6555556 0.323919 2.6583333 0.324427 2.6611111 0.324427 2.6638889 0.322901
+ 2.6666667 0.322901 2.6694444 0.323410 2.6722222 0.325954 2.6750000 0.326972
+ 2.6777778 0.326463 2.6805556 0.326972 2.6833333 0.326463 2.6861111 0.327990
+ 2.6888889 0.329008 2.6916667 0.328499 2.6944444 0.327481 2.6972222 0.326972
+ 2.7000000 0.327481 2.7027778 0.328499 2.7055556 0.331552 2.7083333 0.333079
+ 2.7111111 0.335115 2.7138889 0.335623 2.7166667 0.336641 2.7194444 0.336641
+ 2.7222222 0.337150 2.7250000 0.337659 2.7277778 0.336132 2.7305556 0.334606
+ 2.7333333 0.333079 2.7361111 0.332061 2.7388889 0.334097 2.7416667 0.333588
+ 2.7444444 0.334097 2.7472222 0.332570 2.7500000 0.329517 2.7527778 0.327990
+ 2.7555556 0.327990 2.7583333 0.327481 2.7611111 0.326972 2.7638889 0.325954
+ 2.7666667 0.323919 2.7694444 0.322901 2.7722222 0.322901 2.7750000 0.321374
+ 2.7777778 0.320356 2.7805556 0.319338 2.7833333 0.319847 2.7861111 0.321374
+ 2.7888889 0.321883 2.7916667 0.320865 2.7944444 0.317812 2.7972222 0.317303
+ 2.8000000 0.317303 2.8027778 0.316794 2.8055556 0.317812 2.8083333 0.318830
+ 2.8111111 0.318321 2.8138889 0.316794 2.8166667 0.316285 2.8194444 0.318321
+ 2.8222222 0.319847 2.8250000 0.319338 2.8277778 0.317303 2.8305556 0.316794
+ 2.8333333 0.315776 2.8361111 0.314249 2.8388889 0.313740 2.8416667 0.312723
+ 2.8444444 0.314249 2.8472222 0.318321 2.8500000 0.333079 2.8527778 0.357506
+ 2.8555556 0.380916 2.8583333 0.406870 2.8611111 0.432824 2.8638889 0.459288
+ 2.8666667 0.471501 2.8694444 0.462850 2.8722222 0.436896 2.8750000 0.406870
+ 2.8777778 0.379389 2.8805556 0.354962 2.8833333 0.341221 2.8861111 0.337150
+ 2.8888889 0.334606 2.8916667 0.331552 2.8944444 0.326972 2.8972222 0.324427
+ 2.9000000 0.323919 2.9027778 0.324427 2.9055556 0.322901 2.9083333 0.320865
+ 2.9111111 0.316794 2.9138889 0.314758 2.9166667 0.314758 2.9194444 0.313740
+ 2.9222222 0.314249 2.9250000 0.313740 2.9277778 0.311196 2.9305556 0.309669
+ 2.9333333 0.310687 2.9361111 0.311705 2.9388889 0.312214 2.9416667 0.312214
+ 2.9444444 0.311196 2.9472222 0.308651 2.9500000 0.309160 2.9527778 0.310178
+ 2.9555556 0.311196 2.9583333 0.309669 2.9611111 0.309160 2.9638889 0.310178
+ 2.9666667 0.310178 2.9694444 0.311705 2.9722222 0.312723 2.9750000 0.311705
+ 2.9777778 0.311705 2.9805556 0.310687 2.9833333 0.310178 2.9861111 0.311196
+ 2.9888889 0.311705 2.9916667 0.312723 2.9944444 0.311705 2.9972222 0.310178
+ 3.0000000 0.311705 3.0027778 0.312723 3.0055556 0.311705 3.0083333 0.310687
+ 3.0111111 0.310687 3.0138889 0.310687 3.0166667 0.311705 3.0194444 0.312214
+ 3.0222222 0.312723 3.0250000 0.311705 3.0277778 0.311705 3.0305556 0.311196
+ 3.0333333 0.312214 3.0361111 0.311705 3.0388889 0.313232 3.0416667 0.313232
+ 3.0444444 0.312723 3.0472222 0.310687 3.0500000 0.311705 3.0527778 0.312214
+ 3.0555556 0.313740 3.0583333 0.312723 3.0611111 0.313740 3.0638889 0.313232
+ 3.0666667 0.313232 3.0694444 0.313740 3.0722222 0.315776 3.0750000 0.315776
+ 3.0777778 0.316285 3.0805556 0.315776 3.0833333 0.315776 3.0861111 0.317812
+ 3.0888889 0.318321 3.0916667 0.319338 3.0944444 0.319847 3.0972222 0.318321
+ 3.1000000 0.319338 3.1027778 0.321374 3.1055556 0.323919 3.1083333 0.323919
+ 3.1111111 0.321883 3.1138889 0.323919 3.1166667 0.324936 3.1194444 0.327481
+ 3.1222222 0.329008 3.1250000 0.330534 3.1277778 0.330534 3.1305556 0.331552
+ 3.1333333 0.332061 3.1361111 0.334097 3.1388889 0.336132 3.1416667 0.336132
+ 3.1444444 0.336132 3.1472222 0.335115 3.1500000 0.335623 3.1527778 0.338677
+ 3.1555556 0.340204 3.1583333 0.341730 3.1611111 0.340712 3.1638889 0.340204
+ 3.1666667 0.340712 3.1694444 0.341221 3.1722222 0.342239 3.1750000 0.342748
+ 3.1777778 0.341730 3.1805556 0.341221 3.1833333 0.342239 3.1861111 0.340712
+ 3.1888889 0.340712 3.1916667 0.340204 3.1944444 0.338677 3.1972222 0.336132
+ 3.2000000 0.333588 3.2027778 0.334097 3.2055556 0.334097 3.2083333 0.332570
+ 3.2111111 0.330025 3.2138889 0.327481 3.2166667 0.325954 3.2194444 0.324936
+ 3.2222222 0.326972 3.2250000 0.326463 3.2277778 0.323919 3.2305556 0.322392
+ 3.2333333 0.322392 3.2361111 0.321883 3.2388889 0.322901 3.2416667 0.321883
+ 3.2444444 0.321374 3.2472222 0.320356 3.2500000 0.318321 3.2527778 0.318830
+ 3.2555556 0.318830 3.2583333 0.319847 3.2611111 0.318321 3.2638889 0.317303
+ 3.2666667 0.317303 3.2694444 0.318321 3.2722222 0.320356 3.2750000 0.319847
+ 3.2777778 0.318830 3.2805556 0.317812 3.2833333 0.317303 3.2861111 0.317812
+ 3.2888889 0.318321 3.2916667 0.317812 3.2944444 0.317303 3.2972222 0.316794
+ 3.3000000 0.316794 3.3027778 0.316794 3.3055556 0.319338 3.3083333 0.318830
+ 3.3111111 0.317812 3.3138889 0.316794 3.3166667 0.317303 3.3194444 0.317303
+ 3.3222222 0.317303 3.3250000 0.316285 3.3277778 0.316285 3.3305556 0.316285
+ 3.3333333 0.316285 3.3361111 0.318830 3.3388889 0.318830 3.3416667 0.318830
+ 3.3444444 0.317812 3.3472222 0.316285 3.3500000 0.317303 3.3527778 0.317812
+ 3.3555556 0.318321 3.3583333 0.319338 3.3611111 0.317812 3.3638889 0.317812
+ 3.3666667 0.317812 3.3694444 0.318321 3.3722222 0.320356 3.3750000 0.320356
+ 3.3777778 0.319338 3.3805556 0.318321 3.3833333 0.317812 3.3861111 0.319847
+ 3.3888889 0.320865 3.3916667 0.320356 3.3944444 0.318830 3.3972222 0.319847
+ 3.4000000 0.319338 3.4027778 0.320865 3.4055556 0.321374 3.4083333 0.320356
+ 3.4111111 0.319338 3.4138889 0.317812 3.4166667 0.318321 3.4194444 0.319338
+ 3.4222222 0.319338 3.4250000 0.318321 3.4277778 0.317303 3.4305556 0.318830
+ 3.4333333 0.318321 3.4361111 0.319338 3.4388889 0.319338 3.4416667 0.319847
+ 3.4444444 0.319338 3.4472222 0.317812 3.4500000 0.317303 3.4527778 0.317812
+ 3.4555556 0.318321 3.4583333 0.317303 3.4611111 0.317303 3.4638889 0.317303
+ 3.4666667 0.316285 3.4694444 0.317812 3.4722222 0.319847 3.4750000 0.319338
+ 3.4777778 0.318830 3.4805556 0.317303 3.4833333 0.315776 3.4861111 0.316794
+ 3.4888889 0.317303 3.4916667 0.317812 3.4944444 0.318830 3.4972222 0.318321
+ 3.5000000 0.316285 3.5027778 0.316285 3.5055556 0.319847 3.5083333 0.318321
+ 3.5111111 0.317303 3.5138889 0.316794 3.5166667 0.317812 3.5194444 0.318830
+ 3.5222222 0.318321 3.5250000 0.318830 3.5277778 0.317812 3.5305556 0.317812
+ 3.5333333 0.317812 3.5361111 0.318830 3.5388889 0.320865 3.5416667 0.318321
+ 3.5444444 0.317303 3.5472222 0.316285 3.5500000 0.317303 3.5527778 0.318321
+ 3.5555556 0.319338 3.5583333 0.318830 3.5611111 0.317303 3.5638889 0.317303
+ 3.5666667 0.316285 3.5694444 0.317812 3.5722222 0.319338 3.5750000 0.318321
+ 3.5777778 0.318830 3.5805556 0.318830 3.5833333 0.317812 3.5861111 0.319338
+ 3.5888889 0.318321 3.5916667 0.318321 3.5944444 0.317303 3.5972222 0.318321
+ 3.6000000 0.318830 3.6027778 0.320356 3.6055556 0.321883 3.6083333 0.321883
+ 3.6111111 0.321883 3.6138889 0.321883 3.6166667 0.321883 3.6194444 0.322901
+ 3.6222222 0.324936 3.6250000 0.324936 3.6277778 0.324427 3.6305556 0.321883
+ 3.6333333 0.322392 3.6361111 0.325954 3.6388889 0.330534 3.6416667 0.332570
+ 3.6444444 0.334606 3.6472222 0.336132 3.6500000 0.337150 3.6527778 0.337150
+ 3.6555556 0.337150 3.6583333 0.335115 3.6611111 0.335115 3.6638889 0.333588
+ 3.6666667 0.332570 3.6694444 0.332061 3.6722222 0.332570 3.6750000 0.332061
+ 3.6777778 0.330534 3.6805556 0.328499 3.6833333 0.327990 3.6861111 0.327481
+ 3.6888889 0.327481 3.6916667 0.326463 3.6944444 0.323919 3.6972222 0.321374
+ 3.7000000 0.320356 3.7027778 0.319847 3.7055556 0.320865 3.7083333 0.319338
+ 3.7111111 0.319338 3.7138889 0.317303 3.7166667 0.315776 3.7194444 0.316794
+ 3.7222222 0.318321 3.7250000 0.317303 3.7277778 0.317303 3.7305556 0.316285
+ 3.7333333 0.315776 3.7361111 0.316285 3.7388889 0.317812 3.7416667 0.316794
+ 3.7444444 0.315776 3.7472222 0.315267 3.7500000 0.316794 3.7527778 0.316285
+ 3.7555556 0.317303 3.7583333 0.318321 3.7611111 0.317303 3.7638889 0.316285
+ 3.7666667 0.313740 3.7694444 0.313232 3.7722222 0.312214 3.7750000 0.310178
+ 3.7777778 0.311705 3.7805556 0.317812 3.7833333 0.332570 3.7861111 0.355471
+ 3.7888889 0.378372 3.7916667 0.403817 3.7944444 0.433333 3.7972222 0.459796
+ 3.8000000 0.472010 3.8027778 0.465903 3.8055556 0.440458 3.8083333 0.408906
+ 3.8111111 0.377863 3.8138889 0.352417 3.8166667 0.336641 3.8194444 0.331552
+ 3.8222222 0.329008 3.8250000 0.323919 3.8277778 0.321374 3.8305556 0.319847
+ 3.8333333 0.319847 3.8361111 0.319847 3.8388889 0.319338 3.8416667 0.316285
+ 3.8444444 0.313740 3.8472222 0.312214 3.8500000 0.310687 3.8527778 0.310687
+ 3.8555556 0.310687 3.8583333 0.308651 3.8611111 0.308142 3.8638889 0.308651
+ 3.8666667 0.307634 3.8694444 0.309160 3.8722222 0.310178 3.8750000 0.310178
+ 3.8777778 0.309669 3.8805556 0.308142 3.8833333 0.306616 3.8861111 0.308142
+ 3.8888889 0.310178 3.8916667 0.310178 3.8944444 0.310687 3.8972222 0.310178
+ 3.9000000 0.308651 3.9027778 0.309160 3.9055556 0.310687 3.9083333 0.310178
+ 3.9111111 0.310178 3.9138889 0.309669 3.9166667 0.310687 3.9194444 0.310687
+ 3.9222222 0.310687 3.9250000 0.310687 3.9277778 0.310178 3.9305556 0.310178
+ 3.9333333 0.310687 3.9361111 0.312214 3.9388889 0.312214 3.9416667 0.311196
+ 3.9444444 0.311705 3.9472222 0.310178 3.9500000 0.310178 3.9527778 0.312214
+ 3.9555556 0.313740 3.9583333 0.314249 3.9611111 0.313740 3.9638889 0.313232
+ 3.9666667 0.312214 3.9694444 0.313232 3.9722222 0.313740 3.9750000 0.314758
+ 3.9777778 0.312723 3.9805556 0.312214 3.9833333 0.313232 3.9861111 0.314249
+ 3.9888889 0.316285 3.9916667 0.315776 3.9944444 0.316794 3.9972222 0.316285
+ 4.0000000 0.315776 4.0027778 0.316285 4.0055556 0.317303 4.0083333 0.317303
+ 4.0111111 0.317303 4.0138889 0.316794 4.0166667 0.318321 4.0194444 0.320356
+ 4.0222222 0.321883 4.0250000 0.321374 4.0277778 0.322392 4.0305556 0.322392
+ 4.0333333 0.321374 4.0361111 0.322392 4.0388889 0.323919 4.0416667 0.324936
+ 4.0444444 0.323919 4.0472222 0.324936 4.0500000 0.325445 4.0527778 0.327990
+ 4.0555556 0.329517 4.0583333 0.330025 4.0611111 0.331552 4.0638889 0.331552
+ 4.0666667 0.332570 4.0694444 0.334606 4.0722222 0.335115 4.0750000 0.335115
+ 4.0777778 0.336132 4.0805556 0.336641 4.0833333 0.336132 4.0861111 0.337150
+ 4.0888889 0.339186 4.0916667 0.340204 4.0944444 0.340204 4.0972222 0.340204
+ 4.1000000 0.339695 4.1027778 0.341730 4.1055556 0.342748 4.1083333 0.342748
+ 4.1111111 0.342748 4.1138889 0.341221 4.1166667 0.341221 4.1194444 0.342239
+ 4.1222222 0.343257 4.1250000 0.343257 4.1277778 0.341730 4.1305556 0.341730
+ 4.1333333 0.341221 4.1361111 0.340204 4.1388889 0.339186 4.1416667 0.336641
+ 4.1444444 0.335623 4.1472222 0.335115 4.1500000 0.333079 4.1527778 0.332570
+ 4.1555556 0.332570 4.1583333 0.331043 4.1611111 0.329008 4.1638889 0.327990
+ 4.1666667 0.327990 4.1694444 0.327990 4.1722222 0.328499 4.1750000 0.327990
+ 4.1777778 0.327481 4.1805556 0.325954 4.1833333 0.325445 4.1861111 0.325445
+ 4.1888889 0.325954 4.1916667 0.325445 4.1944444 0.324936 4.1972222 0.323410
+ 4.2000000 0.322901 4.2027778 0.323919 4.2055556 0.324427 4.2083333 0.324936
+ 4.2111111 0.323410 4.2138889 0.321883 4.2166667 0.322392 4.2194444 0.322392
+ 4.2222222 0.322901 4.2250000 0.323410 4.2277778 0.322901 4.2305556 0.321883
+ 4.2333333 0.322901 4.2361111 0.324427 4.2388889 0.326463 4.2416667 0.324936
+ 4.2444444 0.324427 4.2472222 0.324427 4.2500000 0.324427 4.2527778 0.324936
+ 4.2555556 0.326463 4.2583333 0.325954 4.2611111 0.325445 4.2638889 0.323919
+ 4.2666667 0.322901 4.2694444 0.325445 4.2722222 0.326463 4.2750000 0.325954
+ 4.2777778 0.325445 4.2805556 0.324936 4.2833333 0.324936 4.2861111 0.325445
+ 4.2888889 0.327481 4.2916667 0.326463 4.2944444 0.325445 4.2972222 0.326463
+ 4.3000000 0.325954 4.3027778 0.325954 4.3055556 0.326463 4.3083333 0.325954
+ 4.3111111 0.325954 4.3138889 0.325954 4.3166667 0.325954 4.3194444 0.326972
+ 4.3222222 0.328499 4.3250000 0.327990 4.3277778 0.326972 4.3305556 0.327481
+ 4.3333333 0.325954 4.3361111 0.327481 4.3388889 0.328499 4.3416667 0.327990
+ 4.3444444 0.327481 4.3472222 0.327481 4.3500000 0.327481 4.3527778 0.327481
+ 4.3555556 0.328499 4.3583333 0.327481 4.3611111 0.327481 4.3638889 0.326463
+ 4.3666667 0.325445 4.3694444 0.327481 4.3722222 0.328499 4.3750000 0.328499
+ 4.3777778 0.326972 4.3805556 0.325954 4.3833333 0.325954 4.3861111 0.327990
+ 4.3888889 0.327990 4.3916667 0.326463 4.3944444 0.326463 4.3972222 0.326463
+ 4.4000000 0.326463 4.4027778 0.326463 4.4055556 0.328499 4.4083333 0.327481
+ 4.4111111 0.326463 4.4138889 0.326463 4.4166667 0.326463 4.4194444 0.326972
+ 4.4222222 0.327990 4.4250000 0.327481 4.4277778 0.326972 4.4305556 0.326463
+ 4.4333333 0.325954 4.4361111 0.326972 4.4388889 0.329008 4.4416667 0.327990
+ 4.4444444 0.327481 4.4472222 0.326463 4.4500000 0.326463 4.4527778 0.327990
+ 4.4555556 0.327990 4.4583333 0.328499 4.4611111 0.326972 4.4638889 0.326972
+ 4.4666667 0.326972 4.4694444 0.327990 4.4722222 0.328499 4.4750000 0.327990
+ 4.4777778 0.327481 4.4805556 0.326972 4.4833333 0.327481 4.4861111 0.327990
+ 4.4888889 0.327990 4.4916667 0.328499 4.4944444 0.326972 4.4972222 0.326463
+ 4.5000000 0.326972 4.5027778 0.326972 4.5055556 0.328499 4.5083333 0.329517
+ 4.5111111 0.327481 4.5138889 0.327481 4.5166667 0.326463 4.5194444 0.326972
+ 4.5222222 0.328499 4.5250000 0.327481 4.5277778 0.327990 4.5305556 0.327990
+ 4.5333333 0.327481 4.5361111 0.326972 4.5388889 0.328499 4.5416667 0.329008
+ 4.5444444 0.328499 4.5472222 0.327481 4.5500000 0.326463 4.5527778 0.327990
+ 4.5555556 0.330025 4.5583333 0.330534 4.5611111 0.330534 4.5638889 0.328499
+ 4.5666667 0.329517 4.5694444 0.331043 4.5722222 0.331552 4.5750000 0.331552
+ 4.5777778 0.332061 4.5805556 0.331043 4.5833333 0.332061 4.5861111 0.334606
+ 4.5888889 0.337659 4.5916667 0.339695 4.5944444 0.339695 4.5972222 0.341730
+ 4.6000000 0.344275 4.6027778 0.346819 4.6055556 0.347328 4.6083333 0.346819
+ 4.6111111 0.343257 4.6138889 0.341730 4.6166667 0.340712 4.6194444 0.340204
+ 4.6222222 0.340712 4.6250000 0.339695 4.6277778 0.338168 4.6305556 0.337659
+ 4.6333333 0.337150 4.6361111 0.336641 4.6388889 0.338168 4.6416667 0.336132
+ 4.6444444 0.334097 4.6472222 0.333588 4.6500000 0.331043 4.6527778 0.330025
+ 4.6555556 0.328499 4.6583333 0.328499 4.6611111 0.326972 4.6638889 0.325954
+ 4.6666667 0.323919 4.6694444 0.324427 4.6722222 0.324427 4.6750000 0.323410
+ 4.6777778 0.323410 4.6805556 0.322392 4.6833333 0.321883 4.6861111 0.323410
+ 4.6888889 0.324427 4.6916667 0.324427 4.6944444 0.322392 4.6972222 0.320865
+ 4.7000000 0.320865 4.7027778 0.321883 4.7055556 0.323410 4.7083333 0.322392
+ 4.7111111 0.322392 4.7138889 0.322392 4.7166667 0.321883 4.7194444 0.320356
+ 4.7222222 0.320865 4.7250000 0.318830 4.7277778 0.316285 4.7305556 0.316285
+ 4.7333333 0.317812 4.7361111 0.329517 4.7388889 0.346310 4.7416667 0.367684
+ 4.7444444 0.388041 4.7472222 0.412468 4.7500000 0.439949 4.7527778 0.459288
+ 4.7555556 0.461832 4.7583333 0.443511 4.7611111 0.413995 4.7638889 0.387023
+ 4.7666667 0.360051 4.7694444 0.339695 4.7722222 0.332570 4.7750000 0.329517
+ 4.7777778 0.325954 4.7805556 0.322392 4.7833333 0.322392 4.7861111 0.323410
+ 4.7888889 0.322901 4.7916667 0.320356 4.7944444 0.317812 4.7972222 0.313740
+ 4.8000000 0.311196 4.8027778 0.312214 4.8055556 0.312723 4.8083333 0.311196
+ 4.8111111 0.311705 4.8138889 0.309160 4.8166667 0.309669 4.8194444 0.310687
+ 4.8222222 0.310178 4.8250000 0.310178 4.8277778 0.309160 4.8305556 0.307634
+ 4.8333333 0.307634 4.8361111 0.309160 4.8388889 0.310687 4.8416667 0.310687
+ 4.8444444 0.310178 4.8472222 0.308142 4.8500000 0.307125 4.8527778 0.307125
+ 4.8555556 0.308142 4.8583333 0.309669 4.8611111 0.310178 4.8638889 0.309160
+ 4.8666667 0.309160 4.8694444 0.307634 4.8722222 0.307634 4.8750000 0.307125
+ 4.8777778 0.307125 4.8805556 0.307125 4.8833333 0.306616 4.8861111 0.308651
+ 4.8888889 0.309160 4.8916667 0.310178 4.8944444 0.307634 4.8972222 0.307634
+ 4.9000000 0.305598 4.9027778 0.308142 4.9055556 0.307634 4.9083333 0.307634
+ 4.9111111 0.305089 4.9138889 0.304580 4.9166667 0.307125 4.9194444 0.308142
+ 4.9222222 0.310687 4.9250000 0.310687 4.9277778 0.309669 4.9305556 0.308142
+ 4.9333333 0.306616 4.9361111 0.308142 4.9388889 0.309160 4.9416667 0.309669
+ 4.9444444 0.308142 4.9472222 0.308651 4.9500000 0.309160 4.9527778 0.311705
+ 4.9555556 0.310178 4.9583333 0.311196 4.9611111 0.310687 4.9638889 0.309669
+ 4.9666667 0.309669 4.9694444 0.309669 4.9722222 0.309669 4.9750000 0.310178
+ 4.9777778 0.309669 4.9805556 0.310687 4.9833333 0.312214 4.9861111 0.314249
+ 4.9888889 0.315267 4.9916667 0.315267 4.9944444 0.314249 4.9972222 0.312723
+ 5.0000000 0.313740 5.0027778 0.314758 5.0055556 0.317812 5.0083333 0.317303
+ 5.0111111 0.318321 5.0138889 0.317812 5.0166667 0.318321 5.0194444 0.319847
+ 5.0222222 0.322392 5.0250000 0.322901 5.0277778 0.323919 5.0305556 0.323410
+ 5.0333333 0.322392 5.0361111 0.323919 5.0388889 0.327481 5.0416667 0.329008
+ 5.0444444 0.327481 5.0472222 0.326972 5.0500000 0.326463 5.0527778 0.327990
+ 5.0555556 0.330025 5.0583333 0.329517 5.0611111 0.331552 5.0638889 0.331043
+ 5.0666667 0.331552 5.0694444 0.332061 5.0722222 0.333079 5.0750000 0.333079
+ 5.0777778 0.332570 5.0805556 0.331552 5.0833333 0.330534 5.0861111 0.330025
+ 5.0888889 0.330025 5.0916667 0.329008 5.0944444 0.327481 5.0972222 0.327481
+ 5.1000000 0.325954 5.1027778 0.326463 5.1055556 0.325954 5.1083333 0.323410
+ 5.1111111 0.323919 5.1138889 0.322901 5.1166667 0.321374 5.1194444 0.318830
+ 5.1222222 0.318830 5.1250000 0.317812 5.1277778 0.315267 5.1305556 0.315776
+ 5.1333333 0.314758 5.1361111 0.315267 5.1388889 0.317303 5.1416667 0.316794
+ 5.1444444 0.314758 5.1472222 0.314249 5.1500000 0.313232 5.1527778 0.314758
+ 5.1555556 0.314249 5.1583333 0.313740 5.1611111 0.312723 5.1638889 0.312214
+ 5.1666667 0.312723 5.1694444 0.315267 5.1722222 0.315267 5.1750000 0.313232
+ 5.1777778 0.312723 5.1805556 0.312723 5.1833333 0.313740 5.1861111 0.313740
+ 5.1888889 0.311196 5.1916667 0.310178 5.1944444 0.311196 5.1972222 0.311196
+ 5.2000000 0.308651 5.2027778 0.310687 5.2055556 0.313232 5.2083333 0.313740
+ 5.2111111 0.312723 5.2138889 0.311196 5.2166667 0.310178 5.2194444 0.312723
+ 5.2222222 0.315776 5.2250000 0.316285 5.2277778 0.313740 5.2305556 0.310687
+ 5.2333333 0.310178 5.2361111 0.313232 5.2388889 0.314758 5.2416667 0.314249
+ 5.2444444 0.312214 5.2472222 0.310687 5.2500000 0.312214 5.2527778 0.314249
+ 5.2555556 0.314758 5.2583333 0.315267 5.2611111 0.316794 5.2638889 0.313232
+ 5.2666667 0.313232 5.2694444 0.313740 5.2722222 0.313740 5.2750000 0.313740
+ 5.2777778 0.314249 5.2805556 0.313232 5.2833333 0.313740 5.2861111 0.315267
+ 5.2888889 0.316285 5.2916667 0.316285 5.2944444 0.314758 5.2972222 0.314249
+ 5.3000000 0.314249 5.3027778 0.314758 5.3055556 0.314758 5.3083333 0.313232
+ 5.3111111 0.312214 5.3138889 0.313232 5.3166667 0.312723 5.3194444 0.314249
+ 5.3222222 0.314758 5.3250000 0.316285 5.3277778 0.314758 5.3305556 0.313232
+ 5.3333333 0.313232 5.3361111 0.315776 5.3388889 0.315267 5.3416667 0.316285
+ 5.3444444 0.316794 5.3472222 0.314758 5.3500000 0.313740 5.3527778 0.312723
+ 5.3555556 0.312723 5.3583333 0.312214 5.3611111 0.313232 5.3638889 0.313740
+ 5.3666667 0.314758 5.3694444 0.314758 5.3722222 0.313740 5.3750000 0.314249
+ 5.3777778 0.314758 5.3805556 0.314249 5.3833333 0.312214 5.3861111 0.311196
+ 5.3888889 0.313740 5.3916667 0.315776 5.3944444 0.315267 5.3972222 0.314249
+ 5.4000000 0.312214 5.4027778 0.312723 5.4055556 0.314758 5.4083333 0.314758
+ 5.4111111 0.312723 5.4138889 0.312214 5.4166667 0.312723 5.4194444 0.312723
+ 5.4222222 0.312723 5.4250000 0.311705 5.4277778 0.311196 5.4305556 0.311196
+ 5.4333333 0.311705 5.4361111 0.311705 5.4388889 0.313740 5.4416667 0.313232
+ 5.4444444 0.312214 5.4472222 0.311196 5.4500000 0.311196 5.4527778 0.313232
+ 5.4555556 0.313232 5.4583333 0.313232 5.4611111 0.313232 5.4638889 0.313232
+ 5.4666667 0.312214 5.4694444 0.314249 5.4722222 0.315267 5.4750000 0.317303
+ 5.4777778 0.317812 5.4805556 0.316794 5.4833333 0.316794 5.4861111 0.317303
+ 5.4888889 0.318830 5.4916667 0.320356 5.4944444 0.319338 5.4972222 0.317812
+ 5.5000000 0.319338 5.5027778 0.322901 5.5055556 0.327481 5.5083333 0.330534
+ 5.5111111 0.329008 5.5138889 0.324936 5.5166667 0.320865 5.5194444 0.324936
+ 5.5222222 0.325445 5.5250000 0.326972 5.5277778 0.324427 5.5305556 0.321374
+ 5.5333333 0.319338 5.5361111 0.320356 5.5388889 0.321374 5.5416667 0.319338
+ 5.5444444 0.318830 5.5472222 0.316285 5.5500000 0.314249 5.5527778 0.313740
+ 5.5555556 0.314249 5.5583333 0.313232 5.5611111 0.312214 5.5638889 0.311705
+ 5.5666667 0.310178 5.5694444 0.311705 5.5722222 0.312214 5.5750000 0.312723
+ 5.5777778 0.312723 5.5805556 0.311705 5.5833333 0.312214 5.5861111 0.313740
+ 5.5888889 0.313232 5.5916667 0.308651 5.5944444 0.304071 5.5972222 0.304071
+ 5.6000000 0.305598 5.6027778 0.309160 5.6055556 0.312723 5.6083333 0.314249
+ 5.6111111 0.311705 5.6138889 0.308142 5.6166667 0.305598 5.6194444 0.304580
+ 5.6222222 0.307125 5.6250000 0.306616 5.6277778 0.306616 5.6305556 0.305089
+ 5.6333333 0.305598 5.6361111 0.313232 5.6388889 0.328499 5.6416667 0.351908
+ 5.6444444 0.378880 5.6472222 0.408397 5.6500000 0.439440 5.6527778 0.464377
+ 5.6555556 0.468448 5.6583333 0.446565 5.6611111 0.412468 5.6638889 0.380916
+ 5.6666667 0.350382 5.6694444 0.330534 5.6722222 0.321374 5.6750000 0.318830
+ 5.6777778 0.312723 5.6805556 0.310687 5.6833333 0.308651 5.6861111 0.308651
+ 5.6888889 0.308651 5.6916667 0.308651 5.6944444 0.305089 5.6972222 0.302545
+ 5.7000000 0.300000 5.7027778 0.301527 5.7055556 0.303562 5.7083333 0.303562
+ 5.7111111 0.303053 5.7138889 0.302545 5.7166667 0.300509 5.7194444 0.301527
+ 5.7222222 0.302545 5.7250000 0.302036 5.7277778 0.303053 5.7305556 0.302545
+ 5.7333333 0.302036 5.7361111 0.302036 5.7388889 0.303053 5.7416667 0.304071
+ 5.7444444 0.302036 5.7472222 0.303053 5.7500000 0.301018 5.7527778 0.302036
+ 5.7555556 0.301527 5.7583333 0.302545 5.7611111 0.301527 5.7638889 0.302036
+ 5.7666667 0.302036 5.7694444 0.301018 5.7722222 0.302036 5.7750000 0.303053
+ 5.7777778 0.302545 5.7805556 0.303053 5.7833333 0.302545 5.7861111 0.303562
+ 5.7888889 0.303562 5.7916667 0.302545 5.7944444 0.303562 5.7972222 0.303053
+ 5.8000000 0.301527 5.8027778 0.302545 5.8055556 0.304071 5.8083333 0.305089
+ 5.8111111 0.306107 5.8138889 0.305089 5.8166667 0.302036 5.8194444 0.302036
+ 5.8222222 0.302545 5.8250000 0.302545 5.8277778 0.303562 5.8305556 0.303562
+ 5.8333333 0.303562 5.8361111 0.306107 5.8388889 0.307125 5.8416667 0.306616
+ 5.8444444 0.306616 5.8472222 0.305598 5.8500000 0.306107 5.8527778 0.307125
+ 5.8555556 0.309160 5.8583333 0.309160 5.8611111 0.307634 5.8638889 0.306616
+ 5.8666667 0.306616 5.8694444 0.310178 5.8722222 0.311705 5.8750000 0.312723
+ 5.8777778 0.311196 5.8805556 0.312214 5.8833333 0.312214 5.8861111 0.314249
+ 5.8888889 0.314758 5.8916667 0.315267 5.8944444 0.315776 5.8972222 0.314758
+ 5.9000000 0.314758 5.9027778 0.315776 5.9055556 0.315776 5.9083333 0.317303
+ 5.9111111 0.319847 5.9138889 0.321374 5.9166667 0.323919 5.9194444 0.325445
+ 5.9222222 0.326463 5.9250000 0.324936 5.9277778 0.325445 5.9305556 0.324936
+ 5.9333333 0.324936 5.9361111 0.326463 5.9388889 0.328499 5.9416667 0.329008
+ 5.9444444 0.330025 5.9472222 0.329517 5.9500000 0.327990 5.9527778 0.329008
+ 5.9555556 0.331552 5.9583333 0.330025 5.9611111 0.329517 5.9638889 0.329008
+ 5.9666667 0.328499 5.9694444 0.327990 5.9722222 0.326972 5.9750000 0.327481
+ 5.9777778 0.327481 5.9805556 0.324427 5.9833333 0.323410 5.9861111 0.322392
+ 5.9888889 0.322392 5.9916667 0.322392 5.9944444 0.320865 5.9972222 0.318830
+ 6.0000000 0.318321 6.0027778 0.318830 6.0055556 0.318321 6.0083333 0.317812
+ 6.0111111 0.315776 6.0138889 0.314758 6.0166667 0.312214 6.0194444 0.314758
+ 6.0222222 0.314758 6.0250000 0.316794 6.0277778 0.313740 6.0305556 0.313232
+ 6.0333333 0.312723 6.0361111 0.312723 6.0388889 0.312723 6.0416667 0.312723
+ 6.0444444 0.313740 6.0472222 0.314249 6.0500000 0.313232 6.0527778 0.314249
+ 6.0555556 0.314758 6.0583333 0.313740 6.0611111 0.312723 6.0638889 0.313232
+ 6.0666667 0.312723 6.0694444 0.314758 6.0722222 0.316285 6.0750000 0.316794
+ 6.0777778 0.314758 6.0805556 0.315267 6.0833333 0.314249 6.0861111 0.313740
+ 6.0888889 0.315776 6.0916667 0.316285 6.0944444 0.316285 6.0972222 0.313740
+ 6.1000000 0.312723 6.1027778 0.315267 6.1055556 0.316794 6.1083333 0.317303
+ 6.1111111 0.315267 6.1138889 0.314249 6.1166667 0.315776 6.1194444 0.317303
+ 6.1222222 0.319338 6.1250000 0.319338 6.1277778 0.318321 6.1305556 0.316794
+ 6.1333333 0.316794 6.1361111 0.317812 6.1388889 0.317812 6.1416667 0.316794
+ 6.1444444 0.317812 6.1472222 0.317812 6.1500000 0.317812 6.1527778 0.319338
+ 6.1555556 0.319338 6.1583333 0.318321 6.1611111 0.316794 6.1638889 0.316794
+ 6.1666667 0.317303 6.1694444 0.318321 6.1722222 0.319338 6.1750000 0.318321
+ 6.1777778 0.316794 6.1805556 0.315776 6.1833333 0.315267 6.1861111 0.320356
+ 6.1888889 0.320865 6.1916667 0.322392 6.1944444 0.323410 6.1972222 0.324427
+ 6.2000000 0.323919 6.2027778 0.320356 6.2055556 0.318321 6.2083333 0.314249
+ 6.2111111 0.313232 6.2138889 0.312723 6.2166667 0.312723 6.2194444 0.315267
+ 6.2222222 0.320356 6.2250000 0.323919 6.2277778 0.329008 6.2305556 0.327990
+ 6.2333333 0.322392 6.2361111 0.316794 6.2388889 0.315776 6.2416667 0.315776
+ 6.2444444 0.317303 6.2472222 0.320356 6.2500000 0.322392 6.2527778 0.322901
+ 6.2555556 0.324427 6.2583333 0.321883 6.2611111 0.320356 6.2638889 0.316794
+ 6.2666667 0.317303 6.2694444 0.318321 6.2722222 0.318830 6.2750000 0.319847
+ 6.2777778 0.319847 6.2805556 0.320865 6.2833333 0.320356 6.2861111 0.320865
+ 6.2888889 0.321374 6.2916667 0.321883 6.2944444 0.322901 6.2972222 0.323410
+ 6.3000000 0.323919 6.3027778 0.323919 6.3055556 0.324427 6.3083333 0.322392
+ 6.3111111 0.321883 6.3138889 0.321374 6.3166667 0.320865 6.3194444 0.322392
+ 6.3222222 0.323919 6.3250000 0.322901 6.3277778 0.322392 6.3305556 0.321374
+ 6.3333333 0.321374 6.3361111 0.322901 6.3388889 0.325445 6.3416667 0.326463
+ 6.3444444 0.325954 6.3472222 0.324936 6.3500000 0.324427 6.3527778 0.323919
+ 6.3555556 0.326972 6.3583333 0.328499 6.3611111 0.327481 6.3638889 0.326463
+ 6.3666667 0.327481 6.3694444 0.330534 6.3722222 0.334097 6.3750000 0.336641
+ 6.3777778 0.340712 6.3805556 0.342239 6.3833333 0.341221 6.3861111 0.341730
+ 6.3888889 0.339695 6.3916667 0.339186 6.3944444 0.337659 6.3972222 0.336641
+ 6.4000000 0.336132 6.4027778 0.335115 6.4055556 0.334606 6.4083333 0.334606
+ 6.4111111 0.334097 6.4138889 0.334606 6.4166667 0.334606 6.4194444 0.335623
+ 6.4222222 0.334097 6.4250000 0.332570 6.4277778 0.332061 6.4305556 0.332061
+ 6.4333333 0.331043 6.4361111 0.331552 6.4388889 0.329008 6.4416667 0.324936
+ 6.4444444 0.322901 6.4472222 0.323919 6.4500000 0.322901 6.4527778 0.322392
+ 6.4555556 0.323919 6.4583333 0.321883 6.4611111 0.322901 6.4638889 0.320865
+ 6.4666667 0.321374 6.4694444 0.321883 6.4722222 0.323410 6.4750000 0.322392
+ 6.4777778 0.321883 6.4805556 0.320865 6.4833333 0.321883 6.4861111 0.322901
+ 6.4888889 0.324936 6.4916667 0.322901 6.4944444 0.320865 6.4972222 0.317303
+ 6.5000000 0.315267 6.5027778 0.314249 6.5055556 0.321374 6.5083333 0.337659
+ 6.5111111 0.361069 6.5138889 0.392621 6.5166667 0.430789 6.5194444 0.471501
+ 6.5222222 0.498982 6.5250000 0.500000 6.5277778 0.475064 6.5305556 0.436387
+ 6.5333333 0.399746 6.5361111 0.372265 6.5388889 0.358524 6.5416667 0.353435
+ 6.5444444 0.349873 6.5472222 0.342748 6.5500000 0.339695 6.5527778 0.337150
+ 6.5555556 0.336132 6.5583333 0.332570 6.5611111 0.329008 6.5638889 0.323919
+ 6.5666667 0.321883 6.5694444 0.321374 6.5722222 0.319847 6.5750000 0.321374
+ 6.5777778 0.319847 6.5805556 0.318830 6.5833333 0.316794 6.5861111 0.317812
+ 6.5888889 0.318321 6.5916667 0.318830 6.5944444 0.319338 6.5972222 0.317303
+ 6.6000000 0.316285 6.6027778 0.317812 6.6055556 0.317812 6.6083333 0.316794
+ 6.6111111 0.315776 6.6138889 0.316794 6.6166667 0.316285 6.6194444 0.317303
+ 6.6222222 0.318321 6.6250000 0.318830 6.6277778 0.317812 6.6305556 0.317812
+ 6.6333333 0.316794 6.6361111 0.318321 6.6388889 0.319338 6.6416667 0.320356
+ 6.6444444 0.318830 6.6472222 0.317812 6.6500000 0.317303 6.6527778 0.318321
+ 6.6555556 0.320356 6.6583333 0.320356 6.6611111 0.319847 6.6638889 0.317812
+ 6.6666667 0.317303 6.6694444 0.319338 6.6722222 0.319847 6.6750000 0.318321
+ 6.6777778 0.317303 6.6805556 0.317303 6.6833333 0.317812 6.6861111 0.317812
+ 6.6888889 0.320356 6.6916667 0.319847 6.6944444 0.320356 6.6972222 0.319847
+ 6.7000000 0.320356 6.7027778 0.319847 6.7055556 0.320356 6.7083333 0.320865
+ 6.7111111 0.320865 6.7138889 0.319847 6.7166667 0.320865 6.7194444 0.321883
+ 6.7222222 0.323410 6.7250000 0.321883 6.7277778 0.322392 6.7305556 0.323410
+ 6.7333333 0.323919 6.7361111 0.326463 6.7388889 0.327481 6.7416667 0.327990
+ 6.7444444 0.327481 6.7472222 0.326972 6.7500000 0.327481 6.7527778 0.331552
+ 6.7555556 0.333588 6.7583333 0.334097 6.7611111 0.333588 6.7638889 0.333079
+ 6.7666667 0.333588 6.7694444 0.336641 6.7722222 0.339186 6.7750000 0.340712
+ 6.7777778 0.340712 6.7805556 0.340712 6.7833333 0.341221 6.7861111 0.344275
+ 6.7888889 0.346310 6.7916667 0.348346 6.7944444 0.347328 6.7972222 0.347328
+ 6.8000000 0.348855 6.8027778 0.348855 6.8055556 0.349364 6.8083333 0.350891
+ 6.8111111 0.350891 6.8138889 0.351908 6.8166667 0.351908 6.8194444 0.350891
+ 6.8222222 0.353435 6.8250000 0.350891 6.8277778 0.350891 6.8305556 0.350891
+ 6.8333333 0.349873 6.8361111 0.348855 6.8388889 0.347328 6.8416667 0.346819
+ 6.8444444 0.345293 6.8472222 0.343257 6.8500000 0.340712 6.8527778 0.340204
+ 6.8555556 0.339695 6.8583333 0.338677 6.8611111 0.336641 6.8638889 0.335115
+ 6.8666667 0.333588 6.8694444 0.332570 6.8722222 0.333079 6.8750000 0.332570
+ 6.8777778 0.331552 6.8805556 0.330025 6.8833333 0.326972 6.8861111 0.327990
+ 6.8888889 0.328499 6.8916667 0.329517 6.8944444 0.330534 6.8972222 0.328499
+ 6.9000000 0.327481 6.9027778 0.327481 6.9055556 0.329008 6.9083333 0.328499
+ 6.9111111 0.326463 6.9138889 0.324936 6.9166667 0.323919 6.9194444 0.325445
+ 6.9222222 0.326463 6.9250000 0.325954 6.9277778 0.326972 6.9305556 0.326972
+ 6.9333333 0.326463 6.9361111 0.326463 6.9388889 0.327481 6.9416667 0.326972
+ 6.9444444 0.326463 6.9472222 0.325954 6.9500000 0.325954 6.9527778 0.326463
+ 6.9555556 0.327990 6.9583333 0.326972 6.9611111 0.327481 6.9638889 0.327990
+ 6.9666667 0.326972 6.9694444 0.328499 6.9722222 0.327990 6.9750000 0.328499
+ 6.9777778 0.330025 6.9805556 0.329008 6.9833333 0.327990 6.9861111 0.326972
+ 6.9888889 0.328499 6.9916667 0.328499 6.9944444 0.329008 6.9972222 0.330025
+ 7.0000000 0.328499 7.0027778 0.329008 7.0055556 0.330025 7.0083333 0.331043
+ 7.0111111 0.331043 7.0138889 0.331043 7.0166667 0.329517 7.0194444 0.328499
+ 7.0222222 0.329517 7.0250000 0.330025 7.0277778 0.331552 7.0305556 0.328499
+ 7.0333333 0.328499 7.0361111 0.330025 7.0388889 0.332061 7.0416667 0.332061
+ 7.0444444 0.330534 7.0472222 0.329517 7.0500000 0.328499 7.0527778 0.329517
+ 7.0555556 0.332061 7.0583333 0.331552 7.0611111 0.331043 7.0638889 0.329517
+ 7.0666667 0.328499 7.0694444 0.329517 7.0722222 0.331552 7.0750000 0.331043
+ 7.0777778 0.329517 7.0805556 0.329008 7.0833333 0.328499 7.0861111 0.329517
+ 7.0888889 0.330025 7.0916667 0.330534 7.0944444 0.331043 7.0972222 0.330025
+ 7.1000000 0.330025 7.1027778 0.332061 7.1055556 0.331552 7.1083333 0.331552
+ 7.1111111 0.329517 7.1138889 0.329008 7.1166667 0.329517 7.1194444 0.330534
+ 7.1222222 0.331043 7.1250000 0.331552 7.1277778 0.331043 7.1305556 0.330534
+ 7.1333333 0.329517 7.1361111 0.330534 7.1388889 0.330025 7.1416667 0.330534
+ 7.1444444 0.330534 7.1472222 0.330025 7.1500000 0.329517 7.1527778 0.329517
+ 7.1555556 0.330025 7.1583333 0.330534 7.1611111 0.330025 7.1638889 0.330534
+ 7.1666667 0.328499 7.1694444 0.329517 7.1722222 0.330534 7.1750000 0.331043
+ 7.1777778 0.331043 7.1805556 0.329008 7.1833333 0.329517 7.1861111 0.329517
+ 7.1888889 0.330025 7.1916667 0.331552 7.1944444 0.331043 7.1972222 0.329008
+ 7.2000000 0.329517 7.2027778 0.330025 7.2055556 0.332570 7.2083333 0.333588
+ 7.2111111 0.333588 7.2138889 0.332570 7.2166667 0.331043 7.2194444 0.333079
+ 7.2222222 0.334606 7.2250000 0.335115 7.2277778 0.334097 7.2305556 0.332570
+ 7.2333333 0.332570 7.2361111 0.334606 7.2388889 0.336641 7.2416667 0.340712
+ 7.2444444 0.344784 7.2472222 0.346310 7.2500000 0.346310 7.2527778 0.344275
+ 7.2555556 0.344784 7.2583333 0.344784 7.2611111 0.344784 7.2638889 0.343766
+ 7.2666667 0.341221 7.2694444 0.338677 7.2722222 0.339186 7.2750000 0.339186
+ 7.2777778 0.338168 7.2805556 0.337150 7.2833333 0.336641 7.2861111 0.337659
+ 7.2888889 0.338677 7.2916667 0.336641 7.2944444 0.334606 7.2972222 0.330534
+ 7.3000000 0.329517 7.3027778 0.330025 7.3055556 0.329008 7.3083333 0.329008
+ 7.3111111 0.326463 7.3138889 0.325954 7.3166667 0.325954 7.3194444 0.325445
+ 7.3222222 0.325954 7.3250000 0.326463 7.3277778 0.327481 7.3305556 0.327990
+ 7.3333333 0.325445 7.3361111 0.325445 7.3388889 0.327990 7.3416667 0.327990
+ 7.3444444 0.325954 7.3472222 0.324936 7.3500000 0.324427 7.3527778 0.324427
+ 7.3555556 0.325954 7.3583333 0.325954 7.3611111 0.326463 7.3638889 0.324936
+ 7.3666667 0.323919 7.3694444 0.323919 7.3722222 0.322901 7.3750000 0.325954
+ 7.3777778 0.339186 7.3805556 0.361578 7.3833333 0.392621 7.3861111 0.430789
+ 7.3888889 0.469466 7.3916667 0.494911 7.3944444 0.492875 7.3972222 0.466412
+ 7.4000000 0.430280 7.4027778 0.396692 7.4055556 0.370738 7.4083333 0.358015
+ 7.4111111 0.354453 7.4138889 0.350382 7.4166667 0.345293 7.4194444 0.341221
+ 7.4222222 0.339186 7.4250000 0.338677 7.4277778 0.336132 7.4305556 0.332570
+ 7.4333333 0.331043 7.4361111 0.330534 7.4388889 0.329517 7.4416667 0.329008
+ 7.4444444 0.327481 7.4472222 0.327990 7.4500000 0.329008 7.4527778 0.328499
+ 7.4555556 0.323410 7.4583333 0.316794 7.4611111 0.312214 7.4638889 0.309669
+ 7.4666667 0.309669 7.4694444 0.311705 7.4722222 0.313740 7.4750000 0.314249
+ 7.4777778 0.314249 7.4805556 0.313740 7.4833333 0.314249 7.4861111 0.314758
+ 7.4888889 0.316794 7.4916667 0.317303 7.4944444 0.317303 7.4972222 0.317303
+ 7.5000000 0.317303 7.5027778 0.317812 7.5055556 0.317812 7.5083333 0.318830
+ 7.5111111 0.317812 7.5138889 0.315776 7.5166667 0.315776 7.5194444 0.318321
+ 7.5222222 0.319338 7.5250000 0.318321 7.5277778 0.318321 7.5305556 0.317303
+ 7.5333333 0.317812 7.5361111 0.318321 7.5388889 0.317812 7.5416667 0.317812
+ 7.5444444 0.317303 7.5472222 0.317303 7.5500000 0.315776 7.5527778 0.315776
+ 7.5555556 0.316285 7.5583333 0.315267 7.5611111 0.315776 7.5638889 0.316285
+ 7.5666667 0.316285 7.5694444 0.317303 7.5722222 0.318830 7.5750000 0.319338
+ 7.5777778 0.317303 7.5805556 0.315776 7.5833333 0.314758 7.5861111 0.317812
+ 7.5888889 0.318830 7.5916667 0.318321 7.5944444 0.317812 7.5972222 0.317303
+ 7.6000000 0.315776 7.6027778 0.318321 7.6055556 0.319338 7.6083333 0.320356
+ 7.6111111 0.320356 7.6138889 0.318830 7.6166667 0.319847 7.6194444 0.322392
+ 7.6222222 0.322901 7.6250000 0.323410 7.6277778 0.323410 7.6305556 0.323410
+ 7.6333333 0.326463 7.6361111 0.327481 7.6388889 0.327990 7.6416667 0.326972
+ 7.6444444 0.326463 7.6472222 0.327481 7.6500000 0.327481 7.6527778 0.331552
+ 7.6555556 0.334606 7.6583333 0.336132 7.6611111 0.338677 7.6638889 0.338677
+ 7.6666667 0.337150 7.6694444 0.340712 7.6722222 0.343257 7.6750000 0.342748
+ 7.6777778 0.341730 7.6805556 0.340204 7.6833333 0.338677 7.6861111 0.339695
+ 7.6888889 0.342239 7.6916667 0.343766 7.6944444 0.342239 7.6972222 0.342239
+ 7.7000000 0.341730 7.7027778 0.342748 7.7055556 0.343257 7.7083333 0.343766
+ 7.7111111 0.342239 7.7138889 0.340712 7.7166667 0.340204 7.7194444 0.340712
+ 7.7222222 0.337659 7.7250000 0.334097 7.7277778 0.329517 7.7305556 0.325445
+ 7.7333333 0.325954 7.7361111 0.327481 7.7388889 0.327990 7.7416667 0.325954
+ 7.7444444 0.324936 7.7472222 0.324427 7.7500000 0.324427 7.7527778 0.323410
+ 7.7555556 0.322901 7.7583333 0.322901 7.7611111 0.322901 7.7638889 0.323919
+ 7.7666667 0.322392 7.7694444 0.322392 7.7722222 0.322901 7.7750000 0.322901
+ 7.7777778 0.321883 7.7805556 0.320865 7.7833333 0.320865 7.7861111 0.322392
+ 7.7888889 0.321374 7.7916667 0.320356 7.7944444 0.318830 7.7972222 0.319338
+ 7.8000000 0.318830 7.8027778 0.318830 7.8055556 0.320865 7.8083333 0.321883
+ 7.8111111 0.320865 7.8138889 0.319847 7.8166667 0.317812 7.8194444 0.319847
+ 7.8222222 0.321883 7.8250000 0.322901 7.8277778 0.322392 7.8305556 0.319847
+ 7.8333333 0.320356 7.8361111 0.319847 7.8388889 0.321374 7.8416667 0.321883
+ 7.8444444 0.322392 7.8472222 0.320356 7.8500000 0.318830 7.8527778 0.320865
+ 7.8555556 0.322392 7.8583333 0.323410 7.8611111 0.323410 7.8638889 0.322392
+ 7.8666667 0.321883 7.8694444 0.320865 7.8722222 0.322901 7.8750000 0.323410
+ 7.8777778 0.323410 7.8805556 0.323919 7.8833333 0.323919 7.8861111 0.324936
+ 7.8888889 0.324936 7.8916667 0.325445 7.8944444 0.325445 7.8972222 0.323919
+ 7.9000000 0.322392 7.9027778 0.323410 7.9055556 0.323919 7.9083333 0.324427
+ 7.9111111 0.325954 7.9138889 0.325445 7.9166667 0.325954 7.9194444 0.325954
+ 7.9222222 0.325445 7.9250000 0.325445 7.9277778 0.322901 7.9305556 0.324427
+ 7.9333333 0.325954 7.9361111 0.325954 7.9388889 0.326972 7.9416667 0.325445
+ 7.9444444 0.323919 7.9472222 0.321883 7.9500000 0.321883 7.9527778 0.324936
+ 7.9555556 0.326972 7.9583333 0.326972 7.9611111 0.325445 7.9638889 0.322901
+ 7.9666667 0.322392 7.9694444 0.321883 7.9722222 0.323919 7.9750000 0.322901
+ 7.9777778 0.322392 7.9805556 0.319847 7.9833333 0.320865 7.9861111 0.323410
+ 7.9888889 0.324936 7.9916667 0.326972 7.9944444 0.327990 7.9972222 0.328499
+ 8.0000000 0.329008 8.0027778 0.334097 8.0055556 0.338677 8.0083333 0.336641
+ 8.0111111 0.330534 8.0138889 0.323410 8.0166667 0.318830 8.0194444 0.315267
+ 8.0222222 0.313740 8.0250000 0.315267 8.0277778 0.317303 8.0305556 0.319338
+ 8.0333333 0.320865 8.0361111 0.323410 8.0388889 0.326463 8.0416667 0.330025
+ 8.0444444 0.329517 8.0472222 0.324936 8.0500000 0.319338 8.0527778 0.318321
+ 8.0555556 0.321374 8.0583333 0.322901 8.0611111 0.322392 8.0638889 0.321883
+ 8.0666667 0.321374 8.0694444 0.324427 8.0722222 0.325445 8.0750000 0.325445
+ 8.0777778 0.326463 8.0805556 0.326463 8.0833333 0.326463 8.0861111 0.327481
+ 8.0888889 0.327481 8.0916667 0.326972 8.0944444 0.325445 8.0972222 0.325445
+ 8.1000000 0.327990 8.1027778 0.330025 8.1055556 0.334606 8.1083333 0.339186
+ 8.1111111 0.342239 8.1138889 0.340204 8.1166667 0.338168 8.1194444 0.338168
+ 8.1222222 0.338168 8.1250000 0.338168 8.1277778 0.337659 8.1305556 0.336132
+ 8.1333333 0.334606 8.1361111 0.334606 8.1388889 0.334606 8.1416667 0.335115
+ 8.1444444 0.334606 8.1472222 0.333079 8.1500000 0.331043 8.1527778 0.330025
+ 8.1555556 0.329008 8.1583333 0.328499 8.1611111 0.324936 8.1638889 0.322392
+ 8.1666667 0.321883 8.1694444 0.322901 8.1722222 0.323919 8.1750000 0.324427
+ 8.1777778 0.324427 8.1805556 0.323410 8.1833333 0.321374 8.1861111 0.322392
+ 8.1888889 0.323410 8.1916667 0.323410 8.1944444 0.322901 8.1972222 0.321883
+ 8.2000000 0.320356 8.2027778 0.320356 8.2055556 0.322901 8.2083333 0.323919
+ 8.2111111 0.323410 8.2138889 0.321374 8.2166667 0.321374 8.2194444 0.321374
+ 8.2222222 0.320865 8.2250000 0.319847 8.2277778 0.318321 8.2305556 0.314758
+ 8.2333333 0.315267 8.2361111 0.322901 8.2388889 0.342239 8.2416667 0.368193
+ 8.2444444 0.395674 8.2472222 0.426718 8.2500000 0.459288 8.2527778 0.483206
+ 8.2555556 0.484224 8.2583333 0.461323 8.2611111 0.428244 8.2638889 0.394148
+ 8.2666667 0.364631 8.2694444 0.349364 8.2722222 0.347328 8.2750000 0.343257
+ 8.2777778 0.337659 8.2805556 0.335623 8.2833333 0.332570 8.2861111 0.330025
+ 8.2888889 0.326463 8.2916667 0.323410 8.2944444 0.320865 8.2972222 0.319338
+ 8.3000000 0.318830 8.3027778 0.318830 8.3055556 0.318321 8.3083333 0.316794
+ 8.3111111 0.314249 8.3138889 0.311196 8.3166667 0.310687 8.3194444 0.312723
+ 8.3222222 0.314249 8.3250000 0.314758 8.3277778 0.315776 8.3305556 0.315776
+ 8.3333333 0.314758 8.3361111 0.315267 8.3388889 0.315267 8.3416667 0.313232
+ 8.3444444 0.312723 8.3472222 0.311705 8.3500000 0.311705 8.3527778 0.312214
+ 8.3555556 0.314249 8.3583333 0.314249 8.3611111 0.314249 8.3638889 0.314249
+ 8.3666667 0.314249 8.3694444 0.315776 8.3722222 0.316285 8.3750000 0.314758
+ 8.3777778 0.313740 8.3805556 0.312723 8.3833333 0.311705 8.3861111 0.312723
+ 8.3888889 0.313740 8.3916667 0.313232 8.3944444 0.313740 8.3972222 0.311705
+ 8.4000000 0.311705 8.4027778 0.312214 8.4055556 0.314249 8.4083333 0.315776
+ 8.4111111 0.315267 8.4138889 0.315267 8.4166667 0.313740 8.4194444 0.314249
+ 8.4222222 0.315267 8.4250000 0.317812 8.4277778 0.316285 8.4305556 0.315267
+ 8.4333333 0.314758 8.4361111 0.315776 8.4388889 0.316794 8.4416667 0.317303
+ 8.4444444 0.317812 8.4472222 0.316794 8.4500000 0.316794 8.4527778 0.317303
+ 8.4555556 0.318321 8.4583333 0.318830 8.4611111 0.318830 8.4638889 0.318830
+ 8.4666667 0.318830 8.4694444 0.319847 8.4722222 0.321374 8.4750000 0.322392
+ 8.4777778 0.323410 8.4805556 0.322392 8.4833333 0.322392 8.4861111 0.323919
+ 8.4888889 0.326463 8.4916667 0.327990 8.4944444 0.327481 8.4972222 0.327481
+ 8.5000000 0.326972 8.5027778 0.328499 8.5055556 0.330025 8.5083333 0.330534
+ 8.5111111 0.331043 8.5138889 0.331043 8.5166667 0.330534 8.5194444 0.332061
+ 8.5222222 0.334097 8.5250000 0.335623 8.5277778 0.337659 8.5305556 0.338168
+ 8.5333333 0.338168 8.5361111 0.340712 8.5388889 0.342239 8.5416667 0.342239
+ 8.5444444 0.340204 8.5472222 0.339695 8.5500000 0.340204 8.5527778 0.344275
+ 8.5555556 0.346819 8.5583333 0.347837 8.5611111 0.348855 8.5638889 0.348855
+ 8.5666667 0.348855 8.5694444 0.349364 8.5722222 0.347328 8.5750000 0.345293
+ 8.5777778 0.343766 8.5805556 0.341730 8.5833333 0.341221 8.5861111 0.341221
+ 8.5888889 0.342239 8.5916667 0.343257 8.5944444 0.342748 8.5972222 0.339186
+ 8.6000000 0.335115 8.6027778 0.333588 8.6055556 0.332570 8.6083333 0.332570
+ 8.6111111 0.331552 8.6138889 0.331043 8.6166667 0.329517 8.6194444 0.330025
+ 8.6222222 0.329517 8.6250000 0.329517 8.6277778 0.327990 8.6305556 0.327481
+ 8.6333333 0.326463 8.6361111 0.329008 8.6388889 0.329517 8.6416667 0.327481
+ 8.6444444 0.327481 8.6472222 0.327990 8.6500000 0.326463 8.6527778 0.327481
+ 8.6555556 0.328499 8.6583333 0.327481 8.6611111 0.326463 8.6638889 0.325445
+ 8.6666667 0.325954 8.6694444 0.326463 8.6722222 0.327990 8.6750000 0.328499
+ 8.6777778 0.328499 8.6805556 0.326463 8.6833333 0.325954 8.6861111 0.326972
+ 8.6888889 0.327481 8.6916667 0.329008 8.6944444 0.326463 8.6972222 0.326463
+ 8.7000000 0.326463 8.7027778 0.327990 8.7055556 0.330025 8.7083333 0.330534
+ 8.7111111 0.329517 8.7138889 0.329517 8.7166667 0.326972 8.7194444 0.329517
+ 8.7222222 0.330025 8.7250000 0.331043 8.7277778 0.329517 8.7305556 0.329008
+ 8.7333333 0.330025 8.7361111 0.330025 8.7388889 0.331552 8.7416667 0.333079
+ 8.7444444 0.332061 8.7472222 0.329517 8.7500000 0.329008 8.7527778 0.327990
+ 8.7555556 0.327990 8.7583333 0.329517 8.7611111 0.328499 8.7638889 0.329008
+ 8.7666667 0.330534 8.7694444 0.331552 8.7722222 0.333079 8.7750000 0.330025
+ 8.7777778 0.331043 8.7805556 0.328499 8.7833333 0.330534 8.7861111 0.332061
+ 8.7888889 0.332570 8.7916667 0.332061 8.7944444 0.332570 8.7972222 0.331552
+ 8.8000000 0.328499 8.8027778 0.329517 8.8055556 0.330534 8.8083333 0.330025
+ 8.8111111 0.331552 8.8138889 0.330534 8.8166667 0.330025 8.8194444 0.331552
+ 8.8222222 0.333079 8.8250000 0.332570 8.8277778 0.330025 8.8305556 0.329008
+ 8.8333333 0.328499 8.8361111 0.329008 8.8388889 0.331552 8.8416667 0.331043
+ 8.8444444 0.330534 8.8472222 0.330025 8.8500000 0.329517 8.8527778 0.330025
+ 8.8555556 0.330534 8.8583333 0.331552 8.8611111 0.332570 8.8638889 0.331552
+ 8.8666667 0.331043 8.8694444 0.331552 8.8722222 0.332570 8.8750000 0.331043
+ 8.8777778 0.330025 8.8805556 0.330025 8.8833333 0.329517 8.8861111 0.330025
+ 8.8888889 0.331043 8.8916667 0.331552 8.8944444 0.331043 8.8972222 0.330534
+ 8.9000000 0.330534 8.9027778 0.332061 8.9055556 0.332061 8.9083333 0.332570
+ 8.9111111 0.330025 8.9138889 0.327481 8.9166667 0.326463 8.9194444 0.327990
+ 8.9222222 0.328499 8.9250000 0.329517 8.9277778 0.329008 8.9305556 0.329008
+ 8.9333333 0.329008 8.9361111 0.329517 8.9388889 0.331552 8.9416667 0.331552
+ 8.9444444 0.330534 8.9472222 0.330025 8.9500000 0.328499 8.9527778 0.330534
+ 8.9555556 0.330534 8.9583333 0.332061 8.9611111 0.332570 8.9638889 0.332061
+ 8.9666667 0.331043 8.9694444 0.331552 8.9722222 0.332570 8.9750000 0.333079
+ 8.9777778 0.332570 8.9805556 0.331552 8.9833333 0.332061 8.9861111 0.334606
+ 8.9888889 0.335115 8.9916667 0.333588 8.9944444 0.333079 8.9972222 0.333079
+ 9.0000000 0.334606 9.0027778 0.338677 9.0055556 0.342239 9.0083333 0.345293
+ 9.0111111 0.347837 9.0138889 0.349364 9.0166667 0.348346 9.0194444 0.348346
+ 9.0222222 0.346819 9.0250000 0.347837 9.0277778 0.346310 9.0305556 0.346310
+ 9.0333333 0.343257 9.0361111 0.343257 9.0388889 0.341730 9.0416667 0.341221
+ 9.0444444 0.339186 9.0472222 0.340204 9.0500000 0.338677 9.0527778 0.339186
+ 9.0555556 0.338677 9.0583333 0.337150 9.0611111 0.335623 9.0638889 0.332570
+ 9.0666667 0.330534 9.0694444 0.329517 9.0722222 0.329008 9.0750000 0.329008
+ 9.0777778 0.327481 9.0805556 0.326972 9.0833333 0.325954 9.0861111 0.327990
+ 9.0888889 0.328499 9.0916667 0.327990 9.0944444 0.327481 9.0972222 0.327481
+ 9.1000000 0.325445 9.1027778 0.327990 9.1055556 0.328499 9.1083333 0.328499
+ 9.1111111 0.326972 9.1138889 0.326972 9.1166667 0.325954 9.1194444 0.326972
+ 9.1222222 0.329517 9.1250000 0.329517 9.1277778 0.327990 9.1305556 0.325954
+ 9.1333333 0.325954 9.1361111 0.325445 9.1388889 0.323919 9.1416667 0.321374
+ 9.1444444 0.320865 9.1472222 0.322392 9.1500000 0.329517 9.1527778 0.346819
+ 9.1555556 0.367176 9.1583333 0.389567 9.1611111 0.415522 9.1638889 0.444529
+ 9.1666667 0.467939 9.1694444 0.476590 9.1722222 0.463359 9.1750000 0.434860
+ 9.1777778 0.403308 9.1805556 0.376845 9.1833333 0.355980 9.1861111 0.345293
+ 9.1888889 0.344275 9.1916667 0.342748 9.1944444 0.341221 9.1972222 0.338677
+ 9.2000000 0.335115 9.2027778 0.331552 9.2055556 0.330534 9.2083333 0.327990
+ 9.2111111 0.324936 9.2138889 0.322392 9.2166667 0.319847 9.2194444 0.315776
+ 9.2222222 0.316285 9.2250000 0.316285 9.2277778 0.317303 9.2305556 0.317303
+ 9.2333333 0.314758 9.2361111 0.315267 9.2388889 0.315776 9.2416667 0.316794
+ 9.2444444 0.316285 9.2472222 0.315267 9.2500000 0.315267 9.2527778 0.316285
+ 9.2555556 0.316285 9.2583333 0.315776 9.2611111 0.315267 9.2638889 0.313740
+ 9.2666667 0.313740 9.2694444 0.314758 9.2722222 0.315776 9.2750000 0.316794
+ 9.2777778 0.317303 9.2805556 0.317303 9.2833333 0.316285 9.2861111 0.315267
+ 9.2888889 0.317812 9.2916667 0.317812 9.2944444 0.316285 9.2972222 0.315776
+ 9.3000000 0.315267 9.3027778 0.315776 9.3055556 0.316285 9.3083333 0.317812
+ 9.3111111 0.317303 9.3138889 0.317303 9.3166667 0.316285 9.3194444 0.317303
+ 9.3222222 0.318321 9.3250000 0.318830 9.3277778 0.318321 9.3305556 0.318321
+ 9.3333333 0.316794 9.3361111 0.318321 9.3388889 0.320356 9.3416667 0.321374
+ 9.3444444 0.320865 9.3472222 0.318830 9.3500000 0.317812 9.3527778 0.317812
+ 9.3555556 0.318321 9.3583333 0.318830 9.3611111 0.319338 9.3638889 0.318321
+ 9.3666667 0.317303 9.3694444 0.318321 9.3722222 0.318321 9.3750000 0.319847
+ 9.3777778 0.319847 9.3805556 0.318830 9.3833333 0.319338 9.3861111 0.320356
+ 9.3888889 0.321374 9.3916667 0.321883 9.3944444 0.321883 9.3972222 0.321374
+ 9.4000000 0.321883 9.4027778 0.322392 9.4055556 0.322901 9.4083333 0.323919
+ 9.4111111 0.324427 9.4138889 0.324427 9.4166667 0.323919 9.4194444 0.324427
+ 9.4222222 0.325954 9.4250000 0.327990 9.4277778 0.329008 9.4305556 0.329517
+ 9.4333333 0.329517 9.4361111 0.331552 9.4388889 0.333079 9.4416667 0.334097
+ 9.4444444 0.333079 9.4472222 0.333588 9.4500000 0.333079 9.4527778 0.332570
+ 9.4555556 0.335115 9.4583333 0.337150 9.4611111 0.336132 9.4638889 0.338168
+ 9.4666667 0.338168 9.4694444 0.339186 9.4722222 0.340712 9.4750000 0.342239
+ 9.4777778 0.342239 9.4805556 0.341730 9.4833333 0.342239 9.4861111 0.342748
+ 9.4888889 0.344784 9.4916667 0.345802 9.4944444 0.345293 9.4972222 0.344784
+ 9.5000000 0.343766 9.5027778 0.344784 9.5055556 0.342748 9.5083333 0.342748
+ 9.5111111 0.342239 9.5138889 0.338677 9.5166667 0.335623 9.5194444 0.334606
+ 9.5222222 0.334606 9.5250000 0.335623 9.5277778 0.335115 9.5305556 0.334606
+ 9.5333333 0.332061 9.5361111 0.333588 9.5388889 0.332061 9.5416667 0.330534
+ 9.5444444 0.329008 9.5472222 0.327990 9.5500000 0.326463 9.5527778 0.327481
+ 9.5555556 0.326463 9.5583333 0.326972 9.5611111 0.329008 9.5638889 0.327990
+ 9.5666667 0.326972 9.5694444 0.326972 9.5722222 0.326972 9.5750000 0.326463
+ 9.5777778 0.327481 9.5805556 0.325445 9.5833333 0.322901 9.5861111 0.324427
+ 9.5888889 0.323919 9.5916667 0.323919 9.5944444 0.324427 9.5972222 0.323919
+ 9.6000000 0.323410 9.6027778 0.323919 9.6055556 0.326972 9.6083333 0.329008
+ 9.6111111 0.327481 9.6138889 0.326972 9.6166667 0.325445 9.6194444 0.325445
+ 9.6222222 0.325954 9.6250000 0.327481 9.6277778 0.326463 9.6305556 0.324936
+ 9.6333333 0.324936 9.6361111 0.326463 9.6388889 0.328499 9.6416667 0.327990
+ 9.6444444 0.326972 9.6472222 0.325954 9.6500000 0.324936 9.6527778 0.325954
+ 9.6555556 0.327481 9.6583333 0.326972 9.6611111 0.325954 9.6638889 0.324936
+ 9.6666667 0.324427 9.6694444 0.325954 9.6722222 0.325954 9.6750000 0.327990
+ 9.6777778 0.327481 9.6805556 0.327990 9.6833333 0.326972 9.6861111 0.328499
+ 9.6888889 0.328499 9.6916667 0.329008 9.6944444 0.329008 9.6972222 0.328499
+ 9.7000000 0.326463 9.7027778 0.326972 9.7055556 0.327990 9.7083333 0.330025
+ 9.7111111 0.330025 9.7138889 0.329517 9.7166667 0.328499 9.7194444 0.330025
+ 9.7222222 0.330534 9.7250000 0.330534 9.7277778 0.327990 9.7305556 0.327990
+ 9.7333333 0.328499 9.7361111 0.331552 9.7388889 0.331552 9.7416667 0.331552
+ 9.7444444 0.329008 9.7472222 0.328499 9.7500000 0.326972 9.7527778 0.325954
+ 9.7555556 0.325954 9.7583333 0.327990 9.7611111 0.327481 9.7638889 0.327990
+ 9.7666667 0.327481 9.7694444 0.330025 9.7722222 0.331043 9.7750000 0.331043
+ 9.7777778 0.330534 9.7805556 0.329008 9.7833333 0.328499 9.7861111 0.328499
+ 9.7888889 0.330025 9.7916667 0.329008 9.7944444 0.328499 9.7972222 0.327481
+ 9.8000000 0.327481 9.8027778 0.326972 9.8055556 0.327481 9.8083333 0.326972
+ 9.8111111 0.327990 9.8138889 0.328499 9.8166667 0.328499 9.8194444 0.326463
+ 9.8222222 0.327990 9.8250000 0.326463 9.8277778 0.327990 9.8305556 0.326463
+ 9.8333333 0.326972 9.8361111 0.327481 9.8388889 0.329008 9.8416667 0.327990
+ 9.8444444 0.327990 9.8472222 0.327990 9.8500000 0.325954 9.8527778 0.326972
+ 9.8555556 0.326972 9.8583333 0.327481 9.8611111 0.328499 9.8638889 0.327990
+ 9.8666667 0.327481 9.8694444 0.327481 9.8722222 0.328499 9.8750000 0.329517
+ 9.8777778 0.330025 9.8805556 0.327481 9.8833333 0.325954 9.8861111 0.329008
+ 9.8888889 0.332061 9.8916667 0.332570 9.8944444 0.332570 9.8972222 0.331552
+ 9.9000000 0.329008 9.9027778 0.329008 9.9055556 0.332061 9.9083333 0.332061
+ 9.9111111 0.332061 9.9138889 0.331043 9.9166667 0.330534 9.9194444 0.332570
+ 9.9222222 0.338168 9.9250000 0.339695 9.9277778 0.341221 9.9305556 0.344275
+ 9.9333333 0.346310 9.9361111 0.345293 9.9388889 0.342239 9.9416667 0.340204
+ 9.9444444 0.338168 9.9472222 0.336641 9.9500000 0.335115 9.9527778 0.335623
+ 9.9555556 0.335623 9.9583333 0.336641 9.9611111 0.336641 9.9638889 0.335623
+ 9.9666667 0.334097 9.9694444 0.334097 9.9722222 0.332570 9.9750000 0.331552
+ 9.9777778 0.331043 9.9805556 0.329517 9.9833333 0.327990 9.9861111 0.325445
+ 9.9888889 0.325445 9.9916667 0.325445 9.9944444 0.326463 9.9972222 0.325445
+ )

Xdet ecg_in rpeak_out vdd vss vbias
+ v_hpf v_bpf diff_out rect_out mwi_out
+ slow_avg peak_level adapt_thr noise_gate_out thr_gate_out
+ rpeak_detector_v4

.ic v(v_hpf)=0.30
.ic v(v_bpf)=0.30
.ic v(diff_out)=0.40
.ic v(rect_out)=0.40
.ic v(mwi_out)=0.40
.ic v(slow_avg)=0.40
.ic v(peak_level)=0.40
.ic v(adapt_thr)=0.40

.save v(ecg_in) v(rpeak_out) v(mwi_out) v(slow_avg)
+ v(noise_gate_out) v(thr_gate_out) v(rect_out) v(diff_out)

.tran 0.1m 10.0000 uic

.control
run
wrdata scratchpad/_v4_data_101.txt v(ecg_in) v(rpeak_out) v(mwi_out) v(slow_avg) v(noise_gate_out) v(thr_gate_out) v(rect_out) v(diff_out)
quit
.endc

.end
