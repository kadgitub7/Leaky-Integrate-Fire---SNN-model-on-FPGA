* Adaptive threshold validation: Record 105
.lib C:/Users/kadhi/OneDrive/Desktop/amux/verilogLearning/Leaky-Integrate-Fire---SNN-model-on-FPGA/experiments/frontend_optimization/ngspice_frontend/sky130_minimal.lib.spice tt
.include C:/Users/kadhi/OneDrive/Desktop/amux/verilogLearning/Leaky-Integrate-Fire---SNN-model-on-FPGA/experiments/frontend_optimization/complete_frontend_v9b/inverter.spice
.include C:/Users/kadhi/OneDrive/Desktop/amux/verilogLearning/Leaky-Integrate-Fire---SNN-model-on-FPGA/experiments/frontend_optimization/complete_frontend_v9b/rpeak_hold.spice
.include C:/Users/kadhi/OneDrive/Desktop/amux/verilogLearning/Leaky-Integrate-Fire---SNN-model-on-FPGA/experiments/frontend_optimization/complete_frontend_v9b/rpeak_detector_v2.spice
.option scale=1.0u method=gear reltol=0.01 gmin=1e-15

Vdd vdd 0 0.9
Vss vss 0 0.0
Vbias vbias 0 0.300
Vecg ecg_in 0 PWL(
+ 0.0000000 0.264698 0.0027778 0.264698 0.0055556 0.264698 0.0083333 0.264698
+ 0.0111111 0.264698 0.0138889 0.264698 0.0166667 0.264698 0.0194444 0.264698
+ 0.0222222 0.264173 0.0250000 0.266273 0.0277778 0.265748 0.0305556 0.268898
+ 0.0333333 0.270997 0.0361111 0.273097 0.0388889 0.274147 0.0416667 0.275722
+ 0.0444444 0.277297 0.0472222 0.279396 0.0500000 0.281496 0.0527778 0.284121
+ 0.0555556 0.285696 0.0583333 0.287795 0.0611111 0.286220 0.0638889 0.287795
+ 0.0666667 0.289370 0.0694444 0.290945 0.0722222 0.291470 0.0750000 0.290945
+ 0.0777778 0.289895 0.0805556 0.289895 0.0833333 0.290420 0.0861111 0.289895
+ 0.0888889 0.289370 0.0916667 0.288845 0.0944444 0.286745 0.0972222 0.286745
+ 0.1000000 0.288320 0.1027778 0.286745 0.1055556 0.286220 0.1083333 0.284646
+ 0.1111111 0.282021 0.1138889 0.282546 0.1166667 0.283596 0.1194444 0.283071
+ 0.1222222 0.283071 0.1250000 0.281496 0.1277778 0.279396 0.1305556 0.279396
+ 0.1333333 0.280446 0.1361111 0.280971 0.1388889 0.279921 0.1416667 0.279396
+ 0.1444444 0.278346 0.1472222 0.278871 0.1500000 0.278346 0.1527778 0.280446
+ 0.1555556 0.279921 0.1583333 0.278871 0.1611111 0.278346 0.1638889 0.278346
+ 0.1666667 0.277822 0.1694444 0.278346 0.1722222 0.279396 0.1750000 0.278871
+ 0.1777778 0.276772 0.1805556 0.277297 0.1833333 0.276772 0.1861111 0.277822
+ 0.1888889 0.277822 0.1916667 0.278871 0.1944444 0.277297 0.1972222 0.276772
+ 0.2000000 0.276772 0.2027778 0.277297 0.2055556 0.277297 0.2083333 0.276247
+ 0.2111111 0.276247 0.2138889 0.276772 0.2166667 0.277822 0.2194444 0.277822
+ 0.2222222 0.276247 0.2250000 0.276247 0.2277778 0.275197 0.2305556 0.275722
+ 0.2333333 0.277297 0.2361111 0.277822 0.2388889 0.277297 0.2416667 0.274672
+ 0.2444444 0.273622 0.2472222 0.274672 0.2500000 0.277297 0.2527778 0.278871
+ 0.2555556 0.277297 0.2583333 0.276247 0.2611111 0.275722 0.2638889 0.275722
+ 0.2666667 0.276772 0.2694444 0.277297 0.2722222 0.276247 0.2750000 0.275722
+ 0.2777778 0.275197 0.2805556 0.276772 0.2833333 0.276247 0.2861111 0.277297
+ 0.2888889 0.277297 0.2916667 0.276247 0.2944444 0.275722 0.2972222 0.277297
+ 0.3000000 0.277297 0.3027778 0.277822 0.3055556 0.277297 0.3083333 0.276772
+ 0.3111111 0.275197 0.3138889 0.277297 0.3166667 0.277297 0.3194444 0.277297
+ 0.3222222 0.277822 0.3250000 0.277297 0.3277778 0.276772 0.3305556 0.276247
+ 0.3333333 0.279396 0.3361111 0.278871 0.3388889 0.280446 0.3416667 0.281496
+ 0.3444444 0.280971 0.3472222 0.285696 0.3500000 0.287270 0.3527778 0.289370
+ 0.3555556 0.287270 0.3583333 0.285696 0.3611111 0.285696 0.3638889 0.287795
+ 0.3666667 0.291470 0.3694444 0.295144 0.3722222 0.296194 0.3750000 0.295669
+ 0.3777778 0.295144 0.3805556 0.295669 0.3833333 0.296719 0.3861111 0.297769
+ 0.3888889 0.298819 0.3916667 0.298294 0.3944444 0.296719 0.3972222 0.296194
+ 0.4000000 0.295669 0.4027778 0.295144 0.4055556 0.295669 0.4083333 0.293045
+ 0.4111111 0.290420 0.4138889 0.286220 0.4166667 0.282021 0.4194444 0.277297
+ 0.4222222 0.273622 0.4250000 0.271522 0.4277778 0.270472 0.4305556 0.271522
+ 0.4333333 0.271522 0.4361111 0.272572 0.4388889 0.271522 0.4416667 0.269948
+ 0.4444444 0.267848 0.4472222 0.269948 0.4500000 0.269948 0.4527778 0.271522
+ 0.4555556 0.272572 0.4583333 0.272047 0.4611111 0.270472 0.4638889 0.270997
+ 0.4666667 0.271522 0.4694444 0.273097 0.4722222 0.272047 0.4750000 0.272572
+ 0.4777778 0.269423 0.4805556 0.270997 0.4833333 0.272572 0.4861111 0.272047
+ 0.4888889 0.272572 0.4916667 0.272572 0.4944444 0.273622 0.4972222 0.274147
+ 0.5000000 0.274147 0.5027778 0.273097 0.5055556 0.272572 0.5083333 0.272572
+ 0.5111111 0.274147 0.5138889 0.279921 0.5166667 0.289370 0.5194444 0.302493
+ 0.5222222 0.316667 0.5250000 0.336089 0.5277778 0.353412 0.5305556 0.373360
+ 0.5333333 0.392782 0.5361111 0.407480 0.5388889 0.419029 0.5416667 0.426903
+ 0.5444444 0.433202 0.5472222 0.435302 0.5500000 0.425853 0.5527778 0.412205
+ 0.5555556 0.398031 0.5583333 0.385958 0.5611111 0.371785 0.5638889 0.354462
+ 0.5666667 0.338189 0.5694444 0.326640 0.5722222 0.321391 0.5750000 0.311942
+ 0.5777778 0.300394 0.5805556 0.290945 0.5833333 0.285696 0.5861111 0.281496
+ 0.5888889 0.277297 0.5916667 0.272047 0.5944444 0.266273 0.5972222 0.262073
+ 0.6000000 0.259449 0.6027778 0.258399 0.6055556 0.256824 0.6083333 0.253675
+ 0.6111111 0.252625 0.6138889 0.253675 0.6166667 0.254724 0.6194444 0.256824
+ 0.6222222 0.254724 0.6250000 0.254724 0.6277778 0.253675 0.6305556 0.254199
+ 0.6333333 0.255774 0.6361111 0.257349 0.6388889 0.255774 0.6416667 0.255774
+ 0.6444444 0.255249 0.6472222 0.254199 0.6500000 0.256299 0.6527778 0.257349
+ 0.6555556 0.257874 0.6583333 0.256299 0.6611111 0.255249 0.6638889 0.256824
+ 0.6666667 0.257874 0.6694444 0.258399 0.6722222 0.257874 0.6750000 0.256299
+ 0.6777778 0.255249 0.6805556 0.255249 0.6833333 0.257349 0.6861111 0.257874
+ 0.6888889 0.257349 0.6916667 0.256824 0.6944444 0.255774 0.6972222 0.254199
+ 0.7000000 0.255249 0.7027778 0.256299 0.7055556 0.257349 0.7083333 0.255774
+ 0.7111111 0.255249 0.7138889 0.255774 0.7166667 0.257349 0.7194444 0.256824
+ 0.7222222 0.255774 0.7250000 0.256299 0.7277778 0.257349 0.7305556 0.256824
+ 0.7333333 0.259449 0.7361111 0.261024 0.7388889 0.259974 0.7416667 0.260499
+ 0.7444444 0.259449 0.7472222 0.262073 0.7500000 0.262073 0.7527778 0.264173
+ 0.7555556 0.264698 0.7583333 0.266273 0.7611111 0.265748 0.7638889 0.267323
+ 0.7666667 0.269423 0.7694444 0.272047 0.7722222 0.272572 0.7750000 0.273622
+ 0.7777778 0.274672 0.7805556 0.276772 0.7833333 0.279921 0.7861111 0.284121
+ 0.7888889 0.285171 0.7916667 0.286220 0.7944444 0.286745 0.7972222 0.287270
+ 0.8000000 0.289370 0.8027778 0.289895 0.8055556 0.292520 0.8083333 0.293045
+ 0.8111111 0.291995 0.8138889 0.293570 0.8166667 0.294094 0.8194444 0.294619
+ 0.8222222 0.295144 0.8250000 0.293570 0.8277778 0.293570 0.8305556 0.293045
+ 0.8333333 0.293045 0.8361111 0.291995 0.8388889 0.291995 0.8416667 0.290945
+ 0.8444444 0.290420 0.8472222 0.288845 0.8500000 0.288320 0.8527778 0.288845
+ 0.8555556 0.287270 0.8583333 0.283596 0.8611111 0.282021 0.8638889 0.283596
+ 0.8666667 0.284121 0.8694444 0.283596 0.8722222 0.284646 0.8750000 0.282021
+ 0.8777778 0.278871 0.8805556 0.279396 0.8833333 0.280971 0.8861111 0.281496
+ 0.8888889 0.279921 0.8916667 0.281496 0.8944444 0.280971 0.8972222 0.280971
+ 0.9000000 0.280971 0.9027778 0.280446 0.9055556 0.280446 0.9083333 0.278871
+ 0.9111111 0.278871 0.9138889 0.278871 0.9166667 0.278346 0.9194444 0.278346
+ 0.9222222 0.278346 0.9250000 0.277297 0.9277778 0.276772 0.9305556 0.277297
+ 0.9333333 0.278871 0.9361111 0.278346 0.9388889 0.277822 0.9416667 0.277297
+ 0.9444444 0.273622 0.9472222 0.276247 0.9500000 0.277822 0.9527778 0.278871
+ 0.9555556 0.277822 0.9583333 0.277822 0.9611111 0.276772 0.9638889 0.276772
+ 0.9666667 0.278871 0.9694444 0.280971 0.9722222 0.279921 0.9750000 0.277297
+ 0.9777778 0.276772 0.9805556 0.275197 0.9833333 0.277297 0.9861111 0.277822
+ 0.9888889 0.277822 0.9916667 0.278871 0.9944444 0.278346 0.9972222 0.277822
+ 1.0000000 0.277822 1.0027778 0.278346 1.0055556 0.278871 1.0083333 0.276772
+ 1.0111111 0.275722 1.0138889 0.276247 1.0166667 0.277297 1.0194444 0.277822
+ 1.0222222 0.277822 1.0250000 0.277297 1.0277778 0.275197 1.0305556 0.276247
+ 1.0333333 0.277822 1.0361111 0.277822 1.0388889 0.277822 1.0416667 0.276772
+ 1.0444444 0.273622 1.0472222 0.275197 1.0500000 0.277822 1.0527778 0.277822
+ 1.0555556 0.276772 1.0583333 0.275722 1.0611111 0.274147 1.0638889 0.275197
+ 1.0666667 0.276772 1.0694444 0.279396 1.0722222 0.279921 1.0750000 0.280446
+ 1.0777778 0.279396 1.0805556 0.281496 1.0833333 0.285696 1.0861111 0.287795
+ 1.0888889 0.287795 1.0916667 0.285696 1.0944444 0.284121 1.0972222 0.285171
+ 1.1000000 0.288320 1.1027778 0.289895 1.1055556 0.293045 1.1083333 0.292520
+ 1.1111111 0.293045 1.1138889 0.293570 1.1166667 0.296194 1.1194444 0.298819
+ 1.1222222 0.296194 1.1250000 0.295669 1.1277778 0.294094 1.1305556 0.293570
+ 1.1333333 0.294094 1.1361111 0.293570 1.1388889 0.291995 1.1416667 0.289895
+ 1.1444444 0.286220 1.1472222 0.283071 1.1500000 0.277297 1.1527778 0.273622
+ 1.1555556 0.270472 1.1583333 0.269948 1.1611111 0.268898 1.1638889 0.268898
+ 1.1666667 0.267848 1.1694444 0.268373 1.1722222 0.269423 1.1750000 0.268373
+ 1.1777778 0.267323 1.1805556 0.267323 1.1833333 0.269423 1.1861111 0.269948
+ 1.1888889 0.269948 1.1916667 0.269423 1.1944444 0.270472 1.1972222 0.270472
+ 1.2000000 0.270997 1.2027778 0.271522 1.2055556 0.270472 1.2083333 0.269423
+ 1.2111111 0.269948 1.2138889 0.270997 1.2166667 0.272047 1.2194444 0.272572
+ 1.2222222 0.273097 1.2250000 0.270997 1.2277778 0.270472 1.2305556 0.270997
+ 1.2333333 0.270472 1.2361111 0.270472 1.2388889 0.270997 1.2416667 0.272572
+ 1.2444444 0.276772 1.2472222 0.287795 1.2500000 0.301969 1.2527778 0.320866
+ 1.2555556 0.339764 1.2583333 0.359711 1.2611111 0.378609 1.2638889 0.398556
+ 1.2666667 0.414304 1.2694444 0.425328 1.2722222 0.434777 1.2750000 0.434777
+ 1.2777778 0.423228 1.2805556 0.406955 1.2833333 0.393307 1.2861111 0.380709
+ 1.2888889 0.367060 1.2916667 0.351837 1.2944444 0.337139 1.2972222 0.329790
+ 1.3000000 0.327690 1.3027778 0.321391 1.3055556 0.311417 1.3083333 0.299344
+ 1.3111111 0.291470 1.3138889 0.285171 1.3166667 0.280446 1.3194444 0.274672
+ 1.3222222 0.267848 1.3250000 0.263648 1.3277778 0.259974 1.3305556 0.259449
+ 1.3333333 0.259449 1.3361111 0.257874 1.3388889 0.256824 1.3416667 0.254724
+ 1.3444444 0.252625 1.3472222 0.253675 1.3500000 0.254724 1.3527778 0.256824
+ 1.3555556 0.257349 1.3583333 0.256824 1.3611111 0.255774 1.3638889 0.256299
+ 1.3666667 0.259449 1.3694444 0.261549 1.3722222 0.260499 1.3750000 0.259449
+ 1.3777778 0.257874 1.3805556 0.257349 1.3833333 0.258399 1.3861111 0.259449
+ 1.3888889 0.258924 1.3916667 0.259974 1.3944444 0.259449 1.3972222 0.259974
+ 1.4000000 0.259974 1.4027778 0.260499 1.4055556 0.258924 1.4083333 0.258399
+ 1.4111111 0.257349 1.4138889 0.257349 1.4166667 0.257874 1.4194444 0.258399
+ 1.4222222 0.258399 1.4250000 0.258924 1.4277778 0.258399 1.4305556 0.257874
+ 1.4333333 0.258924 1.4361111 0.258924 1.4388889 0.258924 1.4416667 0.258399
+ 1.4444444 0.256299 1.4472222 0.257349 1.4500000 0.257349 1.4527778 0.257349
+ 1.4555556 0.259449 1.4583333 0.258924 1.4611111 0.257874 1.4638889 0.259449
+ 1.4666667 0.259974 1.4694444 0.262073 1.4722222 0.261549 1.4750000 0.261024
+ 1.4777778 0.261549 1.4805556 0.264173 1.4833333 0.265223 1.4861111 0.267848
+ 1.4888889 0.268373 1.4916667 0.267323 1.4944444 0.269423 1.4972222 0.270997
+ 1.5000000 0.275197 1.5027778 0.277297 1.5055556 0.277822 1.5083333 0.276247
+ 1.5111111 0.277297 1.5138889 0.279396 1.5166667 0.281496 1.5194444 0.284646
+ 1.5222222 0.286220 1.5250000 0.286745 1.5277778 0.286745 1.5305556 0.287270
+ 1.5333333 0.289895 1.5361111 0.291470 1.5388889 0.290420 1.5416667 0.290420
+ 1.5444444 0.288320 1.5472222 0.289895 1.5500000 0.288320 1.5527778 0.289895
+ 1.5555556 0.288845 1.5583333 0.285696 1.5611111 0.284121 1.5638889 0.285171
+ 1.5666667 0.284646 1.5694444 0.285171 1.5722222 0.283596 1.5750000 0.282021
+ 1.5777778 0.279921 1.5805556 0.280446 1.5833333 0.279921 1.5861111 0.279921
+ 1.5888889 0.279396 1.5916667 0.278871 1.5944444 0.276772 1.5972222 0.276772
+ 1.6000000 0.277822 1.6027778 0.278346 1.6055556 0.277822 1.6083333 0.276772
+ 1.6111111 0.275197 1.6138889 0.275197 1.6166667 0.275722 1.6194444 0.276247
+ 1.6222222 0.276247 1.6250000 0.275722 1.6277778 0.274147 1.6305556 0.275722
+ 1.6333333 0.275197 1.6361111 0.275722 1.6388889 0.274672 1.6416667 0.274672
+ 1.6444444 0.273097 1.6472222 0.273097 1.6500000 0.274672 1.6527778 0.276247
+ 1.6555556 0.276247 1.6583333 0.274672 1.6611111 0.273622 1.6638889 0.272572
+ 1.6666667 0.273622 1.6694444 0.275197 1.6722222 0.274672 1.6750000 0.273097
+ 1.6777778 0.273097 1.6805556 0.272572 1.6833333 0.274147 1.6861111 0.274147
+ 1.6888889 0.273622 1.6916667 0.273097 1.6944444 0.273097 1.6972222 0.274147
+ 1.7000000 0.276247 1.7027778 0.275722 1.7055556 0.274147 1.7083333 0.272047
+ 1.7111111 0.270997 1.7138889 0.272047 1.7166667 0.273622 1.7194444 0.274672
+ 1.7222222 0.274147 1.7250000 0.273097 1.7277778 0.272047 1.7305556 0.272572
+ 1.7333333 0.273622 1.7361111 0.274147 1.7388889 0.274147 1.7416667 0.273097
+ 1.7444444 0.273097 1.7472222 0.274147 1.7500000 0.276247 1.7527778 0.277297
+ 1.7555556 0.276247 1.7583333 0.273622 1.7611111 0.272047 1.7638889 0.274147
+ 1.7666667 0.276247 1.7694444 0.277822 1.7722222 0.277822 1.7750000 0.280971
+ 1.7777778 0.279921 1.7805556 0.282546 1.7833333 0.285171 1.7861111 0.288320
+ 1.7888889 0.286220 1.7916667 0.284646 1.7944444 0.285696 1.7972222 0.288845
+ 1.8000000 0.292520 1.8027778 0.293570 1.8055556 0.294094 1.8083333 0.296194
+ 1.8111111 0.297244 1.8138889 0.298294 1.8166667 0.299344 1.8194444 0.300394
+ 1.8222222 0.299344 1.8250000 0.297769 1.8277778 0.293570 1.8305556 0.293570
+ 1.8333333 0.292520 1.8361111 0.292520 1.8388889 0.289370 1.8416667 0.284646
+ 1.8444444 0.278346 1.8472222 0.274672 1.8500000 0.272572 1.8527778 0.272047
+ 1.8555556 0.272572 1.8583333 0.270472 1.8611111 0.268898 1.8638889 0.269423
+ 1.8666667 0.270472 1.8694444 0.272047 1.8722222 0.271522 1.8750000 0.270997
+ 1.8777778 0.268898 1.8805556 0.270997 1.8833333 0.272047 1.8861111 0.272047
+ 1.8888889 0.271522 1.8916667 0.272047 1.8944444 0.271522 1.8972222 0.272572
+ 1.9000000 0.274147 1.9027778 0.274672 1.9055556 0.274147 1.9083333 0.273097
+ 1.9111111 0.272047 1.9138889 0.273622 1.9166667 0.274672 1.9194444 0.275722
+ 1.9222222 0.275722 1.9250000 0.274147 1.9277778 0.271522 1.9305556 0.271522
+ 1.9333333 0.273622 1.9361111 0.277822 1.9388889 0.287270 1.9416667 0.300919
+ 1.9444444 0.317192 1.9472222 0.336614 1.9500000 0.354987 1.9527778 0.375459
+ 1.9555556 0.392782 1.9583333 0.408530 1.9611111 0.419554 1.9638889 0.427428
+ 1.9666667 0.432677 1.9694444 0.431102 1.9722222 0.420079 1.9750000 0.404331
+ 1.9777778 0.390682 1.9805556 0.379659 1.9833333 0.368110 1.9861111 0.350262
+ 1.9888889 0.331365 1.9916667 0.319816 1.9944444 0.309843 1.9972222 0.303018
+ 2.0000000 0.293045 2.0027778 0.285696 2.0055556 0.279396 2.0083333 0.273097
+ 2.0111111 0.268373 2.0138889 0.264173 2.0166667 0.262073 2.0194444 0.259974
+ 2.0222222 0.259449 2.0250000 0.255249 2.0277778 0.252625 2.0305556 0.251575
+ 2.0333333 0.252100 2.0361111 0.253150 2.0388889 0.252625 2.0416667 0.252100
+ 2.0444444 0.250000 2.0472222 0.251575 2.0500000 0.253150 2.0527778 0.253675
+ 2.0555556 0.254199 2.0583333 0.253150 2.0611111 0.251575 2.0638889 0.252625
+ 2.0666667 0.253675 2.0694444 0.254199 2.0722222 0.256299 2.0750000 0.255774
+ 2.0777778 0.254199 2.0805556 0.255249 2.0833333 0.255774 2.0861111 0.255774
+ 2.0888889 0.256824 2.0916667 0.256299 2.0944444 0.255249 2.0972222 0.255249
+ 2.1000000 0.256299 2.1027778 0.255249 2.1055556 0.256299 2.1083333 0.255774
+ 2.1111111 0.253675 2.1138889 0.255249 2.1166667 0.255774 2.1194444 0.256824
+ 2.1222222 0.255249 2.1250000 0.254199 2.1277778 0.253675 2.1305556 0.254724
+ 2.1333333 0.256299 2.1361111 0.256299 2.1388889 0.255249 2.1416667 0.254724
+ 2.1444444 0.255774 2.1472222 0.256824 2.1500000 0.257874 2.1527778 0.258924
+ 2.1555556 0.258399 2.1583333 0.257349 2.1611111 0.256824 2.1638889 0.257874
+ 2.1666667 0.258399 2.1694444 0.259449 2.1722222 0.261024 2.1750000 0.261549
+ 2.1777778 0.261549 2.1805556 0.263648 2.1833333 0.266798 2.1861111 0.269423
+ 2.1888889 0.268373 2.1916667 0.268898 2.1944444 0.269423 2.1972222 0.270997
+ 2.2000000 0.272572 2.2027778 0.275197 2.2055556 0.278346 2.2083333 0.278871
+ 2.2111111 0.278346 2.2138889 0.280971 2.2166667 0.284121 2.2194444 0.285171
+ 2.2222222 0.286745 2.2250000 0.287270 2.2277778 0.286220 2.2305556 0.287795
+ 2.2333333 0.288320 2.2361111 0.289895 2.2388889 0.290420 2.2416667 0.292520
+ 2.2444444 0.291995 2.2472222 0.292520 2.2500000 0.291995 2.2527778 0.293570
+ 2.2555556 0.291470 2.2583333 0.289370 2.2611111 0.287795 2.2638889 0.287270
+ 2.2666667 0.288845 2.2694444 0.288845 2.2722222 0.287270 2.2750000 0.285171
+ 2.2777778 0.284121 2.2805556 0.283071 2.2833333 0.284646 2.2861111 0.284646
+ 2.2888889 0.283596 2.2916667 0.282546 2.2944444 0.282546 2.2972222 0.282021
+ 2.3000000 0.281496 2.3027778 0.283071 2.3055556 0.283071 2.3083333 0.280446
+ 2.3111111 0.279921 2.3138889 0.278871 2.3166667 0.278871 2.3194444 0.280446
+ 2.3222222 0.280446 2.3250000 0.280446 2.3277778 0.278346 2.3305556 0.278346
+ 2.3333333 0.277297 2.3361111 0.278346 2.3388889 0.278346 2.3416667 0.278346
+ 2.3444444 0.277297 2.3472222 0.276247 2.3500000 0.276772 2.3527778 0.276772
+ 2.3555556 0.277822 2.3583333 0.277822 2.3611111 0.277297 2.3638889 0.277297
+ 2.3666667 0.278871 2.3694444 0.278871 2.3722222 0.278346 2.3750000 0.279396
+ 2.3777778 0.278871 2.3805556 0.277822 2.3833333 0.277822 2.3861111 0.277822
+ 2.3888889 0.277822 2.3916667 0.277822 2.3944444 0.276772 2.3972222 0.277822
+ 2.4000000 0.278346 2.4027778 0.279396 2.4055556 0.278346 2.4083333 0.278346
+ 2.4111111 0.275722 2.4138889 0.276247 2.4166667 0.277297 2.4194444 0.278346
+ 2.4222222 0.278871 2.4250000 0.276772 2.4277778 0.275722 2.4305556 0.277822
+ 2.4333333 0.279396 2.4361111 0.280446 2.4388889 0.279921 2.4416667 0.278346
+ 2.4444444 0.276772 2.4472222 0.276772 2.4500000 0.278871 2.4527778 0.280446
+ 2.4555556 0.279921 2.4583333 0.277822 2.4611111 0.276772 2.4638889 0.277297
+ 2.4666667 0.278871 2.4694444 0.280446 2.4722222 0.278871 2.4750000 0.277822
+ 2.4777778 0.278346 2.4805556 0.280446 2.4833333 0.282021 2.4861111 0.283596
+ 2.4888889 0.285696 2.4916667 0.285696 2.4944444 0.285696 2.4972222 0.286220
+ 2.5000000 0.288320 2.5027778 0.288845 2.5055556 0.287270 2.5083333 0.289370
+ 2.5111111 0.290945 2.5138889 0.292520 2.5166667 0.294619 2.5194444 0.297244
+ 2.5222222 0.298294 2.5250000 0.297769 2.5277778 0.297769 2.5305556 0.298819
+ 2.5333333 0.301444 2.5361111 0.300394 2.5388889 0.300394 2.5416667 0.297769
+ 2.5444444 0.295669 2.5472222 0.296719 2.5500000 0.296194 2.5527778 0.293570
+ 2.5555556 0.287270 2.5583333 0.282021 2.5611111 0.277297 2.5638889 0.275722
+ 2.5666667 0.275722 2.5694444 0.276247 2.5722222 0.273622 2.5750000 0.273097
+ 2.5777778 0.272047 2.5805556 0.272572 2.5833333 0.274147 2.5861111 0.275722
+ 2.5888889 0.275197 2.5916667 0.274672 2.5944444 0.275197 2.5972222 0.274672
+ 2.6000000 0.274672 2.6027778 0.276772 2.6055556 0.278346 2.6083333 0.277297
+ 2.6111111 0.275722 2.6138889 0.276772 2.6166667 0.276247 2.6194444 0.278346
+ 2.6222222 0.278871 2.6250000 0.278871 2.6277778 0.277822 2.6305556 0.278346
+ 2.6333333 0.279396 2.6361111 0.279396 2.6388889 0.278346 2.6416667 0.277297
+ 2.6444444 0.276247 2.6472222 0.276772 2.6500000 0.282546 2.6527778 0.294094
+ 2.6555556 0.310367 2.6583333 0.330840 2.6611111 0.348688 2.6638889 0.370210
+ 2.6666667 0.392257 2.6694444 0.410630 2.6722222 0.421654 2.6750000 0.431102
+ 2.6777778 0.435302 2.6805556 0.431102 2.6833333 0.420079 2.6861111 0.405381
+ 2.6888889 0.392257 2.6916667 0.382283 2.6944444 0.371260 2.6972222 0.359711
+ 2.7000000 0.343963 2.7027778 0.329265 2.7055556 0.318241 2.7083333 0.308268
+ 2.7111111 0.299869 2.7138889 0.290945 2.7166667 0.283071 2.7194444 0.276772
+ 2.7222222 0.273097 2.7250000 0.267323 2.7277778 0.260499 2.7305556 0.258924
+ 2.7333333 0.257874 2.7361111 0.258924 2.7388889 0.258399 2.7416667 0.257349
+ 2.7444444 0.255249 2.7472222 0.254199 2.7500000 0.254724 2.7527778 0.254724
+ 2.7555556 0.254724 2.7583333 0.255249 2.7611111 0.256824 2.7638889 0.257349
+ 2.7666667 0.257349 2.7694444 0.257874 2.7722222 0.257874 2.7750000 0.258399
+ 2.7777778 0.258924 2.7805556 0.259449 2.7833333 0.259974 2.7861111 0.259974
+ 2.7888889 0.259449 2.7916667 0.259449 2.7944444 0.260499 2.7972222 0.262598
+ 2.8000000 0.262073 2.8027778 0.262073 2.8055556 0.261549 2.8083333 0.259449
+ 2.8111111 0.259974 2.8138889 0.262073 2.8166667 0.262073 2.8194444 0.260499
+ 2.8222222 0.261024 2.8250000 0.258924 2.8277778 0.260499 2.8305556 0.261549
+ 2.8333333 0.260499 2.8361111 0.261024 2.8388889 0.259974 2.8416667 0.259449
+ 2.8444444 0.258399 2.8472222 0.257874 2.8500000 0.261549 2.8527778 0.261024
+ 2.8555556 0.260499 2.8583333 0.258924 2.8611111 0.259449 2.8638889 0.260499
+ 2.8666667 0.261549 2.8694444 0.262598 2.8722222 0.262073 2.8750000 0.260499
+ 2.8777778 0.262598 2.8805556 0.264173 2.8833333 0.266798 2.8861111 0.267323
+ 2.8888889 0.269423 2.8916667 0.267848 2.8944444 0.269948 2.8972222 0.270997
+ 2.9000000 0.271522 2.9027778 0.272047 2.9055556 0.272572 2.9083333 0.272572
+ 2.9111111 0.275197 2.9138889 0.278346 2.9166667 0.281496 2.9194444 0.282021
+ 2.9222222 0.284646 2.9250000 0.284121 2.9277778 0.286745 2.9305556 0.288845
+ 2.9333333 0.290945 2.9361111 0.291470 2.9388889 0.292520 2.9416667 0.293045
+ 2.9444444 0.294094 2.9472222 0.295144 2.9500000 0.296719 2.9527778 0.296194
+ 2.9555556 0.295669 2.9583333 0.295144 2.9611111 0.293045 2.9638889 0.293045
+ 2.9666667 0.294619 2.9694444 0.293045 2.9722222 0.290420 2.9750000 0.288845
+ 2.9777778 0.288320 2.9805556 0.288845 2.9833333 0.287795 2.9861111 0.287270
+ 2.9888889 0.287270 2.9916667 0.286220 2.9944444 0.286745 2.9972222 0.286220
+ 3.0000000 0.285696 3.0027778 0.284646 3.0055556 0.285696 3.0083333 0.285696
+ 3.0111111 0.284646 3.0138889 0.285696 3.0166667 0.286220 3.0194444 0.284646
+ 3.0222222 0.283596 3.0250000 0.282021 3.0277778 0.282546 3.0305556 0.283071
+ 3.0333333 0.284121 3.0361111 0.284121 3.0388889 0.283071 3.0416667 0.282021
+ 3.0444444 0.281496 3.0472222 0.282021 3.0500000 0.283071 3.0527778 0.283071
+ 3.0555556 0.282546 3.0583333 0.283071 3.0611111 0.283071 3.0638889 0.283071
+ 3.0666667 0.283596 3.0694444 0.284646 3.0722222 0.282546 3.0750000 0.280971
+ 3.0777778 0.282021 3.0805556 0.283071 3.0833333 0.282021 3.0861111 0.281496
+ 3.0888889 0.282021 3.0916667 0.282021 3.0944444 0.282546 3.0972222 0.282546
+ 3.1000000 0.284121 3.1027778 0.283596 3.1055556 0.282021 3.1083333 0.281496
+ 3.1111111 0.282021 3.1138889 0.283071 3.1166667 0.285171 3.1194444 0.283071
+ 3.1222222 0.280971 3.1250000 0.282021 3.1277778 0.280971 3.1305556 0.283596
+ 3.1333333 0.284121 3.1361111 0.284646 3.1388889 0.283071 3.1416667 0.281496
+ 3.1444444 0.281496 3.1472222 0.282546 3.1500000 0.284121 3.1527778 0.283071
+ 3.1555556 0.283596 3.1583333 0.282021 3.1611111 0.282021 3.1638889 0.284121
+ 3.1666667 0.283596 3.1694444 0.282546 3.1722222 0.282021 3.1750000 0.280446
+ 3.1777778 0.282546 3.1805556 0.285171 3.1833333 0.285696 3.1861111 0.284646
+ 3.1888889 0.283071 3.1916667 0.281496 3.1944444 0.281496 3.1972222 0.283596
+ 3.2000000 0.286220 3.2027778 0.286745 3.2055556 0.287795 3.2083333 0.289895
+ 3.2111111 0.293570 3.2138889 0.296194 3.2166667 0.295669 3.2194444 0.292520
+ 3.2222222 0.293045 3.2250000 0.293570 3.2277778 0.297769 3.2305556 0.300919
+ 3.2333333 0.302493 3.2361111 0.301969 3.2388889 0.303543 3.2416667 0.302493
+ 3.2444444 0.301969 3.2472222 0.303543 3.2500000 0.305643 3.2527778 0.304593
+ 3.2555556 0.303543 3.2583333 0.301969 3.2611111 0.299869 3.2638889 0.299869
+ 3.2666667 0.298819 3.2694444 0.297769 3.2722222 0.291470 3.2750000 0.284121
+ 3.2777778 0.279921 3.2805556 0.277297 3.2833333 0.276772 3.2861111 0.276247
+ 3.2888889 0.275722 3.2916667 0.276247 3.2944444 0.276772 3.2972222 0.275722
+ 3.3000000 0.275722 3.3027778 0.276247 3.3055556 0.276247 3.3083333 0.275722
+ 3.3111111 0.277297 3.3138889 0.276247 3.3166667 0.277297 3.3194444 0.277822
+ 3.3222222 0.277297 3.3250000 0.277297 3.3277778 0.277297 3.3305556 0.278871
+ 3.3333333 0.280446 3.3361111 0.279396 3.3388889 0.279396 3.3416667 0.279396
+ 3.3444444 0.282021 3.3472222 0.283071 3.3500000 0.282546 3.3527778 0.280971
+ 3.3555556 0.278346 3.3583333 0.278871 3.3611111 0.280971 3.3638889 0.285696
+ 3.3666667 0.294619 3.3694444 0.306693 3.3722222 0.323491 3.3750000 0.342913
+ 3.3777778 0.365486 3.3805556 0.389108 3.3833333 0.409580 3.3861111 0.424278
+ 3.3888889 0.436877 3.3916667 0.441076 3.3944444 0.436877 3.3972222 0.424803
+ 3.4000000 0.412205 3.4027778 0.399081 3.4055556 0.389108 3.4083333 0.377034
+ 3.4111111 0.360236 3.4138889 0.343963 3.4166667 0.333990 3.4194444 0.326115
+ 3.4222222 0.314042 3.4250000 0.303018 3.4277778 0.294619 3.4305556 0.287270
+ 3.4333333 0.283071 3.4361111 0.277297 3.4388889 0.270997 3.4416667 0.264698
+ 3.4444444 0.263123 3.4472222 0.263123 3.4500000 0.260499 3.4527778 0.260499
+ 3.4555556 0.259449 3.4583333 0.258924 3.4611111 0.259449 3.4638889 0.257874
+ 3.4666667 0.257349 3.4694444 0.258399 3.4722222 0.259449 3.4750000 0.259449
+ 3.4777778 0.259449 3.4805556 0.261549 3.4833333 0.261549 3.4861111 0.261024
+ 3.4888889 0.260499 3.4916667 0.259974 3.4944444 0.258924 3.4972222 0.260499
+ 3.5000000 0.262073 3.5027778 0.262073 3.5055556 0.262598 3.5083333 0.262073
+ 3.5111111 0.262598 3.5138889 0.262598 3.5166667 0.261024 3.5194444 0.261549
+ 3.5222222 0.261024 3.5250000 0.261024 3.5277778 0.261024 3.5305556 0.262598
+ 3.5333333 0.262073 3.5361111 0.262073 3.5388889 0.261549 3.5416667 0.260499
+ 3.5444444 0.262598 3.5472222 0.263123 3.5500000 0.263648 3.5527778 0.264173
+ 3.5555556 0.263123 3.5583333 0.261024 3.5611111 0.263123 3.5638889 0.264173
+ 3.5666667 0.265223 3.5694444 0.264698 3.5722222 0.264173 3.5750000 0.262598
+ 3.5777778 0.262598 3.5805556 0.262598 3.5833333 0.263648 3.5861111 0.265223
+ 3.5888889 0.266273 3.5916667 0.265748 3.5944444 0.267323 3.5972222 0.268373
+ 3.6000000 0.270472 3.6027778 0.272572 3.6055556 0.273097 3.6083333 0.273622
+ 3.6111111 0.276772 3.6138889 0.278346 3.6166667 0.280446 3.6194444 0.282546
+ 3.6222222 0.282021 3.6250000 0.283071 3.6277778 0.286220 3.6305556 0.288320
+ 3.6333333 0.290420 3.6361111 0.291995 3.6388889 0.292520 3.6416667 0.293045
+ 3.6444444 0.294619 3.6472222 0.297244 3.6500000 0.299344 3.6527778 0.298294
+ 3.6555556 0.297769 3.6583333 0.295144 3.6611111 0.295669 3.6638889 0.296719
+ 3.6666667 0.297244 3.6694444 0.296719 3.6722222 0.294619 3.6750000 0.293045
+ 3.6777778 0.293045 3.6805556 0.292520 3.6833333 0.293570 3.6861111 0.291995
+ 3.6888889 0.290420 3.6916667 0.288845 3.6944444 0.288320 3.6972222 0.287795
+ 3.7000000 0.286745 3.7027778 0.286745 3.7055556 0.286220 3.7083333 0.285171
+ 3.7111111 0.285171 3.7138889 0.286220 3.7166667 0.286745 3.7194444 0.285171
+ 3.7222222 0.285171 3.7250000 0.282021 3.7277778 0.283071 3.7305556 0.283071
+ 3.7333333 0.284121 3.7361111 0.282546 3.7388889 0.282546 3.7416667 0.279921
+ 3.7444444 0.281496 3.7472222 0.282546 3.7500000 0.283596 3.7527778 0.283071
+ 3.7555556 0.282021 3.7583333 0.280446 3.7611111 0.280971 3.7638889 0.281496
+ 3.7666667 0.283596 3.7694444 0.281496 3.7722222 0.280446 3.7750000 0.280446
+ 3.7777778 0.278871 3.7805556 0.280971 3.7833333 0.282021 3.7861111 0.281496
+ 3.7888889 0.280971 3.7916667 0.280971 3.7944444 0.280446 3.7972222 0.280971
+ 3.8000000 0.281496 3.8027778 0.280971 3.8055556 0.281496 3.8083333 0.278871
+ 3.8111111 0.279921 3.8138889 0.279396 3.8166667 0.280446 3.8194444 0.280971
+ 3.8222222 0.280971 3.8250000 0.280971 3.8277778 0.280446 3.8305556 0.279921
+ 3.8333333 0.282021 3.8361111 0.282021 3.8388889 0.281496 3.8416667 0.279921
+ 3.8444444 0.280971 3.8472222 0.281496 3.8500000 0.282546 3.8527778 0.283071
+ 3.8555556 0.282546 3.8583333 0.279921 3.8611111 0.280971 3.8638889 0.282546
+ 3.8666667 0.282546 3.8694444 0.283071 3.8722222 0.281496 3.8750000 0.280446
+ 3.8777778 0.281496 3.8805556 0.282021 3.8833333 0.283596 3.8861111 0.283071
+ 3.8888889 0.283071 3.8916667 0.283071 3.8944444 0.282546 3.8972222 0.284646
+ 3.9000000 0.284646 3.9027778 0.284646 3.9055556 0.283596 3.9083333 0.283071
+ 3.9111111 0.287795 3.9138889 0.289895 3.9166667 0.290945 3.9194444 0.291995
+ 3.9222222 0.290945 3.9250000 0.290420 3.9277778 0.290945 3.9305556 0.293045
+ 3.9333333 0.296194 3.9361111 0.297769 3.9388889 0.297769 3.9416667 0.298294
+ 3.9444444 0.299869 3.9472222 0.301444 3.9500000 0.305118 3.9527778 0.304068
+ 3.9555556 0.303543 3.9583333 0.300394 3.9611111 0.300919 3.9638889 0.302493
+ 3.9666667 0.302493 3.9694444 0.301969 3.9722222 0.299344 3.9750000 0.297769
+ 3.9777778 0.295144 3.9805556 0.292520 3.9833333 0.288320 3.9861111 0.282546
+ 3.9888889 0.279396 3.9916667 0.274147 3.9944444 0.274672 3.9972222 0.276247
+ 4.0000000 0.276772 4.0027778 0.275722 4.0055556 0.274672 4.0083333 0.272572
+ 4.0111111 0.275197 4.0138889 0.275722 4.0166667 0.276772 4.0194444 0.276772
+ 4.0222222 0.275722 4.0250000 0.275722 4.0277778 0.276772 4.0305556 0.277297
+ 4.0333333 0.277822 4.0361111 0.277822 4.0388889 0.276772 4.0416667 0.275722
+ 4.0444444 0.277822 4.0472222 0.279396 4.0500000 0.280446 4.0527778 0.280971
+ 4.0555556 0.279921 4.0583333 0.277822 4.0611111 0.279921 4.0638889 0.278871
+ 4.0666667 0.278871 4.0694444 0.278346 4.0722222 0.278871 4.0750000 0.279921
+ 4.0777778 0.286745 4.0805556 0.296719 4.0833333 0.311417 4.0861111 0.330315
+ 4.0888889 0.349738 4.0916667 0.369685 4.0944444 0.390682 4.0972222 0.410105
+ 4.1000000 0.424278 4.1027778 0.433202 4.1055556 0.438451 4.1083333 0.433727
+ 4.1111111 0.423228 4.1138889 0.410105 4.1166667 0.399081 4.1194444 0.390682
+ 4.1222222 0.380184 4.1250000 0.366535 4.1277778 0.349213 4.1305556 0.334514
+ 4.1333333 0.325591 4.1361111 0.318766 4.1388889 0.309318 4.1416667 0.297769
+ 4.1444444 0.288845 4.1472222 0.282546 4.1500000 0.278346 4.1527778 0.273622
+ 4.1555556 0.268373 4.1583333 0.264698 4.1611111 0.263648 4.1638889 0.262598
+ 4.1666667 0.262598 4.1694444 0.262073 4.1722222 0.260499 4.1750000 0.259449
+ 4.1777778 0.258399 4.1805556 0.258924 4.1833333 0.259449 4.1861111 0.258924
+ 4.1888889 0.259449 4.1916667 0.258924 4.1944444 0.259449 4.1972222 0.261024
+ 4.2000000 0.262073 4.2027778 0.261549 4.2055556 0.262073 4.2083333 0.260499
+ 4.2111111 0.261549 4.2138889 0.262598 4.2166667 0.262598 4.2194444 0.262073
+ 4.2222222 0.259449 4.2250000 0.259449 4.2277778 0.260499 4.2305556 0.261549
+ 4.2333333 0.262073 4.2361111 0.261024 4.2388889 0.260499 4.2416667 0.258399
+ 4.2444444 0.259449 4.2472222 0.261549 4.2500000 0.263123 4.2527778 0.262598
+ 4.2555556 0.261024 4.2583333 0.260499 4.2611111 0.259449 4.2638889 0.261549
+ 4.2666667 0.260499 4.2694444 0.260499 4.2722222 0.261549 4.2750000 0.259449
+ 4.2777778 0.258399 4.2805556 0.259974 4.2833333 0.260499 4.2861111 0.262073
+ 4.2888889 0.262073 4.2916667 0.262073 4.2944444 0.260499 4.2972222 0.262598
+ 4.3000000 0.262598 4.3027778 0.262598 4.3055556 0.263123 4.3083333 0.264173
+ 4.3111111 0.263648 4.3138889 0.266273 4.3166667 0.268373 4.3194444 0.268373
+ 4.3222222 0.268373 4.3250000 0.268898 4.3277778 0.271522 4.3305556 0.274672
+ 4.3333333 0.275722 4.3361111 0.276772 4.3388889 0.277297 4.3416667 0.279921
+ 4.3444444 0.283071 4.3472222 0.285696 4.3500000 0.286220 4.3527778 0.287795
+ 4.3555556 0.287270 4.3583333 0.287270 4.3611111 0.289370 4.3638889 0.290945
+ 4.3666667 0.293045 4.3694444 0.293045 4.3722222 0.293045 4.3750000 0.293045
+ 4.3777778 0.293570 4.3805556 0.295144 4.3833333 0.296719 4.3861111 0.295144
+ 4.3888889 0.293045 4.3916667 0.291470 4.3944444 0.292520 4.3972222 0.290945
+ 4.4000000 0.289895 4.4027778 0.290420 4.4055556 0.289895 4.4083333 0.287270
+ 4.4111111 0.287270 4.4138889 0.287795 4.4166667 0.289370 4.4194444 0.287795
+ 4.4222222 0.286220 4.4250000 0.285696 4.4277778 0.285171 4.4305556 0.285696
+ 4.4333333 0.285696 4.4361111 0.285696 4.4388889 0.284121 4.4416667 0.282021
+ 4.4444444 0.280971 4.4472222 0.282021 4.4500000 0.284121 4.4527778 0.284121
+ 4.4555556 0.281496 4.4583333 0.280446 4.4611111 0.281496 4.4638889 0.282021
+ 4.4666667 0.283596 4.4694444 0.283071 4.4722222 0.282546 4.4750000 0.279396
+ 4.4777778 0.279921 4.4805556 0.280446 4.4833333 0.282546 4.4861111 0.282021
+ 4.4888889 0.280446 4.4916667 0.279921 4.4944444 0.280446 4.4972222 0.280971
+ 4.5000000 0.281496 4.5027778 0.280971 4.5055556 0.279921 4.5083333 0.279921
+ 4.5111111 0.280971 4.5138889 0.281496 4.5166667 0.280446 4.5194444 0.282021
+ 4.5222222 0.281496 4.5250000 0.280446 4.5277778 0.281496 4.5305556 0.280971
+ 4.5333333 0.282546 4.5361111 0.281496 4.5388889 0.279396 4.5416667 0.279396
+ 4.5444444 0.279396 4.5472222 0.281496 4.5500000 0.281496 4.5527778 0.280971
+ 4.5555556 0.280446 4.5583333 0.279396 4.5611111 0.279396 4.5638889 0.280446
+ 4.5666667 0.281496 4.5694444 0.282021 4.5722222 0.282021 4.5750000 0.280446
+ 4.5777778 0.280971 4.5805556 0.281496 4.5833333 0.282546 4.5861111 0.281496
+ 4.5888889 0.282021 4.5916667 0.280446 4.5944444 0.280971 4.5972222 0.280971
+ 4.6000000 0.281496 4.6027778 0.282021 4.6055556 0.280971 4.6083333 0.279921
+ 4.6111111 0.282546 4.6138889 0.282546 4.6166667 0.282546 4.6194444 0.282546
+ 4.6222222 0.280971 4.6250000 0.281496 4.6277778 0.283071 4.6305556 0.283596
+ 4.6333333 0.285696 4.6361111 0.287270 4.6388889 0.288320 4.6416667 0.288320
+ 4.6444444 0.289370 4.6472222 0.292520 4.6500000 0.292520 4.6527778 0.291470
+ 4.6555556 0.291470 4.6583333 0.291470 4.6611111 0.295669 4.6638889 0.298294
+ 4.6666667 0.300394 4.6694444 0.301444 4.6722222 0.301969 4.6750000 0.301969
+ 4.6777778 0.303543 4.6805556 0.305118 4.6833333 0.304593 4.6861111 0.303018
+ 4.6888889 0.301444 4.6916667 0.299869 4.6944444 0.300394 4.6972222 0.300919
+ 4.7000000 0.300919 4.7027778 0.298294 4.7055556 0.293570 4.7083333 0.287795
+ 4.7111111 0.283071 4.7138889 0.280446 4.7166667 0.279396 4.7194444 0.277297
+ 4.7222222 0.275197 4.7250000 0.275722 4.7277778 0.276247 4.7305556 0.277297
+ 4.7333333 0.277822 4.7361111 0.276772 4.7388889 0.275722 4.7416667 0.274672
+ 4.7444444 0.275722 4.7472222 0.277822 4.7500000 0.277822 4.7527778 0.277822
+ 4.7555556 0.277822 4.7583333 0.277297 4.7611111 0.277297 4.7638889 0.277822
+ 4.7666667 0.279921 4.7694444 0.280446 4.7722222 0.279396 4.7750000 0.278871
+ 4.7777778 0.278871 4.7805556 0.279396 4.7833333 0.280971 4.7861111 0.282021
+ 4.7888889 0.279396 4.7916667 0.278871 4.7944444 0.278346 4.7972222 0.277297
+ 4.8000000 0.278871 4.8027778 0.279921 4.8055556 0.284646 4.8083333 0.292520
+ 4.8111111 0.306693 4.8138889 0.325591 4.8166667 0.345013 4.8194444 0.363386
+ 4.8222222 0.382283 4.8250000 0.401181 4.8277778 0.417979 4.8305556 0.430577
+ 4.8333333 0.437402 4.8361111 0.437927 4.8388889 0.426903 4.8416667 0.411155
+ 4.8444444 0.397507 4.8472222 0.389633 4.8500000 0.380709 4.8527778 0.366010
+ 4.8555556 0.348688 4.8583333 0.336614 4.8611111 0.327690 4.8638889 0.326115
+ 4.8666667 0.319816 4.8694444 0.309318 4.8722222 0.298294 4.8750000 0.288320
+ 4.8777778 0.280971 4.8805556 0.277297 4.8833333 0.274147 4.8861111 0.269948
+ 4.8888889 0.265748 4.8916667 0.263648 4.8944444 0.263123 4.8972222 0.261549
+ 4.9000000 0.261024 4.9027778 0.259449 4.9055556 0.258924 4.9083333 0.257874
+ 4.9111111 0.258924 4.9138889 0.260499 4.9166667 0.261549 4.9194444 0.261024
+ 4.9222222 0.259449 4.9250000 0.259974 4.9277778 0.260499 4.9305556 0.261549
+ 4.9333333 0.264698 4.9361111 0.263123 4.9388889 0.260499 4.9416667 0.259449
+ 4.9444444 0.259974 4.9472222 0.261024 4.9500000 0.262598 4.9527778 0.262598
+ 4.9555556 0.262073 4.9583333 0.261024 4.9611111 0.261549 4.9638889 0.263123
+ 4.9666667 0.262073 4.9694444 0.263123 4.9722222 0.262073 4.9750000 0.262073
+ 4.9777778 0.261024 4.9805556 0.260499 4.9833333 0.261549 4.9861111 0.261549
+ 4.9888889 0.259974 4.9916667 0.257874 4.9944444 0.257874 4.9972222 0.257874
+ 5.0000000 0.259449 5.0027778 0.258924 5.0055556 0.257874 5.0083333 0.258399
+ 5.0111111 0.259449 5.0138889 0.258399 5.0166667 0.259974 5.0194444 0.259974
+ 5.0222222 0.259449 5.0250000 0.259449 5.0277778 0.260499 5.0305556 0.262073
+ 5.0333333 0.262598 5.0361111 0.260499 5.0388889 0.261024 5.0416667 0.260499
+ 5.0444444 0.262073 5.0472222 0.265223 5.0500000 0.266273 5.0527778 0.265223
+ 5.0555556 0.265748 5.0583333 0.266798 5.0611111 0.268898 5.0638889 0.269423
+ 5.0666667 0.270997 5.0694444 0.273097 5.0722222 0.274147 5.0750000 0.274672
+ 5.0777778 0.276772 5.0805556 0.278346 5.0833333 0.280971 5.0861111 0.282546
+ 5.0888889 0.283071 5.0916667 0.283596 5.0944444 0.285171 5.0972222 0.285696
+ 5.1000000 0.288845 5.1027778 0.290420 5.1055556 0.291470 5.1083333 0.290945
+ 5.1111111 0.293045 5.1138889 0.294619 5.1166667 0.295144 5.1194444 0.295669
+ 5.1222222 0.294619 5.1250000 0.294094 5.1277778 0.294619 5.1305556 0.295144
+ 5.1333333 0.295144 5.1361111 0.293570 5.1388889 0.291995 5.1416667 0.290420
+ 5.1444444 0.289370 5.1472222 0.290945 5.1500000 0.290420 5.1527778 0.289370
+ 5.1555556 0.286745 5.1583333 0.286220 5.1611111 0.285696 5.1638889 0.286745
+ 5.1666667 0.288320 5.1694444 0.287270 5.1722222 0.284646 5.1750000 0.283071
+ 5.1777778 0.282546 5.1805556 0.283596 5.1833333 0.284121 5.1861111 0.283596
+ 5.1888889 0.283596 5.1916667 0.282546 5.1944444 0.281496 5.1972222 0.282546
+ 5.2000000 0.283596 5.2027778 0.284121 5.2055556 0.282546 5.2083333 0.280971
+ 5.2111111 0.282021 5.2138889 0.280446 5.2166667 0.282021 5.2194444 0.281496
+ 5.2222222 0.280971 5.2250000 0.278871 5.2277778 0.280446 5.2305556 0.281496
+ 5.2333333 0.281496 5.2361111 0.280446 5.2388889 0.278871 5.2416667 0.277297
+ 5.2444444 0.278871 5.2472222 0.280446 5.2500000 0.281496 5.2527778 0.280446
+ 5.2555556 0.279396 5.2583333 0.279396 5.2611111 0.278871 5.2638889 0.280446
+ 5.2666667 0.280971 5.2694444 0.280971 5.2722222 0.279921 5.2750000 0.279396
+ 5.2777778 0.280446 5.2805556 0.279921 5.2833333 0.279921 5.2861111 0.280446
+ 5.2888889 0.281496 5.2916667 0.280446 5.2944444 0.280971 5.2972222 0.282021
+ 5.3000000 0.282546 5.3027778 0.280971 5.3055556 0.279396 5.3083333 0.279396
+ 5.3111111 0.280446 5.3138889 0.281496 5.3166667 0.282546 5.3194444 0.280971
+ 5.3222222 0.280446 5.3250000 0.278871 5.3277778 0.279921 5.3305556 0.280446
+ 5.3333333 0.282546 5.3361111 0.282546 5.3388889 0.280971 5.3416667 0.279921
+ 5.3444444 0.279396 5.3472222 0.280971 5.3500000 0.280971 5.3527778 0.281496
+ 5.3555556 0.282021 5.3583333 0.281496 5.3611111 0.280971 5.3638889 0.281496
+ 5.3666667 0.282021 5.3694444 0.281496 5.3722222 0.282546 5.3750000 0.281496
+ 5.3777778 0.282546 5.3805556 0.283596 5.3833333 0.283596 5.3861111 0.283596
+ 5.3888889 0.283596 5.3916667 0.284646 5.3944444 0.288320 5.3972222 0.291995
+ 5.4000000 0.293045 5.4027778 0.292520 5.4055556 0.290420 5.4083333 0.288845
+ 5.4111111 0.291470 5.4138889 0.294619 5.4166667 0.298294 5.4194444 0.299344
+ 5.4222222 0.299869 5.4250000 0.299344 5.4277778 0.299344 5.4305556 0.300919
+ 5.4333333 0.303543 5.4361111 0.303543 5.4388889 0.302493 5.4416667 0.300919
+ 5.4444444 0.301444 5.4472222 0.302493 5.4500000 0.300919 5.4527778 0.298819
+ 5.4555556 0.298294 5.4583333 0.296194 5.4611111 0.294094 5.4638889 0.290945
+ 5.4666667 0.285696 5.4694444 0.279921 5.4722222 0.277297 5.4750000 0.274672
+ 5.4777778 0.274672 5.4805556 0.275722 5.4833333 0.275722 5.4861111 0.274672
+ 5.4888889 0.273622 5.4916667 0.272572 5.4944444 0.274147 5.4972222 0.275722
+ 5.5000000 0.276247 5.5027778 0.275197 5.5055556 0.276247 5.5083333 0.274672
+ 5.5111111 0.274672 5.5138889 0.275722 5.5166667 0.275722 5.5194444 0.276247
+ 5.5222222 0.276247 5.5250000 0.274672 5.5277778 0.275722 5.5305556 0.277297
+ 5.5333333 0.278871 5.5361111 0.280446 5.5388889 0.277297 5.5416667 0.277297
+ 5.5444444 0.278871 5.5472222 0.277822 5.5500000 0.278346 5.5527778 0.278346
+ 5.5555556 0.276772 5.5583333 0.276247 5.5611111 0.277822 5.5638889 0.282546
+ 5.5666667 0.288845 5.5694444 0.300919 5.5722222 0.312467 5.5750000 0.328740
+ 5.5777778 0.347113 5.5805556 0.366535 5.5833333 0.385433 5.5861111 0.401706
+ 5.5888889 0.414304 5.5916667 0.424803 5.5944444 0.435302 5.5972222 0.437927
+ 5.6000000 0.432677 5.6027778 0.419029 5.6055556 0.403806 5.6083333 0.392257
+ 5.6111111 0.383333 5.6138889 0.373885 5.6166667 0.361811 5.6194444 0.346063
+ 5.6222222 0.334514 5.6250000 0.328740 5.6277778 0.320866 5.6305556 0.312992
+ 5.6333333 0.303018 5.6361111 0.293045 5.6388889 0.285171 5.6416667 0.278871
+ 5.6444444 0.273622 5.6472222 0.267848 5.6500000 0.262598 5.6527778 0.259974
+ 5.6555556 0.258399 5.6583333 0.256824 5.6611111 0.256299 5.6638889 0.255249
+ 5.6666667 0.255774 5.6694444 0.255774 5.6722222 0.256299 5.6750000 0.253675
+ 5.6777778 0.253675 5.6805556 0.253150 5.6833333 0.255774 5.6861111 0.256299
+ 5.6888889 0.255774 5.6916667 0.255774 5.6944444 0.256299 5.6972222 0.256299
+ 5.7000000 0.256824 5.7027778 0.256299 5.7055556 0.255774 5.7083333 0.256824
+ 5.7111111 0.258399 5.7138889 0.257874 5.7166667 0.258399 5.7194444 0.258399
+ 5.7222222 0.256824 5.7250000 0.256299 5.7277778 0.256824 5.7305556 0.258399
+ 5.7333333 0.258399 5.7361111 0.258399 5.7388889 0.256824 5.7416667 0.256299
+ 5.7444444 0.255249 5.7472222 0.255774 5.7500000 0.256299 5.7527778 0.256299
+ 5.7555556 0.256299 5.7583333 0.255774 5.7611111 0.256299 5.7638889 0.256299
+ 5.7666667 0.256824 5.7694444 0.256299 5.7722222 0.255249 5.7750000 0.255774
+ 5.7777778 0.255774 5.7805556 0.256824 5.7833333 0.257349 5.7861111 0.255774
+ 5.7888889 0.256299 5.7916667 0.255774 5.7944444 0.255774 5.7972222 0.257874
+ 5.8000000 0.259449 5.8027778 0.259449 5.8055556 0.259449 5.8083333 0.258399
+ 5.8111111 0.259974 5.8138889 0.262598 5.8166667 0.265223 5.8194444 0.265748
+ 5.8222222 0.265748 5.8250000 0.264698 5.8277778 0.266273 5.8305556 0.268898
+ 5.8333333 0.272047 5.8361111 0.273097 5.8388889 0.275197 5.8416667 0.276247
+ 5.8444444 0.276247 5.8472222 0.278346 5.8500000 0.280971 5.8527778 0.279921
+ 5.8555556 0.282546 5.8583333 0.282546 5.8611111 0.285171 5.8638889 0.287270
+ 5.8666667 0.288320 5.8694444 0.288320 5.8722222 0.289370 5.8750000 0.288845
+ 5.8777778 0.291470 5.8805556 0.292520 5.8833333 0.294094 5.8861111 0.293570
+ 5.8888889 0.291995 5.8916667 0.289895 5.8944444 0.290945 5.8972222 0.291470
+ 5.9000000 0.291995 5.9027778 0.291995 5.9055556 0.290420 5.9083333 0.289370
+ 5.9111111 0.287795 5.9138889 0.288320 5.9166667 0.288320 5.9194444 0.286745
+ 5.9222222 0.286220 5.9250000 0.284121 5.9277778 0.283071 5.9305556 0.282546
+ 5.9333333 0.283071 5.9361111 0.282546 5.9388889 0.282021 5.9416667 0.280971
+ 5.9444444 0.281496 5.9472222 0.282546 5.9500000 0.282546 5.9527778 0.280971
+ 5.9555556 0.280446 5.9583333 0.278871 5.9611111 0.278871 5.9638889 0.280446
+ 5.9666667 0.282546 5.9694444 0.280446 5.9722222 0.279921 5.9750000 0.278346
+ 5.9777778 0.277822 5.9805556 0.278871 5.9833333 0.280446 5.9861111 0.279921
+ 5.9888889 0.278346 5.9916667 0.276247 5.9944444 0.277822 5.9972222 0.278346
+ 6.0000000 0.279396 6.0027778 0.278346 6.0055556 0.277822 6.0083333 0.277297
+ 6.0111111 0.277822 6.0138889 0.278346 6.0166667 0.278346 6.0194444 0.278871
+ 6.0222222 0.276772 6.0250000 0.276247 6.0277778 0.278346 6.0305556 0.277822
+ 6.0333333 0.278871 6.0361111 0.278871 6.0388889 0.277297 6.0416667 0.276247
+ 6.0444444 0.277297 6.0472222 0.278871 6.0500000 0.279396 6.0527778 0.279921
+ 6.0555556 0.278346 6.0583333 0.277822 6.0611111 0.278871 6.0638889 0.279396
+ 6.0666667 0.280971 6.0694444 0.279921 6.0722222 0.278346 6.0750000 0.278871
+ 6.0777778 0.278346 6.0805556 0.279396 6.0833333 0.279396 6.0861111 0.278871
+ 6.0888889 0.278346 6.0916667 0.278346 6.0944444 0.278871 6.0972222 0.279921
+ 6.1000000 0.280971 6.1027778 0.278871 6.1055556 0.278346 6.1083333 0.276772
+ 6.1111111 0.278346 6.1138889 0.280446 6.1166667 0.280446 6.1194444 0.279921
+ 6.1222222 0.279921 6.1250000 0.278346 6.1277778 0.279921 6.1305556 0.280971
+ 6.1333333 0.281496 6.1361111 0.281496 6.1388889 0.280446 6.1416667 0.279396
+ 6.1444444 0.278871 6.1472222 0.280446 6.1500000 0.282021 6.1527778 0.283071
+ 6.1555556 0.284646 6.1583333 0.285171 6.1611111 0.288320 6.1638889 0.289895
+ 6.1666667 0.291470 6.1694444 0.290945 6.1722222 0.289370 6.1750000 0.288320
+ 6.1777778 0.290945 6.1805556 0.293045 6.1833333 0.294619 6.1861111 0.295144
+ 6.1888889 0.295669 6.1916667 0.296194 6.1944444 0.297769 6.1972222 0.299869
+ 6.2000000 0.301444 6.2027778 0.299869 6.2055556 0.300394 6.2083333 0.298294
+ 6.2111111 0.297244 6.2138889 0.297769 6.2166667 0.298294 6.2194444 0.296719
+ 6.2222222 0.295144 6.2250000 0.290420 6.2277778 0.286220 6.2305556 0.282546
+ 6.2333333 0.279921 6.2361111 0.277822 6.2388889 0.275197 6.2416667 0.271522
+ 6.2444444 0.270997 6.2472222 0.272572 6.2500000 0.274147 6.2527778 0.273097
+ 6.2555556 0.272047 6.2583333 0.271522 6.2611111 0.273097 6.2638889 0.274147
+ 6.2666667 0.274147 6.2694444 0.273622 6.2722222 0.273622 6.2750000 0.272572
+ 6.2777778 0.274147 6.2805556 0.275197 6.2833333 0.275197 6.2861111 0.276247
+ 6.2888889 0.275722 6.2916667 0.275722 6.2944444 0.275722 6.2972222 0.277297
+ 6.3000000 0.278346 6.3027778 0.277822 6.3055556 0.276247 6.3083333 0.275197
+ 6.3111111 0.277297 6.3138889 0.275197 6.3166667 0.277297 6.3194444 0.278346
+ 6.3222222 0.281496 6.3250000 0.291995 6.3277778 0.308793 6.3305556 0.328740
+ 6.3333333 0.350787 6.3361111 0.373885 6.3388889 0.391207 6.3416667 0.410630
+ 6.3444444 0.425853 6.3472222 0.437402 6.3500000 0.445801 6.3527778 0.443176
+ 6.3555556 0.431627 6.3583333 0.415879 6.3611111 0.400656 6.3638889 0.388058
+ 6.3666667 0.377034 6.3694444 0.360761 6.3722222 0.343438 6.3750000 0.329790
+ 6.3777778 0.321916 6.3805556 0.315092 6.3833333 0.305118 6.3861111 0.296194
+ 6.3888889 0.286745 6.3916667 0.280971 6.3944444 0.276247 6.3972222 0.270997
+ 6.4000000 0.265748 6.4027778 0.263123 6.4055556 0.259974 6.4083333 0.259449
+ 6.4111111 0.257874 6.4138889 0.256299 6.4166667 0.255249 6.4194444 0.254724
+ 6.4222222 0.255249 6.4250000 0.253150 6.4277778 0.252625 6.4305556 0.255774
+ 6.4333333 0.256824 6.4361111 0.256824 6.4388889 0.256299 6.4416667 0.254724
+ 6.4444444 0.255774 6.4472222 0.256299 6.4500000 0.256824 6.4527778 0.256824
+ 6.4555556 0.257349 6.4583333 0.256299 6.4611111 0.257349 6.4638889 0.258924
+ 6.4666667 0.258924 6.4694444 0.258399 6.4722222 0.257874 6.4750000 0.255774
+ 6.4777778 0.255774 6.4805556 0.257874 6.4833333 0.257874 6.4861111 0.258399
+ 6.4888889 0.258399 6.4916667 0.257874 6.4944444 0.255774 6.4972222 0.257874
+ 6.5000000 0.258924 6.5027778 0.258399 6.5055556 0.257349 6.5083333 0.256299
+ 6.5111111 0.256824 6.5138889 0.258924 6.5166667 0.259449 6.5194444 0.259449
+ 6.5222222 0.257349 6.5250000 0.256824 6.5277778 0.256299 6.5305556 0.257874
+ 6.5333333 0.257874 6.5361111 0.257874 6.5388889 0.258924 6.5416667 0.258924
+ 6.5444444 0.259974 6.5472222 0.261024 6.5500000 0.260499 6.5527778 0.262073
+ 6.5555556 0.263123 6.5583333 0.262598 6.5611111 0.264173 6.5638889 0.265748
+ 6.5666667 0.267323 6.5694444 0.267848 6.5722222 0.268373 6.5750000 0.268373
+ 6.5777778 0.269423 6.5805556 0.273622 6.5833333 0.275722 6.5861111 0.276772
+ 6.5888889 0.278871 6.5916667 0.278871 6.5944444 0.279921 6.5972222 0.282546
+ 6.6000000 0.284646 6.6027778 0.286745 6.6055556 0.287270 6.6083333 0.286745
+ 6.6111111 0.289370 6.6138889 0.291470 6.6166667 0.293045 6.6194444 0.294619
+ 6.6222222 0.294619 6.6250000 0.294619 6.6277778 0.294094 6.6305556 0.293570
+ 6.6333333 0.292520 6.6361111 0.293045 6.6388889 0.291995 6.6416667 0.289895
+ 6.6444444 0.289895 6.6472222 0.290420 6.6500000 0.289370 6.6527778 0.288320
+ 6.6555556 0.287795 6.6583333 0.285171 6.6611111 0.285171 6.6638889 0.285171
+ 6.6666667 0.284121 6.6694444 0.284121 6.6722222 0.283071 6.6750000 0.280446
+ 6.6777778 0.281496 6.6805556 0.284121 6.6833333 0.284121 6.6861111 0.283071
+ 6.6888889 0.282546 6.6916667 0.279396 6.6944444 0.279921 6.6972222 0.280446
+ 6.7000000 0.280446 6.7027778 0.280971 6.7055556 0.281496 6.7083333 0.279921
+ 6.7111111 0.279396 6.7138889 0.279921 6.7166667 0.280446 6.7194444 0.279921
+ 6.7222222 0.278871 6.7250000 0.278346 6.7277778 0.278346 6.7305556 0.279396
+ 6.7333333 0.279921 6.7361111 0.279396 6.7388889 0.279921 6.7416667 0.277822
+ 6.7444444 0.277822 6.7472222 0.278346 6.7500000 0.277822 6.7527778 0.277297
+ 6.7555556 0.277822 6.7583333 0.276772 6.7611111 0.276772 6.7638889 0.277822
+ 6.7666667 0.279396 6.7694444 0.278871 6.7722222 0.278346 6.7750000 0.277822
+ 6.7777778 0.278346 6.7805556 0.279396 6.7833333 0.279921 6.7861111 0.279396
+ 6.7888889 0.279396 6.7916667 0.276772 6.7944444 0.277822 6.7972222 0.279396
+ 6.8000000 0.279921 6.8027778 0.279396 6.8055556 0.280446 6.8083333 0.279921
+ 6.8111111 0.277297 6.8138889 0.279396 6.8166667 0.280971 6.8194444 0.280446
+ 6.8222222 0.279921 6.8250000 0.278346 6.8277778 0.277822 6.8305556 0.278871
+ 6.8333333 0.279396 6.8361111 0.279921 6.8388889 0.278871 6.8416667 0.277822
+ 6.8444444 0.278871 6.8472222 0.279396 6.8500000 0.280446 6.8527778 0.280446
+ 6.8555556 0.278871 6.8583333 0.278346 6.8611111 0.277822 6.8638889 0.278871
+ 6.8666667 0.278871 6.8694444 0.279396 6.8722222 0.278871 6.8750000 0.279396
+ 6.8777778 0.279396 6.8805556 0.280971 6.8833333 0.284121 6.8861111 0.285171
+ 6.8888889 0.286220 6.8916667 0.285171 6.8944444 0.286745 6.8972222 0.288320
+ 6.9000000 0.289370 6.9027778 0.287795 6.9055556 0.288320 6.9083333 0.287795
+ 6.9111111 0.292520 6.9138889 0.294619 6.9166667 0.296194 6.9194444 0.298294
+ 6.9222222 0.297244 6.9250000 0.298294 6.9277778 0.299869 6.9305556 0.300394
+ 6.9333333 0.299869 6.9361111 0.299344 6.9388889 0.297244 6.9416667 0.295144
+ 6.9444444 0.295144 6.9472222 0.293570 6.9500000 0.293045 6.9527778 0.290945
+ 6.9555556 0.286745 6.9583333 0.282021 6.9611111 0.277297 6.9638889 0.276772
+ 6.9666667 0.275197 6.9694444 0.273622 6.9722222 0.272047 6.9750000 0.271522
+ 6.9777778 0.272047 6.9805556 0.271522 6.9833333 0.271522 6.9861111 0.271522
+ 6.9888889 0.270472 6.9916667 0.272047 6.9944444 0.274147 6.9972222 0.274147
+ 7.0000000 0.274672 7.0027778 0.275197 7.0055556 0.275197 7.0083333 0.274672
+ 7.0111111 0.275197 7.0138889 0.275722 7.0166667 0.276772 7.0194444 0.277297
+ 7.0222222 0.276247 7.0250000 0.275722 7.0277778 0.275722 7.0305556 0.277822
+ 7.0333333 0.278871 7.0361111 0.277297 7.0388889 0.277822 7.0416667 0.276247
+ 7.0444444 0.275722 7.0472222 0.277822 7.0500000 0.278346 7.0527778 0.282546
+ 7.0555556 0.290945 7.0583333 0.306168 7.0611111 0.323491 7.0638889 0.344488
+ 7.0666667 0.361811 7.0694444 0.381759 7.0722222 0.398556 7.0750000 0.411680
+ 7.0777778 0.424803 7.0805556 0.433727 7.0833333 0.439501 7.0861111 0.437402
+ 7.0888889 0.425853 7.0916667 0.409055 7.0944444 0.396457 7.0972222 0.387008
+ 7.1000000 0.375984 7.1027778 0.357612 7.1055556 0.338714 7.1083333 0.324541
+ 7.1111111 0.315092 7.1138889 0.308268 7.1166667 0.301444 7.1194444 0.290945
+ 7.1222222 0.282021 7.1250000 0.276772 7.1277778 0.273097 7.1305556 0.270997
+ 7.1333333 0.267323 7.1361111 0.262598 7.1388889 0.259449 7.1416667 0.257349
+ 7.1444444 0.256299 7.1472222 0.255774 7.1500000 0.256299 7.1527778 0.255774
+ 7.1555556 0.256299 7.1583333 0.254724 7.1611111 0.255249 7.1638889 0.256299
+ 7.1666667 0.256824 7.1694444 0.256824 7.1722222 0.255249 7.1750000 0.257349
+ 7.1777778 0.257349 7.1805556 0.258924 7.1833333 0.256824 7.1861111 0.256824
+ 7.1888889 0.257874 7.1916667 0.256299 7.1944444 0.256824 7.1972222 0.259449
+ 7.2000000 0.259974 7.2027778 0.256824 7.2055556 0.257874 7.2083333 0.257349
+ 7.2111111 0.257874 7.2138889 0.258399 7.2166667 0.258399 7.2194444 0.257874
+ 7.2222222 0.258924 7.2250000 0.257349 7.2277778 0.256824 7.2305556 0.257349
+ 7.2333333 0.257349 7.2361111 0.256299 7.2388889 0.257874 7.2416667 0.256824
+ 7.2444444 0.258399 7.2472222 0.258924 7.2500000 0.258924 7.2527778 0.257874
+ 7.2555556 0.257874 7.2583333 0.257874 7.2611111 0.257874 7.2638889 0.258924
+ 7.2666667 0.258924 7.2694444 0.258924 7.2722222 0.258924 7.2750000 0.259449
+ 7.2777778 0.260499 7.2805556 0.263648 7.2833333 0.263123 7.2861111 0.265223
+ 7.2888889 0.263123 7.2916667 0.263648 7.2944444 0.265748 7.2972222 0.268898
+ 7.3000000 0.269423 7.3027778 0.269948 7.3055556 0.269423 7.3083333 0.269423
+ 7.3111111 0.272572 7.3138889 0.275197 7.3166667 0.277297 7.3194444 0.278346
+ 7.3222222 0.279396 7.3250000 0.280971 7.3277778 0.283071 7.3305556 0.285696
+ 7.3333333 0.287795 7.3361111 0.287795 7.3388889 0.289895 7.3416667 0.288320
+ 7.3444444 0.290945 7.3472222 0.291995 7.3500000 0.293045 7.3527778 0.292520
+ 7.3555556 0.291470 7.3583333 0.290945 7.3611111 0.291995 7.3638889 0.291470
+ 7.3666667 0.290420 7.3694444 0.290945 7.3722222 0.288320 7.3750000 0.286220
+ 7.3777778 0.286220 7.3805556 0.286220 7.3833333 0.287270 7.3861111 0.286745
+ 7.3888889 0.286220 7.3916667 0.283596 7.3944444 0.283596 7.3972222 0.284646
+ 7.4000000 0.284646 7.4027778 0.284121 7.4055556 0.283596 7.4083333 0.283071
+ 7.4111111 0.282021 7.4138889 0.283596 7.4166667 0.285171 7.4194444 0.283071
+ 7.4222222 0.282021 7.4250000 0.280971 7.4277778 0.282021 7.4305556 0.282546
+ 7.4333333 0.282021 7.4361111 0.282546 7.4388889 0.282021 7.4416667 0.280971
+ 7.4444444 0.280446 7.4472222 0.280971 7.4500000 0.279921 7.4527778 0.282021
+ 7.4555556 0.279921 7.4583333 0.280446 7.4611111 0.280446 7.4638889 0.282021
+ 7.4666667 0.282021 7.4694444 0.282021 7.4722222 0.280971 7.4750000 0.279921
+ 7.4777778 0.282546 7.4805556 0.283071 7.4833333 0.282546 7.4861111 0.281496
+ 7.4888889 0.281496 7.4916667 0.280971 7.4944444 0.282546 7.4972222 0.282021
+ 7.5000000 0.283596 7.5027778 0.283071 7.5055556 0.280971 7.5083333 0.279921
+ 7.5111111 0.282546 7.5138889 0.281496 7.5166667 0.283071 7.5194444 0.282546
+ 7.5222222 0.282021 7.5250000 0.281496 7.5277778 0.282021 7.5305556 0.283596
+ 7.5333333 0.283071 7.5361111 0.284121 7.5388889 0.282546 7.5416667 0.282021
+ 7.5444444 0.282546 7.5472222 0.284646 7.5500000 0.285696 7.5527778 0.285696
+ 7.5555556 0.283596 7.5583333 0.281496 7.5611111 0.282546 7.5638889 0.282546
+ 7.5666667 0.284646 7.5694444 0.284646 7.5722222 0.284646 7.5750000 0.283071
+ 7.5777778 0.283596 7.5805556 0.284646 7.5833333 0.286745 7.5861111 0.287270
+ 7.5888889 0.286745 7.5916667 0.285171 7.5944444 0.286745 7.5972222 0.289895
+ 7.6000000 0.293045 7.6027778 0.295144 7.6055556 0.294619 7.6083333 0.294619
+ 7.6111111 0.294619 7.6138889 0.295144 7.6166667 0.295669 7.6194444 0.296719
+ 7.6222222 0.299344 7.6250000 0.300394 7.6277778 0.303018 7.6305556 0.304068
+ 7.6333333 0.305643 7.6361111 0.306693 7.6388889 0.306693 7.6416667 0.305643
+ 7.6444444 0.306168 7.6472222 0.304593 7.6500000 0.304068 7.6527778 0.304068
+ 7.6555556 0.303018 7.6583333 0.300919 7.6611111 0.298819 7.6638889 0.294619
+ 7.6666667 0.290945 7.6694444 0.285171 7.6722222 0.280971 7.6750000 0.278346
+ 7.6777778 0.278346 7.6805556 0.277822 7.6833333 0.280446 7.6861111 0.278871
+ 7.6888889 0.277822 7.6916667 0.278346 7.6944444 0.278346 7.6972222 0.280446
+ 7.7000000 0.282546 7.7027778 0.282021 7.7055556 0.280971 7.7083333 0.278346
+ 7.7111111 0.280446 7.7138889 0.280971 7.7166667 0.280971 7.7194444 0.282546
+ 7.7222222 0.280971 7.7250000 0.279921 7.7277778 0.280971 7.7305556 0.282546
+ 7.7333333 0.283596 7.7361111 0.284646 7.7388889 0.283596 7.7416667 0.280971
+ 7.7444444 0.280446 7.7472222 0.281496 7.7500000 0.284646 7.7527778 0.288320
+ 7.7555556 0.295144 7.7583333 0.303543 7.7611111 0.317717 7.7638889 0.333465
+ 7.7666667 0.351312 7.7694444 0.369685 7.7722222 0.389633 7.7750000 0.407480
+ 7.7777778 0.423228 7.7805556 0.433727 7.7833333 0.442651 7.7861111 0.439501
+ 7.7888889 0.426378 7.7916667 0.409055 7.7944444 0.394882 7.7972222 0.382808
+ 7.8000000 0.371260 7.8027778 0.354462 7.8055556 0.340289 7.8083333 0.331890
+ 7.8111111 0.325066 7.8138889 0.315092 7.8166667 0.305643 7.8194444 0.297769
+ 7.8222222 0.290945 7.8250000 0.284646 7.8277778 0.278871 7.8305556 0.275197
+ 7.8333333 0.272572 7.8361111 0.268898 7.8388889 0.266798 7.8416667 0.265223
+ 7.8444444 0.264173 7.8472222 0.264173 7.8500000 0.264173 7.8527778 0.262598
+ 7.8555556 0.263123 7.8583333 0.261024 7.8611111 0.263123 7.8638889 0.264698
+ 7.8666667 0.266273 7.8694444 0.265748 7.8722222 0.264173 7.8750000 0.262598
+ 7.8777778 0.263123 7.8805556 0.264173 7.8833333 0.264698 7.8861111 0.266273
+ 7.8888889 0.265223 7.8916667 0.265223 7.8944444 0.263648 7.8972222 0.266273
+ 7.9000000 0.265223 7.9027778 0.265748 7.9055556 0.265748 7.9083333 0.264698
+ 7.9111111 0.264698 7.9138889 0.265748 7.9166667 0.265748 7.9194444 0.265748
+ 7.9222222 0.264698 7.9250000 0.265223 7.9277778 0.265748 7.9305556 0.266273
+ 7.9333333 0.266273 7.9361111 0.265223 7.9388889 0.265223 7.9416667 0.265748
+ 7.9444444 0.265748 7.9472222 0.266273 7.9500000 0.267323 7.9527778 0.266273
+ 7.9555556 0.265223 7.9583333 0.265223 7.9611111 0.264698 7.9638889 0.265748
+ 7.9666667 0.268373 7.9694444 0.267848 7.9722222 0.267848 7.9750000 0.266273
+ 7.9777778 0.267848 7.9805556 0.268898 7.9833333 0.270472 7.9861111 0.271522
+ 7.9888889 0.270997 7.9916667 0.269948 7.9944444 0.270997 7.9972222 0.273622
+ 8.0000000 0.276772 8.0027778 0.277822 8.0055556 0.278871 8.0083333 0.278871
+ 8.0111111 0.278871 8.0138889 0.282021 8.0166667 0.285696 8.0194444 0.287795
+ 8.0222222 0.289370 8.0250000 0.289895 8.0277778 0.290945 8.0305556 0.294094
+ 8.0333333 0.295669 8.0361111 0.296719 8.0388889 0.297244 8.0416667 0.299344
+ 8.0444444 0.299869 8.0472222 0.301444 8.0500000 0.301444 8.0527778 0.300394
+ 8.0555556 0.299869 8.0583333 0.299344 8.0611111 0.300394 8.0638889 0.299869
+ 8.0666667 0.299869 8.0694444 0.298294 8.0722222 0.296719 8.0750000 0.295669
+ 8.0777778 0.295144 8.0805556 0.295669 8.0833333 0.295144 8.0861111 0.293570
+ 8.0888889 0.293045 8.0916667 0.291470 8.0944444 0.292520 8.0972222 0.293570
+ 8.1000000 0.293045 8.1027778 0.293045 8.1055556 0.291470 8.1083333 0.289370
+ 8.1111111 0.290420 8.1138889 0.290420 8.1166667 0.290945 8.1194444 0.290420
+ 8.1222222 0.288845 8.1250000 0.288320 8.1277778 0.287795 8.1305556 0.288845
+ 8.1333333 0.290945 8.1361111 0.288320 8.1388889 0.289895 8.1416667 0.287270
+ 8.1444444 0.287270 8.1472222 0.288320 8.1500000 0.288845 8.1527778 0.288845
+ 8.1555556 0.287270 8.1583333 0.285171 8.1611111 0.286220 8.1638889 0.287270
+ 8.1666667 0.288320 8.1694444 0.288845 8.1722222 0.287270 8.1750000 0.287270
+ 8.1777778 0.288320 8.1805556 0.287795 8.1833333 0.287270 8.1861111 0.287270
+ 8.1888889 0.288320 8.1916667 0.287270 8.1944444 0.287270 8.1972222 0.287795
+ 8.2000000 0.288845 8.2027778 0.288320 8.2055556 0.288320 8.2083333 0.287795
+ 8.2111111 0.287795 8.2138889 0.289370 8.2166667 0.288845 8.2194444 0.289370
+ 8.2222222 0.288845 8.2250000 0.288845 8.2277778 0.288845 8.2305556 0.289370
+ 8.2333333 0.290420 8.2361111 0.288845 8.2388889 0.287795 8.2416667 0.287270
+ 8.2444444 0.288845 8.2472222 0.290420 8.2500000 0.289895 8.2527778 0.289895
+ 8.2555556 0.290420 8.2583333 0.288845 8.2611111 0.290945 8.2638889 0.291470
+ 8.2666667 0.293045 8.2694444 0.291470 8.2722222 0.289370 8.2750000 0.288320
+ 8.2777778 0.288845 8.2805556 0.290945 8.2833333 0.291470 8.2861111 0.291995
+ 8.2888889 0.293045 8.2916667 0.295669 8.2944444 0.299344 8.2972222 0.301444
+ 8.3000000 0.301969 8.3027778 0.299869 8.3055556 0.298819 8.3083333 0.297769
+ 8.3111111 0.299869 8.3138889 0.304068 8.3166667 0.306168 8.3194444 0.307218
+ 8.3222222 0.307743 8.3250000 0.306168 8.3277778 0.307218 8.3305556 0.310892
+ 8.3333333 0.312467 8.3361111 0.311417 8.3388889 0.309318 8.3416667 0.306693
+ 8.3444444 0.306693 8.3472222 0.307218 8.3500000 0.305643 8.3527778 0.301969
+ 8.3555556 0.294619 8.3583333 0.288320 8.3611111 0.283071 8.3638889 0.284121
+ 8.3666667 0.283596 8.3694444 0.283596 8.3722222 0.282546 8.3750000 0.280971
+ 8.3777778 0.282021 8.3805556 0.281496 8.3833333 0.283071 8.3861111 0.284646
+ 8.3888889 0.283596 8.3916667 0.283596 8.3944444 0.284121 8.3972222 0.284121
+ 8.4000000 0.284121 8.4027778 0.284121 8.4055556 0.283596 8.4083333 0.283596
+ 8.4111111 0.285696 8.4138889 0.286745 8.4166667 0.287270 8.4194444 0.288320
+ 8.4222222 0.287795 8.4250000 0.285696 8.4277778 0.287795 8.4305556 0.288845
+ 8.4333333 0.289895 8.4361111 0.289895 8.4388889 0.287270 8.4416667 0.285696
+ 8.4444444 0.287795 8.4472222 0.291470 8.4500000 0.300394 8.4527778 0.314042
+ 8.4555556 0.332415 8.4583333 0.352362 8.4611111 0.375984 8.4638889 0.398556
+ 8.4666667 0.416929 8.4694444 0.430052 8.4722222 0.438451 8.4750000 0.444751
+ 8.4777778 0.450000 8.4805556 0.445276 8.4833333 0.431627 8.4861111 0.413255
+ 8.4888889 0.399606 8.4916667 0.386483 8.4944444 0.369160 8.4972222 0.354462
+ 8.5000000 0.343963 8.5027778 0.336089 8.5055556 0.327690 8.5083333 0.315617
+ 8.5111111 0.305118 8.5138889 0.296719 8.5166667 0.291995 8.5194444 0.286220
+ 8.5222222 0.280971 8.5250000 0.274672 8.5277778 0.272572 8.5305556 0.272572
+ 8.5333333 0.270997 8.5361111 0.268898 8.5388889 0.266273 8.5416667 0.265748
+ 8.5444444 0.266273 8.5472222 0.266273 8.5500000 0.266273 8.5527778 0.267323
+ 8.5555556 0.265748 8.5583333 0.265748 8.5611111 0.266273 8.5638889 0.267323
+ 8.5666667 0.269948 8.5694444 0.268898 8.5722222 0.268898 8.5750000 0.267323
+ 8.5777778 0.267848 8.5805556 0.270472 8.5833333 0.271522 8.5861111 0.269948
+ 8.5888889 0.268373 8.5916667 0.267323 8.5944444 0.267848 8.5972222 0.268898
+ 8.6000000 0.270997 8.6027778 0.270472 8.6055556 0.267848 8.6083333 0.267323
+ 8.6111111 0.267848 8.6138889 0.269948 8.6166667 0.270472 8.6194444 0.270472
+ 8.6222222 0.269423 8.6250000 0.265223 8.6277778 0.264698 8.6305556 0.267323
+ 8.6333333 0.268898 8.6361111 0.267848 8.6388889 0.268373 8.6416667 0.266798
+ 8.6444444 0.266798 8.6472222 0.267323 8.6500000 0.268898 8.6527778 0.267323
+ 8.6555556 0.266273 8.6583333 0.266273 8.6611111 0.266273 8.6638889 0.267323
+ 8.6666667 0.268898 8.6694444 0.269423 8.6722222 0.268373 8.6750000 0.268898
+ 8.6777778 0.270472 8.6805556 0.271522 8.6833333 0.273097 8.6861111 0.275197
+ 8.6888889 0.276247 8.6916667 0.276772 8.6944444 0.278346 8.6972222 0.279396
+ 8.7000000 0.282021 8.7027778 0.282546 8.7055556 0.283071 8.7083333 0.283071
+ 8.7111111 0.285171 8.7138889 0.287795 8.7166667 0.289895 8.7194444 0.290945
+ 8.7222222 0.292520 8.7250000 0.291995 8.7277778 0.294619 8.7305556 0.297244
+ 8.7333333 0.299869 8.7361111 0.300919 8.7388889 0.300919 8.7416667 0.300394
+ 8.7444444 0.299869 8.7472222 0.300919 8.7500000 0.303018 8.7527778 0.301444
+ 8.7555556 0.301444 8.7583333 0.298294 8.7611111 0.299344 8.7638889 0.299869
+ 8.7666667 0.299344 8.7694444 0.299344 8.7722222 0.298294 8.7750000 0.295144
+ 8.7777778 0.295669 8.7805556 0.297244 8.7833333 0.296194 8.7861111 0.296194
+ 8.7888889 0.295669 8.7916667 0.294094 8.7944444 0.293045 8.7972222 0.293570
+ 8.8000000 0.292520 8.8027778 0.291995 8.8055556 0.290420 8.8083333 0.290420
+ 8.8111111 0.290945 8.8138889 0.291470 8.8166667 0.290420 8.8194444 0.291470
+ 8.8222222 0.290420 8.8250000 0.289895 8.8277778 0.289895 8.8305556 0.289895
+ 8.8333333 0.290945 8.8361111 0.290420 8.8388889 0.288845 8.8416667 0.287795
+ 8.8444444 0.287795 8.8472222 0.288320 8.8500000 0.287795 8.8527778 0.286745
+ 8.8555556 0.286745 8.8583333 0.287270 8.8611111 0.288845 8.8638889 0.288845
+ 8.8666667 0.289370 8.8694444 0.289370 8.8722222 0.288845 8.8750000 0.287795
+ 8.8777778 0.289370 8.8805556 0.289895 8.8833333 0.290420 8.8861111 0.288845
+ 8.8888889 0.287795 8.8916667 0.286745 8.8944444 0.287270 8.8972222 0.288845
+ 8.9000000 0.290945 8.9027778 0.290945 8.9055556 0.289895 8.9083333 0.287270
+ 8.9111111 0.287795 8.9138889 0.288845 8.9166667 0.289895 8.9194444 0.289370
+ 8.9222222 0.287795 8.9250000 0.287270 8.9277778 0.288845 8.9305556 0.288320
+ 8.9333333 0.287795 8.9361111 0.287270 8.9388889 0.287795 8.9416667 0.288320
+ 8.9444444 0.288320 8.9472222 0.289895 8.9500000 0.289895 8.9527778 0.289370
+ 8.9555556 0.288845 8.9583333 0.287795 8.9611111 0.288320 8.9638889 0.288320
+ 8.9666667 0.288320 8.9694444 0.288845 8.9722222 0.288320 8.9750000 0.287270
+ 8.9777778 0.288845 8.9805556 0.290420 8.9833333 0.289895 8.9861111 0.289895
+ 8.9888889 0.288845 8.9916667 0.289895 8.9944444 0.292520 8.9972222 0.296194
+ 9.0000000 0.298819 9.0027778 0.298819 9.0055556 0.297244 9.0083333 0.296194
+ 9.0111111 0.298294 9.0138889 0.301444 9.0166667 0.304593 9.0194444 0.306693
+ 9.0222222 0.306168 9.0250000 0.306168 9.0277778 0.307743 9.0305556 0.309318
+ 9.0333333 0.311417 9.0361111 0.310367 9.0388889 0.307743 9.0416667 0.306168
+ 9.0444444 0.304593 9.0472222 0.306168 9.0500000 0.305118 9.0527778 0.301969
+ 9.0555556 0.297769 9.0583333 0.291470 9.0611111 0.286745 9.0638889 0.284121
+ 9.0666667 0.282021 9.0694444 0.281496 9.0722222 0.279921 9.0750000 0.279921
+ 9.0777778 0.280446 9.0805556 0.280446 9.0833333 0.283071 9.0861111 0.283596
+ 9.0888889 0.283071 9.0916667 0.280971 9.0944444 0.280971 9.0972222 0.281496
+ 9.1000000 0.282546 9.1027778 0.283071 9.1055556 0.283071 9.1083333 0.281496
+ 9.1111111 0.282546 9.1138889 0.284646 9.1166667 0.285171 9.1194444 0.285696
+ 9.1222222 0.284646 9.1250000 0.283071 9.1277778 0.284121 9.1305556 0.284646
+ 9.1333333 0.284646 9.1361111 0.285171 9.1388889 0.283071 9.1416667 0.282021
+ 9.1444444 0.286220 9.1472222 0.293570 9.1500000 0.308268 9.1527778 0.325066
+ 9.1555556 0.343438 9.1583333 0.363911 9.1611111 0.387533 9.1638889 0.410105
+ 9.1666667 0.426903 9.1694444 0.438976 9.1722222 0.443701 9.1750000 0.437402
+ 9.1777778 0.423228 9.1805556 0.409055 9.1833333 0.395407 9.1861111 0.380709
+ 9.1888889 0.363386 9.1916667 0.347113 9.1944444 0.336089 9.1972222 0.331890
+ 9.2000000 0.329265 9.2027778 0.320341 9.2055556 0.308793 9.2083333 0.297769
+ 9.2111111 0.290945 9.2138889 0.285171 9.2166667 0.279396 9.2194444 0.274147
+ 9.2222222 0.269948 9.2250000 0.267323 9.2277778 0.267323 9.2305556 0.266798
+ 9.2333333 0.265223 9.2361111 0.265223 9.2388889 0.263123 9.2416667 0.263648
+ 9.2444444 0.263123 9.2472222 0.264173 9.2500000 0.265748 9.2527778 0.265223
+ 9.2555556 0.264173 9.2583333 0.264173 9.2611111 0.265223 9.2638889 0.266798
+ 9.2666667 0.268373 9.2694444 0.267323 9.2722222 0.265748 9.2750000 0.265223
+ 9.2777778 0.266273 9.2805556 0.266798 9.2833333 0.267848 9.2861111 0.266798
+ 9.2888889 0.266798 9.2916667 0.266798 9.2944444 0.267323 9.2972222 0.268373
+ 9.3000000 0.268898 9.3027778 0.267848 9.3055556 0.267323 9.3083333 0.266798
+ 9.3111111 0.265748 9.3138889 0.266273 9.3166667 0.266798 9.3194444 0.268373
+ 9.3222222 0.266798 9.3250000 0.266798 9.3277778 0.266798 9.3305556 0.266798
+ 9.3333333 0.266273 9.3361111 0.265223 9.3388889 0.265223 9.3416667 0.266273
+ 9.3444444 0.266798 9.3472222 0.267323 9.3500000 0.268898 9.3527778 0.268373
+ 9.3555556 0.266798 9.3583333 0.268373 9.3611111 0.267848 9.3638889 0.268898
+ 9.3666667 0.268373 9.3694444 0.269948 9.3722222 0.269423 9.3750000 0.268898
+ 9.3777778 0.270997 9.3805556 0.273097 9.3833333 0.275197 9.3861111 0.276772
+ 9.3888889 0.277297 9.3916667 0.277822 9.3944444 0.278871 9.3972222 0.280971
+ 9.4000000 0.282021 9.4027778 0.283596 9.4055556 0.284121 9.4083333 0.283071
+ 9.4111111 0.285696 9.4138889 0.288320 9.4166667 0.291470 9.4194444 0.293570
+ 9.4222222 0.294619 9.4250000 0.293570 9.4277778 0.295144 9.4305556 0.296719
+ 9.4333333 0.298294 9.4361111 0.297769 9.4388889 0.298294 9.4416667 0.298294
+ 9.4444444 0.299869 9.4472222 0.300394 9.4500000 0.299869 9.4527778 0.299869
+ 9.4555556 0.298819 9.4583333 0.298294 9.4611111 0.296719 9.4638889 0.297244
+ 9.4666667 0.297769 9.4694444 0.295669 9.4722222 0.295144 9.4750000 0.292520
+ 9.4777778 0.291995 9.4805556 0.292520 9.4833333 0.294094 9.4861111 0.293045
+ 9.4888889 0.290420 9.4916667 0.290420 9.4944444 0.290420 9.4972222 0.289370
+ 9.5000000 0.291470 9.5027778 0.289370 9.5055556 0.289370 9.5083333 0.289370
+ 9.5111111 0.288320 9.5138889 0.289370 9.5166667 0.289370 9.5194444 0.287795
+ 9.5222222 0.288320 9.5250000 0.286745 9.5277778 0.287795 9.5305556 0.288845
+ 9.5333333 0.288320 9.5361111 0.286745 9.5388889 0.285696 9.5416667 0.284121
+ 9.5444444 0.285171 9.5472222 0.285696 9.5500000 0.284646 9.5527778 0.284646
+ 9.5555556 0.284646 9.5583333 0.284646 9.5611111 0.285171 9.5638889 0.285171
+ 9.5666667 0.286220 9.5694444 0.285696 9.5722222 0.285696 9.5750000 0.285696
+ 9.5777778 0.285171 9.5805556 0.285696 9.5833333 0.286745 9.5861111 0.286745
+ 9.5888889 0.285696 9.5916667 0.285696 9.5944444 0.285696 9.5972222 0.285696
+ 9.6000000 0.286220 9.6027778 0.283596 9.6055556 0.285171 9.6083333 0.283596
+ 9.6111111 0.285696 9.6138889 0.287270 9.6166667 0.287270 9.6194444 0.286220
+ 9.6222222 0.285171 9.6250000 0.283596 9.6277778 0.284646 9.6305556 0.285696
+ 9.6333333 0.287270 9.6361111 0.286745 9.6388889 0.286745 9.6416667 0.285171
+ 9.6444444 0.285696 9.6472222 0.286745 9.6500000 0.286220 9.6527778 0.286220
+ 9.6555556 0.284646 9.6583333 0.283071 9.6611111 0.285171 9.6638889 0.285696
+ 9.6666667 0.285171 9.6694444 0.286220 9.6722222 0.284121 9.6750000 0.284121
+ 9.6777778 0.283596 9.6805556 0.285696 9.6833333 0.286220 9.6861111 0.285696
+ 9.6888889 0.286220 9.6916667 0.286220 9.6944444 0.286220 9.6972222 0.288320
+ 9.7000000 0.289370 9.7027778 0.291470 9.7055556 0.293570 9.7083333 0.292520
+ 9.7111111 0.294094 9.7138889 0.295669 9.7166667 0.295669 9.7194444 0.293045
+ 9.7222222 0.293045 9.7250000 0.294094 9.7277778 0.298294 9.7305556 0.301444
+ 9.7333333 0.304068 9.7361111 0.304593 9.7388889 0.303543 9.7416667 0.304068
+ 9.7444444 0.305118 9.7472222 0.308268 9.7500000 0.308793 9.7527778 0.307743
+ 9.7555556 0.305643 9.7583333 0.303543 9.7611111 0.304593 9.7638889 0.304068
+ 9.7666667 0.301444 9.7694444 0.299344 9.7722222 0.294619 9.7750000 0.288320
+ 9.7777778 0.284646 9.7805556 0.282021 9.7833333 0.282021 9.7861111 0.280971
+ 9.7888889 0.278871 9.7916667 0.277822 9.7944444 0.278871 9.7972222 0.280446
+ 9.8000000 0.280446 9.8027778 0.280446 9.8055556 0.279396 9.8083333 0.279396
+ 9.8111111 0.280446 9.8138889 0.282021 9.8166667 0.282546 9.8194444 0.282021
+ 9.8222222 0.280971 9.8250000 0.279396 9.8277778 0.281496 9.8305556 0.282546
+ 9.8333333 0.282546 9.8361111 0.283596 9.8388889 0.284646 9.8416667 0.283596
+ 9.8444444 0.283596 9.8472222 0.284121 9.8500000 0.285696 9.8527778 0.285696
+ 9.8555556 0.284121 9.8583333 0.283071 9.8611111 0.283596 9.8638889 0.287270
+ 9.8666667 0.293570 9.8694444 0.304068 9.8722222 0.318766 9.8750000 0.335564
+ 9.8777778 0.354462 9.8805556 0.372310 9.8833333 0.390157 9.8861111 0.403806
+ 9.8888889 0.416929 9.8916667 0.427428 9.8944444 0.436352 9.8972222 0.442126
+ 9.9000000 0.437402 9.9027778 0.423228 9.9055556 0.406430 9.9083333 0.391207
+ 9.9111111 0.380709 9.9138889 0.367060 9.9166667 0.350787 9.9194444 0.336089
+ 9.9222222 0.325591 9.9250000 0.319291 9.9277778 0.311417 9.9305556 0.302493
+ 9.9333333 0.295144 9.9361111 0.288320 9.9388889 0.284121 9.9416667 0.279921
+ 9.9444444 0.276772 9.9472222 0.274147 9.9500000 0.270472 9.9527778 0.268373
+ 9.9555556 0.264698 9.9583333 0.264173 9.9611111 0.264173 9.9638889 0.264698
+ 9.9666667 0.263123 9.9694444 0.263648 9.9722222 0.262598 9.9750000 0.262073
+ 9.9777778 0.264698 9.9805556 0.265748 9.9833333 0.265748 9.9861111 0.266273
+ 9.9888889 0.264698 9.9916667 0.265748 9.9944444 0.265748 9.9972222 0.267848
+ )
Vthresh threshold 0 PWL(
+ 0.0000000 0.285971 0.0277778 0.285971 0.0555556 0.285971 0.0833333 0.285971
+ 0.1111111 0.285971 0.1388889 0.285971 0.1666667 0.285971 0.1944444 0.285971
+ 0.2222222 0.285971 0.2500000 0.285971 0.2777778 0.285971 0.3055556 0.285971
+ 0.3333333 0.285971 0.3611111 0.285971 0.3888889 0.285971 0.4166667 0.285971
+ 0.4444444 0.285971 0.4722222 0.285971 0.5000000 0.289518 0.5277778 0.297081
+ 0.5555556 0.304574 0.5833333 0.310932 0.6111111 0.311202 0.6388889 0.310924
+ 0.6666667 0.310648 0.6944444 0.310374 0.7222222 0.310103 0.7500000 0.309835
+ 0.7777778 0.309569 0.8055556 0.309305 0.8333333 0.309044 0.8611111 0.308785
+ 0.8888889 0.308529 0.9166667 0.308275 0.9444444 0.308023 0.9722222 0.307774
+ 1.0000000 0.307527 1.0277778 0.307282 1.0555556 0.307040 1.0833333 0.306799
+ 1.1111111 0.306561 1.1388889 0.306325 1.1666667 0.306092 1.1944444 0.305860
+ 1.2222222 0.305825 1.2500000 0.307402 1.2777778 0.308964 1.3055556 0.310512
+ 1.3333333 0.311127 1.3611111 0.310849 1.3888889 0.310574 1.4166667 0.310301
+ 1.4444444 0.310031 1.4722222 0.309763 1.5000000 0.309498 1.5277778 0.309235
+ 1.5555556 0.308974 1.5833333 0.308716 1.6111111 0.308460 1.6388889 0.308207
+ 1.6666667 0.307956 1.6944444 0.307707 1.7222222 0.307461 1.7500000 0.307217
+ 1.7777778 0.306975 1.8055556 0.306735 1.8333333 0.306498 1.8611111 0.306263
+ 1.8888889 0.306029 1.9166667 0.306053 1.9444444 0.307467 1.9722222 0.308867
+ 2.0000000 0.310254 2.0277778 0.310716 2.0555556 0.310442 2.0833333 0.310170
+ 2.1111111 0.309901 2.1388889 0.309634 2.1666667 0.309370 2.1944444 0.309108
+ 2.2222222 0.308849 2.2500000 0.308592 2.2777778 0.308337 2.3055556 0.308085
+ 2.3333333 0.307835 2.3611111 0.307588 2.3888889 0.307342 2.4166667 0.307099
+ 2.4444444 0.306859 2.4722222 0.306620 2.5000000 0.306384 2.5277778 0.306149
+ 2.5555556 0.305917 2.5833333 0.305687 2.6111111 0.305460 2.6388889 0.306340
+ 2.6666667 0.308026 2.6944444 0.309696 2.7222222 0.311297 2.7500000 0.311118
+ 2.7777778 0.310841 2.8055556 0.310565 2.8333333 0.310293 2.8611111 0.310022
+ 2.8888889 0.309755 2.9166667 0.309489 2.9444444 0.309226 2.9722222 0.308966
+ 3.0000000 0.308708 3.0277778 0.308452 3.0555556 0.308199 3.0833333 0.307948
+ 3.1111111 0.307699 3.1388889 0.307453 3.1666667 0.307209 3.1944444 0.306967
+ 3.2222222 0.306728 3.2500000 0.306490 3.2777778 0.306255 3.3055556 0.306022
+ 3.3333333 0.305791 3.3611111 0.307399 3.3888889 0.309287 3.4166667 0.311156
+ 3.4444444 0.312450 3.4722222 0.312160 3.5000000 0.311872 3.5277778 0.311587
+ 3.5555556 0.311305 3.5833333 0.311026 3.6111111 0.310749 3.6388889 0.310474
+ 3.6666667 0.310202 3.6944444 0.309933 3.7222222 0.309666 3.7500000 0.309401
+ 3.7777778 0.309139 3.8055556 0.308880 3.8333333 0.308623 3.8611111 0.308368
+ 3.8888889 0.308115 3.9166667 0.307865 3.9444444 0.307617 3.9722222 0.307372
+ 4.0000000 0.307128 4.0277778 0.306887 4.0555556 0.306900 4.0833333 0.308394
+ 4.1111111 0.309875 4.1388889 0.311341 4.1666667 0.311848 4.1944444 0.311563
+ 4.2222222 0.311281 4.2500000 0.311002 4.2777778 0.310725 4.3055556 0.310451
+ 4.3333333 0.310179 4.3611111 0.309910 4.3888889 0.309643 4.4166667 0.309379
+ 4.4444444 0.309117 4.4722222 0.308858 4.5000000 0.308601 4.5277778 0.308346
+ 4.5555556 0.308094 4.5833333 0.307844 4.6111111 0.307596 4.6388889 0.307351
+ 4.6666667 0.307108 4.6944444 0.306867 4.7222222 0.306628 4.7500000 0.306392
+ 4.7777778 0.306157 4.8055556 0.307625 4.8333333 0.309237 4.8611111 0.310834
+ 4.8888889 0.311830 4.9166667 0.311546 4.9444444 0.311264 4.9722222 0.310985
+ 5.0000000 0.310708 5.0277778 0.310434 5.0555556 0.310163 5.0833333 0.309894
+ 5.1111111 0.309627 5.1388889 0.309363 5.1666667 0.309101 5.1944444 0.308842
+ 5.2222222 0.308585 5.2500000 0.308331 5.2777778 0.308079 5.3055556 0.307829
+ 5.3333333 0.307581 5.3611111 0.307336 5.3888889 0.307093 5.4166667 0.306852
+ 5.4444444 0.306614 5.4722222 0.306377 5.5000000 0.306143 5.5277778 0.305911
+ 5.5555556 0.306631 5.5833333 0.308343 5.6111111 0.310040 5.6388889 0.311721
+ 5.6666667 0.311660 5.6944444 0.311377 5.7222222 0.311096 5.7500000 0.310819
+ 5.7777778 0.310544 5.8055556 0.310271 5.8333333 0.310001 5.8611111 0.309734
+ 5.8888889 0.309468 5.9166667 0.309206 5.9444444 0.308946 5.9722222 0.308688
+ 6.0000000 0.308432 6.0277778 0.308179 6.0555556 0.307928 6.0833333 0.307680
+ 6.1111111 0.307434 6.1388889 0.307190 6.1666667 0.306948 6.1944444 0.306709
+ 6.2222222 0.306472 6.2500000 0.306237 6.2777778 0.306004 6.3055556 0.306602
+ 6.3333333 0.308732 6.3611111 0.310842 6.3888889 0.312933 6.4166667 0.313229
+ 6.4444444 0.312932 6.4722222 0.312637 6.5000000 0.312345 6.5277778 0.312056
+ 6.5555556 0.311770 6.5833333 0.311486 6.6111111 0.311204 6.6388889 0.310926
+ 6.6666667 0.310650 6.6944444 0.310376 6.7222222 0.310105 6.7500000 0.309837
+ 6.7777778 0.309571 6.8055556 0.309307 6.8333333 0.309046 6.8611111 0.308787
+ 6.8888889 0.308531 6.9166667 0.308277 6.9444444 0.308025 6.9722222 0.307776
+ 7.0000000 0.307529 7.0277778 0.307291 7.0555556 0.308564 7.0833333 0.309941
+ 7.1111111 0.311305 7.1388889 0.312111 7.1666667 0.311824 7.1944444 0.311540
+ 7.2222222 0.311258 7.2500000 0.310979 7.2777778 0.310702 7.3055556 0.310428
+ 7.3333333 0.310157 7.3611111 0.309888 7.3888889 0.309621 7.4166667 0.309357
+ 7.4444444 0.309096 7.4722222 0.308837 7.5000000 0.308580 7.5277778 0.308325
+ 7.5555556 0.308073 7.5833333 0.307823 7.6111111 0.307576 7.6388889 0.307331
+ 7.6666667 0.307088 7.6944444 0.306847 7.7222222 0.306609 7.7500000 0.307820
+ 7.7777778 0.309574 7.8055556 0.311312 7.8333333 0.312789 7.8611111 0.312496
+ 7.8888889 0.312205 7.9166667 0.311917 7.9444444 0.311632 7.9722222 0.311349
+ 8.0000000 0.311069 8.0277778 0.310792 8.0555556 0.310517 8.0833333 0.310245
+ 8.1111111 0.309975 8.1388889 0.309708 8.1666667 0.309443 8.1944444 0.309180
+ 8.2222222 0.308920 8.2500000 0.308663 8.2777778 0.308408 8.3055556 0.308155
+ 8.3333333 0.307904 8.3611111 0.307656 8.3888889 0.307410 8.4166667 0.307166
+ 8.4444444 0.308792 8.4722222 0.310795 8.5000000 0.312780 8.5277778 0.314235
+ 8.5555556 0.313928 8.5833333 0.313625 8.6111111 0.313324 8.6388889 0.313026
+ 8.6666667 0.312730 8.6944444 0.312437 8.7222222 0.312147 8.7500000 0.311860
+ 8.7777778 0.311575 8.8055556 0.311293 8.8333333 0.311014 8.8611111 0.310737
+ 8.8888889 0.310463 8.9166667 0.310191 8.9444444 0.309922 8.9722222 0.309655
+ 9.0000000 0.309390 9.0277778 0.309128 9.0555556 0.308869 9.0833333 0.308612
+ 9.1111111 0.308357 9.1388889 0.309253 9.1666667 0.310578 9.1944444 0.311891
+ 9.2222222 0.312995 9.2500000 0.312700 9.2777778 0.312408 9.3055556 0.312118
+ 9.3333333 0.311831 9.3611111 0.311547 9.3888889 0.311265 9.4166667 0.310986
+ 9.4444444 0.310709 9.4722222 0.310435 9.5000000 0.310163 9.5277778 0.309894
+ 9.5555556 0.309628 9.5833333 0.309364 9.6111111 0.309102 9.6388889 0.308843
+ 9.6666667 0.308586 9.6944444 0.308331 9.7222222 0.308079 9.7500000 0.307829
+ 9.7777778 0.307582 9.8055556 0.307336 9.8333333 0.307093 9.8611111 0.308076
+ 9.8888889 0.309675 9.9166667 0.311258 9.9444444 0.312682 9.9722222 0.285971
+ )

Xdet ecg_in threshold rpeak_out vdd vss vbias
+ env_fast_raw env_fast env_avg noise_gate_out thr_gate_out
+ rpeak_detector_v2

.ic v(env_fast_raw)=0.2810 v(env_fast)=0.2810 v(env_avg)=0.2810

.tran 50u 10.0 0 50u

.meas tran det1 when v(rpeak_out)=0.45 rise=1
.meas tran det2 when v(rpeak_out)=0.45 rise=2
.meas tran det3 when v(rpeak_out)=0.45 rise=3
.meas tran det4 when v(rpeak_out)=0.45 rise=4
.meas tran det5 when v(rpeak_out)=0.45 rise=5
.meas tran det6 when v(rpeak_out)=0.45 rise=6
.meas tran det7 when v(rpeak_out)=0.45 rise=7
.meas tran det8 when v(rpeak_out)=0.45 rise=8
.meas tran det9 when v(rpeak_out)=0.45 rise=9
.meas tran det10 when v(rpeak_out)=0.45 rise=10
.meas tran det11 when v(rpeak_out)=0.45 rise=11
.meas tran det12 when v(rpeak_out)=0.45 rise=12
.meas tran det13 when v(rpeak_out)=0.45 rise=13
.meas tran det14 when v(rpeak_out)=0.45 rise=14
.meas tran det15 when v(rpeak_out)=0.45 rise=15
.meas tran det16 when v(rpeak_out)=0.45 rise=16
.meas tran det17 when v(rpeak_out)=0.45 rise=17
.meas tran det18 when v(rpeak_out)=0.45 rise=18
.meas tran det19 when v(rpeak_out)=0.45 rise=19
.meas tran det20 when v(rpeak_out)=0.45 rise=20

.control
set filetype=ascii
run
echo "=== RECORD 105 DONE ==="
quit
.endc
.end
